`ifndef HISI_ISP_CV300_RDL
`define HISI_ISP_CV300_RDL


regfile eHISI_ISP_CV300 {
    name = "ISP (image signal processor, Hi3516C V300 / Hi3516E V100)";
    desc = "
    Image signal processor (ISP) of the Hi3516C V300 / Hi3516E V100 (data sheet chapter 10; the ISP registers are listed as offsets inside the VICAP window, base 0x11380000, from 0x12200 (AF statistics) to 0x51C64 (DCI)). This regfile is rebased by -0x10000: instantiate it at 0x11390000 (VICAP base + 0x10000) so that the AF block lands at 0x2200 and the ISP core (data sheet 0x20000.., vendor-header offset 0x0) at 0x10000. Pipeline blocks (register name prefixes): AF, FE/BE control, BLC, DG/2DG, WB, DPC, GE, FPN, WDR/WDRSPLIT, AE/AEWDR/MG/AWB statistics, EXPANDER, DIS, LSC, BNR, DEMOSAIC/NDDM, GCAC, SHARPEN, CA, CCM, CSC, GAMMA, DEHAZE, DRC, ACM, CLIP/HCDS/MCDS/VCDS, COLORBAR, CROP0 and the VPDCI (dynamic contrast) unit. Same generation as the Hi3516A V200 / Hi3519 V101 ISP (81 registers in common with its data sheet) and a superset of 58 EV20X `eHISI_ISP` registers.

    Generated 2026-11-10 by build/rdl-audit/video-rdl-scratch/gen_blocks.py: mechanical transcription of the data sheet register tables (ds_extract2 + description extraction from the PDF) merged with the vendor header; not hardware verified.

    Register sources: 775 registers from the data sheet (hi3516cv300--Hi3516CV300-Hi3516EV100-Datasheet.txt, section 10.6); 185 registers and 39 fields from OpenIPC openhisilicon `kernel/isp/arch/hi3516cv300/firmware/vreg/arch/hi3516cv300/isp_reg_define.h` (GPL-3.0 repository, HiSilicon copyright, nManager-generated 2015-12-22 \"Define all registers/tables for Hi3519\"; local copy sources/openhisilicon) (GPL-3.0 repository; header offsets are ISP-core relative (data sheet offset - 0x20000), 632 of 775 data-sheet registers match it by name and offset (ISP_BLC_CFG is at 0x21100 in the data sheet and 0x1000+0x20000 in the header)), each marked `[inferred]` in its desc (names from the header, meanings inferred from the names, reset/access unknown). Header-only register groups NOT transcribed because no register of the group matches the data sheet by name (the header was generated for the Hi3519-era ISP and these modules may differ on this chip): ISP_4BLC2 (2), ISP_4BLC3 (2), ISP_AEWDR0 (68), ISP_BLC (7), ISP_CC (3), ISP_CROP (8), ISP_FLICK (19), ISP_GE2 (4), ISP_GE3 (4), ISP_RESERVED0 (1), ISP_VDDCIADJLUT (33), ISP_VDDCIBINWGT (24), ISP_VDDCIDIVLUT (32), ISP_VPDCI (12), ISP_YUV422 (5), ISP_YUV444 (7). Name differences, data sheet kept: 0x200B0 ISP_FE_STARTUP header field startup [0:0] overlaps DS fields differently; 0x23080 ISP_LSC_GRRGAIN_WADDR [31:0] DS grrgain_waddr / header rgain_waddr; 0x23084 ISP_LSC_GRRGAIN_WDATA [25:0] DS grrgain_wdata / header rgain_wdata; 0x23088 ISP_LSC_GRRGAIN_RADDR [31:0] DS grrgain_raddr / header rgain_raddr; 0x23090 ISP_LSC_GBBGAIN_WADDR [31:0] DS gbbgain_waddr / header grgain_waddr; 0x23094 ISP_LSC_GBBGAIN_WDATA [25:0] DS gbbgain_wdata / header grgain_wdata; 0x23098 ISP_LSC_GBBGAIN_RADDR [31:0] DS gbbgain_raddr / header grgain_raddr; 0x2309C ISP_LSC_GBBGAIN_RDATA [25:0] DS gbbgain_rdata / header grgain_rdata; 0x23954 ISP_GE_MODE header field ge_mode [2:0] overlaps DS fields differently; 0x23D14 DS ISP_DPC_BHARDTHR_EN / header ISP_DPC_HARDTHR_EN: names differ, header fields not merged (strict); 0x2623C ISP_DRC_DETAIL_GAIN [15:8] DS detail_mixing_darkdetail_mixing_brig / header detail_mixing_dark; 0x2623C ISP_DRC_DETAIL_GAIN [23:16] DS detail_mixing_thresDetail / header detail_mixing_thres; 0x29000 DS ISP_AEWDR0_CFG / header ISP_AEWDR0_CFG_ISP_AE_WDR0: names differ, header fields not merged (strict); 0x29010 DS ISP_AEWDR0_ZONE / header ISP_AEWDR0_ZONE_ISP_AE_WDR0: names differ, header fields not merged (strict); 0x29014 DS ISP_AEWDR0_SKIP_CRG / header ISP_AEWDR0_SKIP_CRG_ISP_AE_WDR0: names differ, header fields not merged (strict); 0x29018 DS ISP_AEWDR0_TOTAL_STAT / header ISP_AEWDR0_TOTAL_STAT_ISP_AE_WDR0: names differ, header fields not merged (strict); 0x2901C DS ISP_AEWDR0_COUNT_STAT / header ISP_AEWDR0_COUNT_STAT_ISP_AE_WDR0: names differ, header fields not merged (strict); 0x29030 DS ISP_AEWDR0_HIST_HIGH / header ISP_AEWDR0_HIST_HIGH_ISP_AE_WDR0: names differ, header fields not merged (strict); 0x29040 DS ISP_AEWDR0_BITMOVE / header ISP_AEWDR0_BITMOVE_ISP_AE_WDR0: names differ, header fields not merged (strict); 0x29044 DS ISP_AEWDR0_OFFSET_R / header ISP_AEWDR0_OFFSET_R_ISP_AE_WDR0: names differ, header fields not merged (strict); 0x29048 DS ISP_AEWDR0_OFFSET_GR / header ISP_AEWDR0_OFFSET_GR_ISP_AE_WDR0: names differ, header fields not merged (strict); 0x2904C DS ISP_AEWDR0_OFFSET_GB / header ISP_AEWDR0_OFFSET_GB_ISP_AE_WDR0: names differ, header fields not merged (strict); 0x29050 DS ISP_AEWDR0_OFFSET_B / header ISP_AEWDR0_OFFSET_B_ISP_AE_WDR0: names differ, header fields not merged (strict); 0x29088 DS ISP_AEWDR0_MEM_HIST_RADDR / header ISP_AEWDR0_MEM_HIST_RADDR_ISP_AE_WDR0: names differ, header fields not merged (strict); 0x2908C ISP_AEWDR0_MEM_HIST_RDATA: overlapping data-sheet fields dropped: wei_waddr[31:0], wei_wdata[31:0]; 0x2908C DS ISP_AEWDR0_MEM_HIST_RDATA / header ISP_AEWDR0_MEM_HIST_RDATA_ISP_AE_WDR0: names differ, header fields not merged (strict); 0x290F0 DS ISP_AEWDR0_SIZE / header ISP_AEWDR0_SIZE_ISP_AE_WDR0: names differ, header fields not merged (strict); 0x29100 DS ISP_AEWDR1_CFG / header ISP_AEWDR0_CFG_ISP_AE_WDR1: names differ, header fields not merged (strict); 0x29110 DS ISP_AEWDR1_ZONE / header ISP_AEWDR0_ZONE_ISP_AE_WDR1: names differ, header fields not merged (strict); 0x29114 DS ISP_AEWDR1_SKIP_CRG / header ISP_AEWDR0_SKIP_CRG_ISP_AE_WDR1: names differ, header fields not merged (strict); 0x29118 DS ISP_AEWDR1_TOTAL_STAT / header ISP_AEWDR0_TOTAL_STAT_ISP_AE_WDR1: names differ, header fields not merged (strict); 0x2911C DS ISP_AEWDR1_COUNT_STAT / header ISP_AEWDR0_COUNT_STAT_ISP_AE_WDR1: names differ, header fields not merged (strict); 0x29130 DS ISP_AEWDR1_HIST_HIGH / header ISP_AEWDR0_HIST_HIGH_ISP_AE_WDR1: names differ, header fields not merged (strict); 0x29140 DS ISP_AEWDR1_BITMOVE / header ISP_AEWDR0_BITMOVE_ISP_AE_WDR1: names differ, header fields not merged (strict); 0x29144 DS ISP_AEWDR1_OFFSET_R / header ISP_AEWDR0_OFFSET_R_ISP_AE_WDR1: names differ, header fields not merged (strict); 0x29148 DS ISP_AEWDR1_OFFSET_GR / header ISP_AEWDR0_OFFSET_GR_ISP_AE_WDR1: names differ, header fields not merged (strict); 0x2914C DS ISP_AEWDR1_OFFSET_GB / header ISP_AEWDR0_OFFSET_GB_ISP_AE_WDR1: names differ, header fields not merged (strict); 0x29150 DS ISP_AEWDR1_OFFSET_B / header ISP_AEWDR0_OFFSET_B_ISP_AE_WDR1: names differ, header fields not merged (strict); 0x29188 DS ISP_AEWDR1_MEM_HIST_RADDR / header ISP_AEWDR0_MEM_HIST_RADDR_ISP_AE_WDR1: names differ, header fields not merged (strict); 0x2918C DS ISP_AEWDR1_MEM_HIST_RDATA / header ISP_AEWDR0_MEM_HIST_RDATA_ISP_AE_WDR1: names differ, header fields not merged (strict) (and 23 more).";

    reg {
        name = "AF control register";
        desc = "ISP_AF_CFG is an AF control register. Hi3516C V300/Hi3516E V100 Professional HD IP Camera SoC

Data sheet 10.6 ISP_AF_CFG (offset 0x12200, printed page 10-58, `hi3516cv300--Hi3516CV300-Hi3516EV100-Datasheet.txt` line 43622).";

        field {
            name = "ck_gt_en";
            desc = "AF clock gating enable";
            sw = rw;
            hw = r;
            reset = 0x0;
        } ck_gt_en[31:31];

        enum ISP_AF_CFG_fir1_ldg_en_enum {
            DISABLED = 0 { name = "Disabled"; desc = "disabled"; };
            ENABLED = 1 { name = "Enabled"; desc = "enabled"; };
        };

        field {
            name = "fir1_ldg_en";
            desc = "Vertical FIR filter luma dependent gain (LDG) enable 1";
            sw = rw;
            hw = r;
            encode = ISP_AF_CFG_fir1_ldg_en_enum;
            reset = 0x0;
        } fir1_ldg_en[24:24];

        enum ISP_AF_CFG_fir0_ldg_en_enum {
            DISABLED = 0 { name = "Disabled"; desc = "disabled"; };
            ENABLED = 1 { name = "Enabled"; desc = "enabled"; };
        };

        field {
            name = "fir0_ldg_en";
            desc = "Vertical FIR filter LDG enable 0";
            sw = rw;
            hw = r;
            encode = ISP_AF_CFG_fir0_ldg_en_enum;
            reset = 0x0;
        } fir0_ldg_en[23:23];

        enum ISP_AF_CFG_iir1_ldg_en_enum {
            DISABLED = 0 { name = "Disabled"; desc = "disabled"; };
            ENABLED = 1 { name = "Enabled"; desc = "enabled"; };
        };

        field {
            name = "iir1_ldg_en";
            desc = "Horizontal IIR filter LDG enable 1";
            sw = rw;
            hw = r;
            encode = ISP_AF_CFG_iir1_ldg_en_enum;
            reset = 0x0;
        } iir1_ldg_en[22:22];

        enum ISP_AF_CFG_iir0_ldg_en_enum {
            DISABLED = 0 { name = "Disabled"; desc = "disabled"; };
            ENABLED = 1 { name = "Enabled"; desc = "enabled"; };
        };

        field {
            name = "iir0_ldg_en";
            desc = "Horizontal IIR filter LDG enable 0";
            sw = rw;
            hw = r;
            encode = ISP_AF_CFG_iir0_ldg_en_enum;
            reset = 0x0;
        } iir0_ldg_en[21:21];

        enum ISP_AF_CFG_fir1_lpf_en_enum {
            DISABLED = 0 { name = "Disabled"; desc = "disabled"; };
            ENABLED = 1 { name = "Enabled"; desc = "enabled"; };
        };

        field {
            name = "fir1_lpf_en";
            desc = "Vertical FIR filter low pass filter (LPF) enable 1";
            sw = rw;
            hw = r;
            encode = ISP_AF_CFG_fir1_lpf_en_enum;
            reset = 0x0;
        } fir1_lpf_en[20:20];

        enum ISP_AF_CFG_fir0_lpf_en_enum {
            DISABLED = 0 { name = "Disabled"; desc = "disabled"; };
            ENABLED = 1 { name = "Enabled"; desc = "enabled"; };
        };

        field {
            name = "fir0_lpf_en";
            desc = "Vertical FIR filter LPF enable 0";
            sw = rw;
            hw = r;
            encode = ISP_AF_CFG_fir0_lpf_en_enum;
            reset = 0x0;
        } fir0_lpf_en[19:19];

        enum ISP_AF_CFG_iir1_ds_en_enum {
            DISABLED = 0 { name = "Disabled"; desc = "disabled"; };
            ENABLED = 1 { name = "Enabled"; desc = "enabled"; };
        };

        field {
            name = "iir1_ds_en";
            desc = "Horizontal IIR filter down sampling (DS) enable 1";
            sw = rw;
            hw = r;
            encode = ISP_AF_CFG_iir1_ds_en_enum;
            reset = 0x0;
        } iir1_ds_en[18:18];

        enum ISP_AF_CFG_iir0_ds_en_enum {
            DISABLED = 0 { name = "Disabled"; desc = "disabled"; };
            ENABLED = 1 { name = "Enabled"; desc = "enabled"; };
        };

        field {
            name = "iir0_ds_en";
            desc = "Horizontal IIR filter DS enable 0";
            sw = rw;
            hw = r;
            encode = ISP_AF_CFG_iir0_ds_en_enum;
            reset = 0x0;
        } iir0_ds_en[17:17];

        enum ISP_AF_CFG_bayer_mode_enum {
            RGGB = 0 { name = "Rggb"; desc = "RGGB"; };
            GRBG = 1 { name = "Grbg"; desc = "GRBG"; };
            GBRG = 2 { name = "Gbrg"; desc = "GBRG"; };
            BGGR = 3 { name = "Bggr"; desc = "BGGR"; };
        };

        field {
            name = "bayer_mode";
            desc = "AF raw format";
            sw = rw;
            hw = r;
            encode = ISP_AF_CFG_bayer_mode_enum;
            reset = 0x0;
        } bayer_mode[16:15];

        enum ISP_AF_CFG_raw_mode_enum {
            YUV_DATA = 0 { name = "Yuv Data"; desc = "YUV data"; };
            RAW_DATA = 1 { name = "Raw Data"; desc = "raw data"; };
        };

        field {
            name = "raw_mode";
            desc = "AF data format";
            sw = rw;
            hw = r;
            encode = ISP_AF_CFG_raw_mode_enum;
            reset = 0x0;
        } raw_mode[14:14];

        enum ISP_AF_CFG_sqrt_en_enum {
            DISABLED = 0 { name = "Disabled"; desc = "disabled"; };
            ENABLED = 1 { name = "Enabled"; desc = "enabled"; };
        };

        field {
            name = "sqrt_en";
            desc = "AF gamma enable";
            sw = rw;
            hw = r;
            encode = ISP_AF_CFG_sqrt_en_enum;
            reset = 0x0;
        } sqrt_en[13:13];

        enum ISP_AF_CFG_mean_en_enum {
            DISABLED = 0 { name = "Disabled"; desc = "disabled"; };
            ENABLED = 1 { name = "Enabled"; desc = "enabled"; };
        };

        field {
            name = "mean_en";
            desc = "AF median filtering enable";
            sw = rw;
            hw = r;
            encode = ISP_AF_CFG_mean_en_enum;
            reset = 0x0;
        } mean_en[12:12];

        enum ISP_AF_CFG_lpf_en_enum {
            DISABLED = 0 { name = "Disabled"; desc = "disabled"; };
            ENABLED = 1 { name = "Enabled"; desc = "enabled"; };
        };

        field {
            name = "lpf_en";
            desc = "AF low-pass filter enable";
            sw = rw;
            hw = r;
            encode = ISP_AF_CFG_lpf_en_enum;
            reset = 0x0;
        } lpf_en[11:11];

        enum ISP_AF_CFG_crop_en_enum {
            DISABLED = 0 { name = "Disabled"; desc = "disabled"; };
            ENABLED = 1 { name = "Enabled"; desc = "enabled"; };
        };

        field {
            name = "crop_en";
            desc = "AF crop enable";
            sw = rw;
            hw = r;
            encode = ISP_AF_CFG_crop_en_enum;
            reset = 0x0;
        } crop_en[10:10];

        enum ISP_AF_CFG_offset_en_enum {
            DISABLED = 0 { name = "Disabled"; desc = "disabled"; };
            ENABLED = 1 { name = "Enabled"; desc = "enabled"; };
        };

        field {
            name = "offset_en";
            desc = "offset enable";
            sw = rw;
            hw = r;
            encode = ISP_AF_CFG_offset_en_enum;
            reset = 0x0;
        } offset_en[9:9];

        enum ISP_AF_CFG_squ_mode_enum {
            STATISTICS_DIRECTLY_ACCUMULATE = 0 { name = "Statistics Directly Accumulate"; desc = "Statistics are directly accumulated."; };
            STATISTICS_ACCUMULATED_AFTER = 1 { name = "Statistics Accumulated After"; desc = "Statistics are accumulated after the square operation."; };
        };

        field {
            name = "squ_mode";
            desc = "Square mode of AF statistics";
            sw = rw;
            hw = r;
            encode = ISP_AF_CFG_squ_mode_enum;
            reset = 0x1;
        } squ_mode[8:8];

        enum ISP_AF_CFG_peak_mode_enum {
            ALL_VALUES_BLOCK = 0 { name = "All Values Block"; desc = "All values of a block are selected for statistics."; };
            MAXIMUM_VALUE_EACH = 1 { name = "Maximum Value Each"; desc = "The maximum value in each line of a block is selected for statistics."; };
        };

        field {
            name = "peak_mode";
            desc = "Peak value mode of AF statistics";
            sw = rw;
            hw = r;
            encode = ISP_AF_CFG_peak_mode_enum;
            reset = 0x1;
        } peak_mode[7:7];

        enum ISP_AF_CFG_iir1_en2_enum {
            DISABLED = 0 { name = "Disabled"; desc = "disabled"; };
            ENABLED = 1 { name = "Enabled"; desc = "enabled"; };
        };

        field {
            name = "iir1_en2";
            desc = "Enable for IIR2 among the three cascaded IIRs in group 2";
            sw = rw;
            hw = r;
            encode = ISP_AF_CFG_iir1_en2_enum;
            reset = 0x1;
        } iir1_en2[6:6];

        enum ISP_AF_CFG_iir1_en1_enum {
            DISABLED = 0 { name = "Disabled"; desc = "disabled"; };
            ENABLED = 1 { name = "Enabled"; desc = "enabled"; };
        };

        field {
            name = "iir1_en1";
            desc = "Enable for IIR1 among the three cascaded IIRs in group 2";
            sw = rw;
            hw = r;
            encode = ISP_AF_CFG_iir1_en1_enum;
            reset = 0x0;
        } iir1_en1[5:5];

        enum ISP_AF_CFG_iir1_en0_enum {
            DISABLED = 0 { name = "Disabled"; desc = "disabled"; };
            ENABLED = 1 { name = "Enabled"; desc = "enabled"; };
        };

        field {
            name = "iir1_en0";
            desc = "Enable for IIR0 among the three cascaded IIRs in group 2";
            sw = rw;
            hw = r;
            encode = ISP_AF_CFG_iir1_en0_enum;
            reset = 0x1;
        } iir1_en0[4:4];

        enum ISP_AF_CFG_iir0_en2_enum {
            DISABLED = 0 { name = "Disabled"; desc = "disabled"; };
            ENABLED = 1 { name = "Enabled"; desc = "enabled"; };
        };

        field {
            name = "iir0_en2";
            desc = "Enable for IIR2 among the three cascaded IIRs in group 1";
            sw = rw;
            hw = r;
            encode = ISP_AF_CFG_iir0_en2_enum;
            reset = 0x1;
        } iir0_en2[3:3];

        enum ISP_AF_CFG_iir0_en1_enum {
            DISABLED = 0 { name = "Disabled"; desc = "disabled"; };
            ENABLED = 1 { name = "Enabled"; desc = "enabled"; };
        };

        field {
            name = "iir0_en1";
            desc = "Enable for IIR1 among the three cascaded IIRs in group 1";
            sw = rw;
            hw = r;
            encode = ISP_AF_CFG_iir0_en1_enum;
            reset = 0x0;
        } iir0_en1[2:2];

        enum ISP_AF_CFG_iir0_en0_enum {
            DISABLED = 0 { name = "Disabled"; desc = "disabled"; };
            ENABLED = 1 { name = "Enabled"; desc = "enabled"; };
        };

        field {
            name = "iir0_en0";
            desc = "Enable for IIR0 among the three cascaded IIRs in group 1";
            sw = rw;
            hw = r;
            encode = ISP_AF_CFG_iir0_en0_enum;
            reset = 0x1;
        } iir0_en0[1:1];

        enum ISP_AF_CFG_en_enum {
            DISABLED = 0 { name = "Disabled"; desc = "disabled"; };
            ENABLED = 1 { name = "Enabled"; desc = "enabled"; };
        };

        field {
            name = "en";
            desc = "AF enable";
            sw = rw;
            hw = r;
            encode = ISP_AF_CFG_en_enum;
            reset = 0x0;
        } en[0:0];
    } ISP_AF_CFG @ 0x2200;

    reg {
        name = "AF block configuration register";
        desc = "ISP_AF_ZONE is an AF block configuration register.

Data sheet 10.6 ISP_AF_ZONE (offset 0x12210, printed page 10-60, `hi3516cv300--Hi3516CV300-Hi3516EV100-Datasheet.txt` line 43744).";

        field {
            name = "vnum";
            desc = "Number of vertical AF blocks (15 blocks at most) Blocks are in the CH_AF_CROP_SIZE region when crop_en is 1. Blocks are in the CH_AF_SIZE region when crop_en is 0.";
            sw = rw;
            hw = r;
            reset = 0xF;
        } vnum[12:8];

        field {
            name = "hnum";
            desc = "Number of horizontal AF blocks (17 blocks at most) Blocks are in the CH_AF_CROP_SIZE region when crop_en is 1. Blocks are in the CH_AF_SIZE region when crop_en is 0.";
            sw = rw;
            hw = r;
            reset = 0x11;
        } hnum[4:0];
    } ISP_AF_ZONE @ 0x2210;

    reg {
        name = "AF picture crop start coordinate register";
        desc = "ISP_AF_CROP_START is an AF picture crop start coordinate register.

Data sheet 10.6 ISP_AF_CROP_START (offset 0x12214, printed page 10-61, `hi3516cv300--Hi3516CV300-Hi3516EV100-Datasheet.txt` line 43779).";

        field {
            name = "pos_y";
            desc = "Vertical coordinate of the crop start point";
            sw = rw;
            hw = r;
            reset = 0x0;
        } pos_y[28:16];

        field {
            name = "pos_x";
            desc = "Horizontal coordinate of the crop start point";
            sw = rw;
            hw = r;
            reset = 0x0;
        } pos_x[12:0];
    } ISP_AF_CROP_START @ 0x2214;

    reg {
        name = "AF picture crop size register";
        desc = "ISP_AF_CROP_SIZE is an AF picture crop size register.

Data sheet 10.6 ISP_AF_CROP_SIZE (offset 0x12218, printed page 10-61, `hi3516cv300--Hi3516CV300-Hi3516EV100-Datasheet.txt` line 43804).";

        field {
            name = "vsize";
            desc = "Picture height after AF cropping";
            sw = rw;
            hw = r;
            reset = 0x0;
        } vsize[28:16];

        field {
            name = "hsize";
            desc = "Picture width after AF cropping";
            sw = rw;
            hw = r;
            reset = 0x0;
        } hsize[12:0];
    } ISP_AF_CROP_SIZE @ 0x2218;

    reg {
        name = "AF median filtering threshold register";
        desc = "ISP_AF_MEAN_THRES is an AF median filtering threshold register.

Data sheet 10.6 ISP_AF_MEAN_THRES (offset 0x1221C, printed page 10-62, `hi3516cv300--Hi3516CV300-Hi3516EV100-Datasheet.txt` line 43840).";

        field {
            name = "mean_thres";
            desc = "Threshold for AF median filtering";
            sw = rw;
            hw = r;
            reset = 0x0;
        } mean_thres[15:0];
    } ISP_AF_MEAN_THRES @ 0x221C;

    reg {
        name = "AF IIR filtering parameter register 0";
        desc = "ISP_AF_IIRG0 is AF IIR filtering parameter register 0.

Data sheet 10.6 ISP_AF_IIRG0 (offset 0x12220, printed page 10-62, `hi3516cv300--Hi3516CV300-Hi3516EV100-Datasheet.txt` line 43860).";

        field {
            name = "iirg0_1";
            desc = "g0 gain of AF IIR filtering group 1";
            sw = rw;
            hw = r;
            reset = 0xA1;
        } iirg0_1[23:16];

        field {
            name = "iirg0_0";
            desc = "g0 gain of AF IIR filtering group 0";
            sw = rw;
            hw = r;
            reset = 0xA0;
        } iirg0_0[7:0];
    } ISP_AF_IIRG0 @ 0x2220;

    reg {
        name = "AF IIR filtering parameter register 1";
        desc = "ISP_AF_IIRG1 is AF IIR filtering parameter register 1. Hi3516C V300/Hi3516E V100 Professional HD IP Camera SoC

Data sheet 10.6 ISP_AF_IIRG1 (offset 0x12224, printed page 10-63, `hi3516cv300--Hi3516CV300-Hi3516EV100-Datasheet.txt` line 43895).";

        field {
            name = "iirg1_1";
            desc = "g1 gain of AF IIR filtering group 1";
            sw = rw;
            hw = r;
            reset = 0x244;
        } iirg1_1[25:16];

        field {
            name = "iirg1_0";
            desc = "g1 gain of AF IIR filtering group 0";
            sw = rw;
            hw = r;
            reset = 0x1BC;
        } iirg1_0[9:0];
    } ISP_AF_IIRG1 @ 0x2224;

    reg {
        name = "AF IIR filtering parameter register 2";
        desc = "ISP_AF_IIRG2 is AF IIR filtering parameter register 2.

Data sheet 10.6 ISP_AF_IIRG2 (offset 0x12228, printed page 10-63, `hi3516cv300--Hi3516CV300-Hi3516EV100-Datasheet.txt` line 43924).";

        field {
            name = "iirg2_1";
            desc = "g2 gain of AF IIR filtering group 1";
            sw = rw;
            hw = r;
            reset = 0x328;
        } iirg2_1[25:16];

        field {
            name = "iirg2_0";
            desc = "g2 gain of AF IIR filtering group 0";
            sw = rw;
            hw = r;
            reset = 0x328;
        } iirg2_0[9:0];
    } ISP_AF_IIRG2 @ 0x2228;

    reg {
        name = "AF IIR filtering parameter register 3";
        desc = "ISP_AF_IIRG3 is AF IIR filtering parameter register 3.

Data sheet 10.6 ISP_AF_IIRG3 (offset 0x1222C, printed page 10-64, `hi3516cv300--Hi3516CV300-Hi3516EV100-Datasheet.txt` line 43958).";

        field {
            name = "iirg3_1";
            desc = "g3 gain of AF IIR filtering group 1";
            sw = rw;
            hw = r;
            reset = 0x0;
        } iirg3_1[25:16];

        field {
            name = "iirg3_0";
            desc = "g3 gain of AF IIR filtering group 0";
            sw = rw;
            hw = r;
            reset = 0x0;
        } iirg3_0[9:0];
    } ISP_AF_IIRG3 @ 0x222C;

    reg {
        name = "AF IIR filtering parameter register 4";
        desc = "ISP_AF_IIRG4 is AF IIR filtering parameter register 4.

Data sheet 10.6 ISP_AF_IIRG4 (offset 0x12230, printed page 10-64, `hi3516cv300--Hi3516CV300-Hi3516EV100-Datasheet.txt` line 43987).";

        field {
            name = "iirg4_1";
            desc = "g4 gain of AF IIR filtering group 1";
            sw = rw;
            hw = r;
            reset = 0x0;
        } iirg4_1[25:16];

        field {
            name = "iirg4_0";
            desc = "g4 gain of AF IIR filtering group 0";
            sw = rw;
            hw = r;
            reset = 0x0;
        } iirg4_0[9:0];
    } ISP_AF_IIRG4 @ 0x2230;

    reg {
        name = "AF IIR filtering parameter register 5";
        desc = "ISP_AF_IIRG5 is AF IIR filtering parameter register 5.

Data sheet 10.6 ISP_AF_IIRG5 (offset 0x12234, printed page 10-65, `hi3516cv300--Hi3516CV300-Hi3516EV100-Datasheet.txt` line 44025).";

        field {
            name = "iirg5_1";
            desc = "g5 gain of AF IIR filtering group 1";
            sw = rw;
            hw = r;
            reset = 0x284;
        } iirg5_1[25:16];

        field {
            name = "iirg5_0";
            desc = "g5 gain of AF IIR filtering group 0";
            sw = rw;
            hw = r;
            reset = 0x17C;
        } iirg5_0[9:0];
    } ISP_AF_IIRG5 @ 0x2234;

    reg {
        name = "AF IIR filtering parameter register 6";
        desc = "ISP_AF_IIRG6 is AF IIR filtering parameter register 6.

Data sheet 10.6 ISP_AF_IIRG6 (offset 0x12238, printed page 10-65, `hi3516cv300--Hi3516CV300-Hi3516EV100-Datasheet.txt` line 44054).";

        field {
            name = "iirg6_1";
            desc = "g6 gain of AF IIR filtering group 1";
            sw = rw;
            hw = r;
            reset = 0x33C;
        } iirg6_1[25:16];

        field {
            name = "iirg6_0";
            desc = "g6 gain of AF IIR filtering group 0";
            sw = rw;
            hw = r;
            reset = 0x33C;
        } iirg6_0[9:0];
    } ISP_AF_IIRG6 @ 0x2238;

    reg {
        name = "AF IIR filtering preset register";
        desc = "ISP_AF_IIRPL is an AF IIR filter preset register.

Data sheet 10.6 ISP_AF_IIRPL (offset 0x1223C, printed page 10-66, `hi3516cv300--Hi3516CV300-Hi3516EV100-Datasheet.txt` line 44093).";

        field {
            name = "iirpls_1";
            desc = "Preset shift for AF IIR filter group 1";
            sw = rw;
            hw = r;
            reset = 0x0;
        } iirpls_1[26:24];

        field {
            name = "iirplg_1";
            desc = "Preset gain for AF IIR filter group 1";
            sw = rw;
            hw = r;
            reset = 0x0;
        } iirplg_1[23:16];

        field {
            name = "iirpls_0";
            desc = "Preset shift for AF IIR filter group 0";
            sw = rw;
            hw = r;
            reset = 0x0;
        } iirpls_0[10:8];

        field {
            name = "iirplg_0";
            desc = "Preset gain for AF IIR filter group 0";
            sw = rw;
            hw = r;
            reset = 0x0;
        } iirplg_0[7:0];
    } ISP_AF_IIRPL @ 0x223C;

    reg {
        name = "AF IIR filtering shift parameter register";
        desc = "ISP_AF_SHIFT is an AF IIR filtering shift parameter register. Hi3516C V300/Hi3516E V100 Professional HD IP Camera SoC

Data sheet 10.6 ISP_AF_SHIFT (offset 0x12240, printed page 10-67, `hi3516cv300--Hi3516CV300-Hi3516EV100-Datasheet.txt` line 44130).";

        field {
            name = "iirshift1_3";
            desc = "Shift adjustment for IIR2 in AF IIR filtering group 1";
            sw = rw;
            hw = r;
            reset = 0x0;
        } iirshift1_3[30:28];

        field {
            name = "iirshift1_2";
            desc = "Shift adjustment for IIR1 in AF IIR filtering group 1";
            sw = rw;
            hw = r;
            reset = 0x0;
        } iirshift1_2[26:24];

        field {
            name = "iirshift1_1";
            desc = "Shift adjustment for IIR0 in AF IIR filtering group 1";
            sw = rw;
            hw = r;
            reset = 0x2;
        } iirshift1_1[22:20];

        field {
            name = "iirshift1_0";
            desc = "Input shift adjustment for AF IIR filtering group 1 Note the following: iirg0_1 >= 128, iirshift0_0 >= 4 iirg0_1 >= 64, iirshift0_0 >= 3 iirg0_1 >= 32, iirshift0_0 >= 2 iirg0_1 >= 16, iirshift0_0 >= 1";
            sw = rw;
            hw = r;
            reset = 0x7;
        } iirshift1_0[18:16];

        field {
            name = "iirshift0_3";
            desc = "Shift adjustment for IIR2 in AF IIR filtering group 0";
            sw = rw;
            hw = r;
            reset = 0x1;
        } iirshift0_3[14:12];

        field {
            name = "iirshift0_2";
            desc = "Shift adjustment for IIR1 in AF IIR filtering group 0";
            sw = rw;
            hw = r;
            reset = 0x0;
        } iirshift0_2[10:8];

        field {
            name = "iirshift0_1";
            desc = "Shift adjustment for IIR0 in AF IIR filtering group 0";
            sw = rw;
            hw = r;
            reset = 0x2;
        } iirshift0_1[6:4];

        field {
            name = "iirshift0_0";
            desc = "Input shift adjustment for AF IIR filtering group 0 Note the following: iirg0_0 >= 128, iirshift0_0 >= 4 iirg0_0 >= 64, iirshift0_0 >= 3 iirg0_0 >= 32, iirshift0_0 >= 2 iirg0_0 >= 16, iirshift0_0 >= 1";
            sw = rw;
            hw = r;
            reset = 0x7;
        } iirshift0_0[2:0];
    } ISP_AF_SHIFT @ 0x2240;

    reg {
        name = "AF FIR filtering parameter register 0";
        desc = "ISP_AF_FIRH0 is AF FIR filtering parameter register 0.

Data sheet 10.6 ISP_AF_FIRH0 (offset 0x12250, printed page 10-68, `hi3516cv300--Hi3516CV300-Hi3516EV100-Datasheet.txt` line 44192).";

        field {
            name = "firh0_1";
            desc = "h0 gain of AF FIR filtering group 1";
            sw = rw;
            hw = r;
            reset = 0x30;
        } firh0_1[21:16];

        field {
            name = "firh0_0";
            desc = "h0 gain of AF FIR filtering group 0";
            sw = rw;
            hw = r;
            reset = 0x30;
        } firh0_0[5:0];
    } ISP_AF_FIRH0 @ 0x2250;

    reg {
        name = "AF FIR filtering parameter register 1";
        desc = "ISP_AF_FIRH1 is AF FIR filtering parameter register 1. Hi3516C V300/Hi3516E V100 Professional HD IP Camera SoC

Data sheet 10.6 ISP_AF_FIRH1 (offset 0x12254, printed page 10-69, `hi3516cv300--Hi3516CV300-Hi3516EV100-Datasheet.txt` line 44229).";

        field {
            name = "firh1_1";
            desc = "h1 gain of AF FIR filtering group 1";
            sw = rw;
            hw = r;
            reset = 0x15;
        } firh1_1[21:16];

        field {
            name = "firh1_0";
            desc = "h1 gain of AF FIR filtering group 0";
            sw = rw;
            hw = r;
            reset = 0x2B;
        } firh1_0[5:0];
    } ISP_AF_FIRH1 @ 0x2254;

    reg {
        name = "AF FIR filtering parameter register 2";
        desc = "ISP_AF_FIRH2 is AF FIR filtering parameter register 2.

Data sheet 10.6 ISP_AF_FIRH2 (offset 0x12258, printed page 10-69, `hi3516cv300--Hi3516CV300-Hi3516EV100-Datasheet.txt` line 44258).";

        field {
            name = "firh2_1";
            desc = "h2 gain of AF FIR filtering group 1";
            sw = rw;
            hw = r;
            reset = 0x0;
        } firh2_1[21:16];

        field {
            name = "firh2_0";
            desc = "h2 gain of AF FIR filtering group 0";
            sw = rw;
            hw = r;
            reset = 0x0;
        } firh2_0[5:0];
    } ISP_AF_FIRH2 @ 0x2258;

    reg {
        name = "AF FIR filtering parameter register 3";
        desc = "ISP_AF_FIRH3 is AF FIR filtering parameter register 3.

Data sheet 10.6 ISP_AF_FIRH3 (offset 0x1225C, printed page 10-70, `hi3516cv300--Hi3516CV300-Hi3516EV100-Datasheet.txt` line 44292).";

        field {
            name = "firh3_1";
            desc = "h3 gain of AF FIR filtering group 1";
            sw = rw;
            hw = r;
            reset = 0x2B;
        } firh3_1[21:16];

        field {
            name = "firh3_0";
            desc = "h3 gain of AF FIR filtering group 0";
            sw = rw;
            hw = r;
            reset = 0x15;
        } firh3_0[5:0];
    } ISP_AF_FIRH3 @ 0x225C;

    reg {
        name = "AF FIR filtering parameter register 4";
        desc = "ISP_AF_FIRH4 is AF FIR filtering parameter register 4.

Data sheet 10.6 ISP_AF_FIRH4 (offset 0x12260, printed page 10-70, `hi3516cv300--Hi3516CV300-Hi3516EV100-Datasheet.txt` line 44321).";

        field {
            name = "firh4_1";
            desc = "h4 gain of AF FIR filtering group 1";
            sw = rw;
            hw = r;
            reset = 0x10;
        } firh4_1[21:16];

        field {
            name = "firh4_0";
            desc = "h4 gain of AF FIR filtering group 0";
            sw = rw;
            hw = r;
            reset = 0x10;
        } firh4_0[5:0];
    } ISP_AF_FIRH4 @ 0x2260;

    reg {
        name = "AF cumulative statistics shift register";
        desc = "ISP_AF_ACC_SHIFT is an AF cumulative statistics shift register.

Data sheet 10.6 ISP_AF_ACC_SHIFT (offset 0x12278, printed page 10-71, `hi3516cv300--Hi3516CV300-Hi3516EV100-Datasheet.txt` line 44360).";

        field {
            name = "acc_shift_y";
            desc = "Luminance Y statistics shift (0-15). Y in CH_AF_STAT_RDATA is shifted.";
            sw = rw;
            hw = r;
            reset = 0x2;
        } acc_shift_y[19:16];

        field {
            name = "acc_shift1_v";
            desc = "Shift of vertical FIR filtering statistics in group 1 (0-15). V2 in CH_AF_STAT_RDATA is shifted.";
            sw = rw;
            hw = r;
            reset = 0x0;
        } acc_shift1_v[15:12];

        field {
            name = "acc_shift0_v";
            desc = "Shift of vertical FIR filtering statistics in group 0 (0-15). V1 in CH_AF_STAT_RDATA is shifted.";
            sw = rw;
            hw = r;
            reset = 0x2;
        } acc_shift0_v[11:8];

        field {
            name = "acc_shift1_h";
            desc = "Shift of horizontal IIR filtering statistics in group 1 (0-15). H2 in CH_AF_STAT_RDATA is shifted.";
            sw = rw;
            hw = r;
            reset = 0x0;
        } acc_shift1_h[7:4];

        field {
            name = "acc_shift0_h";
            desc = "Shift of horizontal IIR filtering statistics in group 0 (0-15). H1 in CH_AF_STAT_RDATA is shifted.";
            sw = rw;
            hw = r;
            reset = 0x0;
        } acc_shift0_h[3:0];
    } ISP_AF_ACC_SHIFT @ 0x2278;

    reg {
        name = "AF count statistics shift register";
        desc = "ISP_AF_CNT_SHIFT is an AF count statistics shift register.

Data sheet 10.6 ISP_AF_CNT_SHIFT (offset 0x1227C, printed page 10-71, `hi3516cv300--Hi3516CV300-Hi3516EV100-Datasheet.txt` line 44394).";

        field {
            name = "cnt_shift_y";
            desc = "Luminance Y count statistics shift register.";
            sw = rw;
            hw = r;
            reset = 0x0;
        } cnt_shift_y[19:16];

        field {
            name = "cnt_shift1_v";
            desc = "Shift of vertical FIR filtering statistics in group 1 (0-15). vcnt2 in CH_AF_STAT_RDATA is shifted.";
            sw = rw;
            hw = r;
            reset = 0x0;
        } cnt_shift1_v[15:12];

        field {
            name = "cnt_shift0_v";
            desc = "Shift of vertical FIR filtering statistics in group 0 (0-15). vcnt1 in CH_AF_STAT_RDATA is shifted.";
            sw = rw;
            hw = r;
            reset = 0x2;
        } cnt_shift0_v[11:8];

        field {
            name = "cnt_shift1_h";
            desc = "Shift of horizontal IIR filtering statistics in group 1 (0-15). hcnt2 in CH_AF_STAT_RDATA is shifted.";
            sw = rw;
            hw = r;
            reset = 0x0;
        } cnt_shift1_h[7:4];

        field {
            name = "cnt_shift0_h";
            desc = "Shift of horizontal IIR filtering statistics in group 0 (0-15). hcnt1 in CH_AF_STAT_RDATA is shifted.";
            sw = rw;
            hw = r;
            reset = 0x0;
        } cnt_shift0_h[3:0];
    } ISP_AF_CNT_SHIFT @ 0x227C;

    reg {
        name = "Statistics indirect read address DR register for AF blocks";
        desc = "ISP_AF_STAT_IND_RADDR is a statistics indirect read address register for AF blocks.

Data sheet 10.6 ISP_AF_STAT_IND_RADDR (offset 0x12288, printed page 10-72, `hi3516cv300--Hi3516CV300-Hi3516EV100-Datasheet.txt` line 44435).";

        field {
            name = "af_stat_ind_raddr";
            desc = "Statistics indirect read address register for AF blocks";
            sw = rw;
            hw = r;
            reset = 0x0;
        } af_stat_ind_raddr[31:0];
    } ISP_AF_STAT_IND_RADDR @ 0x2288;

    reg {
        name = "Statistics indirect read data register TA for AF blocks";
        desc = "ISP_AF_STAT_IND_RDATA is a statistics indirect read data register for AF blocks.

Data sheet 10.6 ISP_AF_STAT_IND_RDATA (offset 0x1228C, printed page 10-72, `hi3516cv300--Hi3516CV300-Hi3516EV100-Datasheet.txt` line 44453).";

        field {
            name = "af_stat_ind_rdata";
            desc = "Statistics indirect read data register for AF blocks V1[16], H1[16], V2[16], H2[16], Y[16], hcnt1, hcnt2, vcnt1, vcnt2, and ycnt information about each block is collected for statistics. The following is the information for each address: 1: {V1 (16 bits), H1 (16 bits)} of block 1";
            sw = r;
            hw = w;
            reset = 0x0;
        } af_stat_ind_rdata[31:0];
    } ISP_AF_STAT_IND_RDATA @ 0x228C;

    reg {
        name = "Immediate update control register";
        desc = "ISP_AF_CTRL_I is an immediate update control register.

Data sheet 10.6 ISP_AF_CTRL_I (offset 0x122E4, printed page 10-73, `hi3516cv300--Hi3516CV300-Hi3516EV100-Datasheet.txt` line 44509).";

        field {
            name = "update_mode";
            desc = "ISP update mode 0 update by using ISP_AF_UPDATE 1: frame update";
            sw = rw;
            hw = r;
            reset = 0x0;
        } update_mode[0:0];
    } ISP_AF_CTRL_I @ 0x22E4;

    reg {
        name = "Configuration update register";
        desc = "ISP_AF_UPDATE is a configuration update register.

Data sheet 10.6 ISP_AF_UPDATE (offset 0x122EC, printed page 10-74, `hi3516cv300--Hi3516CV300-Hi3516EV100-Datasheet.txt` line 44540).";

        field {
            name = "update";
            desc = "ISP update register. This bit is cleared automatically for each frame.";
            sw = rw;
            hw = r;
            reset = 0x0;
        } update[0:0];
    } ISP_AF_UPDATE @ 0x22EC;

    reg {
        name = "AF picture size register";
        desc = "ISP_AF_SIZE is an AF picture size register.

Data sheet 10.6 ISP_AF_SIZE (offset 0x122F0, printed page 10-74, `hi3516cv300--Hi3516CV300-Hi3516EV100-Datasheet.txt` line 44563).";

        field {
            name = "vsize";
            desc = "AF input picture height The configured value is the actual value minus 1.";
            sw = rw;
            hw = r;
            reset = 0x437;
        } vsize[28:16];

        field {
            name = "hsize";
            desc = "AF input picture width The configured value is the actual value minus 1.";
            sw = rw;
            hw = r;
            reset = 0x77F;
        } hsize[12:0];
    } ISP_AF_SIZE @ 0x22F0;

    reg {
        name = "AF IIR filtering threshold register";
        desc = "ISP_AF_IIRTHRE is an AF IIR filtering threshold register. Hi3516C V300/Hi3516E V100 Professional HD IP Camera SoC

Data sheet 10.6 ISP_AF_IIRTHRE (offset 0x12300, printed page 10-75, `hi3516cv300--Hi3516CV300-Hi3516EV100-Datasheet.txt` line 44599).";

        field {
            name = "iir_thre1_h";
            desc = "Luma dependent high threshold of AF IIR filter group 1";
            sw = rw;
            hw = r;
            reset = 0x0;
        } iir_thre1_h[31:24];

        field {
            name = "iir_thre1_l";
            desc = "Luma dependent low threshold of AF IIR filter group 1";
            sw = rw;
            hw = r;
            reset = 0x0;
        } iir_thre1_l[23:16];

        field {
            name = "iir_thre0_h";
            desc = "Luma dependent high threshold of AF IIR filter group 0";
            sw = rw;
            hw = r;
            reset = 0x0;
        } iir_thre0_h[15:8];

        field {
            name = "iir_thre0_l";
            desc = "Luma dependent low threshold of AF IIR filter group 0";
            sw = rw;
            hw = r;
            reset = 0x0;
        } iir_thre0_l[7:0];
    } ISP_AF_IIRTHRE @ 0x2300;

    reg {
        name = "AF IIR filtering gain register";
        desc = "ISP_AF_IIRGAIN is an AF IIR filtering gain register.

Data sheet 10.6 ISP_AF_IIRGAIN (offset 0x12304, printed page 10-75, `hi3516cv300--Hi3516CV300-Hi3516EV100-Datasheet.txt` line 44621).";

        field {
            name = "iir_gain1_h";
            desc = "Luma dependent high gain of AF IIR filter group 1";
            sw = rw;
            hw = r;
            reset = 0x0;
        } iir_gain1_h[31:24];

        field {
            name = "iir_gain1_l";
            desc = "Luma dependent low gain of AF IIR filter group 1";
            sw = rw;
            hw = r;
            reset = 0x0;
        } iir_gain1_l[23:16];

        field {
            name = "iir_gain0_h";
            desc = "Luma dependent high gain of AF IIR filter group 0";
            sw = rw;
            hw = r;
            reset = 0x0;
        } iir_gain0_h[15:8];

        field {
            name = "iir_gain0_l";
            desc = "Luma dependent low gain of AF IIR filter group 0";
            sw = rw;
            hw = r;
            reset = 0x0;
        } iir_gain0_l[7:0];
    } ISP_AF_IIRGAIN @ 0x2304;

    reg {
        name = "AF IIR filtering slope register";
        desc = "ISP_AF_IIRSLOPE is an AF IIR filtering slope register. Hi3516C V300/Hi3516E V100 Professional HD IP Camera SoC

Data sheet 10.6 ISP_AF_IIRSLOPE (offset 0x12308, printed page 10-76, `hi3516cv300--Hi3516CV300-Hi3516EV100-Datasheet.txt` line 44652).";

        field {
            name = "iir_slope1_h";
            desc = "Luma dependent high slope of AF IIR filter group 1";
            sw = rw;
            hw = r;
            reset = 0x0;
        } iir_slope1_h[23:20];

        field {
            name = "iir_slope1_l";
            desc = "Luma dependent low slope of AF IIR filter group 1";
            sw = rw;
            hw = r;
            reset = 0x0;
        } iir_slope1_l[19:16];

        field {
            name = "iir_slope0_h";
            desc = "Luma dependent high slope of AF IIR filter group 0";
            sw = rw;
            hw = r;
            reset = 0x0;
        } iir_slope0_h[7:4];

        field {
            name = "iir_slope0_l";
            desc = "Luma dependent low slope of AF IIR filter group 0";
            sw = rw;
            hw = r;
            reset = 0x0;
        } iir_slope0_l[3:0];
    } ISP_AF_IIRSLOPE @ 0x2308;

    reg {
        name = "AF IIR filtering dilate register";
        desc = "ISP_AF_IIRDILATE is an AF IIR filtering dilate register.

Data sheet 10.6 ISP_AF_IIRDILATE (offset 0x1230C, printed page 10-76, `hi3516cv300--Hi3516CV300-Hi3516EV100-Datasheet.txt` line 44676).";

        enum ISP_AF_IIRDILATE_iir_dilate1_enum {
            USE_MAXIMUM_VALUE = 0 { name = "Use Maximum Value"; desc = "Use the maximum value among the adjacent 8 pixels."; };
            USE_MAXIMUM_VALUE_2 = 1 { name = "Use Maximum Value 2"; desc = "Use the maximum value among the adjacent 16 pixels."; };
            USE_MAXIMUM_VALUE_3 = 2 { name = "Use Maximum Value 3"; desc = "Use the maximum value among the adjacent 24 pixels."; };
            USE_MAXIMUM_VALUE_4 = 3 { name = "Use Maximum Value 4"; desc = "Use the maximum value among the adjacent 32 pixels."; };
            USE_MAXIMUM_VALUE_5 = 4 { name = "Use Maximum Value 5"; desc = "Use the maximum value among the adjacent 40 pixels."; };
            USE_MAXIMUM_VALUE_6 = 5 { name = "Use Maximum Value 6"; desc = "Use the maximum value among the adjacent 48 pixels."; };
            USE_MAXIMUM_VALUE_7 = 6 { name = "Use Maximum Value 7"; desc = "Use the maximum value among the adjacent 56 pixels."; };
            USE_MAXIMUM_VALUE_8 = 7 { name = "Use Maximum Value 8"; desc = "Use the maximum value among the adjacent 64 pixels."; };
        };

        field {
            name = "iir_dilate1";
            desc = "Obtain partial maximum value for calculating the IIR1 luma dependent gain. Dilate:";
            sw = rw;
            hw = r;
            encode = ISP_AF_IIRDILATE_iir_dilate1_enum;
            reset = 0x0;
        } iir_dilate1[10:8];

        enum ISP_AF_IIRDILATE_iir_dilate0_enum {
            USE_MAXIMUM_VALUE = 0 { name = "Use Maximum Value"; desc = "Use the maximum value among the adjacent 8 pixels."; };
            USE_MAXIMUM_VALUE_2 = 1 { name = "Use Maximum Value 2"; desc = "Use the maximum value among the adjacent 16 pixels."; };
            USE_MAXIMUM_VALUE_3 = 2 { name = "Use Maximum Value 3"; desc = "Use the maximum value among the adjacent 24 pixels."; };
            USE_MAXIMUM_VALUE_4 = 3 { name = "Use Maximum Value 4"; desc = "Use the maximum value among the adjacent 32 pixels."; };
            USE_MAXIMUM_VALUE_5 = 4 { name = "Use Maximum Value 5"; desc = "Use the maximum value among the adjacent 40 pixels."; };
            USE_MAXIMUM_VALUE_6 = 5 { name = "Use Maximum Value 6"; desc = "Use the maximum value among the adjacent 48 pixels."; };
            USE_MAXIMUM_VALUE_7 = 6 { name = "Use Maximum Value 7"; desc = "Use the maximum value among the adjacent 56 pixels."; };
            USE_MAXIMUM_VALUE_8 = 7 { name = "Use Maximum Value 8"; desc = "Use the maximum value among the adjacent 64 pixels."; };
        };

        field {
            name = "iir_dilate0";
            desc = "Obtain partial maximum value for calculating the IIR0 luma dependent gain. Dilate:";
            sw = rw;
            hw = r;
            encode = ISP_AF_IIRDILATE_iir_dilate0_enum;
            reset = 0x0;
        } iir_dilate0[2:0];
    } ISP_AF_IIRDILATE @ 0x230C;

    reg {
        name = "AF FIR filtering threshold register";
        desc = "ISP_AF_FIRTHRE is an AF FIR filtering threshold register.

Data sheet 10.6 ISP_AF_FIRTHRE (offset 0x12310, printed page 10-77, `hi3516cv300--Hi3516CV300-Hi3516EV100-Datasheet.txt` line 44734).";

        field {
            name = "fir_thre1_h";
            desc = "Luma dependent high threshold of AF FIR filter group 1";
            sw = rw;
            hw = r;
            reset = 0x0;
        } fir_thre1_h[31:24];

        field {
            name = "fir_thre1_l";
            desc = "Luma dependent low threshold of AF FIR filter group 1";
            sw = rw;
            hw = r;
            reset = 0x0;
        } fir_thre1_l[23:16];

        field {
            name = "fir_thre0_h";
            desc = "Luma dependent high threshold of AF FIR filter group 0";
            sw = rw;
            hw = r;
            reset = 0x0;
        } fir_thre0_h[15:8];

        field {
            name = "fir_thre0_l";
            desc = "Luma dependent low threshold of AF FIR filter group 0";
            sw = rw;
            hw = r;
            reset = 0x0;
        } fir_thre0_l[7:0];
    } ISP_AF_FIRTHRE @ 0x2310;

    reg {
        name = "AF FIR filtering gain register";
        desc = "ISP_AF_FIRGAIN is an AF FIR filtering gain register.

Data sheet 10.6 ISP_AF_FIRGAIN (offset 0x12314, printed page 10-78, `hi3516cv300--Hi3516CV300-Hi3516EV100-Datasheet.txt` line 44763).";

        field {
            name = "fir_gain1_h";
            desc = "Luma dependent high gain of AF FIR filter group 1";
            sw = rw;
            hw = r;
            reset = 0x0;
        } fir_gain1_h[31:24];

        field {
            name = "fir_gain1_l";
            desc = "Luma dependent low gain of AF FIR filter group 1";
            sw = rw;
            hw = r;
            reset = 0x0;
        } fir_gain1_l[23:16];

        field {
            name = "fir_gain0_h";
            desc = "Luma dependent high gain of AF FIR filter group 0";
            sw = rw;
            hw = r;
            reset = 0x0;
        } fir_gain0_h[15:8];

        field {
            name = "fir_gain0_l";
            desc = "Luma dependent low gain of AF FIR filter group 0";
            sw = rw;
            hw = r;
            reset = 0x0;
        } fir_gain0_l[7:0];
    } ISP_AF_FIRGAIN @ 0x2314;

    reg {
        name = "AF FIR filtering slope register";
        desc = "ISP_AF_FIRSLOPE is an AF FIR filtering slope register.

Data sheet 10.6 ISP_AF_FIRSLOPE (offset 0x12318, printed page 10-78, `hi3516cv300--Hi3516CV300-Hi3516EV100-Datasheet.txt` line 44784).";

        field {
            name = "fir_slope1_h";
            desc = "Luma dependent high slope of AF FIR filter group 1";
            sw = rw;
            hw = r;
            reset = 0x0;
        } fir_slope1_h[23:20];

        field {
            name = "fir_slope1_l";
            desc = "Luma dependent low slope of AF FIR filter group 1";
            sw = rw;
            hw = r;
            reset = 0x0;
        } fir_slope1_l[19:16];

        field {
            name = "fir_slope0_h";
            desc = "Luma dependent high slope of AF FIR filter group 0";
            sw = rw;
            hw = r;
            reset = 0x0;
        } fir_slope0_h[7:4];

        field {
            name = "fir_slope0_l";
            desc = "Luma dependent low slope of AF FIR filter group 0";
            sw = rw;
            hw = r;
            reset = 0x0;
        } fir_slope0_l[3:0];
    } ISP_AF_FIRSLOPE @ 0x2318;

    reg {
        name = "AF IIR filtering coring threshold NG register";
        desc = "ISP_AF_IIRTHRE_CORING is an AF IIR filtering coring threshold register. Hi3516C V300/Hi3516E V100 Professional HD IP Camera SoC

Data sheet 10.6 ISP_AF_IIRTHRE_CORING (offset 0x12320, printed page 10-79, `hi3516cv300--Hi3516CV300-Hi3516EV100-Datasheet.txt` line 44814).";

        field {
            name = "iir_thre1_c";
            desc = "Coring threshold of AF IIR filter group 1";
            sw = rw;
            hw = r;
            reset = 0x0;
        } iir_thre1_c[26:16];

        field {
            name = "iir_thre0_c";
            desc = "Coring threshold of AF IIR filter group 0";
            sw = rw;
            hw = r;
            reset = 0x0;
        } iir_thre0_c[10:0];
    } ISP_AF_IIRTHRE_CORING @ 0x2320;

    reg {
        name = "AF IIR filtering coring peak value NG register";
        desc = "ISP_AF_IIRPEAK_CORING is an AF IIR filtering coring peak value register.

Data sheet 10.6 ISP_AF_IIRPEAK_CORING (offset 0x12324, printed page 10-79, `hi3516cv300--Hi3516CV300-Hi3516EV100-Datasheet.txt` line 44836).";

        field {
            name = "iir_peak1_c";
            desc = "Coring peak value of AF IIR filter group 1";
            sw = rw;
            hw = r;
            reset = 0x0;
        } iir_peak1_c[26:16];

        field {
            name = "iir_peak0_c";
            desc = "Coring peak value of AF IIR filter group 0";
            sw = rw;
            hw = r;
            reset = 0x0;
        } iir_peak0_c[10:0];
    } ISP_AF_IIRPEAK_CORING @ 0x2324;

    reg {
        name = "AF IIR filtering coring slope register NG";
        desc = "ISP_AF_IIRSLOPE_CORING is an AF IIR filtering coring slope register. Hi3516C V300/Hi3516E V100 Professional HD IP Camera SoC

Data sheet 10.6 ISP_AF_IIRSLOPE_CORING (offset 0x12328, printed page 10-80, `hi3516cv300--Hi3516CV300-Hi3516EV100-Datasheet.txt` line 44867).";

        field {
            name = "iir_slope1_c";
            desc = "Coring slope of AF IIR filter group 1";
            sw = rw;
            hw = r;
            reset = 0x0;
        } iir_slope1_c[11:8];

        field {
            name = "iir_slope0_c";
            desc = "Coring slope of AF IIR filter group 0";
            sw = rw;
            hw = r;
            reset = 0x0;
        } iir_slope0_c[3:0];
    } ISP_AF_IIRSLOPE_CORING @ 0x2328;

    reg {
        name = "AF FIR filtering coring threshold NG register";
        desc = "ISP_AF_FIRTHRE_CORING is an AF FIR filtering coring threshold register.

Data sheet 10.6 ISP_AF_FIRTHRE_CORING (offset 0x12330, printed page 10-80, `hi3516cv300--Hi3516CV300-Hi3516EV100-Datasheet.txt` line 44889).";

        field {
            name = "fir_thre1_c";
            desc = "Coring threshold of AF FIR filter group 1";
            sw = rw;
            hw = r;
            reset = 0x0;
        } fir_thre1_c[26:16];

        field {
            name = "fir_thre0_c";
            desc = "Coring threshold of AF FIR filter group 0";
            sw = rw;
            hw = r;
            reset = 0x0;
        } fir_thre0_c[10:0];
    } ISP_AF_FIRTHRE_CORING @ 0x2330;

    reg {
        name = "AF FIR filtering coring peak value NG register";
        desc = "ISP_AF_FIRPEAK_CORING is an AF FIR filtering coring peak value register. Hi3516C V300/Hi3516E V100 Professional HD IP Camera SoC

Data sheet 10.6 ISP_AF_FIRPEAK_CORING (offset 0x12334, printed page 10-81, `hi3516cv300--Hi3516CV300-Hi3516EV100-Datasheet.txt` line 44920).";

        field {
            name = "fir_peak1_c";
            desc = "Coring peak value of AF FIR filter group 1";
            sw = rw;
            hw = r;
            reset = 0x0;
        } fir_peak1_c[26:16];

        field {
            name = "fir_peak0_c";
            desc = "Coring peak value of AF FIR filter group 0";
            sw = rw;
            hw = r;
            reset = 0x0;
        } fir_peak0_c[10:0];
    } ISP_AF_FIRPEAK_CORING @ 0x2334;

    reg {
        name = "AF FIR filtering coring slope register ING";
        desc = "ISP_AF_FIRSLOPE_CORING is an AF FIR filtering coring slope register.

Data sheet 10.6 ISP_AF_FIRSLOPE_CORING (offset 0x12338, printed page 10-81, `hi3516cv300--Hi3516CV300-Hi3516EV100-Datasheet.txt` line 44942).";

        field {
            name = "fir_slope1_c";
            desc = "Coring slope of AF FIR filter group 1";
            sw = rw;
            hw = r;
            reset = 0x0;
        } fir_slope1_c[11:8];

        field {
            name = "fir_slope0_c";
            desc = "Coring slope of AF FIR filter group 0";
            sw = rw;
            hw = r;
            reset = 0x0;
        } fir_slope0_c[3:0];
    } ISP_AF_FIRSLOPE_CORING @ 0x2338;

    reg {
        name = "AF highlight threshold register";
        desc = "ISP_AF_HILIGHT is an AF highlight threshold register. Hi3516C V300/Hi3516E V100 Professional HD IP Camera SoC

Data sheet 10.6 ISP_AF_HILIGHT (offset 0x12340, printed page 10-82, `hi3516cv300--Hi3516CV300-Hi3516EV100-Datasheet.txt` line 44973).";

        field {
            name = "hilight";
            desc = "AF luminance count threshold";
            sw = rw;
            hw = r;
            reset = 0x0;
        } hilight[7:0];
    } ISP_AF_HILIGHT @ 0x2340;

    reg {
        name = "AF offset configuration register";
        desc = "ISP_AF_OFFSET is an AF offset configuration register.

Data sheet 10.6 ISP_AF_OFFSET (offset 0x12344, printed page 10-82, `hi3516cv300--Hi3516CV300-Hi3516EV100-Datasheet.txt` line 44993).";

        field {
            name = "offset_gb";
            desc = "Gb component offset";
            sw = rw;
            hw = r;
            reset = 0x0;
        } offset_gb[29:16];

        field {
            name = "offset_gr";
            desc = "Gr component offset";
            sw = rw;
            hw = r;
            reset = 0x0;
        } offset_gr[13:0];
    } ISP_AF_OFFSET @ 0x2344;

    reg {
        name = "AF interrupt indicator register";
        desc = "ISP_AF_INT is an AF interrupt indicator register. Hi3516C V300/Hi3516E V100 Professional HD IP Camera SoC

Data sheet 10.6 ISP_AF_INT (offset 0x123F0, printed page 10-83, `hi3516cv300--Hi3516CV300-Hi3516EV100-Datasheet.txt` line 45027).";

        enum ISP_AF_INT_int_af_enum {
            NO_INTERRUPT_GENERATED = 0 { name = "No Interrupt Generated"; desc = "No interrupt is generated."; };
            INTERRUPT_GENERATED = 1 { name = "Interrupt Generated"; desc = "An interrupt is generated."; };
        };

        field {
            name = "int_af";
            desc = "AF interrupt indicator";
            sw = rw;
            hw = w;
            onwrite = woclr;
            encode = ISP_AF_INT_int_af_enum;
            reset = 0x0;
        } int_af[0:0];
    } ISP_AF_INT @ 0x23F0;

    reg {
        name = "AF interrupt mask register";
        desc = "ISP_AF_INT_MASK is an AF interrupt mask register.

Data sheet 10.6 ISP_AF_INT_MASK (offset 0x123F8, printed page 10-83, `hi3516cv300--Hi3516CV300-Hi3516EV100-Datasheet.txt` line 45050).";

        enum ISP_AF_INT_MASK_int_af_enum {
            MASKED = 0 { name = "Masked"; desc = "masked"; };
            ENABLED = 1 { name = "Enabled"; desc = "enabled"; };
        };

        field {
            name = "int_af";
            desc = "AF interrupt enable";
            sw = rw;
            hw = r;
            encode = ISP_AF_INT_MASK_int_af_enum;
            reset = 0x0;
        } int_af[0:0];
    } ISP_AF_INT_MASK @ 0x23F8;

    reg {
        name = "ISP FE VERSION";
        desc = "[inferred] ISP FE VERSION. Not in the data sheet. Source: OpenIPC openhisilicon `kernel/isp/arch/hi3516cv300/firmware/vreg/arch/hi3516cv300/isp_reg_define.h` (GPL-3.0 repository, HiSilicon copyright, nManager-generated 2015-12-22 \"Define all registers/tables for Hi3519\"; local copy sources/openhisilicon), union `U_ISP_FE_VERSION`, struct offset 0x10080 (GPL-3.0 repository; header offsets are ISP-core relative (data sheet offset - 0x20000), 632 of 775 data-sheet registers match it by name and offset (ISP_BLC_CFG is at 0x21100 in the data sheet and 0x1000+0x20000 in the header)). Reset value and access type unknown (modelled RW, no reset). Confidence: medium (vendor header for this chip family, not hardware verified).";

        field {
            name = "version";
            desc = "[inferred] Version. (vendor header `isp_reg_define.h` field `version`; access and reset unknown, modelled RW)";
            sw = rw;
            hw = r;
        } version[31:24];

        field {
            name = "build";
            desc = "[inferred] Build. (vendor header `isp_reg_define.h` field `build`; access and reset unknown, modelled RW)";
            sw = rw;
            hw = r;
        } build[23:16];

        field {
            name = "release";
            desc = "[inferred] Release. (vendor header `isp_reg_define.h` field `release`; access and reset unknown, modelled RW)";
            sw = rw;
            hw = r;
        } release[15:8];

        field {
            name = "customer";
            desc = "[inferred] Customer. (vendor header `isp_reg_define.h` field `customer`; access and reset unknown, modelled RW)";
            sw = rw;
            hw = r;
        } customer[7:0];
    } ISP_FE_VERSION @ 0x10080;

    reg {
        name = "ISP FE DATE";
        desc = "[inferred] ISP FE DATE. Not in the data sheet. Source: OpenIPC openhisilicon `kernel/isp/arch/hi3516cv300/firmware/vreg/arch/hi3516cv300/isp_reg_define.h` (GPL-3.0 repository, HiSilicon copyright, nManager-generated 2015-12-22 \"Define all registers/tables for Hi3519\"; local copy sources/openhisilicon), union `U_ISP_FE_DATE`, struct offset 0x10084 (GPL-3.0 repository; header offsets are ISP-core relative (data sheet offset - 0x20000), 632 of 775 data-sheet registers match it by name and offset (ISP_BLC_CFG is at 0x21100 in the data sheet and 0x1000+0x20000 in the header)). Reset value and access type unknown (modelled RW, no reset). Confidence: medium (vendor header for this chip family, not hardware verified).";

        field {
            name = "date";
            desc = "[inferred] Date. (vendor header `isp_reg_define.h` field `date`; access and reset unknown, modelled RW)";
            sw = rw;
            hw = r;
        } date[31:0];
    } ISP_FE_DATE @ 0x10084;

    reg {
        name = "ISP internal module position select register";
        desc = "ISP_FE_MODULE_POS is an ISP internal module position select register. Hi3516C V300/Hi3516E V100 Professional HD IP Camera SoC

Data sheet 10.6 ISP_FE_MODULE_POS (offset 0x20090, printed page 10-84, `hi3516cv300--Hi3516CV300-Hi3516EV100-Datasheet.txt` line 45083).";

        enum ISP_FE_MODULE_POS_nr_sel_enum {
            BNR_MODULE_BEHIND = 0 { name = "Bnr Module Behind"; desc = "The BNR module is behind the BCOM module."; };
            BNR_MODULE_BEHIND_2 = 1 { name = "Bnr Module Behind 2"; desc = "The BNR module is behind the FPN module."; };
        };

        field {
            name = "nr_sel";
            desc = "BNR position adjustment register";
            sw = rw;
            hw = r;
            encode = ISP_FE_MODULE_POS_nr_sel_enum;
            reset = 0x0;
        } nr_sel[18:18];

        enum ISP_FE_MODULE_POS_dcg_sel_enum {
            DCG_MODULE_BEHIND = 0 { name = "Dcg Module Behind"; desc = "The DCG module is behind the BLC module."; };
            DCG_MODULE_BEHIND_2 = 1 { name = "Dcg Module Behind 2"; desc = "The DCG module is behind the DRC Dither module."; };
        };

        field {
            name = "dcg_sel";
            desc = "DCG position adjustment register";
            sw = rw;
            hw = r;
            encode = ISP_FE_MODULE_POS_dcg_sel_enum;
            reset = 0x0;
        } dcg_sel[16:16];

        enum ISP_FE_MODULE_POS_dis_sel_enum {
            DIS_MODULE_BEHIND = 0 { name = "Dis Module Behind"; desc = "The DIS module is behind the DG module."; };
            DIS_MODULE_BEHIND_2 = 1 { name = "Dis Module Behind 2"; desc = "The DIS module is behind the DRC Dither module."; };
        };

        field {
            name = "dis_sel";
            desc = "DIS position adjustment register";
            sw = rw;
            hw = r;
            encode = ISP_FE_MODULE_POS_dis_sel_enum;
            reset = 0x0;
        } dis_sel[6:6];

        enum ISP_FE_MODULE_POS_af_sel_enum {
            AF_MODULE_BEHIND = 0 { name = "Af Module Behind"; desc = "The AF module is behind the DG module."; };
            AF_MODULE_BEHIND_2 = 1 { name = "Af Module Behind 2"; desc = "The AF module is behind the DRC Dither module."; };
        };

        field {
            name = "af_sel";
            desc = "AF position adjustment register";
            sw = rw;
            hw = r;
            encode = ISP_FE_MODULE_POS_af_sel_enum;
            reset = 0x0;
        } af_sel[4:4];

        enum ISP_FE_MODULE_POS_awb_sel_enum {
            AWB_MODULE_BEHIND = 0 { name = "Awb Module Behind"; desc = "The AWB module is behind the DG module."; };
            AWB_MODULE_BEHIND_2 = 1 { name = "Awb Module Behind 2"; desc = "The AWB module is behind the Expander module."; };
            AWB_MODULE_BEHIND_3 = 2 { name = "Awb Module Behind 3"; desc = "The AWB module is behind the DRC Dither module."; };
        };

        field {
            name = "awb_sel";
            desc = "AWB position adjustment register";
            sw = rw;
            hw = r;
            encode = ISP_FE_MODULE_POS_awb_sel_enum;
            reset = 0x0;
        } awb_sel[3:2];

        enum ISP_FE_MODULE_POS_ae_sel_enum {
            AE_MODULE_BEHIND = 0 { name = "Ae Module Behind"; desc = "The AE module is behind the DG module."; };
            AE_MODULE_BEHIND_2 = 1 { name = "Ae Module Behind 2"; desc = "The AE module is behind the WB module."; };
            AE_MODULE_BEHIND_3 = 2 { name = "Ae Module Behind 3"; desc = "The AE module is behind the DRC Dither module."; };
        };

        field {
            name = "ae_sel";
            desc = "AE position adjustment register";
            sw = rw;
            hw = r;
            encode = ISP_FE_MODULE_POS_ae_sel_enum;
            reset = 0x0;
        } ae_sel[1:0];
    } ISP_FE_MODULE_POS @ 0x10090;

    reg {
        name = "ISP adjustable interrupt trigger time Y configuration register";
        desc = "ISP_FE_FSTART_DELAY is an ISP adjustable interrupt trigger time configuration register.

Data sheet 10.6 ISP_FE_FSTART_DELAY (offset 0x20094, printed page 10-85, `hi3516cv300--Hi3516CV300-Hi3516EV100-Datasheet.txt` line 45138).";

        field {
            name = "delay";
            desc = "Adjustable interrupt trigger time, in the unit of hsync";
            sw = rw;
            hw = r;
            reset = 0x0;
        } delay[31:0];
    } ISP_FE_FSTART_DELAY @ 0x10094;

    reg {
        name = "User-defined register 0";
        desc = "ISP_FE_USER_DEFINE0 is user-defined register 0.

Data sheet 10.6 ISP_FE_USER_DEFINE0 (offset 0x200A0, printed page 10-85, `hi3516cv300--Hi3516CV300-Hi3516EV100-Datasheet.txt` line 45157).";

        field {
            name = "user_define0";
            desc = "User-defined register 0";
            sw = rw;
            hw = r;
            reset = 0x0;
        } user_define0[31:0];
    } ISP_FE_USER_DEFINE0 @ 0x100A0;

    reg {
        name = "User-defined register 1";
        desc = "ISP_FE_USER_DEFINE1 is user-defined register 1.

Data sheet 10.6 ISP_FE_USER_DEFINE1 (offset 0x200A4, printed page 10-85, `hi3516cv300--Hi3516CV300-Hi3516EV100-Datasheet.txt` line 45175).";

        field {
            name = "user_define1";
            desc = "User-defined register 1";
            sw = rw;
            hw = r;
            reset = 0x0;
        } user_define1[31:0];
    } ISP_FE_USER_DEFINE1 @ 0x100A4;

    reg {
        name = "ISP FE startup indicator register";
        desc = "ISP_FE_STARTUP is an ISP FE startup indicator register.

Data sheet 10.6 ISP_FE_STARTUP (offset 0x200B0, printed page 10-86, `hi3516cv300--Hi3516CV300-Hi3516EV100-Datasheet.txt` line 45200).";

        field {
            name = "fcnt";
            desc = "Frame count after startup";
            sw = r;
            hw = w;
            reset = 0x0;
        } fcnt[31:0];
    } ISP_FE_STARTUP @ 0x100B0;

    reg {
        name = "ISP interrupt indicator register";
        desc = "ISP_FE_INT is an ISP interrupt indicator register.

Data sheet 10.6 ISP_FE_INT (offset 0x200F0, printed page 10-86, `hi3516cv300--Hi3516CV300-Hi3516EV100-Datasheet.txt` line 45219).";

        field {
            name = "flick_int";
            desc = "[inferred] Flick interrupt. (bits reserved in the data sheet; vendor header `isp_reg_define.h` field `flick_int`; access and reset unknown, modelled RW)";
            sw = rw;
            hw = r;
        } flick_int[9:9];

        enum ISP_FE_INT_aewdr_int_enum {
            NO_INTERRUPT_GENERATED = 0 { name = "No Interrupt Generated"; desc = "No interrupt is generated."; };
            INTERRUPT_GENERATED = 1 { name = "Interrupt Generated"; desc = "An interrupt is generated."; };
        };

        field {
            name = "aewdr_int";
            desc = "Status of the AEWDR statistics completion interrupt";
            sw = rw;
            hw = w;
            onwrite = woclr;
            encode = ISP_FE_INT_aewdr_int_enum;
            reset = 0x0;
        } aewdr_int[8:8];

        enum ISP_FE_INT_dis_int_enum {
            NO_INTERRUPT_GENERATED = 0 { name = "No Interrupt Generated"; desc = "No interrupt is generated."; };
            INTERRUPT_GENERATED = 1 { name = "Interrupt Generated"; desc = "An interrupt is generated."; };
        };

        field {
            name = "dis_int";
            desc = "Status of the DIS statistics completion interrupt";
            sw = rw;
            hw = w;
            onwrite = woclr;
            encode = ISP_FE_INT_dis_int_enum;
            reset = 0x0;
        } dis_int[7:7];

        enum ISP_FE_INT_mg_int_enum {
            NO_INTERRUPT_GENERATED = 0 { name = "No Interrupt Generated"; desc = "No interrupt is generated."; };
            INTERRUPT_GENERATED = 1 { name = "Interrupt Generated"; desc = "An interrupt is generated."; };
        };

        field {
            name = "mg_int";
            desc = "Status of the MG statistics completion interrupt";
            sw = rw;
            hw = w;
            onwrite = woclr;
            encode = ISP_FE_INT_mg_int_enum;
            reset = 0x0;
        } mg_int[6:6];

        enum ISP_FE_INT_awb_int_enum {
            NO_INTERRUPT_GENERATED = 0 { name = "No Interrupt Generated"; desc = "No interrupt is generated."; };
            INTERRUPT_GENERATED = 1 { name = "Interrupt Generated"; desc = "An interrupt is generated."; };
        };

        field {
            name = "awb_int";
            desc = "Status of the AWB statistics completion interrupt";
            sw = rw;
            hw = w;
            onwrite = woclr;
            encode = ISP_FE_INT_awb_int_enum;
            reset = 0x0;
        } awb_int[5:5];

        enum ISP_FE_INT_ae_int_enum {
            NO_INTERRUPT_GENERATED = 0 { name = "No Interrupt Generated"; desc = "No interrupt is generated."; };
            INTERRUPT_GENERATED = 1 { name = "Interrupt Generated"; desc = "An interrupt is generated."; };
        };

        field {
            name = "ae_int";
            desc = "Status of the AE statistics completion interrupt";
            sw = rw;
            hw = w;
            onwrite = woclr;
            encode = ISP_FE_INT_ae_int_enum;
            reset = 0x0;
        } ae_int[4:4];

        enum ISP_FE_INT_fstart_delay_enum {
            NO_INTERRUPT_GENERATED = 0 { name = "No Interrupt Generated"; desc = "No interrupt is generated."; };
            INTERRUPT_GENERATED = 1 { name = "Interrupt Generated"; desc = "An interrupt is generated."; };
        };

        field {
            name = "fstart_delay";
            desc = "Status of the configurable trigger delay interrupt";
            sw = rw;
            hw = w;
            onwrite = woclr;
            encode = ISP_FE_INT_fstart_delay_enum;
            reset = 0x0;
        } fstart_delay[3:3];

        enum ISP_FE_INT_cfg_loss_enum {
            NO_INTERRUPT_GENERATED = 0 { name = "No Interrupt Generated"; desc = "No interrupt is generated."; };
            INTERRUPT_GENERATED = 1 { name = "Interrupt Generated"; desc = "An interrupt is generated."; };
        };

        field {
            name = "cfg_loss";
            desc = "Status of the register configuration loss interrupt. Writing 1 clears the interrupt.";
            sw = rw;
            hw = w;
            onwrite = woclr;
            encode = ISP_FE_INT_cfg_loss_enum;
            reset = 0x0;
        } cfg_loss[2:2];

        enum ISP_FE_INT_update_cfg_enum {
            NO_INTERRUPT_GENERATED = 0 { name = "No Interrupt Generated"; desc = "No interrupt is generated."; };
            INTERRUPT_GENERATED = 1 { name = "Interrupt Generated"; desc = "An interrupt is generated."; };
        };

        field {
            name = "update_cfg";
            desc = "Status of the register update interrupt. Writing 1 clears the interrupt.";
            sw = rw;
            hw = w;
            onwrite = woclr;
            encode = ISP_FE_INT_update_cfg_enum;
            reset = 0x0;
        } update_cfg[1:1];

        enum ISP_FE_INT_fstart_enum {
            NO_INTERRUPT_GENERATED = 0 { name = "No Interrupt Generated"; desc = "No interrupt is generated."; };
            INTERRUPT_GENERATED = 1 { name = "Interrupt Generated"; desc = "An interrupt is generated."; };
        };

        field {
            name = "fstart";
            desc = "Status of the ISP frame start interrupt. Writing 1 clears the interrupt.";
            sw = rw;
            hw = w;
            onwrite = woclr;
            encode = ISP_FE_INT_fstart_enum;
            reset = 0x0;
        } fstart[0:0];
    } ISP_FE_INT @ 0x100F0;

    reg {
        name = "ISP interrupt mask register";
        desc = "ISP_FE_INT_MASK is an ISP interrupt mask register.

Data sheet 10.6 ISP_FE_INT_MASK (offset 0x200F8, printed page 10-87, `hi3516cv300--Hi3516CV300-Hi3516EV100-Datasheet.txt` line 45288).";

        field {
            name = "flick_int";
            desc = "[inferred] Flick interrupt. (bits reserved in the data sheet; vendor header `isp_reg_define.h` field `flick_int`; access and reset unknown, modelled RW)";
            sw = rw;
            hw = r;
        } flick_int[9:9];

        enum ISP_FE_INT_MASK_aewdr_int_enum {
            DISABLED = 0 { name = "Disabled"; desc = "disabled"; };
            ENABLED = 1 { name = "Enabled"; desc = "enabled"; };
        };

        field {
            name = "aewdr_int";
            desc = "AEWDR statistics completion interrupt enable";
            sw = rw;
            hw = r;
            encode = ISP_FE_INT_MASK_aewdr_int_enum;
            reset = 0x0;
        } aewdr_int[8:8];

        enum ISP_FE_INT_MASK_dis_int_enum {
            DISABLED = 0 { name = "Disabled"; desc = "disabled"; };
            ENABLED = 1 { name = "Enabled"; desc = "enabled"; };
        };

        field {
            name = "dis_int";
            desc = "DIS statistics completion interrupt enable";
            sw = rw;
            hw = r;
            encode = ISP_FE_INT_MASK_dis_int_enum;
            reset = 0x0;
        } dis_int[7:7];

        enum ISP_FE_INT_MASK_mg_int_enum {
            DISABLED = 0 { name = "Disabled"; desc = "disabled"; };
            ENABLED = 1 { name = "Enabled"; desc = "enabled"; };
        };

        field {
            name = "mg_int";
            desc = "MG statistics completion interrupt enable";
            sw = rw;
            hw = r;
            encode = ISP_FE_INT_MASK_mg_int_enum;
            reset = 0x0;
        } mg_int[6:6];

        enum ISP_FE_INT_MASK_awb_int_enum {
            DISABLED = 0 { name = "Disabled"; desc = "disabled"; };
            ENABLED = 1 { name = "Enabled"; desc = "enabled"; };
        };

        field {
            name = "awb_int";
            desc = "AWB statistics completion interrupt enable";
            sw = rw;
            hw = r;
            encode = ISP_FE_INT_MASK_awb_int_enum;
            reset = 0x0;
        } awb_int[5:5];

        enum ISP_FE_INT_MASK_ae_int_enum {
            DISABLED = 0 { name = "Disabled"; desc = "disabled"; };
            ENABLED = 1 { name = "Enabled"; desc = "enabled"; };
        };

        field {
            name = "ae_int";
            desc = "AE statistics completion interrupt enable";
            sw = rw;
            hw = r;
            encode = ISP_FE_INT_MASK_ae_int_enum;
            reset = 0x0;
        } ae_int[4:4];

        enum ISP_FE_INT_MASK_int_delay_enum {
            DISABLED = 0 { name = "Disabled"; desc = "disabled"; };
            ENABLED = 1 { name = "Enabled"; desc = "enabled"; };
        };

        field {
            name = "int_delay";
            desc = "Configurable trigger delay interrupt enable";
            sw = rw;
            hw = r;
            encode = ISP_FE_INT_MASK_int_delay_enum;
            reset = 0x0;
        } int_delay[3:3];

        enum ISP_FE_INT_MASK_cfg_loss_enum {
            DISABLED = 0 { name = "Disabled"; desc = "disabled"; };
            ENABLED = 1 { name = "Enabled"; desc = "enabled"; };
        };

        field {
            name = "cfg_loss";
            desc = "Register configuration loss interrupt enable";
            sw = rw;
            hw = r;
            encode = ISP_FE_INT_MASK_cfg_loss_enum;
            reset = 0x0;
        } cfg_loss[2:2];

        enum ISP_FE_INT_MASK_update_cfg_enum {
            DISABLED = 0 { name = "Disabled"; desc = "disabled"; };
            ENABLED = 1 { name = "Enabled"; desc = "enabled"; };
        };

        field {
            name = "update_cfg";
            desc = "Register update interrupt enable";
            sw = rw;
            hw = r;
            encode = ISP_FE_INT_MASK_update_cfg_enum;
            reset = 0x0;
        } update_cfg[1:1];

        enum ISP_FE_INT_MASK_fstart_enum {
            DISABLED = 0 { name = "Disabled"; desc = "disabled"; };
            ENABLED = 1 { name = "Enabled"; desc = "enabled"; };
        };

        field {
            name = "fstart";
            desc = "ISP frame start interrupt enable";
            sw = rw;
            hw = r;
            encode = ISP_FE_INT_MASK_fstart_enum;
            reset = 0x0;
        } fstart[0:0];
    } ISP_FE_INT_MASK @ 0x100F8;

    reg {
        name = "ISP common update control register";
        desc = "ISP_FE_CTRL_F is an ISP common update control register. Hi3516C V300/Hi3516E V100 Professional HD IP Camera SoC

Data sheet 10.6 ISP_FE_CTRL_F (offset 0x201E0, printed page 10-89, `hi3516cv300--Hi3516CV300-Hi3516EV100-Datasheet.txt` line 45360).";

        enum ISP_FE_CTRL_F_rggb_cfg_enum {
            R_GR_GB = 0 { name = "R Gr Gb"; desc = "R Gr Gb B"; };
            GR_R_B = 1 { name = "Gr R B"; desc = "Gr R B Gb"; };
            GB_B_R = 2 { name = "Gb B R"; desc = "Gb B R Gr"; };
            B_GB_GR = 3 { name = "B Gb Gr"; desc = "B Gb Gr R"; };
        };

        field {
            name = "rggb_cfg";
            desc = "RGGB start";
            sw = rw;
            hw = r;
            encode = ISP_FE_CTRL_F_rggb_cfg_enum;
            reset = 0x3;
        } rggb_cfg[1:0];
    } ISP_FE_CTRL_F @ 0x101E0;

    reg {
        name = "ISP immediate update control register";
        desc = "ISP_FE_CTRL_I is an ISP immediate update control register.

Data sheet 10.6 ISP_FE_CTRL_I (offset 0x201E4, printed page 10-89, `hi3516cv300--Hi3516CV300-Hi3516EV100-Datasheet.txt` line 45389).";

        enum ISP_FE_CTRL_I_update_mode_enum {
            UPDATING_USING_ISP = 0 { name = "Updating Using Isp"; desc = "updating by using ISP_FE_REG_UPDATE"; };
            FRAME_UPDATE = 1 { name = "Frame Update"; desc = "frame update"; };
        };

        field {
            name = "update_mode";
            desc = "ISP register update mode";
            sw = rw;
            hw = r;
            encode = ISP_FE_CTRL_I_update_mode_enum;
            reset = 0x0;
        } update_mode[0:0];
    } ISP_FE_CTRL_I @ 0x101E4;

    reg {
        name = "Output timing configuration register";
        desc = "ISP_FE_TIMING_CFG is an output timing configuration register. Hi3516C V300/Hi3516E V100 Professional HD IP Camera SoC

Data sheet 10.6 ISP_FE_TIMING_CFG (offset 0x201E8, printed page 10-90, `hi3516cv300--Hi3516CV300-Hi3516EV100-Datasheet.txt` line 45425).";

        field {
            name = "fix_timing";
            desc = "Manual timing parameter configuration, for setting the length of the generated horizontal blanking region";
            sw = rw;
            hw = r;
            reset = 0x40;
        } fix_timing[13:1];
    } ISP_FE_TIMING_CFG @ 0x101E8;

    reg {
        name = "Register update register";
        desc = "ISP_FE_REG_UPDATE is a register update register.

Data sheet 10.6 ISP_FE_REG_UPDATE (offset 0x201EC, printed page 10-90, `hi3516cv300--Hi3516CV300-Hi3516EV100-Datasheet.txt` line 45450).";

        field {
            name = "update";
            desc = "ISP update register. This bit is automatically cleared for each frame.";
            sw = rw;
            hw = r;
            reset = 0x0;
        } update[0:0];
    } ISP_FE_REG_UPDATE @ 0x101EC;

    reg {
        name = "Crop enable register";
        desc = "ISP_CROP0_CFG is a crop enable register. Hi3516C V300/Hi3516E V100 Professional HD IP Camera SoC

Data sheet 10.6 ISP_CROP0_CFG (offset 0x20800, printed page 10-91, `hi3516cv300--Hi3516CV300-Hi3516EV100-Datasheet.txt` line 45482).";

        enum ISP_CROP0_CFG_n0_en_enum {
            DISABLED = 0 { name = "Disabled"; desc = "disabled"; };
            ENABLED = 1 { name = "Enabled"; desc = "enabled"; };
        };

        field {
            name = "n0_en";
            desc = "Region 0 enable";
            sw = rw;
            hw = r;
            encode = ISP_CROP0_CFG_n0_en_enum;
            reset = 0x0;
        } n0_en[0:0];
    } ISP_CROP0_CFG @ 0x10800;

    reg {
        name = "ISP CROP0 RESERVED";
        desc = "[inferred] ISP CROP0 RESERVED. Not in the data sheet. Source: OpenIPC openhisilicon `kernel/isp/arch/hi3516cv300/firmware/vreg/arch/hi3516cv300/isp_reg_define.h` (GPL-3.0 repository, HiSilicon copyright, nManager-generated 2015-12-22 \"Define all registers/tables for Hi3519\"; local copy sources/openhisilicon), union `U_ISP_CROP0_RESERVED`, struct offset 0x10804 (GPL-3.0 repository; header offsets are ISP-core relative (data sheet offset - 0x20000), 632 of 775 data-sheet registers match it by name and offset (ISP_BLC_CFG is at 0x21100 in the data sheet and 0x1000+0x20000 in the header)). Reset value and access type unknown (modelled RW, no reset). Confidence: medium (vendor header for this chip family, not hardware verified).";

        field {
            name = "value";
            desc = "[inferred] Register value (the header union has no named bits).";
            sw = rw;
            hw = r;
        } value[31:0];
    } ISP_CROP0_RESERVED @ 0x10804;

    reg {
        name = "Region 0 crop start position register";
        desc = "ISP_CROP0_START is a region 0 crop start position register.

Data sheet 10.6 ISP_CROP0_START (offset 0x20808, printed page 10-91, `hi3516cv300--Hi3516CV300-Hi3516EV100-Datasheet.txt` line 45505).";

        field {
            name = "y_start";
            desc = "Row for starting obtaining the picture";
            sw = rw;
            hw = r;
            reset = 0x0;
        } y_start[28:16];

        field {
            name = "x_start";
            desc = "Pixel for starting obtaining the picture";
            sw = rw;
            hw = r;
            reset = 0x0;
        } x_start[12:0];
    } ISP_CROP0_START @ 0x10808;

    reg {
        name = "Region 0 crop size register";
        desc = "ISP_CROP0_SIZE is a region 0 crop size register. Hi3516C V300/Hi3516E V100 Professional HD IP Camera SoC

Data sheet 10.6 ISP_CROP0_SIZE (offset 0x2080C, printed page 10-92, `hi3516cv300--Hi3516CV300-Hi3516EV100-Datasheet.txt` line 45539).";

        field {
            name = "height";
            desc = "Obtained picture height (in the unit of row) The configured value is the actual value minus 1.";
            sw = rw;
            hw = r;
            reset = 0x0;
        } height[28:16];

        field {
            name = "width";
            desc = "Obtained picture width (in the unit of pixel) The configured value is the actual value minus 1.";
            sw = rw;
            hw = r;
            reset = 0x0;
        } width[12:0];
    } ISP_CROP0_SIZE @ 0x1080C;

    reg {
        name = "ISP DRC dither register";
        desc = "ISP_DRC_DITHER is an ISP DRC dither register.

Data sheet 10.6 ISP_DRC_DITHER (offset 0x20820, printed page 10-92, `hi3516cv300--Hi3516CV300-Hi3516EV100-Datasheet.txt` line 45568).";

        enum ISP_DRC_DITHER_out_bits_enum {
            V_8_BITS = 8 { name = "V 8 Bits"; desc = "8 bits"; };
            V_10_BITS = 10 { name = "V 10 Bits"; desc = "10 bits"; };
            V_12_BITS = 12 { name = "V 12 Bits"; desc = "12 bits"; };
            V_14_BITS_OTHER = 14 { name = "V 14 Bits Other"; desc = "14 bits Other values: forbidden"; };
        };

        field {
            name = "out_bits";
            desc = "Output bit width";
            sw = rw;
            hw = r;
            encode = ISP_DRC_DITHER_out_bits_enum;
            reset = 0x0;
        } out_bits[7:4];

        enum ISP_DRC_DITHER_spatial_mode_enum {
            DISABLED = 0 { name = "Disabled"; desc = "disabled"; };
            ENABLED = 1 { name = "Enabled"; desc = "enabled"; };
        };

        field {
            name = "spatial_mode";
            desc = "Spatial mode enable";
            sw = rw;
            hw = r;
            encode = ISP_DRC_DITHER_spatial_mode_enum;
            reset = 0x1;
        } spatial_mode[3:3];

        enum ISP_DRC_DITHER_isp_dither_round_enum {
            TRUNCATION = 0 { name = "Truncation"; desc = "truncation"; };
            ROUND_OFF = 1 { name = "Round Off"; desc = "round off"; };
            RANDOM = 2 { name = "Random"; desc = "random"; };
        };

        field {
            name = "isp_dither_round";
            desc = "Dither mode select";
            sw = rw;
            hw = r;
            encode = ISP_DRC_DITHER_isp_dither_round_enum;
            reset = 0x0;
        } isp_dither_round[2:1];

        enum ISP_DRC_DITHER_isp_dither_en_enum {
            DISABLED = 0 { name = "Disabled"; desc = "disabled"; };
            ENABLED = 1 { name = "Enabled"; desc = "enabled"; };
        };

        field {
            name = "isp_dither_en";
            desc = "Dither enable";
            sw = rw;
            hw = r;
            encode = ISP_DRC_DITHER_isp_dither_en_enum;
            reset = 0x0;
        } isp_dither_en[0:0];
    } ISP_DRC_DITHER @ 0x10820;

    reg {
        name = "ISP internal module position select register";
        desc = "ISP_INPUT_MUX is an ISP internal module position select register.

Data sheet 10.6 ISP_INPUT_MUX (offset 0x20830, printed page 10-93, `hi3516cv300--Hi3516CV300-Hi3516EV100-Datasheet.txt` line 45622).";

        enum ISP_INPUT_MUX_input4_sel_enum {
            CHANNEL_0 = 0 { name = "Channel 0"; desc = "channel 0"; };
            CHANNEL_1 = 1 { name = "Channel 1"; desc = "channel 1"; };
            CHANNEL_2 = 2 { name = "Channel 2"; desc = "channel 2"; };
            CHANNEL_3 = 3 { name = "Channel 3"; desc = "channel 3"; };
            FPN_BLACK_FRAME = 4 { name = "Fpn Black Frame"; desc = "FPN black frame input Other: reserved"; };
        };

        field {
            name = "input4_sel";
            desc = "ISP FPN data input select";
            sw = rw;
            hw = r;
            encode = ISP_INPUT_MUX_input4_sel_enum;
            reset = 0x4;
        } input4_sel[18:16];

        enum ISP_INPUT_MUX_input3_sel_enum {
            CHANNEL_0 = 0 { name = "Channel 0"; desc = "channel 0"; };
            CHANNEL_1 = 1 { name = "Channel 1"; desc = "channel 1"; };
            CHANNEL_2 = 2 { name = "Channel 2"; desc = "channel 2"; };
            CHANNEL_3 = 3 { name = "Channel 3"; desc = "channel 3"; };
            FPN_BLACK_FRAME = 4 { name = "Fpn Black Frame"; desc = "FPN black frame input Other: reserved"; };
        };

        field {
            name = "input3_sel";
            desc = "ISP channel 3 data input select";
            sw = rw;
            hw = r;
            encode = ISP_INPUT_MUX_input3_sel_enum;
            reset = 0x3;
        } input3_sel[14:12];

        enum ISP_INPUT_MUX_input2_sel_enum {
            CHANNEL_0 = 0 { name = "Channel 0"; desc = "channel 0"; };
            CHANNEL_1 = 1 { name = "Channel 1"; desc = "channel 1"; };
            CHANNEL_2 = 2 { name = "Channel 2"; desc = "channel 2"; };
            CHANNEL_3 = 3 { name = "Channel 3"; desc = "channel 3"; };
            FPN_BLACK_FRAME = 4 { name = "Fpn Black Frame"; desc = "FPN black frame input Other: reserved"; };
        };

        field {
            name = "input2_sel";
            desc = "ISP channel 2 data input select";
            sw = rw;
            hw = r;
            encode = ISP_INPUT_MUX_input2_sel_enum;
            reset = 0x2;
        } input2_sel[10:8];

        enum ISP_INPUT_MUX_input1_sel_enum {
            CHANNEL_0 = 0 { name = "Channel 0"; desc = "channel 0"; };
            CHANNEL_1 = 1 { name = "Channel 1"; desc = "channel 1"; };
            CHANNEL_2 = 2 { name = "Channel 2"; desc = "channel 2"; };
            CHANNEL_3 = 3 { name = "Channel 3"; desc = "channel 3"; };
            FPN_BLACK_FRAME = 4 { name = "Fpn Black Frame"; desc = "FPN black frame input Other: reserved"; };
        };

        field {
            name = "input1_sel";
            desc = "ISP channel 1 data input select";
            sw = rw;
            hw = r;
            encode = ISP_INPUT_MUX_input1_sel_enum;
            reset = 0x1;
        } input1_sel[6:4];

        enum ISP_INPUT_MUX_input0_sel_enum {
            CHANNEL_0 = 0 { name = "Channel 0"; desc = "channel 0"; };
            CHANNEL_1 = 1 { name = "Channel 1"; desc = "channel 1"; };
            CHANNEL_2 = 2 { name = "Channel 2"; desc = "channel 2"; };
            CHANNEL_3 = 3 { name = "Channel 3"; desc = "channel 3"; };
            FPN_BLACK_FRAME = 4 { name = "Fpn Black Frame"; desc = "FPN black frame input Other: reserved"; };
        };

        field {
            name = "input0_sel";
            desc = "ISP channel 0 data input select";
            sw = rw;
            hw = r;
            encode = ISP_INPUT_MUX_input0_sel_enum;
            reset = 0x0;
        } input0_sel[2:0];
    } ISP_INPUT_MUX @ 0x10830;

    reg {
        name = "ISP FE BLACK SUM configuration";
        desc = "[inferred] ISP FE BLACK SUM configuration. Not in the data sheet. Source: OpenIPC openhisilicon `kernel/isp/arch/hi3516cv300/firmware/vreg/arch/hi3516cv300/isp_reg_define.h` (GPL-3.0 repository, HiSilicon copyright, nManager-generated 2015-12-22 \"Define all registers/tables for Hi3519\"; local copy sources/openhisilicon), union `U_ISP_FE_BLACK_SUM_CFG`, struct offset 0x10840 (GPL-3.0 repository; header offsets are ISP-core relative (data sheet offset - 0x20000), 632 of 775 data-sheet registers match it by name and offset (ISP_BLC_CFG is at 0x21100 in the data sheet and 0x1000+0x20000 in the header)). Reset value and access type unknown (modelled RW, no reset). Confidence: medium (vendor header for this chip family, not hardware verified).";

        field {
            name = "en";
            desc = "[inferred] Enable. (vendor header `isp_reg_define.h` field `en`; access and reset unknown, modelled RW)";
            sw = rw;
            hw = r;
        } en[0:0];
    } ISP_FE_BLACK_SUM_CFG @ 0x10840;

    reg {
        name = "ISP FE BAYER SUM configuration";
        desc = "[inferred] ISP FE BAYER SUM configuration. Not in the data sheet. Source: OpenIPC openhisilicon `kernel/isp/arch/hi3516cv300/firmware/vreg/arch/hi3516cv300/isp_reg_define.h` (GPL-3.0 repository, HiSilicon copyright, nManager-generated 2015-12-22 \"Define all registers/tables for Hi3519\"; local copy sources/openhisilicon), union `U_ISP_FE_BAYER_SUM_CFG`, struct offset 0x10844 (GPL-3.0 repository; header offsets are ISP-core relative (data sheet offset - 0x20000), 632 of 775 data-sheet registers match it by name and offset (ISP_BLC_CFG is at 0x21100 in the data sheet and 0x1000+0x20000 in the header)). Reset value and access type unknown (modelled RW, no reset). Confidence: medium (vendor header for this chip family, not hardware verified).";

        field {
            name = "en";
            desc = "[inferred] Enable. (vendor header `isp_reg_define.h` field `en`; access and reset unknown, modelled RW)";
            sw = rw;
            hw = r;
        } en[0:0];
    } ISP_FE_BAYER_SUM_CFG @ 0x10844;

    reg {
        name = "ISP FE WDR SUM configuration";
        desc = "[inferred] ISP FE WDR SUM configuration. Not in the data sheet. Source: OpenIPC openhisilicon `kernel/isp/arch/hi3516cv300/firmware/vreg/arch/hi3516cv300/isp_reg_define.h` (GPL-3.0 repository, HiSilicon copyright, nManager-generated 2015-12-22 \"Define all registers/tables for Hi3519\"; local copy sources/openhisilicon), union `U_ISP_FE_WDR_SUM_CFG`, struct offset 0x10848 (GPL-3.0 repository; header offsets are ISP-core relative (data sheet offset - 0x20000), 632 of 775 data-sheet registers match it by name and offset (ISP_BLC_CFG is at 0x21100 in the data sheet and 0x1000+0x20000 in the header)). Reset value and access type unknown (modelled RW, no reset). Confidence: medium (vendor header for this chip family, not hardware verified).";

        field {
            name = "en";
            desc = "[inferred] Enable. (vendor header `isp_reg_define.h` field `en`; access and reset unknown, modelled RW)";
            sw = rw;
            hw = r;
        } en[0:0];
    } ISP_FE_WDR_SUM_CFG @ 0x10848;

    reg {
        name = "ISP FE BLACK SUM0";
        desc = "[inferred] ISP FE BLACK SUM0. Not in the data sheet. Source: OpenIPC openhisilicon `kernel/isp/arch/hi3516cv300/firmware/vreg/arch/hi3516cv300/isp_reg_define.h` (GPL-3.0 repository, HiSilicon copyright, nManager-generated 2015-12-22 \"Define all registers/tables for Hi3519\"; local copy sources/openhisilicon), union `U_ISP_FE_BLACK_SUM0`, struct offset 0x10880 (GPL-3.0 repository; header offsets are ISP-core relative (data sheet offset - 0x20000), 632 of 775 data-sheet registers match it by name and offset (ISP_BLC_CFG is at 0x21100 in the data sheet and 0x1000+0x20000 in the header)). Reset value and access type unknown (modelled RW, no reset). Confidence: medium (vendor header for this chip family, not hardware verified).";

        field {
            name = "sum";
            desc = "[inferred] Sum. (vendor header `isp_reg_define.h` field `sum`; access and reset unknown, modelled RW)";
            sw = rw;
            hw = r;
        } sum[31:0];
    } ISP_FE_BLACK_SUM0 @ 0x10880;

    reg {
        name = "ISP FE BLACK SUM1";
        desc = "[inferred] ISP FE BLACK SUM1. Not in the data sheet. Source: OpenIPC openhisilicon `kernel/isp/arch/hi3516cv300/firmware/vreg/arch/hi3516cv300/isp_reg_define.h` (GPL-3.0 repository, HiSilicon copyright, nManager-generated 2015-12-22 \"Define all registers/tables for Hi3519\"; local copy sources/openhisilicon), union `U_ISP_FE_BLACK_SUM1`, struct offset 0x10884 (GPL-3.0 repository; header offsets are ISP-core relative (data sheet offset - 0x20000), 632 of 775 data-sheet registers match it by name and offset (ISP_BLC_CFG is at 0x21100 in the data sheet and 0x1000+0x20000 in the header)). Reset value and access type unknown (modelled RW, no reset). Confidence: medium (vendor header for this chip family, not hardware verified).";

        field {
            name = "sum";
            desc = "[inferred] Sum. (vendor header `isp_reg_define.h` field `sum`; access and reset unknown, modelled RW)";
            sw = rw;
            hw = r;
        } sum[31:0];
    } ISP_FE_BLACK_SUM1 @ 0x10884;

    reg {
        name = "ISP FE BAYER SUM0";
        desc = "[inferred] ISP FE BAYER SUM0. Not in the data sheet. Source: OpenIPC openhisilicon `kernel/isp/arch/hi3516cv300/firmware/vreg/arch/hi3516cv300/isp_reg_define.h` (GPL-3.0 repository, HiSilicon copyright, nManager-generated 2015-12-22 \"Define all registers/tables for Hi3519\"; local copy sources/openhisilicon), union `U_ISP_FE_BAYER_SUM0`, struct offset 0x10888 (GPL-3.0 repository; header offsets are ISP-core relative (data sheet offset - 0x20000), 632 of 775 data-sheet registers match it by name and offset (ISP_BLC_CFG is at 0x21100 in the data sheet and 0x1000+0x20000 in the header)). Reset value and access type unknown (modelled RW, no reset). Confidence: medium (vendor header for this chip family, not hardware verified).";

        field {
            name = "sum";
            desc = "[inferred] Sum. (vendor header `isp_reg_define.h` field `sum`; access and reset unknown, modelled RW)";
            sw = rw;
            hw = r;
        } sum[31:0];
    } ISP_FE_BAYER_SUM0 @ 0x10888;

    reg {
        name = "ISP FE BAYER SUM1";
        desc = "[inferred] ISP FE BAYER SUM1. Not in the data sheet. Source: OpenIPC openhisilicon `kernel/isp/arch/hi3516cv300/firmware/vreg/arch/hi3516cv300/isp_reg_define.h` (GPL-3.0 repository, HiSilicon copyright, nManager-generated 2015-12-22 \"Define all registers/tables for Hi3519\"; local copy sources/openhisilicon), union `U_ISP_FE_BAYER_SUM1`, struct offset 0x1088C (GPL-3.0 repository; header offsets are ISP-core relative (data sheet offset - 0x20000), 632 of 775 data-sheet registers match it by name and offset (ISP_BLC_CFG is at 0x21100 in the data sheet and 0x1000+0x20000 in the header)). Reset value and access type unknown (modelled RW, no reset). Confidence: medium (vendor header for this chip family, not hardware verified).";

        field {
            name = "sum";
            desc = "[inferred] Sum. (vendor header `isp_reg_define.h` field `sum`; access and reset unknown, modelled RW)";
            sw = rw;
            hw = r;
        } sum[31:0];
    } ISP_FE_BAYER_SUM1 @ 0x1088C;

    reg {
        name = "ISP FE WDR0 SUM0";
        desc = "[inferred] ISP FE WDR0 SUM0. Not in the data sheet. Source: OpenIPC openhisilicon `kernel/isp/arch/hi3516cv300/firmware/vreg/arch/hi3516cv300/isp_reg_define.h` (GPL-3.0 repository, HiSilicon copyright, nManager-generated 2015-12-22 \"Define all registers/tables for Hi3519\"; local copy sources/openhisilicon), union `U_ISP_FE_WDR0_SUM0`, struct offset 0x10890 (GPL-3.0 repository; header offsets are ISP-core relative (data sheet offset - 0x20000), 632 of 775 data-sheet registers match it by name and offset (ISP_BLC_CFG is at 0x21100 in the data sheet and 0x1000+0x20000 in the header)). Reset value and access type unknown (modelled RW, no reset). Confidence: medium (vendor header for this chip family, not hardware verified).";

        field {
            name = "sum";
            desc = "[inferred] Sum. (vendor header `isp_reg_define.h` field `sum`; access and reset unknown, modelled RW)";
            sw = rw;
            hw = r;
        } sum[31:0];
    } ISP_FE_WDR0_SUM0 @ 0x10890;

    reg {
        name = "ISP FE WDR0 SUM1";
        desc = "[inferred] ISP FE WDR0 SUM1. Not in the data sheet. Source: OpenIPC openhisilicon `kernel/isp/arch/hi3516cv300/firmware/vreg/arch/hi3516cv300/isp_reg_define.h` (GPL-3.0 repository, HiSilicon copyright, nManager-generated 2015-12-22 \"Define all registers/tables for Hi3519\"; local copy sources/openhisilicon), union `U_ISP_FE_WDR0_SUM1`, struct offset 0x10894 (GPL-3.0 repository; header offsets are ISP-core relative (data sheet offset - 0x20000), 632 of 775 data-sheet registers match it by name and offset (ISP_BLC_CFG is at 0x21100 in the data sheet and 0x1000+0x20000 in the header)). Reset value and access type unknown (modelled RW, no reset). Confidence: medium (vendor header for this chip family, not hardware verified).";

        field {
            name = "sum";
            desc = "[inferred] Sum. (vendor header `isp_reg_define.h` field `sum`; access and reset unknown, modelled RW)";
            sw = rw;
            hw = r;
        } sum[31:0];
    } ISP_FE_WDR0_SUM1 @ 0x10894;

    reg {
        name = "ISP FE WDR1 SUM0";
        desc = "[inferred] ISP FE WDR1 SUM0. Not in the data sheet. Source: OpenIPC openhisilicon `kernel/isp/arch/hi3516cv300/firmware/vreg/arch/hi3516cv300/isp_reg_define.h` (GPL-3.0 repository, HiSilicon copyright, nManager-generated 2015-12-22 \"Define all registers/tables for Hi3519\"; local copy sources/openhisilicon), union `U_ISP_FE_WDR1_SUM0`, struct offset 0x10898 (GPL-3.0 repository; header offsets are ISP-core relative (data sheet offset - 0x20000), 632 of 775 data-sheet registers match it by name and offset (ISP_BLC_CFG is at 0x21100 in the data sheet and 0x1000+0x20000 in the header)). Reset value and access type unknown (modelled RW, no reset). Confidence: medium (vendor header for this chip family, not hardware verified).";

        field {
            name = "sum";
            desc = "[inferred] Sum. (vendor header `isp_reg_define.h` field `sum`; access and reset unknown, modelled RW)";
            sw = rw;
            hw = r;
        } sum[31:0];
    } ISP_FE_WDR1_SUM0 @ 0x10898;

    reg {
        name = "ISP FE WDR1 SUM1";
        desc = "[inferred] ISP FE WDR1 SUM1. Not in the data sheet. Source: OpenIPC openhisilicon `kernel/isp/arch/hi3516cv300/firmware/vreg/arch/hi3516cv300/isp_reg_define.h` (GPL-3.0 repository, HiSilicon copyright, nManager-generated 2015-12-22 \"Define all registers/tables for Hi3519\"; local copy sources/openhisilicon), union `U_ISP_FE_WDR1_SUM1`, struct offset 0x1089C (GPL-3.0 repository; header offsets are ISP-core relative (data sheet offset - 0x20000), 632 of 775 data-sheet registers match it by name and offset (ISP_BLC_CFG is at 0x21100 in the data sheet and 0x1000+0x20000 in the header)). Reset value and access type unknown (modelled RW, no reset). Confidence: medium (vendor header for this chip family, not hardware verified).";

        field {
            name = "sum";
            desc = "[inferred] Sum. (vendor header `isp_reg_define.h` field `sum`; access and reset unknown, modelled RW)";
            sw = rw;
            hw = r;
        } sum[31:0];
    } ISP_FE_WDR1_SUM1 @ 0x1089C;

    reg {
        name = "ISP FE WDR2 SUM0";
        desc = "[inferred] ISP FE WDR2 SUM0. Not in the data sheet. Source: OpenIPC openhisilicon `kernel/isp/arch/hi3516cv300/firmware/vreg/arch/hi3516cv300/isp_reg_define.h` (GPL-3.0 repository, HiSilicon copyright, nManager-generated 2015-12-22 \"Define all registers/tables for Hi3519\"; local copy sources/openhisilicon), union `U_ISP_FE_WDR2_SUM0`, struct offset 0x108A0 (GPL-3.0 repository; header offsets are ISP-core relative (data sheet offset - 0x20000), 632 of 775 data-sheet registers match it by name and offset (ISP_BLC_CFG is at 0x21100 in the data sheet and 0x1000+0x20000 in the header)). Reset value and access type unknown (modelled RW, no reset). Confidence: medium (vendor header for this chip family, not hardware verified).";

        field {
            name = "sum";
            desc = "[inferred] Sum. (vendor header `isp_reg_define.h` field `sum`; access and reset unknown, modelled RW)";
            sw = rw;
            hw = r;
        } sum[31:0];
    } ISP_FE_WDR2_SUM0 @ 0x108A0;

    reg {
        name = "ISP FE WDR2 SUM1";
        desc = "[inferred] ISP FE WDR2 SUM1. Not in the data sheet. Source: OpenIPC openhisilicon `kernel/isp/arch/hi3516cv300/firmware/vreg/arch/hi3516cv300/isp_reg_define.h` (GPL-3.0 repository, HiSilicon copyright, nManager-generated 2015-12-22 \"Define all registers/tables for Hi3519\"; local copy sources/openhisilicon), union `U_ISP_FE_WDR2_SUM1`, struct offset 0x108A4 (GPL-3.0 repository; header offsets are ISP-core relative (data sheet offset - 0x20000), 632 of 775 data-sheet registers match it by name and offset (ISP_BLC_CFG is at 0x21100 in the data sheet and 0x1000+0x20000 in the header)). Reset value and access type unknown (modelled RW, no reset). Confidence: medium (vendor header for this chip family, not hardware verified).";

        field {
            name = "sum";
            desc = "[inferred] Sum. (vendor header `isp_reg_define.h` field `sum`; access and reset unknown, modelled RW)";
            sw = rw;
            hw = r;
        } sum[31:0];
    } ISP_FE_WDR2_SUM1 @ 0x108A4;

    reg {
        name = "ISP FE WDR3 SUM0";
        desc = "[inferred] ISP FE WDR3 SUM0. Not in the data sheet. Source: OpenIPC openhisilicon `kernel/isp/arch/hi3516cv300/firmware/vreg/arch/hi3516cv300/isp_reg_define.h` (GPL-3.0 repository, HiSilicon copyright, nManager-generated 2015-12-22 \"Define all registers/tables for Hi3519\"; local copy sources/openhisilicon), union `U_ISP_FE_WDR3_SUM0`, struct offset 0x108A8 (GPL-3.0 repository; header offsets are ISP-core relative (data sheet offset - 0x20000), 632 of 775 data-sheet registers match it by name and offset (ISP_BLC_CFG is at 0x21100 in the data sheet and 0x1000+0x20000 in the header)). Reset value and access type unknown (modelled RW, no reset). Confidence: medium (vendor header for this chip family, not hardware verified).";

        field {
            name = "sum";
            desc = "[inferred] Sum. (vendor header `isp_reg_define.h` field `sum`; access and reset unknown, modelled RW)";
            sw = rw;
            hw = r;
        } sum[31:0];
    } ISP_FE_WDR3_SUM0 @ 0x108A8;

    reg {
        name = "ISP FE WDR3 SUM1";
        desc = "[inferred] ISP FE WDR3 SUM1. Not in the data sheet. Source: OpenIPC openhisilicon `kernel/isp/arch/hi3516cv300/firmware/vreg/arch/hi3516cv300/isp_reg_define.h` (GPL-3.0 repository, HiSilicon copyright, nManager-generated 2015-12-22 \"Define all registers/tables for Hi3519\"; local copy sources/openhisilicon), union `U_ISP_FE_WDR3_SUM1`, struct offset 0x108AC (GPL-3.0 repository; header offsets are ISP-core relative (data sheet offset - 0x20000), 632 of 775 data-sheet registers match it by name and offset (ISP_BLC_CFG is at 0x21100 in the data sheet and 0x1000+0x20000 in the header)). Reset value and access type unknown (modelled RW, no reset). Confidence: medium (vendor header for this chip family, not hardware verified).";

        field {
            name = "sum";
            desc = "[inferred] Sum. (vendor header `isp_reg_define.h` field `sum`; access and reset unknown, modelled RW)";
            sw = rw;
            hw = r;
        } sum[31:0];
    } ISP_FE_WDR3_SUM1 @ 0x108AC;

    reg {
        name = "Color bar control register";
        desc = "ISP_COLORBAR_CFG is a color bar control register. Hi3516C V300/Hi3516E V100 Professional HD IP Camera SoC

Data sheet 10.6 ISP_COLORBAR_CFG (offset 0x20A00, printed page 10-95, `hi3516cv300--Hi3516CV300-Hi3516EV100-Datasheet.txt` line 45704).";

        enum ISP_COLORBAR_CFG_en_enum {
            DISABLED = 0 { name = "Disabled"; desc = "disabled"; };
            ENABLED = 1 { name = "Enabled"; desc = "enabled"; };
        };

        field {
            name = "en";
            desc = "Color bar enable";
            sw = rw;
            hw = r;
            encode = ISP_COLORBAR_CFG_en_enum;
            reset = 0x0;
        } en[0:0];
    } ISP_COLORBAR_CFG @ 0x10A00;

    reg {
        name = "ISP COLORBAR VERSION";
        desc = "[inferred] ISP COLORBAR VERSION. Not in the data sheet. Source: OpenIPC openhisilicon `kernel/isp/arch/hi3516cv300/firmware/vreg/arch/hi3516cv300/isp_reg_define.h` (GPL-3.0 repository, HiSilicon copyright, nManager-generated 2015-12-22 \"Define all registers/tables for Hi3519\"; local copy sources/openhisilicon), union `U_ISP_COLORBAR_VERSION`, struct offset 0x10A0C (GPL-3.0 repository; header offsets are ISP-core relative (data sheet offset - 0x20000), 632 of 775 data-sheet registers match it by name and offset (ISP_BLC_CFG is at 0x21100 in the data sheet and 0x1000+0x20000 in the header)). Reset value and access type unknown (modelled RW, no reset). Confidence: medium (vendor header for this chip family, not hardware verified).";

        field {
            name = "value";
            desc = "[inferred] Register value (the header union has no named bits).";
            sw = rw;
            hw = r;
        } value[31:0];
    } ISP_COLORBAR_VERSION @ 0x10A0C;

    reg {
        name = "Color bar type register RN";
        desc = "ISP_COLORBAR_PATTERN is a color bar type register.

Data sheet 10.6 ISP_COLORBAR_PATTERN (offset 0x20A10, printed page 10-95, `hi3516cv300--Hi3516CV300-Hi3516EV100-Datasheet.txt` line 45726).";

        enum ISP_COLORBAR_PATTERN_pattern_enum {
            PURE_COLOR_PICTURE = 0 { name = "Pure Color Picture"; desc = "pure color picture"; };
            PICTURE_CONSISTING_FOUR = 1 { name = "Picture Consisting Four"; desc = "picture consisting of four horizontal color stripes (gradient color)"; };
            PICTURE_CONSISTING_FOUR_2 = 2 { name = "Picture Consisting Four 2"; desc = "picture consisting of four vertical color stripes (gradient color)"; };
            PICTURE_CONSISTING_EIGHT = 3 { name = "Picture Consisting Eight"; desc = "picture consisting of eight vertical color stripes (fixed color)"; };
            PIP_RECTANGULAR_PURE = 4 { name = "Pip Rectangular Pure"; desc = "PIP. A rectangular pure color target area is generated on the pure color background (configurable color and coordinates). Other values: reserved"; };
        };

        field {
            name = "pattern";
            desc = "Color bar type";
            sw = rw;
            hw = r;
            encode = ISP_COLORBAR_PATTERN_pattern_enum;
            reset = 0x0;
        } pattern[2:0];
    } ISP_COLORBAR_PATTERN @ 0x10A10;

    reg {
        name = "Color bar background color register KGND";
        desc = "ISP_COLORBAR_RBACKGND is a color bar background color register. Hi3516C V300/Hi3516E V100 Professional HD IP Camera SoC

Data sheet 10.6 ISP_COLORBAR_RBACKGND (offset 0x20A14, printed page 10-96, `hi3516cv300--Hi3516CV300-Hi3516EV100-Datasheet.txt` line 45765).";

        field {
            name = "rbackgnd";
            desc = "Background color of the R component in pure color pictures, pictures consisting of eight vertical color stripes, and PIPs";
            sw = rw;
            hw = r;
            reset = 0x0;
        } rbackgnd[15:0];
    } ISP_COLORBAR_RBACKGND @ 0x10A14;

    reg {
        name = "Color bar background color register KGND";
        desc = "ISP_COLORBAR_GBACKGND is a color bar background color register.

Data sheet 10.6 ISP_COLORBAR_GBACKGND (offset 0x20A18, printed page 10-96, `hi3516cv300--Hi3516CV300-Hi3516EV100-Datasheet.txt` line 45787).";

        field {
            name = "gbackgnd";
            desc = "Background color of the G component in pure color pictures, pictures consisting of eight vertical color stripes, and PIPs";
            sw = rw;
            hw = r;
            reset = 0x0;
        } gbackgnd[15:0];
    } ISP_COLORBAR_GBACKGND @ 0x10A18;

    reg {
        name = "Color bar background color register KGND";
        desc = "ISP_COLORBAR_BBACKGND is a color bar background color register.

Data sheet 10.6 ISP_COLORBAR_BBACKGND (offset 0x20A1C, printed page 10-96, `hi3516cv300--Hi3516CV300-Hi3516EV100-Datasheet.txt` line 45808).";

        field {
            name = "bbackgnd";
            desc = "Background color of the B component in pure color pictures, pictures consisting of eight vertical color stripes, and PIPs";
            sw = rw;
            hw = r;
            reset = 0x0;
        } bbackgnd[15:0];
    } ISP_COLORBAR_BBACKGND @ 0x10A1C;

    reg {
        name = "Color bar foreground color register GND";
        desc = "ISP_COLORBAR_RFOREGND is a color bar foreground color register.

Data sheet 10.6 ISP_COLORBAR_RFOREGND (offset 0x20A20, printed page 10-97, `hi3516cv300--Hi3516CV300-Hi3516EV100-Datasheet.txt` line 45839).";

        field {
            name = "rforegnd";
            desc = "Foreground color of the R component in PIPs";
            sw = rw;
            hw = r;
            reset = 0x0;
        } rforegnd[15:0];
    } ISP_COLORBAR_RFOREGND @ 0x10A20;

    reg {
        name = "Color bar foreground color register EGND";
        desc = "ISP_COLORBAR_GFOREGND is a color bar foreground color register.

Data sheet 10.6 ISP_COLORBAR_GFOREGND (offset 0x20A24, printed page 10-97, `hi3516cv300--Hi3516CV300-Hi3516EV100-Datasheet.txt` line 45859).";

        field {
            name = "gforegnd";
            desc = "Foreground color of the G component in PIPs";
            sw = rw;
            hw = r;
            reset = 0x0;
        } gforegnd[15:0];
    } ISP_COLORBAR_GFOREGND @ 0x10A24;

    reg {
        name = "Color bar foreground color register GND";
        desc = "ISP_COLORBAR_BFOREGND is a color bar foreground color register. Hi3516C V300/Hi3516E V100 Professional HD IP Camera SoC

Data sheet 10.6 ISP_COLORBAR_BFOREGND (offset 0x20A28, printed page 10-98, `hi3516cv300--Hi3516CV300-Hi3516EV100-Datasheet.txt` line 45887).";

        field {
            name = "bforegnd";
            desc = "Foreground color of the B component in PIPs";
            sw = rw;
            hw = r;
            reset = 0x0;
        } bforegnd[15:0];
    } ISP_COLORBAR_BFOREGND @ 0x10A28;

    reg {
        name = "Color bar initial value register";
        desc = "ISP_COLORBAR_INIT is a color bar initial value register.

Data sheet 10.6 ISP_COLORBAR_INIT (offset 0x20A2C, printed page 10-98, `hi3516cv300--Hi3516CV300-Hi3516EV100-Datasheet.txt` line 45907).";

        field {
            name = "rgbinit";
            desc = "Initial value of the R/G/B component, for calculating the gradient color bar";
            sw = rw;
            hw = r;
            reset = 0x0;
        } rgbinit[15:0];
    } ISP_COLORBAR_INIT @ 0x10A2C;

    reg {
        name = "Color bar increasing value register";
        desc = "ISP_COLORBAR_GRAD is a color bar increasing value register.

Data sheet 10.6 ISP_COLORBAR_GRAD (offset 0x20A30, printed page 10-98, `hi3516cv300--Hi3516CV300-Hi3516EV100-Datasheet.txt` line 45928).";

        field {
            name = "rgbgrad";
            desc = "Increasing value of the R/G/B component, for calculating the gradient color bar";
            sw = rw;
            hw = r;
            reset = 0x0;
        } rgbgrad[15:0];
    } ISP_COLORBAR_GRAD @ 0x10A30;

    reg {
        name = "Color bar rectangle coordinate register";
        desc = "ISP_COLORBAR_POS1 is a color bar rectangle coordinate register.

Data sheet 10.6 ISP_COLORBAR_POS1 (offset 0x20A34, printed page 10-99, `hi3516cv300--Hi3516CV300-Hi3516EV100-Datasheet.txt` line 45958).";

        field {
            name = "pos_y1";
            desc = "Vertical start coordinate (y1) of the rectangle inside the PIP";
            sw = rw;
            hw = r;
            reset = 0x0;
        } pos_y1[28:16];

        field {
            name = "pos_x1";
            desc = "Horizontal start coordinate (x1) of the rectangle inside the PIP";
            sw = rw;
            hw = r;
            reset = 0x0;
        } pos_x1[12:0];
    } ISP_COLORBAR_POS1 @ 0x10A34;

    reg {
        name = "Color bar rectangle coordinate register";
        desc = "ISP_COLORBAR_POS2 is a color bar rectangle coordinate register.

Data sheet 10.6 ISP_COLORBAR_POS2 (offset 0x20A38, printed page 10-99, `hi3516cv300--Hi3516CV300-Hi3516EV100-Datasheet.txt` line 45983).";

        field {
            name = "pos_y2";
            desc = "Vertical end coordinate (y2) of the rectangle inside the PIP";
            sw = rw;
            hw = r;
            reset = 0x0;
        } pos_y2[28:16];

        field {
            name = "pos_x2";
            desc = "Horizontal end coordinate (x2) of the rectangle inside the PIP";
            sw = rw;
            hw = r;
            reset = 0x0;
        } pos_x2[12:0];
    } ISP_COLORBAR_POS2 @ 0x10A38;

    reg {
        name = "RGGB sequence register";
        desc = "ISP_COLORBAR_RGGB is an RGGB sequence register.

Data sheet 10.6 ISP_COLORBAR_RGGB (offset 0x20A3C, printed page 10-100, `hi3516cv300--Hi3516CV300-Hi3516EV100-Datasheet.txt` line 46015).";

        enum ISP_COLORBAR_RGGB_rggb_enum {
            R_GR_GB = 0 { name = "R Gr Gb"; desc = "R Gr Gb B"; };
            GR_R_B = 1 { name = "Gr R B"; desc = "Gr R B Gb"; };
            GB_B_R = 2 { name = "Gb B R"; desc = "Gb B R Gr"; };
            B_GB_GR = 3 { name = "B Gb Gr"; desc = "B Gb Gr R"; };
        };

        field {
            name = "rggb";
            desc = "RGGB sequence for generating RAW data for the color bar";
            sw = rw;
            hw = r;
            encode = ISP_COLORBAR_RGGB_rggb_enum;
            reset = 0x3;
        } rggb[1:0];
    } ISP_COLORBAR_RGGB @ 0x10A3C;

    reg {
        name = "ISP COLORBAR control I";
        desc = "[inferred] ISP COLORBAR control I. Not in the data sheet. Source: OpenIPC openhisilicon `kernel/isp/arch/hi3516cv300/firmware/vreg/arch/hi3516cv300/isp_reg_define.h` (GPL-3.0 repository, HiSilicon copyright, nManager-generated 2015-12-22 \"Define all registers/tables for Hi3519\"; local copy sources/openhisilicon), union `U_ISP_COLORBAR_CTRL_I`, struct offset 0x10AE4 (GPL-3.0 repository; header offsets are ISP-core relative (data sheet offset - 0x20000), 632 of 775 data-sheet registers match it by name and offset (ISP_BLC_CFG is at 0x21100 in the data sheet and 0x1000+0x20000 in the header)). Reset value and access type unknown (modelled RW, no reset). Confidence: medium (vendor header for this chip family, not hardware verified).";

        field {
            name = "update_mode";
            desc = "[inferred] Update mode. (vendor header `isp_reg_define.h` field `update_mode`; access and reset unknown, modelled RW)";
            sw = rw;
            hw = r;
        } update_mode[0:0];
    } ISP_COLORBAR_CTRL_I @ 0x10AE4;

    reg {
        name = "ISP COLORBAR UPDATE";
        desc = "[inferred] ISP COLORBAR UPDATE. Not in the data sheet. Source: OpenIPC openhisilicon `kernel/isp/arch/hi3516cv300/firmware/vreg/arch/hi3516cv300/isp_reg_define.h` (GPL-3.0 repository, HiSilicon copyright, nManager-generated 2015-12-22 \"Define all registers/tables for Hi3519\"; local copy sources/openhisilicon), union `U_ISP_COLORBAR_UPDATE`, struct offset 0x10AEC (GPL-3.0 repository; header offsets are ISP-core relative (data sheet offset - 0x20000), 632 of 775 data-sheet registers match it by name and offset (ISP_BLC_CFG is at 0x21100 in the data sheet and 0x1000+0x20000 in the header)). Reset value and access type unknown (modelled RW, no reset). Confidence: medium (vendor header for this chip family, not hardware verified).";

        field {
            name = "update";
            desc = "[inferred] Update. (vendor header `isp_reg_define.h` field `update`; access and reset unknown, modelled RW)";
            sw = rw;
            hw = r;
        } update[0:0];
    } ISP_COLORBAR_UPDATE @ 0x10AEC;

    reg {
        name = "Color bar picture size register";
        desc = "ISP_COLORBAR_SIZE is a color bar picture size register.

Data sheet 10.6 ISP_COLORBAR_SIZE (offset 0x20AF0, printed page 10-100, `hi3516cv300--Hi3516CV300-Hi3516EV100-Datasheet.txt` line 46041).";

        field {
            name = "height";
            desc = "Picture height. The configured value is the actual value minus 1. For example, if the actual picture height is 1080, set this field to 1079.";
            sw = rw;
            hw = r;
            reset = 0x437;
        } height[28:16];

        field {
            name = "width";
            desc = "Picture width. The configured value is the actual value minus 1. For example, if the actual picture width is 1920, set this field to 1919.";
            sw = rw;
            hw = r;
            reset = 0x77F;
        } width[12:0];
    } ISP_COLORBAR_SIZE @ 0x10AF0;

    reg {
        name = "BLC control register";
        desc = "ISP_BLC_CFG is a BLC control register.

Data sheet 10.6 ISP_BLC_CFG (offset 0x21100, printed page 10-101, `hi3516cv300--Hi3516CV300-Hi3516EV100-Datasheet.txt` line 46075).";

        enum ISP_BLC_CFG_en_enum {
            DISABLED = 0 { name = "Disabled"; desc = "disabled"; };
            ENABLED = 1 { name = "Enabled"; desc = "enabled"; };
        };

        field {
            name = "en";
            desc = "BLC enable";
            sw = rw;
            hw = r;
            encode = ISP_BLC_CFG_en_enum;
            reset = 0x0;
        } en[0:0];
    } ISP_BLC_CFG @ 0x11100;

    reg {
        name = "ISP 4BLC VERSION";
        desc = "[inferred] ISP 4BLC VERSION. Not in the data sheet. Source: OpenIPC openhisilicon `kernel/isp/arch/hi3516cv300/firmware/vreg/arch/hi3516cv300/isp_reg_define.h` (GPL-3.0 repository, HiSilicon copyright, nManager-generated 2015-12-22 \"Define all registers/tables for Hi3519\"; local copy sources/openhisilicon), union `U_ISP_4BLC_VERSION`, struct offset 0x1110C (GPL-3.0 repository; header offsets are ISP-core relative (data sheet offset - 0x20000), 632 of 775 data-sheet registers match it by name and offset (ISP_BLC_CFG is at 0x21100 in the data sheet and 0x1000+0x20000 in the header)). Reset value and access type unknown (modelled RW, no reset). Confidence: medium (vendor header for this chip family, not hardware verified).";

        field {
            name = "value";
            desc = "[inferred] Register value (the header union has no named bits).";
            sw = rw;
            hw = r;
        } value[31:0];
    } ISP_4BLC_VERSION @ 0x1110C;

    reg {
        name = "BLC0 offset register 1";
        desc = "ISP_BLC0_OFFSET1 is BLC0 offset register 1.

Data sheet 10.6 ISP_BLC0_OFFSET1 (offset 0x21110, printed page 10-101, `hi3516cv300--Hi3516CV300-Hi3516EV100-Datasheet.txt` line 46097).";

        field {
            name = "ofsr";
            desc = "BLC offset of the R component, S15";
            sw = rw;
            hw = r;
            reset = 0x0;
        } ofsr[30:16];

        field {
            name = "ofsgr";
            desc = "BLC offset of the Gr component, S15";
            sw = rw;
            hw = r;
            reset = 0x0;
        } ofsgr[14:0];
    } ISP_BLC0_OFFSET1 @ 0x11110;

    reg {
        name = "BLC0 offset register 2";
        desc = "ISP_BLC0_OFFSET2 is BLC0 offset register 2. Hi3516C V300/Hi3516E V100 Professional HD IP Camera SoC

Data sheet 10.6 ISP_BLC0_OFFSET2 (offset 0x21114, printed page 10-102, `hi3516cv300--Hi3516CV300-Hi3516EV100-Datasheet.txt` line 46131).";

        field {
            name = "ofsb";
            desc = "BLC offset of the B component, S15";
            sw = rw;
            hw = r;
            reset = 0x0;
        } ofsb[30:16];

        field {
            name = "ofsgb";
            desc = "BLC offset of the Gb component, S15";
            sw = rw;
            hw = r;
            reset = 0x0;
        } ofsgb[14:0];
    } ISP_BLC0_OFFSET2 @ 0x11114;

    reg {
        name = "BLC1 offset register 1";
        desc = "ISP_BLC1_OFFSET1 is BLC1 offset register 1.

Data sheet 10.6 ISP_BLC1_OFFSET1 (offset 0x21118, printed page 10-102, `hi3516cv300--Hi3516CV300-Hi3516EV100-Datasheet.txt` line 46156).";

        field {
            name = "ofsr";
            desc = "BLC offset of the R component, S15";
            sw = rw;
            hw = r;
            reset = 0x0;
        } ofsr[30:16];

        field {
            name = "ofsgr";
            desc = "BLC offset of the Gr component, S15";
            sw = rw;
            hw = r;
            reset = 0x0;
        } ofsgr[14:0];
    } ISP_BLC1_OFFSET1 @ 0x11118;

    reg {
        name = "BLC1 offset register 2";
        desc = "ISP_BLC1_OFFSET2 is BLC1 offset register 2. Hi3516C V300/Hi3516E V100 Professional HD IP Camera SoC

Data sheet 10.6 ISP_BLC1_OFFSET2 (offset 0x2111C, printed page 10-103, `hi3516cv300--Hi3516CV300-Hi3516EV100-Datasheet.txt` line 46191).";

        field {
            name = "ofsb";
            desc = "BLC offset of the B component, S15";
            sw = rw;
            hw = r;
            reset = 0x0;
        } ofsb[30:16];

        field {
            name = "ofsgb";
            desc = "BLC offset of the Gb component, S15";
            sw = rw;
            hw = r;
            reset = 0x0;
        } ofsgb[14:0];
    } ISP_BLC1_OFFSET2 @ 0x1111C;

    reg {
        name = "ISP 4BLC control F";
        desc = "[inferred] ISP 4BLC control F. Not in the data sheet. Source: OpenIPC openhisilicon `kernel/isp/arch/hi3516cv300/firmware/vreg/arch/hi3516cv300/isp_reg_define.h` (GPL-3.0 repository, HiSilicon copyright, nManager-generated 2015-12-22 \"Define all registers/tables for Hi3519\"; local copy sources/openhisilicon), union `U_ISP_4BLC_CTRL_F`, struct offset 0x111E0 (GPL-3.0 repository; header offsets are ISP-core relative (data sheet offset - 0x20000), 632 of 775 data-sheet registers match it by name and offset (ISP_BLC_CFG is at 0x21100 in the data sheet and 0x1000+0x20000 in the header)). Reset value and access type unknown (modelled RW, no reset). Confidence: medium (vendor header for this chip family, not hardware verified).";

        field {
            name = "rggb_cfg";
            desc = "[inferred] Rggb configuration. (vendor header `isp_reg_define.h` field `rggb_cfg`; access and reset unknown, modelled RW)";
            sw = rw;
            hw = r;
        } rggb_cfg[1:0];
    } ISP_4BLC_CTRL_F @ 0x111E0;

    reg {
        name = "ISP 4BLC control I";
        desc = "[inferred] ISP 4BLC control I. Not in the data sheet. Source: OpenIPC openhisilicon `kernel/isp/arch/hi3516cv300/firmware/vreg/arch/hi3516cv300/isp_reg_define.h` (GPL-3.0 repository, HiSilicon copyright, nManager-generated 2015-12-22 \"Define all registers/tables for Hi3519\"; local copy sources/openhisilicon), union `U_ISP_4BLC_CTRL_I`, struct offset 0x111E4 (GPL-3.0 repository; header offsets are ISP-core relative (data sheet offset - 0x20000), 632 of 775 data-sheet registers match it by name and offset (ISP_BLC_CFG is at 0x21100 in the data sheet and 0x1000+0x20000 in the header)). Reset value and access type unknown (modelled RW, no reset). Confidence: medium (vendor header for this chip family, not hardware verified).";

        field {
            name = "update_mode";
            desc = "[inferred] Update mode. (vendor header `isp_reg_define.h` field `update_mode`; access and reset unknown, modelled RW)";
            sw = rw;
            hw = r;
        } update_mode[0:0];
    } ISP_4BLC_CTRL_I @ 0x111E4;

    reg {
        name = "ISP 4BLC UPDATE";
        desc = "[inferred] ISP 4BLC UPDATE. Not in the data sheet. Source: OpenIPC openhisilicon `kernel/isp/arch/hi3516cv300/firmware/vreg/arch/hi3516cv300/isp_reg_define.h` (GPL-3.0 repository, HiSilicon copyright, nManager-generated 2015-12-22 \"Define all registers/tables for Hi3519\"; local copy sources/openhisilicon), union `U_ISP_4BLC_UPDATE`, struct offset 0x111EC (GPL-3.0 repository; header offsets are ISP-core relative (data sheet offset - 0x20000), 632 of 775 data-sheet registers match it by name and offset (ISP_BLC_CFG is at 0x21100 in the data sheet and 0x1000+0x20000 in the header)). Reset value and access type unknown (modelled RW, no reset). Confidence: medium (vendor header for this chip family, not hardware verified).";

        field {
            name = "update";
            desc = "[inferred] Update. (vendor header `isp_reg_define.h` field `update`; access and reset unknown, modelled RW)";
            sw = rw;
            hw = r;
        } update[0:0];
    } ISP_4BLC_UPDATE @ 0x111EC;

    reg {
        name = "WB control register";
        desc = "ISP_WB_CFG is a WB control register.

Data sheet 10.6 ISP_WB_CFG (offset 0x21200, printed page 10-103, `hi3516cv300--Hi3516CV300-Hi3516EV100-Datasheet.txt` line 46216).";

        enum ISP_WB_CFG_en_enum {
            DISABLED = 0 { name = "Disabled"; desc = "disabled"; };
            ENABLED = 1 { name = "Enabled"; desc = "enabled"; };
        };

        field {
            name = "en";
            desc = "WB enable";
            sw = rw;
            hw = r;
            encode = ISP_WB_CFG_en_enum;
            reset = 0x0;
        } en[0:0];
    } ISP_WB_CFG @ 0x11200;

    reg {
        name = "WB black level offset enable register";
        desc = "ISP_WB_BLC_CFG is a WB black level offset enable register. Hi3516C V300/Hi3516E V100 Professional HD IP Camera SoC

Data sheet 10.6 ISP_WB_BLC_CFG (offset 0x21204, printed page 10-104, `hi3516cv300--Hi3516CV300-Hi3516EV100-Datasheet.txt` line 46246).";

        enum ISP_WB_BLC_CFG_en_out_enum {
            DISABLED = 0 { name = "Disabled"; desc = "disabled"; };
            ENABLED = 1 { name = "Enabled"; desc = "enabled"; };
        };

        field {
            name = "en_out";
            desc = "Output black level offset enable";
            sw = rw;
            hw = r;
            encode = ISP_WB_BLC_CFG_en_out_enum;
            reset = 0x0;
        } en_out[1:1];

        enum ISP_WB_BLC_CFG_en_in_enum {
            DISABLED = 0 { name = "Disabled"; desc = "disabled"; };
            ENABLED = 1 { name = "Enabled"; desc = "enabled"; };
        };

        field {
            name = "en_in";
            desc = "Input black level offset enable";
            sw = rw;
            hw = r;
            encode = ISP_WB_BLC_CFG_en_in_enum;
            reset = 0x0;
        } en_in[0:0];
    } ISP_WB_BLC_CFG @ 0x11204;

    reg {
        name = "ISP WB VERSION";
        desc = "[inferred] ISP WB VERSION. Not in the data sheet. Source: OpenIPC openhisilicon `kernel/isp/arch/hi3516cv300/firmware/vreg/arch/hi3516cv300/isp_reg_define.h` (GPL-3.0 repository, HiSilicon copyright, nManager-generated 2015-12-22 \"Define all registers/tables for Hi3519\"; local copy sources/openhisilicon), union `U_ISP_WB_VERSION`, struct offset 0x1120C (GPL-3.0 repository; header offsets are ISP-core relative (data sheet offset - 0x20000), 632 of 775 data-sheet registers match it by name and offset (ISP_BLC_CFG is at 0x21100 in the data sheet and 0x1000+0x20000 in the header)). Reset value and access type unknown (modelled RW, no reset). Confidence: medium (vendor header for this chip family, not hardware verified).";

        field {
            name = "value";
            desc = "[inferred] Register value (the header union has no named bits).";
            sw = rw;
            hw = r;
        } value[31:0];
    } ISP_WB_VERSION @ 0x1120C;

    reg {
        name = "WB gain (R & Gr) register";
        desc = "ISP_WB_GAIN1 is a WB gain (R & Gr) register.

Data sheet 10.6 ISP_WB_GAIN1 (offset 0x21210, printed page 10-104, `hi3516cv300--Hi3516CV300-Hi3516EV100-Datasheet.txt` line 46272).";

        field {
            name = "rgain";
            desc = "WB R gain (U4.8)";
            sw = rw;
            hw = r;
            reset = 0x100;
        } rgain[27:16];

        field {
            name = "grgain";
            desc = "WB Gr gain (U4.8)";
            sw = rw;
            hw = r;
            reset = 0x100;
        } grgain[11:0];
    } ISP_WB_GAIN1 @ 0x11210;

    reg {
        name = "WB gain (B & Gb) register";
        desc = "ISP_WB_GAIN2 is a WB gain (B & Gb) register. Hi3516C V300/Hi3516E V100 Professional HD IP Camera SoC

Data sheet 10.6 ISP_WB_GAIN2 (offset 0x21214, printed page 10-105, `hi3516cv300--Hi3516CV300-Hi3516EV100-Datasheet.txt` line 46303).";

        field {
            name = "bgain";
            desc = "WB B gain (U4.8)";
            sw = rw;
            hw = r;
            reset = 0x100;
        } bgain[27:16];

        field {
            name = "gbgain";
            desc = "WB Gb gain (U4.8)";
            sw = rw;
            hw = r;
            reset = 0x100;
        } gbgain[11:0];
    } ISP_WB_GAIN2 @ 0x11214;

    reg {
        name = "WB black level offset register 1";
        desc = "ISP_WB_BLC_OFFSET1 is WB black level offset register 1.

Data sheet 10.6 ISP_WB_BLC_OFFSET1 (offset 0x21218, printed page 10-105, `hi3516cv300--Hi3516CV300-Hi3516EV100-Datasheet.txt` line 46325).";

        field {
            name = "ofsr";
            desc = "Black level R offset, S15";
            sw = rw;
            hw = r;
            reset = 0x0;
        } ofsr[30:16];

        field {
            name = "ofsgr";
            desc = "Black level Gr offset, S15";
            sw = rw;
            hw = r;
            reset = 0x0;
        } ofsgr[14:0];
    } ISP_WB_BLC_OFFSET1 @ 0x11218;

    reg {
        name = "WB black level offset register 2";
        desc = "ISP_WB_BLC_OFFSET2 is WB black level offset register 2. Hi3516C V300/Hi3516E V100 Professional HD IP Camera SoC

Data sheet 10.6 ISP_WB_BLC_OFFSET2 (offset 0x2121C, printed page 10-106, `hi3516cv300--Hi3516CV300-Hi3516EV100-Datasheet.txt` line 46359).";

        field {
            name = "ofsb";
            desc = "Black level B offset, S15";
            sw = rw;
            hw = r;
            reset = 0x0;
        } ofsb[30:16];

        field {
            name = "ofsgb";
            desc = "Black level Gb offset, S15";
            sw = rw;
            hw = r;
            reset = 0x0;
        } ofsgb[14:0];
    } ISP_WB_BLC_OFFSET2 @ 0x1121C;

    reg {
        name = "ISP WB control F";
        desc = "[inferred] ISP WB control F. Not in the data sheet. Source: OpenIPC openhisilicon `kernel/isp/arch/hi3516cv300/firmware/vreg/arch/hi3516cv300/isp_reg_define.h` (GPL-3.0 repository, HiSilicon copyright, nManager-generated 2015-12-22 \"Define all registers/tables for Hi3519\"; local copy sources/openhisilicon), union `U_ISP_WB_CTRL_F`, struct offset 0x112E0 (GPL-3.0 repository; header offsets are ISP-core relative (data sheet offset - 0x20000), 632 of 775 data-sheet registers match it by name and offset (ISP_BLC_CFG is at 0x21100 in the data sheet and 0x1000+0x20000 in the header)). Reset value and access type unknown (modelled RW, no reset). Confidence: medium (vendor header for this chip family, not hardware verified).";

        field {
            name = "rggb_cfg";
            desc = "[inferred] Rggb configuration. (vendor header `isp_reg_define.h` field `rggb_cfg`; access and reset unknown, modelled RW)";
            sw = rw;
            hw = r;
        } rggb_cfg[1:0];
    } ISP_WB_CTRL_F @ 0x112E0;

    reg {
        name = "ISP WB control I";
        desc = "[inferred] ISP WB control I. Not in the data sheet. Source: OpenIPC openhisilicon `kernel/isp/arch/hi3516cv300/firmware/vreg/arch/hi3516cv300/isp_reg_define.h` (GPL-3.0 repository, HiSilicon copyright, nManager-generated 2015-12-22 \"Define all registers/tables for Hi3519\"; local copy sources/openhisilicon), union `U_ISP_WB_CTRL_I`, struct offset 0x112E4 (GPL-3.0 repository; header offsets are ISP-core relative (data sheet offset - 0x20000), 632 of 775 data-sheet registers match it by name and offset (ISP_BLC_CFG is at 0x21100 in the data sheet and 0x1000+0x20000 in the header)). Reset value and access type unknown (modelled RW, no reset). Confidence: medium (vendor header for this chip family, not hardware verified).";

        field {
            name = "update_mode";
            desc = "[inferred] Update mode. (vendor header `isp_reg_define.h` field `update_mode`; access and reset unknown, modelled RW)";
            sw = rw;
            hw = r;
        } update_mode[0:0];
    } ISP_WB_CTRL_I @ 0x112E4;

    reg {
        name = "ISP WB UPDATE";
        desc = "[inferred] ISP WB UPDATE. Not in the data sheet. Source: OpenIPC openhisilicon `kernel/isp/arch/hi3516cv300/firmware/vreg/arch/hi3516cv300/isp_reg_define.h` (GPL-3.0 repository, HiSilicon copyright, nManager-generated 2015-12-22 \"Define all registers/tables for Hi3519\"; local copy sources/openhisilicon), union `U_ISP_WB_UPDATE`, struct offset 0x112EC (GPL-3.0 repository; header offsets are ISP-core relative (data sheet offset - 0x20000), 632 of 775 data-sheet registers match it by name and offset (ISP_BLC_CFG is at 0x21100 in the data sheet and 0x1000+0x20000 in the header)). Reset value and access type unknown (modelled RW, no reset). Confidence: medium (vendor header for this chip family, not hardware verified).";

        field {
            name = "update";
            desc = "[inferred] Update. (vendor header `isp_reg_define.h` field `update`; access and reset unknown, modelled RW)";
            sw = rw;
            hw = r;
        } update[0:0];
    } ISP_WB_UPDATE @ 0x112EC;

    reg {
        name = "DG control register";
        desc = "ISP_DG_CFG is a DG control register.

Data sheet 10.6 ISP_DG_CFG (offset 0x21300, printed page 10-106, `hi3516cv300--Hi3516CV300-Hi3516EV100-Datasheet.txt` line 46384).";

        enum ISP_DG_CFG_en_enum {
            DISABLED = 0 { name = "Disabled"; desc = "disabled"; };
            ENABLED = 1 { name = "Enabled"; desc = "enabled"; };
        };

        field {
            name = "en";
            desc = "DG enable";
            sw = rw;
            hw = r;
            encode = ISP_DG_CFG_en_enum;
            reset = 0x0;
        } en[0:0];
    } ISP_DG_CFG @ 0x11300;

    reg {
        name = "DG black level enable control register";
        desc = "ISP_DG_BLC_CFG is a DG black level enable control register. Hi3516C V300/Hi3516E V100 Professional HD IP Camera SoC

Data sheet 10.6 ISP_DG_BLC_CFG (offset 0x21304, printed page 10-107, `hi3516cv300--Hi3516CV300-Hi3516EV100-Datasheet.txt` line 46414).";

        enum ISP_DG_BLC_CFG_en_out_enum {
            DISABLED = 0 { name = "Disabled"; desc = "disabled"; };
            ENABLED = 1 { name = "Enabled"; desc = "enabled"; };
        };

        field {
            name = "en_out";
            desc = "Output black level offset enable";
            sw = rw;
            hw = r;
            encode = ISP_DG_BLC_CFG_en_out_enum;
            reset = 0x0;
        } en_out[1:1];

        enum ISP_DG_BLC_CFG_en_in_enum {
            DISABLED = 0 { name = "Disabled"; desc = "disabled"; };
            ENABLED = 1 { name = "Enabled"; desc = "enabled"; };
        };

        field {
            name = "en_in";
            desc = "Input black level offset enable";
            sw = rw;
            hw = r;
            encode = ISP_DG_BLC_CFG_en_in_enum;
            reset = 0x0;
        } en_in[0:0];
    } ISP_DG_BLC_CFG @ 0x11304;

    reg {
        name = "ISP DG VERSION";
        desc = "[inferred] ISP DG VERSION. Not in the data sheet. Source: OpenIPC openhisilicon `kernel/isp/arch/hi3516cv300/firmware/vreg/arch/hi3516cv300/isp_reg_define.h` (GPL-3.0 repository, HiSilicon copyright, nManager-generated 2015-12-22 \"Define all registers/tables for Hi3519\"; local copy sources/openhisilicon), union `U_ISP_DG_VERSION`, struct offset 0x1130C (GPL-3.0 repository; header offsets are ISP-core relative (data sheet offset - 0x20000), 632 of 775 data-sheet registers match it by name and offset (ISP_BLC_CFG is at 0x21100 in the data sheet and 0x1000+0x20000 in the header)). Reset value and access type unknown (modelled RW, no reset). Confidence: medium (vendor header for this chip family, not hardware verified).";

        field {
            name = "value";
            desc = "[inferred] Register value (the header union has no named bits).";
            sw = rw;
            hw = r;
        } value[31:0];
    } ISP_DG_VERSION @ 0x1130C;

    reg {
        name = "DG gain (R & Gr) register";
        desc = "ISP_DG_GAIN1 is a DG gain (R & Gr) register.

Data sheet 10.6 ISP_DG_GAIN1 (offset 0x21310, printed page 10-107, `hi3516cv300--Hi3516CV300-Hi3516EV100-Datasheet.txt` line 46440).";

        field {
            name = "rgain";
            desc = "DG R gain (U8.8)";
            sw = rw;
            hw = r;
            reset = 0x100;
        } rgain[31:16];

        field {
            name = "grgain";
            desc = "DG Gr gain (U8.8)";
            sw = rw;
            hw = r;
            reset = 0x100;
        } grgain[15:0];
    } ISP_DG_GAIN1 @ 0x11310;

    reg {
        name = "DG gain (B & Gb) register";
        desc = "ISP_DG_GAIN2 is a DG gain (B & Gb) register. Hi3516C V300/Hi3516E V100 Professional HD IP Camera SoC

Data sheet 10.6 ISP_DG_GAIN2 (offset 0x21314, printed page 10-108, `hi3516cv300--Hi3516CV300-Hi3516EV100-Datasheet.txt` line 46469).";

        field {
            name = "bgain";
            desc = "DG B gain (U8.8)";
            sw = rw;
            hw = r;
            reset = 0x100;
        } bgain[31:16];

        field {
            name = "gbgain";
            desc = "DG Gb gain (U8.8)";
            sw = rw;
            hw = r;
            reset = 0x100;
        } gbgain[15:0];
    } ISP_DG_GAIN2 @ 0x11314;

    reg {
        name = "DG black level offset register 1";
        desc = "ISP_DG_BLC_OFFSET1 is DG black level offset register 1.

Data sheet 10.6 ISP_DG_BLC_OFFSET1 (offset 0x21318, printed page 10-108, `hi3516cv300--Hi3516CV300-Hi3516EV100-Datasheet.txt` line 46489).";

        field {
            name = "ofsr";
            desc = "Black level R offset, S15";
            sw = rw;
            hw = r;
            reset = 0x0;
        } ofsr[30:16];

        field {
            name = "ofsgr";
            desc = "Black level Gr offset, S15";
            sw = rw;
            hw = r;
            reset = 0x0;
        } ofsgr[14:0];
    } ISP_DG_BLC_OFFSET1 @ 0x11318;

    reg {
        name = "DG black level offset register 2";
        desc = "ISP_DG_BLC_OFFSET2 is DG black level offset register 2. Hi3516C V300/Hi3516E V100 Professional HD IP Camera SoC

Data sheet 10.6 ISP_DG_BLC_OFFSET2 (offset 0x2131C, printed page 10-109, `hi3516cv300--Hi3516CV300-Hi3516EV100-Datasheet.txt` line 46523).";

        field {
            name = "ofsb";
            desc = "Black level B offset, S15";
            sw = rw;
            hw = r;
            reset = 0x0;
        } ofsb[30:16];

        field {
            name = "ofsgb";
            desc = "Black level Gb offset, S15";
            sw = rw;
            hw = r;
            reset = 0x0;
        } ofsgb[14:0];
    } ISP_DG_BLC_OFFSET2 @ 0x1131C;

    reg {
        name = "ISP DG control F";
        desc = "[inferred] ISP DG control F. Not in the data sheet. Source: OpenIPC openhisilicon `kernel/isp/arch/hi3516cv300/firmware/vreg/arch/hi3516cv300/isp_reg_define.h` (GPL-3.0 repository, HiSilicon copyright, nManager-generated 2015-12-22 \"Define all registers/tables for Hi3519\"; local copy sources/openhisilicon), union `U_ISP_DG_CTRL_F`, struct offset 0x113E0 (GPL-3.0 repository; header offsets are ISP-core relative (data sheet offset - 0x20000), 632 of 775 data-sheet registers match it by name and offset (ISP_BLC_CFG is at 0x21100 in the data sheet and 0x1000+0x20000 in the header)). Reset value and access type unknown (modelled RW, no reset). Confidence: medium (vendor header for this chip family, not hardware verified).";

        field {
            name = "rggb_cfg";
            desc = "[inferred] Rggb configuration. (vendor header `isp_reg_define.h` field `rggb_cfg`; access and reset unknown, modelled RW)";
            sw = rw;
            hw = r;
        } rggb_cfg[1:0];
    } ISP_DG_CTRL_F @ 0x113E0;

    reg {
        name = "ISP DG control I";
        desc = "[inferred] ISP DG control I. Not in the data sheet. Source: OpenIPC openhisilicon `kernel/isp/arch/hi3516cv300/firmware/vreg/arch/hi3516cv300/isp_reg_define.h` (GPL-3.0 repository, HiSilicon copyright, nManager-generated 2015-12-22 \"Define all registers/tables for Hi3519\"; local copy sources/openhisilicon), union `U_ISP_DG_CTRL_I`, struct offset 0x113E4 (GPL-3.0 repository; header offsets are ISP-core relative (data sheet offset - 0x20000), 632 of 775 data-sheet registers match it by name and offset (ISP_BLC_CFG is at 0x21100 in the data sheet and 0x1000+0x20000 in the header)). Reset value and access type unknown (modelled RW, no reset). Confidence: medium (vendor header for this chip family, not hardware verified).";

        field {
            name = "update_mode";
            desc = "[inferred] Update mode. (vendor header `isp_reg_define.h` field `update_mode`; access and reset unknown, modelled RW)";
            sw = rw;
            hw = r;
        } update_mode[0:0];
    } ISP_DG_CTRL_I @ 0x113E4;

    reg {
        name = "ISP DG UPDATE";
        desc = "[inferred] ISP DG UPDATE. Not in the data sheet. Source: OpenIPC openhisilicon `kernel/isp/arch/hi3516cv300/firmware/vreg/arch/hi3516cv300/isp_reg_define.h` (GPL-3.0 repository, HiSilicon copyright, nManager-generated 2015-12-22 \"Define all registers/tables for Hi3519\"; local copy sources/openhisilicon), union `U_ISP_DG_UPDATE`, struct offset 0x113EC (GPL-3.0 repository; header offsets are ISP-core relative (data sheet offset - 0x20000), 632 of 775 data-sheet registers match it by name and offset (ISP_BLC_CFG is at 0x21100 in the data sheet and 0x1000+0x20000 in the header)). Reset value and access type unknown (modelled RW, no reset). Confidence: medium (vendor header for this chip family, not hardware verified).";

        field {
            name = "update";
            desc = "[inferred] Update. (vendor header `isp_reg_define.h` field `update`; access and reset unknown, modelled RW)";
            sw = rw;
            hw = r;
        } update[0:0];
    } ISP_DG_UPDATE @ 0x113EC;

    reg {
        name = "2DG control register";
        desc = "ISP_2DG_CFG is a 2DG control register.

Data sheet 10.6 ISP_2DG_CFG (offset 0x21C00, printed page 10-109, `hi3516cv300--Hi3516CV300-Hi3516EV100-Datasheet.txt` line 46548).";

        enum ISP_2DG_CFG_en_enum {
            DISABLED = 0 { name = "Disabled"; desc = "disabled"; };
            ENABLED = 1 { name = "Enabled"; desc = "enabled"; };
        };

        field {
            name = "en";
            desc = "DG enable";
            sw = rw;
            hw = r;
            encode = ISP_2DG_CFG_en_enum;
            reset = 0x0;
        } en[0:0];
    } ISP_2DG_CFG @ 0x11C00;

    reg {
        name = "2DG black level control register";
        desc = "ISP_2DG_BLC_CFG is a 2DG black level control register. Hi3516C V300/Hi3516E V100 Professional HD IP Camera SoC

Data sheet 10.6 ISP_2DG_BLC_CFG (offset 0x21C04, printed page 10-110, `hi3516cv300--Hi3516CV300-Hi3516EV100-Datasheet.txt` line 46578).";

        enum ISP_2DG_BLC_CFG_en_out_enum {
            DISABLED = 0 { name = "Disabled"; desc = "disabled"; };
            ENABLED = 1 { name = "Enabled"; desc = "enabled"; };
        };

        field {
            name = "en_out";
            desc = "Output black level enable";
            sw = rw;
            hw = r;
            encode = ISP_2DG_BLC_CFG_en_out_enum;
            reset = 0x0;
        } en_out[1:1];

        enum ISP_2DG_BLC_CFG_en_in_enum {
            DISABLED = 0 { name = "Disabled"; desc = "disabled"; };
            ENABLED = 1 { name = "Enabled"; desc = "enabled"; };
        };

        field {
            name = "en_in";
            desc = "Input black level enable";
            sw = rw;
            hw = r;
            encode = ISP_2DG_BLC_CFG_en_in_enum;
            reset = 0x0;
        } en_in[0:0];
    } ISP_2DG_BLC_CFG @ 0x11C04;

    reg {
        name = "ISP 4DG VERSION";
        desc = "[inferred] ISP 4DG VERSION. Not in the data sheet. Source: OpenIPC openhisilicon `kernel/isp/arch/hi3516cv300/firmware/vreg/arch/hi3516cv300/isp_reg_define.h` (GPL-3.0 repository, HiSilicon copyright, nManager-generated 2015-12-22 \"Define all registers/tables for Hi3519\"; local copy sources/openhisilicon), union `U_ISP_4DG_VERSION`, struct offset 0x11C0C (GPL-3.0 repository; header offsets are ISP-core relative (data sheet offset - 0x20000), 632 of 775 data-sheet registers match it by name and offset (ISP_BLC_CFG is at 0x21100 in the data sheet and 0x1000+0x20000 in the header)). Reset value and access type unknown (modelled RW, no reset). Confidence: medium (vendor header for this chip family, not hardware verified).";

        field {
            name = "version";
            desc = "[inferred] Version. (vendor header `isp_reg_define.h` field `version`; access and reset unknown, modelled RW)";
            sw = rw;
            hw = r;
        } version[31:0];
    } ISP_4DG_VERSION @ 0x11C0C;

    reg {
        name = "Channel 0 DG gain (R, Gr) register";
        desc = "ISP_2DG_0_GAIN1 is a channel 0 DG gain (R, Gr) register.

Data sheet 10.6 ISP_2DG_0_GAIN1 (offset 0x21C10, printed page 10-110, `hi3516cv300--Hi3516CV300-Hi3516EV100-Datasheet.txt` line 46604).";

        field {
            name = "rgain";
            desc = "DG R gain (U8.8)";
            sw = rw;
            hw = r;
            reset = 0x100;
        } rgain[31:16];

        field {
            name = "grgain";
            desc = "DG Gr gain (U8.8)";
            sw = rw;
            hw = r;
            reset = 0x100;
        } grgain[15:0];
    } ISP_2DG_0_GAIN1 @ 0x11C10;

    reg {
        name = "Channel 0 DG gain (B, Gb) register";
        desc = "ISP_2DG_0_GAIN2 is a channel 0 DG gain (B, Gb) register. Hi3516C V300/Hi3516E V100 Professional HD IP Camera SoC

Data sheet 10.6 ISP_2DG_0_GAIN2 (offset 0x21C14, printed page 10-111, `hi3516cv300--Hi3516CV300-Hi3516EV100-Datasheet.txt` line 46633).";

        field {
            name = "bgain";
            desc = "DG B gain (U8.8)";
            sw = rw;
            hw = r;
            reset = 0x100;
        } bgain[31:16];

        field {
            name = "gbgain";
            desc = "DG Gb gain (U8.8)";
            sw = rw;
            hw = r;
            reset = 0x100;
        } gbgain[15:0];
    } ISP_2DG_0_GAIN2 @ 0x11C14;

    reg {
        name = "Channel 0 black level offset register T1 1";
        desc = "ISP_2DG_0_BLC_OFFSET1 is channel 0 black level offset register 1.

Data sheet 10.6 ISP_2DG_0_BLC_OFFSET1 (offset 0x21C18, printed page 10-111, `hi3516cv300--Hi3516CV300-Hi3516EV100-Datasheet.txt` line 46653).";

        field {
            name = "ofsr";
            desc = "Black level R offset, S15";
            sw = rw;
            hw = r;
            reset = 0x0;
        } ofsr[30:16];

        field {
            name = "ofsgr";
            desc = "Black level Gr offset, S15";
            sw = rw;
            hw = r;
            reset = 0x0;
        } ofsgr[14:0];
    } ISP_2DG_0_BLC_OFFSET1 @ 0x11C18;

    reg {
        name = "Channel 0 black level offset register T2 2";
        desc = "ISP_2DG_0_BLC_OFFSET2 is channel 0 black level offset register 2. Hi3516C V300/Hi3516E V100 Professional HD IP Camera SoC

Data sheet 10.6 ISP_2DG_0_BLC_OFFSET2 (offset 0x21C1C, printed page 10-112, `hi3516cv300--Hi3516CV300-Hi3516EV100-Datasheet.txt` line 46687).";

        field {
            name = "ofsb";
            desc = "Black level B offset, S15";
            sw = rw;
            hw = r;
            reset = 0x0;
        } ofsb[30:16];

        field {
            name = "ofsgb";
            desc = "Black level Gb offset, S15";
            sw = rw;
            hw = r;
            reset = 0x0;
        } ofsgb[14:0];
    } ISP_2DG_0_BLC_OFFSET2 @ 0x11C1C;

    reg {
        name = "Channel 1 DG gain (R, Gr) register";
        desc = "ISP_2DG_1_GAIN1 is a channel 1 DG gain (R, Gr) register.

Data sheet 10.6 ISP_2DG_1_GAIN1 (offset 0x21C20, printed page 10-112, `hi3516cv300--Hi3516CV300-Hi3516EV100-Datasheet.txt` line 46712).";

        field {
            name = "rgain";
            desc = "DG R gain (U8.8)";
            sw = rw;
            hw = r;
            reset = 0x100;
        } rgain[31:16];

        field {
            name = "grgain";
            desc = "DG Gr gain (U8.8)";
            sw = rw;
            hw = r;
            reset = 0x100;
        } grgain[15:0];
    } ISP_2DG_1_GAIN1 @ 0x11C20;

    reg {
        name = "Channel 1 DG gain (B, Gb) register";
        desc = "ISP_2DG_1_GAIN2 is a channel 1 DG gain (B, Gb) register. Hi3516C V300/Hi3516E V100 Professional HD IP Camera SoC

Data sheet 10.6 ISP_2DG_1_GAIN2 (offset 0x21C24, printed page 10-113, `hi3516cv300--Hi3516CV300-Hi3516EV100-Datasheet.txt` line 46740).";

        field {
            name = "bgain";
            desc = "DG B gain (U8.8)";
            sw = rw;
            hw = r;
            reset = 0x100;
        } bgain[31:16];

        field {
            name = "gbgain";
            desc = "DG Gb gain (U8.8)";
            sw = rw;
            hw = r;
            reset = 0x100;
        } gbgain[15:0];
    } ISP_2DG_1_GAIN2 @ 0x11C24;

    reg {
        name = "Channel 1 black level offset register T1 1";
        desc = "ISP_2DG_1_BLC_OFFSET1 is channel 1 black level offset register 1.

Data sheet 10.6 ISP_2DG_1_BLC_OFFSET1 (offset 0x21C28, printed page 10-113, `hi3516cv300--Hi3516CV300-Hi3516EV100-Datasheet.txt` line 46760).";

        field {
            name = "ofsr";
            desc = "Black level R offset, S15";
            sw = rw;
            hw = r;
            reset = 0x0;
        } ofsr[30:16];

        field {
            name = "ofsgr";
            desc = "Black level Gr offset, S15";
            sw = rw;
            hw = r;
            reset = 0x0;
        } ofsgr[14:0];
    } ISP_2DG_1_BLC_OFFSET1 @ 0x11C28;

    reg {
        name = "Channel 1 black level offset register T2 2";
        desc = "ISP_2DG_1_BLC_OFFSET2 is channel 1 black level offset register 2. Hi3516C V300/Hi3516E V100 Professional HD IP Camera SoC

Data sheet 10.6 ISP_2DG_1_BLC_OFFSET2 (offset 0x21C2C, printed page 10-114, `hi3516cv300--Hi3516CV300-Hi3516EV100-Datasheet.txt` line 46794).";

        field {
            name = "ofsb";
            desc = "Black level B offset, S15";
            sw = rw;
            hw = r;
            reset = 0x0;
        } ofsb[30:16];

        field {
            name = "ofsgb";
            desc = "Black level Gb offset, S15";
            sw = rw;
            hw = r;
            reset = 0x0;
        } ofsgb[14:0];
    } ISP_2DG_1_BLC_OFFSET2 @ 0x11C2C;

    reg {
        name = "ISP 4DG 2 GAIN1";
        desc = "[inferred] ISP 4DG 2 GAIN1. Not in the data sheet. Source: OpenIPC openhisilicon `kernel/isp/arch/hi3516cv300/firmware/vreg/arch/hi3516cv300/isp_reg_define.h` (GPL-3.0 repository, HiSilicon copyright, nManager-generated 2015-12-22 \"Define all registers/tables for Hi3519\"; local copy sources/openhisilicon), union `U_ISP_4DG_2_GAIN1`, struct offset 0x11C30 (GPL-3.0 repository; header offsets are ISP-core relative (data sheet offset - 0x20000), 632 of 775 data-sheet registers match it by name and offset (ISP_BLC_CFG is at 0x21100 in the data sheet and 0x1000+0x20000 in the header)). Reset value and access type unknown (modelled RW, no reset). Confidence: medium (vendor header for this chip family, not hardware verified).";

        field {
            name = "rgain";
            desc = "[inferred] Rgain. (vendor header `isp_reg_define.h` field `rgain`; access and reset unknown, modelled RW)";
            sw = rw;
            hw = r;
        } rgain[31:16];

        field {
            name = "grgain";
            desc = "[inferred] Grgain. (vendor header `isp_reg_define.h` field `grgain`; access and reset unknown, modelled RW)";
            sw = rw;
            hw = r;
        } grgain[15:0];
    } ISP_4DG_2_GAIN1 @ 0x11C30;

    reg {
        name = "ISP 4DG 2 GAIN2";
        desc = "[inferred] ISP 4DG 2 GAIN2. Not in the data sheet. Source: OpenIPC openhisilicon `kernel/isp/arch/hi3516cv300/firmware/vreg/arch/hi3516cv300/isp_reg_define.h` (GPL-3.0 repository, HiSilicon copyright, nManager-generated 2015-12-22 \"Define all registers/tables for Hi3519\"; local copy sources/openhisilicon), union `U_ISP_4DG_2_GAIN2`, struct offset 0x11C34 (GPL-3.0 repository; header offsets are ISP-core relative (data sheet offset - 0x20000), 632 of 775 data-sheet registers match it by name and offset (ISP_BLC_CFG is at 0x21100 in the data sheet and 0x1000+0x20000 in the header)). Reset value and access type unknown (modelled RW, no reset). Confidence: medium (vendor header for this chip family, not hardware verified).";

        field {
            name = "bgain";
            desc = "[inferred] Bgain. (vendor header `isp_reg_define.h` field `bgain`; access and reset unknown, modelled RW)";
            sw = rw;
            hw = r;
        } bgain[31:16];

        field {
            name = "gbgain";
            desc = "[inferred] Gbgain. (vendor header `isp_reg_define.h` field `gbgain`; access and reset unknown, modelled RW)";
            sw = rw;
            hw = r;
        } gbgain[15:0];
    } ISP_4DG_2_GAIN2 @ 0x11C34;

    reg {
        name = "ISP 4DG 2 black level correction OFFSET1";
        desc = "[inferred] ISP 4DG 2 black level correction OFFSET1. Not in the data sheet. Source: OpenIPC openhisilicon `kernel/isp/arch/hi3516cv300/firmware/vreg/arch/hi3516cv300/isp_reg_define.h` (GPL-3.0 repository, HiSilicon copyright, nManager-generated 2015-12-22 \"Define all registers/tables for Hi3519\"; local copy sources/openhisilicon), union `U_ISP_4DG_2_BLC_OFFSET1`, struct offset 0x11C38 (GPL-3.0 repository; header offsets are ISP-core relative (data sheet offset - 0x20000), 632 of 775 data-sheet registers match it by name and offset (ISP_BLC_CFG is at 0x21100 in the data sheet and 0x1000+0x20000 in the header)). Reset value and access type unknown (modelled RW, no reset). Confidence: medium (vendor header for this chip family, not hardware verified).";

        field {
            name = "ofsr";
            desc = "[inferred] Ofsr. (vendor header `isp_reg_define.h` field `ofsr`; access and reset unknown, modelled RW)";
            sw = rw;
            hw = r;
        } ofsr[30:16];

        field {
            name = "ofsgr";
            desc = "[inferred] Ofsgr. (vendor header `isp_reg_define.h` field `ofsgr`; access and reset unknown, modelled RW)";
            sw = rw;
            hw = r;
        } ofsgr[14:0];
    } ISP_4DG_2_BLC_OFFSET1 @ 0x11C38;

    reg {
        name = "ISP 4DG 2 black level correction OFFSET2";
        desc = "[inferred] ISP 4DG 2 black level correction OFFSET2. Not in the data sheet. Source: OpenIPC openhisilicon `kernel/isp/arch/hi3516cv300/firmware/vreg/arch/hi3516cv300/isp_reg_define.h` (GPL-3.0 repository, HiSilicon copyright, nManager-generated 2015-12-22 \"Define all registers/tables for Hi3519\"; local copy sources/openhisilicon), union `U_ISP_4DG_2_BLC_OFFSET2`, struct offset 0x11C3C (GPL-3.0 repository; header offsets are ISP-core relative (data sheet offset - 0x20000), 632 of 775 data-sheet registers match it by name and offset (ISP_BLC_CFG is at 0x21100 in the data sheet and 0x1000+0x20000 in the header)). Reset value and access type unknown (modelled RW, no reset). Confidence: medium (vendor header for this chip family, not hardware verified).";

        field {
            name = "ofsb";
            desc = "[inferred] Ofsb. (vendor header `isp_reg_define.h` field `ofsb`; access and reset unknown, modelled RW)";
            sw = rw;
            hw = r;
        } ofsb[30:16];

        field {
            name = "ofsgb";
            desc = "[inferred] Ofsgb. (vendor header `isp_reg_define.h` field `ofsgb`; access and reset unknown, modelled RW)";
            sw = rw;
            hw = r;
        } ofsgb[14:0];
    } ISP_4DG_2_BLC_OFFSET2 @ 0x11C3C;

    reg {
        name = "ISP 4DG 3 GAIN1";
        desc = "[inferred] ISP 4DG 3 GAIN1. Not in the data sheet. Source: OpenIPC openhisilicon `kernel/isp/arch/hi3516cv300/firmware/vreg/arch/hi3516cv300/isp_reg_define.h` (GPL-3.0 repository, HiSilicon copyright, nManager-generated 2015-12-22 \"Define all registers/tables for Hi3519\"; local copy sources/openhisilicon), union `U_ISP_4DG_3_GAIN1`, struct offset 0x11C40 (GPL-3.0 repository; header offsets are ISP-core relative (data sheet offset - 0x20000), 632 of 775 data-sheet registers match it by name and offset (ISP_BLC_CFG is at 0x21100 in the data sheet and 0x1000+0x20000 in the header)). Reset value and access type unknown (modelled RW, no reset). Confidence: medium (vendor header for this chip family, not hardware verified).";

        field {
            name = "rgain";
            desc = "[inferred] Rgain. (vendor header `isp_reg_define.h` field `rgain`; access and reset unknown, modelled RW)";
            sw = rw;
            hw = r;
        } rgain[31:16];

        field {
            name = "grgain";
            desc = "[inferred] Grgain. (vendor header `isp_reg_define.h` field `grgain`; access and reset unknown, modelled RW)";
            sw = rw;
            hw = r;
        } grgain[15:0];
    } ISP_4DG_3_GAIN1 @ 0x11C40;

    reg {
        name = "ISP 4DG 3 GAIN2";
        desc = "[inferred] ISP 4DG 3 GAIN2. Not in the data sheet. Source: OpenIPC openhisilicon `kernel/isp/arch/hi3516cv300/firmware/vreg/arch/hi3516cv300/isp_reg_define.h` (GPL-3.0 repository, HiSilicon copyright, nManager-generated 2015-12-22 \"Define all registers/tables for Hi3519\"; local copy sources/openhisilicon), union `U_ISP_4DG_3_GAIN2`, struct offset 0x11C44 (GPL-3.0 repository; header offsets are ISP-core relative (data sheet offset - 0x20000), 632 of 775 data-sheet registers match it by name and offset (ISP_BLC_CFG is at 0x21100 in the data sheet and 0x1000+0x20000 in the header)). Reset value and access type unknown (modelled RW, no reset). Confidence: medium (vendor header for this chip family, not hardware verified).";

        field {
            name = "bgain";
            desc = "[inferred] Bgain. (vendor header `isp_reg_define.h` field `bgain`; access and reset unknown, modelled RW)";
            sw = rw;
            hw = r;
        } bgain[31:16];

        field {
            name = "gbgain";
            desc = "[inferred] Gbgain. (vendor header `isp_reg_define.h` field `gbgain`; access and reset unknown, modelled RW)";
            sw = rw;
            hw = r;
        } gbgain[15:0];
    } ISP_4DG_3_GAIN2 @ 0x11C44;

    reg {
        name = "ISP 4DG 3 black level correction OFFSET1";
        desc = "[inferred] ISP 4DG 3 black level correction OFFSET1. Not in the data sheet. Source: OpenIPC openhisilicon `kernel/isp/arch/hi3516cv300/firmware/vreg/arch/hi3516cv300/isp_reg_define.h` (GPL-3.0 repository, HiSilicon copyright, nManager-generated 2015-12-22 \"Define all registers/tables for Hi3519\"; local copy sources/openhisilicon), union `U_ISP_4DG_3_BLC_OFFSET1`, struct offset 0x11C48 (GPL-3.0 repository; header offsets are ISP-core relative (data sheet offset - 0x20000), 632 of 775 data-sheet registers match it by name and offset (ISP_BLC_CFG is at 0x21100 in the data sheet and 0x1000+0x20000 in the header)). Reset value and access type unknown (modelled RW, no reset). Confidence: medium (vendor header for this chip family, not hardware verified).";

        field {
            name = "ofsr";
            desc = "[inferred] Ofsr. (vendor header `isp_reg_define.h` field `ofsr`; access and reset unknown, modelled RW)";
            sw = rw;
            hw = r;
        } ofsr[30:16];

        field {
            name = "ofsgr";
            desc = "[inferred] Ofsgr. (vendor header `isp_reg_define.h` field `ofsgr`; access and reset unknown, modelled RW)";
            sw = rw;
            hw = r;
        } ofsgr[14:0];
    } ISP_4DG_3_BLC_OFFSET1 @ 0x11C48;

    reg {
        name = "ISP 4DG 3 black level correction OFFSET2";
        desc = "[inferred] ISP 4DG 3 black level correction OFFSET2. Not in the data sheet. Source: OpenIPC openhisilicon `kernel/isp/arch/hi3516cv300/firmware/vreg/arch/hi3516cv300/isp_reg_define.h` (GPL-3.0 repository, HiSilicon copyright, nManager-generated 2015-12-22 \"Define all registers/tables for Hi3519\"; local copy sources/openhisilicon), union `U_ISP_4DG_3_BLC_OFFSET2`, struct offset 0x11C4C (GPL-3.0 repository; header offsets are ISP-core relative (data sheet offset - 0x20000), 632 of 775 data-sheet registers match it by name and offset (ISP_BLC_CFG is at 0x21100 in the data sheet and 0x1000+0x20000 in the header)). Reset value and access type unknown (modelled RW, no reset). Confidence: medium (vendor header for this chip family, not hardware verified).";

        field {
            name = "ofsb";
            desc = "[inferred] Ofsb. (vendor header `isp_reg_define.h` field `ofsb`; access and reset unknown, modelled RW)";
            sw = rw;
            hw = r;
        } ofsb[30:16];

        field {
            name = "ofsgb";
            desc = "[inferred] Ofsgb. (vendor header `isp_reg_define.h` field `ofsgb`; access and reset unknown, modelled RW)";
            sw = rw;
            hw = r;
        } ofsgb[14:0];
    } ISP_4DG_3_BLC_OFFSET2 @ 0x11C4C;

    reg {
        name = "ISP 4DG control F";
        desc = "[inferred] ISP 4DG control F. Not in the data sheet. Source: OpenIPC openhisilicon `kernel/isp/arch/hi3516cv300/firmware/vreg/arch/hi3516cv300/isp_reg_define.h` (GPL-3.0 repository, HiSilicon copyright, nManager-generated 2015-12-22 \"Define all registers/tables for Hi3519\"; local copy sources/openhisilicon), union `U_ISP_4DG_CTRL_F`, struct offset 0x11CE0 (GPL-3.0 repository; header offsets are ISP-core relative (data sheet offset - 0x20000), 632 of 775 data-sheet registers match it by name and offset (ISP_BLC_CFG is at 0x21100 in the data sheet and 0x1000+0x20000 in the header)). Reset value and access type unknown (modelled RW, no reset). Confidence: medium (vendor header for this chip family, not hardware verified).";

        field {
            name = "rggb_cfg";
            desc = "[inferred] Rggb configuration. (vendor header `isp_reg_define.h` field `rggb_cfg`; access and reset unknown, modelled RW)";
            sw = rw;
            hw = r;
        } rggb_cfg[1:0];
    } ISP_4DG_CTRL_F @ 0x11CE0;

    reg {
        name = "ISP 4DG control I";
        desc = "[inferred] ISP 4DG control I. Not in the data sheet. Source: OpenIPC openhisilicon `kernel/isp/arch/hi3516cv300/firmware/vreg/arch/hi3516cv300/isp_reg_define.h` (GPL-3.0 repository, HiSilicon copyright, nManager-generated 2015-12-22 \"Define all registers/tables for Hi3519\"; local copy sources/openhisilicon), union `U_ISP_4DG_CTRL_I`, struct offset 0x11CE4 (GPL-3.0 repository; header offsets are ISP-core relative (data sheet offset - 0x20000), 632 of 775 data-sheet registers match it by name and offset (ISP_BLC_CFG is at 0x21100 in the data sheet and 0x1000+0x20000 in the header)). Reset value and access type unknown (modelled RW, no reset). Confidence: medium (vendor header for this chip family, not hardware verified).";

        field {
            name = "update_mode";
            desc = "[inferred] Update mode. (vendor header `isp_reg_define.h` field `update_mode`; access and reset unknown, modelled RW)";
            sw = rw;
            hw = r;
        } update_mode[0:0];
    } ISP_4DG_CTRL_I @ 0x11CE4;

    reg {
        name = "ISP 4DG UPDATE";
        desc = "[inferred] ISP 4DG UPDATE. Not in the data sheet. Source: OpenIPC openhisilicon `kernel/isp/arch/hi3516cv300/firmware/vreg/arch/hi3516cv300/isp_reg_define.h` (GPL-3.0 repository, HiSilicon copyright, nManager-generated 2015-12-22 \"Define all registers/tables for Hi3519\"; local copy sources/openhisilicon), union `U_ISP_4DG_UPDATE`, struct offset 0x11CEC (GPL-3.0 repository; header offsets are ISP-core relative (data sheet offset - 0x20000), 632 of 775 data-sheet registers match it by name and offset (ISP_BLC_CFG is at 0x21100 in the data sheet and 0x1000+0x20000 in the header)). Reset value and access type unknown (modelled RW, no reset). Confidence: medium (vendor header for this chip family, not hardware verified).";

        field {
            name = "update";
            desc = "[inferred] Update. (vendor header `isp_reg_define.h` field `update`; access and reset unknown, modelled RW)";
            sw = rw;
            hw = r;
        } update[0:0];
    } ISP_4DG_UPDATE @ 0x11CEC;

    reg {
        name = "AE enable register";
        desc = "ISP_AE_CFG is an AE enable register.

Data sheet 10.6 ISP_AE_CFG (offset 0x22000, printed page 10-114, `hi3516cv300--Hi3516CV300-Hi3516EV100-Datasheet.txt` line 46819).";

        enum ISP_AE_CFG_en_enum {
            DISABLED = 0 { name = "Disabled"; desc = "disabled"; };
            ENABLED = 1 { name = "Enabled"; desc = "enabled"; };
        };

        field {
            name = "en";
            desc = "AE enable";
            sw = rw;
            hw = r;
            encode = ISP_AE_CFG_en_enum;
            reset = 0x1;
        } en[0:0];
    } ISP_AE_CFG @ 0x12000;

    reg {
        name = "ISP AE VERSION";
        desc = "[inferred] ISP AE VERSION. Not in the data sheet. Source: OpenIPC openhisilicon `kernel/isp/arch/hi3516cv300/firmware/vreg/arch/hi3516cv300/isp_reg_define.h` (GPL-3.0 repository, HiSilicon copyright, nManager-generated 2015-12-22 \"Define all registers/tables for Hi3519\"; local copy sources/openhisilicon), union `U_ISP_AE_VERSION`, struct offset 0x1200C (GPL-3.0 repository; header offsets are ISP-core relative (data sheet offset - 0x20000), 632 of 775 data-sheet registers match it by name and offset (ISP_BLC_CFG is at 0x21100 in the data sheet and 0x1000+0x20000 in the header)). Reset value and access type unknown (modelled RW, no reset). Confidence: medium (vendor header for this chip family, not hardware verified).";

        field {
            name = "version";
            desc = "[inferred] Version. (vendor header `isp_reg_define.h` field `version`; access and reset unknown, modelled RW)";
            sw = rw;
            hw = r;
        } version[31:0];
    } ISP_AE_VERSION @ 0x1200C;

    reg {
        name = "AE block configuration register";
        desc = "ISP_AE_ZONE is an AE block configuration register. Hi3516C V300/Hi3516E V100 Professional HD IP Camera SoC

Data sheet 10.6 ISP_AE_ZONE (offset 0x22010, printed page 10-115, `hi3516cv300--Hi3516CV300-Hi3516EV100-Datasheet.txt` line 46849).";

        field {
            name = "vnum";
            desc = "Number of vertical blocks";
            sw = rw;
            hw = r;
            reset = 0xF;
        } vnum[12:8];

        field {
            name = "hnum";
            desc = "Number of horizontal blocks";
            sw = rw;
            hw = r;
            reset = 0x11;
        } hnum[4:0];
    } ISP_AE_ZONE @ 0x12010;

    reg {
        name = "AE point select configuration register";
        desc = "ISP_AE_SKIP_CRG is an AE point select configuration register.

Data sheet 10.6 ISP_AE_SKIP_CRG (offset 0x22014, printed page 10-115, `hi3516cv300--Hi3516CV300-Hi3516EV100-Datasheet.txt` line 46874).";

        enum ISP_AE_SKIP_CRG_offset_y_enum {
            COUNT_FROM_ROW = 0 { name = "Count From Row"; desc = "count from row 0"; };
            COUNT_FROM_ROW_2 = 1 { name = "Count From Row 2"; desc = "count from row 1"; };
        };

        field {
            name = "offset_y";
            desc = "Count start row";
            sw = rw;
            hw = r;
            encode = ISP_AE_SKIP_CRG_offset_y_enum;
            reset = 0x0;
        } offset_y[7:7];

        enum ISP_AE_SKIP_CRG_skip_y_enum {
            EACH_PIXEL_POINT = 0 { name = "Each Pixel Point"; desc = "Each pixel point is collected for statistics."; };
            STATISTICS_COLLECTED_EVERY = 1 { name = "Statistics Collected Every"; desc = "Statistics are collected on every two pixels."; };
            STATISTICS_COLLECTED_EVERY_2 = 2 { name = "Statistics Collected Every 2"; desc = "Statistics are collected on every three pixels."; };
            STATISTICS_COLLECTED_EVERY_3 = 3 { name = "Statistics Collected Every 3"; desc = "Statistics are collected on every four pixels."; };
            STATISTICS_COLLECTED_EVERY_4 = 4 { name = "Statistics Collected Every 4"; desc = "Statistics are collected on every five pixels."; };
            STATISTICS_COLLECTED_EVERY_5 = 5 { name = "Statistics Collected Every 5"; desc = "Statistics are collected on every eight pixels. 110 or larger values: Statistics are collected on every nine pixels."; };
        };

        field {
            name = "skip_y";
            desc = "Vertical jump point configuration for statistical points";
            sw = rw;
            hw = r;
            encode = ISP_AE_SKIP_CRG_skip_y_enum;
            reset = 0x0;
        } skip_y[6:4];

        enum ISP_AE_SKIP_CRG_offset_x_enum {
            COUNT_FROM_COLUMN = 0 { name = "Count From Column"; desc = "count from column 0"; };
            COUNT_FROM_COLUMN_2 = 1 { name = "Count From Column 2"; desc = "count from column 1"; };
        };

        field {
            name = "offset_x";
            desc = "Count start column";
            sw = rw;
            hw = r;
            encode = ISP_AE_SKIP_CRG_offset_x_enum;
            reset = 0x0;
        } offset_x[3:3];

        enum ISP_AE_SKIP_CRG_skip_x_enum {
            STATISTICS_COLLECTED_EVERY = 0 { name = "Statistics Collected Every"; desc = "Statistics are collected on every pixel (only for the four- channel mode)."; };
            STATISTICS_COLLECTED_EVERY_2 = 1 { name = "Statistics Collected Every 2"; desc = "Statistics are collected on every two pixels."; };
            STATISTICS_COLLECTED_EVERY_3 = 2 { name = "Statistics Collected Every 3"; desc = "Statistics are collected on every three pixels."; };
            STATISTICS_COLLECTED_EVERY_4 = 3 { name = "Statistics Collected Every 4"; desc = "Statistics are collected on every four pixels."; };
            STATISTICS_COLLECTED_EVERY_5 = 4 { name = "Statistics Collected Every 5"; desc = "Statistics are collected on every five pixels."; };
            STATISTICS_COLLECTED_EVERY_6 = 5 { name = "Statistics Collected Every 6"; desc = "Statistics are collected on every eight pixels. 110 or larger values: Statistics are collected on every nine pixels."; };
        };

        field {
            name = "skip_x";
            desc = "Horizontal jump point configuration for statistical points";
            sw = rw;
            hw = r;
            encode = ISP_AE_SKIP_CRG_skip_x_enum;
            reset = 0x0;
        } skip_x[2:0];
    } ISP_AE_SKIP_CRG @ 0x12014;

    reg {
        name = "Selected point total number register in a picture frame during 1024- segment histogram statistics";
        desc = "ISP_AE_TOTAL_STAT is a selected point total number register in a picture frame during 1024-segment histogram statistics.

Data sheet 10.6 ISP_AE_TOTAL_STAT (offset 0x22018, printed page 10-116, `hi3516cv300--Hi3516CV300-Hi3516EV100-Datasheet.txt` line 46932).";

        field {
            name = "total_pixels";
            desc = "Number of selected points in a picture frame during 1024-segment histogram statistics";
            sw = r;
            hw = w;
            reset = 0x0;
        } total_pixels[25:0];
    } ISP_AE_TOTAL_STAT @ 0x12018;

    reg {
        name = "Selected point total weight register in a picture frame during 1024-segment histogram statistics";
        desc = "ISP_AE_COUNT_STAT is a selected point total weight register in a picture frame during 1024-segment histogram statistics.

Data sheet 10.6 ISP_AE_COUNT_STAT (offset 0x2201C, printed page 10-117, `hi3516cv300--Hi3516CV300-Hi3516EV100-Datasheet.txt` line 46960).";

        field {
            name = "count_pixels";
            desc = "Total weight of selected points in a picture frame during 1024- segment histogram statistics";
            sw = r;
            hw = w;
            reset = 0x0;
        } count_pixels[29:0];
    } ISP_AE_COUNT_STAT @ 0x1201C;

    reg {
        name = "R component average value register R in a picture frame during average value statistics";
        desc = "ISP_AE_TOTAL_R_AVER is an R component average value register in a picture frame during average value statistics.

Data sheet 10.6 ISP_AE_TOTAL_R_AVER (offset 0x22020, printed page 10-117, `hi3516cv300--Hi3516CV300-Hi3516EV100-Datasheet.txt` line 46987).";

        field {
            name = "total_r_aver";
            desc = "Global average value of the R component";
            sw = r;
            hw = w;
            reset = 0x0;
        } total_r_aver[31:0];
    } ISP_AE_TOTAL_R_AVER @ 0x12020;

    reg {
        name = "Gr component average value register ER in a picture frame during average value statistics";
        desc = "ISP_AE_TOTAL_GR_AVER is a Gr component average value register in a picture frame during average value statistics. Hi3516C V300/Hi3516E V100 Professional HD IP Camera SoC

Data sheet 10.6 ISP_AE_TOTAL_GR_AVER (offset 0x22024, printed page 10-118, `hi3516cv300--Hi3516CV300-Hi3516EV100-Datasheet.txt` line 47016).";

        field {
            name = "total_gr_aver";
            desc = "Global average value of the Gr component";
            sw = r;
            hw = w;
            reset = 0x0;
        } total_gr_aver[31:0];
    } ISP_AE_TOTAL_GR_AVER @ 0x12024;

    reg {
        name = "Gb component average value register ER in a picture frame during average value statistics";
        desc = "ISP_AE_TOTAL_GB_AVER is a Gb component average value register in a picture frame during average value statistics.

Data sheet 10.6 ISP_AE_TOTAL_GB_AVER (offset 0x22028, printed page 10-118, `hi3516cv300--Hi3516CV300-Hi3516EV100-Datasheet.txt` line 47036).";

        field {
            name = "total_gb_aver";
            desc = "Global average value of the Gb component";
            sw = r;
            hw = w;
            reset = 0x0;
        } total_gb_aver[31:0];
    } ISP_AE_TOTAL_GB_AVER @ 0x12028;

    reg {
        name = "B component average value register R in a picture frame during average value statistics";
        desc = "ISP_AE_TOTAL_B_AVER is a B component average value register in a picture frame during average value statistics.

Data sheet 10.6 ISP_AE_TOTAL_B_AVER (offset 0x2202C, printed page 10-118, `hi3516cv300--Hi3516CV300-Hi3516EV100-Datasheet.txt` line 47056).";

        field {
            name = "total_b_aver";
            desc = "Global average value of the B component";
            sw = r;
            hw = w;
            reset = 0x0;
        } total_b_aver[31:0];
    } ISP_AE_TOTAL_B_AVER @ 0x1202C;

    reg {
        name = "Histogram statistics high register";
        desc = "ISP_AE_HIST_HIGH is a histogram statistics high register.

Data sheet 10.6 ISP_AE_HIST_HIGH (offset 0x22030, printed page 10-119, `hi3516cv300--Hi3516CV300-Hi3516EV100-Datasheet.txt` line 47080).";

        field {
            name = "hist_high";
            desc = "Upper bits in histogram statistics";
            sw = r;
            hw = w;
            reset = 0x0;
        } hist_high[31:0];
    } ISP_AE_HIST_HIGH @ 0x12030;

    reg {
        name = "AE pixel shift value register";
        desc = "ISP_AE_BITMOVE is an AE pixel shift value register.

Data sheet 10.6 ISP_AE_BITMOVE (offset 0x22040, printed page 10-119, `hi3516cv300--Hi3516CV300-Hi3516EV100-Datasheet.txt` line 47099).";

        enum ISP_AE_BITMOVE_BLC_en_enum {
            DISABLED = 0 { name = "Disabled"; desc = "disabled"; };
            ENABLED = 1 { name = "Enabled"; desc = "enabled"; };
        };

        field {
            name = "BLC_en";
            desc = "AE BLC enable";
            sw = rw;
            hw = r;
            encode = ISP_AE_BITMOVE_BLC_en_enum;
            reset = 0x0;
        } BLC_en[9:9];

        enum ISP_AE_BITMOVE_gamma_en_enum {
            DISABLED = 0 { name = "Disabled"; desc = "disabled"; };
            ENABLED = 1 { name = "Enabled"; desc = "enabled"; };
        };

        field {
            name = "gamma_en";
            desc = "AE gamma enable";
            sw = rw;
            hw = r;
            encode = ISP_AE_BITMOVE_gamma_en_enum;
            reset = 0x0;
        } gamma_en[8:8];

        field {
            name = "bitmove";
            desc = "AE pixel shift value";
            sw = rw;
            hw = r;
            reset = 0x0;
        } bitmove[7:0];
    } ISP_AE_BITMOVE @ 0x12040;

    reg {
        name = "R component black level offset register";
        desc = "ISP_AE_OFFSET_R is an R component black level offset register. Hi3516C V300/Hi3516E V100 Professional HD IP Camera SoC

Data sheet 10.6 ISP_AE_OFFSET_R (offset 0x22044, printed page 10-120, `hi3516cv300--Hi3516CV300-Hi3516EV100-Datasheet.txt` line 47138).";

        field {
            name = "offset_r";
            desc = "Black level offset";
            sw = rw;
            hw = r;
            reset = 0x0;
        } offset_r[14:0];
    } ISP_AE_OFFSET_R @ 0x12044;

    reg {
        name = "Gr component black level offset register";
        desc = "ISP_AE_OFFSET_GR is a Gr component black level offset register.

Data sheet 10.6 ISP_AE_OFFSET_GR (offset 0x22048, printed page 10-120, `hi3516cv300--Hi3516CV300-Hi3516EV100-Datasheet.txt` line 47158).";

        field {
            name = "offset_gr";
            desc = "Black level offset";
            sw = rw;
            hw = r;
            reset = 0x0;
        } offset_gr[14:0];
    } ISP_AE_OFFSET_GR @ 0x12048;

    reg {
        name = "Gb component black level offset register";
        desc = "ISP_AE_OFFSET_GB is a Gb component black level offset register.

Data sheet 10.6 ISP_AE_OFFSET_GB (offset 0x2204C, printed page 10-120, `hi3516cv300--Hi3516CV300-Hi3516EV100-Datasheet.txt` line 47177).";

        field {
            name = "offset_gb";
            desc = "Black level offset";
            sw = rw;
            hw = r;
            reset = 0x0;
        } offset_gb[14:0];
    } ISP_AE_OFFSET_GB @ 0x1204C;

    reg {
        name = "B component black level offset register";
        desc = "ISP_AE_OFFSET_B is a B component black level offset register.

Data sheet 10.6 ISP_AE_OFFSET_B (offset 0x22050, printed page 10-121, `hi3516cv300--Hi3516CV300-Hi3516EV100-Datasheet.txt` line 47203).";

        field {
            name = "offset_b";
            desc = "Black level offset";
            sw = rw;
            hw = r;
            reset = 0x0;
        } offset_b[14:0];
    } ISP_AE_OFFSET_B @ 0x12050;

    reg {
        name = "AE_gamma module shift control register";
        desc = "ISP_AE_GAMMA_LIMIT is an AE_gamma module shift control register.

Data sheet 10.6 ISP_AE_GAMMA_LIMIT (offset 0x22060, printed page 10-121, `hi3516cv300--Hi3516CV300-Hi3516EV100-Datasheet.txt` line 47223).";

        field {
            name = "gamma_limit";
            desc = "Gamma module shift value control The value can be 1000, 1001, 1010, 1011, or 1100.";
            sw = rw;
            hw = r;
            reset = 0x0;
        } gamma_limit[3:0];
    } ISP_AE_GAMMA_LIMIT @ 0x12060;

    reg {
        name = "AE statistics mode select register ODE";
        desc = "ISP_AE_FOURPLANEMODE is an AE statistics mode select register. Hi3516C V300/Hi3516E V100 Professional HD IP Camera SoC

Data sheet 10.6 ISP_AE_FOURPLANEMODE (offset 0x22070, printed page 10-122, `hi3516cv300--Hi3516CV300-Hi3516EV100-Datasheet.txt` line 47253).";

        enum ISP_AE_FOURPLANEMODE_fourplanemode_enum {
            V_1024_HISTOGRAM_STATISTICS = 0 { name = "V 1024 Histogram Statistics"; desc = "1024 histogram statistics"; };
            FOUR_CHANNEL_256 = 1 { name = "Four Channel 256"; desc = "four-channel 256 histogram statistics"; };
        };

        field {
            name = "fourplanemode";
            desc = "Four-channel statistics mode select";
            sw = rw;
            hw = r;
            encode = ISP_AE_FOURPLANEMODE_fourplanemode_enum;
            reset = 0x0;
        } fourplanemode[0:0];
    } ISP_AE_FOURPLANEMODE @ 0x12070;

    reg {
        name = "ISP AE MEM histogram WADDR";
        desc = "[inferred] ISP AE MEM histogram WADDR. Not in the data sheet. Source: OpenIPC openhisilicon `kernel/isp/arch/hi3516cv300/firmware/vreg/arch/hi3516cv300/isp_reg_define.h` (GPL-3.0 repository, HiSilicon copyright, nManager-generated 2015-12-22 \"Define all registers/tables for Hi3519\"; local copy sources/openhisilicon), union `U_ISP_AE_MEM_HIST_WADDR`, struct offset 0x12080 (GPL-3.0 repository; header offsets are ISP-core relative (data sheet offset - 0x20000), 632 of 775 data-sheet registers match it by name and offset (ISP_BLC_CFG is at 0x21100 in the data sheet and 0x1000+0x20000 in the header)). Reset value and access type unknown (modelled RW, no reset). Confidence: medium (vendor header for this chip family, not hardware verified).";

        field {
            name = "hist_waddr";
            desc = "[inferred] Histogram waddr. (vendor header `isp_reg_define.h` field `hist_waddr`; access and reset unknown, modelled RW)";
            sw = rw;
            hw = r;
        } hist_waddr[31:0];
    } ISP_AE_MEM_HIST_WADDR @ 0x12080;

    reg {
        name = "ISP AE MEM histogram WDATA";
        desc = "[inferred] ISP AE MEM histogram WDATA. Not in the data sheet. Source: OpenIPC openhisilicon `kernel/isp/arch/hi3516cv300/firmware/vreg/arch/hi3516cv300/isp_reg_define.h` (GPL-3.0 repository, HiSilicon copyright, nManager-generated 2015-12-22 \"Define all registers/tables for Hi3519\"; local copy sources/openhisilicon), union `U_ISP_AE_MEM_HIST_WDATA`, struct offset 0x12084 (GPL-3.0 repository; header offsets are ISP-core relative (data sheet offset - 0x20000), 632 of 775 data-sheet registers match it by name and offset (ISP_BLC_CFG is at 0x21100 in the data sheet and 0x1000+0x20000 in the header)). Reset value and access type unknown (modelled RW, no reset). Confidence: medium (vendor header for this chip family, not hardware verified).";

        field {
            name = "hist_wdata";
            desc = "[inferred] Histogram wdata. (vendor header `isp_reg_define.h` field `hist_wdata`; access and reset unknown, modelled RW)";
            sw = rw;
            hw = r;
        } hist_wdata[31:0];
    } ISP_AE_MEM_HIST_WDATA @ 0x12084;

    reg {
        name = "AE histogram statistics read address DDR register";
        desc = "ISP_AE_MEM_HIST_RADDR is an AE histogram statistics read address register.

Data sheet 10.6 ISP_AE_MEM_HIST_RADDR (offset 0x22088, printed page 10-122, `hi3516cv300--Hi3516CV300-Hi3516EV100-Datasheet.txt` line 47281).";

        field {
            name = "hist_raddr";
            desc = "Histogram statistics read address";
            sw = rw;
            hw = r;
            reset = 0x0;
        } hist_raddr[31:0];
    } ISP_AE_MEM_HIST_RADDR @ 0x12088;

    reg {
        name = "AE histogram statistics read data ATA register";
        desc = "ISP_AE_MEM_HIST_RDATA is an AE histogram statistics read data register. Hi3516C V300/Hi3516E V100 Professional HD IP Camera SoC

Data sheet 10.6 ISP_AE_MEM_HIST_RDATA (offset 0x2208C, printed page 10-123, `hi3516cv300--Hi3516CV300-Hi3516EV100-Datasheet.txt` line 47308).";

        field {
            name = "hist_rdata";
            desc = "Histogram statistics read data";
            sw = r;
            hw = w;
            reset = 0x0;
        } hist_rdata[31:0];
    } ISP_AE_MEM_HIST_RDATA @ 0x1208C;

    reg {
        name = "ISP AE MEM AVER R GR WADDR";
        desc = "[inferred] ISP AE MEM AVER R GR WADDR. Not in the data sheet. Source: OpenIPC openhisilicon `kernel/isp/arch/hi3516cv300/firmware/vreg/arch/hi3516cv300/isp_reg_define.h` (GPL-3.0 repository, HiSilicon copyright, nManager-generated 2015-12-22 \"Define all registers/tables for Hi3519\"; local copy sources/openhisilicon), union `U_ISP_AE_MEM_AVER_R_GR_WADDR`, struct offset 0x12090 (GPL-3.0 repository; header offsets are ISP-core relative (data sheet offset - 0x20000), 632 of 775 data-sheet registers match it by name and offset (ISP_BLC_CFG is at 0x21100 in the data sheet and 0x1000+0x20000 in the header)). Reset value and access type unknown (modelled RW, no reset). Confidence: medium (vendor header for this chip family, not hardware verified).";

        field {
            name = "aver_r_gr_waddr";
            desc = "[inferred] Aver r gr waddr. (vendor header `isp_reg_define.h` field `aver_r_gr_waddr`; access and reset unknown, modelled RW)";
            sw = rw;
            hw = r;
        } aver_r_gr_waddr[31:0];
    } ISP_AE_MEM_AVER_R_GR_WADDR @ 0x12090;

    reg {
        name = "ISP AE MEM AVER R GR WDATA";
        desc = "[inferred] ISP AE MEM AVER R GR WDATA. Not in the data sheet. Source: OpenIPC openhisilicon `kernel/isp/arch/hi3516cv300/firmware/vreg/arch/hi3516cv300/isp_reg_define.h` (GPL-3.0 repository, HiSilicon copyright, nManager-generated 2015-12-22 \"Define all registers/tables for Hi3519\"; local copy sources/openhisilicon), union `U_ISP_AE_MEM_AVER_R_GR_WDATA`, struct offset 0x12094 (GPL-3.0 repository; header offsets are ISP-core relative (data sheet offset - 0x20000), 632 of 775 data-sheet registers match it by name and offset (ISP_BLC_CFG is at 0x21100 in the data sheet and 0x1000+0x20000 in the header)). Reset value and access type unknown (modelled RW, no reset). Confidence: medium (vendor header for this chip family, not hardware verified).";

        field {
            name = "aver_r_gr_wdata";
            desc = "[inferred] Aver r gr wdata. (vendor header `isp_reg_define.h` field `aver_r_gr_wdata`; access and reset unknown, modelled RW)";
            sw = rw;
            hw = r;
        } aver_r_gr_wdata[31:0];
    } ISP_AE_MEM_AVER_R_GR_WDATA @ 0x12094;

    reg {
        name = "AE module R and Gr value statistics GR_RADDR read address register";
        desc = "ISP_AE_MEM_AVER_R_GR_RADDR is an AE module R and Gr average value statistics read address register.

Data sheet 10.6 ISP_AE_MEM_AVER_R_GR_RADDR (offset 0x22098, printed page 10-123, `hi3516cv300--Hi3516CV300-Hi3516EV100-Datasheet.txt` line 47328).";

        field {
            name = "aver_r_gr_raddr";
            desc = "Read address of the R and Gr average value statistics";
            sw = rw;
            hw = r;
            reset = 0x0;
        } aver_r_gr_raddr[31:0];
    } ISP_AE_MEM_AVER_R_GR_RADDR @ 0x12098;

    reg {
        name = "AE module R and Gr value statistics GR_RDATA read data register";
        desc = "ISP_AE_MEM_AVER_R_GR_RDATA is an AE module R and Gr average value statistics read data register.

Data sheet 10.6 ISP_AE_MEM_AVER_R_GR_RDATA (offset 0x2209C, printed page 10-123, `hi3516cv300--Hi3516CV300-Hi3516EV100-Datasheet.txt` line 47348).";

        field {
            name = "aver_r_gr_rdata";
            desc = "Read data of the R and Gr average value statistics";
            sw = r;
            hw = w;
            reset = 0x0;
        } aver_r_gr_rdata[31:0];
    } ISP_AE_MEM_AVER_R_GR_RDATA @ 0x1209C;

    reg {
        name = "ISP AE MEM AVER GB B WADDR";
        desc = "[inferred] ISP AE MEM AVER GB B WADDR. Not in the data sheet. Source: OpenIPC openhisilicon `kernel/isp/arch/hi3516cv300/firmware/vreg/arch/hi3516cv300/isp_reg_define.h` (GPL-3.0 repository, HiSilicon copyright, nManager-generated 2015-12-22 \"Define all registers/tables for Hi3519\"; local copy sources/openhisilicon), union `U_ISP_AE_MEM_AVER_GB_B_WADDR`, struct offset 0x120A0 (GPL-3.0 repository; header offsets are ISP-core relative (data sheet offset - 0x20000), 632 of 775 data-sheet registers match it by name and offset (ISP_BLC_CFG is at 0x21100 in the data sheet and 0x1000+0x20000 in the header)). Reset value and access type unknown (modelled RW, no reset). Confidence: medium (vendor header for this chip family, not hardware verified).";

        field {
            name = "aver_gb_b_waddr";
            desc = "[inferred] Aver gb b waddr. (vendor header `isp_reg_define.h` field `aver_gb_b_waddr`; access and reset unknown, modelled RW)";
            sw = rw;
            hw = r;
        } aver_gb_b_waddr[31:0];
    } ISP_AE_MEM_AVER_GB_B_WADDR @ 0x120A0;

    reg {
        name = "ISP AE MEM AVER GB B WDATA";
        desc = "[inferred] ISP AE MEM AVER GB B WDATA. Not in the data sheet. Source: OpenIPC openhisilicon `kernel/isp/arch/hi3516cv300/firmware/vreg/arch/hi3516cv300/isp_reg_define.h` (GPL-3.0 repository, HiSilicon copyright, nManager-generated 2015-12-22 \"Define all registers/tables for Hi3519\"; local copy sources/openhisilicon), union `U_ISP_AE_MEM_AVER_GB_B_WDATA`, struct offset 0x120A4 (GPL-3.0 repository; header offsets are ISP-core relative (data sheet offset - 0x20000), 632 of 775 data-sheet registers match it by name and offset (ISP_BLC_CFG is at 0x21100 in the data sheet and 0x1000+0x20000 in the header)). Reset value and access type unknown (modelled RW, no reset). Confidence: medium (vendor header for this chip family, not hardware verified).";

        field {
            name = "aver_gb_b_wdata";
            desc = "[inferred] Aver gb b wdata. (vendor header `isp_reg_define.h` field `aver_gb_b_wdata`; access and reset unknown, modelled RW)";
            sw = rw;
            hw = r;
        } aver_gb_b_wdata[31:0];
    } ISP_AE_MEM_AVER_GB_B_WDATA @ 0x120A4;

    reg {
        name = "AE module Gb and B average value B_B_RADDR statistics read address register";
        desc = "ISP_AE_MEM_AVER_GB_B_RADDR is an AE module Gb and B average value statistics read address register.

Data sheet 10.6 ISP_AE_MEM_AVER_GB_B_RADDR (offset 0x220A8, printed page 10-124, `hi3516cv300--Hi3516CV300-Hi3516EV100-Datasheet.txt` line 47373).";

        field {
            name = "aver_gb_b_raddr";
            desc = "Read address of the Gb and B average value statistics";
            sw = rw;
            hw = r;
            reset = 0x0;
        } aver_gb_b_raddr[31:0];
    } ISP_AE_MEM_AVER_GB_B_RADDR @ 0x120A8;

    reg {
        name = "AE module Gb and B average value B_B_RDATA statistics read data register";
        desc = "ISP_AE_MEM_AVER_GB_B_RDATA is an AE module Gb and B average value statistics read data register.

Data sheet 10.6 ISP_AE_MEM_AVER_GB_B_RDATA (offset 0x220AC, printed page 10-124, `hi3516cv300--Hi3516CV300-Hi3516EV100-Datasheet.txt` line 47392).";

        field {
            name = "aver_gb_b_rdata";
            desc = "Read data of the Gb and B average value statistics";
            sw = r;
            hw = w;
            reset = 0x0;
        } aver_gb_b_rdata[31:0];
    } ISP_AE_MEM_AVER_GB_B_RDATA @ 0x120AC;

    reg {
        name = "Zone weight register write address WADDR register";
        desc = "ISP_AE_MEM_WEIGHT_WADDR is a zone weight register write address register.

Data sheet 10.6 ISP_AE_MEM_WEIGHT_WADDR (offset 0x220B0, printed page 10-124, `hi3516cv300--Hi3516CV300-Hi3516EV100-Datasheet.txt` line 47411).";

        field {
            name = "wei_waddr";
            desc = "Weight table write address";
            sw = rw;
            hw = r;
            reset = 0x0;
        } wei_waddr[31:0];
    } ISP_AE_MEM_WEIGHT_WADDR @ 0x120B0;

    reg {
        name = "Zone weight register write data WDATA register";
        desc = "ISP_AE_MEM_WEIGHT_WDATA is a zone weight register write data register.

Data sheet 10.6 ISP_AE_MEM_WEIGHT_WDATA (offset 0x220B4, printed page 10-125, `hi3516cv300--Hi3516CV300-Hi3516EV100-Datasheet.txt` line 47435).";

        field {
            name = "wei_wdata";
            desc = "Weight table write data";
            sw = rw;
            hw = r;
            reset = 0x0;
        } wei_wdata[31:0];
    } ISP_AE_MEM_WEIGHT_WDATA @ 0x120B4;

    reg {
        name = "ISP AE MEM WEIGHT RADDR";
        desc = "[inferred] ISP AE MEM WEIGHT RADDR. Not in the data sheet. Source: OpenIPC openhisilicon `kernel/isp/arch/hi3516cv300/firmware/vreg/arch/hi3516cv300/isp_reg_define.h` (GPL-3.0 repository, HiSilicon copyright, nManager-generated 2015-12-22 \"Define all registers/tables for Hi3519\"; local copy sources/openhisilicon), union `U_ISP_AE_MEM_WEIGHT_RADDR`, struct offset 0x120B8 (GPL-3.0 repository; header offsets are ISP-core relative (data sheet offset - 0x20000), 632 of 775 data-sheet registers match it by name and offset (ISP_BLC_CFG is at 0x21100 in the data sheet and 0x1000+0x20000 in the header)). Reset value and access type unknown (modelled RW, no reset). Confidence: medium (vendor header for this chip family, not hardware verified).";

        field {
            name = "wei_raddr";
            desc = "[inferred] Wei raddr. (vendor header `isp_reg_define.h` field `wei_raddr`; access and reset unknown, modelled RW)";
            sw = rw;
            hw = r;
        } wei_raddr[31:0];
    } ISP_AE_MEM_WEIGHT_RADDR @ 0x120B8;

    reg {
        name = "ISP AE MEM WEIGHT RDATA";
        desc = "[inferred] ISP AE MEM WEIGHT RDATA. Not in the data sheet. Source: OpenIPC openhisilicon `kernel/isp/arch/hi3516cv300/firmware/vreg/arch/hi3516cv300/isp_reg_define.h` (GPL-3.0 repository, HiSilicon copyright, nManager-generated 2015-12-22 \"Define all registers/tables for Hi3519\"; local copy sources/openhisilicon), union `U_ISP_AE_MEM_WEIGHT_RDATA`, struct offset 0x120BC (GPL-3.0 repository; header offsets are ISP-core relative (data sheet offset - 0x20000), 632 of 775 data-sheet registers match it by name and offset (ISP_BLC_CFG is at 0x21100 in the data sheet and 0x1000+0x20000 in the header)). Reset value and access type unknown (modelled RW, no reset). Confidence: medium (vendor header for this chip family, not hardware verified).";

        field {
            name = "wei_rdata";
            desc = "[inferred] Wei rdata. (vendor header `isp_reg_define.h` field `wei_rdata`; access and reset unknown, modelled RW)";
            sw = rw;
            hw = r;
        } wei_rdata[31:0];
    } ISP_AE_MEM_WEIGHT_RDATA @ 0x120BC;

    reg {
        name = "ISP AE control F";
        desc = "[inferred] ISP AE control F. Not in the data sheet. Source: OpenIPC openhisilicon `kernel/isp/arch/hi3516cv300/firmware/vreg/arch/hi3516cv300/isp_reg_define.h` (GPL-3.0 repository, HiSilicon copyright, nManager-generated 2015-12-22 \"Define all registers/tables for Hi3519\"; local copy sources/openhisilicon), union `U_ISP_AE_CTRL_F`, struct offset 0x120E0 (GPL-3.0 repository; header offsets are ISP-core relative (data sheet offset - 0x20000), 632 of 775 data-sheet registers match it by name and offset (ISP_BLC_CFG is at 0x21100 in the data sheet and 0x1000+0x20000 in the header)). Reset value and access type unknown (modelled RW, no reset). Confidence: medium (vendor header for this chip family, not hardware verified).";

        field {
            name = "rggb_cfg";
            desc = "[inferred] Rggb configuration. (vendor header `isp_reg_define.h` field `rggb_cfg`; access and reset unknown, modelled RW)";
            sw = rw;
            hw = r;
        } rggb_cfg[1:0];
    } ISP_AE_CTRL_F @ 0x120E0;

    reg {
        name = "ISP AE control I";
        desc = "[inferred] ISP AE control I. Not in the data sheet. Source: OpenIPC openhisilicon `kernel/isp/arch/hi3516cv300/firmware/vreg/arch/hi3516cv300/isp_reg_define.h` (GPL-3.0 repository, HiSilicon copyright, nManager-generated 2015-12-22 \"Define all registers/tables for Hi3519\"; local copy sources/openhisilicon), union `U_ISP_AE_CTRL_I`, struct offset 0x120E4 (GPL-3.0 repository; header offsets are ISP-core relative (data sheet offset - 0x20000), 632 of 775 data-sheet registers match it by name and offset (ISP_BLC_CFG is at 0x21100 in the data sheet and 0x1000+0x20000 in the header)). Reset value and access type unknown (modelled RW, no reset). Confidence: medium (vendor header for this chip family, not hardware verified).";

        field {
            name = "update_mode";
            desc = "[inferred] Update mode. (vendor header `isp_reg_define.h` field `update_mode`; access and reset unknown, modelled RW)";
            sw = rw;
            hw = r;
        } update_mode[0:0];
    } ISP_AE_CTRL_I @ 0x120E4;

    reg {
        name = "ISP AE UPDATE";
        desc = "[inferred] ISP AE UPDATE. Not in the data sheet. Source: OpenIPC openhisilicon `kernel/isp/arch/hi3516cv300/firmware/vreg/arch/hi3516cv300/isp_reg_define.h` (GPL-3.0 repository, HiSilicon copyright, nManager-generated 2015-12-22 \"Define all registers/tables for Hi3519\"; local copy sources/openhisilicon), union `U_ISP_AE_UPDATE`, struct offset 0x120EC (GPL-3.0 repository; header offsets are ISP-core relative (data sheet offset - 0x20000), 632 of 775 data-sheet registers match it by name and offset (ISP_BLC_CFG is at 0x21100 in the data sheet and 0x1000+0x20000 in the header)). Reset value and access type unknown (modelled RW, no reset). Confidence: medium (vendor header for this chip family, not hardware verified).";

        field {
            name = "update";
            desc = "[inferred] Update. (vendor header `isp_reg_define.h` field `update`; access and reset unknown, modelled RW)";
            sw = rw;
            hw = r;
        } update[0:0];
    } ISP_AE_UPDATE @ 0x120EC;

    reg {
        name = "AE picture size register";
        desc = "ISP_AE_SIZE is an AE picture size register.

Data sheet 10.6 ISP_AE_SIZE (offset 0x220F0, printed page 10-125, `hi3516cv300--Hi3516CV300-Hi3516EV100-Datasheet.txt` line 47454).";

        field {
            name = "vsize";
            desc = "Picture height";
            sw = rw;
            hw = r;
            reset = 0x437;
        } vsize[28:16];

        field {
            name = "hsize";
            desc = "Picture width";
            sw = rw;
            hw = r;
            reset = 0x77F;
        } hsize[12:0];
    } ISP_AE_SIZE @ 0x120F0;

    reg {
        name = "AWB enable register";
        desc = "ISP_AWB_CFG is an AWB enable register. Hi3516C V300/Hi3516E V100 Professional HD IP Camera SoC

Data sheet 10.6 ISP_AWB_CFG (offset 0x22100, printed page 10-126, `hi3516cv300--Hi3516CV300-Hi3516EV100-Datasheet.txt` line 47488).";

        enum ISP_AWB_CFG_work_en_enum {
            DISABLED = 0 { name = "Disabled"; desc = "disabled"; };
            ENABLED = 1 { name = "Enabled"; desc = "enabled"; };
        };

        field {
            name = "work_en";
            desc = "AWB enable";
            sw = rw;
            hw = r;
            encode = ISP_AWB_CFG_work_en_enum;
            reset = 0x0;
        } work_en[0:0];
    } ISP_AWB_CFG @ 0x12100;

    reg {
        name = "ISP AWB VERSION";
        desc = "[inferred] ISP AWB VERSION. Not in the data sheet. Source: OpenIPC openhisilicon `kernel/isp/arch/hi3516cv300/firmware/vreg/arch/hi3516cv300/isp_reg_define.h` (GPL-3.0 repository, HiSilicon copyright, nManager-generated 2015-12-22 \"Define all registers/tables for Hi3519\"; local copy sources/openhisilicon), union `U_ISP_AWB_VERSION`, struct offset 0x1210C (GPL-3.0 repository; header offsets are ISP-core relative (data sheet offset - 0x20000), 632 of 775 data-sheet registers match it by name and offset (ISP_BLC_CFG is at 0x21100 in the data sheet and 0x1000+0x20000 in the header)). Reset value and access type unknown (modelled RW, no reset). Confidence: medium (vendor header for this chip family, not hardware verified).";

        field {
            name = "version";
            desc = "[inferred] Version. (vendor header `isp_reg_define.h` field `version`; access and reset unknown, modelled RW)";
            sw = rw;
            hw = r;
        } version[31:0];
    } ISP_AWB_VERSION @ 0x1210C;

    reg {
        name = "AWB block configuration register";
        desc = "ISP_AWB_ZONE is an AWB block configuration register.

Data sheet 10.6 ISP_AWB_ZONE (offset 0x22110, printed page 10-126, `hi3516cv300--Hi3516CV300-Hi3516EV100-Datasheet.txt` line 47514).";

        field {
            name = "vnum";
            desc = "Number of vertical blocks. The maximum value is 32.";
            sw = rw;
            hw = r;
            reset = 0x0;
        } vnum[13:8];

        field {
            name = "hnum";
            desc = "Number of horizontal blocks. The maximum value is 32.";
            sw = rw;
            hw = r;
            reset = 0x0;
        } hnum[5:0];
    } ISP_AWB_ZONE @ 0x12110;

    reg {
        name = "AWB statistics bit configuration register";
        desc = "ISP_AWB_BITMOVE is an AWB statistics bit configuration register. Hi3516C V300/Hi3516E V100 Professional HD IP Camera SoC

Data sheet 10.6 ISP_AWB_BITMOVE (offset 0x22114, printed page 10-127, `hi3516cv300--Hi3516CV300-Hi3516EV100-Datasheet.txt` line 47549).";

        field {
            name = "bitmove";
            desc = "If this bit is set to 0, the uppermost 16 bits of the 20 bits RAW data are used as the AWB input data. If this bit is set to 4, the lowermost 16 bits are used as the AWB input data. The rule applies to other values.";
            sw = rw;
            hw = r;
            reset = 0x0;
        } bitmove[2:0];
    } ISP_AWB_BITMOVE @ 0x12114;

    reg {
        name = "AWB minimum RGB field value register";
        desc = "ISP_AWB_THD_MIN is an AWB minimum RGB field value register.

Data sheet 10.6 ISP_AWB_THD_MIN (offset 0x22118, printed page 10-127, `hi3516cv300--Hi3516CV300-Hi3516EV100-Datasheet.txt` line 47575).";

        field {
            name = "threshold_min";
            desc = "Minimum RGB field value during AWB statistics";
            sw = rw;
            hw = r;
            reset = 0x0;
        } threshold_min[15:0];
    } ISP_AWB_THD_MIN @ 0x12118;

    reg {
        name = "AWB maximum RGB field value register";
        desc = "ISP_AWB_THD_MAX is an AWB maximum RGB field value register. Hi3516C V300/Hi3516E V100 Professional HD IP Camera SoC

Data sheet 10.6 ISP_AWB_THD_MAX (offset 0x2211C, printed page 10-128, `hi3516cv300--Hi3516CV300-Hi3516EV100-Datasheet.txt` line 47603).";

        field {
            name = "threshold_max";
            desc = "Maximum RGB field value during AWB statistics";
            sw = rw;
            hw = r;
            reset = 0xFFFF;
        } threshold_max[15:0];
    } ISP_AWB_THD_MAX @ 0x1211C;

    reg {
        name = "AWB reference maximum/minimum R/G value register";
        desc = "ISP_AWB_CR_MM is an AWB reference maximum/minimum R/G value register.

Data sheet 10.6 ISP_AWB_CR_MM (offset 0x22120, printed page 10-128, `hi3516cv300--Hi3516CV300-Hi3516EV100-Datasheet.txt` line 47623).";

        field {
            name = "cr_ref_min";
            desc = "AWB reference minimum R/G value (U4.8)";
            sw = rw;
            hw = r;
            reset = 0x40;
        } cr_ref_min[27:16];

        field {
            name = "cr_ref_max";
            desc = "AWB reference maximum R/G value (U4.8)";
            sw = rw;
            hw = r;
            reset = 0x1FF;
        } cr_ref_max[11:0];
    } ISP_AWB_CR_MM @ 0x12120;

    reg {
        name = "AWB reference maximum/minimum B/G value register";
        desc = "ISP_AWB_CB_MM is an AWB reference maximum/minimum B/G value register.

Data sheet 10.6 ISP_AWB_CB_MM (offset 0x22124, printed page 10-128, `hi3516cv300--Hi3516CV300-Hi3516EV100-Datasheet.txt` line 47644).";

        field {
            name = "cb_ref_min";
            desc = "AWB reference minimum B/G value (U4.8)";
            sw = rw;
            hw = r;
            reset = 0x40;
        } cb_ref_min[27:16];

        field {
            name = "cb_ref_max";
            desc = "AWB reference maximum R/G value (U4.8)";
            sw = rw;
            hw = r;
            reset = 0x1FF;
        } cb_ref_max[11:0];
    } ISP_AWB_CB_MM @ 0x12124;

    reg {
        name = "AWB statistics offset compensation MP register";
        desc = "ISP_AWB_OFFSET_COMP is an AWB statistics offset compensation register.

Data sheet 10.6 ISP_AWB_OFFSET_COMP (offset 0x22128, printed page 10-129, `hi3516cv300--Hi3516CV300-Hi3516EV100-Datasheet.txt` line 47675).";

        field {
            name = "offset_comp";
            desc = "offset_comp";
            sw = rw;
            hw = r;
            reset = 0x0;
        } offset_comp[15:0];
    } ISP_AWB_OFFSET_COMP @ 0x12128;

    reg {
        name = "AWB gray area reference range top hypotenuse slope register";
        desc = "ISP_AWB_TOP_K is an AWB gray area reference range top hypotenuse slope register.

Data sheet 10.6 ISP_AWB_TOP_K (offset 0x22130, printed page 10-129, `hi3516cv300--Hi3516CV300-Hi3516EV100-Datasheet.txt` line 47695).";

        field {
            name = "awb_top_k";
            desc = "Hypotenuse slope of the AWB gray area reference range, two's complement, S13.12";
            sw = rw;
            hw = r;
            reset = 0x0;
        } awb_top_k[24:0];
    } ISP_AWB_TOP_K @ 0x12130;

    reg {
        name = "AWB gray area reference range top hypotenuse intercept register";
        desc = "ISP_AWB_TOP_B is an AWB gray area reference range top hypotenuse intercept register. Hi3516C V300/Hi3516E V100 Professional HD IP Camera SoC

Data sheet 10.6 ISP_AWB_TOP_B (offset 0x22134, printed page 10-130, `hi3516cv300--Hi3516CV300-Hi3516EV100-Datasheet.txt` line 47726).";

        field {
            name = "awb_top_b";
            desc = "Hypotenuse intercept of the AWB gray area reference range (U16.8)";
            sw = rw;
            hw = r;
            reset = 0x0;
        } awb_top_b[23:0];
    } ISP_AWB_TOP_B @ 0x12134;

    reg {
        name = "AWB gray area reference range bottom hypotenuse slope register";
        desc = "ISP_AWB_BOT_K is an AWB gray area reference range bottom hypotenuse slope register.

Data sheet 10.6 ISP_AWB_BOT_K (offset 0x22138, printed page 10-130, `hi3516cv300--Hi3516CV300-Hi3516EV100-Datasheet.txt` line 47748).";

        field {
            name = "awb_bot_k";
            desc = "Hypotenuse slope of the AWB gray area reference range, two's complement, S13.12";
            sw = rw;
            hw = r;
            reset = 0x0;
        } awb_bot_k[24:0];
    } ISP_AWB_BOT_K @ 0x12138;

    reg {
        name = "AWB gray area reference range bottom hypotenuse intercept register";
        desc = "ISP_AWB_BOT_B is an AWB gray area reference range bottom hypotenuse intercept register.

Data sheet 10.6 ISP_AWB_BOT_B (offset 0x2213C, printed page 10-130, `hi3516cv300--Hi3516CV300-Hi3516EV100-Datasheet.txt` line 47769).";

        field {
            name = "awb_bot_b";
            desc = "Hypotenuse intercept of the AWB gray area reference range (U16.8)";
            sw = rw;
            hw = r;
            reset = 0x0;
        } awb_bot_b[23:0];
    } ISP_AWB_BOT_B @ 0x1213C;

    reg {
        name = "R component average value register of an entire picture";
        desc = "ISP_AWB_AVG_R is an R component average value register of an entire picture.

Data sheet 10.6 ISP_AWB_AVG_R (offset 0x22140, printed page 10-131, `hi3516cv300--Hi3516CV300-Hi3516EV100-Datasheet.txt` line 47800).";

        field {
            name = "avg_r";
            desc = "Average value of the R component for an entire picture (U16.0)";
            sw = r;
            hw = w;
            reset = 0x0;
        } avg_r[15:0];
    } ISP_AWB_AVG_R @ 0x12140;

    reg {
        name = "G component average value register of an entire picture";
        desc = "ISP_AWB_AVG_G is a G component average value register of an entire picture.

Data sheet 10.6 ISP_AWB_AVG_G (offset 0x22144, printed page 10-131, `hi3516cv300--Hi3516CV300-Hi3516EV100-Datasheet.txt` line 47820).";

        field {
            name = "avg_g";
            desc = "Average value of the G component for an entire picture (U16.0)";
            sw = r;
            hw = w;
            reset = 0x0;
        } avg_g[15:0];
    } ISP_AWB_AVG_G @ 0x12144;

    reg {
        name = "B component average value register of an entire picture";
        desc = "ISP_AWB_AVG_B is a B component average value register of an entire picture. Hi3516C V300/Hi3516E V100 Professional HD IP Camera SoC

Data sheet 10.6 ISP_AWB_AVG_B (offset 0x22148, printed page 10-132, `hi3516cv300--Hi3516CV300-Hi3516EV100-Datasheet.txt` line 47848).";

        field {
            name = "avg_b";
            desc = "Average value of the B component for an entire picture (U16.0)";
            sw = r;
            hw = w;
            reset = 0x0;
        } avg_b[15:0];
    } ISP_AWB_AVG_B @ 0x12148;

    reg {
        name = "Statistical point number register of an entire picture";
        desc = "ISP_AWB_CNT_ALL is a statistical point number register of an entire picture.

Data sheet 10.6 ISP_AWB_CNT_ALL (offset 0x2214C, printed page 10-132, `hi3516cv300--Hi3516CV300-Hi3516EV100-Datasheet.txt` line 47868).";

        field {
            name = "count_all";
            desc = "Number of statistical points in an entire picture";
            sw = r;
            hw = w;
            reset = 0x0;
        } count_all[15:0];
    } ISP_AWB_CNT_ALL @ 0x1214C;

    reg {
        name = "ISP AWB status WADDR";
        desc = "[inferred] ISP AWB status WADDR. Not in the data sheet. Source: OpenIPC openhisilicon `kernel/isp/arch/hi3516cv300/firmware/vreg/arch/hi3516cv300/isp_reg_define.h` (GPL-3.0 repository, HiSilicon copyright, nManager-generated 2015-12-22 \"Define all registers/tables for Hi3519\"; local copy sources/openhisilicon), union `U_ISP_AWB_STAT_WADDR`, struct offset 0x12180 (GPL-3.0 repository; header offsets are ISP-core relative (data sheet offset - 0x20000), 632 of 775 data-sheet registers match it by name and offset (ISP_BLC_CFG is at 0x21100 in the data sheet and 0x1000+0x20000 in the header)). Reset value and access type unknown (modelled RW, no reset). Confidence: medium (vendor header for this chip family, not hardware verified).";

        field {
            name = "value";
            desc = "[inferred] Register value (the header union has no named bits).";
            sw = rw;
            hw = r;
        } value[31:0];
    } ISP_AWB_STAT_WADDR @ 0x12180;

    reg {
        name = "ISP AWB status WDATA";
        desc = "[inferred] ISP AWB status WDATA. Not in the data sheet. Source: OpenIPC openhisilicon `kernel/isp/arch/hi3516cv300/firmware/vreg/arch/hi3516cv300/isp_reg_define.h` (GPL-3.0 repository, HiSilicon copyright, nManager-generated 2015-12-22 \"Define all registers/tables for Hi3519\"; local copy sources/openhisilicon), union `U_ISP_AWB_STAT_WDATA`, struct offset 0x12184 (GPL-3.0 repository; header offsets are ISP-core relative (data sheet offset - 0x20000), 632 of 775 data-sheet registers match it by name and offset (ISP_BLC_CFG is at 0x21100 in the data sheet and 0x1000+0x20000 in the header)). Reset value and access type unknown (modelled RW, no reset). Confidence: medium (vendor header for this chip family, not hardware verified).";

        field {
            name = "value";
            desc = "[inferred] Register value (the header union has no named bits).";
            sw = rw;
            hw = r;
        } value[31:0];
    } ISP_AWB_STAT_WDATA @ 0x12184;

    reg {
        name = "AWB statistics read address register R";
        desc = "ISP_AWB_STAT_RADDR is an AWB statistics read address register.

Data sheet 10.6 ISP_AWB_STAT_RADDR (offset 0x22188, printed page 10-132, `hi3516cv300--Hi3516CV300-Hi3516EV100-Datasheet.txt` line 47887).";

        enum ISP_AWB_STAT_RADDR_stat_raddr_enum {
            AVG_G_AVG = 0x0 { name = "Avg G Avg"; desc = "AVG G+AVG R for block 0"; };
            COUNT_ALL_AVG = 0x1 { name = "Count All Avg"; desc = "Count All+AVG B for block 0"; };
            BLOCK_1_SAME = 0x2 { name = "Block 1 Same"; desc = "…for block 1 The same rule applies to other values. There are 1024 blocks, and the address value range is 0-2047."; };
        };

        field {
            name = "stat_raddr";
            desc = "AWB statistics address The sequence is as follows:";
            sw = rw;
            hw = r;
            encode = ISP_AWB_STAT_RADDR_stat_raddr_enum;
            reset = 0x0;
        } stat_raddr[10:0];
    } ISP_AWB_STAT_RADDR @ 0x12188;

    reg {
        name = "AWB statistics read return data A register";
        desc = "ISP_AWB_STAT_RDATA is an AWB statistics read return data register.

Data sheet 10.6 ISP_AWB_STAT_RDATA (offset 0x2218C, printed page 10-133, `hi3516cv300--Hi3516CV300-Hi3516EV100-Datasheet.txt` line 47923).";

        field {
            name = "stat_rdata";
            desc = "Read return value of AWB statistics. Each statistical value occupies 16 bits. AVG R/G/B are 16-bit integers, and Count ALL is normalized to 16 bits.";
            sw = r;
            hw = w;
            reset = 0x0;
        } stat_rdata[31:0];
    } ISP_AWB_STAT_RDATA @ 0x1218C;

    reg {
        name = "ISP AWB control F";
        desc = "[inferred] ISP AWB control F. Not in the data sheet. Source: OpenIPC openhisilicon `kernel/isp/arch/hi3516cv300/firmware/vreg/arch/hi3516cv300/isp_reg_define.h` (GPL-3.0 repository, HiSilicon copyright, nManager-generated 2015-12-22 \"Define all registers/tables for Hi3519\"; local copy sources/openhisilicon), union `U_ISP_AWB_CTRL_F`, struct offset 0x121E0 (GPL-3.0 repository; header offsets are ISP-core relative (data sheet offset - 0x20000), 632 of 775 data-sheet registers match it by name and offset (ISP_BLC_CFG is at 0x21100 in the data sheet and 0x1000+0x20000 in the header)). Reset value and access type unknown (modelled RW, no reset). Confidence: medium (vendor header for this chip family, not hardware verified).";

        field {
            name = "rggb_cfg";
            desc = "[inferred] Rggb configuration. (vendor header `isp_reg_define.h` field `rggb_cfg`; access and reset unknown, modelled RW)";
            sw = rw;
            hw = r;
        } rggb_cfg[1:0];
    } ISP_AWB_CTRL_F @ 0x121E0;

    reg {
        name = "ISP AWB control I";
        desc = "[inferred] ISP AWB control I. Not in the data sheet. Source: OpenIPC openhisilicon `kernel/isp/arch/hi3516cv300/firmware/vreg/arch/hi3516cv300/isp_reg_define.h` (GPL-3.0 repository, HiSilicon copyright, nManager-generated 2015-12-22 \"Define all registers/tables for Hi3519\"; local copy sources/openhisilicon), union `U_ISP_AWB_CTRL_I`, struct offset 0x121E4 (GPL-3.0 repository; header offsets are ISP-core relative (data sheet offset - 0x20000), 632 of 775 data-sheet registers match it by name and offset (ISP_BLC_CFG is at 0x21100 in the data sheet and 0x1000+0x20000 in the header)). Reset value and access type unknown (modelled RW, no reset). Confidence: medium (vendor header for this chip family, not hardware verified).";

        field {
            name = "update_mode";
            desc = "[inferred] Update mode. (vendor header `isp_reg_define.h` field `update_mode`; access and reset unknown, modelled RW)";
            sw = rw;
            hw = r;
        } update_mode[0:0];
    } ISP_AWB_CTRL_I @ 0x121E4;

    reg {
        name = "ISP AWB UPDATE";
        desc = "[inferred] ISP AWB UPDATE. Not in the data sheet. Source: OpenIPC openhisilicon `kernel/isp/arch/hi3516cv300/firmware/vreg/arch/hi3516cv300/isp_reg_define.h` (GPL-3.0 repository, HiSilicon copyright, nManager-generated 2015-12-22 \"Define all registers/tables for Hi3519\"; local copy sources/openhisilicon), union `U_ISP_AWB_UPDATE`, struct offset 0x121EC (GPL-3.0 repository; header offsets are ISP-core relative (data sheet offset - 0x20000), 632 of 775 data-sheet registers match it by name and offset (ISP_BLC_CFG is at 0x21100 in the data sheet and 0x1000+0x20000 in the header)). Reset value and access type unknown (modelled RW, no reset). Confidence: medium (vendor header for this chip family, not hardware verified).";

        field {
            name = "update";
            desc = "[inferred] Update. (vendor header `isp_reg_define.h` field `update`; access and reset unknown, modelled RW)";
            sw = rw;
            hw = r;
        } update[0:0];
    } ISP_AWB_UPDATE @ 0x121EC;

    reg {
        name = "AWB picture size register";
        desc = "ISP_AWB_SIZE is an AWB picture size register.

Data sheet 10.6 ISP_AWB_SIZE (offset 0x221F0, printed page 10-133, `hi3516cv300--Hi3516CV300-Hi3516EV100-Datasheet.txt` line 47943).";

        field {
            name = "vsize";
            desc = "Picture height. The configured value is the actual value minus 1. For example, if the actual picture height is 1080, set this field to 1079.";
            sw = rw;
            hw = r;
            reset = 0x437;
        } vsize[28:16];

        field {
            name = "hsize";
            desc = "Picture width (minus 1). For example, if the actual picture width is 1920, set this field to 1919.";
            sw = rw;
            hw = r;
            reset = 0x77F;
        } hsize[12:0];
    } ISP_AWB_SIZE @ 0x121F0;

    reg {
        name = "DIS enable register";
        desc = "ISP_DIS_CFG is a DIS enable register.

Data sheet 10.6 ISP_DIS_CFG (offset 0x22400, printed page 10-134, `hi3516cv300--Hi3516CV300-Hi3516EV100-Datasheet.txt` line 47982).";

        enum ISP_DIS_CFG_work_en_enum {
            DISABLED = 0 { name = "Disabled"; desc = "disabled"; };
            ENABLED = 1 { name = "Enabled"; desc = "enabled"; };
        };

        field {
            name = "work_en";
            desc = "DIS enable";
            sw = rw;
            hw = r;
            encode = ISP_DIS_CFG_work_en_enum;
            reset = 0x0;
        } work_en[0:0];
    } ISP_DIS_CFG @ 0x12400;

    reg {
        name = "Block configuration register";
        desc = "ISP_DIS_BLK is a block configuration register.

Data sheet 10.6 ISP_DIS_BLK (offset 0x22404, printed page 10-134, `hi3516cv300--Hi3516CV300-Hi3516EV100-Datasheet.txt` line 48008).";

        field {
            name = "srch_range";
            desc = "Upper six bits of the search range. The value range is 4-32.";
            sw = rw;
            hw = r;
            reset = 0x0;
        } srch_range[22:17];

        field {
            name = "srch_range_0";
            desc = "Least significant bit (LSB) of the search range. This bit is fixed at 0.";
            sw = r;
            hw = w;
            reset = 0x0;
        } srch_range_0[16:16];

        field {
            name = "blk_size";
            desc = "Upper seven bits of the side length of the square block. The value range is 8-64.";
            sw = rw;
            hw = r;
            reset = 0x0;
        } blk_size[7:1];

        field {
            name = "blk_size_0";
            desc = "LSB of the side length of the square block. This bit is fixed at 0.";
            sw = r;
            hw = w;
            reset = 0x0;
        } blk_size_0[0:0];
    } ISP_DIS_BLK @ 0x12404;

    reg {
        name = "ISP DIS VERSION";
        desc = "[inferred] ISP DIS VERSION. Not in the data sheet. Source: OpenIPC openhisilicon `kernel/isp/arch/hi3516cv300/firmware/vreg/arch/hi3516cv300/isp_reg_define.h` (GPL-3.0 repository, HiSilicon copyright, nManager-generated 2015-12-22 \"Define all registers/tables for Hi3519\"; local copy sources/openhisilicon), union `U_ISP_DIS_VERSION`, struct offset 0x1240C (GPL-3.0 repository; header offsets are ISP-core relative (data sheet offset - 0x20000), 632 of 775 data-sheet registers match it by name and offset (ISP_BLC_CFG is at 0x21100 in the data sheet and 0x1000+0x20000 in the header)). Reset value and access type unknown (modelled RW, no reset). Confidence: medium (vendor header for this chip family, not hardware verified).";

        field {
            name = "version";
            desc = "[inferred] Version. (vendor header `isp_reg_define.h` field `version`; access and reset unknown, modelled RW)";
            sw = rw;
            hw = r;
        } version[31:0];
    } ISP_DIS_VERSION @ 0x1240C;

    reg {
        name = "Vertical PRJ0 block address register";
        desc = "ISP_DIS_V0POS is a vertical PRJ0 block address register.

Data sheet 10.6 ISP_DIS_V0POS (offset 0x22410, printed page 10-135, `hi3516cv300--Hi3516CV300-Hi3516EV100-Datasheet.txt` line 48051).";

        field {
            name = "ver";
            desc = "Vertical coordinate of the vertical PRJ0 block. The LSB of the coordinate value is excluded, and one bit is subtracted.";
            sw = rw;
            hw = r;
            reset = 0x0;
        } ver[26:16];

        field {
            name = "hor";
            desc = "Horizontal coordinate of the vertical PRJ0 block. The LSB of the coordinate value is excluded, and one bit is subtracted.";
            sw = rw;
            hw = r;
            reset = 0x0;
        } hor[10:0];
    } ISP_DIS_V0POS @ 0x12410;

    reg {
        name = "Vertical PRJ4 block address register";
        desc = "ISP_DIS_V4POS is a vertical PRJ4 block address register.

Data sheet 10.6 ISP_DIS_V4POS (offset 0x22414, printed page 10-135, `hi3516cv300--Hi3516CV300-Hi3516EV100-Datasheet.txt` line 48077).";

        field {
            name = "ver";
            desc = "Vertical coordinate of the vertical PRJ4 block. The LSB of the coordinate value is excluded, and one bit is subtracted.";
            sw = rw;
            hw = r;
            reset = 0x0;
        } ver[26:16];

        field {
            name = "hor";
            desc = "Horizontal coordinate of the vertical PRJ4 block. The LSB of the coordinate value is excluded, and one bit is subtracted.";
            sw = rw;
            hw = r;
            reset = 0x0;
        } hor[10:0];
    } ISP_DIS_V4POS @ 0x12414;

    reg {
        name = "Vertical PRJ8 block address register";
        desc = "ISP_DIS_V8POS is a vertical PRJ8 block address register.

Data sheet 10.6 ISP_DIS_V8POS (offset 0x22418, printed page 10-136, `hi3516cv300--Hi3516CV300-Hi3516EV100-Datasheet.txt` line 48112).";

        field {
            name = "ver";
            desc = "Vertical coordinate of the vertical PRJ8 block. The LSB of the coordinate value is excluded, and one bit is subtracted.";
            sw = rw;
            hw = r;
            reset = 0x0;
        } ver[26:16];

        field {
            name = "hor";
            desc = "Horizontal coordinate of the vertical PRJ8 block. The LSB of the coordinate value is excluded, and one bit is subtracted.";
            sw = rw;
            hw = r;
            reset = 0x0;
        } hor[10:0];
    } ISP_DIS_V8POS @ 0x12418;

    reg {
        name = "Vertical PRJ0 block address register";
        desc = "ISP_DIS_V0POSE is a vertical PRJ0 block address register.

Data sheet 10.6 ISP_DIS_V0POSE (offset 0x22420, printed page 10-136, `hi3516cv300--Hi3516CV300-Hi3516EV100-Datasheet.txt` line 48138).";

        field {
            name = "ver";
            desc = "Vertical coordinate of the end point of the vertical PRJ0 block. The LSB of the coordinate value is excluded, and one bit is subtracted.";
            sw = rw;
            hw = r;
            reset = 0x0;
        } ver[26:16];

        field {
            name = "hor";
            desc = "Horizontal coordinate of the end point of the vertical PRJ0 block. The LSB of the coordinate value is excluded, and one bit is subtracted.";
            sw = rw;
            hw = r;
            reset = 0x0;
        } hor[10:0];
    } ISP_DIS_V0POSE @ 0x12420;

    reg {
        name = "Vertical PRJ4 block address register";
        desc = "ISP_DIS_V4POSE is a vertical PRJ4 block address register.

Data sheet 10.6 ISP_DIS_V4POSE (offset 0x22424, printed page 10-137, `hi3516cv300--Hi3516CV300-Hi3516EV100-Datasheet.txt` line 48174).";

        field {
            name = "ver";
            desc = "Vertical coordinate of the end point of the vertical PRJ4 block. The LSB of the coordinate value is excluded, and one bit is subtracted.";
            sw = rw;
            hw = r;
            reset = 0x0;
        } ver[26:16];

        field {
            name = "hor";
            desc = "Horizontal coordinate of the end point of the vertical PRJ4 block. The LSB of the coordinate value is excluded, and one bit is subtracted.";
            sw = rw;
            hw = r;
            reset = 0x0;
        } hor[10:0];
    } ISP_DIS_V4POSE @ 0x12424;

    reg {
        name = "Vertical PRJ8 block address register";
        desc = "ISP_DIS_V8POSE is a vertical PRJ8 block address register.

Data sheet 10.6 ISP_DIS_V8POSE (offset 0x22428, printed page 10-137, `hi3516cv300--Hi3516CV300-Hi3516EV100-Datasheet.txt` line 48199).";

        field {
            name = "ver";
            desc = "Vertical coordinate of the end point of the vertical PRJ8 block. The LSB of the coordinate value is excluded, and one bit is subtracted.";
            sw = rw;
            hw = r;
            reset = 0x0;
        } ver[26:16];

        field {
            name = "hor";
            desc = "Horizontal coordinate of the end point of the vertical PRJ8 block. The LSB of the coordinate value is excluded, and one bit is subtracted.";
            sw = rw;
            hw = r;
            reset = 0x0;
        } hor[10:0];
    } ISP_DIS_V8POSE @ 0x12428;

    reg {
        name = "Horizontal PRJ0 block address register";
        desc = "ISP_DIS_H0POS is a horizontal PRJ0 block address register.

Data sheet 10.6 ISP_DIS_H0POS (offset 0x22430, printed page 10-138, `hi3516cv300--Hi3516CV300-Hi3516EV100-Datasheet.txt` line 48233).";

        field {
            name = "ver";
            desc = "Vertical coordinate of the horizontal PRJ0 block. The LSB of the coordinate value is excluded, and one bit is subtracted.";
            sw = rw;
            hw = r;
            reset = 0x0;
        } ver[26:16];

        field {
            name = "hor";
            desc = "Horizontal coordinate of the horizontal PRJ0 block. The LSB of the coordinate value is excluded, and one bit is subtracted.";
            sw = rw;
            hw = r;
            reset = 0x0;
        } hor[10:0];
    } ISP_DIS_H0POS @ 0x12430;

    reg {
        name = "Horizontal PRJ4 block address register";
        desc = "ISP_DIS_H4POS is a horizontal PRJ4 block address register.

Data sheet 10.6 ISP_DIS_H4POS (offset 0x22434, printed page 10-138, `hi3516cv300--Hi3516CV300-Hi3516EV100-Datasheet.txt` line 48258).";

        field {
            name = "ver";
            desc = "Vertical coordinate of the horizontal PRJ4 block. The LSB of the coordinate value is excluded, and one bit is subtracted.";
            sw = rw;
            hw = r;
            reset = 0x0;
        } ver[26:16];

        field {
            name = "hor";
            desc = "Horizontal coordinate of the horizontal PRJ4 block. The LSB of the coordinate value is excluded, and one bit is subtracted.";
            sw = rw;
            hw = r;
            reset = 0x0;
        } hor[10:0];
    } ISP_DIS_H4POS @ 0x12434;

    reg {
        name = "Horizontal PRJ8 block address register";
        desc = "ISP_DIS_H8POS is a horizontal PRJ8 block address register.

Data sheet 10.6 ISP_DIS_H8POS (offset 0x22438, printed page 10-139, `hi3516cv300--Hi3516CV300-Hi3516EV100-Datasheet.txt` line 48289).";

        field {
            name = "ver";
            desc = "Vertical coordinate of the horizontal PRJ8 block. The LSB of the coordinate value is excluded, and one bit is subtracted.";
            sw = rw;
            hw = r;
            reset = 0x0;
        } ver[26:16];

        field {
            name = "hor";
            desc = "Horizontal coordinate of the horizontal PRJ8 block. The LSB of the coordinate value is excluded, and one bit is subtracted.";
            sw = rw;
            hw = r;
            reset = 0x0;
        } hor[10:0];
    } ISP_DIS_H8POS @ 0x12438;

    reg {
        name = "Horizontal PRJ0 block address register";
        desc = "ISP_DIS_H0POSE is a horizontal PRJ0 block address register.

Data sheet 10.6 ISP_DIS_H0POSE (offset 0x22440, printed page 10-139, `hi3516cv300--Hi3516CV300-Hi3516EV100-Datasheet.txt` line 48315).";

        field {
            name = "ver";
            desc = "Vertical coordinate of the end point of the horizontal PRJ0 block. The LSB of the coordinate value is excluded, and one bit is subtracted.";
            sw = rw;
            hw = r;
            reset = 0x0;
        } ver[26:16];

        field {
            name = "hor";
            desc = "Horizontal coordinate of the end point of the horizontal PRJ0 block. The LSB of the coordinate value is excluded, and one bit is subtracted.";
            sw = rw;
            hw = r;
            reset = 0x0;
        } hor[10:0];
    } ISP_DIS_H0POSE @ 0x12440;

    reg {
        name = "Horizontal PRJ4 block address register";
        desc = "ISP_DIS_H4POSE is a horizontal PRJ4 block address register. Hi3516C V300/Hi3516E V100 Professional HD IP Camera SoC

Data sheet 10.6 ISP_DIS_H4POSE (offset 0x22444, printed page 10-140, `hi3516cv300--Hi3516CV300-Hi3516EV100-Datasheet.txt` line 48348).";

        field {
            name = "ver";
            desc = "Vertical coordinate of the end point of the horizontal PRJ4 block. The LSB of the coordinate value is excluded, and one bit is subtracted.";
            sw = rw;
            hw = r;
            reset = 0x0;
        } ver[26:16];

        field {
            name = "hor";
            desc = "Horizontal coordinate of the end point of the horizontal PRJ4 block. The LSB of the coordinate value is excluded, and one bit is subtracted.";
            sw = rw;
            hw = r;
            reset = 0x0;
        } hor[10:0];
    } ISP_DIS_H4POSE @ 0x12444;

    reg {
        name = "Horizontal PRJ8 block address register";
        desc = "ISP_DIS_H8POSE is a horizontal PRJ8 block address register.

Data sheet 10.6 ISP_DIS_H8POSE (offset 0x22448, printed page 10-140, `hi3516cv300--Hi3516CV300-Hi3516EV100-Datasheet.txt` line 48374).";

        field {
            name = "ver";
            desc = "Vertical coordinate of the end point of the horizontal PRJ8 block. The LSB of the coordinate value is excluded, and one bit is subtracted.";
            sw = rw;
            hw = r;
            reset = 0x0;
        } ver[26:16];

        field {
            name = "hor";
            desc = "Horizontal coordinate of the end point of the horizontal PRJ8 block. The LSB of the coordinate value is excluded, and one bit is subtracted.";
            sw = rw;
            hw = r;
            reset = 0x0;
        } hor[10:0];
    } ISP_DIS_H8POSE @ 0x12448;

    reg {
        name = "ISP DIS RAW LUMA";
        desc = "[inferred] ISP DIS RAW LUMA. Not in the data sheet. Source: OpenIPC openhisilicon `kernel/isp/arch/hi3516cv300/firmware/vreg/arch/hi3516cv300/isp_reg_define.h` (GPL-3.0 repository, HiSilicon copyright, nManager-generated 2015-12-22 \"Define all registers/tables for Hi3519\"; local copy sources/openhisilicon), union `U_ISP_DIS_RAW_LUMA`, struct offset 0x12450 (GPL-3.0 repository; header offsets are ISP-core relative (data sheet offset - 0x20000), 632 of 775 data-sheet registers match it by name and offset (ISP_BLC_CFG is at 0x21100 in the data sheet and 0x1000+0x20000 in the header)). Reset value and access type unknown (modelled RW, no reset). Confidence: medium (vendor header for this chip family, not hardware verified).";

        field {
            name = "raw_luma";
            desc = "[inferred] Raw luma. (vendor header `isp_reg_define.h` field `raw_luma`; access and reset unknown, modelled RW)";
            sw = rw;
            hw = r;
        } raw_luma[0:0];
    } ISP_DIS_RAW_LUMA @ 0x12450;

    reg {
        name = "Gamma enable register";
        desc = "ISP_DIS_GAMMA_EN is a gamma enable register. Hi3516C V300/Hi3516E V100 Professional HD IP Camera SoC

Data sheet 10.6 ISP_DIS_GAMMA_EN (offset 0x22454, printed page 10-141, `hi3516cv300--Hi3516CV300-Hi3516EV100-Datasheet.txt` line 48409).";

        enum ISP_DIS_GAMMA_EN_gamma_en_enum {
            DISABLED = 0 { name = "Disabled"; desc = "disabled"; };
            ENABLED = 1 { name = "Enabled"; desc = "enabled"; };
        };

        field {
            name = "gamma_en";
            desc = "Gamma enable";
            sw = rw;
            hw = r;
            encode = ISP_DIS_GAMMA_EN_gamma_en_enum;
            reset = 0x0;
        } gamma_en[0:0];
    } ISP_DIS_GAMMA_EN @ 0x12454;

    reg {
        name = "ISP DIS H status WADDR";
        desc = "[inferred] ISP DIS H status WADDR. Not in the data sheet. Source: OpenIPC openhisilicon `kernel/isp/arch/hi3516cv300/firmware/vreg/arch/hi3516cv300/isp_reg_define.h` (GPL-3.0 repository, HiSilicon copyright, nManager-generated 2015-12-22 \"Define all registers/tables for Hi3519\"; local copy sources/openhisilicon), union `U_ISP_DIS_H_STAT_WADDR`, struct offset 0x12480 (GPL-3.0 repository; header offsets are ISP-core relative (data sheet offset - 0x20000), 632 of 775 data-sheet registers match it by name and offset (ISP_BLC_CFG is at 0x21100 in the data sheet and 0x1000+0x20000 in the header)). Reset value and access type unknown (modelled RW, no reset). Confidence: medium (vendor header for this chip family, not hardware verified).";

        field {
            name = "value";
            desc = "[inferred] Register value (the header union has no named bits).";
            sw = rw;
            hw = r;
        } value[31:0];
    } ISP_DIS_H_STAT_WADDR @ 0x12480;

    reg {
        name = "ISP DIS H status WDATA";
        desc = "[inferred] ISP DIS H status WDATA. Not in the data sheet. Source: OpenIPC openhisilicon `kernel/isp/arch/hi3516cv300/firmware/vreg/arch/hi3516cv300/isp_reg_define.h` (GPL-3.0 repository, HiSilicon copyright, nManager-generated 2015-12-22 \"Define all registers/tables for Hi3519\"; local copy sources/openhisilicon), union `U_ISP_DIS_H_STAT_WDATA`, struct offset 0x12484 (GPL-3.0 repository; header offsets are ISP-core relative (data sheet offset - 0x20000), 632 of 775 data-sheet registers match it by name and offset (ISP_BLC_CFG is at 0x21100 in the data sheet and 0x1000+0x20000 in the header)). Reset value and access type unknown (modelled RW, no reset). Confidence: medium (vendor header for this chip family, not hardware verified).";

        field {
            name = "value";
            desc = "[inferred] Register value (the header union has no named bits).";
            sw = rw;
            hw = r;
        } value[31:0];
    } ISP_DIS_H_STAT_WDATA @ 0x12484;

    reg {
        name = "Horizontal statistics read address R register";
        desc = "ISP_DIS_H_STAT_RADDR is a horizontal statistics read address register.

Data sheet 10.6 ISP_DIS_H_STAT_RADDR (offset 0x22488, printed page 10-141, `hi3516cv300--Hi3516CV300-Hi3516EV100-Datasheet.txt` line 48436).";

        enum ISP_DIS_H_STAT_RADDR_h_stat_raddr_enum {
            H_DELTA_14 = 0x0 { name = "H Delta 14"; desc = "h_delta[14:0] of block 0"; };
            H_SAD_21 = 0x1 { name = "H Sad 21"; desc = "h_sad[21:0] of block 0"; };
            H_MV_7 = 0x2 { name = "H Mv 7"; desc = "h_mv[7:0] of block 0 … The same rule applies to other values."; };
        };

        field {
            name = "h_stat_raddr";
            desc = "h_delta, h_sad, and h_mv information about each block. Each address contains only one piece of information. For example:";
            sw = rw;
            hw = r;
            encode = ISP_DIS_H_STAT_RADDR_h_stat_raddr_enum;
            reset = 0x0;
        } h_stat_raddr[31:0];
    } ISP_DIS_H_STAT_RADDR @ 0x12488;

    reg {
        name = "Horizontal statistics read data A register";
        desc = "ISP_DIS_H_STAT_RDATA is a horizontal statistics read data register. Hi3516C V300/Hi3516E V100 Professional HD IP Camera SoC

Data sheet 10.6 ISP_DIS_H_STAT_RDATA (offset 0x2248C, printed page 10-142, `hi3516cv300--Hi3516CV300-Hi3516EV100-Datasheet.txt` line 48469).";

        field {
            name = "h_stat_rdata";
            desc = "Horizontal statistics";
            sw = r;
            hw = w;
            reset = 0x0;
        } h_stat_rdata[31:0];
    } ISP_DIS_H_STAT_RDATA @ 0x1248C;

    reg {
        name = "ISP DIS V status WADDR";
        desc = "[inferred] ISP DIS V status WADDR. Not in the data sheet. Source: OpenIPC openhisilicon `kernel/isp/arch/hi3516cv300/firmware/vreg/arch/hi3516cv300/isp_reg_define.h` (GPL-3.0 repository, HiSilicon copyright, nManager-generated 2015-12-22 \"Define all registers/tables for Hi3519\"; local copy sources/openhisilicon), union `U_ISP_DIS_V_STAT_WADDR`, struct offset 0x12490 (GPL-3.0 repository; header offsets are ISP-core relative (data sheet offset - 0x20000), 632 of 775 data-sheet registers match it by name and offset (ISP_BLC_CFG is at 0x21100 in the data sheet and 0x1000+0x20000 in the header)). Reset value and access type unknown (modelled RW, no reset). Confidence: medium (vendor header for this chip family, not hardware verified).";

        field {
            name = "value";
            desc = "[inferred] Register value (the header union has no named bits).";
            sw = rw;
            hw = r;
        } value[31:0];
    } ISP_DIS_V_STAT_WADDR @ 0x12490;

    reg {
        name = "ISP DIS V status WDATA";
        desc = "[inferred] ISP DIS V status WDATA. Not in the data sheet. Source: OpenIPC openhisilicon `kernel/isp/arch/hi3516cv300/firmware/vreg/arch/hi3516cv300/isp_reg_define.h` (GPL-3.0 repository, HiSilicon copyright, nManager-generated 2015-12-22 \"Define all registers/tables for Hi3519\"; local copy sources/openhisilicon), union `U_ISP_DIS_V_STAT_WDATA`, struct offset 0x12494 (GPL-3.0 repository; header offsets are ISP-core relative (data sheet offset - 0x20000), 632 of 775 data-sheet registers match it by name and offset (ISP_BLC_CFG is at 0x21100 in the data sheet and 0x1000+0x20000 in the header)). Reset value and access type unknown (modelled RW, no reset). Confidence: medium (vendor header for this chip family, not hardware verified).";

        field {
            name = "value";
            desc = "[inferred] Register value (the header union has no named bits).";
            sw = rw;
            hw = r;
        } value[31:0];
    } ISP_DIS_V_STAT_WDATA @ 0x12494;

    reg {
        name = "Vertical statistics read address R register";
        desc = "ISP_DIS_V_STAT_RADDR is a vertical statistics read address register.

Data sheet 10.6 ISP_DIS_V_STAT_RADDR (offset 0x22498, printed page 10-142, `hi3516cv300--Hi3516CV300-Hi3516EV100-Datasheet.txt` line 48488).";

        enum ISP_DIS_V_STAT_RADDR_v_stat_raddr_enum {
            V_DELTA_14 = 0x0 { name = "V Delta 14"; desc = "v_delta[14:0] of block 0"; };
            V_SAD_21 = 0x1 { name = "V Sad 21"; desc = "v_sad[21:0] of block 0"; };
            V_MV_7 = 0x2 { name = "V Mv 7"; desc = "v_mv[7:0] of block 0 … The same rule applies to other values."; };
        };

        field {
            name = "v_stat_raddr";
            desc = "v_delta, v_sad, and v_mv information about each block. Each address contains only one piece of information. For example:";
            sw = rw;
            hw = r;
            encode = ISP_DIS_V_STAT_RADDR_v_stat_raddr_enum;
            reset = 0x0;
        } v_stat_raddr[31:0];
    } ISP_DIS_V_STAT_RADDR @ 0x12498;

    reg {
        name = "Vertical statistics read data register A";
        desc = "ISP_DIS_V_STAT_RDATA is a vertical statistics read data register. Hi3516C V300/Hi3516E V100 Professional HD IP Camera SoC

Data sheet 10.6 ISP_DIS_V_STAT_RDATA (offset 0x2249C, printed page 10-143, `hi3516cv300--Hi3516CV300-Hi3516EV100-Datasheet.txt` line 48521).";

        field {
            name = "v_stat_rdata";
            desc = "Vertical statistics";
            sw = r;
            hw = w;
            reset = 0x0;
        } v_stat_rdata[31:0];
    } ISP_DIS_V_STAT_RDATA @ 0x1249C;

    reg {
        name = "ISP DIS control F";
        desc = "[inferred] ISP DIS control F. Not in the data sheet. Source: OpenIPC openhisilicon `kernel/isp/arch/hi3516cv300/firmware/vreg/arch/hi3516cv300/isp_reg_define.h` (GPL-3.0 repository, HiSilicon copyright, nManager-generated 2015-12-22 \"Define all registers/tables for Hi3519\"; local copy sources/openhisilicon), union `U_ISP_DIS_CTRL_F`, struct offset 0x124E0 (GPL-3.0 repository; header offsets are ISP-core relative (data sheet offset - 0x20000), 632 of 775 data-sheet registers match it by name and offset (ISP_BLC_CFG is at 0x21100 in the data sheet and 0x1000+0x20000 in the header)). Reset value and access type unknown (modelled RW, no reset). Confidence: medium (vendor header for this chip family, not hardware verified).";

        field {
            name = "rggb_cfg";
            desc = "[inferred] Rggb configuration. (vendor header `isp_reg_define.h` field `rggb_cfg`; access and reset unknown, modelled RW)";
            sw = rw;
            hw = r;
        } rggb_cfg[1:0];
    } ISP_DIS_CTRL_F @ 0x124E0;

    reg {
        name = "ISP DIS control I";
        desc = "[inferred] ISP DIS control I. Not in the data sheet. Source: OpenIPC openhisilicon `kernel/isp/arch/hi3516cv300/firmware/vreg/arch/hi3516cv300/isp_reg_define.h` (GPL-3.0 repository, HiSilicon copyright, nManager-generated 2015-12-22 \"Define all registers/tables for Hi3519\"; local copy sources/openhisilicon), union `U_ISP_DIS_CTRL_I`, struct offset 0x124E4 (GPL-3.0 repository; header offsets are ISP-core relative (data sheet offset - 0x20000), 632 of 775 data-sheet registers match it by name and offset (ISP_BLC_CFG is at 0x21100 in the data sheet and 0x1000+0x20000 in the header)). Reset value and access type unknown (modelled RW, no reset). Confidence: medium (vendor header for this chip family, not hardware verified).";

        field {
            name = "update_mode";
            desc = "[inferred] Update mode. (vendor header `isp_reg_define.h` field `update_mode`; access and reset unknown, modelled RW)";
            sw = rw;
            hw = r;
        } update_mode[0:0];
    } ISP_DIS_CTRL_I @ 0x124E4;

    reg {
        name = "ISP DIS UPDATE";
        desc = "[inferred] ISP DIS UPDATE. Not in the data sheet. Source: OpenIPC openhisilicon `kernel/isp/arch/hi3516cv300/firmware/vreg/arch/hi3516cv300/isp_reg_define.h` (GPL-3.0 repository, HiSilicon copyright, nManager-generated 2015-12-22 \"Define all registers/tables for Hi3519\"; local copy sources/openhisilicon), union `U_ISP_DIS_UPDATE`, struct offset 0x124EC (GPL-3.0 repository; header offsets are ISP-core relative (data sheet offset - 0x20000), 632 of 775 data-sheet registers match it by name and offset (ISP_BLC_CFG is at 0x21100 in the data sheet and 0x1000+0x20000 in the header)). Reset value and access type unknown (modelled RW, no reset). Confidence: medium (vendor header for this chip family, not hardware verified).";

        field {
            name = "update";
            desc = "[inferred] Update. (vendor header `isp_reg_define.h` field `update`; access and reset unknown, modelled RW)";
            sw = rw;
            hw = r;
        } update[0:0];
    } ISP_DIS_UPDATE @ 0x124EC;

    reg {
        name = "MG enable register";
        desc = "ISP_MG_CFG is an MG enable register.

Data sheet 10.6 ISP_MG_CFG (offset 0x22500, printed page 10-143, `hi3516cv300--Hi3516CV300-Hi3516EV100-Datasheet.txt` line 48540).";

        enum ISP_MG_CFG_en_enum {
            DISABLED = 0 { name = "Disabled"; desc = "disabled"; };
            ENABLED = 1 { name = "Enabled"; desc = "enabled"; };
        };

        field {
            name = "en";
            desc = "MG enable";
            sw = rw;
            hw = r;
            encode = ISP_MG_CFG_en_enum;
            reset = 0x1;
        } en[0:0];
    } ISP_MG_CFG @ 0x12500;

    reg {
        name = "ISP MG VERSION";
        desc = "[inferred] ISP MG VERSION. Not in the data sheet. Source: OpenIPC openhisilicon `kernel/isp/arch/hi3516cv300/firmware/vreg/arch/hi3516cv300/isp_reg_define.h` (GPL-3.0 repository, HiSilicon copyright, nManager-generated 2015-12-22 \"Define all registers/tables for Hi3519\"; local copy sources/openhisilicon), union `U_ISP_MG_VERSION`, struct offset 0x1250C (GPL-3.0 repository; header offsets are ISP-core relative (data sheet offset - 0x20000), 632 of 775 data-sheet registers match it by name and offset (ISP_BLC_CFG is at 0x21100 in the data sheet and 0x1000+0x20000 in the header)). Reset value and access type unknown (modelled RW, no reset). Confidence: medium (vendor header for this chip family, not hardware verified).";

        field {
            name = "version";
            desc = "[inferred] Version. (vendor header `isp_reg_define.h` field `version`; access and reset unknown, modelled RW)";
            sw = rw;
            hw = r;
        } version[31:0];
    } ISP_MG_VERSION @ 0x1250C;

    reg {
        name = "MG zone configuration register";
        desc = "ISP_MG_ZONE is an MG zone configuration register. Hi3516C V300/Hi3516E V100 Professional HD IP Camera SoC

Data sheet 10.6 ISP_MG_ZONE (offset 0x22510, printed page 10-144, `hi3516cv300--Hi3516CV300-Hi3516EV100-Datasheet.txt` line 48570).";

        field {
            name = "vnum";
            desc = "Number of zones in the vertical direction";
            sw = rw;
            hw = r;
            reset = 0xF;
        } vnum[12:8];

        field {
            name = "hnum";
            desc = "Number of zones in the horizontal direction";
            sw = rw;
            hw = r;
            reset = 0x11;
        } hnum[4:0];
    } ISP_MG_ZONE @ 0x12510;

    reg {
        name = "MG pixel shift register";
        desc = "ISP_MG_BITMOVE is an MG pixel shift register.

Data sheet 10.6 ISP_MG_BITMOVE (offset 0x22540, printed page 10-144, `hi3516cv300--Hi3516CV300-Hi3516EV100-Datasheet.txt` line 48595).";

        field {
            name = "BLC_en";
            desc = "MG BLC enable";
            sw = rw;
            hw = r;
            reset = 0x0;
        } BLC_en[9:9];

        field {
            name = "gamma_en";
            desc = "MG gamma enable";
            sw = rw;
            hw = r;
            reset = 0x0;
        } gamma_en[8:8];

        field {
            name = "bitmove";
            desc = "MG pixel shift value";
            sw = rw;
            hw = r;
            reset = 0x0;
        } bitmove[7:0];
    } ISP_MG_BITMOVE @ 0x12540;

    reg {
        name = "R component black level offset register";
        desc = "ISP_MG_OFFSET_R is an R component black level offset register. Hi3516C V300/Hi3516E V100 Professional HD IP Camera SoC

Data sheet 10.6 ISP_MG_OFFSET_R (offset 0x22544, printed page 10-145, `hi3516cv300--Hi3516CV300-Hi3516EV100-Datasheet.txt` line 48631).";

        field {
            name = "offset_r";
            desc = "Black level offset";
            sw = rw;
            hw = r;
            reset = 0x0;
        } offset_r[14:0];
    } ISP_MG_OFFSET_R @ 0x12544;

    reg {
        name = "Gr component black level offset register";
        desc = "ISP_MG_OFFSET_GR is a Gr component black level offset register.

Data sheet 10.6 ISP_MG_OFFSET_GR (offset 0x22548, printed page 10-145, `hi3516cv300--Hi3516CV300-Hi3516EV100-Datasheet.txt` line 48651).";

        field {
            name = "offset_gr";
            desc = "Black level offset";
            sw = rw;
            hw = r;
            reset = 0x0;
        } offset_gr[14:0];
    } ISP_MG_OFFSET_GR @ 0x12548;

    reg {
        name = "Gb component black level offset register";
        desc = "ISP_MG_OFFSET_GB is a Gb component black level offset register.

Data sheet 10.6 ISP_MG_OFFSET_GB (offset 0x2254C, printed page 10-145, `hi3516cv300--Hi3516CV300-Hi3516EV100-Datasheet.txt` line 48670).";

        field {
            name = "offset_gb";
            desc = "Black level offset";
            sw = rw;
            hw = r;
            reset = 0x0;
        } offset_gb[14:0];
    } ISP_MG_OFFSET_GB @ 0x1254C;

    reg {
        name = "B component black level offset register";
        desc = "ISP_MG_OFFSET_B is a B component black level offset register.

Data sheet 10.6 ISP_MG_OFFSET_B (offset 0x22550, printed page 10-146, `hi3516cv300--Hi3516CV300-Hi3516EV100-Datasheet.txt` line 48696).";

        field {
            name = "offset_b";
            desc = "Black level offset";
            sw = rw;
            hw = r;
            reset = 0x0;
        } offset_b[14:0];
    } ISP_MG_OFFSET_B @ 0x12550;

    reg {
        name = "MG_gamma module shift control T register";
        desc = "ISP_MG_GAMMA_LIMIT is an MG_gamma module shift control register.

Data sheet 10.6 ISP_MG_GAMMA_LIMIT (offset 0x22560, printed page 10-146, `hi3516cv300--Hi3516CV300-Hi3516EV100-Datasheet.txt` line 48716).";

        field {
            name = "gamma_limit";
            desc = "Gamma module shift control The value can be 1000, 1001, 1010, 1011, or 1100.";
            sw = rw;
            hw = r;
            reset = 0x0;
        } gamma_limit[3:0];
    } ISP_MG_GAMMA_LIMIT @ 0x12560;

    reg {
        name = "ISP MG MEM AVER WADDR";
        desc = "[inferred] ISP MG MEM AVER WADDR. Not in the data sheet. Source: OpenIPC openhisilicon `kernel/isp/arch/hi3516cv300/firmware/vreg/arch/hi3516cv300/isp_reg_define.h` (GPL-3.0 repository, HiSilicon copyright, nManager-generated 2015-12-22 \"Define all registers/tables for Hi3519\"; local copy sources/openhisilicon), union `U_ISP_MG_MEM_AVER_WADDR`, struct offset 0x12590 (GPL-3.0 repository; header offsets are ISP-core relative (data sheet offset - 0x20000), 632 of 775 data-sheet registers match it by name and offset (ISP_BLC_CFG is at 0x21100 in the data sheet and 0x1000+0x20000 in the header)). Reset value and access type unknown (modelled RW, no reset). Confidence: medium (vendor header for this chip family, not hardware verified).";

        field {
            name = "aver_waddr";
            desc = "[inferred] Aver waddr. (vendor header `isp_reg_define.h` field `aver_waddr`; access and reset unknown, modelled RW)";
            sw = rw;
            hw = r;
        } aver_waddr[31:0];
    } ISP_MG_MEM_AVER_WADDR @ 0x12590;

    reg {
        name = "ISP MG MEM AVER WDATA";
        desc = "[inferred] ISP MG MEM AVER WDATA. Not in the data sheet. Source: OpenIPC openhisilicon `kernel/isp/arch/hi3516cv300/firmware/vreg/arch/hi3516cv300/isp_reg_define.h` (GPL-3.0 repository, HiSilicon copyright, nManager-generated 2015-12-22 \"Define all registers/tables for Hi3519\"; local copy sources/openhisilicon), union `U_ISP_MG_MEM_AVER_WDATA`, struct offset 0x12594 (GPL-3.0 repository; header offsets are ISP-core relative (data sheet offset - 0x20000), 632 of 775 data-sheet registers match it by name and offset (ISP_BLC_CFG is at 0x21100 in the data sheet and 0x1000+0x20000 in the header)). Reset value and access type unknown (modelled RW, no reset). Confidence: medium (vendor header for this chip family, not hardware verified).";

        field {
            name = "aver_wdata";
            desc = "[inferred] Aver wdata. (vendor header `isp_reg_define.h` field `aver_wdata`; access and reset unknown, modelled RW)";
            sw = rw;
            hw = r;
        } aver_wdata[31:0];
    } ISP_MG_MEM_AVER_WDATA @ 0x12594;

    reg {
        name = "MG module R/Gr/Gb/B average ADDR value statistics read address register";
        desc = "ISP_MG_MEM_AVER_RADDR is an MG module R/Gr/Gb/B average value statistics read address register. Hi3516C V300/Hi3516E V100 Professional HD IP Camera SoC

Data sheet 10.6 ISP_MG_MEM_AVER_RADDR (offset 0x22598, printed page 10-147, `hi3516cv300--Hi3516CV300-Hi3516EV100-Datasheet.txt` line 48747).";

        field {
            name = "aver_raddr";
            desc = "Read address of the R/Gr/Gb/B average value statistics";
            sw = rw;
            hw = r;
            reset = 0x0;
        } aver_raddr[31:0];
    } ISP_MG_MEM_AVER_RADDR @ 0x12598;

    reg {
        name = "MG module R/Gr/Gb/B average DATA value statistics read data register";
        desc = "ISP_MG_MEM_AVER_RDATA is an MG module R/Gr/Gb/B average value statistics read data register.

Data sheet 10.6 ISP_MG_MEM_AVER_RDATA (offset 0x2259C, printed page 10-147, `hi3516cv300--Hi3516CV300-Hi3516EV100-Datasheet.txt` line 48767).";

        field {
            name = "aver_rdata";
            desc = "Read data of the R/Gr/Gb/B average value statistics";
            sw = r;
            hw = w;
            reset = 0x0;
        } aver_rdata[31:0];
    } ISP_MG_MEM_AVER_RDATA @ 0x1259C;

    reg {
        name = "ISP MG control F";
        desc = "[inferred] ISP MG control F. Not in the data sheet. Source: OpenIPC openhisilicon `kernel/isp/arch/hi3516cv300/firmware/vreg/arch/hi3516cv300/isp_reg_define.h` (GPL-3.0 repository, HiSilicon copyright, nManager-generated 2015-12-22 \"Define all registers/tables for Hi3519\"; local copy sources/openhisilicon), union `U_ISP_MG_CTRL_F`, struct offset 0x125E0 (GPL-3.0 repository; header offsets are ISP-core relative (data sheet offset - 0x20000), 632 of 775 data-sheet registers match it by name and offset (ISP_BLC_CFG is at 0x21100 in the data sheet and 0x1000+0x20000 in the header)). Reset value and access type unknown (modelled RW, no reset). Confidence: medium (vendor header for this chip family, not hardware verified).";

        field {
            name = "rggb_cfg";
            desc = "[inferred] Rggb configuration. (vendor header `isp_reg_define.h` field `rggb_cfg`; access and reset unknown, modelled RW)";
            sw = rw;
            hw = r;
        } rggb_cfg[1:0];
    } ISP_MG_CTRL_F @ 0x125E0;

    reg {
        name = "ISP MG control I";
        desc = "[inferred] ISP MG control I. Not in the data sheet. Source: OpenIPC openhisilicon `kernel/isp/arch/hi3516cv300/firmware/vreg/arch/hi3516cv300/isp_reg_define.h` (GPL-3.0 repository, HiSilicon copyright, nManager-generated 2015-12-22 \"Define all registers/tables for Hi3519\"; local copy sources/openhisilicon), union `U_ISP_MG_CTRL_I`, struct offset 0x125E4 (GPL-3.0 repository; header offsets are ISP-core relative (data sheet offset - 0x20000), 632 of 775 data-sheet registers match it by name and offset (ISP_BLC_CFG is at 0x21100 in the data sheet and 0x1000+0x20000 in the header)). Reset value and access type unknown (modelled RW, no reset). Confidence: medium (vendor header for this chip family, not hardware verified).";

        field {
            name = "update_mode";
            desc = "[inferred] Update mode. (vendor header `isp_reg_define.h` field `update_mode`; access and reset unknown, modelled RW)";
            sw = rw;
            hw = r;
        } update_mode[0:0];
    } ISP_MG_CTRL_I @ 0x125E4;

    reg {
        name = "ISP MG UPDATE";
        desc = "[inferred] ISP MG UPDATE. Not in the data sheet. Source: OpenIPC openhisilicon `kernel/isp/arch/hi3516cv300/firmware/vreg/arch/hi3516cv300/isp_reg_define.h` (GPL-3.0 repository, HiSilicon copyright, nManager-generated 2015-12-22 \"Define all registers/tables for Hi3519\"; local copy sources/openhisilicon), union `U_ISP_MG_UPDATE`, struct offset 0x125EC (GPL-3.0 repository; header offsets are ISP-core relative (data sheet offset - 0x20000), 632 of 775 data-sheet registers match it by name and offset (ISP_BLC_CFG is at 0x21100 in the data sheet and 0x1000+0x20000 in the header)). Reset value and access type unknown (modelled RW, no reset). Confidence: medium (vendor header for this chip family, not hardware verified).";

        field {
            name = "update";
            desc = "[inferred] Update. (vendor header `isp_reg_define.h` field `update`; access and reset unknown, modelled RW)";
            sw = rw;
            hw = r;
        } update[0:0];
    } ISP_MG_UPDATE @ 0x125EC;

    reg {
        name = "MG picture size register";
        desc = "ISP_MG_SIZE is an MG picture size register.

Data sheet 10.6 ISP_MG_SIZE (offset 0x225F0, printed page 10-147, `hi3516cv300--Hi3516CV300-Hi3516EV100-Datasheet.txt` line 48786).";

        field {
            name = "vsize";
            desc = "Picture height";
            sw = rw;
            hw = r;
            reset = 0x437;
        } vsize[28:16];

        field {
            name = "hsize";
            desc = "Picture width";
            sw = rw;
            hw = r;
            reset = 0x77F;
        } hsize[12:0];
    } ISP_MG_SIZE @ 0x125F0;

    reg {
        name = "LSC enable register";
        desc = "ISP_LSC_CFG is an LSC enable register.

Data sheet 10.6 ISP_LSC_CFG (offset 0x23000, printed page 10-148, `hi3516cv300--Hi3516CV300-Hi3516EV100-Datasheet.txt` line 48821).";

        enum ISP_LSC_CFG_en_enum {
            DISABLED = 0 { name = "Disabled"; desc = "disabled"; };
            ENABLED = 1 { name = "Enabled"; desc = "enabled"; };
        };

        field {
            name = "en";
            desc = "LSC enable";
            sw = rw;
            hw = r;
            encode = ISP_LSC_CFG_en_enum;
            reset = 0x0;
        } en[0:0];
    } ISP_LSC_CFG @ 0x13000;

    reg {
        name = "LSC picture segmentation window quantity configuration register";
        desc = "ISP_LSC_WINNUM is an LSC picture segmentation window quantity configuration register.

Data sheet 10.6 ISP_LSC_WINNUM (offset 0x23010, printed page 10-148, `hi3516cv300--Hi3516CV300-Hi3516EV100-Datasheet.txt` line 48843).";

        field {
            name = "numv";
            desc = "Number of windows in the vertical direction after the LSC picture is segmented. The configured value is the actual value minus 1.";
            sw = rw;
            hw = r;
            reset = 0xF;
        } numv[20:16];

        field {
            name = "numh";
            desc = "Number of windows in the horizontal direction after the LSC picture is segmented. The configured value is the actual value minus 1.";
            sw = rw;
            hw = r;
            reset = 0xF;
        } numh[4:0];
    } ISP_LSC_WINNUM @ 0x13010;

    reg {
        name = "LSC interpolation horizontal first window width information register";
        desc = "ISP_LSC_WINX1 is an LSC interpolation horizontal first window width information register.

Data sheet 10.6 ISP_LSC_WINX1 (offset 0x23014, printed page 10-149, `hi3516cv300--Hi3516CV300-Hi3516EV100-Datasheet.txt` line 48875).";

        field {
            name = "invx1";
            desc = "Reciprocal value of the width of the LSC interpolation horizontal first window";
            sw = rw;
            hw = r;
            reset = 0x125;
        } invx1[27:16];

        field {
            name = "deltax1";
            desc = "Width of the LSC interpolation horizontal first window. The configured value is the actual value minus 1.";
            sw = rw;
            hw = r;
            reset = 0x1B;
        } deltax1[9:0];
    } ISP_LSC_WINX1 @ 0x13014;

    reg {
        name = "LSC interpolation horizontal second window width information register";
        desc = "ISP_LSC_WINX2 is an LSC interpolation horizontal second window width information register.

Data sheet 10.6 ISP_LSC_WINX2 (offset 0x23018, printed page 10-149, `hi3516cv300--Hi3516CV300-Hi3516EV100-Datasheet.txt` line 48902).";

        field {
            name = "invx2";
            desc = "Reciprocal value of the width of the LSC interpolation horizontal second window";
            sw = rw;
            hw = r;
            reset = 0xCD;
        } invx2[27:16];

        field {
            name = "deltax2";
            desc = "Width of the LSC interpolation horizontal second window";
            sw = rw;
            hw = r;
            reset = 0x27;
        } deltax2[9:0];
    } ISP_LSC_WINX2 @ 0x13018;

    reg {
        name = "LSC interpolation horizontal third window width information register";
        desc = "ISP_LSC_WINX3 is an LSC interpolation horizontal third window width information register. Hi3516C V300/Hi3516E V100 Professional HD IP Camera SoC

Data sheet 10.6 ISP_LSC_WINX3 (offset 0x2301C, printed page 10-150, `hi3516cv300--Hi3516CV300-Hi3516EV100-Datasheet.txt` line 48935).";

        field {
            name = "invx3";
            desc = "Reciprocal value of the width of the LSC interpolation horizontal third window";
            sw = rw;
            hw = r;
            reset = 0x98;
        } invx3[27:16];

        field {
            name = "deltax3";
            desc = "Width of the LSC interpolation horizontal third window";
            sw = rw;
            hw = r;
            reset = 0x35;
        } deltax3[9:0];
    } ISP_LSC_WINX3 @ 0x1301C;

    reg {
        name = "LSC interpolation horizontal fourth window width information register";
        desc = "ISP_LSC_WINX4 is an LSC interpolation horizontal fourth window width information register.

Data sheet 10.6 ISP_LSC_WINX4 (offset 0x23020, printed page 10-150, `hi3516cv300--Hi3516CV300-Hi3516EV100-Datasheet.txt` line 48960).";

        field {
            name = "invx4";
            desc = "Reciprocal value of the width of the LSC interpolation horizontal fourth window";
            sw = rw;
            hw = r;
            reset = 0x6C;
        } invx4[27:16];

        field {
            name = "deltax4";
            desc = "Width of the LSC interpolation horizontal fourth window";
            sw = rw;
            hw = r;
            reset = 0x4B;
        } deltax4[9:0];
    } ISP_LSC_WINX4 @ 0x13020;

    reg {
        name = "LSC interpolation horizontal fifth window width information register";
        desc = "ISP_LSC_WINX5 is an LSC interpolation horizontal fifth window width information register. Hi3516C V300/Hi3516E V100 Professional HD IP Camera SoC

Data sheet 10.6 ISP_LSC_WINX5 (offset 0x23024, printed page 10-151, `hi3516cv300--Hi3516CV300-Hi3516EV100-Datasheet.txt` line 48993).";

        field {
            name = "invx5";
            desc = "Reciprocal value of the width of the LSC interpolation horizontal fifth window";
            sw = rw;
            hw = r;
            reset = 0x4C;
        } invx5[27:16];

        field {
            name = "deltax5";
            desc = "Width of the LSC interpolation horizontal fifth window";
            sw = rw;
            hw = r;
            reset = 0x6B;
        } deltax5[9:0];
    } ISP_LSC_WINX5 @ 0x13024;

    reg {
        name = "LSC interpolation horizontal sixth window width information register";
        desc = "ISP_LSC_WINX6 is an LSC interpolation horizontal sixth window width information register.

Data sheet 10.6 ISP_LSC_WINX6 (offset 0x23028, printed page 10-151, `hi3516cv300--Hi3516CV300-Hi3516EV100-Datasheet.txt` line 49017).";

        field {
            name = "invx6";
            desc = "Reciprocal value of the width of the LSC interpolation horizontal sixth window";
            sw = rw;
            hw = r;
            reset = 0x37;
        } invx6[27:16];

        field {
            name = "deltax6";
            desc = "Width of the LSC interpolation horizontal sixth window";
            sw = rw;
            hw = r;
            reset = 0x95;
        } deltax6[9:0];
    } ISP_LSC_WINX6 @ 0x13028;

    reg {
        name = "LSC interpolation horizontal seventh window width information register";
        desc = "ISP_LSC_WINX7 is an LSC interpolation horizontal seventh window width information register. Hi3516C V300/Hi3516E V100 Professional HD IP Camera SoC

Data sheet 10.6 ISP_LSC_WINX7 (offset 0x2302C, printed page 10-152, `hi3516cv300--Hi3516CV300-Hi3516EV100-Datasheet.txt` line 49050).";

        field {
            name = "invx7";
            desc = "Reciprocal value of the width of the LSC interpolation horizontal seventh window";
            sw = rw;
            hw = r;
            reset = 0x27;
        } invx7[27:16];

        field {
            name = "deltax7";
            desc = "Width of the LSC interpolation horizontal seventh window";
            sw = rw;
            hw = r;
            reset = 0xD1;
        } deltax7[9:0];
    } ISP_LSC_WINX7 @ 0x1302C;

    reg {
        name = "LSC interpolation horizontal eighth window width information register";
        desc = "ISP_LSC_WINX8 is an LSC interpolation horizontal eighth window width information register.

Data sheet 10.6 ISP_LSC_WINX8 (offset 0x23030, printed page 10-152, `hi3516cv300--Hi3516CV300-Hi3516EV100-Datasheet.txt` line 49075).";

        field {
            name = "invx8";
            desc = "Reciprocal value of the width of the LSC interpolation horizontal eighth window";
            sw = rw;
            hw = r;
            reset = 0x1C;
        } invx8[27:16];

        field {
            name = "deltax8";
            desc = "Width of the LSC interpolation horizontal eighth window";
            sw = rw;
            hw = r;
            reset = 0x125;
        } deltax8[9:0];
    } ISP_LSC_WINX8 @ 0x13030;

    reg {
        name = "LSC interpolation vertical first window width information register";
        desc = "ISP_LSC_WINY1 is an LSC interpolation vertical first window width information register. Hi3516C V300/Hi3516E V100 Professional HD IP Camera SoC

Data sheet 10.6 ISP_LSC_WINY1 (offset 0x23034, printed page 10-153, `hi3516cv300--Hi3516CV300-Hi3516EV100-Datasheet.txt` line 49108).";

        field {
            name = "invy1";
            desc = "Reciprocal value of the width of the LSC interpolation vertical first window";
            sw = rw;
            hw = r;
            reset = 0x200;
        } invy1[27:16];

        field {
            name = "deltay1";
            desc = "Width of the LSC interpolation vertical first window";
            sw = rw;
            hw = r;
            reset = 0xF;
        } deltay1[9:0];
    } ISP_LSC_WINY1 @ 0x13034;

    reg {
        name = "LSC interpolation vertical second window width information register";
        desc = "ISP_LSC_WINY2 is an LSC interpolation vertical second window width information register.

Data sheet 10.6 ISP_LSC_WINY2 (offset 0x23038, printed page 10-153, `hi3516cv300--Hi3516CV300-Hi3516EV100-Datasheet.txt` line 49132).";

        field {
            name = "invy2";
            desc = "Reciprocal value of the width of the LSC interpolation vertical second window";
            sw = rw;
            hw = r;
            reset = 0x174;
        } invy2[27:16];

        field {
            name = "deltay2";
            desc = "Width of the LSC interpolation vertical second window";
            sw = rw;
            hw = r;
            reset = 0x15;
        } deltay2[9:0];
    } ISP_LSC_WINY2 @ 0x13038;

    reg {
        name = "LSC interpolation vertical third window width information register";
        desc = "ISP_LSC_WINY3 is an LSC interpolation vertical third window width information register. Hi3516C V300/Hi3516E V100 Professional HD IP Camera SoC

Data sheet 10.6 ISP_LSC_WINY3 (offset 0x2303C, printed page 10-154, `hi3516cv300--Hi3516CV300-Hi3516EV100-Datasheet.txt` line 49164).";

        field {
            name = "invy3";
            desc = "Reciprocal value of the width of the LSC interpolation vertical third window";
            sw = rw;
            hw = r;
            reset = 0x111;
        } invy3[27:16];

        field {
            name = "deltay3";
            desc = "Width of the LSC interpolation vertical third window";
            sw = rw;
            hw = r;
            reset = 0x1D;
        } deltay3[9:0];
    } ISP_LSC_WINY3 @ 0x1303C;

    reg {
        name = "LSC interpolation vertical fourth window width information register";
        desc = "ISP_LSC_WINY4 is an LSC interpolation vertical fourth window width information register.

Data sheet 10.6 ISP_LSC_WINY4 (offset 0x23040, printed page 10-154, `hi3516cv300--Hi3516CV300-Hi3516EV100-Datasheet.txt` line 49188).";

        field {
            name = "invy4";
            desc = "Reciprocal value of the width of the LSC interpolation vertical fourth window";
            sw = rw;
            hw = r;
            reset = 0xBA;
        } invy4[27:16];

        field {
            name = "deltay4";
            desc = "Width of the LSC interpolation vertical fourth window";
            sw = rw;
            hw = r;
            reset = 0x2B;
        } deltay4[9:0];
    } ISP_LSC_WINY4 @ 0x13040;

    reg {
        name = "LSC interpolation vertical fifth window width information register";
        desc = "ISP_LSC_WINY5 is an LSC interpolation vertical fifth window width information register. Hi3516C V300/Hi3516E V100 Professional HD IP Camera SoC

Data sheet 10.6 ISP_LSC_WINY5 (offset 0x23044, printed page 10-155, `hi3516cv300--Hi3516CV300-Hi3516EV100-Datasheet.txt` line 49220).";

        field {
            name = "invy5";
            desc = "Reciprocal value of the width of the LSC interpolation vertical fifth window";
            sw = rw;
            hw = r;
            reset = 0x89;
        } invy5[27:16];

        field {
            name = "deltay5";
            desc = "Width of the LSC interpolation vertical fifth window";
            sw = rw;
            hw = r;
            reset = 0x3B;
        } deltay5[9:0];
    } ISP_LSC_WINY5 @ 0x13044;

    reg {
        name = "LSC interpolation vertical sixth window width information register";
        desc = "ISP_LSC_WINY6 is an LSC interpolation vertical sixth window width information register.

Data sheet 10.6 ISP_LSC_WINY6 (offset 0x23048, printed page 10-155, `hi3516cv300--Hi3516CV300-Hi3516EV100-Datasheet.txt` line 49244).";

        field {
            name = "invy6";
            desc = "Reciprocal value of the width of the LSC interpolation vertical sixth window";
            sw = rw;
            hw = r;
            reset = 0x62;
        } invy6[27:16];

        field {
            name = "deltay6";
            desc = "Width of the LSC interpolation vertical sixth window";
            sw = rw;
            hw = r;
            reset = 0x53;
        } deltay6[9:0];
    } ISP_LSC_WINY6 @ 0x13048;

    reg {
        name = "LSC interpolation vertical seventh window width information register";
        desc = "ISP_LSC_WINY7 is an LSC interpolation vertical seventh window width information register. Hi3516C V300/Hi3516E V100 Professional HD IP Camera SoC

Data sheet 10.6 ISP_LSC_WINY7 (offset 0x2304C, printed page 10-156, `hi3516cv300--Hi3516CV300-Hi3516EV100-Datasheet.txt` line 49276).";

        field {
            name = "invy7";
            desc = "Reciprocal value of the width of the LSC interpolation vertical seventh window";
            sw = rw;
            hw = r;
            reset = 0x45;
        } invy7[27:16];

        field {
            name = "deltay7";
            desc = "Width of the LSC interpolation vertical seventh window";
            sw = rw;
            hw = r;
            reset = 0x75;
        } deltay7[9:0];
    } ISP_LSC_WINY7 @ 0x1304C;

    reg {
        name = "LSC interpolation vertical eighth window width information register";
        desc = "ISP_LSC_WINY8 is an LSC interpolation vertical eighth window width information register.

Data sheet 10.6 ISP_LSC_WINY8 (offset 0x23050, printed page 10-156, `hi3516cv300--Hi3516CV300-Hi3516EV100-Datasheet.txt` line 49300).";

        field {
            name = "invy8";
            desc = "Reciprocal value of the width of the LSC interpolation vertical eighth window";
            sw = rw;
            hw = r;
            reset = 0x31;
        } invy8[27:16];

        field {
            name = "deltay8";
            desc = "Width of the LSC interpolation vertical eighth window";
            sw = rw;
            hw = r;
            reset = 0xA5;
        } deltay8[9:0];
    } ISP_LSC_WINY8 @ 0x13050;

    reg {
        name = "LSC input and output black level offset enable register";
        desc = "ISP_LSC_BLCEN is an LSC input and output black level offset enable register. Hi3516C V300/Hi3516E V100 Professional HD IP Camera SoC

Data sheet 10.6 ISP_LSC_BLCEN (offset 0x23054, printed page 10-157, `hi3516cv300--Hi3516CV300-Hi3516EV100-Datasheet.txt` line 49332).";

        enum ISP_LSC_BLCEN_BLC_out_en_enum {
            DISABLED = 0 { name = "Disabled"; desc = "disabled"; };
            ENABLED = 1 { name = "Enabled"; desc = "enabled"; };
        };

        field {
            name = "BLC_out_en";
            desc = "Output black level enable";
            sw = rw;
            hw = r;
            encode = ISP_LSC_BLCEN_BLC_out_en_enum;
            reset = 0x0;
        } BLC_out_en[8:8];

        enum ISP_LSC_BLCEN_BLC_in_en_enum {
            DISABLED = 0 { name = "Disabled"; desc = "disabled"; };
            ENABLED = 1 { name = "Enabled"; desc = "enabled"; };
        };

        field {
            name = "BLC_in_en";
            desc = "Input black level enable";
            sw = rw;
            hw = r;
            encode = ISP_LSC_BLCEN_BLC_in_en_enum;
            reset = 0x0;
        } BLC_in_en[0:0];
    } ISP_LSC_BLCEN @ 0x13054;

    reg {
        name = "LSC R channel black level offset register";
        desc = "ISP_LSC_RBLC is an LSC R channel black level offset register.

Data sheet 10.6 ISP_LSC_RBLC (offset 0x23058, printed page 10-157, `hi3516cv300--Hi3516CV300-Hi3516EV100-Datasheet.txt` line 49364).";

        field {
            name = "BLC_r";
            desc = "Black level data in the R channel";
            sw = rw;
            hw = r;
            reset = 0x0;
        } BLC_r[14:0];
    } ISP_LSC_RBLC @ 0x13058;

    reg {
        name = "LSC Gr channel black level offset register";
        desc = "ISP_LSC_GRBLC is an LSC Gr channel black level offset register. Hi3516C V300/Hi3516E V100 Professional HD IP Camera SoC

Data sheet 10.6 ISP_LSC_GRBLC (offset 0x2305C, printed page 10-158, `hi3516cv300--Hi3516CV300-Hi3516EV100-Datasheet.txt` line 49393).";

        field {
            name = "BLC_gr";
            desc = "Black level data in the Gr channel";
            sw = rw;
            hw = r;
            reset = 0x0;
        } BLC_gr[14:0];
    } ISP_LSC_GRBLC @ 0x1305C;

    reg {
        name = "LSC Gb channel black level offset register";
        desc = "ISP_LSC_GBBLC is an LSC Gb channel black level offset register.

Data sheet 10.6 ISP_LSC_GBBLC (offset 0x23060, printed page 10-158, `hi3516cv300--Hi3516CV300-Hi3516EV100-Datasheet.txt` line 49413).";

        field {
            name = "BLC_gb";
            desc = "Black level data in the Gb channel";
            sw = rw;
            hw = r;
            reset = 0x0;
        } BLC_gb[14:0];
    } ISP_LSC_GBBLC @ 0x13060;

    reg {
        name = "LSC B channel black level offset register";
        desc = "ISP_LSC_BBLC is an LSC B channel black level offset register.

Data sheet 10.6 ISP_LSC_BBLC (offset 0x23064, printed page 10-158, `hi3516cv300--Hi3516CV300-Hi3516EV100-Datasheet.txt` line 49432).";

        field {
            name = "BLC_b";
            desc = "Black level data in the B channel";
            sw = rw;
            hw = r;
            reset = 0x0;
        } BLC_b[14:0];
    } ISP_LSC_BBLC @ 0x13064;

    reg {
        name = "LSC gain LUT switch enable register";
        desc = "ISP_LSC_LUT_UPDATE is an LSC gain LUT switch enable register.

Data sheet 10.6 ISP_LSC_LUT_UPDATE (offset 0x23068, printed page 10-159, `hi3516cv300--Hi3516CV300-Hi3516EV100-Datasheet.txt` line 49458).";

        enum ISP_LSC_LUT_UPDATE_lut_update_enum {
            DISABLED = 0 { name = "Disabled"; desc = "disabled"; };
            ENABLED = 1 { name = "Enabled"; desc = "enabled"; };
        };

        field {
            name = "lut_update";
            desc = "LSC LUT switch enable. This bit is automatically cleared for each frame.";
            sw = rw;
            hw = r;
            encode = ISP_LSC_LUT_UPDATE_lut_update_enum;
            reset = 0x0;
        } lut_update[0:0];
    } ISP_LSC_LUT_UPDATE @ 0x13068;

    reg {
        name = "LSC interpolation R/Gr channel gain DDR information write address register";
        desc = "ISP_LSC_GRRGAIN_WADDR is an LSC interpolation R/Gr channel gain write address register.

Data sheet 10.6 ISP_LSC_GRRGAIN_WADDR (offset 0x23080, printed page 10-159, `hi3516cv300--Hi3516CV300-Hi3516EV100-Datasheet.txt` line 49489).";

        field {
            name = "grrgain_waddr";
            desc = "Write address of the LSC interpolation R/Gr channel gain";
            sw = rw;
            hw = r;
            reset = 0x0;
        } grrgain_waddr[31:0];
    } ISP_LSC_GRRGAIN_WADDR @ 0x13080;

    reg {
        name = "LSC interpolation R/Gr channel gain ATA information write data register";
        desc = "ISP_LSC_GRRGAIN_WDATA is an LSC interpolation R/Gr channel gain write data register. Hi3516C V300/Hi3516E V100 Professional HD IP Camera SoC

Data sheet 10.6 ISP_LSC_GRRGAIN_WDATA (offset 0x23084, printed page 10-160, `hi3516cv300--Hi3516CV300-Hi3516EV100-Datasheet.txt` line 49517).";

        field {
            name = "grrgain_wdata";
            desc = "Write data of the LSC interpolation R/Gr channel gain";
            sw = rw;
            hw = r;
            reset = 0x0;
        } grrgain_wdata[25:0];
    } ISP_LSC_GRRGAIN_WDATA @ 0x13084;

    reg {
        name = "LSC interpolation R/Gr channel gain DDR information read address register";
        desc = "ISP_LSC_GRRGAIN_RADDR is an LSC interpolation R/Gr channel gain read address register.

Data sheet 10.6 ISP_LSC_GRRGAIN_RADDR (offset 0x23088, printed page 10-160, `hi3516cv300--Hi3516CV300-Hi3516EV100-Datasheet.txt` line 49538).";

        field {
            name = "grrgain_raddr";
            desc = "Read address of the LSC interpolation R/Gr channel gain";
            sw = rw;
            hw = r;
            reset = 0x0;
        } grrgain_raddr[31:0];
    } ISP_LSC_GRRGAIN_RADDR @ 0x13088;

    reg {
        name = "LSC interpolation R/Gr channel gain ATA information read data register";
        desc = "ISP_LSC_GRRGAIN_RDATA is an LSC interpolation R/Gr channel gain read data register.

Data sheet 10.6 ISP_LSC_GRRGAIN_RDATA (offset 0x2308C, printed page 10-160, `hi3516cv300--Hi3516CV300-Hi3516EV100-Datasheet.txt` line 49556).";

        field {
            name = "grgain_rdata";
            desc = "Read data of the LSC interpolation R/Gr channel gain";
            sw = r;
            hw = w;
            reset = 0x0;
        } grgain_rdata[25:0];
    } ISP_LSC_GRRGAIN_RDATA @ 0x1308C;

    reg {
        name = "LSC interpolation B/Gb channel gain DDR write address register.";
        desc = "ISP_LSC_GBBGAIN_WADDR is an LSC interpolation B/Gb channel gain write address register.

Data sheet 10.6 ISP_LSC_GBBGAIN_WADDR (offset 0x23090, printed page 10-161, `hi3516cv300--Hi3516CV300-Hi3516EV100-Datasheet.txt` line 49583).";

        field {
            name = "gbbgain_waddr";
            desc = "Write address of the LSC interpolation B/Gb channel gain";
            sw = rw;
            hw = r;
            reset = 0x0;
        } gbbgain_waddr[31:0];
    } ISP_LSC_GBBGAIN_WADDR @ 0x13090;

    reg {
        name = "LSC interpolation B/Gb channel gain ATA write data register.";
        desc = "ISP_LSC_GBBGAIN_WDATA is an LSC interpolation B/Gb channel gain write data register.

Data sheet 10.6 ISP_LSC_GBBGAIN_WDATA (offset 0x23094, printed page 10-161, `hi3516cv300--Hi3516CV300-Hi3516EV100-Datasheet.txt` line 49601).";

        field {
            name = "gbbgain_wdata";
            desc = "Write data of the LSC interpolation B/Gb channel gain";
            sw = rw;
            hw = r;
            reset = 0x0;
        } gbbgain_wdata[25:0];
    } ISP_LSC_GBBGAIN_WDATA @ 0x13094;

    reg {
        name = "LSC interpolation B/Gb channel gain DDR read address register.";
        desc = "ISP_LSC_GBBGAIN_RADDR is an LSC interpolation B/Gb channel gain read address register.

Data sheet 10.6 ISP_LSC_GBBGAIN_RADDR (offset 0x23098, printed page 10-161, `hi3516cv300--Hi3516CV300-Hi3516EV100-Datasheet.txt` line 49622).";

        field {
            name = "gbbgain_raddr";
            desc = "Read address of the LSC interpolation B/Gb channel gain";
            sw = rw;
            hw = r;
            reset = 0x0;
        } gbbgain_raddr[31:0];
    } ISP_LSC_GBBGAIN_RADDR @ 0x13098;

    reg {
        name = "LSC interpolation B/Gb channel gain ATA read data register.";
        desc = "ISP_LSC_GBBGAIN_RDATA is an LSC interpolation B/Gb channel gain read data register.

Data sheet 10.6 ISP_LSC_GBBGAIN_RDATA (offset 0x2309C, printed page 10-162, `hi3516cv300--Hi3516CV300-Hi3516EV100-Datasheet.txt` line 49647).";

        field {
            name = "gbbgain_rdata";
            desc = "Read data of the LSC interpolation B/Gb channel gain";
            sw = r;
            hw = w;
            reset = 0x0;
        } gbbgain_rdata[25:0];
    } ISP_LSC_GBBGAIN_RDATA @ 0x1309C;

    reg {
        name = "ISP lens shading correction control F";
        desc = "[inferred] ISP lens shading correction control F. Not in the data sheet. Source: OpenIPC openhisilicon `kernel/isp/arch/hi3516cv300/firmware/vreg/arch/hi3516cv300/isp_reg_define.h` (GPL-3.0 repository, HiSilicon copyright, nManager-generated 2015-12-22 \"Define all registers/tables for Hi3519\"; local copy sources/openhisilicon), union `U_ISP_LSC_CTRL_F`, struct offset 0x130E0 (GPL-3.0 repository; header offsets are ISP-core relative (data sheet offset - 0x20000), 632 of 775 data-sheet registers match it by name and offset (ISP_BLC_CFG is at 0x21100 in the data sheet and 0x1000+0x20000 in the header)). Reset value and access type unknown (modelled RW, no reset). Confidence: medium (vendor header for this chip family, not hardware verified).";

        field {
            name = "rggb_cfg";
            desc = "[inferred] Rggb configuration. (vendor header `isp_reg_define.h` field `rggb_cfg`; access and reset unknown, modelled RW)";
            sw = rw;
            hw = r;
        } rggb_cfg[1:0];
    } ISP_LSC_CTRL_F @ 0x130E0;

    reg {
        name = "ISP lens shading correction control I";
        desc = "[inferred] ISP lens shading correction control I. Not in the data sheet. Source: OpenIPC openhisilicon `kernel/isp/arch/hi3516cv300/firmware/vreg/arch/hi3516cv300/isp_reg_define.h` (GPL-3.0 repository, HiSilicon copyright, nManager-generated 2015-12-22 \"Define all registers/tables for Hi3519\"; local copy sources/openhisilicon), union `U_ISP_LSC_CTRL_I`, struct offset 0x130E4 (GPL-3.0 repository; header offsets are ISP-core relative (data sheet offset - 0x20000), 632 of 775 data-sheet registers match it by name and offset (ISP_BLC_CFG is at 0x21100 in the data sheet and 0x1000+0x20000 in the header)). Reset value and access type unknown (modelled RW, no reset). Confidence: medium (vendor header for this chip family, not hardware verified).";

        field {
            name = "update_mode";
            desc = "[inferred] Update mode. (vendor header `isp_reg_define.h` field `update_mode`; access and reset unknown, modelled RW)";
            sw = rw;
            hw = r;
        } update_mode[0:0];
    } ISP_LSC_CTRL_I @ 0x130E4;

    reg {
        name = "ISP lens shading correction UPDATE";
        desc = "[inferred] ISP lens shading correction UPDATE. Not in the data sheet. Source: OpenIPC openhisilicon `kernel/isp/arch/hi3516cv300/firmware/vreg/arch/hi3516cv300/isp_reg_define.h` (GPL-3.0 repository, HiSilicon copyright, nManager-generated 2015-12-22 \"Define all registers/tables for Hi3519\"; local copy sources/openhisilicon), union `U_ISP_LSC_UPDATE`, struct offset 0x130EC (GPL-3.0 repository; header offsets are ISP-core relative (data sheet offset - 0x20000), 632 of 775 data-sheet registers match it by name and offset (ISP_BLC_CFG is at 0x21100 in the data sheet and 0x1000+0x20000 in the header)). Reset value and access type unknown (modelled RW, no reset). Confidence: medium (vendor header for this chip family, not hardware verified).";

        field {
            name = "newer";
            desc = "[inferred] Newer. (vendor header `isp_reg_define.h` field `newer`; access and reset unknown, modelled RW)";
            sw = rw;
            hw = r;
        } newer[0:0];
    } ISP_LSC_UPDATE @ 0x130EC;

    reg {
        name = "GE control register";
        desc = "ISP_GE_CFG is a GE control register.

Data sheet 10.6 ISP_GE_CFG (offset 0x23900, printed page 10-162, `hi3516cv300--Hi3516CV300-Hi3516EV100-Datasheet.txt` line 49666).";

        enum ISP_GE_CFG_ge_cor_en_enum {
            DISABLED = 0 { name = "Disabled"; desc = "disabled"; };
            ENABLED = 1 { name = "Enabled"; desc = "enabled"; };
        };

        field {
            name = "ge_cor_en";
            desc = "GE correction enable";
            sw = rw;
            hw = r;
            encode = ISP_GE_CFG_ge_cor_en_enum;
            reset = 0x0;
        } ge_cor_en[8:8];

        enum ISP_GE_CFG_ge_aver_en_enum {
            DISABLED = 0 { name = "Disabled"; desc = "disabled"; };
            ENABLED = 1 { name = "Enabled"; desc = "enabled"; };
        };

        field {
            name = "ge_aver_en";
            desc = "GE_AVER enable";
            sw = rw;
            hw = r;
            encode = ISP_GE_CFG_ge_aver_en_enum;
            reset = 0x0;
        } ge_aver_en[4:4];

        field {
            name = "ge3_en";
            desc = "[inferred] Ge3 enable. (bits reserved in the data sheet; vendor header `isp_reg_define.h` field `ge3_en`; access and reset unknown, modelled RW)";
            sw = rw;
            hw = r;
        } ge3_en[3:3];

        field {
            name = "ge2_en";
            desc = "[inferred] Ge2 enable. (bits reserved in the data sheet; vendor header `isp_reg_define.h` field `ge2_en`; access and reset unknown, modelled RW)";
            sw = rw;
            hw = r;
        } ge2_en[2:2];

        enum ISP_GE_CFG_ge1_en_enum {
            DISABLED = 0 { name = "Disabled"; desc = "disabled"; };
            ENABLED = 1 { name = "Enabled"; desc = "enabled"; };
        };

        field {
            name = "ge1_en";
            desc = "GE1 enable";
            sw = rw;
            hw = r;
            encode = ISP_GE_CFG_ge1_en_enum;
            reset = 0x0;
        } ge1_en[1:1];

        enum ISP_GE_CFG_ge0_en_enum {
            DISABLED = 0 { name = "Disabled"; desc = "disabled"; };
            ENABLED = 1 { name = "Enabled"; desc = "enabled"; };
        };

        field {
            name = "ge0_en";
            desc = "GE0 enable";
            sw = rw;
            hw = r;
            encode = ISP_GE_CFG_ge0_en_enum;
            reset = 0x0;
        } ge0_en[0:0];
    } ISP_GE_CFG @ 0x13900;

    reg {
        name = "ISP GE VERSION";
        desc = "[inferred] ISP GE VERSION. Not in the data sheet. Source: OpenIPC openhisilicon `kernel/isp/arch/hi3516cv300/firmware/vreg/arch/hi3516cv300/isp_reg_define.h` (GPL-3.0 repository, HiSilicon copyright, nManager-generated 2015-12-22 \"Define all registers/tables for Hi3519\"; local copy sources/openhisilicon), union `U_ISP_GE_VERSION`, struct offset 0x1390C (GPL-3.0 repository; header offsets are ISP-core relative (data sheet offset - 0x20000), 632 of 775 data-sheet registers match it by name and offset (ISP_BLC_CFG is at 0x21100 in the data sheet and 0x1000+0x20000 in the header)). Reset value and access type unknown (modelled RW, no reset). Confidence: medium (vendor header for this chip family, not hardware verified).";

        field {
            name = "version";
            desc = "[inferred] Version. (vendor header `isp_reg_define.h` field `version`; access and reset unknown, modelled RW)";
            sw = rw;
            hw = r;
        } version[31:0];
    } ISP_GE_VERSION @ 0x1390C;

    reg {
        name = "GE0 configuration register";
        desc = "ISP_GE0_CT_TH1 is a GE0 configuration register.

Data sheet 10.6 ISP_GE0_CT_TH1 (offset 0x23910, printed page 10-163, `hi3516cv300--Hi3516CV300-Hi3516EV100-Datasheet.txt` line 49715).";

        field {
            name = "ge0_ct_th1";
            desc = "Threshold";
            sw = rw;
            hw = r;
            reset = 0x400;
        } ge0_ct_th1[13:0];
    } ISP_GE0_CT_TH1 @ 0x13910;

    reg {
        name = "GE0 configuration register";
        desc = "ISP_GE0_CT_TH2 is a GE0 configuration register.

Data sheet 10.6 ISP_GE0_CT_TH2 (offset 0x23914, printed page 10-163, `hi3516cv300--Hi3516CV300-Hi3516EV100-Datasheet.txt` line 49734).";

        field {
            name = "ge0_ct_th2";
            desc = "Threshold";
            sw = rw;
            hw = r;
            reset = 0x200;
        } ge0_ct_th2[13:0];
    } ISP_GE0_CT_TH2 @ 0x13914;

    reg {
        name = "GE0 configuration register";
        desc = "ISP_GE0_CT_TH3 is a GE0 configuration register. Hi3516C V300/Hi3516E V100 Professional HD IP Camera SoC

Data sheet 10.6 ISP_GE0_CT_TH3 (offset 0x23918, printed page 10-164, `hi3516cv300--Hi3516CV300-Hi3516EV100-Datasheet.txt` line 49762).";

        field {
            name = "ge0_ct_th3";
            desc = "Threshold";
            sw = rw;
            hw = r;
            reset = 0x200;
        } ge0_ct_th3[13:0];
    } ISP_GE0_CT_TH3 @ 0x13918;

    reg {
        name = "GE0 configuration register";
        desc = "ISP_GE0_CT_SLOPE is a GE0 configuration register.

Data sheet 10.6 ISP_GE0_CT_SLOPE (offset 0x2391C, printed page 10-164, `hi3516cv300--Hi3516CV300-Hi3516EV100-Datasheet.txt` line 49782).";

        enum ISP_GE0_CT_SLOPE_ge0_ct_slope2_enum {
            V_1 = 0 { name = "V 1"; desc = "1"; };
            V_2 = 1 { name = "V 2"; desc = "2"; };
            V_4 = 2 { name = "V 4"; desc = "4"; };
            V_8_THIS_FIELD = 3 { name = "V 8 This Field"; desc = "8 … This field can be set to 0xE at most, and the value 14 indicates 2 ."; };
        };

        field {
            name = "ge0_ct_slope2";
            desc = "General correction slope";
            sw = rw;
            hw = r;
            encode = ISP_GE0_CT_SLOPE_ge0_ct_slope2_enum;
            reset = 0x9;
        } ge0_ct_slope2[7:4];

        enum ISP_GE0_CT_SLOPE_ge0_ct_slope1_enum {
            V_1 = 0 { name = "V 1"; desc = "1"; };
            V_2 = 1 { name = "V 2"; desc = "2"; };
            V_4 = 2 { name = "V 4"; desc = "4"; };
            V_8_THIS_FIELD = 3 { name = "V 8 This Field"; desc = "8 … This field can be set to 0xE at most, and the value 14 indicates 2 ."; };
        };

        field {
            name = "ge0_ct_slope1";
            desc = "Edge correction slope";
            sw = rw;
            hw = r;
            encode = ISP_GE0_CT_SLOPE_ge0_ct_slope1_enum;
            reset = 0x9;
        } ge0_ct_slope1[3:0];
    } ISP_GE0_CT_SLOPE @ 0x1391C;

    reg {
        name = "GE1 configuration register";
        desc = "ISP_GE1_CT_TH1 is a GE1 configuration register.

Data sheet 10.6 ISP_GE1_CT_TH1 (offset 0x23920, printed page 10-165, `hi3516cv300--Hi3516CV300-Hi3516EV100-Datasheet.txt` line 49820).";

        field {
            name = "ge1_ct_th1";
            desc = "Threshold";
            sw = rw;
            hw = r;
            reset = 0x400;
        } ge1_ct_th1[13:0];
    } ISP_GE1_CT_TH1 @ 0x13920;

    reg {
        name = "GE1 configuration register";
        desc = "ISP_GE1_CT_TH2 is a GE1 configuration register.

Data sheet 10.6 ISP_GE1_CT_TH2 (offset 0x23924, printed page 10-165, `hi3516cv300--Hi3516CV300-Hi3516EV100-Datasheet.txt` line 49840).";

        field {
            name = "ge1_ct_th2";
            desc = "Threshold";
            sw = rw;
            hw = r;
            reset = 0x0;
        } ge1_ct_th2[13:0];
    } ISP_GE1_CT_TH2 @ 0x13924;

    reg {
        name = "GE1 configuration register";
        desc = "ISP_GE1_CT_TH3 is a GE1 configuration register.

Data sheet 10.6 ISP_GE1_CT_TH3 (offset 0x23928, printed page 10-165, `hi3516cv300--Hi3516CV300-Hi3516EV100-Datasheet.txt` line 49860).";

        field {
            name = "ge1_ct_th3";
            desc = "Threshold";
            sw = rw;
            hw = r;
            reset = 0x0;
        } ge1_ct_th3[13:0];
    } ISP_GE1_CT_TH3 @ 0x13928;

    reg {
        name = "GE1 configuration register";
        desc = "ISP_GE1_CT_SLOPE is a GE1 configuration register.

Data sheet 10.6 ISP_GE1_CT_SLOPE (offset 0x2392C, printed page 10-166, `hi3516cv300--Hi3516CV300-Hi3516EV100-Datasheet.txt` line 49888).";

        enum ISP_GE1_CT_SLOPE_ge1_ct_slope2_enum {
            V_1 = 0 { name = "V 1"; desc = "1"; };
            V_2 = 1 { name = "V 2"; desc = "2"; };
            V_4 = 2 { name = "V 4"; desc = "4"; };
            V_8_THIS_FIELD = 3 { name = "V 8 This Field"; desc = "8 … This field can be set to 0xE at most, and the value 14 indicates 2 ."; };
        };

        field {
            name = "ge1_ct_slope2";
            desc = "General correction slope";
            sw = rw;
            hw = r;
            encode = ISP_GE1_CT_SLOPE_ge1_ct_slope2_enum;
            reset = 0x9;
        } ge1_ct_slope2[7:4];

        enum ISP_GE1_CT_SLOPE_ge1_ct_slope1_enum {
            V_1 = 0 { name = "V 1"; desc = "1"; };
            V_2 = 1 { name = "V 2"; desc = "2"; };
            V_4 = 2 { name = "V 4"; desc = "4"; };
            V_8_THIS_FIELD = 3 { name = "V 8 This Field"; desc = "8 … This field can be set to 0xE at most, and the value 14 indicates 2 ."; };
        };

        field {
            name = "ge1_ct_slope1";
            desc = "Edge correction slope";
            sw = rw;
            hw = r;
            encode = ISP_GE1_CT_SLOPE_ge1_ct_slope1_enum;
            reset = 0x9;
        } ge1_ct_slope1[3:0];
    } ISP_GE1_CT_SLOPE @ 0x1392C;

    reg {
        name = "GE zone configuration register";
        desc = "ISP_GE_ZONE is a GE zone configuration register. Hi3516C V300/Hi3516E V100 Professional HD IP Camera SoC

Data sheet 10.6 ISP_GE_ZONE (offset 0x23950, printed page 10-167, `hi3516cv300--Hi3516CV300-Hi3516EV100-Datasheet.txt` line 49930).";

        field {
            name = "vnum";
            desc = "Number of zones in the vertical direction";
            sw = rw;
            hw = r;
            reset = 0x0;
        } vnum[12:8];

        field {
            name = "hnum";
            desc = "Number of zones in the horizontal direction";
            sw = rw;
            hw = r;
            reset = 0x0;
        } hnum[4:0];
    } ISP_GE_ZONE @ 0x13950;

    reg {
        name = "GE correction mode select register";
        desc = "ISP_GE_MODE is a GE correction mode select register.

Data sheet 10.6 ISP_GE_MODE (offset 0x23954, printed page 10-167, `hi3516cv300--Hi3516CV300-Hi3516EV100-Datasheet.txt` line 49953).";

        enum ISP_GE_MODE_gr_gb_en_enum {
            DISABLED = 0 { name = "Disabled"; desc = "disabled"; };
            ENABLED = 1 { name = "Enabled"; desc = "enabled"; };
        };

        field {
            name = "gr_gb_en";
            desc = "Gr and Gb correction enable";
            sw = rw;
            hw = r;
            encode = ISP_GE_MODE_gr_gb_en_enum;
            reset = 0x1;
        } gr_gb_en[2:2];

        enum ISP_GE_MODE_gb_en_enum {
            DISABLED = 0 { name = "Disabled"; desc = "disabled"; };
            ENABLED = 1 { name = "Enabled"; desc = "enabled"; };
        };

        field {
            name = "gb_en";
            desc = "Gb correction enable";
            sw = rw;
            hw = r;
            encode = ISP_GE_MODE_gb_en_enum;
            reset = 0x0;
        } gb_en[1:1];

        enum ISP_GE_MODE_gr_en_enum {
            DISABLED = 0 { name = "Disabled"; desc = "disabled"; };
            ENABLED = 1 { name = "Enabled"; desc = "enabled"; };
        };

        field {
            name = "gr_en";
            desc = "Gr correction enable";
            sw = rw;
            hw = r;
            encode = ISP_GE_MODE_gr_en_enum;
            reset = 0x0;
        } gr_en[0:0];
    } ISP_GE_MODE @ 0x13954;

    reg {
        name = "GE correction strength configuration register";
        desc = "ISP_GE_STRENGTH is a GE correction strength configuration register.

Data sheet 10.6 ISP_GE_STRENGTH (offset 0x23958, printed page 10-168, `hi3516cv300--Hi3516CV300-Hi3516EV100-Datasheet.txt` line 49991).";

        field {
            name = "strength";
            desc = "GE correction strength, U9.0";
            sw = rw;
            hw = r;
            reset = 0x80;
        } strength[8:0];
    } ISP_GE_STRENGTH @ 0x13958;

    reg {
        name = "ISP GE MEM AVER WADDR0";
        desc = "[inferred] ISP GE MEM AVER WADDR0. Not in the data sheet. Source: OpenIPC openhisilicon `kernel/isp/arch/hi3516cv300/firmware/vreg/arch/hi3516cv300/isp_reg_define.h` (GPL-3.0 repository, HiSilicon copyright, nManager-generated 2015-12-22 \"Define all registers/tables for Hi3519\"; local copy sources/openhisilicon), union `U_ISP_GE_MEM_AVER_WADDR0`, struct offset 0x13980 (GPL-3.0 repository; header offsets are ISP-core relative (data sheet offset - 0x20000), 632 of 775 data-sheet registers match it by name and offset (ISP_BLC_CFG is at 0x21100 in the data sheet and 0x1000+0x20000 in the header)). Reset value and access type unknown (modelled RW, no reset). Confidence: medium (vendor header for this chip family, not hardware verified).";

        field {
            name = "aver0_waddr";
            desc = "[inferred] Aver0 waddr. (vendor header `isp_reg_define.h` field `aver0_waddr`; access and reset unknown, modelled RW)";
            sw = rw;
            hw = r;
        } aver0_waddr[31:0];
    } ISP_GE_MEM_AVER_WADDR0 @ 0x13980;

    reg {
        name = "ISP GE MEM AVER WDATA0";
        desc = "[inferred] ISP GE MEM AVER WDATA0. Not in the data sheet. Source: OpenIPC openhisilicon `kernel/isp/arch/hi3516cv300/firmware/vreg/arch/hi3516cv300/isp_reg_define.h` (GPL-3.0 repository, HiSilicon copyright, nManager-generated 2015-12-22 \"Define all registers/tables for Hi3519\"; local copy sources/openhisilicon), union `U_ISP_GE_MEM_AVER_WDATA0`, struct offset 0x13984 (GPL-3.0 repository; header offsets are ISP-core relative (data sheet offset - 0x20000), 632 of 775 data-sheet registers match it by name and offset (ISP_BLC_CFG is at 0x21100 in the data sheet and 0x1000+0x20000 in the header)). Reset value and access type unknown (modelled RW, no reset). Confidence: medium (vendor header for this chip family, not hardware verified).";

        field {
            name = "aver0_wdata";
            desc = "[inferred] Aver0 wdata. (vendor header `isp_reg_define.h` field `aver0_wdata`; access and reset unknown, modelled RW)";
            sw = rw;
            hw = r;
        } aver0_wdata[31:0];
    } ISP_GE_MEM_AVER_WDATA0 @ 0x13984;

    reg {
        name = "GE average value statistics read ADDR0 address register 0";
        desc = "ISP_GE_MEM_AVER_RADDR0 is GE average value statistics read address register 0.

Data sheet 10.6 ISP_GE_MEM_AVER_RADDR0 (offset 0x23988, printed page 10-168, `hi3516cv300--Hi3516CV300-Hi3516EV100-Datasheet.txt` line 50011).";

        field {
            name = "aver0_raddr";
            desc = "Read address of the GE average value statistics";
            sw = rw;
            hw = r;
            reset = 0x0;
        } aver0_raddr[31:0];
    } ISP_GE_MEM_AVER_RADDR0 @ 0x13988;

    reg {
        name = "GE average value statistics read data DATA0 register 0";
        desc = "ISP_GE_MEM_AVER_RDATA0 is GE average value statistics read data register 0.

Data sheet 10.6 ISP_GE_MEM_AVER_RDATA0 (offset 0x2398C, printed page 10-168, `hi3516cv300--Hi3516CV300-Hi3516EV100-Datasheet.txt` line 50029).";

        field {
            name = "aver0_rdata";
            desc = "Read data of the GE average value statistics";
            sw = r;
            hw = w;
            reset = 0x0;
        } aver0_rdata[31:0];
    } ISP_GE_MEM_AVER_RDATA0 @ 0x1398C;

    reg {
        name = "ISP GE MEM AVER WADDR1";
        desc = "[inferred] ISP GE MEM AVER WADDR1. Not in the data sheet. Source: OpenIPC openhisilicon `kernel/isp/arch/hi3516cv300/firmware/vreg/arch/hi3516cv300/isp_reg_define.h` (GPL-3.0 repository, HiSilicon copyright, nManager-generated 2015-12-22 \"Define all registers/tables for Hi3519\"; local copy sources/openhisilicon), union `U_ISP_GE_MEM_AVER_WADDR1`, struct offset 0x13990 (GPL-3.0 repository; header offsets are ISP-core relative (data sheet offset - 0x20000), 632 of 775 data-sheet registers match it by name and offset (ISP_BLC_CFG is at 0x21100 in the data sheet and 0x1000+0x20000 in the header)). Reset value and access type unknown (modelled RW, no reset). Confidence: medium (vendor header for this chip family, not hardware verified).";

        field {
            name = "aver1_waddr";
            desc = "[inferred] Aver1 waddr. (vendor header `isp_reg_define.h` field `aver1_waddr`; access and reset unknown, modelled RW)";
            sw = rw;
            hw = r;
        } aver1_waddr[31:0];
    } ISP_GE_MEM_AVER_WADDR1 @ 0x13990;

    reg {
        name = "ISP GE MEM AVER WDATA1";
        desc = "[inferred] ISP GE MEM AVER WDATA1. Not in the data sheet. Source: OpenIPC openhisilicon `kernel/isp/arch/hi3516cv300/firmware/vreg/arch/hi3516cv300/isp_reg_define.h` (GPL-3.0 repository, HiSilicon copyright, nManager-generated 2015-12-22 \"Define all registers/tables for Hi3519\"; local copy sources/openhisilicon), union `U_ISP_GE_MEM_AVER_WDATA1`, struct offset 0x13994 (GPL-3.0 repository; header offsets are ISP-core relative (data sheet offset - 0x20000), 632 of 775 data-sheet registers match it by name and offset (ISP_BLC_CFG is at 0x21100 in the data sheet and 0x1000+0x20000 in the header)). Reset value and access type unknown (modelled RW, no reset). Confidence: medium (vendor header for this chip family, not hardware verified).";

        field {
            name = "aver1_wdata";
            desc = "[inferred] Aver1 wdata. (vendor header `isp_reg_define.h` field `aver1_wdata`; access and reset unknown, modelled RW)";
            sw = rw;
            hw = r;
        } aver1_wdata[31:0];
    } ISP_GE_MEM_AVER_WDATA1 @ 0x13994;

    reg {
        name = "GE average value statistics read ADDR1 address register 1";
        desc = "ISP_GE_MEM_AVER_RADDR1 is GE average value statistics read address register 1.

Data sheet 10.6 ISP_GE_MEM_AVER_RADDR1 (offset 0x23998, printed page 10-169, `hi3516cv300--Hi3516CV300-Hi3516EV100-Datasheet.txt` line 50054).";

        field {
            name = "aver1_raddr";
            desc = "Read address of the GE average value statistics";
            sw = rw;
            hw = r;
            reset = 0x0;
        } aver1_raddr[31:0];
    } ISP_GE_MEM_AVER_RADDR1 @ 0x13998;

    reg {
        name = "GE average value statistics read data DATA1 register 1";
        desc = "ISP_GE_MEM_AVER_RDATA1 is GE average value statistics read data register 1.

Data sheet 10.6 ISP_GE_MEM_AVER_RDATA1 (offset 0x2399C, printed page 10-169, `hi3516cv300--Hi3516CV300-Hi3516EV100-Datasheet.txt` line 50073).";

        field {
            name = "aver1_rdata";
            desc = "Read data of the GE average value statistics";
            sw = r;
            hw = w;
            reset = 0x0;
        } aver1_rdata[31:0];
    } ISP_GE_MEM_AVER_RDATA1 @ 0x1399C;

    reg {
        name = "ISP GE control F";
        desc = "[inferred] ISP GE control F. Not in the data sheet. Source: OpenIPC openhisilicon `kernel/isp/arch/hi3516cv300/firmware/vreg/arch/hi3516cv300/isp_reg_define.h` (GPL-3.0 repository, HiSilicon copyright, nManager-generated 2015-12-22 \"Define all registers/tables for Hi3519\"; local copy sources/openhisilicon), union `U_ISP_GE_CTRL_F`, struct offset 0x139E0 (GPL-3.0 repository; header offsets are ISP-core relative (data sheet offset - 0x20000), 632 of 775 data-sheet registers match it by name and offset (ISP_BLC_CFG is at 0x21100 in the data sheet and 0x1000+0x20000 in the header)). Reset value and access type unknown (modelled RW, no reset). Confidence: medium (vendor header for this chip family, not hardware verified).";

        field {
            name = "rggb_cfg";
            desc = "[inferred] Rggb configuration. (vendor header `isp_reg_define.h` field `rggb_cfg`; access and reset unknown, modelled RW)";
            sw = rw;
            hw = r;
        } rggb_cfg[1:0];
    } ISP_GE_CTRL_F @ 0x139E0;

    reg {
        name = "ISP GE control I";
        desc = "[inferred] ISP GE control I. Not in the data sheet. Source: OpenIPC openhisilicon `kernel/isp/arch/hi3516cv300/firmware/vreg/arch/hi3516cv300/isp_reg_define.h` (GPL-3.0 repository, HiSilicon copyright, nManager-generated 2015-12-22 \"Define all registers/tables for Hi3519\"; local copy sources/openhisilicon), union `U_ISP_GE_CTRL_I`, struct offset 0x139E4 (GPL-3.0 repository; header offsets are ISP-core relative (data sheet offset - 0x20000), 632 of 775 data-sheet registers match it by name and offset (ISP_BLC_CFG is at 0x21100 in the data sheet and 0x1000+0x20000 in the header)). Reset value and access type unknown (modelled RW, no reset). Confidence: medium (vendor header for this chip family, not hardware verified).";

        field {
            name = "update_mode";
            desc = "[inferred] Update mode. (vendor header `isp_reg_define.h` field `update_mode`; access and reset unknown, modelled RW)";
            sw = rw;
            hw = r;
        } update_mode[0:0];
    } ISP_GE_CTRL_I @ 0x139E4;

    reg {
        name = "ISP GE TIMING";
        desc = "[inferred] ISP GE TIMING. Not in the data sheet. Source: OpenIPC openhisilicon `kernel/isp/arch/hi3516cv300/firmware/vreg/arch/hi3516cv300/isp_reg_define.h` (GPL-3.0 repository, HiSilicon copyright, nManager-generated 2015-12-22 \"Define all registers/tables for Hi3519\"; local copy sources/openhisilicon), union `U_ISP_GE_TIMING`, struct offset 0x139E8 (GPL-3.0 repository; header offsets are ISP-core relative (data sheet offset - 0x20000), 632 of 775 data-sheet registers match it by name and offset (ISP_BLC_CFG is at 0x21100 in the data sheet and 0x1000+0x20000 in the header)). Reset value and access type unknown (modelled RW, no reset). Confidence: medium (vendor header for this chip family, not hardware verified).";

        field {
            name = "cpi_fix_timing_stat";
            desc = "[inferred] Cpi fix timing status. (vendor header `isp_reg_define.h` field `cpi_fix_timing_stat`; access and reset unknown, modelled RW)";
            sw = rw;
            hw = r;
        } cpi_fix_timing_stat[13:1];
    } ISP_GE_TIMING @ 0x139E8;

    reg {
        name = "ISP GE UPDATE";
        desc = "[inferred] ISP GE UPDATE. Not in the data sheet. Source: OpenIPC openhisilicon `kernel/isp/arch/hi3516cv300/firmware/vreg/arch/hi3516cv300/isp_reg_define.h` (GPL-3.0 repository, HiSilicon copyright, nManager-generated 2015-12-22 \"Define all registers/tables for Hi3519\"; local copy sources/openhisilicon), union `U_ISP_GE_UPDATE`, struct offset 0x139EC (GPL-3.0 repository; header offsets are ISP-core relative (data sheet offset - 0x20000), 632 of 775 data-sheet registers match it by name and offset (ISP_BLC_CFG is at 0x21100 in the data sheet and 0x1000+0x20000 in the header)). Reset value and access type unknown (modelled RW, no reset). Confidence: medium (vendor header for this chip family, not hardware verified).";

        field {
            name = "update";
            desc = "[inferred] Update. (vendor header `isp_reg_define.h` field `update`; access and reset unknown, modelled RW)";
            sw = rw;
            hw = r;
        } update[0:0];
    } ISP_GE_UPDATE @ 0x139EC;

    reg {
        name = "GE picture size register";
        desc = "ISP_GE_SIZE is a GE picture size register.

Data sheet 10.6 ISP_GE_SIZE (offset 0x239F0, printed page 10-169, `hi3516cv300--Hi3516CV300-Hi3516EV100-Datasheet.txt` line 50091).";

        field {
            name = "height";
            desc = "Picture height. The configured value is the actual value minus 1. For example, if the actual picture height is 1080, set this field to 1079.";
            sw = rw;
            hw = r;
            reset = 0x437;
        } height[28:16];

        field {
            name = "width";
            desc = "Picture width. The configured value is the actual value minus 1. For example, if the actual picture width is 1920, set this field to 1919.";
            sw = rw;
            hw = r;
            reset = 0x77F;
        } width[12:0];
    } ISP_GE_SIZE @ 0x139F0;

    reg {
        name = "FPN configuration register";
        desc = "ISP_FPN_CFG is an FPN configuration register.

Data sheet 10.6 ISP_FPN_CFG (offset 0x23A00, printed page 10-170, `hi3516cv300--Hi3516CV300-Hi3516EV100-Datasheet.txt` line 50130).";

        enum ISP_FPN_CFG_line_frame_enum {
            FRAME_MODE = 0 { name = "Frame Mode"; desc = "frame mode"; };
            LINE_MODE = 1 { name = "Line Mode"; desc = "line mode"; };
        };

        field {
            name = "line_frame";
            desc = "FPN frame/line mode";
            sw = rw;
            hw = r;
            encode = ISP_FPN_CFG_line_frame_enum;
            reset = 0x0;
        } line_frame[9:9];

        enum ISP_FPN_CFG_calib_corr_enum {
            CORRECTION_MODE = 0 { name = "Correction Mode"; desc = "correction mode"; };
            CALIBRATION_MODE = 1 { name = "Calibration Mode"; desc = "calibration mode"; };
        };

        field {
            name = "calib_corr";
            desc = "FPN correction/calibration mode";
            sw = rw;
            hw = r;
            encode = ISP_FPN_CFG_calib_corr_enum;
            reset = 0x0;
        } calib_corr[8:8];

        enum ISP_FPN_CFG_enable_f_enum {
            DISABLED = 0 { name = "Disabled"; desc = "disabled"; };
            ENABLED = 1 { name = "Enabled"; desc = "enabled"; };
        };

        field {
            name = "enable";
            desc = "FPN enable";
            sw = rw;
            hw = r;
            encode = ISP_FPN_CFG_enable_f_enum;
            reset = 0x0;
        } enable_f[0:0];
    } ISP_FPN_CFG @ 0x13A00;

    reg {
        name = "FPN calibration start signal register";
        desc = "ISP_FPN_CALIB_START is an FPN calibration start signal register. Hi3516C V300/Hi3516E V100 Professional HD IP Camera SoC

Data sheet 10.6 ISP_FPN_CALIB_START (offset 0x23A04, printed page 10-171, `hi3516cv300--Hi3516CV300-Hi3516EV100-Datasheet.txt` line 50175).";

        field {
            name = "calib_start";
            desc = "FPN calibration start. This bit is automatically cleared.";
            sw = rw;
            hw = r;
            reset = 0x0;
        } calib_start[0:0];
    } ISP_FPN_CALIB_START @ 0x13A04;

    reg {
        name = "FPN correction enable register";
        desc = "ISP_FPN_CORR_CFG is an FPN correction enable register.

Data sheet 10.6 ISP_FPN_CORR_CFG (offset 0x23A08, printed page 10-171, `hi3516cv300--Hi3516CV300-Hi3516EV100-Datasheet.txt` line 50201).";

        field {
            name = "correct3_en";
            desc = "[inferred] Correct3 enable. (bits reserved in the data sheet; vendor header `isp_reg_define.h` field `correct3_en`; access and reset unknown, modelled RW)";
            sw = rw;
            hw = r;
        } correct3_en[3:3];

        field {
            name = "correct2_en";
            desc = "[inferred] Correct2 enable. (bits reserved in the data sheet; vendor header `isp_reg_define.h` field `correct2_en`; access and reset unknown, modelled RW)";
            sw = rw;
            hw = r;
        } correct2_en[2:2];

        field {
            name = "correct1_en";
            desc = "[inferred] Correct1 enable. (bits reserved in the data sheet; vendor header `isp_reg_define.h` field `correct1_en`; access and reset unknown, modelled RW)";
            sw = rw;
            hw = r;
        } correct1_en[1:1];

        enum ISP_FPN_CORR_CFG_correct0_en_enum {
            DISABLED = 0 { name = "Disabled"; desc = "disabled"; };
            ENABLED = 1 { name = "Enabled"; desc = "enabled"; };
        };

        field {
            name = "correct0_en";
            desc = "FPN correction enable for channel 0";
            sw = rw;
            hw = r;
            encode = ISP_FPN_CORR_CFG_correct0_en_enum;
            reset = 0x1;
        } correct0_en[0:0];
    } ISP_FPN_CORR_CFG @ 0x13A08;

    reg {
        name = "FPN calibration status register";
        desc = "ISP_FPN_STAT is an FPN calibration status register. Hi3516C V300/Hi3516E V100 Professional HD IP Camera SoC

Data sheet 10.6 ISP_FPN_STAT (offset 0x23A0C, printed page 10-172, `hi3516cv300--Hi3516CV300-Hi3516EV100-Datasheet.txt` line 50239).";

        field {
            name = "hcnt";
            desc = "Number of lines";
            sw = r;
            hw = w;
            reset = 0xFFFF;
        } hcnt[31:16];

        field {
            name = "vcnt";
            desc = "Number of calibrated frames";
            sw = r;
            hw = w;
            reset = 0x0;
        } vcnt[13:8];

        enum ISP_FPN_STAT_busy_enum {
            IDLE = 0 { name = "Idle"; desc = "idle"; };
            BEING_CALIBRATED = 1 { name = "Being Calibrated"; desc = "being calibrated"; };
        };

        field {
            name = "busy";
            desc = "FPN calibration status";
            sw = r;
            hw = w;
            encode = ISP_FPN_STAT_busy_enum;
            reset = 0x0;
        } busy[0:0];
    } ISP_FPN_STAT @ 0x13A0C;

    reg {
        name = "FPN calibration white point L configuration register";
        desc = "ISP_FPN_WHITE_LEVEL is an FPN calibration white point configuration register.

Data sheet 10.6 ISP_FPN_WHITE_LEVEL (offset 0x23A10, printed page 10-172, `hi3516cv300--Hi3516CV300-Hi3516EV100-Datasheet.txt` line 50267).";

        field {
            name = "white_level";
            desc = "FPN calibration white point configuration";
            sw = rw;
            hw = r;
            reset = 0x0;
        } white_level[13:0];
    } ISP_FPN_WHITE_LEVEL @ 0x13A10;

    reg {
        name = "FPN calibration division coefficient register";
        desc = "ISP_FPN_DIVCOEF is an FPN calibration division coefficient register. Hi3516C V300/Hi3516E V100 Professional HD IP Camera SoC

Data sheet 10.6 ISP_FPN_DIVCOEF (offset 0x23A18, printed page 10-173, `hi3516cv300--Hi3516CV300-Hi3516EV100-Datasheet.txt` line 50295).";

        field {
            name = "divcoef";
            desc = "FPN calibration division coefficient";
            sw = rw;
            hw = r;
            reset = 0x0;
        } divcoef[11:0];
    } ISP_FPN_DIVCOEF @ 0x13A18;

    reg {
        name = "FPN calibrated frame number register";
        desc = "ISP_FPN_FRAMELOG2 is an FPN calibrated frame number register.

Data sheet 10.6 ISP_FPN_FRAMELOG2 (offset 0x23A1C, printed page 10-173, `hi3516cv300--Hi3516CV300-Hi3516EV100-Datasheet.txt` line 50315).";

        field {
            name = "cpi_fpn_framelog2";
            desc = "Number of FPN calibrated frames. The configured value is obtained by taking the logarithm of the number of frames to 2.";
            sw = rw;
            hw = r;
            reset = 0x0;
        } cpi_fpn_framelog2[2:0];
    } ISP_FPN_FRAMELOG2 @ 0x13A1C;

    reg {
        name = "FPN calibration accumulated sum low bits register";
        desc = "ISP_FPN_SUM0 is an FPN calibration accumulated sum lower bits register. Hi3516C V300/Hi3516E V100 Professional HD IP Camera SoC

Data sheet 10.6 ISP_FPN_SUM0 (offset 0x23A20, printed page 10-174, `hi3516cv300--Hi3516CV300-Hi3516EV100-Datasheet.txt` line 50352).";

        field {
            name = "sum";
            desc = "Lower bits of the FPN calibration accumulated sum";
            sw = r;
            hw = w;
            reset = 0x0;
        } sum[31:0];
    } ISP_FPN_SUM0 @ 0x13A20;

    reg {
        name = "FPN calibration accumulated sum upper bits register";
        desc = "ISP_FPN_SUM1 is an FPN calibration accumulated sum upper bits register.

Data sheet 10.6 ISP_FPN_SUM1 (offset 0x23A24, printed page 10-174, `hi3516cv300--Hi3516CV300-Hi3516EV100-Datasheet.txt` line 50371).";

        field {
            name = "sum";
            desc = "Upper bits of the FPN calibration accumulated sum";
            sw = r;
            hw = w;
            reset = 0x0;
        } sum[31:0];
    } ISP_FPN_SUM1 @ 0x13A24;

    reg {
        name = "FPN correction configuration register 0";
        desc = "ISP_FPN_CORR0 is FPN correction configuration register 0.

Data sheet 10.6 ISP_FPN_CORR0 (offset 0x23A30, printed page 10-174, `hi3516cv300--Hi3516CV300-Hi3516EV100-Datasheet.txt` line 50389).";

        field {
            name = "strength";
            desc = "FPN correction strength (U8.8)";
            sw = rw;
            hw = r;
            reset = 0x0;
        } strength[31:16];

        field {
            name = "offset";
            desc = "FPN correction bias";
            sw = rw;
            hw = r;
            reset = 0x0;
        } offset[11:0];
    } ISP_FPN_CORR0 @ 0x13A30;

    reg {
        name = "FPN correction configuration register 1";
        desc = "ISP_FPN_CORR1 is FPN correction configuration register 1.

Data sheet 10.6 ISP_FPN_CORR1 (offset 0x23A34, printed page 10-175, `hi3516cv300--Hi3516CV300-Hi3516EV100-Datasheet.txt` line 50416).";

        field {
            name = "strength";
            desc = "FPN correction strength (U8.8)";
            sw = rw;
            hw = r;
            reset = 0x0;
        } strength[31:16];

        field {
            name = "offset";
            desc = "FPN correction bias";
            sw = rw;
            hw = r;
            reset = 0x0;
        } offset[11:0];
    } ISP_FPN_CORR1 @ 0x13A34;

    reg {
        name = "FPN correction configuration register 2";
        desc = "ISP_FPN_CORR2 is FPN correction configuration register 2.

Data sheet 10.6 ISP_FPN_CORR2 (offset 0x23A38, printed page 10-175, `hi3516cv300--Hi3516CV300-Hi3516EV100-Datasheet.txt` line 50437).";

        field {
            name = "strength";
            desc = "FPN correction strength (U8.8)";
            sw = rw;
            hw = r;
            reset = 0x0;
        } strength[31:16];

        field {
            name = "offset";
            desc = "FPN correction bias";
            sw = rw;
            hw = r;
            reset = 0x0;
        } offset[11:0];
    } ISP_FPN_CORR2 @ 0x13A38;

    reg {
        name = "FPN correction configuration register 3";
        desc = "ISP_FPN_CORR3 is FPN correction configuration register 3. Hi3516C V300/Hi3516E V100 Professional HD IP Camera SoC

Data sheet 10.6 ISP_FPN_CORR3 (offset 0x23A3C, printed page 10-176, `hi3516cv300--Hi3516CV300-Hi3516EV100-Datasheet.txt` line 50466).";

        field {
            name = "strength";
            desc = "FPN correction strength (U8.8)";
            sw = rw;
            hw = r;
            reset = 0x0;
        } strength[31:16];

        field {
            name = "offset";
            desc = "FPN correction bias";
            sw = rw;
            hw = r;
            reset = 0x0;
        } offset[11:0];
    } ISP_FPN_CORR3 @ 0x13A3C;

    reg {
        name = "FPN shift configuration register";
        desc = "ISP_FPN_SHIFT is an FPN shift configuration register.

Data sheet 10.6 ISP_FPN_SHIFT (offset 0x23A40, printed page 10-176, `hi3516cv300--Hi3516CV300-Hi3516EV100-Datasheet.txt` line 50487).";

        field {
            name = "frame_calib_shift";
            desc = "Number of left shift bits for the last output frame during frame calibration";
            sw = rw;
            hw = r;
            reset = 0x0;
        } frame_calib_shift[27:24];

        field {
            name = "out_shift";
            desc = "Number of left shift bits for the output";
            sw = rw;
            hw = r;
            reset = 0x0;
        } out_shift[19:16];

        field {
            name = "in_shift";
            desc = "Number of right shift bits for the input";
            sw = rw;
            hw = r;
            reset = 0x0;
        } in_shift[11:8];

        field {
            name = "fpn_shift";
            desc = "Number of right shift bits for the input FPN";
            sw = rw;
            hw = r;
            reset = 0x0;
        } fpn_shift[3:0];
    } ISP_FPN_SHIFT @ 0x13A40;

    reg {
        name = "FPN maximum output value register";
        desc = "ISP_FPN_MAX_O is an FPN maximum output value register. Hi3516C V300/Hi3516E V100 Professional HD IP Camera SoC

Data sheet 10.6 ISP_FPN_MAX_O (offset 0x23A50, printed page 10-177, `hi3516cv300--Hi3516CV300-Hi3516EV100-Datasheet.txt` line 50525).";

        field {
            name = "max_o";
            desc = "Maximum value of the FPN output";
            sw = rw;
            hw = r;
            reset = 0x3FFF;
        } max_o[15:0];
    } ISP_FPN_MAX_O @ 0x13A50;

    reg {
        name = "FPN correction threshold register HR";
        desc = "ISP_FPN_OVERFLOWTHR is an FPN correction threshold register.

Data sheet 10.6 ISP_FPN_OVERFLOWTHR (offset 0x23A54, printed page 10-177, `hi3516cv300--Hi3516CV300-Hi3516EV100-Datasheet.txt` line 50545).";

        field {
            name = "overflowthr";
            desc = "FPN correction threshold";
            sw = rw;
            hw = r;
            reset = 0x3FFF;
        } overflowthr[13:0];
    } ISP_FPN_OVERFLOWTHR @ 0x13A54;

    reg {
        name = "ISP FPN RESERVED";
        desc = "[inferred] ISP FPN RESERVED. Not in the data sheet. Source: OpenIPC openhisilicon `kernel/isp/arch/hi3516cv300/firmware/vreg/arch/hi3516cv300/isp_reg_define.h` (GPL-3.0 repository, HiSilicon copyright, nManager-generated 2015-12-22 \"Define all registers/tables for Hi3519\"; local copy sources/openhisilicon), union `U_ISP_FPN_RESERVED`, struct offset 0x13A5C (GPL-3.0 repository; header offsets are ISP-core relative (data sheet offset - 0x20000), 632 of 775 data-sheet registers match it by name and offset (ISP_BLC_CFG is at 0x21100 in the data sheet and 0x1000+0x20000 in the header)). Reset value and access type unknown (modelled RW, no reset). Confidence: medium (vendor header for this chip family, not hardware verified).";

        field {
            name = "fpn_reserved";
            desc = "[inferred] Fpn reserved. (vendor header `isp_reg_define.h` field `fpn_reserved`; access and reset unknown, modelled RW)";
            sw = rw;
            hw = r;
        } fpn_reserved[31:0];
    } ISP_FPN_RESERVED @ 0x13A5C;

    reg {
        name = "FPN line mode black line write address register";
        desc = "ISP_FPN_LINE_WADDR is an FPN line mode black line write address register.

Data sheet 10.6 ISP_FPN_LINE_WADDR (offset 0x23A80, printed page 10-177, `hi3516cv300--Hi3516CV300-Hi3516EV100-Datasheet.txt` line 50564).";

        field {
            name = "fpn_line_waddr";
            desc = "Write address of the black line in FPN line mode";
            sw = rw;
            hw = r;
            reset = 0x0;
        } fpn_line_waddr[31:0];
    } ISP_FPN_LINE_WADDR @ 0x13A80;

    reg {
        name = "FPN line mode black line write data register";
        desc = "ISP_FPN_LINE_WDATA is an FPN line mode black line write data register.

Data sheet 10.6 ISP_FPN_LINE_WDATA (offset 0x23A84, printed page 10-178, `hi3516cv300--Hi3516CV300-Hi3516EV100-Datasheet.txt` line 50589).";

        field {
            name = "fpn_line_wdata";
            desc = "Write data of the black line in FPN line mode";
            sw = rw;
            hw = r;
            reset = 0x0;
        } fpn_line_wdata[31:0];
    } ISP_FPN_LINE_WDATA @ 0x13A84;

    reg {
        name = "FPN line mode black line read address register";
        desc = "ISP_FPN_LINE_RADDR is an FPN line mode black line read address register.

Data sheet 10.6 ISP_FPN_LINE_RADDR (offset 0x23A88, printed page 10-178, `hi3516cv300--Hi3516CV300-Hi3516EV100-Datasheet.txt` line 50608).";

        field {
            name = "fpn_line_raddr";
            desc = "Read address of the black line in FPN line mode";
            sw = rw;
            hw = r;
            reset = 0x0;
        } fpn_line_raddr[31:0];
    } ISP_FPN_LINE_RADDR @ 0x13A88;

    reg {
        name = "FPN line mode black line read data register";
        desc = "ISP_FPN_LINE_RDATA is an FPN line mode black line read data register.

Data sheet 10.6 ISP_FPN_LINE_RDATA (offset 0x23A8C, printed page 10-178, `hi3516cv300--Hi3516CV300-Hi3516EV100-Datasheet.txt` line 50626).";

        field {
            name = "fpn_line_rdata";
            desc = "Read data of the black line in FPN line mode";
            sw = rw;
            hw = r;
            reset = 0x0;
        } fpn_line_rdata[31:0];
    } ISP_FPN_LINE_RDATA @ 0x13A8C;

    reg {
        name = "ISP FPN control F";
        desc = "[inferred] ISP FPN control F. Not in the data sheet. Source: OpenIPC openhisilicon `kernel/isp/arch/hi3516cv300/firmware/vreg/arch/hi3516cv300/isp_reg_define.h` (GPL-3.0 repository, HiSilicon copyright, nManager-generated 2015-12-22 \"Define all registers/tables for Hi3519\"; local copy sources/openhisilicon), union `U_ISP_FPN_CTRL_F`, struct offset 0x13AE0 (GPL-3.0 repository; header offsets are ISP-core relative (data sheet offset - 0x20000), 632 of 775 data-sheet registers match it by name and offset (ISP_BLC_CFG is at 0x21100 in the data sheet and 0x1000+0x20000 in the header)). Reset value and access type unknown (modelled RW, no reset). Confidence: medium (vendor header for this chip family, not hardware verified).";

        field {
            name = "rggb_cfg";
            desc = "[inferred] Rggb configuration. (vendor header `isp_reg_define.h` field `rggb_cfg`; access and reset unknown, modelled RW)";
            sw = rw;
            hw = r;
        } rggb_cfg[1:0];
    } ISP_FPN_CTRL_F @ 0x13AE0;

    reg {
        name = "ISP FPN control I";
        desc = "[inferred] ISP FPN control I. Not in the data sheet. Source: OpenIPC openhisilicon `kernel/isp/arch/hi3516cv300/firmware/vreg/arch/hi3516cv300/isp_reg_define.h` (GPL-3.0 repository, HiSilicon copyright, nManager-generated 2015-12-22 \"Define all registers/tables for Hi3519\"; local copy sources/openhisilicon), union `U_ISP_FPN_CTRL_I`, struct offset 0x13AE4 (GPL-3.0 repository; header offsets are ISP-core relative (data sheet offset - 0x20000), 632 of 775 data-sheet registers match it by name and offset (ISP_BLC_CFG is at 0x21100 in the data sheet and 0x1000+0x20000 in the header)). Reset value and access type unknown (modelled RW, no reset). Confidence: medium (vendor header for this chip family, not hardware verified).";

        field {
            name = "update_mode";
            desc = "[inferred] Update mode. (vendor header `isp_reg_define.h` field `update_mode`; access and reset unknown, modelled RW)";
            sw = rw;
            hw = r;
        } update_mode[0:0];
    } ISP_FPN_CTRL_I @ 0x13AE4;

    reg {
        name = "ISP FPN TIMING";
        desc = "[inferred] ISP FPN TIMING. Not in the data sheet. Source: OpenIPC openhisilicon `kernel/isp/arch/hi3516cv300/firmware/vreg/arch/hi3516cv300/isp_reg_define.h` (GPL-3.0 repository, HiSilicon copyright, nManager-generated 2015-12-22 \"Define all registers/tables for Hi3519\"; local copy sources/openhisilicon), union `U_ISP_FPN_TIMING`, struct offset 0x13AE8 (GPL-3.0 repository; header offsets are ISP-core relative (data sheet offset - 0x20000), 632 of 775 data-sheet registers match it by name and offset (ISP_BLC_CFG is at 0x21100 in the data sheet and 0x1000+0x20000 in the header)). Reset value and access type unknown (modelled RW, no reset). Confidence: medium (vendor header for this chip family, not hardware verified).";

        field {
            name = "cpi_fix_timing_stat";
            desc = "[inferred] Cpi fix timing status. (vendor header `isp_reg_define.h` field `cpi_fix_timing_stat`; access and reset unknown, modelled RW)";
            sw = rw;
            hw = r;
        } cpi_fix_timing_stat[13:1];

        field {
            name = "fpn_reserved1";
            desc = "[inferred] Fpn reserved1. (vendor header `isp_reg_define.h` field `fpn_reserved1`; access and reset unknown, modelled RW)";
            sw = rw;
            hw = r;
        } fpn_reserved1[0:0];
    } ISP_FPN_TIMING @ 0x13AE8;

    reg {
        name = "ISP FPN UPDATE";
        desc = "[inferred] ISP FPN UPDATE. Not in the data sheet. Source: OpenIPC openhisilicon `kernel/isp/arch/hi3516cv300/firmware/vreg/arch/hi3516cv300/isp_reg_define.h` (GPL-3.0 repository, HiSilicon copyright, nManager-generated 2015-12-22 \"Define all registers/tables for Hi3519\"; local copy sources/openhisilicon), union `U_ISP_FPN_UPDATE`, struct offset 0x13AEC (GPL-3.0 repository; header offsets are ISP-core relative (data sheet offset - 0x20000), 632 of 775 data-sheet registers match it by name and offset (ISP_BLC_CFG is at 0x21100 in the data sheet and 0x1000+0x20000 in the header)). Reset value and access type unknown (modelled RW, no reset). Confidence: medium (vendor header for this chip family, not hardware verified).";

        field {
            name = "update";
            desc = "[inferred] Update. (vendor header `isp_reg_define.h` field `update`; access and reset unknown, modelled RW)";
            sw = rw;
            hw = r;
        } update[0:0];
    } ISP_FPN_UPDATE @ 0x13AEC;

    reg {
        name = "FPN picture size register";
        desc = "ISP_FPN_SIZE is an FPN picture size register.

Data sheet 10.6 ISP_FPN_SIZE (offset 0x23AF0, printed page 10-179, `hi3516cv300--Hi3516CV300-Hi3516EV100-Datasheet.txt` line 50651).";

        field {
            name = "height";
            desc = "Picture height. The configured value is the actual value minus 1. For example, if the actual picture height is 1080, set this field to 1079.";
            sw = rw;
            hw = r;
            reset = 0x437;
        } height[31:16];

        field {
            name = "width";
            desc = "Picture width. The configured value is the actual value minus 1. For example, if the actual picture width is 1920, set this field to 1919.";
            sw = rw;
            hw = r;
            reset = 0x77F;
        } width[15:0];
    } ISP_FPN_SIZE @ 0x13AF0;

    reg {
        name = "DPC control register";
        desc = "ISP_DPC_CFG is a DPC control register.

Data sheet 10.6 ISP_DPC_CFG (offset 0x23C00, printed page 10-179, `hi3516cv300--Hi3516CV300-Hi3516EV100-Datasheet.txt` line 50674).";

        field {
            name = "en3";
            desc = "[inferred] En3. (bits reserved in the data sheet; vendor header `isp_reg_define.h` field `en3`; access and reset unknown, modelled RW)";
            sw = rw;
            hw = r;
        } en3[3:3];

        field {
            name = "en2";
            desc = "[inferred] En2. (bits reserved in the data sheet; vendor header `isp_reg_define.h` field `en2`; access and reset unknown, modelled RW)";
            sw = rw;
            hw = r;
        } en2[2:2];

        enum ISP_DPC_CFG_en1_enum {
            DISABLED = 0 { name = "Disabled"; desc = "disabled"; };
            ENABLED = 1 { name = "Enabled"; desc = "enabled"; };
        };

        field {
            name = "en1";
            desc = "DPC1 enable";
            sw = rw;
            hw = r;
            encode = ISP_DPC_CFG_en1_enum;
            reset = 0x0;
        } en1[1:1];

        enum ISP_DPC_CFG_en0_enum {
            DISABLED = 0 { name = "Disabled"; desc = "disabled"; };
            ENABLED = 1 { name = "Enabled"; desc = "enabled"; };
        };

        field {
            name = "en0";
            desc = "DPC0 enable";
            sw = rw;
            hw = r;
            encode = ISP_DPC_CFG_en0_enum;
            reset = 0x0;
        } en0[0:0];
    } ISP_DPC_CFG @ 0x13C00;

    reg {
        name = "DCG mode register";
        desc = "ISP_DCG_MODE is a DCG working mode select register. Hi3516C V300/Hi3516E V100 Professional HD IP Camera SoC

Data sheet 10.6 ISP_DCG_MODE (offset 0x23C04, printed page 10-180, `hi3516cv300--Hi3516CV300-Hi3516EV100-Datasheet.txt` line 50708).";

        enum ISP_DCG_MODE_mode_enum {
            ONLY_GE0_DPC0 = 0 { name = "Only Ge0 Dpc0"; desc = "Only ge0, dpc0, and cac0 can be enabled."; };
            GE0_GE1_ENABLED = 1 { name = "Ge0 Ge1 Enabled"; desc = "ge0 and ge1 are enabled and disabled together, dpc0 and dpc1 are enabled and disabled together, and cac0 and cac1 are enabled and disabled together. 10 and 11: invalid"; };
        };

        field {
            name = "mode";
            desc = "DCG working mode select";
            sw = rw;
            hw = r;
            encode = ISP_DCG_MODE_mode_enum;
            reset = 0x0;
        } mode[1:0];
    } ISP_DCG_MODE @ 0x13C04;

    reg {
        name = "DPC blending ratio register";
        desc = "ISP_DPC_ALPHA is a DPC blending ratio register.

Data sheet 10.6 ISP_DPC_ALPHA (offset 0x23C08, printed page 10-180, `hi3516cv300--Hi3516CV300-Hi3516EV100-Datasheet.txt` line 50735).";

        field {
            name = "alpha0_rb";
            desc = "Blending ratio of the R/B component 5-point median filtering result to the 9-point median filtering result";
            sw = rw;
            hw = r;
            reset = 0x0;
        } alpha0_rb[31:24];

        field {
            name = "alpha0_g";
            desc = "Blending ratio of the G component 5-point median filtering result to the 9-point median filtering result";
            sw = rw;
            hw = r;
            reset = 0x0;
        } alpha0_g[23:16];

        field {
            name = "alpha1_rb";
            desc = "Blending ratio of the R/B component input to the median filtering result";
            sw = rw;
            hw = r;
            reset = 0x0;
        } alpha1_rb[15:8];

        field {
            name = "alpha1_g";
            desc = "Blending ratio of the G component input to the median filtering result";
            sw = rw;
            hw = r;
            reset = 0x0;
        } alpha1_g[7:0];
    } ISP_DPC_ALPHA @ 0x13C08;

    reg {
        name = "ISP defect pixel correction VERSION";
        desc = "[inferred] ISP defect pixel correction VERSION. Not in the data sheet. Source: OpenIPC openhisilicon `kernel/isp/arch/hi3516cv300/firmware/vreg/arch/hi3516cv300/isp_reg_define.h` (GPL-3.0 repository, HiSilicon copyright, nManager-generated 2015-12-22 \"Define all registers/tables for Hi3519\"; local copy sources/openhisilicon), union `U_ISP_DPC_VERSION`, struct offset 0x13C0C (GPL-3.0 repository; header offsets are ISP-core relative (data sheet offset - 0x20000), 632 of 775 data-sheet registers match it by name and offset (ISP_BLC_CFG is at 0x21100 in the data sheet and 0x1000+0x20000 in the header)). Reset value and access type unknown (modelled RW, no reset). Confidence: medium (vendor header for this chip family, not hardware verified).";

        field {
            name = "version";
            desc = "[inferred] Version. (vendor header `isp_reg_define.h` field `version`; access and reset unknown, modelled RW)";
            sw = rw;
            hw = r;
        } version[31:0];
    } ISP_DPC_VERSION @ 0x13C0C;

    reg {
        name = "DPC mode register";
        desc = "ISP_DPC_MODE is a DPC mode register. Hi3516C V300/Hi3516E V100 Professional HD IP Camera SoC

Data sheet 10.6 ISP_DPC_MODE (offset 0x23C10, printed page 10-181, `hi3516cv300--Hi3516CV300-Hi3516EV100-Datasheet.txt` line 50772).";

        enum ISP_DPC_MODE_ir_channel_enum {
            DISABLED_BAYER_FORMAT = 0 { name = "Disabled Bayer Format"; desc = "disabled. The Bayer format is used."; };
            ENABLED_RGBIR_FORMAT = 1 { name = "Enabled Rgbir Format"; desc = "enabled. The RGBIR format is used."; };
        };

        field {
            name = "ir_channel";
            desc = "IR channel enable";
            sw = rw;
            hw = r;
            encode = ISP_DPC_MODE_ir_channel_enum;
            reset = 0x0;
        } ir_channel[9:9];

        enum ISP_DPC_MODE_ir_position_enum {
            IR_USES_GB = 0 { name = "Ir Uses Gb"; desc = "The IR uses the Gb channel."; };
            IR_USES_GR = 1 { name = "Ir Uses Gr"; desc = "The IR uses the Gr channel."; };
        };

        field {
            name = "ir_position";
            desc = "IR channel select";
            sw = rw;
            hw = r;
            encode = ISP_DPC_MODE_ir_position_enum;
            reset = 0x0;
        } ir_position[8:8];

        enum ISP_DPC_MODE_dp_hightlight_en_enum {
            DISABLED = 0 { name = "Disabled"; desc = "disabled"; };
            ENABLED = 1 { name = "Enabled"; desc = "enabled"; };
        };

        field {
            name = "dp_hightlight_en";
            desc = "Defect pixel highlight enable";
            sw = rw;
            hw = r;
            encode = ISP_DPC_MODE_dp_hightlight_en_enum;
            reset = 0x0;
        } dp_hightlight_en[7:7];

        enum ISP_DPC_MODE_dpt_det_sel_enum {
            BRIGHT_DOTS_DETECTED = 0 { name = "Bright Dots Detected"; desc = "The bright dots are detected."; };
            DARK_DOTS_DETECTED = 1 { name = "Dark Dots Detected"; desc = "The dark dots are detected."; };
        };

        field {
            name = "dpt_det_sel";
            desc = "Defect pixel table detection select";
            sw = rw;
            hw = r;
            encode = ISP_DPC_MODE_dpt_det_sel_enum;
            reset = 0x0;
        } dpt_det_sel[6:6];

        enum ISP_DPC_MODE_bpt_cor_en_enum {
            DISABLED = 0 { name = "Disabled"; desc = "disabled"; };
            ENABLED = 1 { name = "Enabled"; desc = "enabled"; };
        };

        field {
            name = "bpt_cor_en";
            desc = "Defect pixel table correction enable";
            sw = rw;
            hw = r;
            encode = ISP_DPC_MODE_bpt_cor_en_enum;
            reset = 0x0;
        } bpt_cor_en[5:5];

        enum ISP_DPC_MODE_grayscale_mode_enum {
            RAW_DATA = 0 { name = "Raw Data"; desc = "raw data"; };
            GRAY_SCALE_IMAGE = 1 { name = "Gray Scale Image"; desc = "gray scale image"; };
        };

        field {
            name = "grayscale_mode";
            desc = "Mode of the gray scale image";
            sw = rw;
            hw = r;
            encode = ISP_DPC_MODE_grayscale_mode_enum;
            reset = 0x0;
        } grayscale_mode[4:4];

        enum ISP_DPC_MODE_bpt_update_enum {
            DISABLED = 0 { name = "Disabled"; desc = "disabled"; };
            ENABLED = 1 { name = "Enabled"; desc = "enabled"; };
        };

        field {
            name = "bpt_update";
            desc = "Defect pixel table calibration enable";
            sw = rw;
            hw = r;
            encode = ISP_DPC_MODE_bpt_update_enum;
            reset = 0x0;
        } bpt_update[3:3];

        enum ISP_DPC_MODE_six_det_en_enum {
            DISABLED = 0 { name = "Disabled"; desc = "disabled"; };
            ENABLED = 1 { name = "Enabled"; desc = "enabled"; };
        };

        field {
            name = "six_det_en";
            desc = "Maximum/Minimum value detection, used only during defect pixel table calibration";
            sw = rw;
            hw = r;
            encode = ISP_DPC_MODE_six_det_en_enum;
            reset = 0x0;
        } six_det_en[2:2];

        enum ISP_DPC_MODE_cor_en_enum {
            DISABLED = 0 { name = "Disabled"; desc = "disabled"; };
            ENABLED = 1 { name = "Enabled"; desc = "enabled"; };
        };

        field {
            name = "cor_en";
            desc = "Dynamic correction enable";
            sw = rw;
            hw = r;
            encode = ISP_DPC_MODE_cor_en_enum;
            reset = 0x1;
        } cor_en[1:1];

        enum ISP_DPC_MODE_det_en_enum {
            DISABLED = 0 { name = "Disabled"; desc = "disabled"; };
            ENABLED = 1 { name = "Enabled"; desc = "enabled"; };
        };

        field {
            name = "det_en";
            desc = "Dynamic detection enable";
            sw = rw;
            hw = r;
            encode = ISP_DPC_MODE_det_en_enum;
            reset = 0x1;
        } det_en[0:0];
    } ISP_DPC_MODE @ 0x13C10;

    reg {
        name = "Dynamic correction mode register DE";
        desc = "ISP_DPC_OUTPUT_MODE is a dynamic correction mode register.

Data sheet 10.6 ISP_DPC_OUTPUT_MODE (offset 0x23C14, printed page 10-182, `hi3516cv300--Hi3516CV300-Hi3516EV100-Datasheet.txt` line 50839).";

        enum ISP_DPC_OUTPUT_MODE_stage1_incl_rb_3x3_enum {
            NO = 0 { name = "No"; desc = "no"; };
            YES = 1 { name = "Yes"; desc = "yes"; };
        };

        field {
            name = "stage1_incl_rb_3x3";
            desc = "Whether the R/B point correction uses the 9-point median";
            sw = rw;
            hw = r;
            encode = ISP_DPC_OUTPUT_MODE_stage1_incl_rb_3x3_enum;
            reset = 0x0;
        } stage1_incl_rb_3x3[3:3];

        enum ISP_DPC_OUTPUT_MODE_stage1_incl_g_3x3_enum {
            NO = 0 { name = "No"; desc = "no"; };
            YES = 1 { name = "Yes"; desc = "yes"; };
        };

        field {
            name = "stage1_incl_g_3x3";
            desc = "Whether the G point correction uses the 9-point median";
            sw = rw;
            hw = r;
            encode = ISP_DPC_OUTPUT_MODE_stage1_incl_g_3x3_enum;
            reset = 0x0;
        } stage1_incl_g_3x3[2:2];

        enum ISP_DPC_OUTPUT_MODE_stage1_incl_rb_center_enum {
            NO = 0 { name = "No"; desc = "no"; };
            YES = 1 { name = "Yes"; desc = "yes"; };
        };

        field {
            name = "stage1_incl_rb_center";
            desc = "Whether the R/B point correction contains the central point";
            sw = rw;
            hw = r;
            encode = ISP_DPC_OUTPUT_MODE_stage1_incl_rb_center_enum;
            reset = 0x1;
        } stage1_incl_rb_center[1:1];

        enum ISP_DPC_OUTPUT_MODE_stage1_incl_gr_center_enum {
            NO = 0 { name = "No"; desc = "no"; };
            YES = 1 { name = "Yes"; desc = "yes"; };
        };

        field {
            name = "stage1_incl_gr_center";
            desc = "Whether the G point correction contains the central point";
            sw = rw;
            hw = r;
            encode = ISP_DPC_OUTPUT_MODE_stage1_incl_gr_center_enum;
            reset = 0x1;
        } stage1_incl_gr_center[0:0];
    } ISP_DPC_OUTPUT_MODE @ 0x13C14;

    reg {
        name = "Dynamic detection level register";
        desc = "ISP_DPC_SET_USE is a dynamic detection level register.

Data sheet 10.6 ISP_DPC_SET_USE (offset 0x23C18, printed page 10-183, `hi3516cv300--Hi3516CV300-Hi3516EV100-Datasheet.txt` line 50887).";

        enum ISP_DPC_SET_USE_stage1_use_fix_set_enum {
            NO = 0 { name = "No"; desc = "no"; };
            YES = 1 { name = "Yes"; desc = "yes"; };
        };

        field {
            name = "stage1_use_fix_set";
            desc = "Whether other detection levels are valid";
            sw = rw;
            hw = r;
            encode = ISP_DPC_SET_USE_stage1_use_fix_set_enum;
            reset = 0x0;
        } stage1_use_fix_set[3:3];

        enum ISP_DPC_SET_USE_stage1_use_set3_enum {
            NO = 0 { name = "No"; desc = "no"; };
            YES = 1 { name = "Yes"; desc = "yes"; };
        };

        field {
            name = "stage1_use_set3";
            desc = "Whether detection level 3 is valid";
            sw = rw;
            hw = r;
            encode = ISP_DPC_SET_USE_stage1_use_set3_enum;
            reset = 0x0;
        } stage1_use_set3[2:2];

        enum ISP_DPC_SET_USE_stage1_use_set2_enum {
            NO = 0 { name = "No"; desc = "no"; };
            YES = 1 { name = "Yes"; desc = "yes"; };
        };

        field {
            name = "stage1_use_set2";
            desc = "Whether detection level 2 is valid";
            sw = rw;
            hw = r;
            encode = ISP_DPC_SET_USE_stage1_use_set2_enum;
            reset = 0x1;
        } stage1_use_set2[1:1];

        enum ISP_DPC_SET_USE_stage1_use_set1_enum {
            NO = 0 { name = "No"; desc = "no"; };
            YES = 1 { name = "Yes"; desc = "yes"; };
        };

        field {
            name = "stage1_use_set1";
            desc = "Whether detection level 1 is valid";
            sw = rw;
            hw = r;
            encode = ISP_DPC_SET_USE_stage1_use_set1_enum;
            reset = 0x1;
        } stage1_use_set1[0:0];
    } ISP_DPC_SET_USE @ 0x13C18;

    reg {
        name = "Detection switch register 1 T_1";
        desc = "ISP_DPC_METHODS_SET_1 is detection switch register 1. Hi3516C V300/Hi3516E V100 Professional HD IP Camera SoC

Data sheet 10.6 ISP_DPC_METHODS_SET_1 (offset 0x23C1C, printed page 10-184, `hi3516cv300--Hi3516CV300-Hi3516EV100-Datasheet.txt` line 50933).";

        enum ISP_DPC_METHODS_SET_1_rg_red_blue1_enable_enum {
            DISABLED = 0 { name = "Disabled"; desc = "disabled"; };
            ENABLED = 1 { name = "Enabled"; desc = "enabled"; };
        };

        field {
            name = "rg_red_blue1_enable";
            desc = "R/B point level 1 gradient sorting detection enable";
            sw = rw;
            hw = r;
            encode = ISP_DPC_METHODS_SET_1_rg_red_blue1_enable_enum;
            reset = 0x1;
        } rg_red_blue1_enable[12:12];

        enum ISP_DPC_METHODS_SET_1_rnd_red_blue1_enable_enum {
            DISABLED = 0 { name = "Disabled"; desc = "disabled"; };
            ENABLED = 1 { name = "Enabled"; desc = "enabled"; };
        };

        field {
            name = "rnd_red_blue1_enable";
            desc = "R/B point level 1 adjacent difference sorting detection enable";
            sw = rw;
            hw = r;
            encode = ISP_DPC_METHODS_SET_1_rnd_red_blue1_enable_enum;
            reset = 0x1;
        } rnd_red_blue1_enable[11:11];

        enum ISP_DPC_METHODS_SET_1_ro_red_blue1_enable_enum {
            DISABLED = 0 { name = "Disabled"; desc = "disabled"; };
            ENABLED = 1 { name = "Enabled"; desc = "enabled"; };
        };

        field {
            name = "ro_red_blue1_enable";
            desc = "R/B point level 1 sorting detection enable";
            sw = rw;
            hw = r;
            encode = ISP_DPC_METHODS_SET_1_ro_red_blue1_enable_enum;
            reset = 0x1;
        } ro_red_blue1_enable[10:10];

        enum ISP_DPC_METHODS_SET_1_lc_red_blue1_enable_enum {
            DISABLED = 0 { name = "Disabled"; desc = "disabled"; };
            ENABLED = 1 { name = "Enabled"; desc = "enabled"; };
        };

        field {
            name = "lc_red_blue1_enable";
            desc = "R/B point level 1 linear detection enable";
            sw = rw;
            hw = r;
            encode = ISP_DPC_METHODS_SET_1_lc_red_blue1_enable_enum;
            reset = 0x1;
        } lc_red_blue1_enable[9:9];

        enum ISP_DPC_METHODS_SET_1_pg_red_blue1_enable_enum {
            DISABLED = 0 { name = "Disabled"; desc = "disabled"; };
            ENABLED = 1 { name = "Enabled"; desc = "enabled"; };
        };

        field {
            name = "pg_red_blue1_enable";
            desc = "R/B point level 1 peak value gradient detection enable";
            sw = rw;
            hw = r;
            encode = ISP_DPC_METHODS_SET_1_pg_red_blue1_enable_enum;
            reset = 0x1;
        } pg_red_blue1_enable[8:8];

        enum ISP_DPC_METHODS_SET_1_rg_green1_enable_enum {
            DISABLED = 0 { name = "Disabled"; desc = "disabled"; };
            ENABLED = 1 { name = "Enabled"; desc = "enabled"; };
        };

        field {
            name = "rg_green1_enable";
            desc = "G point level 1 gradient sorting detection enable";
            sw = rw;
            hw = r;
            encode = ISP_DPC_METHODS_SET_1_rg_green1_enable_enum;
            reset = 0x1;
        } rg_green1_enable[4:4];

        enum ISP_DPC_METHODS_SET_1_rnd_green1_enable_enum {
            DISABLED = 0 { name = "Disabled"; desc = "disabled"; };
            ENABLED = 1 { name = "Enabled"; desc = "enabled"; };
        };

        field {
            name = "rnd_green1_enable";
            desc = "G point level 1 adjacent difference sorting detection enable";
            sw = rw;
            hw = r;
            encode = ISP_DPC_METHODS_SET_1_rnd_green1_enable_enum;
            reset = 0x1;
        } rnd_green1_enable[3:3];

        enum ISP_DPC_METHODS_SET_1_ro_green1_enable_enum {
            DISABLED = 0 { name = "Disabled"; desc = "disabled"; };
            ENABLED = 1 { name = "Enabled"; desc = "enabled"; };
        };

        field {
            name = "ro_green1_enable";
            desc = "G point level 1 sorting detection enable";
            sw = rw;
            hw = r;
            encode = ISP_DPC_METHODS_SET_1_ro_green1_enable_enum;
            reset = 0x1;
        } ro_green1_enable[2:2];

        enum ISP_DPC_METHODS_SET_1_lc_green1_enable_enum {
            DISABLED = 0 { name = "Disabled"; desc = "disabled"; };
            ENABLED = 1 { name = "Enabled"; desc = "enabled"; };
        };

        field {
            name = "lc_green1_enable";
            desc = "G point level 1 linear detection enable";
            sw = rw;
            hw = r;
            encode = ISP_DPC_METHODS_SET_1_lc_green1_enable_enum;
            reset = 0x1;
        } lc_green1_enable[1:1];

        enum ISP_DPC_METHODS_SET_1_pg_green1_enable_enum {
            DISABLED = 0 { name = "Disabled"; desc = "disabled"; };
            ENABLED = 1 { name = "Enabled"; desc = "enabled"; };
        };

        field {
            name = "pg_green1_enable";
            desc = "G point level 1 peak value gradient detection enable";
            sw = rw;
            hw = r;
            encode = ISP_DPC_METHODS_SET_1_pg_green1_enable_enum;
            reset = 0x1;
        } pg_green1_enable[0:0];
    } ISP_DPC_METHODS_SET_1 @ 0x13C1C;

    reg {
        name = "Detection switch register 2 T_2";
        desc = "ISP_DPC_METHODS_SET_2 is detection switch register 2.

Data sheet 10.6 ISP_DPC_METHODS_SET_2 (offset 0x23C20, printed page 10-185, `hi3516cv300--Hi3516CV300-Hi3516EV100-Datasheet.txt` line 51011).";

        enum ISP_DPC_METHODS_SET_2_rg_red_blue2_enable_enum {
            DISABLED = 0 { name = "Disabled"; desc = "disabled"; };
            ENABLED = 1 { name = "Enabled"; desc = "enabled"; };
        };

        field {
            name = "rg_red_blue2_enable";
            desc = "R/B point level 2 gradient sorting detection enable";
            sw = rw;
            hw = r;
            encode = ISP_DPC_METHODS_SET_2_rg_red_blue2_enable_enum;
            reset = 0x0;
        } rg_red_blue2_enable[12:12];

        enum ISP_DPC_METHODS_SET_2_rnd_red_blue2_enable_enum {
            DISABLED = 0 { name = "Disabled"; desc = "disabled"; };
            ENABLED = 1 { name = "Enabled"; desc = "enabled"; };
        };

        field {
            name = "rnd_red_blue2_enable";
            desc = "R/B point level 2 adjacent difference sorting detection enable";
            sw = rw;
            hw = r;
            encode = ISP_DPC_METHODS_SET_2_rnd_red_blue2_enable_enum;
            reset = 0x0;
        } rnd_red_blue2_enable[11:11];

        enum ISP_DPC_METHODS_SET_2_ro_red_blue2_enable_enum {
            DISABLED = 0 { name = "Disabled"; desc = "disabled"; };
            ENABLED = 1 { name = "Enabled"; desc = "enabled"; };
        };

        field {
            name = "ro_red_blue2_enable";
            desc = "R/B point level 2 sorting detection enable";
            sw = rw;
            hw = r;
            encode = ISP_DPC_METHODS_SET_2_ro_red_blue2_enable_enum;
            reset = 0x1;
        } ro_red_blue2_enable[10:10];

        enum ISP_DPC_METHODS_SET_2_lc_red_blue2_enable_enum {
            DISABLED = 0 { name = "Disabled"; desc = "disabled"; };
            ENABLED = 1 { name = "Enabled"; desc = "enabled"; };
        };

        field {
            name = "lc_red_blue2_enable";
            desc = "R/B point level 2 linear detection enable";
            sw = rw;
            hw = r;
            encode = ISP_DPC_METHODS_SET_2_lc_red_blue2_enable_enum;
            reset = 0x1;
        } lc_red_blue2_enable[9:9];

        enum ISP_DPC_METHODS_SET_2_pg_red_blue2_enable_enum {
            DISABLED = 0 { name = "Disabled"; desc = "disabled"; };
            ENABLED = 1 { name = "Enabled"; desc = "enabled"; };
        };

        field {
            name = "pg_red_blue2_enable";
            desc = "R/B point level 2 peak value gradient detection enable";
            sw = rw;
            hw = r;
            encode = ISP_DPC_METHODS_SET_2_pg_red_blue2_enable_enum;
            reset = 0x1;
        } pg_red_blue2_enable[8:8];

        enum ISP_DPC_METHODS_SET_2_rg_green2_enable_enum {
            DISABLED = 0 { name = "Disabled"; desc = "disabled"; };
            ENABLED = 1 { name = "Enabled"; desc = "enabled"; };
        };

        field {
            name = "rg_green2_enable";
            desc = "G point level 2 gradient sorting detection enable";
            sw = rw;
            hw = r;
            encode = ISP_DPC_METHODS_SET_2_rg_green2_enable_enum;
            reset = 0x0;
        } rg_green2_enable[4:4];

        enum ISP_DPC_METHODS_SET_2_rnd_green2_enable_enum {
            DISABLED = 0 { name = "Disabled"; desc = "disabled"; };
            ENABLED = 1 { name = "Enabled"; desc = "enabled"; };
        };

        field {
            name = "rnd_green2_enable";
            desc = "G point level 2 adjacent difference sorting detection enable";
            sw = rw;
            hw = r;
            encode = ISP_DPC_METHODS_SET_2_rnd_green2_enable_enum;
            reset = 0x0;
        } rnd_green2_enable[3:3];

        enum ISP_DPC_METHODS_SET_2_ro_green2_enable_enum {
            DISABLED = 0 { name = "Disabled"; desc = "disabled"; };
            ENABLED = 1 { name = "Enabled"; desc = "enabled"; };
        };

        field {
            name = "ro_green2_enable";
            desc = "G point level 2 sorting detection enable";
            sw = rw;
            hw = r;
            encode = ISP_DPC_METHODS_SET_2_ro_green2_enable_enum;
            reset = 0x1;
        } ro_green2_enable[2:2];

        enum ISP_DPC_METHODS_SET_2_lc_green2_enable_enum {
            DISABLED = 0 { name = "Disabled"; desc = "disabled"; };
            ENABLED = 1 { name = "Enabled"; desc = "enabled"; };
        };

        field {
            name = "lc_green2_enable";
            desc = "G point level 2 linear detection enable";
            sw = rw;
            hw = r;
            encode = ISP_DPC_METHODS_SET_2_lc_green2_enable_enum;
            reset = 0x1;
        } lc_green2_enable[1:1];

        enum ISP_DPC_METHODS_SET_2_pg_green2_enable_enum {
            DISABLED = 0 { name = "Disabled"; desc = "disabled"; };
            ENABLED = 1 { name = "Enabled"; desc = "enabled"; };
        };

        field {
            name = "pg_green2_enable";
            desc = "G point level 2 peak value gradient detection enable";
            sw = rw;
            hw = r;
            encode = ISP_DPC_METHODS_SET_2_pg_green2_enable_enum;
            reset = 0x1;
        } pg_green2_enable[0:0];
    } ISP_DPC_METHODS_SET_2 @ 0x13C20;

    reg {
        name = "Detection switch register 3 T_3";
        desc = "ISP_DPC_METHODS_SET_3 is detection switch register 3. Hi3516C V300/Hi3516E V100 Professional HD IP Camera SoC

Data sheet 10.6 ISP_DPC_METHODS_SET_3 (offset 0x23C24, printed page 10-187, `hi3516cv300--Hi3516CV300-Hi3516EV100-Datasheet.txt` line 51098).";

        enum ISP_DPC_METHODS_SET_3_rg_red_blue3_enable_enum {
            DISABLED = 0 { name = "Disabled"; desc = "disabled"; };
            ENABLED = 1 { name = "Enabled"; desc = "enabled"; };
        };

        field {
            name = "rg_red_blue3_enable";
            desc = "R/B point level 3 gradient sorting detection enable";
            sw = rw;
            hw = r;
            encode = ISP_DPC_METHODS_SET_3_rg_red_blue3_enable_enum;
            reset = 0x1;
        } rg_red_blue3_enable[12:12];

        enum ISP_DPC_METHODS_SET_3_rnd_red_blue3_enable_enum {
            DISABLED = 0 { name = "Disabled"; desc = "disabled"; };
            ENABLED = 1 { name = "Enabled"; desc = "enabled"; };
        };

        field {
            name = "rnd_red_blue3_enable";
            desc = "R/B point level 3 adjacent difference sorting detection enable";
            sw = rw;
            hw = r;
            encode = ISP_DPC_METHODS_SET_3_rnd_red_blue3_enable_enum;
            reset = 0x1;
        } rnd_red_blue3_enable[11:11];

        enum ISP_DPC_METHODS_SET_3_ro_red_blue3_enable_enum {
            DISABLED = 0 { name = "Disabled"; desc = "disabled"; };
            ENABLED = 1 { name = "Enabled"; desc = "enabled"; };
        };

        field {
            name = "ro_red_blue3_enable";
            desc = "R/B point level 3 sorting detection enable";
            sw = rw;
            hw = r;
            encode = ISP_DPC_METHODS_SET_3_ro_red_blue3_enable_enum;
            reset = 0x1;
        } ro_red_blue3_enable[10:10];

        enum ISP_DPC_METHODS_SET_3_lc_red_blue3_enable_enum {
            DISABLED = 0 { name = "Disabled"; desc = "disabled"; };
            ENABLED = 1 { name = "Enabled"; desc = "enabled"; };
        };

        field {
            name = "lc_red_blue3_enable";
            desc = "R/B point level 3 linear detection enable";
            sw = rw;
            hw = r;
            encode = ISP_DPC_METHODS_SET_3_lc_red_blue3_enable_enum;
            reset = 0x1;
        } lc_red_blue3_enable[9:9];

        enum ISP_DPC_METHODS_SET_3_pg_red_blue3_enable_enum {
            DISABLED = 0 { name = "Disabled"; desc = "disabled"; };
            ENABLED = 1 { name = "Enabled"; desc = "enabled"; };
        };

        field {
            name = "pg_red_blue3_enable";
            desc = "R/B point level 3 peak value gradient detection enable";
            sw = rw;
            hw = r;
            encode = ISP_DPC_METHODS_SET_3_pg_red_blue3_enable_enum;
            reset = 0x1;
        } pg_red_blue3_enable[8:8];

        enum ISP_DPC_METHODS_SET_3_rg_green3_enable_enum {
            DISABLED = 0 { name = "Disabled"; desc = "disabled"; };
            ENABLED = 1 { name = "Enabled"; desc = "enabled"; };
        };

        field {
            name = "rg_green3_enable";
            desc = "G point level 3 gradient sorting detection enable";
            sw = rw;
            hw = r;
            encode = ISP_DPC_METHODS_SET_3_rg_green3_enable_enum;
            reset = 0x1;
        } rg_green3_enable[4:4];

        enum ISP_DPC_METHODS_SET_3_rnd_green3_enable_enum {
            DISABLED = 0 { name = "Disabled"; desc = "disabled"; };
            ENABLED = 1 { name = "Enabled"; desc = "enabled"; };
        };

        field {
            name = "rnd_green3_enable";
            desc = "G point level 3 adjacent difference sorting detection enable";
            sw = rw;
            hw = r;
            encode = ISP_DPC_METHODS_SET_3_rnd_green3_enable_enum;
            reset = 0x1;
        } rnd_green3_enable[3:3];

        enum ISP_DPC_METHODS_SET_3_ro_green3_enable_enum {
            DISABLED = 0 { name = "Disabled"; desc = "disabled"; };
            ENABLED = 1 { name = "Enabled"; desc = "enabled"; };
        };

        field {
            name = "ro_green3_enable";
            desc = "G point level 3 sorting detection enable";
            sw = rw;
            hw = r;
            encode = ISP_DPC_METHODS_SET_3_ro_green3_enable_enum;
            reset = 0x1;
        } ro_green3_enable[2:2];

        enum ISP_DPC_METHODS_SET_3_lc_green3_enable_enum {
            DISABLED = 0 { name = "Disabled"; desc = "disabled"; };
            ENABLED = 1 { name = "Enabled"; desc = "enabled"; };
        };

        field {
            name = "lc_green3_enable";
            desc = "G point level 3 linear detection enable";
            sw = rw;
            hw = r;
            encode = ISP_DPC_METHODS_SET_3_lc_green3_enable_enum;
            reset = 0x1;
        } lc_green3_enable[1:1];

        enum ISP_DPC_METHODS_SET_3_pg_green3_enable_enum {
            DISABLED = 0 { name = "Disabled"; desc = "disabled"; };
            ENABLED = 1 { name = "Enabled"; desc = "enabled"; };
        };

        field {
            name = "pg_green3_enable";
            desc = "G point level 3 peak value gradient detection enable";
            sw = rw;
            hw = r;
            encode = ISP_DPC_METHODS_SET_3_pg_green3_enable_enum;
            reset = 0x1;
        } pg_green3_enable[0:0];
    } ISP_DPC_METHODS_SET_3 @ 0x13C24;

    reg {
        name = "Linear detection parameter 1 register _1";
        desc = "ISP_DPC_LINE_THRESH_1 is a linear detection parameter 1 register.

Data sheet 10.6 ISP_DPC_LINE_THRESH_1 (offset 0x23C28, printed page 10-188, `hi3516cv300--Hi3516CV300-Hi3516EV100-Datasheet.txt` line 51176).";

        field {
            name = "line_thr1_rb";
            desc = "R/B point detection parameter";
            sw = rw;
            hw = r;
            reset = 0x8;
        } line_thr1_rb[15:8];

        field {
            name = "line_thr1_g";
            desc = "G point detection parameter";
            sw = rw;
            hw = r;
            reset = 0x8;
        } line_thr1_g[7:0];
    } ISP_DPC_LINE_THRESH_1 @ 0x13C28;

    reg {
        name = "Linear detection parameter 1 register AC_1";
        desc = "ISP_DPC_LINE_MAD_FAC_1 is a linear detection parameter 1 register. Hi3516C V300/Hi3516E V100 Professional HD IP Camera SoC

Data sheet 10.6 ISP_DPC_LINE_MAD_FAC_1 (offset 0x23C2C, printed page 10-189, `hi3516cv300--Hi3516CV300-Hi3516EV100-Datasheet.txt` line 51206).";

        field {
            name = "line_mad_fac_1_rb";
            desc = "R/B point detection parameter";
            sw = rw;
            hw = r;
            reset = 0x1B;
        } line_mad_fac_1_rb[13:8];

        field {
            name = "line_mad_fac_1_g";
            desc = "G point detection parameter";
            sw = rw;
            hw = r;
            reset = 0x1B;
        } line_mad_fac_1_g[5:0];
    } ISP_DPC_LINE_MAD_FAC_1 @ 0x13C2C;

    reg {
        name = "Peak gradient parameter 1 register";
        desc = "ISP_DPC_PG_FAC_1 is a peak gradient parameter 1 register.

Data sheet 10.6 ISP_DPC_PG_FAC_1 (offset 0x23C30, printed page 10-189, `hi3516cv300--Hi3516CV300-Hi3516EV100-Datasheet.txt` line 51231).";

        field {
            name = "pg_fac_1_rb";
            desc = "R/B point detection parameter";
            sw = rw;
            hw = r;
            reset = 0x8;
        } pg_fac_1_rb[13:8];

        field {
            name = "pg_fac_1_g";
            desc = "G point detection parameter";
            sw = rw;
            hw = r;
            reset = 0x8;
        } pg_fac_1_g[5:0];
    } ISP_DPC_PG_FAC_1 @ 0x13C30;

    reg {
        name = "Adjacent difference value sorting _1 parameter 1 register";
        desc = "ISP_DPC_RND_THRESH_1 is an adjacent difference value sorting parameter 1 register. Hi3516C V300/Hi3516E V100 Professional HD IP Camera SoC

Data sheet 10.6 ISP_DPC_RND_THRESH_1 (offset 0x23C34, printed page 10-190, `hi3516cv300--Hi3516CV300-Hi3516EV100-Datasheet.txt` line 51266).";

        field {
            name = "rnd_thr1_rb";
            desc = "R/B point detection parameter";
            sw = rw;
            hw = r;
            reset = 0xA;
        } rnd_thr1_rb[15:8];

        field {
            name = "rnd_thr1_g";
            desc = "G point detection parameter";
            sw = rw;
            hw = r;
            reset = 0xA;
        } rnd_thr1_g[7:0];
    } ISP_DPC_RND_THRESH_1 @ 0x13C34;

    reg {
        name = "Gradient sorting parameter 1 register";
        desc = "ISP_DPC_RG_FAC_1 is a gradient sorting parameter 1 register.

Data sheet 10.6 ISP_DPC_RG_FAC_1 (offset 0x23C38, printed page 10-190, `hi3516cv300--Hi3516CV300-Hi3516EV100-Datasheet.txt` line 51287).";

        field {
            name = "rg_fac_1_rb";
            desc = "R/B point detection parameter";
            sw = rw;
            hw = r;
            reset = 0x26;
        } rg_fac_1_rb[13:8];

        field {
            name = "rg_fac_1_g";
            desc = "G point detection parameter";
            sw = rw;
            hw = r;
            reset = 0x26;
        } rg_fac_1_g[5:0];
    } ISP_DPC_RG_FAC_1 @ 0x13C38;

    reg {
        name = "Linear detection parameter 2 register _2";
        desc = "ISP_DPC_LINE_THRESH_2 is a linear detection parameter 2 register. Hi3516C V300/Hi3516E V100 Professional HD IP Camera SoC

Data sheet 10.6 ISP_DPC_LINE_THRESH_2 (offset 0x23C3C, printed page 10-191, `hi3516cv300--Hi3516CV300-Hi3516EV100-Datasheet.txt` line 51321).";

        field {
            name = "line_thr2_rb";
            desc = "R/B point detection parameter";
            sw = rw;
            hw = r;
            reset = 0x21;
        } line_thr2_rb[15:8];

        field {
            name = "line_thr2_g";
            desc = "G point detection parameter";
            sw = rw;
            hw = r;
            reset = 0x21;
        } line_thr2_g[7:0];
    } ISP_DPC_LINE_THRESH_2 @ 0x13C3C;

    reg {
        name = "Linear detection parameter 2 register AC_2";
        desc = "ISP_DPC_LINE_MAD_FAC_2 is a linear detection parameter 2 register.

Data sheet 10.6 ISP_DPC_LINE_MAD_FAC_2 (offset 0x23C40, printed page 10-191, `hi3516cv300--Hi3516CV300-Hi3516EV100-Datasheet.txt` line 51342).";

        field {
            name = "line_mad_fac_2_rb";
            desc = "R/B point detection parameter";
            sw = rw;
            hw = r;
            reset = 0x18;
        } line_mad_fac_2_rb[13:8];

        field {
            name = "line_mad_fac_2_g";
            desc = "G point detection parameter";
            sw = rw;
            hw = r;
            reset = 0x10;
        } line_mad_fac_2_g[5:0];
    } ISP_DPC_LINE_MAD_FAC_2 @ 0x13C40;

    reg {
        name = "Peak gradient parameter 2 register";
        desc = "ISP_DPC_PG_FAC_2 is a peak gradient parameter 2 register. Hi3516C V300/Hi3516E V100 Professional HD IP Camera SoC

Data sheet 10.6 ISP_DPC_PG_FAC_2 (offset 0x23C44, printed page 10-192, `hi3516cv300--Hi3516CV300-Hi3516EV100-Datasheet.txt` line 51376).";

        field {
            name = "pg_fac_2_rb";
            desc = "R/B point detection parameter";
            sw = rw;
            hw = r;
            reset = 0xB;
        } pg_fac_2_rb[13:8];

        field {
            name = "pg_fac_2_g";
            desc = "G point detection parameter";
            sw = rw;
            hw = r;
            reset = 0xB;
        } pg_fac_2_g[5:0];
    } ISP_DPC_PG_FAC_2 @ 0x13C44;

    reg {
        name = "Adjacent difference value sorting _2 parameter 2 register";
        desc = "ISP_DPC_RND_THRESH_2 is an adjacent difference value sorting parameter 2 register.

Data sheet 10.6 ISP_DPC_RND_THRESH_2 (offset 0x23C48, printed page 10-192, `hi3516cv300--Hi3516CV300-Hi3516EV100-Datasheet.txt` line 51401).";

        field {
            name = "rnd_thr2_rb";
            desc = "R/B point detection parameter";
            sw = rw;
            hw = r;
            reset = 0x8;
        } rnd_thr2_rb[15:8];

        field {
            name = "rnd_thr2_g";
            desc = "G point detection parameter";
            sw = rw;
            hw = r;
            reset = 0x8;
        } rnd_thr2_g[7:0];
    } ISP_DPC_RND_THRESH_2 @ 0x13C48;

    reg {
        name = "Gradient sorting parameter 2 register";
        desc = "ISP_DPC_RG_FAC_2 is a gradient sorting parameter 2 register. Hi3516C V300/Hi3516E V100 Professional HD IP Camera SoC

Data sheet 10.6 ISP_DPC_RG_FAC_2 (offset 0x23C4C, printed page 10-193, `hi3516cv300--Hi3516CV300-Hi3516EV100-Datasheet.txt` line 51430).";

        field {
            name = "rg_fac_2_rb";
            desc = "R/B point detection parameter";
            sw = rw;
            hw = r;
            reset = 0x8;
        } rg_fac_2_rb[13:8];

        field {
            name = "rg_fac_2_g";
            desc = "G point detection parameter";
            sw = rw;
            hw = r;
            reset = 0x8;
        } rg_fac_2_g[5:0];
    } ISP_DPC_RG_FAC_2 @ 0x13C4C;

    reg {
        name = "Linear detection parameter 3 register _3";
        desc = "ISP_DPC_LINE_THRESH_3 is a linear detection parameter 3 register.

Data sheet 10.6 ISP_DPC_LINE_THRESH_3 (offset 0x23C50, printed page 10-193, `hi3516cv300--Hi3516CV300-Hi3516EV100-Datasheet.txt` line 51455).";

        field {
            name = "line_thr3_rb";
            desc = "R/B point detection parameter";
            sw = rw;
            hw = r;
            reset = 0x20;
        } line_thr3_rb[15:8];

        field {
            name = "line_thr3_g";
            desc = "G point detection parameter";
            sw = rw;
            hw = r;
            reset = 0x20;
        } line_thr3_g[7:0];
    } ISP_DPC_LINE_THRESH_3 @ 0x13C50;

    reg {
        name = "Linear detection parameter 3 register AC_3";
        desc = "ISP_DPC_LINE_MAD_FAC_3 is a linear detection parameter 3 register. Hi3516C V300/Hi3516E V100 Professional HD IP Camera SoC

Data sheet 10.6 ISP_DPC_LINE_MAD_FAC_3 (offset 0x23C54, printed page 10-194, `hi3516cv300--Hi3516CV300-Hi3516EV100-Datasheet.txt` line 51484).";

        field {
            name = "line_mad_fac_3_rb";
            desc = "R/B point detection parameter";
            sw = rw;
            hw = r;
            reset = 0x4;
        } line_mad_fac_3_rb[13:8];

        field {
            name = "line_mad_fac_3_g";
            desc = "G point detection parameter";
            sw = rw;
            hw = r;
            reset = 0x4;
        } line_mad_fac_3_g[5:0];
    } ISP_DPC_LINE_MAD_FAC_3 @ 0x13C54;

    reg {
        name = "Peak gradient parameter 3 register";
        desc = "ISP_DPC_PG_FAC_3 is a peak gradient parameter 3 register.

Data sheet 10.6 ISP_DPC_PG_FAC_3 (offset 0x23C58, printed page 10-194, `hi3516cv300--Hi3516CV300-Hi3516EV100-Datasheet.txt` line 51509).";

        field {
            name = "pg_fac_3_rb";
            desc = "R/B point detection parameter";
            sw = rw;
            hw = r;
            reset = 0xA;
        } pg_fac_3_rb[13:8];

        field {
            name = "pg_fac_3_g";
            desc = "G point detection parameter";
            sw = rw;
            hw = r;
            reset = 0xA;
        } pg_fac_3_g[5:0];
    } ISP_DPC_PG_FAC_3 @ 0x13C58;

    reg {
        name = "Adjacent difference value sorting _3 parameter 3 register";
        desc = "ISP_DPC_RND_THRESH_3 is an adjacent difference value sorting parameter 3 register. Hi3516C V300/Hi3516E V100 Professional HD IP Camera SoC

Data sheet 10.6 ISP_DPC_RND_THRESH_3 (offset 0x23C5C, printed page 10-195, `hi3516cv300--Hi3516CV300-Hi3516EV100-Datasheet.txt` line 51544).";

        field {
            name = "rnd_thr3_rb";
            desc = "R/B point detection parameter";
            sw = rw;
            hw = r;
            reset = 0x8;
        } rnd_thr3_rb[15:8];

        field {
            name = "rnd_thr3_g";
            desc = "G point detection parameter";
            sw = rw;
            hw = r;
            reset = 0x6;
        } rnd_thr3_g[7:0];
    } ISP_DPC_RND_THRESH_3 @ 0x13C5C;

    reg {
        name = "Gradient sorting parameter 3 register";
        desc = "ISP_DPC_RG_FAC_3 is a gradient sorting parameter 3 register.

Data sheet 10.6 ISP_DPC_RG_FAC_3 (offset 0x23C60, printed page 10-195, `hi3516cv300--Hi3516CV300-Hi3516EV100-Datasheet.txt` line 51565).";

        field {
            name = "rg_fac_3_rb";
            desc = "R/B point detection parameter";
            sw = rw;
            hw = r;
            reset = 0x4;
        } rg_fac_3_rb[13:8];

        field {
            name = "rg_fac_3_g";
            desc = "G point detection parameter";
            sw = rw;
            hw = r;
            reset = 0x4;
        } rg_fac_3_g[5:0];
    } ISP_DPC_RG_FAC_3 @ 0x13C60;

    reg {
        name = "Sorting parameter 3 register";
        desc = "ISP_DPC_RO_LIMITS is a sorting parameter 3 register. Hi3516C V300/Hi3516E V100 Professional HD IP Camera SoC

Data sheet 10.6 ISP_DPC_RO_LIMITS (offset 0x23C64, printed page 10-196, `hi3516cv300--Hi3516CV300-Hi3516EV100-Datasheet.txt` line 51599).";

        field {
            name = "ro_3_rb";
            desc = "R/B point detection parameter";
            sw = rw;
            hw = r;
            reset = 0x2;
        } ro_3_rb[11:10];

        field {
            name = "ro_3_g";
            desc = "G point detection parameter";
            sw = rw;
            hw = r;
            reset = 0x1;
        } ro_3_g[9:8];

        field {
            name = "ro_2_rb";
            desc = "R/B point detection parameter";
            sw = rw;
            hw = r;
            reset = 0x2;
        } ro_2_rb[7:6];

        field {
            name = "ro_2_g";
            desc = "G point detection parameter";
            sw = rw;
            hw = r;
            reset = 0x2;
        } ro_2_g[5:4];

        field {
            name = "ro_1_rb";
            desc = "R/B point detection parameter";
            sw = rw;
            hw = r;
            reset = 0x1;
        } ro_1_rb[3:2];

        field {
            name = "ro_1_g";
            desc = "G point detection parameter";
            sw = rw;
            hw = r;
            reset = 0x1;
        } ro_1_g[1:0];
    } ISP_DPC_RO_LIMITS @ 0x13C64;

    reg {
        name = "Adjacent difference value sorting parameter 3 register";
        desc = "ISP_DPC_RND_OFFS is an adjacent difference value sorting parameter 3 register.

Data sheet 10.6 ISP_DPC_RND_OFFS (offset 0x23C68, printed page 10-196, `hi3516cv300--Hi3516CV300-Hi3516EV100-Datasheet.txt` line 51626).";

        field {
            name = "rnd_offs_3_rb";
            desc = "R/B point detection parameter";
            sw = rw;
            hw = r;
            reset = 0x2;
        } rnd_offs_3_rb[11:10];

        field {
            name = "rnd_offs_3_g";
            desc = "G point detection parameter";
            sw = rw;
            hw = r;
            reset = 0x2;
        } rnd_offs_3_g[9:8];

        field {
            name = "rnd_offs_2_rb";
            desc = "R/B point detection parameter";
            sw = rw;
            hw = r;
            reset = 0x2;
        } rnd_offs_2_rb[7:6];

        field {
            name = "rnd_offs_2_g";
            desc = "G point detection parameter";
            sw = rw;
            hw = r;
            reset = 0x2;
        } rnd_offs_2_g[5:4];

        field {
            name = "rnd_offs_1_rb";
            desc = "R/B point detection parameter";
            sw = rw;
            hw = r;
            reset = 0x2;
        } rnd_offs_1_rb[3:2];

        field {
            name = "rnd_offs_1_g";
            desc = "G point detection parameter";
            sw = rw;
            hw = r;
            reset = 0x2;
        } rnd_offs_1_g[1:0];
    } ISP_DPC_RND_OFFS @ 0x13C68;

    reg {
        name = "Defect pixel table control register";
        desc = "ISP_DPC_BPT_CTRL is a defect pixel table control register.

Data sheet 10.6 ISP_DPC_BPT_CTRL (offset 0x23C6C, printed page 10-197, `hi3516cv300--Hi3516CV300-Hi3516EV100-Datasheet.txt` line 51667).";

        field {
            name = "bp_data";
            desc = "Defect pixel highlight value";
            sw = rw;
            hw = r;
            reset = 0x0;
        } bp_data[31:16];

        enum ISP_DPC_BPT_CTRL_rb_3x3_enum {
            NO = 0 { name = "No"; desc = "no"; };
            YES = 1 { name = "Yes"; desc = "yes"; };
        };

        field {
            name = "rb_3x3";
            desc = "Whether the R/B point correction uses the 9-point median";
            sw = rw;
            hw = r;
            encode = ISP_DPC_BPT_CTRL_rb_3x3_enum;
            reset = 0x0;
        } rb_3x3[11:11];

        enum ISP_DPC_BPT_CTRL_g_3x3_enum {
            NO = 0 { name = "No"; desc = "no"; };
            YES = 1 { name = "Yes"; desc = "yes"; };
        };

        field {
            name = "g_3x3";
            desc = "Whether the G point correction uses the 9-point median";
            sw = rw;
            hw = r;
            encode = ISP_DPC_BPT_CTRL_g_3x3_enum;
            reset = 0x0;
        } g_3x3[10:10];

        enum ISP_DPC_BPT_CTRL_bpt_incl_rb_center_enum {
            NO = 0 { name = "No"; desc = "no"; };
            YES = 1 { name = "Yes"; desc = "yes"; };
        };

        field {
            name = "bpt_incl_rb_center";
            desc = "Whether the R/B point correction contains the central point";
            sw = rw;
            hw = r;
            encode = ISP_DPC_BPT_CTRL_bpt_incl_rb_center_enum;
            reset = 0x0;
        } bpt_incl_rb_center[9:9];

        enum ISP_DPC_BPT_CTRL_bpt_incl_green_center_enum {
            NO = 0 { name = "No"; desc = "no"; };
            YES = 1 { name = "Yes"; desc = "yes"; };
        };

        field {
            name = "bpt_incl_green_center";
            desc = "Whether the G point correction contains the central point";
            sw = rw;
            hw = r;
            encode = ISP_DPC_BPT_CTRL_bpt_incl_green_center_enum;
            reset = 0x0;
        } bpt_incl_green_center[8:8];

        enum ISP_DPC_BPT_CTRL_bpt_use_fix_set_enum {
            NO = 0 { name = "No"; desc = "no"; };
            YES = 1 { name = "Yes"; desc = "yes"; };
        };

        field {
            name = "bpt_use_fix_set";
            desc = "Whether other detection levels are valid";
            sw = rw;
            hw = r;
            encode = ISP_DPC_BPT_CTRL_bpt_use_fix_set_enum;
            reset = 0x0;
        } bpt_use_fix_set[7:7];

        enum ISP_DPC_BPT_CTRL_bpt_use_set_3_enum {
            NO = 0 { name = "No"; desc = "no"; };
            YES = 1 { name = "Yes"; desc = "yes"; };
        };

        field {
            name = "bpt_use_set_3";
            desc = "Whether detection level 3 is valid";
            sw = rw;
            hw = r;
            encode = ISP_DPC_BPT_CTRL_bpt_use_set_3_enum;
            reset = 0x0;
        } bpt_use_set_3[6:6];

        enum ISP_DPC_BPT_CTRL_bpt_use_set_2_enum {
            NO = 0 { name = "No"; desc = "no"; };
            YES = 1 { name = "Yes"; desc = "yes"; };
        };

        field {
            name = "bpt_use_set_2";
            desc = "Whether detection level 2 is valid";
            sw = rw;
            hw = r;
            encode = ISP_DPC_BPT_CTRL_bpt_use_set_2_enum;
            reset = 0x0;
        } bpt_use_set_2[5:5];

        enum ISP_DPC_BPT_CTRL_bpt_use_set_1_enum {
            NO = 0 { name = "No"; desc = "no"; };
            YES = 1 { name = "Yes"; desc = "yes"; };
        };

        field {
            name = "bpt_use_set_1";
            desc = "Whether detection level 1 is valid";
            sw = rw;
            hw = r;
            encode = ISP_DPC_BPT_CTRL_bpt_use_set_1_enum;
            reset = 0x0;
        } bpt_use_set_1[4:4];
    } ISP_DPC_BPT_CTRL @ 0x13C6C;

    reg {
        name = "Defect pixel number register";
        desc = "ISP_DPC_BPT_NUMBER is a defect pixel number register.

Data sheet 10.6 ISP_DPC_BPT_NUMBER (offset 0x23C70, printed page 10-198, `hi3516cv300--Hi3516CV300-Hi3516EV100-Datasheet.txt` line 51730).";

        field {
            name = "bpt_number";
            desc = "Number of defect pixels. The value range is 0-2048.";
            sw = rw;
            hw = r;
            reset = 0x0;
        } bpt_number[11:0];
    } ISP_DPC_BPT_NUMBER @ 0x13C70;

    reg {
        name = "Calibrated defect pixel number UMBER register";
        desc = "ISP_DPC_BPT_CALIB_NUMBER is a calibrated defect pixel number register.

Data sheet 10.6 ISP_DPC_BPT_CALIB_NUMBER (offset 0x23C74, printed page 10-198, `hi3516cv300--Hi3516CV300-Hi3516EV100-Datasheet.txt` line 51750).";

        field {
            name = "bpt_calib_number";
            desc = "Number of calibrated defect pixels. The value range is 0-2048.";
            sw = r;
            hw = w;
            reset = 0x0;
        } bpt_calib_number[11:0];
    } ISP_DPC_BPT_CALIB_NUMBER @ 0x13C74;

    reg {
        name = "ISP defect pixel correction RESERVED";
        desc = "[inferred] ISP defect pixel correction RESERVED. Not in the data sheet. Source: OpenIPC openhisilicon `kernel/isp/arch/hi3516cv300/firmware/vreg/arch/hi3516cv300/isp_reg_define.h` (GPL-3.0 repository, HiSilicon copyright, nManager-generated 2015-12-22 \"Define all registers/tables for Hi3519\"; local copy sources/openhisilicon), union `U_ISP_DPC_RESERVED`, struct offset 0x13C78 (GPL-3.0 repository; header offsets are ISP-core relative (data sheet offset - 0x20000), 632 of 775 data-sheet registers match it by name and offset (ISP_BLC_CFG is at 0x21100 in the data sheet and 0x1000+0x20000 in the header)). Reset value and access type unknown (modelled RW, no reset). Confidence: medium (vendor header for this chip family, not hardware verified).";

        field {
            name = "value";
            desc = "[inferred] Register value (the header union has no named bits).";
            sw = rw;
            hw = r;
        } value[31:0];
    } ISP_DPC_RESERVED @ 0x13C78;

    reg {
        name = "Calibrated defect pixel parameter register";
        desc = "ISP_DPC_BPT_THRD is a calibrated defect pixel parameter register.

Data sheet 10.6 ISP_DPC_BPT_THRD (offset 0x23C7C, printed page 10-199, `hi3516cv300--Hi3516CV300-Hi3516EV100-Datasheet.txt` line 51774).";

        field {
            name = "abs_hot_thresh";
            desc = "abs_hot_thresh";
            sw = rw;
            hw = r;
            reset = 0x0;
        } abs_hot_thresh[31:24];

        field {
            name = "dev_hot_thresh";
            desc = "dev_hot_thresh";
            sw = rw;
            hw = r;
            reset = 0x0;
        } dev_hot_thresh[23:16];

        field {
            name = "abs_dead_thresh";
            desc = "abs_dead_thresh";
            sw = rw;
            hw = r;
            reset = 0x0;
        } abs_dead_thresh[15:8];

        field {
            name = "dev_dead_thresh";
            desc = "dev_dead_thresh";
            sw = rw;
            hw = r;
            reset = 0x0;
        } dev_dead_thresh[7:0];
    } ISP_DPC_BPT_THRD @ 0x13C7C;

    reg {
        name = "Defect pixel table write address register";
        desc = "ISP_DPC_BPT_WADDR is a defect pixel table write address register.

Data sheet 10.6 ISP_DPC_BPT_WADDR (offset 0x23C80, printed page 10-199, `hi3516cv300--Hi3516CV300-Hi3516EV100-Datasheet.txt` line 51812).";

        field {
            name = "bpt_waddr";
            desc = "Write address of the defect pixel table (bit [10:0])";
            sw = rw;
            hw = r;
            reset = 0x0;
        } bpt_waddr[31:0];
    } ISP_DPC_BPT_WADDR @ 0x13C80;

    reg {
        name = "Defect pixel table write data register";
        desc = "ISP_DPC_BPT_WDATA is a defect pixel table write data register.

Data sheet 10.6 ISP_DPC_BPT_WDATA (offset 0x23C84, printed page 10-200, `hi3516cv300--Hi3516CV300-Hi3516EV100-Datasheet.txt` line 51837).";

        field {
            name = "bpt_wdata";
            desc = "Write data of the defect pixel table. Bit [24:0] indicate the defect pixel coordinate.";
            sw = rw;
            hw = r;
            reset = 0x0;
        } bpt_wdata[31:0];
    } ISP_DPC_BPT_WDATA @ 0x13C84;

    reg {
        name = "Defect pixel table read address register";
        desc = "ISP_DPC_BPT_RADDR is a defect pixel table read address register.

Data sheet 10.6 ISP_DPC_BPT_RADDR (offset 0x23C88, printed page 10-200, `hi3516cv300--Hi3516CV300-Hi3516EV100-Datasheet.txt` line 51858).";

        field {
            name = "bpt_raddr";
            desc = "Read address of the defect pixel table (bit [10:0])";
            sw = rw;
            hw = r;
            reset = 0x0;
        } bpt_raddr[31:0];
    } ISP_DPC_BPT_RADDR @ 0x13C88;

    reg {
        name = "Defect pixel table read data register";
        desc = "ISP_DPC_BPT_RDATA is a defect pixel table read data register.

Data sheet 10.6 ISP_DPC_BPT_RDATA (offset 0x23C8C, printed page 10-200, `hi3516cv300--Hi3516CV300-Hi3516EV100-Datasheet.txt` line 51877).";

        field {
            name = "bpt_rdata";
            desc = "Read data of the defect pixel table. Bit [24:0] indicate the defect pixel coordinate.";
            sw = rw;
            hw = r;
            reset = 0x0;
        } bpt_rdata[31:0];
    } ISP_DPC_BPT_RDATA @ 0x13C8C;

    reg {
        name = "ISP defect pixel correction control F";
        desc = "[inferred] ISP defect pixel correction control F. Not in the data sheet. Source: OpenIPC openhisilicon `kernel/isp/arch/hi3516cv300/firmware/vreg/arch/hi3516cv300/isp_reg_define.h` (GPL-3.0 repository, HiSilicon copyright, nManager-generated 2015-12-22 \"Define all registers/tables for Hi3519\"; local copy sources/openhisilicon), union `U_ISP_DPC_CTRL_F`, struct offset 0x13CE0 (GPL-3.0 repository; header offsets are ISP-core relative (data sheet offset - 0x20000), 632 of 775 data-sheet registers match it by name and offset (ISP_BLC_CFG is at 0x21100 in the data sheet and 0x1000+0x20000 in the header)). Reset value and access type unknown (modelled RW, no reset). Confidence: medium (vendor header for this chip family, not hardware verified).";

        field {
            name = "rggb_cfg";
            desc = "[inferred] Rggb configuration. (vendor header `isp_reg_define.h` field `rggb_cfg`; access and reset unknown, modelled RW)";
            sw = rw;
            hw = r;
        } rggb_cfg[1:0];
    } ISP_DPC_CTRL_F @ 0x13CE0;

    reg {
        name = "ISP defect pixel correction control I";
        desc = "[inferred] ISP defect pixel correction control I. Not in the data sheet. Source: OpenIPC openhisilicon `kernel/isp/arch/hi3516cv300/firmware/vreg/arch/hi3516cv300/isp_reg_define.h` (GPL-3.0 repository, HiSilicon copyright, nManager-generated 2015-12-22 \"Define all registers/tables for Hi3519\"; local copy sources/openhisilicon), union `U_ISP_DPC_CTRL_I`, struct offset 0x13CE4 (GPL-3.0 repository; header offsets are ISP-core relative (data sheet offset - 0x20000), 632 of 775 data-sheet registers match it by name and offset (ISP_BLC_CFG is at 0x21100 in the data sheet and 0x1000+0x20000 in the header)). Reset value and access type unknown (modelled RW, no reset). Confidence: medium (vendor header for this chip family, not hardware verified).";

        field {
            name = "update_mode";
            desc = "[inferred] Update mode. (vendor header `isp_reg_define.h` field `update_mode`; access and reset unknown, modelled RW)";
            sw = rw;
            hw = r;
        } update_mode[0:0];
    } ISP_DPC_CTRL_I @ 0x13CE4;

    reg {
        name = "ISP defect pixel correction TIMING";
        desc = "[inferred] ISP defect pixel correction TIMING. Not in the data sheet. Source: OpenIPC openhisilicon `kernel/isp/arch/hi3516cv300/firmware/vreg/arch/hi3516cv300/isp_reg_define.h` (GPL-3.0 repository, HiSilicon copyright, nManager-generated 2015-12-22 \"Define all registers/tables for Hi3519\"; local copy sources/openhisilicon), union `U_ISP_DPC_TIMING`, struct offset 0x13CE8 (GPL-3.0 repository; header offsets are ISP-core relative (data sheet offset - 0x20000), 632 of 775 data-sheet registers match it by name and offset (ISP_BLC_CFG is at 0x21100 in the data sheet and 0x1000+0x20000 in the header)). Reset value and access type unknown (modelled RW, no reset). Confidence: medium (vendor header for this chip family, not hardware verified).";

        field {
            name = "cpi_fix_timing_stat";
            desc = "[inferred] Cpi fix timing status. (vendor header `isp_reg_define.h` field `cpi_fix_timing_stat`; access and reset unknown, modelled RW)";
            sw = rw;
            hw = r;
        } cpi_fix_timing_stat[13:1];
    } ISP_DPC_TIMING @ 0x13CE8;

    reg {
        name = "ISP defect pixel correction UPDATE";
        desc = "[inferred] ISP defect pixel correction UPDATE. Not in the data sheet. Source: OpenIPC openhisilicon `kernel/isp/arch/hi3516cv300/firmware/vreg/arch/hi3516cv300/isp_reg_define.h` (GPL-3.0 repository, HiSilicon copyright, nManager-generated 2015-12-22 \"Define all registers/tables for Hi3519\"; local copy sources/openhisilicon), union `U_ISP_DPC_UPDATE`, struct offset 0x13CEC (GPL-3.0 repository; header offsets are ISP-core relative (data sheet offset - 0x20000), 632 of 775 data-sheet registers match it by name and offset (ISP_BLC_CFG is at 0x21100 in the data sheet and 0x1000+0x20000 in the header)). Reset value and access type unknown (modelled RW, no reset). Confidence: medium (vendor header for this chip family, not hardware verified).";

        field {
            name = "update";
            desc = "[inferred] Update. (vendor header `isp_reg_define.h` field `update`; access and reset unknown, modelled RW)";
            sw = rw;
            hw = r;
        } update[0:0];
    } ISP_DPC_UPDATE @ 0x13CEC;

    reg {
        name = "DPC picture size register";
        desc = "ISP_DPC_SIZE is a DPC picture size register.

Data sheet 10.6 ISP_DPC_SIZE (offset 0x23CF0, printed page 10-201, `hi3516cv300--Hi3516CV300-Hi3516EV100-Datasheet.txt` line 51903).";

        field {
            name = "height";
            desc = "Picture height. The configured value is the actual value minus 1. For example, for the 1080P picture, set the height to 1079.";
            sw = rw;
            hw = r;
            reset = 0x437;
        } height[28:16];

        field {
            name = "width";
            desc = "Picture width. The configured value is the actual value minus 1. For example, for the 1080P picture, set the width to 1919.";
            sw = rw;
            hw = r;
            reset = 0x77F;
        } width[12:0];
    } ISP_DPC_SIZE @ 0x13CF0;

    reg {
        name = "DPC soft correction threshold register";
        desc = "ISP_DPC_SOFT_THR is a DPC soft correction threshold register.

Data sheet 10.6 ISP_DPC_SOFT_THR (offset 0x23D10, printed page 10-201, `hi3516cv300--Hi3516CV300-Hi3516EV100-Datasheet.txt` line 51932).";

        field {
            name = "soft_thr_max";
            desc = "Maximum DPC soft threshold, signed 8.0-bit, two's complement";
            sw = rw;
            hw = r;
            reset = 0x0;
        } soft_thr_max[15:8];

        field {
            name = "soft_thr_min";
            desc = "Minimum DPC soft threshold, signed 8.0-bit, two's complement";
            sw = rw;
            hw = r;
            reset = 0x0;
        } soft_thr_min[7:0];
    } ISP_DPC_SOFT_THR @ 0x13D10;

    reg {
        name = "DPC hard correction enable register N";
        desc = "ISP_DPC_BHARDTHR_EN is a DPC hard correction enable register. Hi3516C V300/Hi3516E V100 Professional HD IP Camera SoC

Data sheet 10.6 ISP_DPC_BHARDTHR_EN (offset 0x23D14, printed page 10-202, `hi3516cv300--Hi3516CV300-Hi3516EV100-Datasheet.txt` line 51962).";

        enum ISP_DPC_BHARDTHR_EN_hard_thr_en_enum {
            DISABLED = 0 { name = "Disabled"; desc = "disabled"; };
            ENABLED = 1 { name = "Enabled"; desc = "enabled"; };
        };

        field {
            name = "hard_thr_en";
            desc = "DPC hard correction enable";
            sw = rw;
            hw = r;
            encode = ISP_DPC_BHARDTHR_EN_hard_thr_en_enum;
            reset = 0x1;
        } hard_thr_en[0:0];
    } ISP_DPC_BHARDTHR_EN @ 0x13D14;

    reg {
        name = "DPC soft correction curve slope register";
        desc = "ISP_DPC_RAKERATIO is a DPC soft correction curve slope register.

Data sheet 10.6 ISP_DPC_RAKERATIO (offset 0x23D18, printed page 10-202, `hi3516cv300--Hi3516CV300-Hi3516EV100-Datasheet.txt` line 51991).";

        field {
            name = "rake_ratio";
            desc = "Slope of the DPC soft correction curve, unsigned 8.2";
            sw = rw;
            hw = r;
            reset = 0x0;
        } rake_ratio[9:0];
    } ISP_DPC_RAKERATIO @ 0x13D18;

    reg {
        name = "ISP defect pixel correction EX control I";
        desc = "[inferred] ISP defect pixel correction EX control I. Not in the data sheet. Source: OpenIPC openhisilicon `kernel/isp/arch/hi3516cv300/firmware/vreg/arch/hi3516cv300/isp_reg_define.h` (GPL-3.0 repository, HiSilicon copyright, nManager-generated 2015-12-22 \"Define all registers/tables for Hi3519\"; local copy sources/openhisilicon), union `U_ISP_DPC_EX_CTRL_I`, struct offset 0x13DE4 (GPL-3.0 repository; header offsets are ISP-core relative (data sheet offset - 0x20000), 632 of 775 data-sheet registers match it by name and offset (ISP_BLC_CFG is at 0x21100 in the data sheet and 0x1000+0x20000 in the header)). Reset value and access type unknown (modelled RW, no reset). Confidence: medium (vendor header for this chip family, not hardware verified).";

        field {
            name = "update_mode";
            desc = "[inferred] Update mode. (vendor header `isp_reg_define.h` field `update_mode`; access and reset unknown, modelled RW)";
            sw = rw;
            hw = r;
        } update_mode[0:0];
    } ISP_DPC_EX_CTRL_I @ 0x13DE4;

    reg {
        name = "ISP defect pixel correction EX UPDATE";
        desc = "[inferred] ISP defect pixel correction EX UPDATE. Not in the data sheet. Source: OpenIPC openhisilicon `kernel/isp/arch/hi3516cv300/firmware/vreg/arch/hi3516cv300/isp_reg_define.h` (GPL-3.0 repository, HiSilicon copyright, nManager-generated 2015-12-22 \"Define all registers/tables for Hi3519\"; local copy sources/openhisilicon), union `U_ISP_DPC_EX_UPDATE`, struct offset 0x13DEC (GPL-3.0 repository; header offsets are ISP-core relative (data sheet offset - 0x20000), 632 of 775 data-sheet registers match it by name and offset (ISP_BLC_CFG is at 0x21100 in the data sheet and 0x1000+0x20000 in the header)). Reset value and access type unknown (modelled RW, no reset). Confidence: medium (vendor header for this chip family, not hardware verified).";

        field {
            name = "update";
            desc = "[inferred] Update. (vendor header `isp_reg_define.h` field `update`; access and reset unknown, modelled RW)";
            sw = rw;
            hw = r;
        } update[0:0];
    } ISP_DPC_EX_UPDATE @ 0x13DEC;

    reg {
        name = "BAYERNR control register";
        desc = "ISP_BNR_CFG is a BAYERNR control register. Hi3516C V300/Hi3516E V100 Professional HD IP Camera SoC

Data sheet 10.6 ISP_BNR_CFG (offset 0x25400, printed page 10-203, `hi3516cv300--Hi3516CV300-Hi3516EV100-Datasheet.txt` line 52020).";

        enum ISP_BNR_CFG_bnr_en_enum {
            DISABLED = 0 { name = "Disabled"; desc = "disabled"; };
            ENABLED = 1 { name = "Enabled"; desc = "enabled"; };
        };

        field {
            name = "bnr_en";
            desc = "BAYERNR enable";
            sw = rw;
            hw = r;
            encode = ISP_BNR_CFG_bnr_en_enum;
            reset = 0x0;
        } bnr_en[0:0];
    } ISP_BNR_CFG @ 0x15400;

    reg {
        name = "BAYERNR version register";
        desc = "ISP_BNR_VERSION is a BAYERNRR version register.

Data sheet 10.6 ISP_BNR_VERSION (offset 0x2540C, printed page 10-203, `hi3516cv300--Hi3516CV300-Hi3516EV100-Datasheet.txt` line 52043).";

        field {
            name = "version";
            desc = "BAYERNR logic version";
            sw = r;
            hw = w;
            reset = 0x00100208;
        } version[31:0];
    } ISP_BNR_VERSION @ 0x1540C;

    reg {
        name = "BAYERNR blending coefficient register";
        desc = "ISP_BNR_CRATIO is a BAYERNR blending coefficient register. Hi3516C V300/Hi3516E V100 Professional HD IP Camera SoC

Data sheet 10.6 ISP_BNR_CRATIO (offset 0x25410, printed page 10-204, `hi3516cv300--Hi3516CV300-Hi3516EV100-Datasheet.txt` line 52070).";

        field {
            name = "bg_bnr_cratio";
            desc = "Blending coefficient of the BAYERNR BG component.0 is the origin and 32 is the average point. The format is U6.0 and the value range is [0, 32].";
            sw = rw;
            hw = r;
            reset = 0x0;
        } bg_bnr_cratio[29:24];

        field {
            name = "gb_bnr_cratio";
            desc = "Blending coefficient of the BAYERNR GB component.0 is the origin and 32 is the average point. The format is U6.0 and the value range is [0, 32].";
            sw = rw;
            hw = r;
            reset = 0x0;
        } gb_bnr_cratio[21:16];

        field {
            name = "gr_bnr_cratio";
            desc = "Blending coefficient of the BAYERNR GR component.0 is the origin and 32 is the average point. The format is U6.0 and the value range is [0, 32].";
            sw = rw;
            hw = r;
            reset = 0x0;
        } gr_bnr_cratio[13:8];

        field {
            name = "rg_bnr_cratio";
            desc = "Blending coefficient of the BAYERNR RG component.0 is the origin and 32 is the average point. The format is U6.0 and the value range is [0, 32].";
            sw = rw;
            hw = r;
            reset = 0x0;
        } rg_bnr_cratio[5:0];
    } ISP_BNR_CRATIO @ 0x15410;

    reg {
        name = "BAYERNR chrominance median filtering level register";
        desc = "ISP_BNR_LEV is a BAYERNR chrominance median filtering level register. Hi3516C V300/Hi3516E V100 Professional HD IP Camera SoC

Data sheet 10.6 ISP_BNR_LEV (offset 0x25414, printed page 10-205, `hi3516cv300--Hi3516CV300-Hi3516EV100-Datasheet.txt` line 52116).";

        enum ISP_BNR_LEV_bg_amed_mode_enum {
            V_5X5_WINDOW_DATA = 0 { name = "V 5X5 Window Data"; desc = "5x5 window data filtering"; };
            V_9X9_WINDOW_DATA = 1 { name = "V 9X9 Window Data"; desc = "9x9 window data filtering"; };
        };

        field {
            name = "bg_amed_mode";
            desc = "Chrominance median filtering mode of the BAYERNR BG component";
            sw = rw;
            hw = r;
            encode = ISP_BNR_LEV_bg_amed_mode_enum;
            reset = 0x0;
        } bg_amed_mode[31:31];

        enum ISP_BNR_LEV_gb_amed_mode_enum {
            V_5X5_WINDOW_DATA = 0 { name = "V 5X5 Window Data"; desc = "5x5 window data filtering"; };
            V_9X9_WINDOW_DATA = 1 { name = "V 9X9 Window Data"; desc = "9x9 window data filtering"; };
        };

        field {
            name = "gb_amed_mode";
            desc = "Chrominance median filtering mode of the BAYERNR GB component";
            sw = rw;
            hw = r;
            encode = ISP_BNR_LEV_gb_amed_mode_enum;
            reset = 0x0;
        } gb_amed_mode[30:30];

        enum ISP_BNR_LEV_gr_amed_mode_enum {
            V_5X5_WINDOW_DATA = 0 { name = "V 5X5 Window Data"; desc = "5x5 window data filtering"; };
            V_9X9_WINDOW_DATA = 1 { name = "V 9X9 Window Data"; desc = "9x9 window data filtering"; };
        };

        field {
            name = "gr_amed_mode";
            desc = "Chrominance median filtering mode of the BAYERNR GR component";
            sw = rw;
            hw = r;
            encode = ISP_BNR_LEV_gr_amed_mode_enum;
            reset = 0x0;
        } gr_amed_mode[29:29];

        enum ISP_BNR_LEV_rg_amed_mode_enum {
            V_5X5_WINDOW_DATA = 0 { name = "V 5X5 Window Data"; desc = "5x5 window data filtering"; };
            V_9X9_WINDOW_DATA = 1 { name = "V 9X9 Window Data"; desc = "9x9 window data filtering"; };
        };

        field {
            name = "rg_amed_mode";
            desc = "Chrominance median filtering mode of the BAYERNR RG component";
            sw = rw;
            hw = r;
            encode = ISP_BNR_LEV_rg_amed_mode_enum;
            reset = 0x0;
        } rg_amed_mode[28:28];

        enum ISP_BNR_LEV_bg_amed_lev_enum {
            MEDIAN_FILTERING_DISABLED = 0 { name = "Median Filtering Disabled"; desc = "median filtering disabled"; };
            STANDARD_MEDIAN_FILTERING = 1 { name = "Standard Median Filtering"; desc = "standard median filtering"; };
            HIGH_OFFSET_MEDIAN = 2 { name = "High Offset Median"; desc = "high-offset median filtering"; };
            LOW_OFFSET_MEDIAN = 3 { name = "Low Offset Median"; desc = "low-offset median filtering"; };
        };

        field {
            name = "bg_amed_lev";
            desc = "BAYERNR chrominance median filtering strength of the B component";
            sw = rw;
            hw = r;
            encode = ISP_BNR_LEV_bg_amed_lev_enum;
            reset = 0x1;
        } bg_amed_lev[25:24];

        enum ISP_BNR_LEV_gb_amed_lev_enum {
            MEDIAN_FILTERING_DISABLED = 0 { name = "Median Filtering Disabled"; desc = "median filtering disabled"; };
            STANDARD_MEDIAN_FILTERING = 1 { name = "Standard Median Filtering"; desc = "standard median filtering"; };
            HIGH_OFFSET_MEDIAN = 2 { name = "High Offset Median"; desc = "high-offset median filtering"; };
            LOW_OFFSET_MEDIAN = 3 { name = "Low Offset Median"; desc = "low-offset median filtering"; };
        };

        field {
            name = "gb_amed_lev";
            desc = "BAYERNR chrominance median filtering strength";
            sw = rw;
            hw = r;
            encode = ISP_BNR_LEV_gb_amed_lev_enum;
            reset = 0x0;
        } gb_amed_lev[17:16];

        enum ISP_BNR_LEV_gr_amed_lev_enum {
            MEDIAN_FILTERING_DISABLED = 0 { name = "Median Filtering Disabled"; desc = "median filtering disabled"; };
            STANDARD_MEDIAN_FILTERING = 1 { name = "Standard Median Filtering"; desc = "standard median filtering"; };
            HIGH_OFFSET_MEDIAN = 2 { name = "High Offset Median"; desc = "high-offset median filtering"; };
            LOW_OFFSET_MEDIAN = 3 { name = "Low Offset Median"; desc = "low-offset median filtering"; };
        };

        field {
            name = "gr_amed_lev";
            desc = "BAYERNR chrominance median filtering strength";
            sw = rw;
            hw = r;
            encode = ISP_BNR_LEV_gr_amed_lev_enum;
            reset = 0x0;
        } gr_amed_lev[9:8];

        enum ISP_BNR_LEV_rg_amed_lev_enum {
            MEDIAN_FILTERING_DISABLED = 0 { name = "Median Filtering Disabled"; desc = "median filtering disabled"; };
            STANDARD_MEDIAN_FILTERING = 1 { name = "Standard Median Filtering"; desc = "standard median filtering"; };
            HIGH_OFFSET_MEDIAN = 2 { name = "High Offset Median"; desc = "high-offset median filtering"; };
            LOW_OFFSET_MEDIAN = 3 { name = "Low Offset Median"; desc = "low-offset median filtering"; };
        };

        field {
            name = "rg_amed_lev";
            desc = "BAYERNR chrominance median filtering strength";
            sw = rw;
            hw = r;
            encode = ISP_BNR_LEV_rg_amed_lev_enum;
            reset = 0x1;
        } rg_amed_lev[1:0];
    } ISP_BNR_LEV @ 0x15414;

    reg {
        name = "ISP BNR select";
        desc = "[inferred] ISP BNR select. Not in the data sheet. Source: OpenIPC openhisilicon `kernel/isp/arch/hi3516cv300/firmware/vreg/arch/hi3516cv300/isp_reg_define.h` (GPL-3.0 repository, HiSilicon copyright, nManager-generated 2015-12-22 \"Define all registers/tables for Hi3519\"; local copy sources/openhisilicon), union `U_ISP_BNR_SEL`, struct offset 0x15418 (GPL-3.0 repository; header offsets are ISP-core relative (data sheet offset - 0x20000), 632 of 775 data-sheet registers match it by name and offset (ISP_BLC_CFG is at 0x21100 in the data sheet and 0x1000+0x20000 in the header)). Reset value and access type unknown (modelled RW, no reset). Confidence: medium (vendor header for this chip family, not hardware verified).";

        field {
            name = "bnr_jnlm_bitshift";
            desc = "[inferred] Bnr jnlm bitshift. (vendor header `isp_reg_define.h` field `bnr_jnlm_bitshift`; access and reset unknown, modelled RW)";
            sw = rw;
            hw = r;
        } bnr_jnlm_bitshift[7:4];

        field {
            name = "bnr_jnlm_sel";
            desc = "[inferred] Bnr jnlm select. (vendor header `isp_reg_define.h` field `bnr_jnlm_sel`; access and reset unknown, modelled RW)";
            sw = rw;
            hw = r;
        } bnr_jnlm_sel[1:0];
    } ISP_BNR_SEL @ 0x15418;

    reg {
        name = "BAYERNR luminance accumulation coefficient register";
        desc = "ISP_BNR_GAIN is a BAYERNR luminance accumulation coefficient register.

Data sheet 10.6 ISP_BNR_GAIN (offset 0x2541C, printed page 10-206, `hi3516cv300--Hi3516CV300-Hi3516EV100-Datasheet.txt` line 52196).";

        field {
            name = "bnr_jnlm_gain";
            desc = "BAYERNR luminance accumulation coefficient. The format is U8.0 and the value range is [0, 128].";
            sw = rw;
            hw = r;
            reset = 0x52;
        } bnr_jnlm_gain[7:0];
    } ISP_BNR_GAIN @ 0x1541C;

    reg {
        name = "BAYERNR symmetric filtering coefficient register";
        desc = "ISP_BNR_SYMCOEF is a BAYERNR symmetric filtering coefficient register. Hi3516C V300/Hi3516E V100 Professional HD IP Camera SoC

Data sheet 10.6 ISP_BNR_SYMCOEF (offset 0x25420, printed page 10-207, `hi3516cv300--Hi3516CV300-Hi3516EV100-Datasheet.txt` line 52227).";

        field {
            name = "bnr_jnlm_symcoef";
            desc = "BAYERNR symmetric filtering coefficient. The format is U8.0 and the value range is [0, 255].";
            sw = rw;
            hw = r;
            reset = 0x2D;
        } bnr_jnlm_symcoef[7:0];
    } ISP_BNR_SYMCOEF @ 0x15420;

    reg {
        name = "BAYERNR truncation coefficient register";
        desc = "ISP_BNR_CORING is a BAYERNR truncation coefficient register.

Data sheet 10.6 ISP_BNR_CORING (offset 0x25424, printed page 10-207, `hi3516cv300--Hi3516CV300-Hi3516EV100-Datasheet.txt` line 52249).";

        field {
            name = "bnr_coring_hig";
            desc = "BAYERNR truncation upper limit. The format is U14.0 and the value range is [0, 16383].";
            sw = rw;
            hw = r;
            reset = 0x300;
        } bnr_coring_hig[29:16];
    } ISP_BNR_CORING @ 0x15424;

    reg {
        name = "BAYERNR blending frame number register";
        desc = "ISP_BNR_FRMNUM is a BAYERNR blending frame number register. Hi3516C V300/Hi3516E V100 Professional HD IP Camera SoC

Data sheet 10.6 ISP_BNR_FRMNUM (offset 0x25428, printed page 10-208, `hi3516cv300--Hi3516CV300-Hi3516EV100-Datasheet.txt` line 52284).";

        enum ISP_BNR_FRMNUM_frm_num_enum {
            V_0 = 0 { name = "V 0"; desc = "0"; };
            V_1 = 1 { name = "V 1"; desc = "1"; };
            V_2 = 2 { name = "V 2"; desc = "2"; };
            V_3 = 3 { name = "V 3"; desc = "3"; };
            V_4_OTHER_VALUES = 4 { name = "V 4 Other Values"; desc = "4 Other values: invalid"; };
        };

        field {
            name = "frm_num";
            desc = "Number of BAYERNR blending frames";
            sw = rw;
            hw = r;
            encode = ISP_BNR_FRMNUM_frm_num_enum;
            reset = 0x1;
        } frm_num[2:0];
    } ISP_BNR_FRMNUM @ 0x15428;

    reg {
        name = "BAYERNR LUT switch enable register";
        desc = "ISP_BNR_LUT_UPDATE is a BAYERNR LUT switch enable register.

Data sheet 10.6 ISP_BNR_LUT_UPDATE (offset 0x2542C, printed page 10-208, `hi3516cv300--Hi3516CV300-Hi3516EV100-Datasheet.txt` line 52314).";

        enum ISP_BNR_LUT_UPDATE_lut_update_enum {
            DISABLED = 0 { name = "Disabled"; desc = "disabled"; };
            ENABLED = 1 { name = "Enabled"; desc = "enabled"; };
        };

        field {
            name = "lut_update";
            desc = "BAYERNR LUT switch enable. This bit is automatically cleared for each frame.";
            sw = rw;
            hw = r;
            encode = ISP_BNR_LUT_UPDATE_lut_update_enum;
            reset = 0x0;
        } lut_update[0:0];
    } ISP_BNR_LUT_UPDATE @ 0x1542C;

    reg {
        name = "ISP BNR RLMT";
        desc = "[inferred] ISP BNR RLMT. Not in the data sheet. Source: OpenIPC openhisilicon `kernel/isp/arch/hi3516cv300/firmware/vreg/arch/hi3516cv300/isp_reg_define.h` (GPL-3.0 repository, HiSilicon copyright, nManager-generated 2015-12-22 \"Define all registers/tables for Hi3519\"; local copy sources/openhisilicon), union `U_ISP_BNR_RLMT`, struct offset 0x15430 (GPL-3.0 repository; header offsets are ISP-core relative (data sheet offset - 0x20000), 632 of 775 data-sheet registers match it by name and offset (ISP_BLC_CFG is at 0x21100 in the data sheet and 0x1000+0x20000 in the header)). Reset value and access type unknown (modelled RW, no reset). Confidence: medium (vendor header for this chip family, not hardware verified).";

        field {
            name = "bnr_rlmt_bgain";
            desc = "[inferred] Bnr rlmt bgain. (vendor header `isp_reg_define.h` field `bnr_rlmt_bgain`; access and reset unknown, modelled RW)";
            sw = rw;
            hw = r;
        } bnr_rlmt_bgain[29:20];

        field {
            name = "bnr_rlmt_rgain";
            desc = "[inferred] Bnr rlmt rgain. (vendor header `isp_reg_define.h` field `bnr_rlmt_rgain`; access and reset unknown, modelled RW)";
            sw = rw;
            hw = r;
        } bnr_rlmt_rgain[17:8];

        field {
            name = "bnr_rlmt_blc";
            desc = "[inferred] Bnr rlmt black level correction. (vendor header `isp_reg_define.h` field `bnr_rlmt_blc`; access and reset unknown, modelled RW)";
            sw = rw;
            hw = r;
        } bnr_rlmt_blc[4:0];
    } ISP_BNR_RLMT @ 0x15430;

    reg {
        name = "BAYERNR saturation denoising coefficient register";
        desc = "ISP_BNR_SATU0 is a BAYERNR saturation denoising coefficient register.

Data sheet 10.6 ISP_BNR_SATU0 (offset 0x25434, printed page 10-209, `hi3516cv300--Hi3516CV300-Hi3516EV100-Datasheet.txt` line 52350).";

        field {
            name = "bnr_satu_ratio";
            desc = "BAYERNR saturation denoising coefficient. The format is U9.0 and the value range is [0, 511].";
            sw = rw;
            hw = r;
            reset = 0x8C;
        } bnr_satu_ratio[8:0];
    } ISP_BNR_SATU0 @ 0x15434;

    reg {
        name = "BAYERNR saturation threshold 1 register";
        desc = "ISP_BNR_SATU1 is a BAYERNR saturation threshold 1 register.

Data sheet 10.6 ISP_BNR_SATU1 (offset 0x25438, printed page 10-209, `hi3516cv300--Hi3516CV300-Hi3516EV100-Datasheet.txt` line 52372).";

        field {
            name = "bnr_satu_thhig1";
            desc = "BAYERNR saturation high threshold 1. The format is U9.0 and the value range is [bnr_satu_thlow1 + 1, 256].";
            sw = rw;
            hw = r;
            reset = 0x6E;
        } bnr_satu_thhig1[24:16];

        field {
            name = "bnr_satu_thlow1";
            desc = "BAYERNR saturation low threshold 1. The format is U9.0 and the value range is [0, bnr_satu_thhig1 - 1].";
            sw = rw;
            hw = r;
            reset = 0x55;
        } bnr_satu_thlow1[8:0];
    } ISP_BNR_SATU1 @ 0x15438;

    reg {
        name = "BAYERNR saturation threshold 2 register";
        desc = "ISP_BNR_SATU2 is a BAYERNR saturation threshold 2 register. Hi3516C V300/Hi3516E V100 Professional HD IP Camera SoC

Data sheet 10.6 ISP_BNR_SATU2 (offset 0x2543C, printed page 10-210, `hi3516cv300--Hi3516CV300-Hi3516EV100-Datasheet.txt` line 52407).";

        field {
            name = "bnr_satu_thhig2";
            desc = "BAYERNR saturation high threshold 2. The format is U9.0 and the value range is [bnr_satu_thlow2 + 1, 256].";
            sw = rw;
            hw = r;
            reset = 0xB4;
        } bnr_satu_thhig2[24:16];

        field {
            name = "bnr_satu_thlow2";
            desc = "BAYERNR saturation low threshold 2. The format is U9.0 and the value range is [0, bnr_satu_thhig2 - 1].";
            sw = rw;
            hw = r;
            reset = 0x8C;
        } bnr_satu_thlow2[8:0];
    } ISP_BNR_SATU2 @ 0x1543C;

    reg {
        name = "Pattern_RGGB weight coefficient WADDR LUT write address register";
        desc = "ISP_BNR_RGGB_ODD_WADDR is a Pattern_RGGB weight coefficient LUT write address register.

Data sheet 10.6 ISP_BNR_RGGB_ODD_WADDR (offset 0x25480, printed page 10-210, `hi3516cv300--Hi3516CV300-Hi3516EV100-Datasheet.txt` line 52434).";

        field {
            name = "lut_hwaddr";
            desc = "Write address of the Pattern_RGGB weight coefficient LUT";
            sw = rw;
            hw = r;
            reset = 0x0;
        } lut_hwaddr[31:0];
    } ISP_BNR_RGGB_ODD_WADDR @ 0x15480;

    reg {
        name = "Pattern_RGGB weight coefficient WDATA LUT write data register";
        desc = "ISP_BNR_RGGB_ODD_WDATA is a Pattern_RGGB weight coefficient LUT write data register. Hi3516C V300/Hi3516E V100 Professional HD IP Camera SoC

Data sheet 10.6 ISP_BNR_RGGB_ODD_WDATA (offset 0x25484, printed page 10-211, `hi3516cv300--Hi3516CV300-Hi3516EV100-Datasheet.txt` line 52463).";

        field {
            name = "lut_hwdata";
            desc = "Write data of the Pattern_RGGB weight coefficient LUT";
            sw = w;
            hw = r;
            reset = 0x0;
        } lut_hwdata[31:0];
    } ISP_BNR_RGGB_ODD_WDATA @ 0x15484;

    reg {
        name = "Pattern_RGGB weight coefficient ADDR LUT read address register";
        desc = "ISP_BNR_RGGB_ODD_RADDR is a Pattern_RGGB weight coefficient LUT read address register.

Data sheet 10.6 ISP_BNR_RGGB_ODD_RADDR (offset 0x25488, printed page 10-211, `hi3516cv300--Hi3516CV300-Hi3516EV100-Datasheet.txt` line 52483).";

        field {
            name = "lut_hraddr";
            desc = "Read address of the Pattern_RGGB weight coefficient LUT";
            sw = rw;
            hw = r;
            reset = 0x0;
        } lut_hraddr[31:0];
    } ISP_BNR_RGGB_ODD_RADDR @ 0x15488;

    reg {
        name = "Pattern_RGGB weight coefficient DATA LUT read data register";
        desc = "ISP_BNR_RGGB_ODD_RDATA is a Pattern_RGGB weight coefficient LUT read data register.

Data sheet 10.6 ISP_BNR_RGGB_ODD_RDATA (offset 0x2548C, printed page 10-211, `hi3516cv300--Hi3516CV300-Hi3516EV100-Datasheet.txt` line 52503).";

        field {
            name = "lut_hrdata";
            desc = "Read data of the Pattern_RGGB weight coefficient LUT";
            sw = r;
            hw = w;
            reset = 0x0;
        } lut_hrdata[31:0];
    } ISP_BNR_RGGB_ODD_RDATA @ 0x1548C;

    reg {
        name = "Pattern_GRBG weight coefficient WADDR LUT write address register";
        desc = "ISP_BNR_GRBG_ODD_WADDR is a Pattern_GRBG weight coefficient LUT write address register.

Data sheet 10.6 ISP_BNR_GRBG_ODD_WADDR (offset 0x25490, printed page 10-212, `hi3516cv300--Hi3516CV300-Hi3516EV100-Datasheet.txt` line 52528).";

        field {
            name = "lut_hwaddr";
            desc = "Write address of the Pattern_GRBG weight coefficient LUT";
            sw = rw;
            hw = r;
            reset = 0x0;
        } lut_hwaddr[31:0];
    } ISP_BNR_GRBG_ODD_WADDR @ 0x15490;

    reg {
        name = "Pattern_GRBG weight coefficient WDATA LUT write data register";
        desc = "ISP_BNR_GRBG_ODD_WDATA is a Pattern_GRBG weight coefficient LUT write data register.

Data sheet 10.6 ISP_BNR_GRBG_ODD_WDATA (offset 0x25494, printed page 10-212, `hi3516cv300--Hi3516CV300-Hi3516EV100-Datasheet.txt` line 52547).";

        field {
            name = "lut_hwdata";
            desc = "Write data of the Pattern_GRBG weight coefficient LUT";
            sw = w;
            hw = r;
            reset = 0x0;
        } lut_hwdata[31:0];
    } ISP_BNR_GRBG_ODD_WDATA @ 0x15494;

    reg {
        name = "Pattern_GRBG weight coefficient ADDR LUT read address register";
        desc = "ISP_BNR_GRBG_ODD_RADDR is a Pattern_GRBG weight coefficient LUT read address register.

Data sheet 10.6 ISP_BNR_GRBG_ODD_RADDR (offset 0x25498, printed page 10-212, `hi3516cv300--Hi3516CV300-Hi3516EV100-Datasheet.txt` line 52567).";

        field {
            name = "lut_hraddr";
            desc = "Read address of the Pattern_GRBG weight coefficient LUT";
            sw = rw;
            hw = r;
            reset = 0x0;
        } lut_hraddr[31:0];
    } ISP_BNR_GRBG_ODD_RADDR @ 0x15498;

    reg {
        name = "Pattern_GRBG weight coefficient DATA LUT read data register";
        desc = "ISP_BNR_GRBG_ODD_RDATA is a Pattern_GRBG weight coefficient LUT read data register.

Data sheet 10.6 ISP_BNR_GRBG_ODD_RDATA (offset 0x2549C, printed page 10-213, `hi3516cv300--Hi3516CV300-Hi3516EV100-Datasheet.txt` line 52595).";

        field {
            name = "lut_hrdata";
            desc = "Read data of the Pattern_GRBG weight coefficient LUT";
            sw = r;
            hw = w;
            reset = 0x0;
        } lut_hrdata[31:0];
    } ISP_BNR_GRBG_ODD_RDATA @ 0x1549C;

    reg {
        name = "Pattern_GBRG weight coefficient WADDR LUT write address register";
        desc = "ISP_BNR_GBRG_ODD_WADDR is a Pattern_GBRG weight coefficient LUT write address register.

Data sheet 10.6 ISP_BNR_GBRG_ODD_WADDR (offset 0x254A0, printed page 10-213, `hi3516cv300--Hi3516CV300-Hi3516EV100-Datasheet.txt` line 52614).";

        field {
            name = "lut_hwaddr";
            desc = "Write address of the Pattern_GBRG weight coefficient LUT";
            sw = rw;
            hw = r;
            reset = 0x0;
        } lut_hwaddr[31:0];
    } ISP_BNR_GBRG_ODD_WADDR @ 0x154A0;

    reg {
        name = "Pattern_GBRG weight coefficient WDATA LUT write data register";
        desc = "ISP_BNR_GBRG_ODD_WDATA is a Pattern_GBRG weight coefficient LUT write data register. Hi3516C V300/Hi3516E V100 Professional HD IP Camera SoC

Data sheet 10.6 ISP_BNR_GBRG_ODD_WDATA (offset 0x254A4, printed page 10-214, `hi3516cv300--Hi3516CV300-Hi3516EV100-Datasheet.txt` line 52642).";

        field {
            name = "lut_hwdata";
            desc = "Write data of the Pattern_GBRG weight coefficient LUT";
            sw = w;
            hw = r;
            reset = 0x0;
        } lut_hwdata[31:0];
    } ISP_BNR_GBRG_ODD_WDATA @ 0x154A4;

    reg {
        name = "Pattern_GBRG weight coefficient ADDR LUT read address register";
        desc = "ISP_BNR_GBRG_ODD_RADDR is a Pattern_GBRG weight coefficient LUT read address register.

Data sheet 10.6 ISP_BNR_GBRG_ODD_RADDR (offset 0x254A8, printed page 10-214, `hi3516cv300--Hi3516CV300-Hi3516EV100-Datasheet.txt` line 52662).";

        field {
            name = "lut_hraddr";
            desc = "Read address of the Pattern_GBRG weight coefficient LUT";
            sw = rw;
            hw = r;
            reset = 0x0;
        } lut_hraddr[31:0];
    } ISP_BNR_GBRG_ODD_RADDR @ 0x154A8;

    reg {
        name = "Pattern_GBRG weight coefficient DATA LUT read data register";
        desc = "ISP_BNR_GBRG_ODD_RDATA is a Pattern_GBRG weight coefficient LUT read data register.

Data sheet 10.6 ISP_BNR_GBRG_ODD_RDATA (offset 0x254AC, printed page 10-214, `hi3516cv300--Hi3516CV300-Hi3516EV100-Datasheet.txt` line 52682).";

        field {
            name = "lut_hrdata";
            desc = "Read data of the Pattern_GBRG weight coefficient LUT";
            sw = r;
            hw = w;
            reset = 0x0;
        } lut_hrdata[31:0];
    } ISP_BNR_GBRG_ODD_RDATA @ 0x154AC;

    reg {
        name = "Pattern_BGGR weight coefficient WADDR LUT write address register";
        desc = "ISP_BNR_BGGR_ODD_WADDR is a Pattern_BGGR weight coefficient LUT write address register.

Data sheet 10.6 ISP_BNR_BGGR_ODD_WADDR (offset 0x254B0, printed page 10-215, `hi3516cv300--Hi3516CV300-Hi3516EV100-Datasheet.txt` line 52707).";

        field {
            name = "lut_hwaddr";
            desc = "Write address of the Pattern_BGGR weight coefficient LUT";
            sw = rw;
            hw = r;
            reset = 0x0;
        } lut_hwaddr[31:0];
    } ISP_BNR_BGGR_ODD_WADDR @ 0x154B0;

    reg {
        name = "Pattern_BGGR weight coefficient WDATA LUT write data register";
        desc = "ISP_BNR_BGGR_ODD_WDATA is a Pattern_BGGR weight coefficient LUT write data register.

Data sheet 10.6 ISP_BNR_BGGR_ODD_WDATA (offset 0x254B4, printed page 10-215, `hi3516cv300--Hi3516CV300-Hi3516EV100-Datasheet.txt` line 52726).";

        field {
            name = "lut_hwdata";
            desc = "Write data of the Pattern_BGGR weight coefficient LUT";
            sw = w;
            hw = r;
            reset = 0x0;
        } lut_hwdata[31:0];
    } ISP_BNR_BGGR_ODD_WDATA @ 0x154B4;

    reg {
        name = "Pattern_BGGR weight coefficient ADDR LUT read address register";
        desc = "ISP_BNR_BGGR_ODD_RADDR is a Pattern_BGGR weight coefficient LUT read address register.

Data sheet 10.6 ISP_BNR_BGGR_ODD_RADDR (offset 0x254B8, printed page 10-215, `hi3516cv300--Hi3516CV300-Hi3516EV100-Datasheet.txt` line 52746).";

        field {
            name = "lut_hraddr";
            desc = "Read address of the Pattern_BGGR weight coefficient LUT";
            sw = rw;
            hw = r;
            reset = 0x0;
        } lut_hraddr[31:0];
    } ISP_BNR_BGGR_ODD_RADDR @ 0x154B8;

    reg {
        name = "Pattern_BGGR weight coefficient DATA LUT read data register";
        desc = "ISP_BNR_BGGR_ODD_RDATA is a Pattern_BGGR weight coefficient LUT read data register.

Data sheet 10.6 ISP_BNR_BGGR_ODD_RDATA (offset 0x254BC, printed page 10-216, `hi3516cv300--Hi3516CV300-Hi3516EV100-Datasheet.txt` line 52771).";

        field {
            name = "lut_hrdata";
            desc = "Read data of the Pattern_BGGR weight coefficient LUT";
            sw = r;
            hw = w;
            reset = 0x0;
        } lut_hrdata[31:0];
    } ISP_BNR_BGGR_ODD_RDATA @ 0x154BC;

    reg {
        name = "Pattern_RLMT weight coefficient WADDR LUT write address register";
        desc = "ISP_BNR_RLMT_ODD_WADDR is a Pattern_RLMT weight coefficient LUT write address register.

Data sheet 10.6 ISP_BNR_RLMT_ODD_WADDR (offset 0x254C0, printed page 10-216, `hi3516cv300--Hi3516CV300-Hi3516EV100-Datasheet.txt` line 52790).";

        field {
            name = "lut_hwaddr";
            desc = "Write address of the Pattern_RLMT weight coefficient LUT";
            sw = rw;
            hw = r;
            reset = 0x0;
        } lut_hwaddr[31:0];
    } ISP_BNR_RLMT_ODD_WADDR @ 0x154C0;

    reg {
        name = "Pattern_RLMT weight coefficient WDATA LUT write data register";
        desc = "ISP_BNR_RLMT_ODD_WDATA is a Pattern_RLMT weight coefficient LUT write data register.

Data sheet 10.6 ISP_BNR_RLMT_ODD_WDATA (offset 0x254C4, printed page 10-216, `hi3516cv300--Hi3516CV300-Hi3516EV100-Datasheet.txt` line 52810).";

        field {
            name = "lut_hwdata";
            desc = "Write data of the Pattern_RLMT weight coefficient LUT";
            sw = w;
            hw = r;
            reset = 0x0;
        } lut_hwdata[31:0];
    } ISP_BNR_RLMT_ODD_WDATA @ 0x154C4;

    reg {
        name = "Pattern_RLMT weight coefficient ADDR LUT read address register";
        desc = "ISP_BNR_RLMT_ODD_RADDR is a Pattern_RLMT weight coefficient LUT read address register.

Data sheet 10.6 ISP_BNR_RLMT_ODD_RADDR (offset 0x254C8, printed page 10-217, `hi3516cv300--Hi3516CV300-Hi3516EV100-Datasheet.txt` line 52835).";

        field {
            name = "lut_hraddr";
            desc = "Read address of the Pattern_RLMT weight coefficient LUT";
            sw = rw;
            hw = r;
            reset = 0x0;
        } lut_hraddr[31:0];
    } ISP_BNR_RLMT_ODD_RADDR @ 0x154C8;

    reg {
        name = "Pattern_RLMT weight coefficient DATA LUT read data register";
        desc = "ISP_BNR_RLMT_ODD_RDATA is a Pattern_RLMT weight coefficient LUT read data register.

Data sheet 10.6 ISP_BNR_RLMT_ODD_RDATA (offset 0x254CC, printed page 10-217, `hi3516cv300--Hi3516CV300-Hi3516EV100-Datasheet.txt` line 52854).";

        field {
            name = "lut_hrdata";
            desc = "Read data of the Pattern_RLMT weight coefficient LUT";
            sw = r;
            hw = w;
            reset = 0x0;
        } lut_hrdata[31:0];
    } ISP_BNR_RLMT_ODD_RDATA @ 0x154CC;

    reg {
        name = "ISP BNR control F";
        desc = "[inferred] ISP BNR control F. Not in the data sheet. Source: OpenIPC openhisilicon `kernel/isp/arch/hi3516cv300/firmware/vreg/arch/hi3516cv300/isp_reg_define.h` (GPL-3.0 repository, HiSilicon copyright, nManager-generated 2015-12-22 \"Define all registers/tables for Hi3519\"; local copy sources/openhisilicon), union `U_ISP_BNR_CTRL_F`, struct offset 0x154E0 (GPL-3.0 repository; header offsets are ISP-core relative (data sheet offset - 0x20000), 632 of 775 data-sheet registers match it by name and offset (ISP_BLC_CFG is at 0x21100 in the data sheet and 0x1000+0x20000 in the header)). Reset value and access type unknown (modelled RW, no reset). Confidence: medium (vendor header for this chip family, not hardware verified).";

        field {
            name = "rggb_cfg";
            desc = "[inferred] Rggb configuration. (vendor header `isp_reg_define.h` field `rggb_cfg`; access and reset unknown, modelled RW)";
            sw = rw;
            hw = r;
        } rggb_cfg[1:0];
    } ISP_BNR_CTRL_F @ 0x154E0;

    reg {
        name = "ISP BNR control I";
        desc = "[inferred] ISP BNR control I. Not in the data sheet. Source: OpenIPC openhisilicon `kernel/isp/arch/hi3516cv300/firmware/vreg/arch/hi3516cv300/isp_reg_define.h` (GPL-3.0 repository, HiSilicon copyright, nManager-generated 2015-12-22 \"Define all registers/tables for Hi3519\"; local copy sources/openhisilicon), union `U_ISP_BNR_CTRL_I`, struct offset 0x154E4 (GPL-3.0 repository; header offsets are ISP-core relative (data sheet offset - 0x20000), 632 of 775 data-sheet registers match it by name and offset (ISP_BLC_CFG is at 0x21100 in the data sheet and 0x1000+0x20000 in the header)). Reset value and access type unknown (modelled RW, no reset). Confidence: medium (vendor header for this chip family, not hardware verified).";

        field {
            name = "update_mode";
            desc = "[inferred] Update mode. (vendor header `isp_reg_define.h` field `update_mode`; access and reset unknown, modelled RW)";
            sw = rw;
            hw = r;
        } update_mode[0:0];
    } ISP_BNR_CTRL_I @ 0x154E4;

    reg {
        name = "ISP BNR TIMING";
        desc = "[inferred] ISP BNR TIMING. Not in the data sheet. Source: OpenIPC openhisilicon `kernel/isp/arch/hi3516cv300/firmware/vreg/arch/hi3516cv300/isp_reg_define.h` (GPL-3.0 repository, HiSilicon copyright, nManager-generated 2015-12-22 \"Define all registers/tables for Hi3519\"; local copy sources/openhisilicon), union `U_ISP_BNR_TIMING`, struct offset 0x154E8 (GPL-3.0 repository; header offsets are ISP-core relative (data sheet offset - 0x20000), 632 of 775 data-sheet registers match it by name and offset (ISP_BLC_CFG is at 0x21100 in the data sheet and 0x1000+0x20000 in the header)). Reset value and access type unknown (modelled RW, no reset). Confidence: medium (vendor header for this chip family, not hardware verified).";

        field {
            name = "cpi_fix_timing_stat";
            desc = "[inferred] Cpi fix timing status. (vendor header `isp_reg_define.h` field `cpi_fix_timing_stat`; access and reset unknown, modelled RW)";
            sw = rw;
            hw = r;
        } cpi_fix_timing_stat[13:1];
    } ISP_BNR_TIMING @ 0x154E8;

    reg {
        name = "ISP BNR UPDATE";
        desc = "[inferred] ISP BNR UPDATE. Not in the data sheet. Source: OpenIPC openhisilicon `kernel/isp/arch/hi3516cv300/firmware/vreg/arch/hi3516cv300/isp_reg_define.h` (GPL-3.0 repository, HiSilicon copyright, nManager-generated 2015-12-22 \"Define all registers/tables for Hi3519\"; local copy sources/openhisilicon), union `U_ISP_BNR_UPDATE`, struct offset 0x154EC (GPL-3.0 repository; header offsets are ISP-core relative (data sheet offset - 0x20000), 632 of 775 data-sheet registers match it by name and offset (ISP_BLC_CFG is at 0x21100 in the data sheet and 0x1000+0x20000 in the header)). Reset value and access type unknown (modelled RW, no reset). Confidence: medium (vendor header for this chip family, not hardware verified).";

        field {
            name = "update";
            desc = "[inferred] Update. (vendor header `isp_reg_define.h` field `update`; access and reset unknown, modelled RW)";
            sw = rw;
            hw = r;
        } update[0:0];
    } ISP_BNR_UPDATE @ 0x154EC;

    reg {
        name = "BNR input picture size register";
        desc = "ISP_BNR_SIZE is a BNR input picture size register. Hi3516C V300/Hi3516E V100 Professional HD IP Camera SoC

Data sheet 10.6 ISP_BNR_SIZE (offset 0x254F0, printed page 10-218, `hi3516cv300--Hi3516CV300-Hi3516EV100-Datasheet.txt` line 52882).";

        field {
            name = "height";
            desc = "Input picture height. The configured value is the actual value minus 1. For example, for the 1080P picture, set the height to 1079.";
            sw = rw;
            hw = r;
            reset = 0x437;
        } height[28:16];

        field {
            name = "width";
            desc = "Input picture width. The configured value is the actual value minus 1. For example, for the 1080P picture, set the width to 1919.";
            sw = rw;
            hw = r;
            reset = 0x77F;
        } width[12:0];
    } ISP_BNR_SIZE @ 0x154F0;

    reg {
        name = "Pattern_RGGB weight coefficient WADDR LUT write address register";
        desc = "ISP_BNR_RGGB_EVEN_WADDR is a Pattern_RGGB weight coefficient LUT write address register.

Data sheet 10.6 ISP_BNR_RGGB_EVEN_WADDR (offset 0x25580, printed page 10-218, `hi3516cv300--Hi3516CV300-Hi3516EV100-Datasheet.txt` line 52912).";

        field {
            name = "lut_hwaddr";
            desc = "Write address of the Pattern_RGGB weight coefficient LUT";
            sw = rw;
            hw = r;
            reset = 0x0;
        } lut_hwaddr[31:0];
    } ISP_BNR_RGGB_EVEN_WADDR @ 0x15580;

    reg {
        name = "Pattern_RGGB weight coefficient WDATA LUT write data register";
        desc = "ISP_BNR_RGGB_EVEN_WDATA is a Pattern_RGGB weight coefficient LUT write data register. Hi3516C V300/Hi3516E V100 Professional HD IP Camera SoC

Data sheet 10.6 ISP_BNR_RGGB_EVEN_WDATA (offset 0x25584, printed page 10-219, `hi3516cv300--Hi3516CV300-Hi3516EV100-Datasheet.txt` line 52940).";

        field {
            name = "lut_hwdata";
            desc = "Write data of the Pattern_RGGB weight coefficient LUT";
            sw = w;
            hw = r;
            reset = 0x0;
        } lut_hwdata[31:0];
    } ISP_BNR_RGGB_EVEN_WDATA @ 0x15584;

    reg {
        name = "Pattern_RGGB weight coefficient RADDR LUT read address register";
        desc = "ISP_BNR_RGGB_EVEN_RADDR is a Pattern_RGGB weight coefficient LUT read address register.

Data sheet 10.6 ISP_BNR_RGGB_EVEN_RADDR (offset 0x25588, printed page 10-219, `hi3516cv300--Hi3516CV300-Hi3516EV100-Datasheet.txt` line 52960).";

        field {
            name = "lut_hraddr";
            desc = "Read address of the Pattern_RGGB weight coefficient LUT";
            sw = rw;
            hw = r;
            reset = 0x0;
        } lut_hraddr[31:0];
    } ISP_BNR_RGGB_EVEN_RADDR @ 0x15588;

    reg {
        name = "Pattern_RGGB weight coefficient RDATA LUT read data register";
        desc = "ISP_BNR_RGGB_EVEN_RDATA is a Pattern_RGGB weight coefficient LUT read data register.

Data sheet 10.6 ISP_BNR_RGGB_EVEN_RDATA (offset 0x2558C, printed page 10-219, `hi3516cv300--Hi3516CV300-Hi3516EV100-Datasheet.txt` line 52980).";

        field {
            name = "lut_hrdata";
            desc = "Read data of the Pattern_RGGB weight coefficient LUT";
            sw = r;
            hw = w;
            reset = 0x0;
        } lut_hrdata[31:0];
    } ISP_BNR_RGGB_EVEN_RDATA @ 0x1558C;

    reg {
        name = "Pattern_GRBG weight coefficient WADDR LUT write address register";
        desc = "ISP_BNR_GRBG_EVEN_WADDR is a Pattern_GRBG weight coefficient LUT write address register.

Data sheet 10.6 ISP_BNR_GRBG_EVEN_WADDR (offset 0x25590, printed page 10-220, `hi3516cv300--Hi3516CV300-Hi3516EV100-Datasheet.txt` line 53005).";

        field {
            name = "lut_hwaddr";
            desc = "Write address of the Pattern_GRBG weight coefficient LUT";
            sw = rw;
            hw = r;
            reset = 0x0;
        } lut_hwaddr[31:0];
    } ISP_BNR_GRBG_EVEN_WADDR @ 0x15590;

    reg {
        name = "Pattern_GRBG weight coefficient WDATA LUT write data register";
        desc = "ISP_BNR_GRBG_EVEN_WDATA is a Pattern_GRBG weight coefficient LUT write data register.

Data sheet 10.6 ISP_BNR_GRBG_EVEN_WDATA (offset 0x25594, printed page 10-220, `hi3516cv300--Hi3516CV300-Hi3516EV100-Datasheet.txt` line 53024).";

        field {
            name = "lut_hwdata";
            desc = "Write data of the Pattern_GRBG weight coefficient LUT";
            sw = w;
            hw = r;
            reset = 0x0;
        } lut_hwdata[31:0];
    } ISP_BNR_GRBG_EVEN_WDATA @ 0x15594;

    reg {
        name = "Pattern_GRBG weight coefficient RADDR LUT read address register";
        desc = "ISP_BNR_GRBG_EVEN_RADDR is a Pattern_GRBG weight coefficient LUT read address register.

Data sheet 10.6 ISP_BNR_GRBG_EVEN_RADDR (offset 0x25598, printed page 10-220, `hi3516cv300--Hi3516CV300-Hi3516EV100-Datasheet.txt` line 53044).";

        field {
            name = "lut_hraddr";
            desc = "Read address of the Pattern_GRBG weight coefficient LUT";
            sw = rw;
            hw = r;
            reset = 0x0;
        } lut_hraddr[31:0];
    } ISP_BNR_GRBG_EVEN_RADDR @ 0x15598;

    reg {
        name = "Pattern_GRBG weight coefficient RDATA LUT read data register";
        desc = "ISP_BNR_GRBG_EVEN_RDATA is a Pattern_GRBG weight coefficient LUT read data register.

Data sheet 10.6 ISP_BNR_GRBG_EVEN_RDATA (offset 0x2559C, printed page 10-221, `hi3516cv300--Hi3516CV300-Hi3516EV100-Datasheet.txt` line 53069).";

        field {
            name = "lut_hrdata";
            desc = "Read data of the Pattern_GRBG weight coefficient LUT";
            sw = r;
            hw = w;
            reset = 0x0;
        } lut_hrdata[31:0];
    } ISP_BNR_GRBG_EVEN_RDATA @ 0x1559C;

    reg {
        name = "Pattern_GBRG weight coefficient WADDR LUT write address register";
        desc = "ISP_BNR_GBRG_EVEN_WADDR is a Pattern_GBRG weight coefficient LUT write address register.

Data sheet 10.6 ISP_BNR_GBRG_EVEN_WADDR (offset 0x255A0, printed page 10-221, `hi3516cv300--Hi3516CV300-Hi3516EV100-Datasheet.txt` line 53088).";

        field {
            name = "lut_hwaddr";
            desc = "Write address of the Pattern_GBRG weight coefficient LUT";
            sw = rw;
            hw = r;
            reset = 0x0;
        } lut_hwaddr[31:0];
    } ISP_BNR_GBRG_EVEN_WADDR @ 0x155A0;

    reg {
        name = "Pattern_GBRG weight coefficient WDATA LUT write data register";
        desc = "ISP_BNR_GBRG_EVEN_WDATA is a Pattern_GBRG weight coefficient LUT write data register.

Data sheet 10.6 ISP_BNR_GBRG_EVEN_WDATA (offset 0x255A4, printed page 10-221, `hi3516cv300--Hi3516CV300-Hi3516EV100-Datasheet.txt` line 53108).";

        field {
            name = "lut_hwdata";
            desc = "Write data of the Pattern_GBRG weight coefficient LUT";
            sw = w;
            hw = r;
            reset = 0x0;
        } lut_hwdata[31:0];
    } ISP_BNR_GBRG_EVEN_WDATA @ 0x155A4;

    reg {
        name = "Pattern_GBRG weight coefficient RADDR LUT read address register";
        desc = "ISP_BNR_GBRG_EVEN_RADDR is a Pattern_GBRG weight coefficient LUT read address register.

Data sheet 10.6 ISP_BNR_GBRG_EVEN_RADDR (offset 0x255A8, printed page 10-222, `hi3516cv300--Hi3516CV300-Hi3516EV100-Datasheet.txt` line 53133).";

        field {
            name = "lut_hraddr";
            desc = "Read address of the Pattern_GBRG weight coefficient LUT";
            sw = rw;
            hw = r;
            reset = 0x0;
        } lut_hraddr[31:0];
    } ISP_BNR_GBRG_EVEN_RADDR @ 0x155A8;

    reg {
        name = "Pattern_GBRG weight coefficient RDATA LUT read data register";
        desc = "ISP_BNR_GBRG_EVEN_RDATA is a Pattern_GBRG weight coefficient LUT read data register.

Data sheet 10.6 ISP_BNR_GBRG_EVEN_RDATA (offset 0x255AC, printed page 10-222, `hi3516cv300--Hi3516CV300-Hi3516EV100-Datasheet.txt` line 53152).";

        field {
            name = "lut_hrdata";
            desc = "Read data of the Pattern_GBRG weight coefficient LUT";
            sw = r;
            hw = w;
            reset = 0x0;
        } lut_hrdata[31:0];
    } ISP_BNR_GBRG_EVEN_RDATA @ 0x155AC;

    reg {
        name = "Pattern_BGGR weight coefficient WADDR LUT write address register";
        desc = "ISP_BNR_BGGR_EVEN_WADDR is a Pattern_BGGR weight coefficient LUT write address register.

Data sheet 10.6 ISP_BNR_BGGR_EVEN_WADDR (offset 0x255B0, printed page 10-222, `hi3516cv300--Hi3516CV300-Hi3516EV100-Datasheet.txt` line 53172).";

        field {
            name = "lut_hwaddr";
            desc = "Write address of the Pattern_BGGR weight coefficient LUT";
            sw = rw;
            hw = r;
            reset = 0x0;
        } lut_hwaddr[31:0];
    } ISP_BNR_BGGR_EVEN_WADDR @ 0x155B0;

    reg {
        name = "Pattern_BGGR weight coefficient WDATA LUT write data register";
        desc = "ISP_BNR_BGGR_EVEN_WDATA is a Pattern_BGGR weight coefficient LUT write data register.

Data sheet 10.6 ISP_BNR_BGGR_EVEN_WDATA (offset 0x255B4, printed page 10-223, `hi3516cv300--Hi3516CV300-Hi3516EV100-Datasheet.txt` line 53197).";

        field {
            name = "lut_hwdata";
            desc = "Write data of the Pattern_BGGR weight coefficient LUT";
            sw = w;
            hw = r;
            reset = 0x0;
        } lut_hwdata[31:0];
    } ISP_BNR_BGGR_EVEN_WDATA @ 0x155B4;

    reg {
        name = "Pattern_BGGR weight coefficient RADDR LUT read address register";
        desc = "ISP_BNR_BGGR_EVEN_RADDR is a Pattern_BGGR weight coefficient LUT read address register.

Data sheet 10.6 ISP_BNR_BGGR_EVEN_RADDR (offset 0x255B8, printed page 10-223, `hi3516cv300--Hi3516CV300-Hi3516EV100-Datasheet.txt` line 53216).";

        field {
            name = "lut_hraddr";
            desc = "Read address of the Pattern_BGGR weight coefficient LUT";
            sw = rw;
            hw = r;
            reset = 0x0;
        } lut_hraddr[31:0];
    } ISP_BNR_BGGR_EVEN_RADDR @ 0x155B8;

    reg {
        name = "Pattern_BGGR weight coefficient RDATA LUT read data register";
        desc = "ISP_BNR_BGGR_EVEN_RDATA is a Pattern_BGGR weight coefficient LUT read data register.

Data sheet 10.6 ISP_BNR_BGGR_EVEN_RDATA (offset 0x255BC, printed page 10-223, `hi3516cv300--Hi3516CV300-Hi3516EV100-Datasheet.txt` line 53236).";

        field {
            name = "lut_hrdata";
            desc = "Read data of the Pattern_BGGR weight coefficient LUT";
            sw = r;
            hw = w;
            reset = 0x0;
        } lut_hrdata[31:0];
    } ISP_BNR_BGGR_EVEN_RDATA @ 0x155BC;

    reg {
        name = "Pattern_RLMT weight coefficient WADDR LUT write address register";
        desc = "ISP_BNR_RLMT_EVEN_WADDR is a Pattern_RLMT weight coefficient LUT write address register.

Data sheet 10.6 ISP_BNR_RLMT_EVEN_WADDR (offset 0x255C0, printed page 10-224, `hi3516cv300--Hi3516CV300-Hi3516EV100-Datasheet.txt` line 53261).";

        field {
            name = "lut_hwaddr";
            desc = "Write address of the Pattern_RLMT weight coefficient LUT";
            sw = rw;
            hw = r;
            reset = 0x0;
        } lut_hwaddr[31:0];
    } ISP_BNR_RLMT_EVEN_WADDR @ 0x155C0;

    reg {
        name = "Pattern_RLMT weight coefficient WDATA LUT write data register";
        desc = "ISP_BNR_RLMT_EVEN_WDATA is a Pattern_RLMT weight coefficient LUT write data register.

Data sheet 10.6 ISP_BNR_RLMT_EVEN_WDATA (offset 0x255C4, printed page 10-224, `hi3516cv300--Hi3516CV300-Hi3516EV100-Datasheet.txt` line 53280).";

        field {
            name = "lut_hwdata";
            desc = "Write data of the Pattern_RLMT weight coefficient LUT";
            sw = w;
            hw = r;
            reset = 0x0;
        } lut_hwdata[31:0];
    } ISP_BNR_RLMT_EVEN_WDATA @ 0x155C4;

    reg {
        name = "Pattern_RLMT weight coefficient RADDR LUT read address register";
        desc = "ISP_BNR_RLMT_EVEN_RADDR is a Pattern_RLMT weight coefficient LUT read address register.

Data sheet 10.6 ISP_BNR_RLMT_EVEN_RADDR (offset 0x255C8, printed page 10-224, `hi3516cv300--Hi3516CV300-Hi3516EV100-Datasheet.txt` line 53300).";

        field {
            name = "lut_hraddr";
            desc = "Read address of the Pattern_RLMT weight coefficient LUT";
            sw = rw;
            hw = r;
            reset = 0x0;
        } lut_hraddr[31:0];
    } ISP_BNR_RLMT_EVEN_RADDR @ 0x155C8;

    reg {
        name = "Pattern_RLMT weight coefficient RDATA LUT read data register";
        desc = "ISP_BNR_RLMT_EVEN_RDATA is a Pattern_RLMT weight coefficient LUT read data register.

Data sheet 10.6 ISP_BNR_RLMT_EVEN_RDATA (offset 0x255CC, printed page 10-225, `hi3516cv300--Hi3516CV300-Hi3516EV100-Datasheet.txt` line 53325).";

        field {
            name = "lut_hrdata";
            desc = "Read data of the Pattern_RLMT weight coefficient LUT";
            sw = r;
            hw = w;
            reset = 0x0;
        } lut_hrdata[31:0];
    } ISP_BNR_RLMT_EVEN_RDATA @ 0x155CC;

    reg {
        name = "WDR control register";
        desc = "ISP_WDR_CFG is a WDR control register.

Data sheet 10.6 ISP_WDR_CFG (offset 0x26000, printed page 10-225, `hi3516cv300--Hi3516CV300-Hi3516EV100-Datasheet.txt` line 53343).";

        enum ISP_WDR_CFG_en_enum {
            DISABLED = 0 { name = "Disabled"; desc = "disabled"; };
            ENABLED = 1 { name = "Enabled"; desc = "enabled"; };
        };

        field {
            name = "en";
            desc = "WDR enable (U1)";
            sw = rw;
            hw = r;
            encode = ISP_WDR_CFG_en_enum;
            reset = 0x0;
        } en[0:0];
    } ISP_WDR_CFG @ 0x16000;

    reg {
        name = "Input black level offset register";
        desc = "ISP_WDR_INBLC is an input black level offset register. Hi3516C V300/Hi3516E V100 Professional HD IP Camera SoC

Data sheet 10.6 ISP_WDR_INBLC (offset 0x26010, printed page 10-226, `hi3516cv300--Hi3516CV300-Hi3516EV100-Datasheet.txt` line 53374).";

        field {
            name = "f0_inBLC";
            desc = "f0_inBLC";
            sw = rw;
            hw = r;
            reset = 0x0;
        } f0_inBLC[30:16];

        field {
            name = "f1_inBLC";
            desc = "f1_inBLC";
            sw = rw;
            hw = r;
            reset = 0x0;
        } f1_inBLC[14:0];
    } ISP_WDR_INBLC @ 0x16010;

    reg {
        name = "Output black level offset register";
        desc = "ISP_WDR_OUTBLC is an output black level offset register.

Data sheet 10.6 ISP_WDR_OUTBLC (offset 0x26014, printed page 10-226, `hi3516cv300--Hi3516CV300-Hi3516EV100-Datasheet.txt` line 53403).";

        field {
            name = "outBLC";
            desc = "outBLC";
            sw = rw;
            hw = r;
            reset = 0x0;
        } outBLC[19:0];
    } ISP_WDR_OUTBLC @ 0x16014;

    reg {
        name = "Exposure ratio register S";
        desc = "ISP_WDR_EXPOSRATIOS is an exposure ratio register. Hi3516C V300/Hi3516E V100 Professional HD IP Camera SoC

Data sheet 10.6 ISP_WDR_EXPOSRATIOS (offset 0x26018, printed page 10-227, `hi3516cv300--Hi3516CV300-Hi3516EV100-Datasheet.txt` line 53432).";

        field {
            name = "exporatio_r";
            desc = "Reciprocal of the exposure ratio of the long frame (f1) relative to the short frame (f0) (U10)";
            sw = rw;
            hw = r;
            reset = 0x0;
        } exporatio_r[25:16];

        field {
            name = "exporatio";
            desc = "Exposure ratio of the long frame (f1) relative to the short frame (f0) (U6.6)";
            sw = rw;
            hw = r;
            reset = 0x0;
        } exporatio[11:0];
    } ISP_WDR_EXPOSRATIOS @ 0x16018;

    reg {
        name = "Black level save control register";
        desc = "ISP_WDR_BLCSAVE is a black level save control register.

Data sheet 10.6 ISP_WDR_BLCSAVE (offset 0x2601C, printed page 10-227, `hi3516cv300--Hi3516CV300-Hi3516EV100-Datasheet.txt` line 53458).";

        enum ISP_WDR_BLCSAVE_esaveBLC_enum {
            BLACK_LEVEL_SHORT = 0 { name = "Black Level Short"; desc = "The black level of the short frame (f0) is saved."; };
            BLACK_LEVEL_LONG = 1 { name = "Black Level Long"; desc = "The black level of the long frame (f1) is saved."; };
        };

        field {
            name = "esaveBLC";
            desc = "Frame of which the black level is to be saved during output (U1)";
            sw = rw;
            hw = r;
            encode = ISP_WDR_BLCSAVE_esaveBLC_enum;
            reset = 0x0;
        } esaveBLC[16:16];

        enum ISP_WDR_BLCSAVE_bsaveBLC_enum {
            UNSAVED_BLACK_LEVEL = 0 { name = "Unsaved Black Level"; desc = "The unsaved black level is output."; };
            SAVED_BLACK_LEVEL = 1 { name = "Saved Black Level"; desc = "The saved black level is output."; };
        };

        field {
            name = "bsaveBLC";
            desc = "Black level save enable (U1)";
            sw = rw;
            hw = r;
            encode = ISP_WDR_BLCSAVE_bsaveBLC_enum;
            reset = 0x0;
        } bsaveBLC[0:0];
    } ISP_WDR_BLCSAVE @ 0x1601C;

    reg {
        name = "Black level zoom coefficient register";
        desc = "ISP_WDR_ZOOMBLC is a black level zoom coefficient register.

Data sheet 10.6 ISP_WDR_ZOOMBLC (offset 0x26020, printed page 10-228, `hi3516cv300--Hi3516CV300-Hi3516EV100-Datasheet.txt` line 53496).";

        field {
            name = "zoomBLC";
            desc = "Zoom coefficient of the black level. The maximum value is 64 and the data format is U7. This register takes effect for pixel values below the BLC threshold. That is, the difference between the pixel value and the black level is zoomed in (zoom in the negative signal).";
            sw = rw;
            hw = r;
            reset = 0x0;
        } zoomBLC[6:0];
    } ISP_WDR_ZOOMBLC @ 0x16020;

    reg {
        name = "Weight index blending coefficient O register";
        desc = "ISP_WDR_BLENDRATIO is a weight index blending coefficient register.

Data sheet 10.6 ISP_WDR_BLENDRATIO (offset 0x26024, printed page 10-228, `hi3516cv300--Hi3516CV300-Hi3516EV100-Datasheet.txt` line 53520).";

        field {
            name = "bldrlhfidx";
            desc = "Blending coefficient of the high- and low-frequency weight index. The maximum value is 16 and the data format is U5.";
            sw = rw;
            hw = r;
            reset = 0x0;
        } bldrlhfidx[20:16];

        field {
            name = "bldrclridx";
            desc = "Blending coefficient of the point index and maximum value index. The maximum value is 16 and the data format is U5.";
            sw = rw;
            hw = r;
            reset = 0x0;
        } bldrclridx[4:0];
    } ISP_WDR_BLENDRATIO @ 0x16024;

    reg {
        name = "Long frame index threshold register";
        desc = "ISP_WDR_FLRGTTH is a long frame index threshold register. Hi3516C V300/Hi3516E V100 Professional HD IP Camera SoC

Data sheet 10.6 ISP_WDR_FLRGTTH (offset 0x26028, printed page 10-229, `hi3516cv300--Hi3516CV300-Hi3516EV100-Datasheet.txt` line 53555).";

        field {
            name = "flrgtth_high";
            desc = "Upper threshold of the long frame index (U14)";
            sw = rw;
            hw = r;
            reset = 0x0;
        } flrgtth_high[29:16];

        field {
            name = "flrgtth_low";
            desc = "Lower threshold of the long frame index (U14)";
            sw = rw;
            hw = r;
            reset = 0x0;
        } flrgtth_low[13:0];
    } ISP_WDR_FLRGTTH @ 0x16028;

    reg {
        name = "Long frame default weight register";
        desc = "ISP_WDR_FLDFTWGT is a long frame default weight register.

Data sheet 10.6 ISP_WDR_FLDFTWGT (offset 0x2602C, printed page 10-229, `hi3516cv300--Hi3516CV300-Hi3516EV100-Datasheet.txt` line 53580).";

        field {
            name = "fl_dftwgt";
            desc = "Default weight of the long frame. The data format is U9 and the maximum value is 256.";
            sw = rw;
            hw = r;
            reset = 0x0;
        } fl_dftwgt[8:0];
    } ISP_WDR_FLDFTWGT @ 0x1602C;

    reg {
        name = "Motion detection control register";
        desc = "ISP_WDR_MDT_CTRL is a motion detection control register. Hi3516C V300/Hi3516E V100 Professional HD IP Camera SoC

Data sheet 10.6 ISP_WDR_MDT_CTRL (offset 0x26030, printed page 10-230, `hi3516cv300--Hi3516CV300-Hi3516EV100-Datasheet.txt` line 53610).";

        enum ISP_WDR_MDT_CTRL_bmdthf_enum {
            NO_FILTERING_MOTION = 0 { name = "No Filtering Motion"; desc = "no filtering on motion intensity"; };
            HORIZONTAL_LOW_PASS = 1 { name = "Horizontal Low Pass"; desc = "horizontal low-pass filtering on motion intensity"; };
        };

        field {
            name = "bmdthf";
            desc = "Horizontal filtering control of motion intensity (U1)";
            sw = rw;
            hw = r;
            encode = ISP_WDR_MDT_CTRL_bmdthf_enum;
            reset = 0x0;
        } bmdthf[28:28];

        enum ISP_WDR_MDT_CTRL_fl_bmdtmnu_enum {
            LONG_FRAME_WEIGHT = 0 { name = "Long Frame Weight"; desc = "The long frame weight in motion regions decreases."; };
            LONG_FRAME_WEIGHT_2 = 1 { name = "Long Frame Weight 2"; desc = "The long frame weight in motion regions increases."; };
        };

        field {
            name = "fl_bmdtmnu";
            desc = "Long frame weight adjustment in motion regions (U1)";
            sw = rw;
            hw = r;
            encode = ISP_WDR_MDT_CTRL_fl_bmdtmnu_enum;
            reset = 0x0;
        } fl_bmdtmnu[24:24];

        enum ISP_WDR_MDT_CTRL_bmdtstrong_enum {
            WEAK_MOTION_DETECTION = 0 { name = "Weak Motion Detection"; desc = "Weak motion detection and the small window are used."; };
            STRONG_MOTION_DETECTION = 1 { name = "Strong Motion Detection"; desc = "Strong motion detection and the large window are used."; };
        };

        field {
            name = "bmdtstrong";
            desc = "Motion detection strength control (U1)";
            sw = rw;
            hw = r;
            encode = ISP_WDR_MDT_CTRL_bmdtstrong_enum;
            reset = 0x0;
        } bmdtstrong[16:16];

        enum ISP_WDR_MDT_CTRL_balgprocmdt_enum {
            DISABLED = 0 { name = "Disabled"; desc = "disabled"; };
            ENABLED = 1 { name = "Enabled"; desc = "enabled"; };
        };

        field {
            name = "balgprocmdt";
            desc = "Motion detection enable (U1)";
            sw = rw;
            hw = r;
            encode = ISP_WDR_MDT_CTRL_balgprocmdt_enum;
            reset = 0x0;
        } balgprocmdt[0:0];
    } ISP_WDR_MDT_CTRL @ 0x16030;

    reg {
        name = "Inter-frame difference blending AX coefficient register";
        desc = "ISP_WDR_BLDRMDTMAX is an inter-frame difference blending coefficient register. Hi3516C V300/Hi3516E V100 Professional HD IP Camera SoC

Data sheet 10.6 ISP_WDR_BLDRMDTMAX (offset 0x26034, printed page 10-231, `hi3516cv300--Hi3516CV300-Hi3516EV100-Datasheet.txt` line 53659).";

        field {
            name = "bldrmdtmax";
            desc = "Blending coefficient of inter-frame difference average value filtering and maximum value filtering. The maximum value is 16 and the data format is U5.";
            sw = rw;
            hw = r;
            reset = 0x0;
        } bldrmdtmax[4:0];
    } ISP_WDR_BLDRMDTMAX @ 0x16034;

    reg {
        name = "Inter-frame difference threshold register";
        desc = "ISP_WDR_NOSCLIPTH is an inter-frame difference threshold register.

Data sheet 10.6 ISP_WDR_NOSCLIPTH (offset 0x26038, printed page 10-231, `hi3516cv300--Hi3516CV300-Hi3516EV100-Datasheet.txt` line 53681).";

        field {
            name = "nosclipth";
            desc = "Threshold when the inter-frame difference is clipped (U14) If the inter-frame difference of a certain point is lower than the threshold, it is clipped to 0.";
            sw = rw;
            hw = r;
            reset = 0x0;
        } nosclipth[13:0];
    } ISP_WDR_NOSCLIPTH @ 0x16038;

    reg {
        name = "Motion judgment coefficient register";
        desc = "ISP_WDR_NOSFACTOR is a motion judgment factor register. Hi3516C V300/Hi3516E V100 Professional HD IP Camera SoC

Data sheet 10.6 ISP_WDR_NOSFACTOR (offset 0x2603C, printed page 10-232, `hi3516cv300--Hi3516CV300-Hi3516EV100-Datasheet.txt` line 53712).";

        field {
            name = "nosfactor_low";
            desc = "Amplification factor corresponding to the lower threshold for motion judgment (U4.2)";
            sw = rw;
            hw = r;
            reset = 0x0;
        } nosfactor_low[21:16];

        field {
            name = "nosfactor_high";
            desc = "Amplification factor corresponding to the upper threshold for motion judgment (U4.2)";
            sw = rw;
            hw = r;
            reset = 0x0;
        } nosfactor_high[5:0];
    } ISP_WDR_NOSFACTOR @ 0x1603C;

    reg {
        name = "LUT update register E";
        desc = "ISP_WDR_LUT_UPDATE is an LUT update register.

Data sheet 10.6 ISP_WDR_LUT_UPDATE (offset 0x26040, printed page 10-232, `hi3516cv300--Hi3516CV300-Hi3516EV100-Datasheet.txt` line 53738).";

        field {
            name = "noslut_update";
            desc = "WDR noise LUT update control (U1). This bit is automatically cleared for each frame.";
            sw = rw;
            hw = r;
            reset = 0x0;
        } noslut_update[0:0];
    } ISP_WDR_LUT_UPDATE @ 0x16040;

    reg {
        name = "Motion region short frame denoising judgment threshold register";
        desc = "ISP_WDR_FSNRJUDGE is a motion region short frame denoising judgment threshold register. Hi3516C V300/Hi3516E V100 Professional HD IP Camera SoC

Data sheet 10.6 ISP_WDR_FSNRJUDGE (offset 0x26044, printed page 10-233, `hi3516cv300--Hi3516CV300-Hi3516EV100-Datasheet.txt` line 53776).";

        field {
            name = "fsnr_judge";
            desc = "Short frame denoising judgment threshold. The data format is U9 and the maximum value is 256. When the motion intensity is greater than this threshold, denoising is performed on short frames; otherwise, denoising is not performed.";
            sw = rw;
            hw = r;
            reset = 0x0;
        } fsnr_judge[8:0];
    } ISP_WDR_FSNRJUDGE @ 0x16044;

    reg {
        name = "Short frame denoising threshold register";
        desc = "ISP_WDR_FSNRTH is a short frame denoising threshold register.

Data sheet 10.6 ISP_WDR_FSNRTH (offset 0x26048, printed page 10-233, `hi3516cv300--Hi3516CV300-Hi3516EV100-Datasheet.txt` line 53800).";

        field {
            name = "fsnrth_low";
            desc = "Lower threshold of short frame denoising. The data format is U9 and the maximum value is 256.";
            sw = rw;
            hw = r;
            reset = 0x0;
        } fsnrth_low[24:16];

        field {
            name = "fsnrth_high";
            desc = "Upper threshold of short frame denoising. The data format is U9 and the maximum value is 256.";
            sw = rw;
            hw = r;
            reset = 0x0;
        } fsnrth_high[8:0];
    } ISP_WDR_FSNRTH @ 0x16048;

    reg {
        name = "Short frame denoising gain register";
        desc = "ISP_WDR_FSNRGN is a short frame denoising gain register. Hi3516C V300/Hi3516E V100 Professional HD IP Camera SoC

Data sheet 10.6 ISP_WDR_FSNRGN (offset 0x2604C, printed page 10-234, `hi3516cv300--Hi3516CV300-Hi3516EV100-Datasheet.txt` line 53835).";

        field {
            name = "fsnrgn_low";
            desc = "Lower gain of short frame denoising (U4.2)";
            sw = rw;
            hw = r;
            reset = 0x0;
        } fsnrgn_low[21:16];

        field {
            name = "fsnrgn_high";
            desc = "Upper gain of short frame denoising (U4.2)";
            sw = rw;
            hw = r;
            reset = 0x0;
        } fsnrgn_high[5:0];
    } ISP_WDR_FSNRGN @ 0x1604C;

    reg {
        name = "Motion judgment control register S";
        desc = "ISP_WDR_MDT_REFNOS is a motion judgment control register.

Data sheet 10.6 ISP_WDR_MDT_REFNOS (offset 0x26050, printed page 10-234, `hi3516cv300--Hi3516CV300-Hi3516EV100-Datasheet.txt` line 53857).";

        enum ISP_WDR_MDT_REFNOS_bmdtrefnos_enum {
            NO = 0 { name = "No"; desc = "no"; };
            YES = 1 { name = "Yes"; desc = "yes"; };
        };

        field {
            name = "bmdtrefnos";
            desc = "Whether the noise level is referenced during motion judgment (U1)";
            sw = rw;
            hw = r;
            encode = ISP_WDR_MDT_REFNOS_bmdtrefnos_enum;
            reset = 0x0;
        } bmdtrefnos[0:0];
    } ISP_WDR_MDT_REFNOS @ 0x16050;

    reg {
        name = "Noise LUT write address register DDR";
        desc = "ISP_WDR_NOSLUT_WADDR is a noise LUT write address register. Hi3516C V300/Hi3516E V100 Professional HD IP Camera SoC

Data sheet 10.6 ISP_WDR_NOSLUT_WADDR (offset 0x26080, printed page 10-235, `hi3516cv300--Hi3516CV300-Hi3516EV100-Datasheet.txt` line 53896).";

        field {
            name = "noslut_waddr";
            desc = "Write address of the noise LUT. The maximum value is 32 and the data format is U6.";
            sw = rw;
            hw = r;
            reset = 0x0;
        } noslut_waddr[5:0];
    } ISP_WDR_NOSLUT_WADDR @ 0x16080;

    reg {
        name = "Noise LUT write data register ATA";
        desc = "ISP_WDR_NOSLUT_WDATA is a noise LUT write data register.

Data sheet 10.6 ISP_WDR_NOSLUT_WDATA (offset 0x26084, printed page 10-235, `hi3516cv300--Hi3516CV300-Hi3516EV100-Datasheet.txt` line 53918).";

        field {
            name = "noslut_wdata";
            desc = "Write data of the noise LUT (U14)";
            sw = rw;
            hw = r;
            reset = 0x0;
        } noslut_wdata[13:0];
    } ISP_WDR_NOSLUT_WDATA @ 0x16084;

    reg {
        name = "Noise LUT read address register DDR";
        desc = "ISP_WDR_NOSLUT_RADDR is a noise LUT read address register.

Data sheet 10.6 ISP_WDR_NOSLUT_RADDR (offset 0x26088, printed page 10-235, `hi3516cv300--Hi3516CV300-Hi3516EV100-Datasheet.txt` line 53937).";

        field {
            name = "noslut_raddr";
            desc = "Read address of the noise LUT. The maximum value is 32 and the data format is U6.";
            sw = rw;
            hw = r;
            reset = 0x0;
        } noslut_raddr[5:0];
    } ISP_WDR_NOSLUT_RADDR @ 0x16088;

    reg {
        name = "Noise LUT read data register ATA";
        desc = "ISP_WDR_NOSLUT_RDATA is a noise LUT read data register.

Data sheet 10.6 ISP_WDR_NOSLUT_RDATA (offset 0x2608C, printed page 10-236, `hi3516cv300--Hi3516CV300-Hi3516EV100-Datasheet.txt` line 53964).";

        field {
            name = "noslut_rdata";
            desc = "Read data of the noise LUT (U14)";
            sw = r;
            hw = w;
            reset = 0x0;
        } noslut_rdata[13:0];
    } ISP_WDR_NOSLUT_RDATA @ 0x1608C;

    reg {
        name = "ISP WDR control F";
        desc = "[inferred] ISP WDR control F. Not in the data sheet. Source: OpenIPC openhisilicon `kernel/isp/arch/hi3516cv300/firmware/vreg/arch/hi3516cv300/isp_reg_define.h` (GPL-3.0 repository, HiSilicon copyright, nManager-generated 2015-12-22 \"Define all registers/tables for Hi3519\"; local copy sources/openhisilicon), union `U_ISP_WDR_CTRL_F`, struct offset 0x160E0 (GPL-3.0 repository; header offsets are ISP-core relative (data sheet offset - 0x20000), 632 of 775 data-sheet registers match it by name and offset (ISP_BLC_CFG is at 0x21100 in the data sheet and 0x1000+0x20000 in the header)). Reset value and access type unknown (modelled RW, no reset). Confidence: medium (vendor header for this chip family, not hardware verified).";

        field {
            name = "rggb_cfg";
            desc = "[inferred] Rggb configuration. (vendor header `isp_reg_define.h` field `rggb_cfg`; access and reset unknown, modelled RW)";
            sw = rw;
            hw = r;
        } rggb_cfg[1:0];
    } ISP_WDR_CTRL_F @ 0x160E0;

    reg {
        name = "ISP WDR control I";
        desc = "[inferred] ISP WDR control I. Not in the data sheet. Source: OpenIPC openhisilicon `kernel/isp/arch/hi3516cv300/firmware/vreg/arch/hi3516cv300/isp_reg_define.h` (GPL-3.0 repository, HiSilicon copyright, nManager-generated 2015-12-22 \"Define all registers/tables for Hi3519\"; local copy sources/openhisilicon), union `U_ISP_WDR_CTRL_I`, struct offset 0x160E4 (GPL-3.0 repository; header offsets are ISP-core relative (data sheet offset - 0x20000), 632 of 775 data-sheet registers match it by name and offset (ISP_BLC_CFG is at 0x21100 in the data sheet and 0x1000+0x20000 in the header)). Reset value and access type unknown (modelled RW, no reset). Confidence: medium (vendor header for this chip family, not hardware verified).";

        field {
            name = "update_mode";
            desc = "[inferred] Update mode. (vendor header `isp_reg_define.h` field `update_mode`; access and reset unknown, modelled RW)";
            sw = rw;
            hw = r;
        } update_mode[0:0];
    } ISP_WDR_CTRL_I @ 0x160E4;

    reg {
        name = "ISP WDR TIMING";
        desc = "[inferred] ISP WDR TIMING. Not in the data sheet. Source: OpenIPC openhisilicon `kernel/isp/arch/hi3516cv300/firmware/vreg/arch/hi3516cv300/isp_reg_define.h` (GPL-3.0 repository, HiSilicon copyright, nManager-generated 2015-12-22 \"Define all registers/tables for Hi3519\"; local copy sources/openhisilicon), union `U_ISP_WDR_TIMING`, struct offset 0x160E8 (GPL-3.0 repository; header offsets are ISP-core relative (data sheet offset - 0x20000), 632 of 775 data-sheet registers match it by name and offset (ISP_BLC_CFG is at 0x21100 in the data sheet and 0x1000+0x20000 in the header)). Reset value and access type unknown (modelled RW, no reset). Confidence: medium (vendor header for this chip family, not hardware verified).";

        field {
            name = "cpi_fix_timing_stat";
            desc = "[inferred] Cpi fix timing status. (vendor header `isp_reg_define.h` field `cpi_fix_timing_stat`; access and reset unknown, modelled RW)";
            sw = rw;
            hw = r;
        } cpi_fix_timing_stat[13:1];
    } ISP_WDR_TIMING @ 0x160E8;

    reg {
        name = "ISP WDR UPDATE";
        desc = "[inferred] ISP WDR UPDATE. Not in the data sheet. Source: OpenIPC openhisilicon `kernel/isp/arch/hi3516cv300/firmware/vreg/arch/hi3516cv300/isp_reg_define.h` (GPL-3.0 repository, HiSilicon copyright, nManager-generated 2015-12-22 \"Define all registers/tables for Hi3519\"; local copy sources/openhisilicon), union `U_ISP_WDR_UPDATE`, struct offset 0x160EC (GPL-3.0 repository; header offsets are ISP-core relative (data sheet offset - 0x20000), 632 of 775 data-sheet registers match it by name and offset (ISP_BLC_CFG is at 0x21100 in the data sheet and 0x1000+0x20000 in the header)). Reset value and access type unknown (modelled RW, no reset). Confidence: medium (vendor header for this chip family, not hardware verified).";

        field {
            name = "update";
            desc = "[inferred] Update. (vendor header `isp_reg_define.h` field `update`; access and reset unknown, modelled RW)";
            sw = rw;
            hw = r;
        } update[0:0];
    } ISP_WDR_UPDATE @ 0x160EC;

    reg {
        name = "WDR picture size register";
        desc = "ISP_WDR_SIZE is a WDR picture size register.

Data sheet 10.6 ISP_WDR_SIZE (offset 0x260F0, printed page 10-236, `hi3516cv300--Hi3516CV300-Hi3516EV100-Datasheet.txt` line 53984).";

        field {
            name = "height";
            desc = "Picture height The configured value is the actual value minus 1. For example, if the actual picture height is 720, set this field to 719.";
            sw = rw;
            hw = r;
            reset = 0x2CF;
        } height[28:16];

        field {
            name = "width";
            desc = "Picture width The configured value is the actual value minus 1. For example, if the actual picture width is 1280, set this field to 1279.";
            sw = rw;
            hw = r;
            reset = 0x4FF;
        } width[12:0];
    } ISP_WDR_SIZE @ 0x160F0;

    reg {
        name = "DRC configuration register";
        desc = "ISP_DRC_CFG is a DRC configuration register.

Data sheet 10.6 ISP_DRC_CFG (offset 0x26200, printed page 10-237, `hi3516cv300--Hi3516CV300-Hi3516EV100-Datasheet.txt` line 54024).";

        enum ISP_DRC_CFG_drc_en_enum {
            DISABLED = 0 { name = "Disabled"; desc = "disabled"; };
            ENABLED = 1 { name = "Enabled"; desc = "enabled"; };
        };

        field {
            name = "drc_en";
            desc = "DRC module enable";
            sw = rw;
            hw = r;
            encode = ISP_DRC_CFG_drc_en_enum;
            reset = 0x0;
        } drc_en[0:0];
    } ISP_DRC_CFG @ 0x16200;

    reg {
        name = "ISP DRC VERSION";
        desc = "[inferred] ISP DRC VERSION. Not in the data sheet. Source: OpenIPC openhisilicon `kernel/isp/arch/hi3516cv300/firmware/vreg/arch/hi3516cv300/isp_reg_define.h` (GPL-3.0 repository, HiSilicon copyright, nManager-generated 2015-12-22 \"Define all registers/tables for Hi3519\"; local copy sources/openhisilicon), union `U_ISP_DRC_VERSION`, struct offset 0x1620C (GPL-3.0 repository; header offsets are ISP-core relative (data sheet offset - 0x20000), 632 of 775 data-sheet registers match it by name and offset (ISP_BLC_CFG is at 0x21100 in the data sheet and 0x1000+0x20000 in the header)). Reset value and access type unknown (modelled RW, no reset). Confidence: medium (vendor header for this chip family, not hardware verified).";

        field {
            name = "version";
            desc = "[inferred] Version. (vendor header `isp_reg_define.h` field `version`; access and reset unknown, modelled RW)";
            sw = rw;
            hw = r;
        } version[31:0];
    } ISP_DRC_VERSION @ 0x1620C;

    reg {
        name = "DRC zone configuration register";
        desc = "ISP_DRC_ZONE is a DRC zone configuration register.

Data sheet 10.6 ISP_DRC_ZONE (offset 0x26210, printed page 10-237, `hi3516cv300--Hi3516CV300-Hi3516EV100-Datasheet.txt` line 54047).";

        field {
            name = "vnum";
            desc = "DRC vertical zone configuration";
            sw = rw;
            hw = r;
            reset = 0x15;
        } vnum[12:8];

        field {
            name = "hnum";
            desc = "DRC horizontal zone configuration";
            sw = rw;
            hw = r;
            reset = 0x19;
        } hnum[4:0];
    } ISP_DRC_ZONE @ 0x16210;

    reg {
        name = "DRC block size register";
        desc = "ISP_DRC_ZONE_SIZE is a DRC block size register.

Data sheet 10.6 ISP_DRC_ZONE_SIZE (offset 0x26214, printed page 10-238, `hi3516cv300--Hi3516CV300-Hi3516EV100-Datasheet.txt` line 54084).";

        field {
            name = "chk_y";
            desc = "The block sizes are unequal. chk_y = vsize%vnum";
            sw = rw;
            hw = r;
            reset = 0x9;
        } chk_y[29:25];

        field {
            name = "vsize";
            desc = "Height of each DRC block";
            sw = rw;
            hw = r;
            reset = 0x32;
        } vsize[24:16];

        field {
            name = "chk_x";
            desc = "The block sizes are unequal. chk_x = hsize%hnum";
            sw = rw;
            hw = r;
            reset = 0x14;
        } chk_x[13:9];

        field {
            name = "hsize";
            desc = "Width of each DRC block";
            sw = rw;
            hw = r;
            reset = 0x4B;
        } hsize[8:0];
    } ISP_DRC_ZONE_SIZE @ 0x16214;

    reg {
        name = "DRC block division coefficient register";
        desc = "ISP_DRC_ZONE_DIV0 is a DRC block division coefficient register. Hi3516C V300/Hi3516E V100 Professional HD IP Camera SoC

Data sheet 10.6 ISP_DRC_ZONE_DIV0 (offset 0x26218, printed page 10-239, `hi3516cv300--Hi3516CV300-Hi3516EV100-Datasheet.txt` line 54129).";

        field {
            name = "div_y";
            desc = "Reciprocal value of the height of each DRC block div_y = 32768/vsize";
            sw = rw;
            hw = r;
            reset = 0x283;
        } div_y[30:16];

        field {
            name = "div_x";
            desc = "Reciprocal value of the width of each DRC block div_x = 32768/hsize";
            sw = rw;
            hw = r;
            reset = 0x1AF;
        } div_x[14:0];
    } ISP_DRC_ZONE_DIV0 @ 0x16218;

    reg {
        name = "DRC block division coefficient register";
        desc = "ISP_DRC_ZONE_DIV1 is a DRC block division coefficient register.

Data sheet 10.6 ISP_DRC_ZONE_DIV1 (offset 0x2621C, printed page 10-239, `hi3516cv300--Hi3516CV300-Hi3516EV100-Datasheet.txt` line 54158).";

        field {
            name = "div_y";
            desc = "Reciprocal value of the height of each DRC block div_y = 32768/vsize";
            sw = rw;
            hw = r;
            reset = 0x276;
        } div_y[30:16];

        field {
            name = "div_x";
            desc = "Reciprocal value of the width of each DRC block div_x = 32768/hsize";
            sw = rw;
            hw = r;
            reset = 0x1AA;
        } div_x[14:0];
    } ISP_DRC_ZONE_DIV1 @ 0x1621C;

    reg {
        name = "DRC block histogram segment number register";
        desc = "ISP_DRC_BIN is a DRC block histogram segment number register.

Data sheet 10.6 ISP_DRC_BIN (offset 0x26220, printed page 10-240, `hi3516cv300--Hi3516CV300-Hi3516EV100-Datasheet.txt` line 54194).";

        field {
            name = "bin";
            desc = "Number of required histogram segments for each DRC block";
            sw = rw;
            hw = r;
            reset = 0xC;
        } bin[4:0];
    } ISP_DRC_BIN @ 0x16220;

    reg {
        name = "DRC histogram division coefficient register";
        desc = "ISP_DRC_BIN_DIV is a DRC histogram division coefficient register.

Data sheet 10.6 ISP_DRC_BIN_DIV (offset 0x26224, printed page 10-240, `hi3516cv300--Hi3516CV300-Hi3516EV100-Datasheet.txt` line 54216).";

        field {
            name = "div_z";
            desc = "Reciprocal value of the number of layers of each DRC block div_z = 32768/bin";
            sw = rw;
            hw = r;
            reset = 0xAAB;
        } div_z[14:0];
    } ISP_DRC_BIN_DIV @ 0x16224;

    reg {
        name = "DRC histogram scaling ratio register";
        desc = "ISP_DRC_BIN_SCALE is a DRC histogram scaling ratio register. Hi3516C V300/Hi3516E V100 Professional HD IP Camera SoC

Data sheet 10.6 ISP_DRC_BIN_SCALE (offset 0x26228, printed page 10-241, `hi3516cv300--Hi3516CV300-Hi3516EV100-Datasheet.txt` line 54247).";

        field {
            name = "bin_scale";
            desc = "DRC histogram statistics weight";
            sw = rw;
            hw = r;
            reset = 0x5;
        } bin_scale[2:0];
    } ISP_DRC_BIN_SCALE @ 0x16228;

    reg {
        name = "DRC value domain filtering COEF coefficient register";
        desc = "ISP_DRC_RANGE_FLT_COEF is a DRC value domain filtering coefficient register.

Data sheet 10.6 ISP_DRC_RANGE_FLT_COEF (offset 0x2622C, printed page 10-241, `hi3516cv300--Hi3516CV300-Hi3516EV100-Datasheet.txt` line 54274).";

        field {
            name = "range_flt_coef";
            desc = "The value range is 0-8.";
            sw = rw;
            hw = r;
            reset = 0x4;
        } range_flt_coef[3:0];
    } ISP_DRC_RANGE_FLT_COEF @ 0x1622C;

    reg {
        name = "DRC current frame exposure value register";
        desc = "ISP_DRC_EXPOSURE is a DRC current frame exposure ratio register. Hi3516C V300/Hi3516E V100 Professional HD IP Camera SoC

Data sheet 10.6 ISP_DRC_EXPOSURE (offset 0x26230, printed page 10-242, `hi3516cv300--Hi3516CV300-Hi3516EV100-Datasheet.txt` line 54302).";

        field {
            name = "exposure";
            desc = "Exposure ratio of the current DRC frame, for compensating bright- to-dark switching";
            sw = rw;
            hw = r;
            reset = 0x1000;
        } exposure[15:0];
    } ISP_DRC_EXPOSURE @ 0x16230;

    reg {
        name = "DRC local limit register _LMT";
        desc = "ISP_DRC_LOCAL_EDGE_LMT is a DRC local limit register.

Data sheet 10.6 ISP_DRC_LOCAL_EDGE_LMT (offset 0x26234, printed page 10-242, `hi3516cv300--Hi3516CV300-Hi3516EV100-Datasheet.txt` line 54324).";

        field {
            name = "local_edge_lmt";
            desc = "Limit on the input/output luminance difference of the dual-edge filter";
            sw = rw;
            hw = r;
            reset = 0x9B;
        } local_edge_lmt[7:0];
    } ISP_DRC_LOCAL_EDGE_LMT @ 0x16234;

    reg {
        name = "DRC strength adjustment register";
        desc = "ISP_DRC_STRENGTH is a DRC strength adjustment register.

Data sheet 10.6 ISP_DRC_STRENGTH (offset 0x26238, printed page 10-242, `hi3516cv300--Hi3516CV300-Hi3516EV100-Datasheet.txt` line 54345).";

        field {
            name = "strength";
            desc = "DRC strength";
            sw = rw;
            hw = r;
            reset = 0xFF;
        } strength[7:0];
    } ISP_DRC_STRENGTH @ 0x16238;

    reg {
        name = "DRC detail gain adjustment register";
        desc = "ISP_DRC_DETAIL_GAIN is a DRC detail gain adjustment register.

Data sheet 10.6 ISP_DRC_DETAIL_GAIN (offset 0x2623C, printed page 10-243, `hi3516cv300--Hi3516CV300-Hi3516EV100-Datasheet.txt` line 54369).";

        field {
            name = "detail_mixing_thresDetail";
            desc = "detail_mixing_thresDetail";
            sw = rw;
            hw = r;
            reset = 0x60;
        } detail_mixing_thresDetail[23:16];

        field {
            name = "detail_mixing_darkdetail_mixing_brig";
            desc = "Enhancement strength of the detail in dark regions";
            sw = rw;
            hw = r;
            reset = 0x80;
        } detail_mixing_darkdetail_mixing_brig[15:8];

        field {
            name = "detail_mixing_bright";
            desc = "Enhancement strength of the detail in bright regions";
            sw = rw;
            hw = r;
            reset = 0x10;
        } detail_mixing_bright[7:0];
    } ISP_DRC_DETAIL_GAIN @ 0x1623C;

    reg {
        name = "DRC dark region luminance limit LMT_Y register";
        desc = "ISP_DRC_DARK_GAIN_LMT_Y is a DRC dark region luminance limit register.

Data sheet 10.6 ISP_DRC_DARK_GAIN_LMT_Y (offset 0x26240, printed page 10-243, `hi3516cv300--Hi3516CV300-Hi3516EV100-Datasheet.txt` line 54393).";

        field {
            name = "sft2";
            desc = "Limit on the luminance gain of the dark region";
            sw = rw;
            hw = r;
            reset = 0x0;
        } sft2[15:14];

        field {
            name = "val2";
            desc = "Limit on the luminance gain of the dark region";
            sw = rw;
            hw = r;
            reset = 0x0;
        } val2[13:10];

        field {
            name = "sft1";
            desc = "Limit on the luminance gain of the dark region";
            sw = rw;
            hw = r;
            reset = 0x0;
        } sft1[9:7];

        field {
            name = "val1";
            desc = "Limit on the luminance gain of the dark region";
            sw = rw;
            hw = r;
            reset = 0x7F;
        } val1[6:0];
    } ISP_DRC_DARK_GAIN_LMT_Y @ 0x16240;

    reg {
        name = "DRC dark region chrominance limit LMT_C register";
        desc = "ISP_DRC_DARK_GAIN_LMT_C is a DRC dark region chrominance limit register. Hi3516C V300/Hi3516E V100 Professional HD IP Camera SoC

Data sheet 10.6 ISP_DRC_DARK_GAIN_LMT_C (offset 0x26244, printed page 10-244, `hi3516cv300--Hi3516CV300-Hi3516EV100-Datasheet.txt` line 54426).";

        field {
            name = "sft2";
            desc = "Limit on the chrominance gain of the dark region";
            sw = rw;
            hw = r;
            reset = 0x0;
        } sft2[15:14];

        field {
            name = "val2";
            desc = "Limit on the chrominance gain of the dark region";
            sw = rw;
            hw = r;
            reset = 0x0;
        } val2[13:10];

        field {
            name = "sft1";
            desc = "Limit on the chrominance gain of the dark region";
            sw = rw;
            hw = r;
            reset = 0x0;
        } sft1[9:7];

        field {
            name = "val1";
            desc = "Limit on the chrominance gain of the dark region";
            sw = rw;
            hw = r;
            reset = 0x7F;
        } val1[6:0];
    } ISP_DRC_DARK_GAIN_LMT_C @ 0x16244;

    reg {
        name = "DRC bright region limit register N_LMT";
        desc = "ISP_DRC_BRIGHT_GAIN_LMT is a DRC bright region limit register.

Data sheet 10.6 ISP_DRC_BRIGHT_GAIN_LMT (offset 0x26248, printed page 10-244, `hi3516cv300--Hi3516CV300-Hi3516EV100-Datasheet.txt` line 54451).";

        field {
            name = "sft";
            desc = "Limit on the bright region gain";
            sw = rw;
            hw = r;
            reset = 0x0;
        } sft[9:7];

        field {
            name = "val";
            desc = "Limit on the bright region gain";
            sw = rw;
            hw = r;
            reset = 0x7F;
        } val[6:0];
    } ISP_DRC_BRIGHT_GAIN_LMT @ 0x16248;

    reg {
        name = "DRC RGB weight configuration register";
        desc = "ISP_DRC_RGB_WGT is a DRC RGB weight configuration register. Hi3516C V300/Hi3516E V100 Professional HD IP Camera SoC

Data sheet 10.6 ISP_DRC_RGB_WGT (offset 0x2624C, printed page 10-245, `hi3516cv300--Hi3516CV300-Hi3516EV100-Datasheet.txt` line 54481).";

        field {
            name = "b_wgt";
            desc = "Weight of the B component";
            sw = rw;
            hw = r;
            reset = 0xE;
        } b_wgt[19:16];

        field {
            name = "g_wgt";
            desc = "Weight of the G component";
            sw = rw;
            hw = r;
            reset = 0x1F;
        } g_wgt[12:8];

        field {
            name = "r_wgt";
            desc = "Weight of the R component";
            sw = rw;
            hw = r;
            reset = 0x3;
        } r_wgt[3:0];
    } ISP_DRC_RGB_WGT @ 0x1624C;

    reg {
        name = "DRC TMLUT mix register TL";
        desc = "ISP_DRC_LUT_MIX_CRTL is a DRC TMLUT mix register.

Data sheet 10.6 ISP_DRC_LUT_MIX_CRTL (offset 0x26254, printed page 10-245, `hi3516cv300--Hi3516CV300-Hi3516EV100-Datasheet.txt` line 54508).";

        field {
            name = "lut_mix_ctrl";
            desc = "Mix ratio of LUT0 to LUT1";
            sw = rw;
            hw = r;
            reset = 0x80;
        } lut_mix_ctrl[7:0];
    } ISP_DRC_LUT_MIX_CRTL @ 0x16254;

    reg {
        name = "DRC gain limit register";
        desc = "ISP_DRC_GAIN_CLIP is a DRC gain limit register. Hi3516C V300/Hi3516E V100 Professional HD IP Camera SoC

Data sheet 10.6 ISP_DRC_GAIN_CLIP (offset 0x26258, printed page 10-246, `hi3516cv300--Hi3516CV300-Hi3516EV100-Datasheet.txt` line 54536).";

        field {
            name = "gain_clip_knee";
            desc = "Limit start point of the bright region gain";
            sw = rw;
            hw = r;
            reset = 0xA;
        } gain_clip_knee[7:4];

        field {
            name = "gain_clip_step";
            desc = "Limit range of the bright region gain";
            sw = rw;
            hw = r;
            reset = 0x6;
        } gain_clip_step[3:0];
    } ISP_DRC_GAIN_CLIP @ 0x16258;

    reg {
        name = "DRC color correction control register";
        desc = "ISP_DRC_COLOR_CTRL is a DRC color correction control register.

Data sheet 10.6 ISP_DRC_COLOR_CTRL (offset 0x2625C, printed page 10-246, `hi3516cv300--Hi3516CV300-Hi3516EV100-Datasheet.txt` line 54557).";

        enum ISP_DRC_COLOR_CTRL_cc_lin_pow_enum {
            LINEAR_MODE = 0 { name = "Linear Mode"; desc = "linear mode"; };
            POWER_LAW_MODE = 1 { name = "Power Law Mode"; desc = "power-law mode"; };
        };

        field {
            name = "cc_lin_pow";
            desc = "DRC color correction mode select";
            sw = rw;
            hw = r;
            encode = ISP_DRC_COLOR_CTRL_cc_lin_pow_enum;
            reset = 0x1;
        } cc_lin_pow[1:1];

        enum ISP_DRC_COLOR_CTRL_cc_lut_ctrl_enum {
            LOGIN_LUT = 0 { name = "Login Lut"; desc = "login LUT"; };
            LOGOUT_LUT = 1 { name = "Logout Lut"; desc = "logout LUT"; };
        };

        field {
            name = "cc_lut_ctrl";
            desc = "DRC color correction LUT mode select";
            sw = rw;
            hw = r;
            encode = ISP_DRC_COLOR_CTRL_cc_lut_ctrl_enum;
            reset = 0x1;
        } cc_lut_ctrl[0:0];
    } ISP_DRC_COLOR_CTRL @ 0x1625C;

    reg {
        name = "DRC global color correction register R";
        desc = "ISP_DRC_GLOBAL_CORR is a DRC global color correction register. Hi3516C V300/Hi3516E V100 Professional HD IP Camera SoC

Data sheet 10.6 ISP_DRC_GLOBAL_CORR (offset 0x26260, printed page 10-247, `hi3516cv300--Hi3516CV300-Hi3516EV100-Datasheet.txt` line 54597).";

        field {
            name = "cc_global_corr";
            desc = "Global color correction";
            sw = rw;
            hw = r;
            reset = 0x400;
        } cc_global_corr[11:0];
    } ISP_DRC_GLOBAL_CORR @ 0x16260;

    reg {
        name = "DRC detail threshold register NG";
        desc = "ISP_DRC_MIXING_CORING is a DRC detail threshold register.

Data sheet 10.6 ISP_DRC_MIXING_CORING (offset 0x26264, printed page 10-247, `hi3516cv300--Hi3516CV300-Hi3516EV100-Datasheet.txt` line 54617).";

        field {
            name = "mixing_coring";
            desc = "Detail threshold";
            sw = rw;
            hw = r;
            reset = 0x2;
        } mixing_coring[7:0];
    } ISP_DRC_MIXING_CORING @ 0x16264;

    reg {
        name = "DRC dark detail control register K";
        desc = "ISP_DRC_MIXING_DARK is a DRC dark detail control register.

Data sheet 10.6 ISP_DRC_MIXING_DARK (offset 0x26268, printed page 10-247, `hi3516cv300--Hi3516CV300-Hi3516EV100-Datasheet.txt` line 54636).";

        field {
            name = "dark_slo";
            desc = "Slope of the dark detail";
            sw = rw;
            hw = r;
            reset = 0x3;
        } dark_slo[26:24];

        field {
            name = "dark_thr";
            desc = "Threshold of the dark detail";
            sw = rw;
            hw = r;
            reset = 0x80;
        } dark_thr[23:16];

        field {
            name = "dark_max";
            desc = "Maximum value of the dark detail";
            sw = rw;
            hw = r;
            reset = 0x40;
        } dark_max[15:8];

        field {
            name = "dark_min";
            desc = "Minimum value of the dark detail";
            sw = rw;
            hw = r;
            reset = 0x2D;
        } dark_min[7:0];
    } ISP_DRC_MIXING_DARK @ 0x16268;

    reg {
        name = "DRC bright detail control register HT";
        desc = "ISP_DRC_MIXING_BRIGHT is a DRC bright detail control register.

Data sheet 10.6 ISP_DRC_MIXING_BRIGHT (offset 0x2626C, printed page 10-248, `hi3516cv300--Hi3516CV300-Hi3516EV100-Datasheet.txt` line 54672).";

        field {
            name = "bright_slo";
            desc = "Slope of the bright detail";
            sw = rw;
            hw = r;
            reset = 0x7;
        } bright_slo[26:24];

        field {
            name = "bright_thr";
            desc = "Threshold of the bright detail";
            sw = rw;
            hw = r;
            reset = 0x40;
        } bright_thr[23:16];

        field {
            name = "bright_max";
            desc = "Maximum value of the bright detail";
            sw = rw;
            hw = r;
            reset = 0x40;
        } bright_max[15:8];

        field {
            name = "bright_min";
            desc = "Minimum value of the bright detail";
            sw = rw;
            hw = r;
            reset = 0x2D;
        } bright_min[7:0];
    } ISP_DRC_MIXING_BRIGHT @ 0x1626C;

    reg {
        name = "DRC purple fringing detection condition R/G control register";
        desc = "ISP_DRC_RG_CTRL is a DRC purple fringing detection condition R/G control register. Hi3516C V300/Hi3516E V100 Professional HD IP Camera SoC

Data sheet 10.6 ISP_DRC_RG_CTRL (offset 0x26270, printed page 10-249, `hi3516cv300--Hi3516CV300-Hi3516EV100-Datasheet.txt` line 54711).";

        field {
            name = "rg_slo";
            desc = "R/G slope of purple fringing detection";
            sw = rw;
            hw = r;
            reset = 0x4;
        } rg_slo[18:16];

        field {
            name = "rg_wid";
            desc = "R/G width of purple fringing detection";
            sw = rw;
            hw = r;
            reset = 0x27;
        } rg_wid[14:8];

        field {
            name = "rg_ctr";
            desc = "R/G center point of purple fringing detection";
            sw = rw;
            hw = r;
            reset = 0x4A;
        } rg_ctr[7:0];
    } ISP_DRC_RG_CTRL @ 0x16270;

    reg {
        name = "DRC purple fringing detection condition B/G control register";
        desc = "ISP_DRC_BG_CTRL is a DRC purple fringing detection condition B/G control register.

Data sheet 10.6 ISP_DRC_BG_CTRL (offset 0x26274, printed page 10-249, `hi3516cv300--Hi3516CV300-Hi3516EV100-Datasheet.txt` line 54737).";

        field {
            name = "bg_slo";
            desc = "B/G slope of purple fringing detection";
            sw = rw;
            hw = r;
            reset = 0x2;
        } bg_slo[10:8];

        field {
            name = "bg_thr";
            desc = "B/G threshold of purple fringing detection";
            sw = rw;
            hw = r;
            reset = 0x59;
        } bg_thr[7:0];
    } ISP_DRC_BG_CTRL @ 0x16274;

    reg {
        name = "DRC purple fringing detection weight control register";
        desc = "ISP_DRC_PDW is a DRC purple fringing detection weight control register. Hi3516C V300/Hi3516E V100 Professional HD IP Camera SoC

Data sheet 10.6 ISP_DRC_PDW (offset 0x26278, printed page 10-250, `hi3516cv300--Hi3516CV300-Hi3516EV100-Datasheet.txt` line 54769).";

        field {
            name = "high_slo";
            desc = "High slope of the purple fringing detection weight";
            sw = rw;
            hw = r;
            reset = 0x8;
        } high_slo[27:24];

        field {
            name = "high_thr";
            desc = "High threshold of the purple fringing detection weight";
            sw = rw;
            hw = r;
            reset = 0x40;
        } high_thr[23:16];

        field {
            name = "low_slo";
            desc = "Low slope of the purple fringing detection weight";
            sw = rw;
            hw = r;
            reset = 0xC;
        } low_slo[11:8];

        field {
            name = "low_thr";
            desc = "Low threshold of the purple fringing detection weight";
            sw = rw;
            hw = r;
            reset = 0x28;
        } low_thr[7:0];
    } ISP_DRC_PDW @ 0x16278;

    reg {
        name = "DRC purple fringing detection weight statistics register";
        desc = "ISP_DRC_PPDTC_SUM is a DRC purple fringing detection weight statistics register.

Data sheet 10.6 ISP_DRC_PPDTC_SUM (offset 0x2627C, printed page 10-250, `hi3516cv300--Hi3516CV300-Hi3516EV100-Datasheet.txt` line 54793).";

        field {
            name = "ppdtc_sum";
            desc = "Purple fringing detection statistics";
            sw = r;
            hw = w;
            reset = 0x0;
        } ppdtc_sum[15:0];
    } ISP_DRC_PPDTC_SUM @ 0x1627C;

    reg {
        name = "DRC tone mapping table indirect ADDR0 write address 0 register";
        desc = "ISP_DRC_STAT_IND_WADDR0 is a DRC tone mapping table indirect write address 0 register. Hi3516C V300/Hi3516E V100 Professional HD IP Camera SoC

Data sheet 10.6 ISP_DRC_STAT_IND_WADDR0 (offset 0x26280, printed page 10-251, `hi3516cv300--Hi3516CV300-Hi3516EV100-Datasheet.txt` line 54823).";

        field {
            name = "drc_stat_ind_waddr";
            desc = "Tone mapping entry 0";
            sw = rw;
            hw = r;
            reset = 0x0;
        } drc_stat_ind_waddr[31:0];
    } ISP_DRC_STAT_IND_WADDR0 @ 0x16280;

    reg {
        name = "DRC tone mapping table indirect DATA0 write data 0 register";
        desc = "ISP_DRC_STAT_IND_WDATA0 is a DRC tone mapping table indirect write data 0 register.

Data sheet 10.6 ISP_DRC_STAT_IND_WDATA0 (offset 0x26284, printed page 10-251, `hi3516cv300--Hi3516CV300-Hi3516EV100-Datasheet.txt` line 54844).";

        field {
            name = "drc_stat_ind_wdata";
            desc = "Tone mapping entry 0";
            sw = w;
            hw = r;
            reset = 0x0;
        } drc_stat_ind_wdata[31:0];
    } ISP_DRC_STAT_IND_WDATA0 @ 0x16284;

    reg {
        name = "DRC tone mapping table indirect ADDR0 read address 0 register";
        desc = "ISP_DRC_STAT_IND_RADDR0 is a DRC tone mapping table indirect read address 0 register.

Data sheet 10.6 ISP_DRC_STAT_IND_RADDR0 (offset 0x26288, printed page 10-251, `hi3516cv300--Hi3516CV300-Hi3516EV100-Datasheet.txt` line 54866).";

        field {
            name = "drc_stat_ind_raddr";
            desc = "Tone mapping entry 0";
            sw = rw;
            hw = r;
            reset = 0x0;
        } drc_stat_ind_raddr[31:0];
    } ISP_DRC_STAT_IND_RADDR0 @ 0x16288;

    reg {
        name = "DRC tone mapping table indirect DATA0 read data 0 register";
        desc = "ISP_DRC_STAT_IND_RDATA0 is a DRC tone mapping table indirect read data 0 register.

Data sheet 10.6 ISP_DRC_STAT_IND_RDATA0 (offset 0x2628C, printed page 10-252, `hi3516cv300--Hi3516CV300-Hi3516EV100-Datasheet.txt` line 54893).";

        field {
            name = "drc_stat_ind_rdata0";
            desc = "Tone mapping entry 0";
            sw = r;
            hw = w;
            reset = 0x0;
        } drc_stat_ind_rdata0[31:0];
    } ISP_DRC_STAT_IND_RDATA0 @ 0x1628C;

    reg {
        name = "DRC tone mapping table indirect ADDR1 write address 1 register";
        desc = "ISP_DRC_STAT_IND_WADDR1 is a DRC tone mapping table indirect write address 1 register.

Data sheet 10.6 ISP_DRC_STAT_IND_WADDR1 (offset 0x26290, printed page 10-252, `hi3516cv300--Hi3516CV300-Hi3516EV100-Datasheet.txt` line 54913).";

        field {
            name = "drc_stat_ind_waddr";
            desc = "Tone mapping entry 1";
            sw = rw;
            hw = r;
            reset = 0x0;
        } drc_stat_ind_waddr[31:0];
    } ISP_DRC_STAT_IND_WADDR1 @ 0x16290;

    reg {
        name = "DRC tone mapping table indirect DATA1 write data 1 register";
        desc = "ISP_DRC_STAT_IND_WDATA1 is a DRC tone mapping table indirect write data 1 register.

Data sheet 10.6 ISP_DRC_STAT_IND_WDATA1 (offset 0x26294, printed page 10-252, `hi3516cv300--Hi3516CV300-Hi3516EV100-Datasheet.txt` line 54934).";

        field {
            name = "drc_stat_ind_wdata";
            desc = "Tone mapping entry 1";
            sw = w;
            hw = r;
            reset = 0x0;
        } drc_stat_ind_wdata[31:0];
    } ISP_DRC_STAT_IND_WDATA1 @ 0x16294;

    reg {
        name = "DRC tone mapping table indirect ADDR1 read address 1 register";
        desc = "ISP_DRC_STAT_IND_RADDR1 is a DRC tone mapping table indirect read address 1 register.

Data sheet 10.6 ISP_DRC_STAT_IND_RADDR1 (offset 0x26298, printed page 10-253, `hi3516cv300--Hi3516CV300-Hi3516EV100-Datasheet.txt` line 54960).";

        field {
            name = "drc_stat_ind_raddr";
            desc = "Tone mapping entry 1";
            sw = rw;
            hw = r;
            reset = 0x0;
        } drc_stat_ind_raddr[31:0];
    } ISP_DRC_STAT_IND_RADDR1 @ 0x16298;

    reg {
        name = "DRC tone mapping table indirect DATA1 read data 1 register";
        desc = "ISP_DRC_STAT_IND_RDATA1 is a DRC tone mapping table indirect read data 1 register.

Data sheet 10.6 ISP_DRC_STAT_IND_RDATA1 (offset 0x2629C, printed page 10-253, `hi3516cv300--Hi3516CV300-Hi3516EV100-Datasheet.txt` line 54980).";

        field {
            name = "drc_stat_ind_rdata1";
            desc = "Tone mapping entry 1";
            sw = r;
            hw = w;
            reset = 0x0;
        } drc_stat_ind_rdata1[31:0];
    } ISP_DRC_STAT_IND_RDATA1 @ 0x1629C;

    reg {
        name = "DRC color correct table indirect ADDR2 write address 2 register";
        desc = "ISP_DRC_STAT_IND_WADDR2 is a DRC color correct table indirect write address 2 register.

Data sheet 10.6 ISP_DRC_STAT_IND_WADDR2 (offset 0x262A0, printed page 10-253, `hi3516cv300--Hi3516CV300-Hi3516EV100-Datasheet.txt` line 55000).";

        field {
            name = "drc_stat_ind_waddr";
            desc = "Color correct entry";
            sw = rw;
            hw = r;
            reset = 0x0;
        } drc_stat_ind_waddr[31:0];
    } ISP_DRC_STAT_IND_WADDR2 @ 0x162A0;

    reg {
        name = "DRC color correct table indirect DATA2 write data 2 register";
        desc = "ISP_DRC_STAT_IND_WDATA2 is a DRC color correct table indirect write data 2 register.

Data sheet 10.6 ISP_DRC_STAT_IND_WDATA2 (offset 0x262A4, printed page 10-254, `hi3516cv300--Hi3516CV300-Hi3516EV100-Datasheet.txt` line 55025).";

        field {
            name = "drc_stat_ind_wdata";
            desc = "Color correct entry";
            sw = w;
            hw = r;
            reset = 0x0;
        } drc_stat_ind_wdata[31:0];
    } ISP_DRC_STAT_IND_WDATA2 @ 0x162A4;

    reg {
        name = "DRC color correct table indirect read ADDR2 address 2 register";
        desc = "ISP_DRC_STAT_IND_RADDR2 is a DRC color correct table indirect read address 2 register.

Data sheet 10.6 ISP_DRC_STAT_IND_RADDR2 (offset 0x262A8, printed page 10-254, `hi3516cv300--Hi3516CV300-Hi3516EV100-Datasheet.txt` line 55046).";

        field {
            name = "drc_stat_ind_raddr";
            desc = "Color correct entry";
            sw = rw;
            hw = r;
            reset = 0x0;
        } drc_stat_ind_raddr[31:0];
    } ISP_DRC_STAT_IND_RADDR2 @ 0x162A8;

    reg {
        name = "DRC color correct table indirect read DATA2 data 2 register";
        desc = "ISP_DRC_STAT_IND_RDATA2 is a DRC color correct table indirect read data 2 register.

Data sheet 10.6 ISP_DRC_STAT_IND_RDATA2 (offset 0x262AC, printed page 10-254, `hi3516cv300--Hi3516CV300-Hi3516EV100-Datasheet.txt` line 55067).";

        field {
            name = "drc_stat_ind_rdata2";
            desc = "Color correct entry";
            sw = r;
            hw = w;
            reset = 0x0;
        } drc_stat_ind_rdata2[31:0];
    } ISP_DRC_STAT_IND_RDATA2 @ 0x162AC;

    reg {
        name = "DRC gradient reverse adjustment register";
        desc = "ISP_DRC_GRAD_REV is a DRC gradient reverse adjustment register.

Data sheet 10.6 ISP_DRC_GRAD_REV (offset 0x26300, printed page 10-255, `hi3516cv300--Hi3516CV300-Hi3516EV100-Datasheet.txt` line 55091).";

        field {
            name = "grad_rev_shift";
            desc = "Gradient reverse adjustment";
            sw = rw;
            hw = r;
            reset = 0x2;
        } grad_rev_shift[26:24];

        field {
            name = "grad_rev_slope";
            desc = "Gradient reverse slope";
            sw = rw;
            hw = r;
            reset = 0xD;
        } grad_rev_slope[19:16];

        field {
            name = "grad_rev_max";
            desc = "Maximum value of the gradient reverse limit";
            sw = rw;
            hw = r;
            reset = 0x0;
        } grad_rev_max[14:8];

        field {
            name = "grad_rev_thres";
            desc = "Gradient reverse threshold";
            sw = rw;
            hw = r;
            reset = 0x29;
        } grad_rev_thres[7:0];
    } ISP_DRC_GRAD_REV @ 0x16300;

    reg {
        name = "DRC VBI filtering strength register TH";
        desc = "ISP_DRC_VBI_STRENGTH is a DRC VBI filtering strength register.

Data sheet 10.6 ISP_DRC_VBI_STRENGTH (offset 0x26304, printed page 10-255, `hi3516cv300--Hi3516CV300-Hi3516EV100-Datasheet.txt` line 55122).";

        field {
            name = "var_sap_coarse";
            desc = "Bilateral filtering spatial coarse strength";
            sw = rw;
            hw = r;
            reset = 0xA;
        } var_sap_coarse[23:20];

        field {
            name = "var_spa_medium";
            desc = "Bilateral filtering spatial medium strength";
            sw = rw;
            hw = r;
            reset = 0xA;
        } var_spa_medium[19:16];

        field {
            name = "var_spa_fine";
            desc = "Bilateral filtering spatial fine strength";
            sw = rw;
            hw = r;
            reset = 0x6;
        } var_spa_fine[15:12];

        field {
            name = "var_rng_coarse";
            desc = "Bilateral filtering range coarse strength";
            sw = rw;
            hw = r;
            reset = 0x6;
        } var_rng_coarse[11:8];

        field {
            name = "var_rng_medium";
            desc = "Bilateral filtering range medium strength";
            sw = rw;
            hw = r;
            reset = 0x6;
        } var_rng_medium[7:4];

        field {
            name = "var_rng_fine";
            desc = "Bilateral filtering range fine strength";
            sw = rw;
            hw = r;
            reset = 0x6;
        } var_rng_fine[3:0];
    } ISP_DRC_VBI_STRENGTH @ 0x16304;

    reg {
        name = "DRC VBI mixing strength register";
        desc = "ISP_DRC_VBI_MIXING is a DRC VBI mixing strength register.

Data sheet 10.6 ISP_DRC_VBI_MIXING (offset 0x26308, printed page 10-256, `hi3516cv300--Hi3516CV300-Hi3516EV100-Datasheet.txt` line 55157).";

        field {
            name = "bin_mix_coarse";
            desc = "Mixing ratio of coarse and medium strength";
            sw = rw;
            hw = r;
            reset = 0xD;
        } bin_mix_coarse[12:8];

        field {
            name = "bin_mix_medium";
            desc = "Mixing ratio of medium and fine strength";
            sw = rw;
            hw = r;
            reset = 0x6;
        } bin_mix_medium[4:0];
    } ISP_DRC_VBI_MIXING @ 0x16308;

    reg {
        name = "DRC VBI status indicator register";
        desc = "ISP_DRC_VBI_STATE is a DRC VBI status indicator register.

Data sheet 10.6 ISP_DRC_VBI_STATE (offset 0x26310, printed page 10-256, `hi3516cv300--Hi3516CV300-Hi3516EV100-Datasheet.txt` line 55183).";

        field {
            name = "vbi_state";
            desc = "VBI status indicator";
            sw = r;
            hw = w;
            reset = 0x1;
        } vbi_state[15:0];
    } ISP_DRC_VBI_STATE @ 0x16310;

    reg {
        name = "ISP DRC control F";
        desc = "[inferred] ISP DRC control F. Not in the data sheet. Source: OpenIPC openhisilicon `kernel/isp/arch/hi3516cv300/firmware/vreg/arch/hi3516cv300/isp_reg_define.h` (GPL-3.0 repository, HiSilicon copyright, nManager-generated 2015-12-22 \"Define all registers/tables for Hi3519\"; local copy sources/openhisilicon), union `U_ISP_DRC_CTRL_F`, struct offset 0x163E0 (GPL-3.0 repository; header offsets are ISP-core relative (data sheet offset - 0x20000), 632 of 775 data-sheet registers match it by name and offset (ISP_BLC_CFG is at 0x21100 in the data sheet and 0x1000+0x20000 in the header)). Reset value and access type unknown (modelled RW, no reset). Confidence: medium (vendor header for this chip family, not hardware verified).";

        field {
            name = "rggb_cfg";
            desc = "[inferred] Rggb configuration. (vendor header `isp_reg_define.h` field `rggb_cfg`; access and reset unknown, modelled RW)";
            sw = rw;
            hw = r;
        } rggb_cfg[1:0];
    } ISP_DRC_CTRL_F @ 0x163E0;

    reg {
        name = "ISP DRC control I";
        desc = "[inferred] ISP DRC control I. Not in the data sheet. Source: OpenIPC openhisilicon `kernel/isp/arch/hi3516cv300/firmware/vreg/arch/hi3516cv300/isp_reg_define.h` (GPL-3.0 repository, HiSilicon copyright, nManager-generated 2015-12-22 \"Define all registers/tables for Hi3519\"; local copy sources/openhisilicon), union `U_ISP_DRC_CTRL_I`, struct offset 0x163E4 (GPL-3.0 repository; header offsets are ISP-core relative (data sheet offset - 0x20000), 632 of 775 data-sheet registers match it by name and offset (ISP_BLC_CFG is at 0x21100 in the data sheet and 0x1000+0x20000 in the header)). Reset value and access type unknown (modelled RW, no reset). Confidence: medium (vendor header for this chip family, not hardware verified).";

        field {
            name = "update_mode";
            desc = "[inferred] Update mode. (vendor header `isp_reg_define.h` field `update_mode`; access and reset unknown, modelled RW)";
            sw = rw;
            hw = r;
        } update_mode[0:0];
    } ISP_DRC_CTRL_I @ 0x163E4;

    reg {
        name = "ISP DRC TIMING";
        desc = "[inferred] ISP DRC TIMING. Not in the data sheet. Source: OpenIPC openhisilicon `kernel/isp/arch/hi3516cv300/firmware/vreg/arch/hi3516cv300/isp_reg_define.h` (GPL-3.0 repository, HiSilicon copyright, nManager-generated 2015-12-22 \"Define all registers/tables for Hi3519\"; local copy sources/openhisilicon), union `U_ISP_DRC_TIMING`, struct offset 0x163E8 (GPL-3.0 repository; header offsets are ISP-core relative (data sheet offset - 0x20000), 632 of 775 data-sheet registers match it by name and offset (ISP_BLC_CFG is at 0x21100 in the data sheet and 0x1000+0x20000 in the header)). Reset value and access type unknown (modelled RW, no reset). Confidence: medium (vendor header for this chip family, not hardware verified).";

        field {
            name = "cpi_fix_timing_stat";
            desc = "[inferred] Cpi fix timing status. (vendor header `isp_reg_define.h` field `cpi_fix_timing_stat`; access and reset unknown, modelled RW)";
            sw = rw;
            hw = r;
        } cpi_fix_timing_stat[13:1];
    } ISP_DRC_TIMING @ 0x163E8;

    reg {
        name = "ISP DRC UPDATE";
        desc = "[inferred] ISP DRC UPDATE. Not in the data sheet. Source: OpenIPC openhisilicon `kernel/isp/arch/hi3516cv300/firmware/vreg/arch/hi3516cv300/isp_reg_define.h` (GPL-3.0 repository, HiSilicon copyright, nManager-generated 2015-12-22 \"Define all registers/tables for Hi3519\"; local copy sources/openhisilicon), union `U_ISP_DRC_UPDATE`, struct offset 0x163EC (GPL-3.0 repository; header offsets are ISP-core relative (data sheet offset - 0x20000), 632 of 775 data-sheet registers match it by name and offset (ISP_BLC_CFG is at 0x21100 in the data sheet and 0x1000+0x20000 in the header)). Reset value and access type unknown (modelled RW, no reset). Confidence: medium (vendor header for this chip family, not hardware verified).";

        field {
            name = "update";
            desc = "[inferred] Update. (vendor header `isp_reg_define.h` field `update`; access and reset unknown, modelled RW)";
            sw = rw;
            hw = r;
        } update[0:0];
    } ISP_DRC_UPDATE @ 0x163EC;

    reg {
        name = "DRC picture size register";
        desc = "ISP_DRC_SIZE is a DRC picture size register.

Data sheet 10.6 ISP_DRC_SIZE (offset 0x263F0, printed page 10-257, `hi3516cv300--Hi3516CV300-Hi3516EV100-Datasheet.txt` line 55209).";

        field {
            name = "vsize";
            desc = "DRC input picture height Note: The configured value is the actual value minus 1.";
            sw = rw;
            hw = r;
            reset = 0x437;
        } vsize[28:16];

        field {
            name = "hsize";
            desc = "DRC input picture width Note: The configured value is the actual value minus 1.";
            sw = rw;
            hw = r;
            reset = 0x77F;
        } hsize[12:0];
    } ISP_DRC_SIZE @ 0x163F0;

    reg {
        name = "Expander configuration register";
        desc = "ISP_EXPANDER_CFG is an expander configuration register.

Data sheet 10.6 ISP_EXPANDER_CFG (offset 0x26800, printed page 10-257, `hi3516cv300--Hi3516CV300-Hi3516EV100-Datasheet.txt` line 55238).";

        enum ISP_EXPANDER_CFG_en_enum {
            DISABLED = 0 { name = "Disabled"; desc = "disabled"; };
            ENABLED = 1 { name = "Enabled"; desc = "enabled"; };
        };

        field {
            name = "en";
            desc = "Expander enable";
            sw = rw;
            hw = r;
            encode = ISP_EXPANDER_CFG_en_enum;
            reset = 0x0;
        } en[0:0];
    } ISP_EXPANDER_CFG @ 0x16800;

    reg {
        name = "ISP EXPANDER VERSION";
        desc = "[inferred] ISP EXPANDER VERSION. Not in the data sheet. Source: OpenIPC openhisilicon `kernel/isp/arch/hi3516cv300/firmware/vreg/arch/hi3516cv300/isp_reg_define.h` (GPL-3.0 repository, HiSilicon copyright, nManager-generated 2015-12-22 \"Define all registers/tables for Hi3519\"; local copy sources/openhisilicon), union `U_ISP_EXPANDER_VERSION`, struct offset 0x1680C (GPL-3.0 repository; header offsets are ISP-core relative (data sheet offset - 0x20000), 632 of 775 data-sheet registers match it by name and offset (ISP_BLC_CFG is at 0x21100 in the data sheet and 0x1000+0x20000 in the header)). Reset value and access type unknown (modelled RW, no reset). Confidence: medium (vendor header for this chip family, not hardware verified).";

        field {
            name = "version";
            desc = "[inferred] Version. (vendor header `isp_reg_define.h` field `version`; access and reset unknown, modelled RW)";
            sw = rw;
            hw = r;
        } version[31:0];
    } ISP_EXPANDER_VERSION @ 0x1680C;

    reg {
        name = "Data bit width configuration register";
        desc = "ISP_EXPANDER_BITW is a data bit width configuration register. Hi3516C V300/Hi3516E V100 Professional HD IP Camera SoC

Data sheet 10.6 ISP_EXPANDER_BITW (offset 0x26810, printed page 10-258, `hi3516cv300--Hi3516CV300-Hi3516EV100-Datasheet.txt` line 55267).";

        enum ISP_EXPANDER_BITW_bitw_in_enum {
            V_12_BITS = 0xC { name = "V 12 Bits"; desc = "12 bits"; };
            V_14_BITS = 0xE { name = "V 14 Bits"; desc = "14 bits"; };
            V_16_BITS_OTHER = 0x10 { name = "V 16 Bits Other"; desc = "16 bits Other values: reserved"; };
        };

        field {
            name = "bitw_in";
            desc = "Bit width of the expander input data";
            sw = rw;
            hw = r;
            encode = ISP_EXPANDER_BITW_bitw_in_enum;
            reset = 0x0;
        } bitw_in[20:16];

        enum ISP_EXPANDER_BITW_bitw_out_enum {
            V_14_BITS = 0xE { name = "V 14 Bits"; desc = "14 bits"; };
            V_16_BITS = 0x10 { name = "V 16 Bits"; desc = "16 bits"; };
            V_18_BITS = 0x12 { name = "V 18 Bits"; desc = "18 bits"; };
            V_20_BITS_OTHER = 0x14 { name = "V 20 Bits Other"; desc = "20 bits Other values: reserved"; };
        };

        field {
            name = "bitw_out";
            desc = "Bit width of the expander output data";
            sw = rw;
            hw = r;
            encode = ISP_EXPANDER_BITW_bitw_out_enum;
            reset = 0x0;
        } bitw_out[4:0];
    } ISP_EXPANDER_BITW @ 0x16810;

    reg {
        name = "R channel data offset configuration TR register";
        desc = "ISP_EXPANDER_OFFSETR is an R channel data offset configuration register.

Data sheet 10.6 ISP_EXPANDER_OFFSETR (offset 0x26814, printed page 10-258, `hi3516cv300--Hi3516CV300-Hi3516EV100-Datasheet.txt` line 55299).";

        field {
            name = "offset_r";
            desc = "EXPANDER R channel data offset configuration";
            sw = rw;
            hw = r;
            reset = 0x0;
        } offset_r[19:0];
    } ISP_EXPANDER_OFFSETR @ 0x16814;

    reg {
        name = "Gr channel data offset configuration TGR register";
        desc = "ISP_EXPANDER_OFFSETGR is a Gr channel data offset configuration register. Hi3516C V300/Hi3516E V100 Professional HD IP Camera SoC

Data sheet 10.6 ISP_EXPANDER_OFFSETGR (offset 0x26818, printed page 10-259, `hi3516cv300--Hi3516CV300-Hi3516EV100-Datasheet.txt` line 55326).";

        field {
            name = "offset_gr";
            desc = "Expander Gr channel data offset configuration";
            sw = rw;
            hw = r;
            reset = 0x0;
        } offset_gr[19:0];
    } ISP_EXPANDER_OFFSETGR @ 0x16818;

    reg {
        name = "Gb channel data offset configuration TGB register";
        desc = "ISP_EXPANDER_OFFSETGB is a Gb channel data offset configuration register.

Data sheet 10.6 ISP_EXPANDER_OFFSETGB (offset 0x2681C, printed page 10-259, `hi3516cv300--Hi3516CV300-Hi3516EV100-Datasheet.txt` line 55346).";

        field {
            name = "offset_gb";
            desc = "Expander Gb channel data offset configuration";
            sw = rw;
            hw = r;
            reset = 0x0;
        } offset_gb[19:0];
    } ISP_EXPANDER_OFFSETGB @ 0x1681C;

    reg {
        name = "B channel data offset configuration TB register";
        desc = "ISP_EXPANDER_OFFSETB is a B channel data offset configuration register.

Data sheet 10.6 ISP_EXPANDER_OFFSETB (offset 0x26820, printed page 10-259, `hi3516cv300--Hi3516CV300-Hi3516EV100-Datasheet.txt` line 55365).";

        field {
            name = "offset_b";
            desc = "Expander B channel data offset configuration";
            sw = rw;
            hw = r;
            reset = 0x0;
        } offset_b[19:0];
    } ISP_EXPANDER_OFFSETB @ 0x16820;

    reg {
        name = "Indirect write address register R";
        desc = "ISP_EXPANDER_WADDR is an indirect write address register.

Data sheet 10.6 ISP_EXPANDER_WADDR (offset 0x26880, printed page 10-260, `hi3516cv300--Hi3516CV300-Hi3516EV100-Datasheet.txt` line 55391).";

        field {
            name = "expander_waddr";
            desc = "Write address of the 129-entry expander LUT";
            sw = rw;
            hw = r;
            reset = 0x0;
        } expander_waddr[31:0];
    } ISP_EXPANDER_WADDR @ 0x16880;

    reg {
        name = "Indirect write data register A";
        desc = "ISP_EXPANDER_WDATA is indirect write data register.

Data sheet 10.6 ISP_EXPANDER_WDATA (offset 0x26884, printed page 10-260, `hi3516cv300--Hi3516CV300-Hi3516EV100-Datasheet.txt` line 55410).";

        field {
            name = "expander_wdata";
            desc = "Write data of the 129-entry expander LUT";
            sw = rw;
            hw = r;
            reset = 0x0;
        } expander_wdata[31:0];
    } ISP_EXPANDER_WDATA @ 0x16884;

    reg {
        name = "Indirect read address register R";
        desc = "ISP_EXPANDER_RADDR is an indirect read address register.

Data sheet 10.6 ISP_EXPANDER_RADDR (offset 0x26888, printed page 10-260, `hi3516cv300--Hi3516CV300-Hi3516EV100-Datasheet.txt` line 55428).";

        field {
            name = "expander_raddr";
            desc = "Read address of the 129-entry expander LUT";
            sw = rw;
            hw = r;
            reset = 0x0;
        } expander_raddr[31:0];
    } ISP_EXPANDER_RADDR @ 0x16888;

    reg {
        name = "Indirect read data register A";
        desc = "ISP_EXPANDER_RDATA is indirect read data register.

Data sheet 10.6 ISP_EXPANDER_RDATA (offset 0x2688C, printed page 10-261, `hi3516cv300--Hi3516CV300-Hi3516EV100-Datasheet.txt` line 55453).";

        field {
            name = "expander_rdata";
            desc = "Read data of the 129-entry expander LUT";
            sw = r;
            hw = w;
            reset = 0x0;
        } expander_rdata[31:0];
    } ISP_EXPANDER_RDATA @ 0x1688C;

    reg {
        name = "ISP EXPANDER control F";
        desc = "[inferred] ISP EXPANDER control F. Not in the data sheet. Source: OpenIPC openhisilicon `kernel/isp/arch/hi3516cv300/firmware/vreg/arch/hi3516cv300/isp_reg_define.h` (GPL-3.0 repository, HiSilicon copyright, nManager-generated 2015-12-22 \"Define all registers/tables for Hi3519\"; local copy sources/openhisilicon), union `U_ISP_EXPANDER_CTRL_F`, struct offset 0x168E0 (GPL-3.0 repository; header offsets are ISP-core relative (data sheet offset - 0x20000), 632 of 775 data-sheet registers match it by name and offset (ISP_BLC_CFG is at 0x21100 in the data sheet and 0x1000+0x20000 in the header)). Reset value and access type unknown (modelled RW, no reset). Confidence: medium (vendor header for this chip family, not hardware verified).";

        field {
            name = "rggb_cfg";
            desc = "[inferred] Rggb configuration. (vendor header `isp_reg_define.h` field `rggb_cfg`; access and reset unknown, modelled RW)";
            sw = rw;
            hw = r;
        } rggb_cfg[1:0];
    } ISP_EXPANDER_CTRL_F @ 0x168E0;

    reg {
        name = "ISP EXPANDER control I";
        desc = "[inferred] ISP EXPANDER control I. Not in the data sheet. Source: OpenIPC openhisilicon `kernel/isp/arch/hi3516cv300/firmware/vreg/arch/hi3516cv300/isp_reg_define.h` (GPL-3.0 repository, HiSilicon copyright, nManager-generated 2015-12-22 \"Define all registers/tables for Hi3519\"; local copy sources/openhisilicon), union `U_ISP_EXPANDER_CTRL_I`, struct offset 0x168E4 (GPL-3.0 repository; header offsets are ISP-core relative (data sheet offset - 0x20000), 632 of 775 data-sheet registers match it by name and offset (ISP_BLC_CFG is at 0x21100 in the data sheet and 0x1000+0x20000 in the header)). Reset value and access type unknown (modelled RW, no reset). Confidence: medium (vendor header for this chip family, not hardware verified).";

        field {
            name = "update_mode";
            desc = "[inferred] Update mode. (vendor header `isp_reg_define.h` field `update_mode`; access and reset unknown, modelled RW)";
            sw = rw;
            hw = r;
        } update_mode[0:0];
    } ISP_EXPANDER_CTRL_I @ 0x168E4;

    reg {
        name = "ISP EXPANDER UPDATE";
        desc = "[inferred] ISP EXPANDER UPDATE. Not in the data sheet. Source: OpenIPC openhisilicon `kernel/isp/arch/hi3516cv300/firmware/vreg/arch/hi3516cv300/isp_reg_define.h` (GPL-3.0 repository, HiSilicon copyright, nManager-generated 2015-12-22 \"Define all registers/tables for Hi3519\"; local copy sources/openhisilicon), union `U_ISP_EXPANDER_UPDATE`, struct offset 0x168EC (GPL-3.0 repository; header offsets are ISP-core relative (data sheet offset - 0x20000), 632 of 775 data-sheet registers match it by name and offset (ISP_BLC_CFG is at 0x21100 in the data sheet and 0x1000+0x20000 in the header)). Reset value and access type unknown (modelled RW, no reset). Confidence: medium (vendor header for this chip family, not hardware verified).";

        field {
            name = "update";
            desc = "[inferred] Update. (vendor header `isp_reg_define.h` field `update`; access and reset unknown, modelled RW)";
            sw = rw;
            hw = r;
        } update[0:0];
    } ISP_EXPANDER_UPDATE @ 0x168EC;

    reg {
        name = "BCOM enable register";
        desc = "ISP_BCOM_CFG is a BCOM enable register.

Data sheet 10.6 ISP_BCOM_CFG (offset 0x26C00, printed page 10-261, `hi3516cv300--Hi3516CV300-Hi3516EV100-Datasheet.txt` line 55472).";

        enum ISP_BCOM_CFG_en_enum {
            DISABLED = 0 { name = "Disabled"; desc = "disabled"; };
            ENABLED = 1 { name = "Enabled"; desc = "enabled"; };
        };

        field {
            name = "en";
            desc = "BCOM enable";
            sw = rw;
            hw = r;
            encode = ISP_BCOM_CFG_en_enum;
            reset = 0x0;
        } en[0:0];
    } ISP_BCOM_CFG @ 0x16C00;

    reg {
        name = "ISP BCOM VERSION";
        desc = "[inferred] ISP BCOM VERSION. Not in the data sheet. Source: OpenIPC openhisilicon `kernel/isp/arch/hi3516cv300/firmware/vreg/arch/hi3516cv300/isp_reg_define.h` (GPL-3.0 repository, HiSilicon copyright, nManager-generated 2015-12-22 \"Define all registers/tables for Hi3519\"; local copy sources/openhisilicon), union `U_ISP_BCOM_VERSION`, struct offset 0x16C0C (GPL-3.0 repository; header offsets are ISP-core relative (data sheet offset - 0x20000), 632 of 775 data-sheet registers match it by name and offset (ISP_BLC_CFG is at 0x21100 in the data sheet and 0x1000+0x20000 in the header)). Reset value and access type unknown (modelled RW, no reset). Confidence: medium (vendor header for this chip family, not hardware verified).";

        field {
            name = "version";
            desc = "[inferred] Version. (vendor header `isp_reg_define.h` field `version`; access and reset unknown, modelled RW)";
            sw = rw;
            hw = r;
        } version[31:0];
    } ISP_BCOM_VERSION @ 0x16C0C;

    reg {
        name = "Alpha coefficient register";
        desc = "ISP_BCOM_ALPHA is an alpha coefficient register. Hi3516C V300/Hi3516E V100 Professional HD IP Camera SoC

Data sheet 10.6 ISP_BCOM_ALPHA (offset 0x26C10, printed page 10-262, `hi3516cv300--Hi3516CV300-Hi3516EV100-Datasheet.txt` line 55502).";

        field {
            name = "alpha";
            desc = "Alpha coefficient The value ranges from 0 to 6.";
            sw = rw;
            hw = r;
            reset = 0x0;
        } alpha[2:0];
    } ISP_BCOM_ALPHA @ 0x16C10;

    reg {
        name = "ISP BCOM control I";
        desc = "[inferred] ISP BCOM control I. Not in the data sheet. Source: OpenIPC openhisilicon `kernel/isp/arch/hi3516cv300/firmware/vreg/arch/hi3516cv300/isp_reg_define.h` (GPL-3.0 repository, HiSilicon copyright, nManager-generated 2015-12-22 \"Define all registers/tables for Hi3519\"; local copy sources/openhisilicon), union `U_ISP_BCOM_CTRL_I`, struct offset 0x16CE4 (GPL-3.0 repository; header offsets are ISP-core relative (data sheet offset - 0x20000), 632 of 775 data-sheet registers match it by name and offset (ISP_BLC_CFG is at 0x21100 in the data sheet and 0x1000+0x20000 in the header)). Reset value and access type unknown (modelled RW, no reset). Confidence: medium (vendor header for this chip family, not hardware verified).";

        field {
            name = "update_mode";
            desc = "[inferred] Update mode. (vendor header `isp_reg_define.h` field `update_mode`; access and reset unknown, modelled RW)";
            sw = rw;
            hw = r;
        } update_mode[0:0];
    } ISP_BCOM_CTRL_I @ 0x16CE4;

    reg {
        name = "ISP BCOM UPDATE";
        desc = "[inferred] ISP BCOM UPDATE. Not in the data sheet. Source: OpenIPC openhisilicon `kernel/isp/arch/hi3516cv300/firmware/vreg/arch/hi3516cv300/isp_reg_define.h` (GPL-3.0 repository, HiSilicon copyright, nManager-generated 2015-12-22 \"Define all registers/tables for Hi3519\"; local copy sources/openhisilicon), union `U_ISP_BCOM_UPDATE`, struct offset 0x16CEC (GPL-3.0 repository; header offsets are ISP-core relative (data sheet offset - 0x20000), 632 of 775 data-sheet registers match it by name and offset (ISP_BLC_CFG is at 0x21100 in the data sheet and 0x1000+0x20000 in the header)). Reset value and access type unknown (modelled RW, no reset). Confidence: medium (vendor header for this chip family, not hardware verified).";

        field {
            name = "update";
            desc = "[inferred] Update. (vendor header `isp_reg_define.h` field `update`; access and reset unknown, modelled RW)";
            sw = rw;
            hw = r;
        } update[0:0];
    } ISP_BCOM_UPDATE @ 0x16CEC;

    reg {
        name = "BDEC enable register";
        desc = "ISP_BDEC_CFG is a BDEC enable register.

Data sheet 10.6 ISP_BDEC_CFG (offset 0x26D00, printed page 10-262, `hi3516cv300--Hi3516CV300-Hi3516EV100-Datasheet.txt` line 55525).";

        enum ISP_BDEC_CFG_en_enum {
            DISABLED = 0 { name = "Disabled"; desc = "disabled"; };
            ENABLED = 1 { name = "Enabled"; desc = "enabled"; };
        };

        field {
            name = "en";
            desc = "BDEC enable";
            sw = rw;
            hw = r;
            encode = ISP_BDEC_CFG_en_enum;
            reset = 0x0;
        } en[0:0];
    } ISP_BDEC_CFG @ 0x16D00;

    reg {
        name = "ISP BDEC VERSION";
        desc = "[inferred] ISP BDEC VERSION. Not in the data sheet. Source: OpenIPC openhisilicon `kernel/isp/arch/hi3516cv300/firmware/vreg/arch/hi3516cv300/isp_reg_define.h` (GPL-3.0 repository, HiSilicon copyright, nManager-generated 2015-12-22 \"Define all registers/tables for Hi3519\"; local copy sources/openhisilicon), union `U_ISP_BDEC_VERSION`, struct offset 0x16D0C (GPL-3.0 repository; header offsets are ISP-core relative (data sheet offset - 0x20000), 632 of 775 data-sheet registers match it by name and offset (ISP_BLC_CFG is at 0x21100 in the data sheet and 0x1000+0x20000 in the header)). Reset value and access type unknown (modelled RW, no reset). Confidence: medium (vendor header for this chip family, not hardware verified).";

        field {
            name = "version";
            desc = "[inferred] Version. (vendor header `isp_reg_define.h` field `version`; access and reset unknown, modelled RW)";
            sw = rw;
            hw = r;
        } version[31:0];
    } ISP_BDEC_VERSION @ 0x16D0C;

    reg {
        name = "Alpha coefficient register";
        desc = "ISP_BDEC_ALPHA is an alpha coefficient register. Hi3516C V300/Hi3516E V100 Professional HD IP Camera SoC

Data sheet 10.6 ISP_BDEC_ALPHA (offset 0x26D10, printed page 10-263, `hi3516cv300--Hi3516CV300-Hi3516EV100-Datasheet.txt` line 55555).";

        field {
            name = "alpha";
            desc = "Alpha coefficient The value ranges from 0 to 6.";
            sw = rw;
            hw = r;
            reset = 0x0;
        } alpha[2:0];
    } ISP_BDEC_ALPHA @ 0x16D10;

    reg {
        name = "ISP BDEC control I";
        desc = "[inferred] ISP BDEC control I. Not in the data sheet. Source: OpenIPC openhisilicon `kernel/isp/arch/hi3516cv300/firmware/vreg/arch/hi3516cv300/isp_reg_define.h` (GPL-3.0 repository, HiSilicon copyright, nManager-generated 2015-12-22 \"Define all registers/tables for Hi3519\"; local copy sources/openhisilicon), union `U_ISP_BDEC_CTRL_I`, struct offset 0x16DE4 (GPL-3.0 repository; header offsets are ISP-core relative (data sheet offset - 0x20000), 632 of 775 data-sheet registers match it by name and offset (ISP_BLC_CFG is at 0x21100 in the data sheet and 0x1000+0x20000 in the header)). Reset value and access type unknown (modelled RW, no reset). Confidence: medium (vendor header for this chip family, not hardware verified).";

        field {
            name = "update_mode";
            desc = "[inferred] Update mode. (vendor header `isp_reg_define.h` field `update_mode`; access and reset unknown, modelled RW)";
            sw = rw;
            hw = r;
        } update_mode[0:0];
    } ISP_BDEC_CTRL_I @ 0x16DE4;

    reg {
        name = "ISP BDEC UPDATE";
        desc = "[inferred] ISP BDEC UPDATE. Not in the data sheet. Source: OpenIPC openhisilicon `kernel/isp/arch/hi3516cv300/firmware/vreg/arch/hi3516cv300/isp_reg_define.h` (GPL-3.0 repository, HiSilicon copyright, nManager-generated 2015-12-22 \"Define all registers/tables for Hi3519\"; local copy sources/openhisilicon), union `U_ISP_BDEC_UPDATE`, struct offset 0x16DEC (GPL-3.0 repository; header offsets are ISP-core relative (data sheet offset - 0x20000), 632 of 775 data-sheet registers match it by name and offset (ISP_BLC_CFG is at 0x21100 in the data sheet and 0x1000+0x20000 in the header)). Reset value and access type unknown (modelled RW, no reset). Confidence: medium (vendor header for this chip family, not hardware verified).";

        field {
            name = "update";
            desc = "[inferred] Update. (vendor header `isp_reg_define.h` field `update`; access and reset unknown, modelled RW)";
            sw = rw;
            hw = r;
        } update[0:0];
    } ISP_BDEC_UPDATE @ 0x16DEC;

    reg {
        name = "WDRSPLIT configuration register";
        desc = "ISP_WDRSPLIT_CFG is a WDRSPLIT configuration register.

Data sheet 10.6 ISP_WDRSPLIT_CFG (offset 0x26E00, printed page 10-263, `hi3516cv300--Hi3516CV300-Hi3516EV100-Datasheet.txt` line 55578).";

        enum ISP_WDRSPLIT_CFG_en_enum {
            DISABLED = 0 { name = "Disabled"; desc = "disabled"; };
            ENABLED = 1 { name = "Enabled"; desc = "enabled"; };
        };

        field {
            name = "en";
            desc = "WDRSPLIT enable";
            sw = rw;
            hw = r;
            encode = ISP_WDRSPLIT_CFG_en_enum;
            reset = 0x0;
        } en[0:0];
    } ISP_WDRSPLIT_CFG @ 0x16E00;

    reg {
        name = "ISP WDRSPLIT VERSION";
        desc = "[inferred] ISP WDRSPLIT VERSION. Not in the data sheet. Source: OpenIPC openhisilicon `kernel/isp/arch/hi3516cv300/firmware/vreg/arch/hi3516cv300/isp_reg_define.h` (GPL-3.0 repository, HiSilicon copyright, nManager-generated 2015-12-22 \"Define all registers/tables for Hi3519\"; local copy sources/openhisilicon), union `U_ISP_WDRSPLIT_VERSION`, struct offset 0x16E0C (GPL-3.0 repository; header offsets are ISP-core relative (data sheet offset - 0x20000), 632 of 775 data-sheet registers match it by name and offset (ISP_BLC_CFG is at 0x21100 in the data sheet and 0x1000+0x20000 in the header)). Reset value and access type unknown (modelled RW, no reset). Confidence: medium (vendor header for this chip family, not hardware verified).";

        field {
            name = "version";
            desc = "[inferred] Version. (vendor header `isp_reg_define.h` field `version`; access and reset unknown, modelled RW)";
            sw = rw;
            hw = r;
        } version[31:0];
    } ISP_WDRSPLIT_VERSION @ 0x16E0C;

    reg {
        name = "Data bit width configuration register";
        desc = "ISP_WDRSPLIT_BITW is a data bit width configuration register. Hi3516C V300/Hi3516E V100 Professional HD IP Camera SoC

Data sheet 10.6 ISP_WDRSPLIT_BITW (offset 0x26E10, printed page 10-264, `hi3516cv300--Hi3516CV300-Hi3516EV100-Datasheet.txt` line 55608).";

        enum ISP_WDRSPLIT_BITW_bitw_in_enum {
            V_12_BIT_INPUT = 0xC { name = "V 12 Bit Input"; desc = "12-bit input"; };
            V_14_BIT_INPUT = 0xE { name = "V 14 Bit Input"; desc = "14-bit input"; };
            V_16_BIT_INPUT = 0x10 { name = "V 16 Bit Input"; desc = "16-bit input"; };
            V_20_BIT_INPUT = 0x14 { name = "V 20 Bit Input"; desc = "20-bit input Other values: reserved Note: The value 0x14 is supported only when mode_in is linear."; };
        };

        field {
            name = "bitw_in";
            desc = "Bit width of WDRSPLIT input data";
            sw = rw;
            hw = r;
            encode = ISP_WDRSPLIT_BITW_bitw_in_enum;
            reset = 0x0;
        } bitw_in[20:16];

        enum ISP_WDRSPLIT_BITW_bitw_out_enum {
            V_12_BIT_OUTPUT = 0xC { name = "V 12 Bit Output"; desc = "12-bit output"; };
            V_13_BIT_OUTPUT = 0xD { name = "V 13 Bit Output"; desc = "13-bit output"; };
            V_14_BIT_OUTPUT = 0xE { name = "V 14 Bit Output"; desc = "14-bit output"; };
            V_15_BIT_OUTPUT = 0xF { name = "V 15 Bit Output"; desc = "15-bit output"; };
            V_16_BIT_OUTPUT = 0x10 { name = "V 16 Bit Output"; desc = "16-bit output"; };
            V_17_BIT_OUTPUT = 0x11 { name = "V 17 Bit Output"; desc = "17-bit output"; };
            V_18_BIT_OUTPUT = 0x12 { name = "V 18 Bit Output"; desc = "18-bit output"; };
            V_19_BIT_OUTPUT = 0x13 { name = "V 19 Bit Output"; desc = "19-bit output"; };
            V_20_BIT_OUTPUT = 0x14 { name = "V 20 Bit Output"; desc = "20-bit output Other values: reserved"; };
        };

        field {
            name = "bitw_out";
            desc = "Bit width of decompressed WDRSPLIT data";
            sw = rw;
            hw = r;
            encode = ISP_WDRSPLIT_BITW_bitw_out_enum;
            reset = 0x0;
        } bitw_out[4:0];
    } ISP_WDRSPLIT_BITW @ 0x16E10;

    reg {
        name = "Mode configuration register";
        desc = "ISP_WDRSPLIT_MODE is a mode configuration register. Hi3516C V300/Hi3516E V100 Professional HD IP Camera SoC

Data sheet 10.6 ISP_WDRSPLIT_MODE (offset 0x26E14, printed page 10-265, `hi3516cv300--Hi3516CV300-Hi3516EV100-Datasheet.txt` line 55655).";

        enum ISP_WDRSPLIT_MODE_mode_in_enum {
            LINEAR_MODE = 0 { name = "Linear Mode"; desc = "linear mode"; };
            V_2_3MUX_MODE = 1 { name = "V 2 3Mux Mode"; desc = "2-3mux mode"; };
            LOG_MODE = 2 { name = "Log Mode"; desc = "LOG mode"; };
            SENSOR_BUILT_MODE = 3 { name = "Sensor Built Mode"; desc = "sensor built-in mode"; };
        };

        field {
            name = "mode_in";
            desc = "WDRSPLIT input data mode";
            sw = rw;
            hw = r;
            encode = ISP_WDRSPLIT_MODE_mode_in_enum;
            reset = 0x0;
        } mode_in[5:4];

        enum ISP_WDRSPLIT_MODE_mode_out_enum {
            V_1_CHANNEL_OUTPUT = 0 { name = "V 1 Channel Output"; desc = "1-channel output"; };
            V_2_CHANNEL_OUTPUT = 1 { name = "V 2 Channel Output"; desc = "2-channel output"; };
            V_3_CHANNEL_OUTPUT = 2 { name = "V 3 Channel Output"; desc = "3-channel output"; };
            V_4_CHANNEL_OUTPUT = 3 { name = "V 4 Channel Output"; desc = "4-channel output"; };
        };

        field {
            name = "mode_out";
            desc = "WDRSPLIT output data mode";
            sw = rw;
            hw = r;
            encode = ISP_WDRSPLIT_MODE_mode_out_enum;
            reset = 0x0;
        } mode_out[1:0];
    } ISP_WDRSPLIT_MODE @ 0x16E14;

    reg {
        name = "R channel data offset configuration R register";
        desc = "ISP_WDRSPLIT_OFFSETR is an R channel data offset configuration register.

Data sheet 10.6 ISP_WDRSPLIT_OFFSETR (offset 0x26E20, printed page 10-265, `hi3516cv300--Hi3516CV300-Hi3516EV100-Datasheet.txt` line 55689).";

        field {
            name = "offset_r";
            desc = "offset_r";
            sw = rw;
            hw = r;
            reset = 0x0;
        } offset_r[19:0];
    } ISP_WDRSPLIT_OFFSETR @ 0x16E20;

    reg {
        name = "GR channel data offset configuration GR register";
        desc = "ISP_WDRSPLIT_OFFSETGR is a Gr channel data offset configuration register.

Data sheet 10.6 ISP_WDRSPLIT_OFFSETGR (offset 0x26E24, printed page 10-266, `hi3516cv300--Hi3516CV300-Hi3516EV100-Datasheet.txt` line 55715).";

        field {
            name = "offset_gr";
            desc = "offset_gr";
            sw = rw;
            hw = r;
            reset = 0x0;
        } offset_gr[19:0];
    } ISP_WDRSPLIT_OFFSETGR @ 0x16E24;

    reg {
        name = "GB channel data offset configuration GB register";
        desc = "ISP_WDRSPLIT_OFFSETGB is a Gb channel data offset configuration register.

Data sheet 10.6 ISP_WDRSPLIT_OFFSETGB (offset 0x26E28, printed page 10-266, `hi3516cv300--Hi3516CV300-Hi3516EV100-Datasheet.txt` line 55735).";

        field {
            name = "offset_gb";
            desc = "offset_gb";
            sw = rw;
            hw = r;
            reset = 0x0;
        } offset_gb[19:0];
    } ISP_WDRSPLIT_OFFSETGB @ 0x16E28;

    reg {
        name = "B channel data offset configuration B register";
        desc = "ISP_WDRSPLIT_OFFSETB is a B channel data offset configuration register.

Data sheet 10.6 ISP_WDRSPLIT_OFFSETB (offset 0x26E2C, printed page 10-266, `hi3516cv300--Hi3516CV300-Hi3516EV100-Datasheet.txt` line 55754).";

        field {
            name = "offset_b";
            desc = "offset_b";
            sw = rw;
            hw = r;
            reset = 0x0;
        } offset_b[19:0];
    } ISP_WDRSPLIT_OFFSETB @ 0x16E2C;

    reg {
        name = "B channel data offset configuration register";
        desc = "ISP_WDRSPLIT_BLC is a B channel data offset configuration register.

Data sheet 10.6 ISP_WDRSPLIT_BLC (offset 0x26E30, printed page 10-267, `hi3516cv300--Hi3516CV300-Hi3516EV100-Datasheet.txt` line 55783).";

        field {
            name = "BLC";
            desc = "BLC offset of the WDRSPLIT output";
            sw = rw;
            hw = r;
            reset = 0x0;
        } BLC[19:0];
    } ISP_WDRSPLIT_BLC @ 0x16E30;

    reg {
        name = "Indirect write address register R";
        desc = "ISP_WDRSPLIT_WADDR is an indirect write address register.

Data sheet 10.6 ISP_WDRSPLIT_WADDR (offset 0x26E80, printed page 10-267, `hi3516cv300--Hi3516CV300-Hi3516EV100-Datasheet.txt` line 55803).";

        field {
            name = "wdrsplit_waddr";
            desc = "Write address of the 129-entry WDRSPLIT LUT";
            sw = rw;
            hw = r;
            reset = 0x0;
        } wdrsplit_waddr[31:0];
    } ISP_WDRSPLIT_WADDR @ 0x16E80;

    reg {
        name = "Indirect write data register A";
        desc = "ISP_WDRSPLIT_WDATA is an indirect write data register. Hi3516C V300/Hi3516E V100 Professional HD IP Camera SoC

Data sheet 10.6 ISP_WDRSPLIT_WDATA (offset 0x26E84, printed page 10-268, `hi3516cv300--Hi3516CV300-Hi3516EV100-Datasheet.txt` line 55830).";

        field {
            name = "wdrsplit_wdata";
            desc = "Write data of the 129-entry WDRSPLIT LUT";
            sw = rw;
            hw = r;
            reset = 0x0;
        } wdrsplit_wdata[31:0];
    } ISP_WDRSPLIT_WDATA @ 0x16E84;

    reg {
        name = "Indirect read address register";
        desc = "ISP_WDRSPLIT_RADDR is an indirect read address register.

Data sheet 10.6 ISP_WDRSPLIT_RADDR (offset 0x26E88, printed page 10-268, `hi3516cv300--Hi3516CV300-Hi3516EV100-Datasheet.txt` line 55849).";

        field {
            name = "wdrsplit_raddr";
            desc = "Read address of the 129-entry WDRSPLIT LUT";
            sw = rw;
            hw = r;
            reset = 0x0;
        } wdrsplit_raddr[31:0];
    } ISP_WDRSPLIT_RADDR @ 0x16E88;

    reg {
        name = "Indirect read data register";
        desc = "ISP_WDRSPLIT_RDATA is an indirect read data register.

Data sheet 10.6 ISP_WDRSPLIT_RDATA (offset 0x26E8C, printed page 10-268, `hi3516cv300--Hi3516CV300-Hi3516EV100-Datasheet.txt` line 55867).";

        field {
            name = "wdrsplit_rdata";
            desc = "Read data of the 129-entry WDRSPLIT LUT";
            sw = r;
            hw = w;
            reset = 0x0;
        } wdrsplit_rdata[31:0];
    } ISP_WDRSPLIT_RDATA @ 0x16E8C;

    reg {
        name = "ISP WDRSPLIT control F";
        desc = "[inferred] ISP WDRSPLIT control F. Not in the data sheet. Source: OpenIPC openhisilicon `kernel/isp/arch/hi3516cv300/firmware/vreg/arch/hi3516cv300/isp_reg_define.h` (GPL-3.0 repository, HiSilicon copyright, nManager-generated 2015-12-22 \"Define all registers/tables for Hi3519\"; local copy sources/openhisilicon), union `U_ISP_WDRSPLIT_CTRL_F`, struct offset 0x16EE0 (GPL-3.0 repository; header offsets are ISP-core relative (data sheet offset - 0x20000), 632 of 775 data-sheet registers match it by name and offset (ISP_BLC_CFG is at 0x21100 in the data sheet and 0x1000+0x20000 in the header)). Reset value and access type unknown (modelled RW, no reset). Confidence: medium (vendor header for this chip family, not hardware verified).";

        field {
            name = "rggb_cfg";
            desc = "[inferred] Rggb configuration. (vendor header `isp_reg_define.h` field `rggb_cfg`; access and reset unknown, modelled RW)";
            sw = rw;
            hw = r;
        } rggb_cfg[1:0];
    } ISP_WDRSPLIT_CTRL_F @ 0x16EE0;

    reg {
        name = "ISP WDRSPLIT control I";
        desc = "[inferred] ISP WDRSPLIT control I. Not in the data sheet. Source: OpenIPC openhisilicon `kernel/isp/arch/hi3516cv300/firmware/vreg/arch/hi3516cv300/isp_reg_define.h` (GPL-3.0 repository, HiSilicon copyright, nManager-generated 2015-12-22 \"Define all registers/tables for Hi3519\"; local copy sources/openhisilicon), union `U_ISP_WDRSPLIT_CTRL_I`, struct offset 0x16EE4 (GPL-3.0 repository; header offsets are ISP-core relative (data sheet offset - 0x20000), 632 of 775 data-sheet registers match it by name and offset (ISP_BLC_CFG is at 0x21100 in the data sheet and 0x1000+0x20000 in the header)). Reset value and access type unknown (modelled RW, no reset). Confidence: medium (vendor header for this chip family, not hardware verified).";

        field {
            name = "update_mode";
            desc = "[inferred] Update mode. (vendor header `isp_reg_define.h` field `update_mode`; access and reset unknown, modelled RW)";
            sw = rw;
            hw = r;
        } update_mode[0:0];
    } ISP_WDRSPLIT_CTRL_I @ 0x16EE4;

    reg {
        name = "ISP WDRSPLIT UPDATE";
        desc = "[inferred] ISP WDRSPLIT UPDATE. Not in the data sheet. Source: OpenIPC openhisilicon `kernel/isp/arch/hi3516cv300/firmware/vreg/arch/hi3516cv300/isp_reg_define.h` (GPL-3.0 repository, HiSilicon copyright, nManager-generated 2015-12-22 \"Define all registers/tables for Hi3519\"; local copy sources/openhisilicon), union `U_ISP_WDRSPLIT_UPDATE`, struct offset 0x16EEC (GPL-3.0 repository; header offsets are ISP-core relative (data sheet offset - 0x20000), 632 of 775 data-sheet registers match it by name and offset (ISP_BLC_CFG is at 0x21100 in the data sheet and 0x1000+0x20000 in the header)). Reset value and access type unknown (modelled RW, no reset). Confidence: medium (vendor header for this chip family, not hardware verified).";

        field {
            name = "update";
            desc = "[inferred] Update. (vendor header `isp_reg_define.h` field `update`; access and reset unknown, modelled RW)";
            sw = rw;
            hw = r;
        } update[0:0];
    } ISP_WDRSPLIT_UPDATE @ 0x16EEC;

    reg {
        name = "AEWDR0 enable register";
        desc = "ISP_AEWDR0_CFG is an AEWDR0 enable register. Hi3516C V300/Hi3516E V100 Professional HD IP Camera SoC

Data sheet 10.6 ISP_AEWDR0_CFG (offset 0x29000, printed page 10-269, `hi3516cv300--Hi3516CV300-Hi3516EV100-Datasheet.txt` line 55895).";

        enum ISP_AEWDR0_CFG_en_enum {
            DISABLED = 0 { name = "Disabled"; desc = "disabled"; };
            ENABLED = 1 { name = "Enabled"; desc = "enabled"; };
        };

        field {
            name = "en";
            desc = "AEWDR0 enable";
            sw = rw;
            hw = r;
            encode = ISP_AEWDR0_CFG_en_enum;
            reset = 0x0;
        } en[0:0];
    } ISP_AEWDR0_CFG @ 0x19000;

    reg {
        name = "AEWDR0 zone configuration register";
        desc = "ISP_AEWDR0_ZONE is an AEWDR0 zone configuration register.

Data sheet 10.6 ISP_AEWDR0_ZONE (offset 0x29010, printed page 10-269, `hi3516cv300--Hi3516CV300-Hi3516EV100-Datasheet.txt` line 55917).";

        field {
            name = "vnum";
            desc = "Number of zones in the vertical direction";
            sw = rw;
            hw = r;
            reset = 0x0;
        } vnum[12:8];

        field {
            name = "hnum";
            desc = "Number of zones in the horizontal direction";
            sw = rw;
            hw = r;
            reset = 0x0;
        } hnum[4:0];
    } ISP_AEWDR0_ZONE @ 0x19010;

    reg {
        name = "AEWDR0 pixel select configuration G register";
        desc = "ISP_AEWDR0_SKIP_CRG is an AEWDR0 point select configuration register. Hi3516C V300/Hi3516E V100 Professional HD IP Camera SoC

Data sheet 10.6 ISP_AEWDR0_SKIP_CRG (offset 0x29014, printed page 10-270, `hi3516cv300--Hi3516CV300-Hi3516EV100-Datasheet.txt` line 55951).";

        enum ISP_AEWDR0_SKIP_CRG_offset_y_enum {
            COUNT_FROM_ROW = 0 { name = "Count From Row"; desc = "count from row 0"; };
            COUNT_FROM_ROW_2 = 1 { name = "Count From Row 2"; desc = "count from row 1"; };
        };

        field {
            name = "offset_y";
            desc = "Count start row";
            sw = rw;
            hw = r;
            encode = ISP_AEWDR0_SKIP_CRG_offset_y_enum;
            reset = 0x0;
        } offset_y[7:7];

        enum ISP_AEWDR0_SKIP_CRG_skip_y_enum {
            COUNTED_EACH_PIXEL = 0 { name = "Counted Each Pixel"; desc = "counted for each pixel point"; };
            COUNTED_EVERY_TWO = 1 { name = "Counted Every Two"; desc = "counted for every two pixels"; };
            COUNTED_EVERY_THREE = 2 { name = "Counted Every Three"; desc = "counted for every three pixels"; };
            COUNTED_EVERY_FOUR = 3 { name = "Counted Every Four"; desc = "counted for every four pixels"; };
            COUNTED_EVERY_FIVE = 4 { name = "Counted Every Five"; desc = "counted for every five pixels"; };
            COUNTED_EVERY_EIGHT = 5 { name = "Counted Every Eight"; desc = "counted for every eight pixels 110 or above: counted for every nine pixels"; };
        };

        field {
            name = "skip_y";
            desc = "Vertical point skip for statistics";
            sw = rw;
            hw = r;
            encode = ISP_AEWDR0_SKIP_CRG_skip_y_enum;
            reset = 0x0;
        } skip_y[6:4];

        enum ISP_AEWDR0_SKIP_CRG_offset_x_enum {
            COUNT_FROM_COLUMN = 0 { name = "Count From Column"; desc = "count from column 0"; };
            COUNT_FROM_COLUMN_2 = 1 { name = "Count From Column 2"; desc = "count from column 1"; };
        };

        field {
            name = "offset_x";
            desc = "Count start column";
            sw = rw;
            hw = r;
            encode = ISP_AEWDR0_SKIP_CRG_offset_x_enum;
            reset = 0x0;
        } offset_x[3:3];

        enum ISP_AEWDR0_SKIP_CRG_skip_x_enum {
            COUNTED_EVERY_TWO = 0 { name = "Counted Every Two"; desc = "counted for every two pixels"; };
            COUNTED_EVERY_THREE = 1 { name = "Counted Every Three"; desc = "counted for every three pixels"; };
            COUNTED_EVERY_FOUR = 2 { name = "Counted Every Four"; desc = "counted for every four pixels"; };
            COUNTED_EVERY_FIVE = 3 { name = "Counted Every Five"; desc = "counted for every five pixels"; };
            COUNTED_EVERY_EIGHT = 4 { name = "Counted Every Eight"; desc = "counted for every eight pixels 101 or above: counted for every nine pixels"; };
        };

        field {
            name = "skip_x";
            desc = "Horizontal point skip for statistics";
            sw = rw;
            hw = r;
            encode = ISP_AEWDR0_SKIP_CRG_skip_x_enum;
            reset = 0x0;
        } skip_x[2:0];
    } ISP_AEWDR0_SKIP_CRG @ 0x19014;

    reg {
        name = "Selected pixel count register in a TAT frame during 256 histogram statistics";
        desc = "ISP_AEWDR0_TOTAL_STAT is a selected pixel count register in a frame during 256 histogram statistics. Hi3516C V300/Hi3516E V100 Professional HD IP Camera SoC

Data sheet 10.6 ISP_AEWDR0_TOTAL_STAT (offset 0x29018, printed page 10-271, `hi3516cv300--Hi3516CV300-Hi3516EV100-Datasheet.txt` line 56005).";

        field {
            name = "total_pixels";
            desc = "Number of selected pixels in a frame during 256 histogram statistics";
            sw = r;
            hw = w;
            reset = 0x0;
        } total_pixels[23:0];
    } ISP_AEWDR0_TOTAL_STAT @ 0x19018;

    reg {
        name = "Selected pixel weight count register TAT in a frame during 256 histogram statistics";
        desc = "ISP_AEWDR0_COUNT_STAT is a selected pixel weight count register in a frame during 256 histogram statistics.

Data sheet 10.6 ISP_AEWDR0_COUNT_STAT (offset 0x2901C, printed page 10-271, `hi3516cv300--Hi3516CV300-Hi3516EV100-Datasheet.txt` line 56028).";

        field {
            name = "count_pixels";
            desc = "Total weight of the selected pixels in a frame during 256 histogram statistics";
            sw = r;
            hw = w;
            reset = 0x0;
        } count_pixels[27:0];
    } ISP_AEWDR0_COUNT_STAT @ 0x1901C;

    reg {
        name = "Histogram statistics high register H";
        desc = "ISP_AEWDR0_HIST_HIGH is a histogram statistics high register.

Data sheet 10.6 ISP_AEWDR0_HIST_HIGH (offset 0x29030, printed page 10-271, `hi3516cv300--Hi3516CV300-Hi3516EV100-Datasheet.txt` line 56050).";

        field {
            name = "hist_high";
            desc = "Upper bits in histogram statistics";
            sw = r;
            hw = w;
            reset = 0x0;
        } hist_high[31:0];
    } ISP_AEWDR0_HIST_HIGH @ 0x19030;

    reg {
        name = "AEWDR0 pixel shift register E";
        desc = "ISP_AEWDR0_BITMOVE is an AEWDR0 pixel shift register.

Data sheet 10.6 ISP_AEWDR0_BITMOVE (offset 0x29040, printed page 10-272, `hi3516cv300--Hi3516CV300-Hi3516EV100-Datasheet.txt` line 56073).";

        enum ISP_AEWDR0_BITMOVE_BLC_en_enum {
            DISABLED = 0 { name = "Disabled"; desc = "disabled"; };
            ENABLED = 1 { name = "Enabled"; desc = "enabled"; };
        };

        field {
            name = "BLC_en";
            desc = "AEWDR0 BLC enable";
            sw = rw;
            hw = r;
            encode = ISP_AEWDR0_BITMOVE_BLC_en_enum;
            reset = 0x0;
        } BLC_en[9:9];

        field {
            name = "bitmove";
            desc = "AEWDR0 pixel shift value";
            sw = rw;
            hw = r;
            reset = 0x0;
        } bitmove[4:0];
    } ISP_AEWDR0_BITMOVE @ 0x19040;

    reg {
        name = "R component black level offset R register";
        desc = "ISP_AEWDR0_OFFSET_R is an R component black level offset register.

Data sheet 10.6 ISP_AEWDR0_OFFSET_R (offset 0x29044, printed page 10-272, `hi3516cv300--Hi3516CV300-Hi3516EV100-Datasheet.txt` line 56098).";

        field {
            name = "offset_r";
            desc = "Black level offset";
            sw = rw;
            hw = r;
            reset = 0x0;
        } offset_r[14:0];
    } ISP_AEWDR0_OFFSET_R @ 0x19044;

    reg {
        name = "Gr component black level offset GR register";
        desc = "ISP_AEWDR0_OFFSET_GR is a Gr component black level offset register. Hi3516C V300/Hi3516E V100 Professional HD IP Camera SoC

Data sheet 10.6 ISP_AEWDR0_OFFSET_GR (offset 0x29048, printed page 10-273, `hi3516cv300--Hi3516CV300-Hi3516EV100-Datasheet.txt` line 56126).";

        field {
            name = "offset_gr";
            desc = "Black level offset";
            sw = rw;
            hw = r;
            reset = 0x0;
        } offset_gr[14:0];
    } ISP_AEWDR0_OFFSET_GR @ 0x19048;

    reg {
        name = "Gb component black level offset GB register";
        desc = "ISP_AEWDR0_OFFSET_GB is a Gb component black level offset register.

Data sheet 10.6 ISP_AEWDR0_OFFSET_GB (offset 0x2904C, printed page 10-273, `hi3516cv300--Hi3516CV300-Hi3516EV100-Datasheet.txt` line 56146).";

        field {
            name = "offset_gb";
            desc = "Black level offset";
            sw = rw;
            hw = r;
            reset = 0x0;
        } offset_gb[14:0];
    } ISP_AEWDR0_OFFSET_GB @ 0x1904C;

    reg {
        name = "B component black level offset B register";
        desc = "ISP_AEWDR0_OFFSET_B is a B component black level offset register.

Data sheet 10.6 ISP_AEWDR0_OFFSET_B (offset 0x29050, printed page 10-273, `hi3516cv300--Hi3516CV300-Hi3516EV100-Datasheet.txt` line 56165).";

        field {
            name = "offset_b";
            desc = "Black level offset";
            sw = rw;
            hw = r;
            reset = 0x0;
        } offset_b[14:0];
    } ISP_AEWDR0_OFFSET_B @ 0x19050;

    reg {
        name = "AEWDR0 histogram statistics read T_RADDR address register";
        desc = "ISP_AEWDR0_MEM_HIST_RADDR is an AEWDR0 histogram statistics read address register.

Data sheet 10.6 ISP_AEWDR0_MEM_HIST_RADDR (offset 0x29088, printed page 10-274, `hi3516cv300--Hi3516CV300-Hi3516EV100-Datasheet.txt` line 56192).";

        field {
            name = "hist_raddr";
            desc = "Read address of histogram statistics";
            sw = rw;
            hw = r;
            reset = 0x0;
        } hist_raddr[31:0];
    } ISP_AEWDR0_MEM_HIST_RADDR @ 0x19088;

    reg {
        name = "AEWDR0 histogram statistics read T_RDATA data register";
        desc = "ISP_AEWDR0_MEM_HIST_RDATA is an AEWDR0 histogram statistics read data register. [check] The data-sheet table extraction produced overlapping bit fields for this register; the overlapping entries wei_waddr[31:0], wei_wdata[31:0] were dropped - verify against the printed page.

Data sheet 10.6 ISP_AEWDR0_MEM_HIST_RDATA (offset 0x2908C, printed page 10-274, `hi3516cv300--Hi3516CV300-Hi3516EV100-Datasheet.txt` line 56210).";

        field {
            name = "hist_rdata";
            desc = "hist_rdata";
            sw = r;
            hw = w;
            reset = 0x0;
        } hist_rdata[31:0];
    } ISP_AEWDR0_MEM_HIST_RDATA @ 0x1908C;

    reg {
        name = "AEWDR0 picture size register";
        desc = "ISP_AEWDR0_SIZE is an AEWDR0 picture size register.

Data sheet 10.6 ISP_AEWDR0_SIZE (offset 0x290F0, printed page 10-275, `hi3516cv300--Hi3516CV300-Hi3516EV100-Datasheet.txt` line 56278).";

        field {
            name = "vsize";
            desc = "Picture height";
            sw = rw;
            hw = r;
            reset = 0x437;
        } vsize[28:16];

        field {
            name = "hsize";
            desc = "Picture width";
            sw = rw;
            hw = r;
            reset = 0x77F;
        } hsize[12:0];
    } ISP_AEWDR0_SIZE @ 0x190F0;

    reg {
        name = "AEWDR1 enable register";
        desc = "ISP_AEWDR1_CFG is an AEWDR1 enable register. Hi3516C V300/Hi3516E V100 Professional HD IP Camera SoC

Data sheet 10.6 ISP_AEWDR1_CFG (offset 0x29100, printed page 10-276, `hi3516cv300--Hi3516CV300-Hi3516EV100-Datasheet.txt` line 56313).";

        enum ISP_AEWDR1_CFG_en_enum {
            DISABLED = 0 { name = "Disabled"; desc = "disabled"; };
            ENABLED = 1 { name = "Enabled"; desc = "enabled"; };
        };

        field {
            name = "en";
            desc = "AEWDR1 enable";
            sw = rw;
            hw = r;
            encode = ISP_AEWDR1_CFG_en_enum;
            reset = 0x0;
        } en[0:0];
    } ISP_AEWDR1_CFG @ 0x19100;

    reg {
        name = "AEWDR1 zone configuration register";
        desc = "ISP_AEWDR1_ZONE is an AEWDR1 zone configuration register.

Data sheet 10.6 ISP_AEWDR1_ZONE (offset 0x29110, printed page 10-276, `hi3516cv300--Hi3516CV300-Hi3516EV100-Datasheet.txt` line 56335).";

        field {
            name = "vnum";
            desc = "Number of zones in the vertical direction";
            sw = rw;
            hw = r;
            reset = 0x0;
        } vnum[12:8];

        field {
            name = "hnum";
            desc = "Number of zones in the horizontal direction";
            sw = rw;
            hw = r;
            reset = 0x0;
        } hnum[4:0];
    } ISP_AEWDR1_ZONE @ 0x19110;

    reg {
        name = "AEWDR1 pixel select configuration G register";
        desc = "ISP_AEWDR1_SKIP_CRG is an AEWDR1 point select configuration register. Hi3516C V300/Hi3516E V100 Professional HD IP Camera SoC

Data sheet 10.6 ISP_AEWDR1_SKIP_CRG (offset 0x29114, printed page 10-277, `hi3516cv300--Hi3516CV300-Hi3516EV100-Datasheet.txt` line 56369).";

        enum ISP_AEWDR1_SKIP_CRG_offset_y_enum {
            COUNT_FROM_ROW = 0 { name = "Count From Row"; desc = "count from row 0"; };
            COUNT_FROM_ROW_2 = 1 { name = "Count From Row 2"; desc = "count from row 1"; };
        };

        field {
            name = "offset_y";
            desc = "Count start row";
            sw = rw;
            hw = r;
            encode = ISP_AEWDR1_SKIP_CRG_offset_y_enum;
            reset = 0x0;
        } offset_y[7:7];

        enum ISP_AEWDR1_SKIP_CRG_skip_y_enum {
            COUNTED_EACH_PIXEL = 0 { name = "Counted Each Pixel"; desc = "counted for each pixel point"; };
            COUNTED_EVERY_TWO = 1 { name = "Counted Every Two"; desc = "counted for every two pixels"; };
            COUNTED_EVERY_THREE = 2 { name = "Counted Every Three"; desc = "counted for every three pixels"; };
            COUNTED_EVERY_FOUR = 3 { name = "Counted Every Four"; desc = "counted for every four pixels"; };
            COUNTED_EVERY_FIVE = 4 { name = "Counted Every Five"; desc = "counted for every five pixels"; };
            COUNTED_EVERY_EIGHT = 5 { name = "Counted Every Eight"; desc = "counted for every eight pixels 110 or above: counted for every nine pixels"; };
        };

        field {
            name = "skip_y";
            desc = "Vertical point skip for statistics";
            sw = rw;
            hw = r;
            encode = ISP_AEWDR1_SKIP_CRG_skip_y_enum;
            reset = 0x0;
        } skip_y[6:4];

        enum ISP_AEWDR1_SKIP_CRG_offset_x_enum {
            COUNT_FROM_COLUMN = 0 { name = "Count From Column"; desc = "count from column 0"; };
            COUNT_FROM_COLUMN_2 = 1 { name = "Count From Column 2"; desc = "count from column 1"; };
        };

        field {
            name = "offset_x";
            desc = "Count start column";
            sw = rw;
            hw = r;
            encode = ISP_AEWDR1_SKIP_CRG_offset_x_enum;
            reset = 0x0;
        } offset_x[3:3];

        enum ISP_AEWDR1_SKIP_CRG_skip_x_enum {
            COUNTED_EVERY_TWO = 0 { name = "Counted Every Two"; desc = "counted for every two pixels"; };
            COUNTED_EVERY_THREE = 1 { name = "Counted Every Three"; desc = "counted for every three pixels"; };
            COUNTED_EVERY_FOUR = 2 { name = "Counted Every Four"; desc = "counted for every four pixels"; };
            COUNTED_EVERY_FIVE = 3 { name = "Counted Every Five"; desc = "counted for every five pixels"; };
            COUNTED_EVERY_EIGHT = 4 { name = "Counted Every Eight"; desc = "counted for every eight pixels 101 or above: counted for every nine pixels"; };
        };

        field {
            name = "skip_x";
            desc = "Horizontal point skip for statistics";
            sw = rw;
            hw = r;
            encode = ISP_AEWDR1_SKIP_CRG_skip_x_enum;
            reset = 0x0;
        } skip_x[2:0];
    } ISP_AEWDR1_SKIP_CRG @ 0x19114;

    reg {
        name = "Selected pixel count register in a TAT frame during 256 histogram statistics";
        desc = "ISP_AEWDR1_TOTAL_STAT is a selected pixel count register in a frame during 256 histogram statistics. Hi3516C V300/Hi3516E V100 Professional HD IP Camera SoC

Data sheet 10.6 ISP_AEWDR1_TOTAL_STAT (offset 0x29118, printed page 10-278, `hi3516cv300--Hi3516CV300-Hi3516EV100-Datasheet.txt` line 56423).";

        field {
            name = "total_pixels";
            desc = "Number of selected pixels in a frame during 256 histogram statistics";
            sw = r;
            hw = w;
            reset = 0x0;
        } total_pixels[23:0];
    } ISP_AEWDR1_TOTAL_STAT @ 0x19118;

    reg {
        name = "Selected pixel weight count register TAT in a frame during 256 histogram statistics";
        desc = "ISP_AEWDR1_COUNT_STAT is a selected pixel weight count register in a frame during 256 histogram statistics.

Data sheet 10.6 ISP_AEWDR1_COUNT_STAT (offset 0x2911C, printed page 10-278, `hi3516cv300--Hi3516CV300-Hi3516EV100-Datasheet.txt` line 56446).";

        field {
            name = "count_pixels";
            desc = "Total weight of the selected pixels in a frame during 256 histogram statistics";
            sw = r;
            hw = w;
            reset = 0x0;
        } count_pixels[27:0];
    } ISP_AEWDR1_COUNT_STAT @ 0x1911C;

    reg {
        name = "Histogram statistics high register H";
        desc = "ISP_AEWDR1_HIST_HIGH is a histogram statistics high register.

Data sheet 10.6 ISP_AEWDR1_HIST_HIGH (offset 0x29130, printed page 10-278, `hi3516cv300--Hi3516CV300-Hi3516EV100-Datasheet.txt` line 56468).";

        field {
            name = "hist_high";
            desc = "Upper bits in histogram statistics";
            sw = r;
            hw = w;
            reset = 0x0;
        } hist_high[31:0];
    } ISP_AEWDR1_HIST_HIGH @ 0x19130;

    reg {
        name = "AEWDR1 pixel shift register E";
        desc = "ISP_AEWDR1_BITMOVE is an AEWDR1 pixel shift register.

Data sheet 10.6 ISP_AEWDR1_BITMOVE (offset 0x29140, printed page 10-279, `hi3516cv300--Hi3516CV300-Hi3516EV100-Datasheet.txt` line 56491).";

        field {
            name = "BLC_en";
            desc = "AEWDR1 BLC enable";
            sw = rw;
            hw = r;
            reset = 0x0;
        } BLC_en[9:9];

        field {
            name = "bitmove";
            desc = "AEWDR1 pixel shift value";
            sw = rw;
            hw = r;
            reset = 0x0;
        } bitmove[4:0];
    } ISP_AEWDR1_BITMOVE @ 0x19140;

    reg {
        name = "R component black level offset R register";
        desc = "ISP_AEWDR1_OFFSET_R is an R component black level offset register.

Data sheet 10.6 ISP_AEWDR1_OFFSET_R (offset 0x29144, printed page 10-279, `hi3516cv300--Hi3516CV300-Hi3516EV100-Datasheet.txt` line 56514).";

        field {
            name = "offset_r";
            desc = "Black level offset";
            sw = rw;
            hw = r;
            reset = 0x0;
        } offset_r[14:0];
    } ISP_AEWDR1_OFFSET_R @ 0x19144;

    reg {
        name = "Gr component black level offset GR register";
        desc = "ISP_AEWDR1_OFFSET_GR is a Gr component black level offset register. Hi3516C V300/Hi3516E V100 Professional HD IP Camera SoC

Data sheet 10.6 ISP_AEWDR1_OFFSET_GR (offset 0x29148, printed page 10-280, `hi3516cv300--Hi3516CV300-Hi3516EV100-Datasheet.txt` line 56542).";

        field {
            name = "offset_gr";
            desc = "Black level offset";
            sw = rw;
            hw = r;
            reset = 0x0;
        } offset_gr[14:0];
    } ISP_AEWDR1_OFFSET_GR @ 0x19148;

    reg {
        name = "Gb component black level offset GB register";
        desc = "ISP_AEWDR1_OFFSET_GB is a Gb component black level offset register.

Data sheet 10.6 ISP_AEWDR1_OFFSET_GB (offset 0x2914C, printed page 10-280, `hi3516cv300--Hi3516CV300-Hi3516EV100-Datasheet.txt` line 56562).";

        field {
            name = "offset_gb";
            desc = "Black level offset";
            sw = rw;
            hw = r;
            reset = 0x0;
        } offset_gb[14:0];
    } ISP_AEWDR1_OFFSET_GB @ 0x1914C;

    reg {
        name = "B component black level offset B register";
        desc = "ISP_AEWDR1_OFFSET_B is a B component black level offset register.

Data sheet 10.6 ISP_AEWDR1_OFFSET_B (offset 0x29150, printed page 10-280, `hi3516cv300--Hi3516CV300-Hi3516EV100-Datasheet.txt` line 56581).";

        field {
            name = "offset_b";
            desc = "Black level offset";
            sw = rw;
            hw = r;
            reset = 0x0;
        } offset_b[14:0];
    } ISP_AEWDR1_OFFSET_B @ 0x19150;

    reg {
        name = "AEWDR1 histogram statistics read T_RADDR address register";
        desc = "ISP_AEWDR1_MEM_HIST_RADDR is an AEWDR1 histogram statistics read address register.

Data sheet 10.6 ISP_AEWDR1_MEM_HIST_RADDR (offset 0x29188, printed page 10-281, `hi3516cv300--Hi3516CV300-Hi3516EV100-Datasheet.txt` line 56608).";

        field {
            name = "hist_raddr";
            desc = "Read address of histogram statistics";
            sw = rw;
            hw = r;
            reset = 0x0;
        } hist_raddr[31:0];
    } ISP_AEWDR1_MEM_HIST_RADDR @ 0x19188;

    reg {
        name = "AEWDR1 histogram statistics read T_RDATA data register";
        desc = "ISP_AEWDR1_MEM_HIST_RDATA is an AEWDR1 histogram statistics read data register.

Data sheet 10.6 ISP_AEWDR1_MEM_HIST_RDATA (offset 0x2918C, printed page 10-281, `hi3516cv300--Hi3516CV300-Hi3516EV100-Datasheet.txt` line 56626).";

        field {
            name = "hist_rdata";
            desc = "Read data of histogram statistics";
            sw = r;
            hw = w;
            reset = 0x0;
        } hist_rdata[31:0];
    } ISP_AEWDR1_MEM_HIST_RDATA @ 0x1918C;

    reg {
        name = "AEWDR1 picture size register";
        desc = "ISP_AEWDR1_SIZE is an AEWDR1 picture size register. Hi3516C V300/Hi3516E V100 Professional HD IP Camera SoC

Data sheet 10.6 ISP_AEWDR1_SIZE (offset 0x291F0, printed page 10-282, `hi3516cv300--Hi3516CV300-Hi3516EV100-Datasheet.txt` line 56654).";

        field {
            name = "vsize";
            desc = "Picture height";
            sw = rw;
            hw = r;
            reset = 0x437;
        } vsize[28:16];

        field {
            name = "hsize";
            desc = "Picture width";
            sw = rw;
            hw = r;
            reset = 0x77F;
        } hsize[12:0];
    } ISP_AEWDR1_SIZE @ 0x191F0;

    reg {
        name = "ISP BE VERSION";
        desc = "[inferred] ISP BE VERSION. Not in the data sheet. Source: OpenIPC openhisilicon `kernel/isp/arch/hi3516cv300/firmware/vreg/arch/hi3516cv300/isp_reg_define.h` (GPL-3.0 repository, HiSilicon copyright, nManager-generated 2015-12-22 \"Define all registers/tables for Hi3519\"; local copy sources/openhisilicon), union `U_ISP_BE_VERSION`, struct offset 0x30080 (GPL-3.0 repository; header offsets are ISP-core relative (data sheet offset - 0x20000), 632 of 775 data-sheet registers match it by name and offset (ISP_BLC_CFG is at 0x21100 in the data sheet and 0x1000+0x20000 in the header)). Reset value and access type unknown (modelled RW, no reset). Confidence: medium (vendor header for this chip family, not hardware verified).";

        field {
            name = "version";
            desc = "[inferred] Version. (vendor header `isp_reg_define.h` field `version`; access and reset unknown, modelled RW)";
            sw = rw;
            hw = r;
        } version[31:24];

        field {
            name = "build";
            desc = "[inferred] Build. (vendor header `isp_reg_define.h` field `build`; access and reset unknown, modelled RW)";
            sw = rw;
            hw = r;
        } build[23:16];

        field {
            name = "release";
            desc = "[inferred] Release. (vendor header `isp_reg_define.h` field `release`; access and reset unknown, modelled RW)";
            sw = rw;
            hw = r;
        } release[15:8];

        field {
            name = "customer";
            desc = "[inferred] Customer. (vendor header `isp_reg_define.h` field `customer`; access and reset unknown, modelled RW)";
            sw = rw;
            hw = r;
        } customer[7:0];
    } ISP_BE_VERSION @ 0x30080;

    reg {
        name = "ISP BE DATE";
        desc = "[inferred] ISP BE DATE. Not in the data sheet. Source: OpenIPC openhisilicon `kernel/isp/arch/hi3516cv300/firmware/vreg/arch/hi3516cv300/isp_reg_define.h` (GPL-3.0 repository, HiSilicon copyright, nManager-generated 2015-12-22 \"Define all registers/tables for Hi3519\"; local copy sources/openhisilicon), union `U_ISP_BE_DATE`, struct offset 0x30084 (GPL-3.0 repository; header offsets are ISP-core relative (data sheet offset - 0x20000), 632 of 775 data-sheet registers match it by name and offset (ISP_BLC_CFG is at 0x21100 in the data sheet and 0x1000+0x20000 in the header)). Reset value and access type unknown (modelled RW, no reset). Confidence: medium (vendor header for this chip family, not hardware verified).";

        field {
            name = "date";
            desc = "[inferred] Date. (vendor header `isp_reg_define.h` field `date`; access and reset unknown, modelled RW)";
            sw = rw;
            hw = r;
        } date[31:0];
    } ISP_BE_DATE @ 0x30084;

    reg {
        name = "ISP BE MODULE position";
        desc = "[inferred] ISP BE MODULE position. Not in the data sheet. Source: OpenIPC openhisilicon `kernel/isp/arch/hi3516cv300/firmware/vreg/arch/hi3516cv300/isp_reg_define.h` (GPL-3.0 repository, HiSilicon copyright, nManager-generated 2015-12-22 \"Define all registers/tables for Hi3519\"; local copy sources/openhisilicon), union `U_ISP_BE_MODULE_POS`, struct offset 0x30090 (GPL-3.0 repository; header offsets are ISP-core relative (data sheet offset - 0x20000), 632 of 775 data-sheet registers match it by name and offset (ISP_BLC_CFG is at 0x21100 in the data sheet and 0x1000+0x20000 in the header)). Reset value and access type unknown (modelled RW, no reset). Confidence: medium (vendor header for this chip family, not hardware verified).";

        field {
            name = "value";
            desc = "[inferred] Register value (the header union has no named bits).";
            sw = rw;
            hw = r;
        } value[31:0];
    } ISP_BE_MODULE_POS @ 0x30090;

    reg {
        name = "ISP adjustable interrupt trigger time Y configuration register";
        desc = "ISP_BE_FSTART_DELAY is an ISP adjustable interrupt trigger time configuration register.

Data sheet 10.6 ISP_BE_FSTART_DELAY (offset 0x40094, printed page 10-282, `hi3516cv300--Hi3516CV300-Hi3516EV100-Datasheet.txt` line 56679).";

        field {
            name = "delay";
            desc = "Adjustable interrupt trigger time";
            sw = rw;
            hw = r;
            reset = 0x0;
        } delay[31:0];
    } ISP_BE_FSTART_DELAY @ 0x30094;

    reg {
        name = "User-defined register 0";
        desc = "ISP_BE_USER_DEFINE0 is user-defined register 0. Hi3516C V300/Hi3516E V100 Professional HD IP Camera SoC

Data sheet 10.6 ISP_BE_USER_DEFINE0 (offset 0x400A0, printed page 10-283, `hi3516cv300--Hi3516CV300-Hi3516EV100-Datasheet.txt` line 56706).";

        field {
            name = "user_define0";
            desc = "User-defined register 0";
            sw = rw;
            hw = r;
            reset = 0x0;
        } user_define0[31:0];
    } ISP_BE_USER_DEFINE0 @ 0x300A0;

    reg {
        name = "User-defined register 1";
        desc = "ISP_BE_USER_DEFINE1 is user-defined register 1.

Data sheet 10.6 ISP_BE_USER_DEFINE1 (offset 0x400A4, printed page 10-283, `hi3516cv300--Hi3516CV300-Hi3516EV100-Datasheet.txt` line 56725).";

        field {
            name = "user_define1";
            desc = "User-defined register 1";
            sw = rw;
            hw = r;
            reset = 0x0;
        } user_define1[31:0];
    } ISP_BE_USER_DEFINE1 @ 0x300A4;

    reg {
        name = "ISP BE startup indicator register";
        desc = "ISP_BE_STARTUP is an ISP BE startup indicator register.

Data sheet 10.6 ISP_BE_STARTUP (offset 0x400B0, printed page 10-283, `hi3516cv300--Hi3516CV300-Hi3516EV100-Datasheet.txt` line 56743).";

        field {
            name = "fcnt";
            desc = "Frame count after startup";
            sw = r;
            hw = w;
            reset = 0x0;
        } fcnt[31:0];
    } ISP_BE_STARTUP @ 0x300B0;

    reg {
        name = "ISP interrupt indicator register";
        desc = "ISP_BE_INT is an ISP interrupt indicator register. Hi3516C V300/Hi3516E V100 Professional HD IP Camera SoC

Data sheet 10.6 ISP_BE_INT (offset 0x400F0, printed page 10-284, `hi3516cv300--Hi3516CV300-Hi3516EV100-Datasheet.txt` line 56771).";

        enum ISP_BE_INT_acm_para_finish_enum {
            NO_INTERRUPT_GENERATED = 0 { name = "No Interrupt Generated"; desc = "No interrupt is generated."; };
            INTERRUPT_GENERATED = 1 { name = "Interrupt Generated"; desc = "An interrupt is generated."; };
        };

        field {
            name = "acm_para_finish";
            desc = "Status of the ACM LUT load completion interrupt. Writing 1 clears the interrupt.";
            sw = rw;
            hw = w;
            onwrite = woclr;
            encode = ISP_BE_INT_acm_para_finish_enum;
            reset = 0x0;
        } acm_para_finish[16:16];

        enum ISP_BE_INT_fstart_delay_enum {
            NO_INTERRUPT_GENERATED = 0 { name = "No Interrupt Generated"; desc = "No interrupt is generated."; };
            INTERRUPT_GENERATED = 1 { name = "Interrupt Generated"; desc = "An interrupt is generated."; };
        };

        field {
            name = "fstart_delay";
            desc = "Status of the configurable trigger delay interrupt";
            sw = rw;
            hw = w;
            onwrite = woclr;
            encode = ISP_BE_INT_fstart_delay_enum;
            reset = 0x0;
        } fstart_delay[3:3];

        enum ISP_BE_INT_cfg_loss_enum {
            NO_INTERRUPT_GENERATED = 0 { name = "No Interrupt Generated"; desc = "No interrupt is generated."; };
            INTERRUPT_GENERATED = 1 { name = "Interrupt Generated"; desc = "An interrupt is generated."; };
        };

        field {
            name = "cfg_loss";
            desc = "Status of the register configuration loss interrupt. Writing 1 clears the interrupt.";
            sw = rw;
            hw = w;
            onwrite = woclr;
            encode = ISP_BE_INT_cfg_loss_enum;
            reset = 0x0;
        } cfg_loss[2:2];

        enum ISP_BE_INT_update_cfg_enum {
            NO_INTERRUPT_GENERATED = 0 { name = "No Interrupt Generated"; desc = "No interrupt is generated."; };
            INTERRUPT_GENERATED = 1 { name = "Interrupt Generated"; desc = "An interrupt is generated."; };
        };

        field {
            name = "update_cfg";
            desc = "Status of the register update interrupt. Writing 1 clears the interrupt.";
            sw = rw;
            hw = w;
            onwrite = woclr;
            encode = ISP_BE_INT_update_cfg_enum;
            reset = 0x0;
        } update_cfg[1:1];

        enum ISP_BE_INT_fstart_enum {
            NO_INTERRUPT_GENERATED = 0 { name = "No Interrupt Generated"; desc = "No interrupt is generated."; };
            INTERRUPT_GENERATED = 1 { name = "Interrupt Generated"; desc = "An interrupt is generated."; };
        };

        field {
            name = "fstart";
            desc = "Status of the ISP frame start interrupt. Writing 1 clears the interrupt.";
            sw = rw;
            hw = w;
            onwrite = woclr;
            encode = ISP_BE_INT_fstart_enum;
            reset = 0x0;
        } fstart[0:0];
    } ISP_BE_INT @ 0x300F0;

    reg {
        name = "ISP interrupt mask register";
        desc = "ISP_BE_INT_MASK is an ISP interrupt mask register. Hi3516C V300/Hi3516E V100 Professional HD IP Camera SoC

Data sheet 10.6 ISP_BE_INT_MASK (offset 0x400F8, printed page 10-285, `hi3516cv300--Hi3516CV300-Hi3516EV100-Datasheet.txt` line 56830).";

        enum ISP_BE_INT_MASK_acm_para_finish_enum {
            DISABLED = 0 { name = "Disabled"; desc = "disabled"; };
            ENABLED = 1 { name = "Enabled"; desc = "enabled"; };
        };

        field {
            name = "acm_para_finish";
            desc = "ACM LUT load completion interrupt enable";
            sw = rw;
            hw = r;
            encode = ISP_BE_INT_MASK_acm_para_finish_enum;
            reset = 0x0;
        } acm_para_finish[16:16];

        enum ISP_BE_INT_MASK_int_delay_enum {
            DISABLED = 0 { name = "Disabled"; desc = "disabled"; };
            ENABLED = 1 { name = "Enabled"; desc = "enabled"; };
        };

        field {
            name = "int_delay";
            desc = "Configurable trigger delay interrupt enable";
            sw = rw;
            hw = r;
            encode = ISP_BE_INT_MASK_int_delay_enum;
            reset = 0x0;
        } int_delay[3:3];

        enum ISP_BE_INT_MASK_cfg_loss_enum {
            DISABLED = 0 { name = "Disabled"; desc = "disabled"; };
            ENABLED = 1 { name = "Enabled"; desc = "enabled"; };
        };

        field {
            name = "cfg_loss";
            desc = "Register configuration loss interrupt enable";
            sw = rw;
            hw = r;
            encode = ISP_BE_INT_MASK_cfg_loss_enum;
            reset = 0x0;
        } cfg_loss[2:2];

        enum ISP_BE_INT_MASK_update_cfg_enum {
            DISABLED = 0 { name = "Disabled"; desc = "disabled"; };
            ENABLED = 1 { name = "Enabled"; desc = "enabled"; };
        };

        field {
            name = "update_cfg";
            desc = "Register update interrupt enable";
            sw = rw;
            hw = r;
            encode = ISP_BE_INT_MASK_update_cfg_enum;
            reset = 0x0;
        } update_cfg[1:1];

        enum ISP_BE_INT_MASK_fstart_enum {
            DISABLED = 0 { name = "Disabled"; desc = "disabled"; };
            ENABLED = 1 { name = "Enabled"; desc = "enabled"; };
        };

        field {
            name = "fstart";
            desc = "ISP frame start interrupt enable";
            sw = rw;
            hw = r;
            encode = ISP_BE_INT_MASK_fstart_enum;
            reset = 0x0;
        } fstart[0:0];
    } ISP_BE_INT_MASK @ 0x300F8;

    reg {
        name = "ISP common update control register";
        desc = "ISP_BE_CTRL_F is an ISP common update control register. Hi3516C V300/Hi3516E V100 Professional HD IP Camera SoC

Data sheet 10.6 ISP_BE_CTRL_F (offset 0x401E0, printed page 10-286, `hi3516cv300--Hi3516CV300-Hi3516EV100-Datasheet.txt` line 56881).";

        enum ISP_BE_CTRL_F_rggb_cfg_enum {
            R_GR_GB = 0 { name = "R Gr Gb"; desc = "R Gr Gb B"; };
            GR_R_B = 1 { name = "Gr R B"; desc = "Gr R B Gb"; };
            GB_B_R = 2 { name = "Gb B R"; desc = "Gb B R Gr"; };
            B_GB_GR = 3 { name = "B Gb Gr"; desc = "B Gb Gr R"; };
        };

        field {
            name = "rggb_cfg";
            desc = "RGGB start";
            sw = rw;
            hw = r;
            encode = ISP_BE_CTRL_F_rggb_cfg_enum;
            reset = 0x3;
        } rggb_cfg[1:0];
    } ISP_BE_CTRL_F @ 0x301E0;

    reg {
        name = "ISP immediate update control register";
        desc = "ISP_BE_CTRL_I is an ISP immediate update control register.

Data sheet 10.6 ISP_BE_CTRL_I (offset 0x401E4, printed page 10-286, `hi3516cv300--Hi3516CV300-Hi3516EV100-Datasheet.txt` line 56910).";

        enum ISP_BE_CTRL_I_update_mode_enum {
            UPDATE_USING_ISP = 0 { name = "Update Using Isp"; desc = "update by using ISP_BE_REG_UPDATE"; };
            FRAME_UPDATE = 1 { name = "Frame Update"; desc = "frame update"; };
        };

        field {
            name = "update_mode";
            desc = "ISP register update mode";
            sw = rw;
            hw = r;
            encode = ISP_BE_CTRL_I_update_mode_enum;
            reset = 0x0;
        } update_mode[0:0];
    } ISP_BE_CTRL_I @ 0x301E4;

    reg {
        name = "Output timing configuration register";
        desc = "ISP_BE_TIMING_CFG is an output timing configuration register. Hi3516C V300/Hi3516E V100 Professional HD IP Camera SoC

Data sheet 10.6 ISP_BE_TIMING_CFG (offset 0x401E8, printed page 10-287, `hi3516cv300--Hi3516CV300-Hi3516EV100-Datasheet.txt` line 56946).";

        field {
            name = "fix_timing";
            desc = "Manual timing parameter configuration, for setting the length of the generated horizontal blanking region";
            sw = rw;
            hw = r;
            reset = 0x40;
        } fix_timing[13:1];
    } ISP_BE_TIMING_CFG @ 0x301E8;

    reg {
        name = "Register update register";
        desc = "ISP_BE_REG_UPDATE is a register update register.

Data sheet 10.6 ISP_BE_REG_UPDATE (offset 0x401EC, printed page 10-287, `hi3516cv300--Hi3516CV300-Hi3516EV100-Datasheet.txt` line 56971).";

        field {
            name = "update";
            desc = "ISP update register. This bit is automatically cleared for each frame.";
            sw = rw;
            hw = r;
            reset = 0x0;
        } update[0:0];
    } ISP_BE_REG_UPDATE @ 0x301EC;

    reg {
        name = "Luminance clamping configuration register";
        desc = "ISP_CLIP_Y_CFG is a luminance clamping configuration register. Hi3516C V300/Hi3516E V100 Professional HD IP Camera SoC

Data sheet 10.6 ISP_CLIP_Y_CFG (offset 0x40800, printed page 10-288, `hi3516cv300--Hi3516CV300-Hi3516EV100-Datasheet.txt` line 57003).";

        field {
            name = "max";
            desc = "Maximum value of luminance clamping. If the data bit width is less than 16 bits, the upper bits are valid.";
            sw = rw;
            hw = r;
            reset = 0xFFFF;
        } max[31:16];

        field {
            name = "min";
            desc = "Minimum value of luminance clamping. If the data bit width is less than 16 bits, the upper bits are valid.";
            sw = rw;
            hw = r;
            reset = 0x0;
        } min[15:0];
    } ISP_CLIP_Y_CFG @ 0x30800;

    reg {
        name = "Chrominance clamping configuration register";
        desc = "ISP_CLIP_C_CFG is a chrominance clamping configuration register.

Data sheet 10.6 ISP_CLIP_C_CFG (offset 0x40804, printed page 10-288, `hi3516cv300--Hi3516CV300-Hi3516EV100-Datasheet.txt` line 57027).";

        field {
            name = "max";
            desc = "Maximum value of chrominance clamping. If the data bit width is less than 16 bits, the upper bits are valid.";
            sw = rw;
            hw = r;
            reset = 0xFFFF;
        } max[31:16];

        field {
            name = "min";
            desc = "Minimum value of chrominance clamping. If the data bit width is less than 16 bits, the upper bits are valid.";
            sw = rw;
            hw = r;
            reset = 0x0;
        } min[15:0];
    } ISP_CLIP_C_CFG @ 0x30804;

    reg {
        name = "Y component skip configuration register";
        desc = "ISP_SKIP_Y_CFG is a Y component skip configuration register.

Data sheet 10.6 ISP_SKIP_Y_CFG (offset 0x40810, printed page 10-288, `hi3516cv300--Hi3516CV300-Hi3516EV100-Datasheet.txt` line 57051).";

        field {
            name = "skip_cfg";
            desc = "Skip configuration";
            sw = rw;
            hw = r;
            reset = 0xFFFFFFFF;
        } skip_cfg[31:0];
    } ISP_SKIP_Y_CFG @ 0x30810;

    reg {
        name = "ISP SKIP Y WIN";
        desc = "[inferred] ISP SKIP Y WIN. Not in the data sheet. Source: OpenIPC openhisilicon `kernel/isp/arch/hi3516cv300/firmware/vreg/arch/hi3516cv300/isp_reg_define.h` (GPL-3.0 repository, HiSilicon copyright, nManager-generated 2015-12-22 \"Define all registers/tables for Hi3519\"; local copy sources/openhisilicon), union `U_ISP_SKIP_Y_WIN`, struct offset 0x30814 (GPL-3.0 repository; header offsets are ISP-core relative (data sheet offset - 0x20000), 632 of 775 data-sheet registers match it by name and offset (ISP_BLC_CFG is at 0x21100 in the data sheet and 0x1000+0x20000 in the header)). Reset value and access type unknown (modelled RW, no reset). Confidence: medium (vendor header for this chip family, not hardware verified).";

        field {
            name = "height";
            desc = "[inferred] Height. (vendor header `isp_reg_define.h` field `height`; access and reset unknown, modelled RW)";
            sw = rw;
            hw = r;
        } height[17:16];

        field {
            name = "width";
            desc = "[inferred] Width. (vendor header `isp_reg_define.h` field `width`; access and reset unknown, modelled RW)";
            sw = rw;
            hw = r;
        } width[2:0];
    } ISP_SKIP_Y_WIN @ 0x30814;

    reg {
        name = "C component skip configuration register";
        desc = "ISP_SKIP_C_CFG is a C component skip configuration register.

Data sheet 10.6 ISP_SKIP_C_CFG (offset 0x40818, printed page 10-289, `hi3516cv300--Hi3516CV300-Hi3516EV100-Datasheet.txt` line 57074).";

        field {
            name = "skip_cfg";
            desc = "Skip configuration";
            sw = rw;
            hw = r;
            reset = 0xFFFFFFFF;
        } skip_cfg[31:0];
    } ISP_SKIP_C_CFG @ 0x30818;

    reg {
        name = "ISP SKIP C WIN";
        desc = "[inferred] ISP SKIP C WIN. Not in the data sheet. Source: OpenIPC openhisilicon `kernel/isp/arch/hi3516cv300/firmware/vreg/arch/hi3516cv300/isp_reg_define.h` (GPL-3.0 repository, HiSilicon copyright, nManager-generated 2015-12-22 \"Define all registers/tables for Hi3519\"; local copy sources/openhisilicon), union `U_ISP_SKIP_C_WIN`, struct offset 0x3081C (GPL-3.0 repository; header offsets are ISP-core relative (data sheet offset - 0x20000), 632 of 775 data-sheet registers match it by name and offset (ISP_BLC_CFG is at 0x21100 in the data sheet and 0x1000+0x20000 in the header)). Reset value and access type unknown (modelled RW, no reset). Confidence: medium (vendor header for this chip family, not hardware verified).";

        field {
            name = "height";
            desc = "[inferred] Height. (vendor header `isp_reg_define.h` field `height`; access and reset unknown, modelled RW)";
            sw = rw;
            hw = r;
        } height[17:16];

        field {
            name = "width";
            desc = "[inferred] Width. (vendor header `isp_reg_define.h` field `width`; access and reset unknown, modelled RW)";
            sw = rw;
            hw = r;
        } width[2:0];
    } ISP_SKIP_C_WIN @ 0x3081C;

    reg {
        name = "CSC statistics and configuration register";
        desc = "ISP_CSC_SUM_CFG is a CSC statistics and configuration register.

Data sheet 10.6 ISP_CSC_SUM_CFG (offset 0x40820, printed page 10-289, `hi3516cv300--Hi3516CV300-Hi3516EV100-Datasheet.txt` line 57093).";

        enum ISP_CSC_SUM_CFG_en_enum {
            DISABLED = 0 { name = "Disabled"; desc = "disabled"; };
            ENABLED = 1 { name = "Enabled"; desc = "enabled"; };
        };

        field {
            name = "en";
            desc = "Summation enable";
            sw = rw;
            hw = r;
            encode = ISP_CSC_SUM_CFG_en_enum;
            reset = 0x1;
        } en[0:0];
    } ISP_CSC_SUM_CFG @ 0x30820;

    reg {
        name = "ISP DMNR dither register";
        desc = "ISP_DMNR_DITHER is an ISP DMNR dither register. Hi3516C V300/Hi3516E V100 Professional HD IP Camera SoC

Data sheet 10.6 ISP_DMNR_DITHER (offset 0x40840, printed page 10-290, `hi3516cv300--Hi3516CV300-Hi3516EV100-Datasheet.txt` line 57123).";

        enum ISP_DMNR_DITHER_out_bits_enum {
            V_8_BITS = 8 { name = "V 8 Bits"; desc = "8 bits"; };
            V_10_BITS = 10 { name = "V 10 Bits"; desc = "10 bits"; };
            V_12_BITS = 12 { name = "V 12 Bits"; desc = "12 bits"; };
            V_14_BITS_OTHER = 14 { name = "V 14 Bits Other"; desc = "14 bits Other values: forbidden"; };
        };

        field {
            name = "out_bits";
            desc = "Output bit width";
            sw = rw;
            hw = r;
            encode = ISP_DMNR_DITHER_out_bits_enum;
            reset = 0x0;
        } out_bits[7:4];

        enum ISP_DMNR_DITHER_spatial_mode_enum {
            DISABLED = 0 { name = "Disabled"; desc = "disabled"; };
            ENABLED = 1 { name = "Enabled"; desc = "enabled"; };
        };

        field {
            name = "spatial_mode";
            desc = "Spatial mode enable";
            sw = rw;
            hw = r;
            encode = ISP_DMNR_DITHER_spatial_mode_enum;
            reset = 0x1;
        } spatial_mode[3:3];

        enum ISP_DMNR_DITHER_isp_dither_round_enum {
            TRUNCATION = 0 { name = "Truncation"; desc = "truncation"; };
            ROUND_OFF = 1 { name = "Round Off"; desc = "round off"; };
            RANDOM = 2 { name = "Random"; desc = "random"; };
        };

        field {
            name = "isp_dither_round";
            desc = "Dither mode select";
            sw = rw;
            hw = r;
            encode = ISP_DMNR_DITHER_isp_dither_round_enum;
            reset = 0x0;
        } isp_dither_round[2:1];

        enum ISP_DMNR_DITHER_isp_dither_en_enum {
            DISABLED = 0 { name = "Disabled"; desc = "disabled"; };
            ENABLED = 1 { name = "Enabled"; desc = "enabled"; };
        };

        field {
            name = "isp_dither_en";
            desc = "Dither enable";
            sw = rw;
            hw = r;
            encode = ISP_DMNR_DITHER_isp_dither_en_enum;
            reset = 0x0;
        } isp_dither_en[0:0];
    } ISP_DMNR_DITHER @ 0x30840;

    reg {
        name = "ISP ACM dither register";
        desc = "ISP_ACM_DITHER is an ISP ACM dither register. Hi3516C V300/Hi3516E V100 Professional HD IP Camera SoC

Data sheet 10.6 ISP_ACM_DITHER (offset 0x40850, printed page 10-291, `hi3516cv300--Hi3516CV300-Hi3516EV100-Datasheet.txt` line 57175).";

        enum ISP_ACM_DITHER_out_bits_enum {
            V_8_BITS = 8 { name = "V 8 Bits"; desc = "8 bits"; };
            V_10_BITS = 10 { name = "V 10 Bits"; desc = "10 bits"; };
            V_12_BITS = 12 { name = "V 12 Bits"; desc = "12 bits"; };
            V_14_BITS_OTHER = 14 { name = "V 14 Bits Other"; desc = "14 bits Other values: forbidden"; };
        };

        field {
            name = "out_bits";
            desc = "Output bit width";
            sw = rw;
            hw = r;
            encode = ISP_ACM_DITHER_out_bits_enum;
            reset = 0x0;
        } out_bits[7:4];

        enum ISP_ACM_DITHER_spatial_mode_enum {
            DISABLED = 0 { name = "Disabled"; desc = "disabled"; };
            ENABLED = 1 { name = "Enabled"; desc = "enabled"; };
        };

        field {
            name = "spatial_mode";
            desc = "Spatial mode enable";
            sw = rw;
            hw = r;
            encode = ISP_ACM_DITHER_spatial_mode_enum;
            reset = 0x1;
        } spatial_mode[3:3];

        enum ISP_ACM_DITHER_isp_dither_round_enum {
            TRUNCATION = 0 { name = "Truncation"; desc = "truncation"; };
            ROUND_OFF = 1 { name = "Round Off"; desc = "round off"; };
            RANDOM = 2 { name = "Random"; desc = "random"; };
        };

        field {
            name = "isp_dither_round";
            desc = "Dither mode select";
            sw = rw;
            hw = r;
            encode = ISP_ACM_DITHER_isp_dither_round_enum;
            reset = 0x0;
        } isp_dither_round[2:1];

        enum ISP_ACM_DITHER_isp_dither_en_enum {
            DISABLED = 0 { name = "Disabled"; desc = "disabled"; };
            ENABLED = 1 { name = "Enabled"; desc = "enabled"; };
        };

        field {
            name = "isp_dither_en";
            desc = "Dither enable";
            sw = rw;
            hw = r;
            encode = ISP_ACM_DITHER_isp_dither_en_enum;
            reset = 0x0;
        } isp_dither_en[0:0];
    } ISP_ACM_DITHER @ 0x30850;

    reg {
        name = "Input picture luminance sum low register";
        desc = "ISP_Y_SUM0 is an input picture luminance sum low register. Hi3516C V300/Hi3516E V100 Professional HD IP Camera SoC

Data sheet 10.6 ISP_Y_SUM0 (offset 0x40880, printed page 10-292, `hi3516cv300--Hi3516CV300-Hi3516EV100-Datasheet.txt` line 57227).";

        field {
            name = "sum";
            desc = "Lower 32 bits of luminance sum statistics";
            sw = r;
            hw = w;
            reset = 0x0;
        } sum[31:0];
    } ISP_Y_SUM0 @ 0x30880;

    reg {
        name = "Input picture luminance sum high register";
        desc = "ISP_Y_SUM1 is an input picture luminance sum high register.

Data sheet 10.6 ISP_Y_SUM1 (offset 0x40884, printed page 10-292, `hi3516cv300--Hi3516CV300-Hi3516EV100-Datasheet.txt` line 57246).";

        field {
            name = "sum";
            desc = "Upper 32 bits of luminance sum statistics";
            sw = r;
            hw = w;
            reset = 0x0;
        } sum[31:0];
    } ISP_Y_SUM1 @ 0x30884;

    reg {
        name = "Split enable register";
        desc = "ISP_SPLIT_CFG is a split enable register.

Data sheet 10.6 ISP_SPLIT_CFG (offset 0x40900, printed page 10-292, `hi3516cv300--Hi3516CV300-Hi3516EV100-Datasheet.txt` line 57264).";

        enum ISP_SPLIT_CFG_en_enum {
            DISABLED = 0 { name = "Disabled"; desc = "disabled"; };
            ENABLED = 1 { name = "Enabled"; desc = "enabled"; };
        };

        field {
            name = "en";
            desc = "SPLIT enable";
            sw = rw;
            hw = r;
            encode = ISP_SPLIT_CFG_en_enum;
            reset = 0x0;
        } en[0:0];
    } ISP_SPLIT_CFG @ 0x30900;

    reg {
        name = "ISP SPLIT VERSION";
        desc = "[inferred] ISP SPLIT VERSION. Not in the data sheet. Source: OpenIPC openhisilicon `kernel/isp/arch/hi3516cv300/firmware/vreg/arch/hi3516cv300/isp_reg_define.h` (GPL-3.0 repository, HiSilicon copyright, nManager-generated 2015-12-22 \"Define all registers/tables for Hi3519\"; local copy sources/openhisilicon), union `U_ISP_SPLIT_VERSION`, struct offset 0x3090C (GPL-3.0 repository; header offsets are ISP-core relative (data sheet offset - 0x20000), 632 of 775 data-sheet registers match it by name and offset (ISP_BLC_CFG is at 0x21100 in the data sheet and 0x1000+0x20000 in the header)). Reset value and access type unknown (modelled RW, no reset). Confidence: medium (vendor header for this chip family, not hardware verified).";

        field {
            name = "version";
            desc = "[inferred] Version. (vendor header `isp_reg_define.h` field `version`; access and reset unknown, modelled RW)";
            sw = rw;
            hw = r;
        } version[31:0];
    } ISP_SPLIT_VERSION @ 0x3090C;

    reg {
        name = "Split configuration register";
        desc = "ISP_SPLIT_DATA_CFG is a split configuration register.

Data sheet 10.6 ISP_SPLIT_DATA_CFG (offset 0x40910, printed page 10-293, `hi3516cv300--Hi3516CV300-Hi3516EV100-Datasheet.txt` line 57292).";

        field {
            name = "dc_data";
            desc = "Data split DC component";
            sw = rw;
            hw = r;
            reset = 0x0;
        } dc_data[22:16];

        enum ISP_SPLIT_DATA_CFG_data_sel_enum {
            DATA_0 = 0 { name = "Data 0"; desc = "data 0"; };
            DATA_1 = 1 { name = "Data 1"; desc = "data 1"; };
            DATA_2 = 2 { name = "Data 2"; desc = "data 2"; };
            DATA_0_2 = 3 { name = "Data 0 2"; desc = "data 0"; };
        };

        field {
            name = "data_sel";
            desc = "Data component to be splited";
            sw = rw;
            hw = r;
            encode = ISP_SPLIT_DATA_CFG_data_sel_enum;
            reset = 0x0;
        } data_sel[11:10];

        enum ISP_SPLIT_DATA_CFG_SPLIT_en_enum {
            DISABLED = 0 { name = "Disabled"; desc = "disabled"; };
            ENABLED = 1 { name = "Enabled"; desc = "enabled"; };
        };

        field {
            name = "SPLIT_en";
            desc = "Data split enable";
            sw = rw;
            hw = r;
            encode = ISP_SPLIT_DATA_CFG_SPLIT_en_enum;
            reset = 0x0;
        } SPLIT_en[9:9];

        enum ISP_SPLIT_DATA_CFG_ex_yuv_en_enum {
            YUV_OUTPUT = 0 { name = "Yuv Output"; desc = "YUV output"; };
            YVU_OUTPUT = 1 { name = "Yvu Output"; desc = "YVU output"; };
            UYV_OUTPUT = 2 { name = "Uyv Output"; desc = "UYV output"; };
            UVY_OUTPUT = 3 { name = "Uvy Output"; desc = "UVY output"; };
            VYU_OUTPUT = 4 { name = "Vyu Output"; desc = "VYU output"; };
            VUY_OUTPUT_OTHER = 5 { name = "Vuy Output Other"; desc = "VUY output Other values: YUV output"; };
        };

        field {
            name = "ex_yuv_en";
            desc = "YUV sequence of split data";
            sw = rw;
            hw = r;
            encode = ISP_SPLIT_DATA_CFG_ex_yuv_en_enum;
            reset = 0x0;
        } ex_yuv_en[8:6];

        enum ISP_SPLIT_DATA_CFG_ex_v_en_enum {
            DISABLED = 0 { name = "Disabled"; desc = "disabled"; };
            ENABLED = 1 { name = "Enabled"; desc = "enabled"; };
        };

        field {
            name = "ex_v_en";
            desc = "Adjacent data exchange of split data V (Repeated exchange is not allowed. One data segment can be exchanged with the one that is two data segments away from it.)";
            sw = rw;
            hw = r;
            encode = ISP_SPLIT_DATA_CFG_ex_v_en_enum;
            reset = 0x0;
        } ex_v_en[5:5];

        enum ISP_SPLIT_DATA_CFG_ex_u_en_enum {
            DISABLED = 0 { name = "Disabled"; desc = "disabled"; };
            ENABLED = 1 { name = "Enabled"; desc = "enabled"; };
        };

        field {
            name = "ex_u_en";
            desc = "Adjacent data exchange of split data U (Repeated exchange is not allowed. One data segment can be exchanged with the one that is two data segments away from it.)";
            sw = rw;
            hw = r;
            encode = ISP_SPLIT_DATA_CFG_ex_u_en_enum;
            reset = 0x0;
        } ex_u_en[4:4];

        enum ISP_SPLIT_DATA_CFG_ex_y_en_enum {
            DISABLED = 0 { name = "Disabled"; desc = "disabled"; };
            ENABLED = 1 { name = "Enabled"; desc = "enabled"; };
        };

        field {
            name = "ex_y_en";
            desc = "Adjacent data exchange of split data Y (Repeated exchange is not allowed. One data segment can be exchanged with the one that is two data segments away from it.)";
            sw = rw;
            hw = r;
            encode = ISP_SPLIT_DATA_CFG_ex_y_en_enum;
            reset = 0x0;
        } ex_y_en[3:3];

        enum ISP_SPLIT_DATA_CFG_replace_v_en_enum {
            DISABLED = 0 { name = "Disabled"; desc = "disabled"; };
            ENABLED = 1 { name = "Enabled"; desc = "enabled"; };
        };

        field {
            name = "replace_v_en";
            desc = "Storing split data information in channel V";
            sw = rw;
            hw = r;
            encode = ISP_SPLIT_DATA_CFG_replace_v_en_enum;
            reset = 0x0;
        } replace_v_en[2:2];

        enum ISP_SPLIT_DATA_CFG_replace_u_en_enum {
            DISABLED = 0 { name = "Disabled"; desc = "disabled"; };
            ENABLED = 1 { name = "Enabled"; desc = "enabled"; };
        };

        field {
            name = "replace_u_en";
            desc = "Storing split data information in channel U";
            sw = rw;
            hw = r;
            encode = ISP_SPLIT_DATA_CFG_replace_u_en_enum;
            reset = 0x0;
        } replace_u_en[1:1];

        enum ISP_SPLIT_DATA_CFG_replace_y_en_enum {
            DISABLED = 0 { name = "Disabled"; desc = "disabled"; };
            ENABLED = 1 { name = "Enabled"; desc = "enabled"; };
        };

        field {
            name = "replace_y_en";
            desc = "Storing split data information in channel Y";
            sw = rw;
            hw = r;
            encode = ISP_SPLIT_DATA_CFG_replace_y_en_enum;
            reset = 0x0;
        } replace_y_en[0:0];
    } ISP_SPLIT_DATA_CFG @ 0x30910;

    reg {
        name = "Split data version register ION";
        desc = "ISP_SPLIT_DATA_VERSION is a split data version register.

Data sheet 10.6 ISP_SPLIT_DATA_VERSION (offset 0x40914, printed page 10-294, `hi3516cv300--Hi3516CV300-Hi3516EV100-Datasheet.txt` line 57370).";

        field {
            name = "data_version";
            desc = "Split data version";
            sw = rw;
            hw = r;
            reset = 0x0;
        } data_version[15:0];
    } ISP_SPLIT_DATA_VERSION @ 0x30914;

    reg {
        name = "Split data bit width register IDTH";
        desc = "ISP_SPLIT_DATA_BITWIDTH is a split data bit width register. Hi3516C V300/Hi3516E V100 Professional HD IP Camera SoC

Data sheet 10.6 ISP_SPLIT_DATA_BITWIDTH (offset 0x40918, printed page 10-295, `hi3516cv300--Hi3516CV300-Hi3516EV100-Datasheet.txt` line 57398).";

        field {
            name = "data_bitw";
            desc = "Bit width of split data";
            sw = rw;
            hw = r;
            reset = 0x0;
        } data_bitw[15:0];
    } ISP_SPLIT_DATA_BITWIDTH @ 0x30918;

    reg {
        name = "Split data analog gain information N register";
        desc = "ISP_SPLIT_DATA_AGAIN is a split data analog gain information register.

Data sheet 10.6 ISP_SPLIT_DATA_AGAIN (offset 0x4091C, printed page 10-295, `hi3516cv300--Hi3516CV300-Hi3516EV100-Datasheet.txt` line 57418).";

        field {
            name = "data_again";
            desc = "Analog gain of split data";
            sw = rw;
            hw = r;
            reset = 0x0;
        } data_again[31:0];
    } ISP_SPLIT_DATA_AGAIN @ 0x3091C;

    reg {
        name = "Split data digital gain information N register";
        desc = "ISP_SPLIT_DATA_DGAIN is a split data digital gain information register.

Data sheet 10.6 ISP_SPLIT_DATA_DGAIN (offset 0x40920, printed page 10-295, `hi3516cv300--Hi3516CV300-Hi3516EV100-Datasheet.txt` line 57436).";

        field {
            name = "data_dgain";
            desc = "Digital gain of split data";
            sw = rw;
            hw = r;
            reset = 0x0;
        } data_dgain[31:0];
    } ISP_SPLIT_DATA_DGAIN @ 0x30920;

    reg {
        name = "Split data shutter information TER register";
        desc = "ISP_SPLIT_DATA_SHUTTER is a split data SHUTTER information register. Hi3516C V300/Hi3516E V100 Professional HD IP Camera SoC

Data sheet 10.6 ISP_SPLIT_DATA_SHUTTER (offset 0x40924, printed page 10-296, `hi3516cv300--Hi3516CV300-Hi3516EV100-Datasheet.txt` line 57461).";

        field {
            name = "data_shutter";
            desc = "SHUTTER information of split data";
            sw = rw;
            hw = r;
            reset = 0x0;
        } data_shutter[31:0];
    } ISP_SPLIT_DATA_SHUTTER @ 0x30924;

    reg {
        name = "ISP SPLIT control I";
        desc = "[inferred] ISP SPLIT control I. Not in the data sheet. Source: OpenIPC openhisilicon `kernel/isp/arch/hi3516cv300/firmware/vreg/arch/hi3516cv300/isp_reg_define.h` (GPL-3.0 repository, HiSilicon copyright, nManager-generated 2015-12-22 \"Define all registers/tables for Hi3519\"; local copy sources/openhisilicon), union `U_ISP_SPLIT_CTRL_I`, struct offset 0x309E4 (GPL-3.0 repository; header offsets are ISP-core relative (data sheet offset - 0x20000), 632 of 775 data-sheet registers match it by name and offset (ISP_BLC_CFG is at 0x21100 in the data sheet and 0x1000+0x20000 in the header)). Reset value and access type unknown (modelled RW, no reset). Confidence: medium (vendor header for this chip family, not hardware verified).";

        field {
            name = "update_mode";
            desc = "[inferred] Update mode. (vendor header `isp_reg_define.h` field `update_mode`; access and reset unknown, modelled RW)";
            sw = rw;
            hw = r;
        } update_mode[0:0];
    } ISP_SPLIT_CTRL_I @ 0x309E4;

    reg {
        name = "ISP SPLIT UPDATE";
        desc = "[inferred] ISP SPLIT UPDATE. Not in the data sheet. Source: OpenIPC openhisilicon `kernel/isp/arch/hi3516cv300/firmware/vreg/arch/hi3516cv300/isp_reg_define.h` (GPL-3.0 repository, HiSilicon copyright, nManager-generated 2015-12-22 \"Define all registers/tables for Hi3519\"; local copy sources/openhisilicon), union `U_ISP_SPLIT_UPDATE`, struct offset 0x309EC (GPL-3.0 repository; header offsets are ISP-core relative (data sheet offset - 0x20000), 632 of 775 data-sheet registers match it by name and offset (ISP_BLC_CFG is at 0x21100 in the data sheet and 0x1000+0x20000 in the header)). Reset value and access type unknown (modelled RW, no reset). Confidence: medium (vendor header for this chip family, not hardware verified).";

        field {
            name = "newer";
            desc = "[inferred] Newer. (vendor header `isp_reg_define.h` field `newer`; access and reset unknown, modelled RW)";
            sw = rw;
            hw = r;
        } newer[0:0];
    } ISP_SPLIT_UPDATE @ 0x309EC;

    reg {
        name = "CCM enable register";
        desc = "ISP_CCM_CFG is a CCM enable register.

Data sheet 10.6 ISP_CCM_CFG (offset 0x41400, printed page 10-296, `hi3516cv300--Hi3516CV300-Hi3516EV100-Datasheet.txt` line 57480).";

        enum ISP_CCM_CFG_prot_ext_en_enum {
            DISABLED = 0 { name = "Disabled"; desc = "disabled"; };
            ENABLED = 1 { name = "Enabled"; desc = "enabled"; };
        };

        field {
            name = "prot_ext_en";
            desc = "CCM dark region protection extended function enable";
            sw = rw;
            hw = r;
            encode = ISP_CCM_CFG_prot_ext_en_enum;
            reset = 0x0;
        } prot_ext_en[3:3];

        enum ISP_CCM_CFG_colortone_en_enum {
            DISABLED = 0 { name = "Disabled"; desc = "disabled"; };
            ENABLED = 1 { name = "Enabled"; desc = "enabled"; };
        };

        field {
            name = "colortone_en";
            desc = "CCM hue adjustment enable";
            sw = rw;
            hw = r;
            encode = ISP_CCM_CFG_colortone_en_enum;
            reset = 0x0;
        } colortone_en[2:2];

        enum ISP_CCM_CFG_prot_en_enum {
            DISABLED = 0 { name = "Disabled"; desc = "disabled"; };
            ENABLED = 1 { name = "Enabled"; desc = "enabled"; };
        };

        field {
            name = "prot_en";
            desc = "CCM dark region protection enable";
            sw = rw;
            hw = r;
            encode = ISP_CCM_CFG_prot_en_enum;
            reset = 0x0;
        } prot_en[1:1];

        enum ISP_CCM_CFG_en_enum {
            DISABLED = 0 { name = "Disabled"; desc = "disabled"; };
            ENABLED = 1 { name = "Enabled"; desc = "enabled"; };
        };

        field {
            name = "en";
            desc = "CCM enable";
            sw = rw;
            hw = r;
            encode = ISP_CCM_CFG_en_enum;
            reset = 0x0;
        } en[0:0];
    } ISP_CCM_CFG @ 0x31400;

    reg {
        name = "CCM coefficient register 0";
        desc = "ISP_CCM_COEF0 is CCM coefficient register 0.

Data sheet 10.6 ISP_CCM_COEF0 (offset 0x41410, printed page 10-297, `hi3516cv300--Hi3516CV300-Hi3516EV100-Datasheet.txt` line 57523).";

        field {
            name = "coef01";
            desc = "CCM coefficient Its format is S5.10. It consists of a sign bit, a 4-bit integral part, and a 10-bit decimal part.";
            sw = rw;
            hw = r;
            reset = 0x0;
        } coef01[31:17];

        field {
            name = "coef00";
            desc = "CCM coefficient Its format is S5.10. It consists of a sign bit, a 4-bit integral part, and a 10-bit decimal part.";
            sw = rw;
            hw = r;
            reset = 0x400;
        } coef00[15:1];
    } ISP_CCM_COEF0 @ 0x31410;

    reg {
        name = "CCM coefficient register 1";
        desc = "ISP_CCM_COEF1 is CCM coefficient register 1.

Data sheet 10.6 ISP_CCM_COEF1 (offset 0x41414, printed page 10-297, `hi3516cv300--Hi3516CV300-Hi3516EV100-Datasheet.txt` line 57551).";

        field {
            name = "coef10";
            desc = "CCM coefficient Its format is S5.10. It consists of a sign bit, a 4-bit integral part, and a 10-bit decimal part.";
            sw = rw;
            hw = r;
            reset = 0x0;
        } coef10[31:17];

        field {
            name = "coef02";
            desc = "CCM coefficient Its format is S5.10. It consists of a sign bit, a 4-bit integral part, and a 10-bit decimal part.";
            sw = rw;
            hw = r;
            reset = 0x0;
        } coef02[15:1];
    } ISP_CCM_COEF1 @ 0x31414;

    reg {
        name = "CCM coefficient register 2";
        desc = "ISP_CCM_COEF2 is CCM coefficient register 2.

Data sheet 10.6 ISP_CCM_COEF2 (offset 0x41418, printed page 10-298, `hi3516cv300--Hi3516CV300-Hi3516EV100-Datasheet.txt` line 57590).";

        field {
            name = "coef12";
            desc = "CCM coefficient Its format is S5.10. It consists of a sign bit, a 4-bit integral part, and a 10-bit decimal part.";
            sw = rw;
            hw = r;
            reset = 0x0;
        } coef12[31:17];

        field {
            name = "coef11";
            desc = "CCM coefficient Its format is S5.10. It consists of a sign bit, a 4-bit integral part, and a 10-bit decimal part.";
            sw = rw;
            hw = r;
            reset = 0x400;
        } coef11[15:1];
    } ISP_CCM_COEF2 @ 0x31418;

    reg {
        name = "CCM coefficient register 3";
        desc = "ISP_CCM_COEF3 is CCM coefficient register 3. Hi3516C V300/Hi3516E V100 Professional HD IP Camera SoC

Data sheet 10.6 ISP_CCM_COEF3 (offset 0x4141C, printed page 10-299, `hi3516cv300--Hi3516CV300-Hi3516EV100-Datasheet.txt` line 57628).";

        field {
            name = "coef21";
            desc = "CCM coefficient Its format is S5.10. It consists of a sign bit, a 4-bit integral part, and a 10-bit decimal part.";
            sw = rw;
            hw = r;
            reset = 0x0;
        } coef21[31:17];

        field {
            name = "coef20";
            desc = "CCM coefficient Its format is S5.10. It consists of a sign bit, a 4-bit integral part, and a 10-bit decimal part.";
            sw = rw;
            hw = r;
            reset = 0x0;
        } coef20[15:1];
    } ISP_CCM_COEF3 @ 0x3141C;

    reg {
        name = "CCM coefficient register 4";
        desc = "ISP_CCM_COEF4 is CCM coefficient register 4.

Data sheet 10.6 ISP_CCM_COEF4 (offset 0x41420, printed page 10-299, `hi3516cv300--Hi3516CV300-Hi3516EV100-Datasheet.txt` line 57656).";

        field {
            name = "coef22";
            desc = "CCM coefficient Its format is S5.10. It consists of a sign bit, a 4-bit integral part, and a 10-bit decimal part.";
            sw = rw;
            hw = r;
            reset = 0x400;
        } coef22[15:1];
    } ISP_CCM_COEF4 @ 0x31420;

    reg {
        name = "CCM luminance protection threshold register";
        desc = "ISP_CCM_BRIT_THRES is a CCM luminance protection threshold register.

Data sheet 10.6 ISP_CCM_BRIT_THRES (offset 0x41448, printed page 10-300, `hi3516cv300--Hi3516CV300-Hi3516EV100-Datasheet.txt` line 57689).";

        field {
            name = "brit_thres1";
            desc = "Luminance protection threshold 1 It is an unsigned integer.";
            sw = rw;
            hw = r;
            reset = 0x0;
        } brit_thres1[24:16];

        field {
            name = "brit_thres0";
            desc = "Luminance protection threshold 0 It is an unsigned integer.";
            sw = rw;
            hw = r;
            reset = 0x0;
        } brit_thres0[7:0];
    } ISP_CCM_BRIT_THRES @ 0x31448;

    reg {
        name = "CCM chrominance protection ES threshold register";
        desc = "ISP_CCM_COLOR_THRES is a CCM chrominance protection threshold register.

Data sheet 10.6 ISP_CCM_COLOR_THRES (offset 0x4144C, printed page 10-300, `hi3516cv300--Hi3516CV300-Hi3516EV100-Datasheet.txt` line 57715).";

        field {
            name = "color_thres1";
            desc = "Chrominance protection threshold 1 It is an unsigned integer.";
            sw = rw;
            hw = r;
            reset = 0x0;
        } color_thres1[24:16];

        field {
            name = "color_thres0";
            desc = "Chrominance protection threshold 0 It is an unsigned integer.";
            sw = rw;
            hw = r;
            reset = 0x0;
        } color_thres0[7:0];
    } ISP_CCM_COLOR_THRES @ 0x3144C;

    reg {
        name = "CCM blending ratio threshold register";
        desc = "ISP_CCM_LOW_RATIO is a CCM blending ratio threshold register. Hi3516C V300/Hi3516E V100 Professional HD IP Camera SoC

Data sheet 10.6 ISP_CCM_LOW_RATIO (offset 0x41450, printed page 10-301, `hi3516cv300--Hi3516CV300-Hi3516EV100-Datasheet.txt` line 57748).";

        field {
            name = "low_ratio";
            desc = "Blending ratio threshold It is an unsigned integer.";
            sw = rw;
            hw = r;
            reset = 0x0;
        } low_ratio[7:0];
    } ISP_CCM_LOW_RATIO @ 0x31450;

    reg {
        name = "CCM blending ratio register";
        desc = "ISP_CCM_PRO_RATIO is a CCM blending ratio register.

Data sheet 10.6 ISP_CCM_PRO_RATIO (offset 0x41454, printed page 10-301, `hi3516cv300--Hi3516CV300-Hi3516EV100-Datasheet.txt` line 57770).";

        field {
            name = "brit_ratio";
            desc = "Luminance blending ratio";
            sw = rw;
            hw = r;
            reset = 0x0;
        } brit_ratio[27:16];

        field {
            name = "color_ratio";
            desc = "Chromiance blending ratio";
            sw = rw;
            hw = r;
            reset = 0x0;
        } color_ratio[11:0];
    } ISP_CCM_PRO_RATIO @ 0x31454;

    reg {
        name = "CCM hue adjustment RB channel _RB_GAIN gain register";
        desc = "ISP_CCM_COLORTONE_RB_GAIN is a CCM hue adjustment RB channel gain register. Hi3516C V300/Hi3516E V100 Professional HD IP Camera SoC

Data sheet 10.6 ISP_CCM_COLORTONE_RB_GAIN (offset 0x41458, printed page 10-302, `hi3516cv300--Hi3516CV300-Hi3516EV100-Datasheet.txt` line 57800).";

        field {
            name = "r_gain";
            desc = "R channel gain of CCM hue adjustment, 4.8 precision. It is an unsigned number.";
            sw = rw;
            hw = r;
            reset = 0x100;
        } r_gain[27:16];

        field {
            name = "b_gain";
            desc = "B channel gain of CCM hue adjustment, 4.8 precision. It is an unsigned number.";
            sw = rw;
            hw = r;
            reset = 0x100;
        } b_gain[11:0];
    } ISP_CCM_COLORTONE_RB_GAIN @ 0x31458;

    reg {
        name = "CCM hue adjustment G channel gain _G_GAIN register";
        desc = "ISP_CCM_COLORTONE_G_GAIN is a CCM hue adjustment G channel gain register.

Data sheet 10.6 ISP_CCM_COLORTONE_G_GAIN (offset 0x4145C, printed page 10-302, `hi3516cv300--Hi3516CV300-Hi3516EV100-Datasheet.txt` line 57826).";

        field {
            name = "g_gain";
            desc = "G channel gain of CCM hue adjustment, 4.8 precision. It is an unsigned number.";
            sw = rw;
            hw = r;
            reset = 0x100;
        } g_gain[11:0];
    } ISP_CCM_COLORTONE_G_GAIN @ 0x3145C;

    reg {
        name = "CCM dark region protection 0 extended function threshold 0 register";
        desc = "ISP_CCM_PROT_EX_TH0 is a CCM dark region protection extended function threshold 0 register. Hi3516C V300/Hi3516E V100 Professional HD IP Camera SoC

Data sheet 10.6 ISP_CCM_PROT_EX_TH0 (offset 0x41460, printed page 10-303, `hi3516cv300--Hi3516CV300-Hi3516EV100-Datasheet.txt` line 57858).";

        field {
            name = "data_bb_thd0";
            desc = "BB threshold 0";
            sw = rw;
            hw = r;
            reset = 0x0;
        } data_bb_thd0[29:20];

        field {
            name = "data_gg_thd0";
            desc = "GG threshold 0";
            sw = rw;
            hw = r;
            reset = 0x0;
        } data_gg_thd0[19:10];

        field {
            name = "data_rr_thd0";
            desc = "RR threshold 0";
            sw = rw;
            hw = r;
            reset = 0x0;
        } data_rr_thd0[9:0];
    } ISP_CCM_PROT_EX_TH0 @ 0x31460;

    reg {
        name = "CCM dark region protection 1 extended function threshold 1 register";
        desc = "ISP_CCM_PROT_EX_TH1 is a CCM dark region protection extended function threshold 1 register.

Data sheet 10.6 ISP_CCM_PROT_EX_TH1 (offset 0x41464, printed page 10-303, `hi3516cv300--Hi3516CV300-Hi3516EV100-Datasheet.txt` line 57884).";

        field {
            name = "data_bb_thd1";
            desc = "BB threshold 1";
            sw = rw;
            hw = r;
            reset = 0x0;
        } data_bb_thd1[29:20];

        field {
            name = "data_gg_thd1";
            desc = "GG threshold 1";
            sw = rw;
            hw = r;
            reset = 0x0;
        } data_gg_thd1[19:10];

        field {
            name = "data_rr_thd1";
            desc = "RR threshold 1";
            sw = rw;
            hw = r;
            reset = 0x0;
        } data_rr_thd1[9:0];
    } ISP_CCM_PROT_EX_TH1 @ 0x31464;

    reg {
        name = "CCM dark region protection B_SET extended function RGB configuration register";
        desc = "ISP_CCM_PROT_EX_RGB_SET is a CCM dark region protection extended function RGB configuration register. Hi3516C V300/Hi3516E V100 Professional HD IP Camera SoC

Data sheet 10.6 ISP_CCM_PROT_EX_RGB_SET (offset 0x41468, printed page 10-304, `hi3516cv300--Hi3516CV300-Hi3516EV100-Datasheet.txt` line 57919).";

        field {
            name = "max_rgb_thd";
            desc = "Dark region threshold";
            sw = rw;
            hw = r;
            reset = 0x0;
        } max_rgb_thd[25:16];

        field {
            name = "rgb_prot_ration";
            desc = "Minimum gain of dark region color protection. It ranges from 0 to 256.";
            sw = rw;
            hw = r;
            reset = 0x0;
        } rgb_prot_ration[8:0];
    } ISP_CCM_PROT_EX_RGB_SET @ 0x31468;

    reg {
        name = "CSC enable register";
        desc = "ISP_CSC_CFG is a CSC enable register.

Data sheet 10.6 ISP_CSC_CFG (offset 0x41500, printed page 10-304, `hi3516cv300--Hi3516CV300-Hi3516EV100-Datasheet.txt` line 57943).";

        enum ISP_CSC_CFG_en_enum {
            DISABLED = 0 { name = "Disabled"; desc = "disabled"; };
            ENABLED = 1 { name = "Enabled"; desc = "enabled"; };
        };

        field {
            name = "en";
            desc = "CSC enable";
            sw = rw;
            hw = r;
            encode = ISP_CSC_CFG_en_enum;
            reset = 0x0;
        } en[0:0];
    } ISP_CSC_CFG @ 0x31500;

    reg {
        name = "ISP colour-space conversion VERSION";
        desc = "[inferred] ISP colour-space conversion VERSION. Not in the data sheet. Source: OpenIPC openhisilicon `kernel/isp/arch/hi3516cv300/firmware/vreg/arch/hi3516cv300/isp_reg_define.h` (GPL-3.0 repository, HiSilicon copyright, nManager-generated 2015-12-22 \"Define all registers/tables for Hi3519\"; local copy sources/openhisilicon), union `U_ISP_CSC_VERSION`, struct offset 0x3150C (GPL-3.0 repository; header offsets are ISP-core relative (data sheet offset - 0x20000), 632 of 775 data-sheet registers match it by name and offset (ISP_BLC_CFG is at 0x21100 in the data sheet and 0x1000+0x20000 in the header)). Reset value and access type unknown (modelled RW, no reset). Confidence: medium (vendor header for this chip family, not hardware verified).";

        field {
            name = "version";
            desc = "[inferred] Version. (vendor header `isp_reg_define.h` field `version`; access and reset unknown, modelled RW)";
            sw = rw;
            hw = r;
        } version[31:0];
    } ISP_CSC_VERSION @ 0x3150C;

    reg {
        name = "CSC coefficient register 0";
        desc = "ISP_CSC_COEF0 is CSC coefficient register 0. Hi3516C V300/Hi3516E V100 Professional HD IP Camera SoC

Data sheet 10.6 ISP_CSC_COEF0 (offset 0x41510, printed page 10-305, `hi3516cv300--Hi3516CV300-Hi3516EV100-Datasheet.txt` line 57973).";

        field {
            name = "coef01";
            desc = "CSC coefficient Its format is S5.10. It consists of a sign bit, a 4-bit integral part, and a 10-bit decimal part.";
            sw = rw;
            hw = r;
            reset = 0x2DC;
        } coef01[31:17];

        field {
            name = "coef00";
            desc = "CSC coefficient Its format is S5.10. It consists of a sign bit, a 4-bit integral part, and a 10-bit decimal part.";
            sw = rw;
            hw = r;
            reset = 0xDA;
        } coef00[15:1];
    } ISP_CSC_COEF0 @ 0x31510;

    reg {
        name = "CSC coefficient register 1";
        desc = "ISP_CSC_COEF1 is CSC coefficient register 1.

Data sheet 10.6 ISP_CSC_COEF1 (offset 0x41514, printed page 10-305, `hi3516cv300--Hi3516CV300-Hi3516EV100-Datasheet.txt` line 58001).";

        field {
            name = "coef10";
            desc = "CSC coefficient Its format is S5.10. It consists of a sign bit, a 4-bit integral part, and a 10-bit decimal part.";
            sw = rw;
            hw = r;
            reset = 0x7F89;
        } coef10[31:17];

        field {
            name = "coef02";
            desc = "CSC coefficient Its format is S5.10. It consists of a sign bit, a 4-bit integral part, and a 10-bit decimal part.";
            sw = rw;
            hw = r;
            reset = 0x49;
        } coef02[15:1];
    } ISP_CSC_COEF1 @ 0x31514;

    reg {
        name = "CSC coefficient register 2";
        desc = "ISP_CSC_COEF2 is CSC coefficient register 2.

Data sheet 10.6 ISP_CSC_COEF2 (offset 0x41518, printed page 10-306, `hi3516cv300--Hi3516CV300-Hi3516EV100-Datasheet.txt` line 58040).";

        field {
            name = "coef12";
            desc = "CSC coefficient Its format is S5.10. It consists of a sign bit, a 4-bit integral part, and a 10-bit decimal part.";
            sw = rw;
            hw = r;
            reset = 0x20B;
        } coef12[31:17];

        field {
            name = "coef11";
            desc = "CSC coefficient Its format is S5.10. It consists of a sign bit, a 4-bit integral part, and a 10-bit decimal part.";
            sw = rw;
            hw = r;
            reset = 0x7E6D;
        } coef11[15:1];
    } ISP_CSC_COEF2 @ 0x31518;

    reg {
        name = "CSC coefficient register 3";
        desc = "ISP_CSC_COEF3 is CSC coefficient register 3. Hi3516C V300/Hi3516E V100 Professional HD IP Camera SoC

Data sheet 10.6 ISP_CSC_COEF3 (offset 0x4151C, printed page 10-307, `hi3516cv300--Hi3516CV300-Hi3516EV100-Datasheet.txt` line 58078).";

        field {
            name = "coef21";
            desc = "CSC coefficient Its format is S5.10. It consists of a sign bit, a 4-bit integral part, and a 10-bit decimal part.";
            sw = rw;
            hw = r;
            reset = 0x7E25;
        } coef21[31:17];

        field {
            name = "coef20";
            desc = "CSC coefficient Its format is S5.10. It consists of a sign bit, a 4-bit integral part, and a 10-bit decimal part.";
            sw = rw;
            hw = r;
            reset = 0x20B;
        } coef20[15:1];
    } ISP_CSC_COEF3 @ 0x3151C;

    reg {
        name = "CSC coefficient register 4";
        desc = "ISP_CSC_COEF4 is CSC coefficient register 4.

Data sheet 10.6 ISP_CSC_COEF4 (offset 0x41520, printed page 10-307, `hi3516cv300--Hi3516CV300-Hi3516EV100-Datasheet.txt` line 58106).";

        field {
            name = "coef22";
            desc = "CSC coefficient Its format is S5.10. It consists of a sign bit, a 4-bit integral part, and a 10-bit decimal part.";
            sw = rw;
            hw = r;
            reset = 0x7FD0;
        } coef22[15:1];
    } ISP_CSC_COEF4 @ 0x31520;

    reg {
        name = "CSC input DC component register 0";
        desc = "ISP_CSC_IN_DC0 is CSC input DC component register 0.

Data sheet 10.6 ISP_CSC_IN_DC0 (offset 0x41530, printed page 10-308, `hi3516cv300--Hi3516CV300-Hi3516EV100-Datasheet.txt` line 58140).";

        field {
            name = "in_dc1";
            desc = "DC offset of the input G component, defined in the 10-bit coding Its format is S11. It consists of a sign bit and a 10-bit integer part.";
            sw = rw;
            hw = r;
            reset = 0x0;
        } in_dc1[31:21];

        field {
            name = "in_dc0";
            desc = "DC offset of the input R component, defined in the 10-bit coding Its format is S11. It consists of a sign bit and a 10-bit integer part.";
            sw = rw;
            hw = r;
            reset = 0x0;
        } in_dc0[15:5];
    } ISP_CSC_IN_DC0 @ 0x31530;

    reg {
        name = "CSC input DC component register 1";
        desc = "ISP_CSC_IN_DC1 is CSC input DC component register 1.

Data sheet 10.6 ISP_CSC_IN_DC1 (offset 0x41534, printed page 10-308, `hi3516cv300--Hi3516CV300-Hi3516EV100-Datasheet.txt` line 58166).";

        field {
            name = "in_dc2";
            desc = "DC offset of the input B component, defined in the 10-bit coding Its format is S11. It consists of a sign bit and a 10-bit integer part.";
            sw = rw;
            hw = r;
            reset = 0x0;
        } in_dc2[15:5];
    } ISP_CSC_IN_DC1 @ 0x31534;

    reg {
        name = "CSC output DC component register 0";
        desc = "ISP_CSC_OUT_DC0 is CSC output DC component register 0. Hi3516C V300/Hi3516E V100 Professional HD IP Camera SoC

Data sheet 10.6 ISP_CSC_OUT_DC0 (offset 0x41540, printed page 10-309, `hi3516cv300--Hi3516CV300-Hi3516EV100-Datasheet.txt` line 58199).";

        field {
            name = "out_dc1";
            desc = "DC offset of the output U component, defined in the 10-bit coding Its format is S11. It consists of a sign bit and a 10-bit integer part.";
            sw = rw;
            hw = r;
            reset = 0x200;
        } out_dc1[31:21];

        field {
            name = "out_dc0";
            desc = "DC offset of the output Y component, defined in the 10-bit coding Its format is S11. It consists of a sign bit and a 10-bit integer part.";
            sw = rw;
            hw = r;
            reset = 0x0;
        } out_dc0[15:5];
    } ISP_CSC_OUT_DC0 @ 0x31540;

    reg {
        name = "CSC output DC component register 1";
        desc = "ISP_CSC_OUT_DC1 is CSC output DC component register 1.

Data sheet 10.6 ISP_CSC_OUT_DC1 (offset 0x41544, printed page 10-309, `hi3516cv300--Hi3516CV300-Hi3516EV100-Datasheet.txt` line 58225).";

        field {
            name = "out_dc2";
            desc = "DC offset of the output V component, defined in the 10-bit coding Its format is S11. It consists of a sign bit and a 10-bit integer part.";
            sw = rw;
            hw = r;
            reset = 0x200;
        } out_dc2[15:5];
    } ISP_CSC_OUT_DC1 @ 0x31544;

    reg {
        name = "ISP colour-space conversion control I";
        desc = "[inferred] ISP colour-space conversion control I. Not in the data sheet. Source: OpenIPC openhisilicon `kernel/isp/arch/hi3516cv300/firmware/vreg/arch/hi3516cv300/isp_reg_define.h` (GPL-3.0 repository, HiSilicon copyright, nManager-generated 2015-12-22 \"Define all registers/tables for Hi3519\"; local copy sources/openhisilicon), union `U_ISP_CSC_CTRL_I`, struct offset 0x315E4 (GPL-3.0 repository; header offsets are ISP-core relative (data sheet offset - 0x20000), 632 of 775 data-sheet registers match it by name and offset (ISP_BLC_CFG is at 0x21100 in the data sheet and 0x1000+0x20000 in the header)). Reset value and access type unknown (modelled RW, no reset). Confidence: medium (vendor header for this chip family, not hardware verified).";

        field {
            name = "update_mode";
            desc = "[inferred] Update mode. (vendor header `isp_reg_define.h` field `update_mode`; access and reset unknown, modelled RW)";
            sw = rw;
            hw = r;
        } update_mode[0:0];
    } ISP_CSC_CTRL_I @ 0x315E4;

    reg {
        name = "ISP colour-space conversion UPDATE";
        desc = "[inferred] ISP colour-space conversion UPDATE. Not in the data sheet. Source: OpenIPC openhisilicon `kernel/isp/arch/hi3516cv300/firmware/vreg/arch/hi3516cv300/isp_reg_define.h` (GPL-3.0 repository, HiSilicon copyright, nManager-generated 2015-12-22 \"Define all registers/tables for Hi3519\"; local copy sources/openhisilicon), union `U_ISP_CSC_UPDATE`, struct offset 0x315EC (GPL-3.0 repository; header offsets are ISP-core relative (data sheet offset - 0x20000), 632 of 775 data-sheet registers match it by name and offset (ISP_BLC_CFG is at 0x21100 in the data sheet and 0x1000+0x20000 in the header)). Reset value and access type unknown (modelled RW, no reset). Confidence: medium (vendor header for this chip family, not hardware verified).";

        field {
            name = "update";
            desc = "[inferred] Update. (vendor header `isp_reg_define.h` field `update`; access and reset unknown, modelled RW)";
            sw = rw;
            hw = r;
        } update[0:0];
    } ISP_CSC_UPDATE @ 0x315EC;

    reg {
        name = "MCDS control register";
        desc = "ISP_UVNR_CFG is a MCDS control register. Hi3516C V300/Hi3516E V100 Professional HD IP Camera SoC

Data sheet 10.6 ISP_MCDS_CFG (offset 0x41800, printed page 10-310, `hi3516cv300--Hi3516CV300-Hi3516EV100-Datasheet.txt` line 58258).";

        enum ISP_MCDS_CFG_uvnr_sel_enum {
            DISABLED = 0 { name = "Disabled"; desc = "disabled"; };
            ENABLED = 1 { name = "Enabled"; desc = "enabled"; };
        };

        field {
            name = "uvnr_sel";
            desc = "MCDSILTER enable";
            sw = rw;
            hw = r;
            encode = ISP_MCDS_CFG_uvnr_sel_enum;
            reset = 0x0;
        } uvnr_sel[4:4];

        enum ISP_MCDS_CFG_uv2c_mode_enum {
            OUTPUT_U_COMPONENT = 0 { name = "Output U Component"; desc = "Output the U component data."; };
            OUTPUT_V_COMPONENT = 1 { name = "Output V Component"; desc = "Output the V component data."; };
        };

        field {
            name = "uv2c_mode";
            desc = "UV2C bypass mode";
            sw = rw;
            hw = r;
            encode = ISP_MCDS_CFG_uv2c_mode_enum;
            reset = 0x0;
        } uv2c_mode[3:3];

        enum ISP_MCDS_CFG_vcds_en_enum {
            DISABLED = 0 { name = "Disabled"; desc = "disabled"; };
            ENABLED = 1 { name = "Enabled"; desc = "enabled"; };
        };

        field {
            name = "vcds_en";
            desc = "Chrominance vertical down sampling enable";
            sw = rw;
            hw = r;
            encode = ISP_MCDS_CFG_vcds_en_enum;
            reset = 0x0;
        } vcds_en[1:1];

        enum ISP_MCDS_CFG_hcds_en_enum {
            DISABLED = 0 { name = "Disabled"; desc = "disabled"; };
            ENABLED = 1 { name = "Enabled"; desc = "enabled"; };
        };

        field {
            name = "hcds_en";
            desc = "Chrominance horizontal down sampling enable";
            sw = rw;
            hw = r;
            encode = ISP_MCDS_CFG_hcds_en_enum;
            reset = 0x0;
        } hcds_en[0:0];
    } ISP_MCDS_CFG @ 0x31800;

    reg {
        name = "ISP MCDS VERSION";
        desc = "[inferred] ISP MCDS VERSION. Not in the data sheet. Source: OpenIPC openhisilicon `kernel/isp/arch/hi3516cv300/firmware/vreg/arch/hi3516cv300/isp_reg_define.h` (GPL-3.0 repository, HiSilicon copyright, nManager-generated 2015-12-22 \"Define all registers/tables for Hi3519\"; local copy sources/openhisilicon), union `U_ISP_MCDS_VERSION`, struct offset 0x3180C (GPL-3.0 repository; header offsets are ISP-core relative (data sheet offset - 0x20000), 632 of 775 data-sheet registers match it by name and offset (ISP_BLC_CFG is at 0x21100 in the data sheet and 0x1000+0x20000 in the header)). Reset value and access type unknown (modelled RW, no reset). Confidence: medium (vendor header for this chip family, not hardware verified).";

        field {
            name = "version";
            desc = "[inferred] Version. (vendor header `isp_reg_define.h` field `version`; access and reset unknown, modelled RW)";
            sw = rw;
            hw = r;
        } version[31:0];
    } ISP_MCDS_VERSION @ 0x3180C;

    reg {
        name = "Horizontal chrominance down sampling input size configuration register";
        desc = "ISP_HCDS_SIZE is a horizontal chrominance down sampling input size configuration register. Hi3516C V300/Hi3516E V100 Professional HD IP Camera SoC

Data sheet 10.6 ISP_HCDS_SIZE (offset 0x41814, printed page 10-311, `hi3516cv300--Hi3516CV300-Hi3516EV100-Datasheet.txt` line 58305).";

        field {
            name = "width_out";
            desc = "U/V line width (in pixel) of the output picture during horizontal chrominance down sampling. The configured value is the actual value minus 1.";
            sw = rw;
            hw = r;
            reset = 0x3BF;
        } width_out[28:16];

        field {
            name = "width_in";
            desc = "U/V line width (in pixel) of the input picture. The configured value is the actual value minus 1.";
            sw = rw;
            hw = r;
            reset = 0x77F;
        } width_in[12:0];
    } ISP_HCDS_SIZE @ 0x31814;

    reg {
        name = "Horizontal chrominance down sampling coefficient register 0";
        desc = "ISP_HCDS_COEF0 is horizontal chrominance down sampling coefficient register 0.

Data sheet 10.6 ISP_HCDS_COEF0 (offset 0x4181C, printed page 10-311, `hi3516cv300--Hi3516CV300-Hi3516EV100-Datasheet.txt` line 58334).";

        field {
            name = "coef2";
            desc = "Horizontal chrominance scaling and filtering coefficient 2";
            sw = rw;
            hw = r;
            reset = 0x91;
        } coef2[29:20];

        field {
            name = "coef1";
            desc = "Horizontal chrominance scaling and filtering coefficient 1";
            sw = rw;
            hw = r;
            reset = 0x0;
        } coef1[19:10];

        field {
            name = "coef0";
            desc = "Horizontal chrominance scaling and filtering coefficient 0 Horizontal scaling contains eight taps, and the sum of the eight coefficients is 512. The format is S10.0 and the value range is [- 512, 511].";
            sw = rw;
            hw = r;
            reset = 0x3F0;
        } coef0[9:0];
    } ISP_HCDS_COEF0 @ 0x3181C;

    reg {
        name = "Horizontal chrominance down sampling coefficient register 1";
        desc = "ISP_HCDS_COEF1 is horizontal chrominance down sampling coefficient register 1.

Data sheet 10.6 ISP_HCDS_COEF1 (offset 0x41820, printed page 10-312, `hi3516cv300--Hi3516CV300-Hi3516EV100-Datasheet.txt` line 58368).";

        field {
            name = "coef5";
            desc = "Horizontal chrominance scaling and filtering coefficient 5";
            sw = rw;
            hw = r;
            reset = 0x0;
        } coef5[29:20];

        field {
            name = "coef4";
            desc = "Horizontal chrominance scaling and filtering coefficient 4";
            sw = rw;
            hw = r;
            reset = 0x91;
        } coef4[19:10];

        field {
            name = "coef3";
            desc = "Horizontal chrominance scaling and filtering coefficient 3";
            sw = rw;
            hw = r;
            reset = 0xFE;
        } coef3[9:0];
    } ISP_HCDS_COEF1 @ 0x31820;

    reg {
        name = "Horizontal chrominance down sampling coefficient register 2";
        desc = "ISP_HCDS_COEF2 is horizontal chrominance down sampling coefficient register 2.

Data sheet 10.6 ISP_HCDS_COEF2 (offset 0x41824, printed page 10-312, `hi3516cv300--Hi3516CV300-Hi3516EV100-Datasheet.txt` line 58393).";

        field {
            name = "coef7";
            desc = "Horizontal chrominance scaling and filtering coefficient 7";
            sw = rw;
            hw = r;
            reset = 0x0;
        } coef7[19:10];

        field {
            name = "coef6";
            desc = "Horizontal chrominance scaling and filtering coefficient 6";
            sw = rw;
            hw = r;
            reset = 0x3F0;
        } coef6[9:0];
    } ISP_HCDS_COEF2 @ 0x31824;

    reg {
        name = "Vertical chrominance down sampling coefficient register";
        desc = "ISP_VCDS_COEF is a vertical chrominance down sampling coefficient register. Hi3516C V300/Hi3516E V100 Professional HD IP Camera SoC

Data sheet 10.6 ISP_VCDS_COEF (offset 0x41828, printed page 10-313, `hi3516cv300--Hi3516CV300-Hi3516EV100-Datasheet.txt` line 58422).";

        field {
            name = "coef3";
            desc = "Down sampling coefficient 3. The value meanings are the same as those of coefficient 0.";
            sw = rw;
            hw = r;
            reset = 0x6;
        } coef3[26:24];

        field {
            name = "coef2";
            desc = "Down sampling coefficient 2. The value meanings are the same as those of coefficient 0.";
            sw = rw;
            hw = r;
            reset = 0x6;
        } coef2[18:16];

        field {
            name = "coef1";
            desc = "Down sampling coefficient 1. The value meanings are the same as those of coefficient 0.";
            sw = rw;
            hw = r;
            reset = 0x4;
        } coef1[10:8];

        enum ISP_VCDS_COEF_coef0_enum {
            MULTIPLIED_1 = 0 { name = "Multiplied 1"; desc = "multiplied by 1"; };
            MULTIPLIED_2 = 1 { name = "Multiplied 2"; desc = "multiplied by 2"; };
            MULTIPLIED_4 = 2 { name = "Multiplied 4"; desc = "multiplied by 4"; };
            MULTIPLIED_8 = 3 { name = "Multiplied 8"; desc = "multiplied by 8"; };
            MULTIPLIED_16 = 4 { name = "Multiplied 16"; desc = "multiplied by 16"; };
            MULTIPLIED_32 = 5 { name = "Multiplied 32"; desc = "multiplied by 32"; };
            MULTIPLIED_0 = 6 { name = "Multiplied 0"; desc = "multiplied by 0"; };
            MULTIPLIED_0_2 = 7 { name = "Multiplied 0 2"; desc = "multiplied by 0 (invalid)"; };
        };

        field {
            name = "coef0";
            desc = "Down sampling coefficient 0";
            sw = rw;
            hw = r;
            encode = ISP_VCDS_COEF_coef0_enum;
            reset = 0x4;
        } coef0[2:0];
    } ISP_VCDS_COEF @ 0x31828;

    reg {
        name = "Median filtering input picture chrominance width/height register";
        desc = "ISP_MIDF_SIZE is a median filtering input picture chrominance width/height register. Hi3516C V300/Hi3516E V100 Professional HD IP Camera SoC

Data sheet 10.6 ISP_MIDF_SIZE (offset 0x4182C, printed page 10-314, `hi3516cv300--Hi3516CV300-Hi3516EV100-Datasheet.txt` line 58472).";

        field {
            name = "height";
            desc = "Picture height after vertical chrominance down sampling. The configured value is the actual height minus 1. For example, if the actual picture height is 720, set this field to 719.";
            sw = rw;
            hw = r;
            reset = 0x437;
        } height[28:16];

        field {
            name = "width";
            desc = "Picture width after vertical chrominance down sampling (UV-to-C conversion). The configured value is the actual width minus 1. For example, if the actual picture width is 1280, set this field to 1279.";
            sw = rw;
            hw = r;
            reset = 0x77F;
        } width[12:0];
    } ISP_MIDF_SIZE @ 0x3182C;

    reg {
        name = "NR blending ratio and shift register";
        desc = "ISP_MCDS_PARA is an NR blending ratio and shift register.

Data sheet 10.6 ISP_MCDS_PARA (offset 0x41844, printed page 10-314, `hi3516cv300--Hi3516CV300-Hi3516EV100-Datasheet.txt` line 58501).";

        field {
            name = "midf_bldr";
            desc = "MIDF blending ratio. The format is U5.0 and the value range is [0, 16].";
            sw = rw;
            hw = r;
            reset = 0x0;
        } midf_bldr[28:24];

        field {
            name = "limit";
            desc = "Coring function limit configuration. The format is U7.0 and the value range is [0, 127].";
            sw = rw;
            hw = r;
            reset = 0x0;
        } limit[22:16];
    } ISP_MCDS_PARA @ 0x31844;

    reg {
        name = "ISP MCDS control I";
        desc = "[inferred] ISP MCDS control I. Not in the data sheet. Source: OpenIPC openhisilicon `kernel/isp/arch/hi3516cv300/firmware/vreg/arch/hi3516cv300/isp_reg_define.h` (GPL-3.0 repository, HiSilicon copyright, nManager-generated 2015-12-22 \"Define all registers/tables for Hi3519\"; local copy sources/openhisilicon), union `U_ISP_MCDS_CTRL_I`, struct offset 0x318E4 (GPL-3.0 repository; header offsets are ISP-core relative (data sheet offset - 0x20000), 632 of 775 data-sheet registers match it by name and offset (ISP_BLC_CFG is at 0x21100 in the data sheet and 0x1000+0x20000 in the header)). Reset value and access type unknown (modelled RW, no reset). Confidence: medium (vendor header for this chip family, not hardware verified).";

        field {
            name = "update_mode";
            desc = "[inferred] Update mode. (vendor header `isp_reg_define.h` field `update_mode`; access and reset unknown, modelled RW)";
            sw = rw;
            hw = r;
        } update_mode[0:0];
    } ISP_MCDS_CTRL_I @ 0x318E4;

    reg {
        name = "ISP MCDS TIMING";
        desc = "[inferred] ISP MCDS TIMING. Not in the data sheet. Source: OpenIPC openhisilicon `kernel/isp/arch/hi3516cv300/firmware/vreg/arch/hi3516cv300/isp_reg_define.h` (GPL-3.0 repository, HiSilicon copyright, nManager-generated 2015-12-22 \"Define all registers/tables for Hi3519\"; local copy sources/openhisilicon), union `U_ISP_MCDS_TIMING`, struct offset 0x318E8 (GPL-3.0 repository; header offsets are ISP-core relative (data sheet offset - 0x20000), 632 of 775 data-sheet registers match it by name and offset (ISP_BLC_CFG is at 0x21100 in the data sheet and 0x1000+0x20000 in the header)). Reset value and access type unknown (modelled RW, no reset). Confidence: medium (vendor header for this chip family, not hardware verified).";

        field {
            name = "cpi_fix_timing_stat";
            desc = "[inferred] Cpi fix timing status. (vendor header `isp_reg_define.h` field `cpi_fix_timing_stat`; access and reset unknown, modelled RW)";
            sw = rw;
            hw = r;
        } cpi_fix_timing_stat[13:1];
    } ISP_MCDS_TIMING @ 0x318E8;

    reg {
        name = "ISP MCDS UPDATE";
        desc = "[inferred] ISP MCDS UPDATE. Not in the data sheet. Source: OpenIPC openhisilicon `kernel/isp/arch/hi3516cv300/firmware/vreg/arch/hi3516cv300/isp_reg_define.h` (GPL-3.0 repository, HiSilicon copyright, nManager-generated 2015-12-22 \"Define all registers/tables for Hi3519\"; local copy sources/openhisilicon), union `U_ISP_MCDS_UPDATE`, struct offset 0x318EC (GPL-3.0 repository; header offsets are ISP-core relative (data sheet offset - 0x20000), 632 of 775 data-sheet registers match it by name and offset (ISP_BLC_CFG is at 0x21100 in the data sheet and 0x1000+0x20000 in the header)). Reset value and access type unknown (modelled RW, no reset). Confidence: medium (vendor header for this chip family, not hardware verified).";

        field {
            name = "update";
            desc = "[inferred] Update. (vendor header `isp_reg_define.h` field `update`; access and reset unknown, modelled RW)";
            sw = rw;
            hw = r;
        } update[0:0];
    } ISP_MCDS_UPDATE @ 0x318EC;

    reg {
        name = "MCDS input picture size register";
        desc = "ISP_MCDS_SIZE is an MCDS input picture size register.

Data sheet 10.6 ISP_MCDS_SIZE (offset 0x418F0, printed page 10-315, `hi3516cv300--Hi3516CV300-Hi3516EV100-Datasheet.txt` line 58541).";

        field {
            name = "height";
            desc = "Input picture height. The configured value is the actual value minus 1. For example, for the 1080P picture, set the height to 1079.";
            sw = rw;
            hw = r;
            reset = 0x437;
        } height[28:16];

        field {
            name = "width";
            desc = "Input picture width. The configured value is the actual value minus 1. For example, for the 1080P picture, set the width to 1919.";
            sw = rw;
            hw = r;
            reset = 0x77F;
        } width[12:0];
    } ISP_MCDS_SIZE @ 0x318F0;

    reg {
        name = "GLOBALCAC control register";
        desc = "ISP_GCAC_CFG is global CAC control register.

Data sheet 10.6 ISP_GCAC_CFG (offset 0x43200, printed page 10-315, `hi3516cv300--Hi3516CV300-Hi3516EV100-Datasheet.txt` line 58570).";

        enum ISP_GCAC_CFG_gcac_en_enum {
            DISABLED = 0 { name = "Disabled"; desc = "disabled"; };
            ENABLED = 1 { name = "Enabled"; desc = "enabled"; };
        };

        field {
            name = "gcac_en";
            desc = "Global CAC enable";
            sw = rw;
            hw = r;
            encode = ISP_GCAC_CFG_gcac_en_enum;
            reset = 0x0;
        } gcac_en[0:0];
    } ISP_GCAC_CFG @ 0x33200;

    reg {
        name = "ISP GCAC VERSION";
        desc = "[inferred] ISP GCAC VERSION. Not in the data sheet. Source: OpenIPC openhisilicon `kernel/isp/arch/hi3516cv300/firmware/vreg/arch/hi3516cv300/isp_reg_define.h` (GPL-3.0 repository, HiSilicon copyright, nManager-generated 2015-12-22 \"Define all registers/tables for Hi3519\"; local copy sources/openhisilicon), union `U_ISP_GCAC_VERSION`, struct offset 0x3320C (GPL-3.0 repository; header offsets are ISP-core relative (data sheet offset - 0x20000), 632 of 775 data-sheet registers match it by name and offset (ISP_BLC_CFG is at 0x21100 in the data sheet and 0x1000+0x20000 in the header)). Reset value and access type unknown (modelled RW, no reset). Confidence: medium (vendor header for this chip family, not hardware verified).";

        field {
            name = "version";
            desc = "[inferred] Version. (vendor header `isp_reg_define.h` field `version`; access and reset unknown, modelled RW)";
            sw = rw;
            hw = r;
        } version[31:0];
    } ISP_GCAC_VERSION @ 0x3320C;

    reg {
        name = "Global CAC polynomial coefficient A register";
        desc = "ISP_GCAC_PARAMA is a global CAC polynomial coefficient A register.

Data sheet 10.6 ISP_GCAC_PARAMA (offset 0x43210, printed page 10-316, `hi3516cv300--Hi3516CV300-Hi3516EV100-Datasheet.txt` line 58600).";

        field {
            name = "blue_a";
            desc = "Coefficient A of the B component. The format is S9.0 and the value range is [-256, 255].";
            sw = rw;
            hw = r;
            reset = 0x0;
        } blue_a[24:16];

        field {
            name = "red_a";
            desc = "Coefficient A of the R component. The format is S9.0 and the value range is [-256, 255].";
            sw = rw;
            hw = r;
            reset = 0x0;
        } red_a[8:0];
    } ISP_GCAC_PARAMA @ 0x33210;

    reg {
        name = "Global CAC polynomial coefficient B register";
        desc = "ISP_GCAC_PARAMB is a global CAC polynomial coefficient B register.

Data sheet 10.6 ISP_GCAC_PARAMB (offset 0x43214, printed page 10-316, `hi3516cv300--Hi3516CV300-Hi3516EV100-Datasheet.txt` line 58626).";

        field {
            name = "blue_b";
            desc = "Coefficient B of the B component. The format is S9.0 and the value range is [-256, 255].";
            sw = rw;
            hw = r;
            reset = 0x0;
        } blue_b[24:16];

        field {
            name = "red_b";
            desc = "Coefficient B of the R component. The format is S9.0 and the value range is [-256, 255].";
            sw = rw;
            hw = r;
            reset = 0x0;
        } red_b[8:0];
    } ISP_GCAC_PARAMB @ 0x33214;

    reg {
        name = "Global CAC polynomial coefficient C register";
        desc = "ISP_GCAC_PARAMC is a global CAC polynomial coefficient C register. Hi3516C V300/Hi3516E V100 Professional HD IP Camera SoC

Data sheet 10.6 ISP_GCAC_PARAMC (offset 0x43218, printed page 10-317, `hi3516cv300--Hi3516CV300-Hi3516EV100-Datasheet.txt` line 58661).";

        field {
            name = "blue_c";
            desc = "Coefficient C of the B component. The format is S9.0 and the value range is [-256, 255].";
            sw = rw;
            hw = r;
            reset = 0x0;
        } blue_c[24:16];

        field {
            name = "red_c";
            desc = "Coefficient C of the R component. The format is S9.0 and the value range is [-256, 255].";
            sw = rw;
            hw = r;
            reset = 0x0;
        } red_c[8:0];
    } ISP_GCAC_PARAMC @ 0x33218;

    reg {
        name = "Global CAC vertical normalization factor register";
        desc = "ISP_GCAC_YNORM is a global CAC vertical normalization factor register.

Data sheet 10.6 ISP_GCAC_YNORM (offset 0x4321C, printed page 10-317, `hi3516cv300--Hi3516CV300-Hi3516EV100-Datasheet.txt` line 58687).";

        field {
            name = "ns_y";
            desc = "Vertical shift factor. The format is U4.0 and the value range is [0, 7].";
            sw = rw;
            hw = r;
            reset = 0x0;
        } ns_y[18:16];

        field {
            name = "nf_y";
            desc = "Vertical normalization factor. The format is U5.0 and the value range is [0, 31].";
            sw = rw;
            hw = r;
            reset = 0x0;
        } nf_y[4:0];
    } ISP_GCAC_YNORM @ 0x3321C;

    reg {
        name = "Global CAC horizontal normalization factor register";
        desc = "ISP_GCAC_XNORM is a global CAC horizontal normalization factor register. Hi3516C V300/Hi3516E V100 Professional HD IP Camera SoC

Data sheet 10.6 ISP_GCAC_XNORM (offset 0x43220, printed page 10-318, `hi3516cv300--Hi3516CV300-Hi3516EV100-Datasheet.txt` line 58724).";

        field {
            name = "ns_x";
            desc = "Horizontal shift factor. The format is U4.0 and the value range is [0, 7].";
            sw = rw;
            hw = r;
            reset = 0x0;
        } ns_x[18:16];

        field {
            name = "nf_x";
            desc = "Horizontal normalization factor. The format is U5.0 and the value range is [0, 31].";
            sw = rw;
            hw = r;
            reset = 0x0;
        } nf_x[4:0];
    } ISP_GCAC_XNORM @ 0x33220;

    reg {
        name = "Global CAC optical center coordinate register";
        desc = "ISP_GCAC_CNTSTART is a global CAC optical center coordinate register.

Data sheet 10.6 ISP_GCAC_CNTSTART (offset 0x43224, printed page 10-318, `hi3516cv300--Hi3516CV300-Hi3516EV100-Datasheet.txt` line 58752).";

        field {
            name = "cnt_start_v";
            desc = "Vertical coordinate of the global CAC optical center. The format is U13.0 and the value range is [0, 8191].";
            sw = rw;
            hw = r;
            reset = 0x0;
        } cnt_start_v[28:16];

        field {
            name = "cnt_start_h";
            desc = "Horizontal coordinate of the global CAC optical center. The format is U13.0 and the value range is [0, 8191].";
            sw = rw;
            hw = r;
            reset = 0x0;
        } cnt_start_h[12:0];
    } ISP_GCAC_CNTSTART @ 0x33224;

    reg {
        name = "Global CAC original picture start coordinate register";
        desc = "ISP_GCAC_CORSTART is a global CAC original picture start coordinate register. Hi3516C V300/Hi3516E V100 Professional HD IP Camera SoC

Data sheet 10.6 ISP_GCAC_CORSTART (offset 0x43228, printed page 10-319, `hi3516cv300--Hi3516CV300-Hi3516EV100-Datasheet.txt` line 58789).";

        field {
            name = "cor_start_v";
            desc = "Start vertical coordinate of the global CAC original picture. The format is U13.0 and the value range is [0, 8191].";
            sw = rw;
            hw = r;
            reset = 0x0;
        } cor_start_v[28:16];

        field {
            name = "cor_start_h";
            desc = "Start horizontal coordinate of the global CAC original picture. The format is U13.0 and the value range is [0, 8191].";
            sw = rw;
            hw = r;
            reset = 0x0;
        } cor_start_h[12:0];
    } ISP_GCAC_CORSTART @ 0x33228;

    reg {
        name = "Global CAC filtering enable register";
        desc = "ISP_GCAC_FILTEN is a global CAC filtering enable register.

Data sheet 10.6 ISP_GCAC_FILTEN (offset 0x4322C, printed page 10-319, `hi3516cv300--Hi3516CV300-Hi3516EV100-Datasheet.txt` line 58818).";

        enum ISP_GCAC_FILTEN_ver_filt_en_enum {
            DISABLED = 0 { name = "Disabled"; desc = "disabled"; };
            ENABLED = 1 { name = "Enabled"; desc = "enabled"; };
        };

        field {
            name = "ver_filt_en";
            desc = "Global CAC vertical filtering enable";
            sw = rw;
            hw = r;
            encode = ISP_GCAC_FILTEN_ver_filt_en_enum;
            reset = 0x0;
        } ver_filt_en[0:0];
    } ISP_GCAC_FILTEN @ 0x3322C;

    reg {
        name = "Global CAC filtering mode select register";
        desc = "ISP_GCAC_CHRVMODE is a global CAC filtering mode select register.

Data sheet 10.6 ISP_GCAC_CHRVMODE (offset 0x43230, printed page 10-320, `hi3516cv300--Hi3516CV300-Hi3516EV100-Datasheet.txt` line 58852).";

        enum ISP_GCAC_CHRVMODE_chrv_mode_enum {
            INVALID = 0 { name = "Invalid"; desc = "invalid"; };
            FILTERING_COEFFICIENT_8 = 1 { name = "Filtering Coefficient 8"; desc = "filtering coefficient {8,16,8}"; };
            FILTERING_COEFFICIENT_10 = 2 { name = "Filtering Coefficient 10"; desc = "filtering coefficient {10,12,10}"; };
            FILTERING_COEFFICIENT_12 = 3 { name = "Filtering Coefficient 12"; desc = "filtering coefficient {12,8,12}"; };
        };

        field {
            name = "chrv_mode";
            desc = "Global CAC vertical filtering mode";
            sw = rw;
            hw = r;
            encode = ISP_GCAC_CHRVMODE_chrv_mode_enum;
            reset = 0x0;
        } chrv_mode[1:0];
    } ISP_GCAC_CHRVMODE @ 0x33230;

    reg {
        name = "Global CAC truncation mode select register";
        desc = "ISP_GCAC_CLIPMODE is a global CAC clipping mode select register.

Data sheet 10.6 ISP_GCAC_CLIPMODE (offset 0x43234, printed page 10-320, `hi3516cv300--Hi3516CV300-Hi3516EV100-Datasheet.txt` line 58881).";

        enum ISP_GCAC_CLIPMODE_clip_mode_v_enum {
            FIXED_CLIPPING_CLIPPING = 0 { name = "Fixed Clipping Clipping"; desc = "fixed clipping. The clipping range is [96, 160]."; };
            FIXED_CLIPPING_CLIPPING_2 = 1 { name = "Fixed Clipping Clipping 2"; desc = "fixed clipping. The clipping range is [80, 176]."; };
            DYNAMIC_CLIPPING_CLIPPING = 2 { name = "Dynamic Clipping Clipping"; desc = "dynamic clipping. The clipping range is determined by the Bayer format of the pixel. The clipping range for the R and B pixels is [64, 192], and that for the Gr and Gb pixels is [80, 176]."; };
            INVALID = 3 { name = "Invalid"; desc = "invalid"; };
        };

        field {
            name = "clip_mode_v";
            desc = "Global CAC vertical clipping mode. The value ranges from 0 to 2.";
            sw = rw;
            hw = r;
            encode = ISP_GCAC_CLIPMODE_clip_mode_v_enum;
            reset = 0x0;
        } clip_mode_v[17:16];

        enum ISP_GCAC_CLIPMODE_clip_mode_h_enum {
            FIXED_CLIPPING_CLIPPING = 0 { name = "Fixed Clipping Clipping"; desc = "fixed clipping. The clipping range is [64, 192]."; };
            DYNAMIC_CLIPPING_CLIPPING = 1 { name = "Dynamic Clipping Clipping"; desc = "dynamic clipping, The clipping range is determined by the Bayer format of the pixel. The clipping range for column R (R and Gb) on plane R is [64, 192], that for column B (B and Gr) on plane R is [80,176], that for column R on plane B is [80, 176], and that for column B on plane B is [64, 192]."; };
        };

        field {
            name = "clip_mode_h";
            desc = "Global CAC horizontal clipping mode";
            sw = rw;
            hw = r;
            encode = ISP_GCAC_CLIPMODE_clip_mode_h_enum;
            reset = 0x0;
        } clip_mode_h[0:0];
    } ISP_GCAC_CLIPMODE @ 0x33234;

    reg {
        name = "ISP GCAC control F";
        desc = "[inferred] ISP GCAC control F. Not in the data sheet. Source: OpenIPC openhisilicon `kernel/isp/arch/hi3516cv300/firmware/vreg/arch/hi3516cv300/isp_reg_define.h` (GPL-3.0 repository, HiSilicon copyright, nManager-generated 2015-12-22 \"Define all registers/tables for Hi3519\"; local copy sources/openhisilicon), union `U_ISP_GCAC_CTRL_F`, struct offset 0x332E0 (GPL-3.0 repository; header offsets are ISP-core relative (data sheet offset - 0x20000), 632 of 775 data-sheet registers match it by name and offset (ISP_BLC_CFG is at 0x21100 in the data sheet and 0x1000+0x20000 in the header)). Reset value and access type unknown (modelled RW, no reset). Confidence: medium (vendor header for this chip family, not hardware verified).";

        field {
            name = "rggb_cfg";
            desc = "[inferred] Rggb configuration. (vendor header `isp_reg_define.h` field `rggb_cfg`; access and reset unknown, modelled RW)";
            sw = rw;
            hw = r;
        } rggb_cfg[1:0];
    } ISP_GCAC_CTRL_F @ 0x332E0;

    reg {
        name = "ISP GCAC control I";
        desc = "[inferred] ISP GCAC control I. Not in the data sheet. Source: OpenIPC openhisilicon `kernel/isp/arch/hi3516cv300/firmware/vreg/arch/hi3516cv300/isp_reg_define.h` (GPL-3.0 repository, HiSilicon copyright, nManager-generated 2015-12-22 \"Define all registers/tables for Hi3519\"; local copy sources/openhisilicon), union `U_ISP_GCAC_CTRL_I`, struct offset 0x332E4 (GPL-3.0 repository; header offsets are ISP-core relative (data sheet offset - 0x20000), 632 of 775 data-sheet registers match it by name and offset (ISP_BLC_CFG is at 0x21100 in the data sheet and 0x1000+0x20000 in the header)). Reset value and access type unknown (modelled RW, no reset). Confidence: medium (vendor header for this chip family, not hardware verified).";

        field {
            name = "update_mode";
            desc = "[inferred] Update mode. (vendor header `isp_reg_define.h` field `update_mode`; access and reset unknown, modelled RW)";
            sw = rw;
            hw = r;
        } update_mode[0:0];
    } ISP_GCAC_CTRL_I @ 0x332E4;

    reg {
        name = "ISP GCAC TIMING";
        desc = "[inferred] ISP GCAC TIMING. Not in the data sheet. Source: OpenIPC openhisilicon `kernel/isp/arch/hi3516cv300/firmware/vreg/arch/hi3516cv300/isp_reg_define.h` (GPL-3.0 repository, HiSilicon copyright, nManager-generated 2015-12-22 \"Define all registers/tables for Hi3519\"; local copy sources/openhisilicon), union `U_ISP_GCAC_TIMING`, struct offset 0x332E8 (GPL-3.0 repository; header offsets are ISP-core relative (data sheet offset - 0x20000), 632 of 775 data-sheet registers match it by name and offset (ISP_BLC_CFG is at 0x21100 in the data sheet and 0x1000+0x20000 in the header)). Reset value and access type unknown (modelled RW, no reset). Confidence: medium (vendor header for this chip family, not hardware verified).";

        field {
            name = "cpi_fix_timing_stat";
            desc = "[inferred] Cpi fix timing status. (vendor header `isp_reg_define.h` field `cpi_fix_timing_stat`; access and reset unknown, modelled RW)";
            sw = rw;
            hw = r;
        } cpi_fix_timing_stat[13:1];
    } ISP_GCAC_TIMING @ 0x332E8;

    reg {
        name = "ISP GCAC UPDATE";
        desc = "[inferred] ISP GCAC UPDATE. Not in the data sheet. Source: OpenIPC openhisilicon `kernel/isp/arch/hi3516cv300/firmware/vreg/arch/hi3516cv300/isp_reg_define.h` (GPL-3.0 repository, HiSilicon copyright, nManager-generated 2015-12-22 \"Define all registers/tables for Hi3519\"; local copy sources/openhisilicon), union `U_ISP_GCAC_UPDATE`, struct offset 0x332EC (GPL-3.0 repository; header offsets are ISP-core relative (data sheet offset - 0x20000), 632 of 775 data-sheet registers match it by name and offset (ISP_BLC_CFG is at 0x21100 in the data sheet and 0x1000+0x20000 in the header)). Reset value and access type unknown (modelled RW, no reset). Confidence: medium (vendor header for this chip family, not hardware verified).";

        field {
            name = "update";
            desc = "[inferred] Update. (vendor header `isp_reg_define.h` field `update`; access and reset unknown, modelled RW)";
            sw = rw;
            hw = r;
        } update[0:0];
    } ISP_GCAC_UPDATE @ 0x332EC;

    reg {
        name = "Global CAC input picture size register";
        desc = "ISP_GCAC_SIZE is a global CAC input picture size register.

Data sheet 10.6 ISP_GCAC_SIZE (offset 0x432F0, printed page 10-321, `hi3516cv300--Hi3516CV300-Hi3516EV100-Datasheet.txt` line 58932).";

        field {
            name = "height";
            desc = "Input picture height. The configured value is the actual value minus 1. For example, for the 1080P picture, set the height to 1079.";
            sw = rw;
            hw = r;
            reset = 0x437;
        } height[28:16];

        field {
            name = "width";
            desc = "Input picture width. The configured value is the actual value minus 1. For example, for the 1080P picture, set the width to 1919.";
            sw = rw;
            hw = r;
            reset = 0x77F;
        } width[12:0];
    } ISP_GCAC_SIZE @ 0x332F0;

    reg {
        name = "Demosaic control register";
        desc = "ISP_DEMOSAIC_CFG is a demosaic control register. Hi3516C V300/Hi3516E V100 Professional HD IP Camera SoC

Data sheet 10.6 ISP_DEMOSAIC_CFG (offset 0x44000, printed page 10-322, `hi3516cv300--Hi3516CV300-Hi3516EV100-Datasheet.txt` line 58970).";

        enum ISP_DEMOSAIC_CFG_en_enum {
            DISABLED = 0 { name = "Disabled"; desc = "disabled"; };
            ENABLED = 1 { name = "Enabled"; desc = "enabled"; };
        };

        field {
            name = "en";
            desc = "Demosaic enable";
            sw = rw;
            hw = r;
            encode = ISP_DEMOSAIC_CFG_en_enum;
            reset = 0x0;
        } en[0:0];
    } ISP_DEMOSAIC_CFG @ 0x34000;

    reg {
        name = "Demosaic internal algorithm enable register";
        desc = "ISP_DEMOSAIC_CFG1 is a demosaic internal algorithm enable register.

Data sheet 10.6 ISP_DEMOSAIC_CFG1 (offset 0x44004, printed page 10-322, `hi3516cv300--Hi3516CV300-Hi3516EV100-Datasheet.txt` line 58992).";

        enum ISP_DEMOSAIC_CFG1_de_fake_en_enum {
            ENABLED = 1 { name = "Enabled"; desc = "enabled"; };
            DISABLED = 0 { name = "Disabled"; desc = "disabled"; };
        };

        field {
            name = "de_fake_en";
            desc = "Demosaic anti-false color enable";
            sw = rw;
            hw = r;
            encode = ISP_DEMOSAIC_CFG1_de_fake_en_enum;
            reset = 0x1;
        } de_fake_en[21:21];

        enum ISP_DEMOSAIC_CFG1_mid_filter_en_enum {
            ENABLED = 1 { name = "Enabled"; desc = "enabled"; };
            DISABLED = 0 { name = "Disabled"; desc = "disabled"; };
        };

        field {
            name = "mid_filter_en";
            desc = "Demosaic RGB interpolation median filtering enable";
            sw = rw;
            hw = r;
            encode = ISP_DEMOSAIC_CFG1_mid_filter_en_enum;
            reset = 0x1;
        } mid_filter_en[20:20];

        enum ISP_DEMOSAIC_CFG1_hv_dir_en_enum {
            DISABLED = 0 { name = "Disabled"; desc = "disabled"; };
            ENABLED = 1 { name = "Enabled"; desc = "enabled"; };
        };

        field {
            name = "hv_dir_en";
            desc = "Demosaic HV direction correction enable";
            sw = rw;
            hw = r;
            encode = ISP_DEMOSAIC_CFG1_hv_dir_en_enum;
            reset = 0x1;
        } hv_dir_en[19:19];

        enum ISP_DEMOSAIC_CFG1_gcac_blend_select_enum {
            OUTPUT_DATA_GCAC = 0 { name = "Output Data Gcac"; desc = "The output data is the GCAC and demosaic blending data."; };
            RB_COMPONENT_OUTPUT = 1 { name = "Rb Component Output"; desc = "The RB component of the output data is GCAC data."; };
        };

        field {
            name = "gcac_blend_select";
            desc = "GCAC and Demosaic data blending control";
            sw = rw;
            hw = r;
            encode = ISP_DEMOSAIC_CFG1_gcac_blend_select_enum;
            reset = 0x0;
        } gcac_blend_select[18:18];

        enum ISP_DEMOSAIC_CFG1_local_cac_en_enum {
            DISABLED = 0 { name = "Disabled"; desc = "disabled"; };
            ENABLED = 1 { name = "Enabled"; desc = "enabled"; };
        };

        field {
            name = "local_cac_en";
            desc = "Demosaic local cac nable";
            sw = rw;
            hw = r;
            encode = ISP_DEMOSAIC_CFG1_local_cac_en_enum;
            reset = 0x1;
        } local_cac_en[17:17];

        enum ISP_DEMOSAIC_CFG1_fcr_en_enum {
            DISABLED = 0 { name = "Disabled"; desc = "disabled"; };
            ENABLED = 1 { name = "Enabled"; desc = "enabled"; };
        };

        field {
            name = "fcr_en";
            desc = "Demosaic FCR enable";
            sw = rw;
            hw = r;
            encode = ISP_DEMOSAIC_CFG1_fcr_en_enum;
            reset = 0x1;
        } fcr_en[16:16];

        enum ISP_DEMOSAIC_CFG1_ahd_en_enum {
            DISABLED = 0 { name = "Disabled"; desc = "disabled"; };
            ENABLED = 1 { name = "Enabled"; desc = "enabled"; };
        };

        field {
            name = "ahd_en";
            desc = "Demosaic AHD enable";
            sw = rw;
            hw = r;
            encode = ISP_DEMOSAIC_CFG1_ahd_en_enum;
            reset = 0x1;
        } ahd_en[0:0];
    } ISP_DEMOSAIC_CFG1 @ 0x34004;

    reg {
        name = "ISP demosaic VERSION";
        desc = "[inferred] ISP demosaic VERSION. Not in the data sheet. Source: OpenIPC openhisilicon `kernel/isp/arch/hi3516cv300/firmware/vreg/arch/hi3516cv300/isp_reg_define.h` (GPL-3.0 repository, HiSilicon copyright, nManager-generated 2015-12-22 \"Define all registers/tables for Hi3519\"; local copy sources/openhisilicon), union `U_ISP_DEMOSAIC_VERSION`, struct offset 0x3400C (GPL-3.0 repository; header offsets are ISP-core relative (data sheet offset - 0x20000), 632 of 775 data-sheet registers match it by name and offset (ISP_BLC_CFG is at 0x21100 in the data sheet and 0x1000+0x20000 in the header)). Reset value and access type unknown (modelled RW, no reset). Confidence: medium (vendor header for this chip family, not hardware verified).";

        field {
            name = "version";
            desc = "[inferred] Version. (vendor header `isp_reg_define.h` field `version`; access and reset unknown, modelled RW)";
            sw = rw;
            hw = r;
        } version[31:0];
    } ISP_DEMOSAIC_VERSION @ 0x3400C;

    reg {
        name = "Demosaic parameter register 0";
        desc = "ISP_DEMOSAIC_COEF0 is a demosaic parameter register 0.

Data sheet 10.6 ISP_DEMOSAIC_COEF0 (offset 0x44010, printed page 10-323, `hi3516cv300--Hi3516CV300-Hi3516EV100-Datasheet.txt` line 59050).";

        field {
            name = "bld_limit1";
            desc = "Demosaic gradient blending threshold (U8.0)";
            sw = rw;
            hw = r;
            reset = 0x18;
        } bld_limit1[23:16];

        field {
            name = "bld_limit2";
            desc = "Demosaic gradient blending threshold (U8.0)";
            sw = rw;
            hw = r;
            reset = 0x28;
        } bld_limit2[7:0];
    } ISP_DEMOSAIC_COEF0 @ 0x34010;

    reg {
        name = "Demosaic parameter register 1";
        desc = "ISP_DEMOSAIC_COEF1 is a demosaic parameter register 1. Hi3516C V300/Hi3516E V100 Professional HD IP Camera SoC

Data sheet 10.6 ISP_DEMOSAIC_COEF1 (offset 0x44014, printed page 10-324, `hi3516cv300--Hi3516CV300-Hi3516EV100-Datasheet.txt` line 59080).";

        field {
            name = "bld_ratio1";
            desc = "Demosaic gradient blending threshold (U9.0)";
            sw = rw;
            hw = r;
            reset = 0x0;
        } bld_ratio1[24:16];

        field {
            name = "bld_ratio2";
            desc = "Demosaic gradient blending threshold (U9.0)";
            sw = rw;
            hw = r;
            reset = 0x100;
        } bld_ratio2[8:0];
    } ISP_DEMOSAIC_COEF1 @ 0x34014;

    reg {
        name = "Demosaic parameter register 2";
        desc = "ISP_DEMOSAIC_COEF2 is a demosaic parameter register 2.

Data sheet 10.6 ISP_DEMOSAIC_COEF2 (offset 0x44018, printed page 10-324, `hi3516cv300--Hi3516CV300-Hi3516EV100-Datasheet.txt` line 59102).";

        field {
            name = "fcr_limit1";
            desc = "Demosaic FCR threshold (U12.0)";
            sw = rw;
            hw = r;
            reset = 0x10;
        } fcr_limit1[27:16];

        field {
            name = "fcr_limit2";
            desc = "Demosaic FCR threshold (U12.0)";
            sw = rw;
            hw = r;
            reset = 0xA0;
        } fcr_limit2[11:0];
    } ISP_DEMOSAIC_COEF2 @ 0x34018;

    reg {
        name = "Demosaic parameter register 3";
        desc = "ISP_DEMOSAIC_COEF3 is a demosaic parameter register 3. Hi3516C V300/Hi3516E V100 Professional HD IP Camera SoC

Data sheet 10.6 ISP_DEMOSAIC_COEF3 (offset 0x4401C, printed page 10-325, `hi3516cv300--Hi3516CV300-Hi3516EV100-Datasheet.txt` line 59133).";

        field {
            name = "ahd_par1";
            desc = "Demosaic AHD coefficient (U10.0)";
            sw = rw;
            hw = r;
            reset = 0x190;
        } ahd_par1[25:16];

        field {
            name = "ahd_par2";
            desc = "Demosaic AHD coefficient (U8.0)";
            sw = rw;
            hw = r;
            reset = 0x8;
        } ahd_par2[7:0];
    } ISP_DEMOSAIC_COEF3 @ 0x3401C;

    reg {
        name = "Demosaic parameter register 4";
        desc = "ISP_DEMOSAIC_COEF4 is a demosaic parameter register 4.

Data sheet 10.6 ISP_DEMOSAIC_COEF4 (offset 0x44020, printed page 10-325, `hi3516cv300--Hi3516CV300-Hi3516EV100-Datasheet.txt` line 59155).";

        field {
            name = "fcr_thr";
            desc = "Demosaic FCR threshold (U12.0)";
            sw = rw;
            hw = r;
            reset = 0x1;
        } fcr_thr[27:16];

        field {
            name = "fcr_gain";
            desc = "Demosaic FCR gain (U5.0)";
            sw = rw;
            hw = r;
            reset = 0x8;
        } fcr_gain[4:0];
    } ISP_DEMOSAIC_COEF4 @ 0x34020;

    reg {
        name = "Demosaic parameter register 5";
        desc = "ISP_DEMOSAIC_COEF5 is a demosaic parameter register 5. Hi3516C V300/Hi3516E V100 Professional HD IP Camera SoC

Data sheet 10.6 ISP_DEMOSAIC_COEF5 (offset 0x44024, printed page 10-326, `hi3516cv300--Hi3516CV300-Hi3516EV100-Datasheet.txt` line 59186).";

        field {
            name = "hv_ratio";
            desc = "Direction ratio (U8.0)";
            sw = rw;
            hw = r;
            reset = 0x30;
        } hv_ratio[7:0];
    } ISP_DEMOSAIC_COEF5 @ 0x34024;

    reg {
        name = "Demosaic parameter register 6";
        desc = "ISP_DEMOSAIC_COEF6 is a demosaic parameter register 6.

Data sheet 10.6 ISP_DEMOSAIC_COEF6 (offset 0x44028, printed page 10-326, `hi3516cv300--Hi3516CV300-Hi3516EV100-Datasheet.txt` line 59206).";

        field {
            name = "fcr_ratio";
            desc = "DEMOSAIC FCR adjustment ratio (U6.0)";
            sw = rw;
            hw = r;
            reset = 0xA;
        } fcr_ratio[5:0];
    } ISP_DEMOSAIC_COEF6 @ 0x34028;

    reg {
        name = "Demosaic threshold register";
        desc = "ISP_DEMOSAIC_SEL is a direction select register.

Data sheet 10.6 ISP_DEMOSAIC_SEL (offset 0x44030, printed page 10-326, `hi3516cv300--Hi3516CV300-Hi3516EV100-Datasheet.txt` line 59225).";

        field {
            name = "hv_sel";
            desc = "Direction select (U2.0)";
            sw = rw;
            hw = r;
            reset = 0x3;
        } hv_sel[1:0];
    } ISP_DEMOSAIC_SEL @ 0x34030;

    reg {
        name = "ISP demosaic TMP";
        desc = "[inferred] ISP demosaic TMP. Not in the data sheet. Source: OpenIPC openhisilicon `kernel/isp/arch/hi3516cv300/firmware/vreg/arch/hi3516cv300/isp_reg_define.h` (GPL-3.0 repository, HiSilicon copyright, nManager-generated 2015-12-22 \"Define all registers/tables for Hi3519\"; local copy sources/openhisilicon), union `U_ISP_DEMOSAIC_TMP`, struct offset 0x34034 (GPL-3.0 repository; header offsets are ISP-core relative (data sheet offset - 0x20000), 632 of 775 data-sheet registers match it by name and offset (ISP_BLC_CFG is at 0x21100 in the data sheet and 0x1000+0x20000 in the header)). Reset value and access type unknown (modelled RW, no reset). Confidence: medium (vendor header for this chip family, not hardware verified).";

        field {
            name = "tmplate";
            desc = "[inferred] Tmplate. (vendor header `isp_reg_define.h` field `tmplate`; access and reset unknown, modelled RW)";
            sw = rw;
            hw = r;
        } tmplate[0:0];
    } ISP_DEMOSAIC_TMP @ 0x34034;

    reg {
        name = "Demosaic LCAC highlight count CNT_THR threshold register";
        desc = "ISP_DEMOSAIC_LCAC_CNT_THR is a demosaic LCAC highlight count threshold register. [check] The data-sheet table extraction produced overlapping bit fields for this register; the overlapping entries r_luma_thr[11:0], g_luma_thr[11:0] were dropped - verify against the printed page.

Data sheet 10.6 ISP_DEMOSAIC_LCAC_CNT_THR (offset 0x44038, printed page 10-327, `hi3516cv300--Hi3516CV300-Hi3516EV100-Datasheet.txt` line 59255).";

        field {
            name = "b_luma_thr";
            desc = "b_luma_thr";
            sw = rw;
            hw = r;
            reset = 0x0;
        } b_luma_thr[27:16];

        field {
            name = "g_counter_thr";
            desc = "Demosaic LCAC highlight count G threshold";
            sw = rw;
            hw = r;
            reset = 0x1;
        } g_counter_thr[15:10];

        field {
            name = "b_counter_thr";
            desc = "Demosaic LCAC highlight count B threshold";
            sw = rw;
            hw = r;
            reset = 0x1;
        } b_counter_thr[9:5];

        field {
            name = "r_counter_thr";
            desc = "Demosaic LCAC highlight count R threshold";
            sw = rw;
            hw = r;
            reset = 0x1;
        } r_counter_thr[4:0];
    } ISP_DEMOSAIC_LCAC_CNT_THR @ 0x34038;

    reg {
        name = "ISP demosaic LCAC LUMA RB THR";
        desc = "[inferred] ISP demosaic LCAC LUMA RB THR. Not in the data sheet. Source: OpenIPC openhisilicon `kernel/isp/arch/hi3516cv300/firmware/vreg/arch/hi3516cv300/isp_reg_define.h` (GPL-3.0 repository, HiSilicon copyright, nManager-generated 2015-12-22 \"Define all registers/tables for Hi3519\"; local copy sources/openhisilicon), union `U_ISP_DEMOSAIC_LCAC_LUMA_RB_THR`, struct offset 0x3403C (GPL-3.0 repository; header offsets are ISP-core relative (data sheet offset - 0x20000), 632 of 775 data-sheet registers match it by name and offset (ISP_BLC_CFG is at 0x21100 in the data sheet and 0x1000+0x20000 in the header)). Reset value and access type unknown (modelled RW, no reset). Confidence: medium (vendor header for this chip family, not hardware verified).";

        field {
            name = "b_luma_thr";
            desc = "[inferred] B luma thr. (vendor header `isp_reg_define.h` field `b_luma_thr`; access and reset unknown, modelled RW)";
            sw = rw;
            hw = r;
        } b_luma_thr[27:16];

        field {
            name = "r_luma_thr";
            desc = "[inferred] R luma thr. (vendor header `isp_reg_define.h` field `r_luma_thr`; access and reset unknown, modelled RW)";
            sw = rw;
            hw = r;
        } r_luma_thr[11:0];
    } ISP_DEMOSAIC_LCAC_LUMA_RB_THR @ 0x3403C;

    reg {
        name = "ISP demosaic LCAC LUMA G THR";
        desc = "[inferred] ISP demosaic LCAC LUMA G THR. Not in the data sheet. Source: OpenIPC openhisilicon `kernel/isp/arch/hi3516cv300/firmware/vreg/arch/hi3516cv300/isp_reg_define.h` (GPL-3.0 repository, HiSilicon copyright, nManager-generated 2015-12-22 \"Define all registers/tables for Hi3519\"; local copy sources/openhisilicon), union `U_ISP_DEMOSAIC_LCAC_LUMA_G_THR`, struct offset 0x34040 (GPL-3.0 repository; header offsets are ISP-core relative (data sheet offset - 0x20000), 632 of 775 data-sheet registers match it by name and offset (ISP_BLC_CFG is at 0x21100 in the data sheet and 0x1000+0x20000 in the header)). Reset value and access type unknown (modelled RW, no reset). Confidence: medium (vendor header for this chip family, not hardware verified).";

        field {
            name = "g_luma_thr";
            desc = "[inferred] G luma thr. (vendor header `isp_reg_define.h` field `g_luma_thr`; access and reset unknown, modelled RW)";
            sw = rw;
            hw = r;
        } g_luma_thr[11:0];
    } ISP_DEMOSAIC_LCAC_LUMA_G_THR @ 0x34040;

    reg {
        name = "Demosaic purple fringing detection E_VAR_THR variance threshold register";
        desc = "ISP_DEMOSAIC_PURPLE_VAR_THR is a demosaic purple fringing detection variance threshold register.

Data sheet 10.6 ISP_DEMOSAIC_PURPLE_VAR_THR (offset 0x44044, printed page 10-328, `hi3516cv300--Hi3516CV300-Hi3516EV100-Datasheet.txt` line 59334).";

        field {
            name = "purple_var_thr";
            desc = "Variance threshold of demosaic purple fringing detection";
            sw = rw;
            hw = r;
            reset = 0x0;
        } purple_var_thr[11:0];
    } ISP_DEMOSAIC_PURPLE_VAR_THR @ 0x34044;

    reg {
        name = "Demosaic pseudo-color detection CR_VAR_THR threshold register";
        desc = "ISP_DEMOSAIC_FAKE_CR_VAR_THR is a demosaic false color detection threshold register.

Data sheet 10.6 ISP_DEMOSAIC_FAKE_CR_VAR_THR (offset 0x44048, printed page 10-328, `hi3516cv300--Hi3516CV300-Hi3516EV100-Datasheet.txt` line 59354).";

        field {
            name = "fake_cr_var_thr_high";
            desc = "Upper threshold of demosaic false color detection";
            sw = rw;
            hw = r;
            reset = 0x12C;
        } fake_cr_var_thr_high[27:16];

        field {
            name = "fake_cr_var_thr_low";
            desc = "Lower threshold of demosaic false color detection";
            sw = rw;
            hw = r;
            reset = 0x0;
        } fake_cr_var_thr_low[11:0];
    } ISP_DEMOSAIC_FAKE_CR_VAR_THR @ 0x34048;

    reg {
        name = "Demosaic purple fringing removal PLECTR strength control register";
        desc = "ISP_DEMOSAIC_DEPURPLECTR is a demosaic purple fringing removal strength control register.

Data sheet 10.6 ISP_DEMOSAIC_DEPURPLECTR (offset 0x4404C, printed page 10-329, `hi3516cv300--Hi3516CV300-Hi3516EV100-Datasheet.txt` line 59389).";

        field {
            name = "depurplectrcr";
            desc = "Demosaic de-purple fringing Cr strength";
            sw = rw;
            hw = r;
            reset = 0x8;
        } depurplectrcr[19:16];

        field {
            name = "depurplectrcb";
            desc = "Demosaic de-purple fringing Cb strength";
            sw = rw;
            hw = r;
            reset = 0x4;
        } depurplectrcb[3:0];
    } ISP_DEMOSAIC_DEPURPLECTR @ 0x3404C;

    reg {
        name = "Demosaic direction detection INT_THLD threshold register";
        desc = "ISP_DEMOSAIC_HV_POINT_THLD is a demosaic direction detection threshold register.

Data sheet 10.6 ISP_DEMOSAIC_HV_POINT_THLD (offset 0x44050, printed page 10-329, `hi3516cv300--Hi3516CV300-Hi3516EV100-Datasheet.txt` line 59410).";

        field {
            name = "tot_point_thld";
            desc = "Demosaic block direction detection threshold";
            sw = rw;
            hw = r;
            reset = 0x14;
        } tot_point_thld[23:16];

        field {
            name = "sig_point_thld";
            desc = "Demosaic single-point direction detection threshold";
            sw = rw;
            hw = r;
            reset = 0x14;
        } sig_point_thld[9:0];
    } ISP_DEMOSAIC_HV_POINT_THLD @ 0x34050;

    reg {
        name = "Demosaic direction correction DJUST strength control register";
        desc = "ISP_DEMOSAIC_BLD_ADJUST is a demosaic direction correction strength control register.

Data sheet 10.6 ISP_DEMOSAIC_BLD_ADJUST (offset 0x44054, printed page 10-330, `hi3516cv300--Hi3516CV300-Hi3516EV100-Datasheet.txt` line 59436).";

        field {
            name = "bld_adjust";
            desc = "Demosiac direction correction strength";
            sw = rw;
            hw = r;
            reset = 0x4;
        } bld_adjust[3:0];
    } ISP_DEMOSAIC_BLD_ADJUST @ 0x34054;

    reg {
        name = "Demosaic anti-false color average VGTHLD chromatic aberration threshold register";
        desc = "ISP_DEMOSAIC_CBCRAVGTHLD is a demosaic anti-false color average chromatic aberration threshold register.

Data sheet 10.6 ISP_DEMOSAIC_CBCRAVGTHLD (offset 0x44058, printed page 10-330, `hi3516cv300--Hi3516CV300-Hi3516EV100-Datasheet.txt` line 59457).";

        field {
            name = "cbcr_avg_thld";
            desc = "Demosaic anti-false color average chromatic aberration threshold";
            sw = rw;
            hw = r;
            reset = 0x96;
        } cbcr_avg_thld[11:0];
    } ISP_DEMOSAIC_CBCRAVGTHLD @ 0x34058;

    reg {
        name = "Demosaic median filtering condition LD register";
        desc = "ISP_DEMOSAIC_GAPTHLD is a demosaic median filtering condition register. Hi3516C V300/Hi3516E V100 Professional HD IP Camera SoC

Data sheet 10.6 ISP_DEMOSAIC_GAPTHLD (offset 0x4405C, printed page 10-331, `hi3516cv300--Hi3516CV300-Hi3516EV100-Datasheet.txt` line 59486).";

        field {
            name = "g_gap_thld";
            desc = "Luminance difference threshold of the demosaic median filtering condition";
            sw = rw;
            hw = r;
            reset = 0x64;
        } g_gap_thld[27:16];

        field {
            name = "cr_gap_thld";
            desc = "Chrominance difference threshold of the demosaic median filtering condition";
            sw = rw;
            hw = r;
            reset = 0xC8;
        } cr_gap_thld[11:0];
    } ISP_DEMOSAIC_GAPTHLD @ 0x3405C;

    reg {
        name = "Demosaic direction correction THLD register";
        desc = "ISP_DEMOSAIC_COLORTHLD is a demosaic direction correction register. [check] The data-sheet table extraction produced overlapping bit fields for this register; the overlapping entries varthrforblend[11:0] were dropped - verify against the printed page.

Data sheet 10.6 ISP_DEMOSAIC_COLORTHLD (offset 0x44060, printed page 10-331, `hi3516cv300--Hi3516CV300-Hi3516EV100-Datasheet.txt` line 59512).";

        field {
            name = "colorthld";
            desc = "colorthld";
            sw = rw;
            hw = r;
            reset = 0x32;
        } colorthld[11:0];
    } ISP_DEMOSAIC_COLORTHLD @ 0x34060;

    reg {
        name = "ISP demosaic GVAR BLEND THLD";
        desc = "[inferred] ISP demosaic GVAR BLEND THLD. Not in the data sheet. Source: OpenIPC openhisilicon `kernel/isp/arch/hi3516cv300/firmware/vreg/arch/hi3516cv300/isp_reg_define.h` (GPL-3.0 repository, HiSilicon copyright, nManager-generated 2015-12-22 \"Define all registers/tables for Hi3519\"; local copy sources/openhisilicon), union `U_ISP_DEMOSAIC_GVAR_BLEND_THLD`, struct offset 0x34064 (GPL-3.0 repository; header offsets are ISP-core relative (data sheet offset - 0x20000), 632 of 775 data-sheet registers match it by name and offset (ISP_BLC_CFG is at 0x21100 in the data sheet and 0x1000+0x20000 in the header)). Reset value and access type unknown (modelled RW, no reset). Confidence: medium (vendor header for this chip family, not hardware verified).";

        field {
            name = "varthrforblend";
            desc = "[inferred] Varthrforblend. (vendor header `isp_reg_define.h` field `varthrforblend`; access and reset unknown, modelled RW)";
            sw = rw;
            hw = r;
        } varthrforblend[11:0];
    } ISP_DEMOSAIC_GVAR_BLEND_THLD @ 0x34064;

    reg {
        name = "Demosaic purple detection saturation THR threshold register";
        desc = "ISP_DEMOSAIC_SATU_THR is a demosaic purple detection saturation threshold register. [check] The data-sheet table extraction produced overlapping bit fields for this register; the overlapping entries cbcr_ratio_low_limit[11:0] were dropped - verify against the printed page.

Data sheet 10.6 ISP_DEMOSAIC_SATU_THR (offset 0x44068, printed page 10-332, `hi3516cv300--Hi3516CV300-Hi3516EV100-Datasheet.txt` line 59564).";

        field {
            name = "cbcr_ratio_high_limit";
            desc = "Upper threshold of purple region detection";
            sw = rw;
            hw = r;
            reset = 0x0;
        } cbcr_ratio_high_limit[27:16];

        field {
            name = "satu_thr";
            desc = "satu_thr";
            sw = rw;
            hw = r;
            reset = 0x0;
        } satu_thr[11:0];
    } ISP_DEMOSAIC_SATU_THR @ 0x34068;

    reg {
        name = "ISP demosaic CBCR RATIO LIMIT";
        desc = "[inferred] ISP demosaic CBCR RATIO LIMIT. Not in the data sheet. Source: OpenIPC openhisilicon `kernel/isp/arch/hi3516cv300/firmware/vreg/arch/hi3516cv300/isp_reg_define.h` (GPL-3.0 repository, HiSilicon copyright, nManager-generated 2015-12-22 \"Define all registers/tables for Hi3519\"; local copy sources/openhisilicon), union `U_ISP_DEMOSAIC_CBCR_RATIO_LIMIT`, struct offset 0x3406C (GPL-3.0 repository; header offsets are ISP-core relative (data sheet offset - 0x20000), 632 of 775 data-sheet registers match it by name and offset (ISP_BLC_CFG is at 0x21100 in the data sheet and 0x1000+0x20000 in the header)). Reset value and access type unknown (modelled RW, no reset). Confidence: medium (vendor header for this chip family, not hardware verified).";

        field {
            name = "cbcr_ratio_high_limit";
            desc = "[inferred] Cbcr ratio high limit. (vendor header `isp_reg_define.h` field `cbcr_ratio_high_limit`; access and reset unknown, modelled RW)";
            sw = rw;
            hw = r;
        } cbcr_ratio_high_limit[27:16];

        field {
            name = "cbcr_ratio_low_limit";
            desc = "[inferred] Cbcr ratio low limit. (vendor header `isp_reg_define.h` field `cbcr_ratio_low_limit`; access and reset unknown, modelled RW)";
            sw = rw;
            hw = r;
        } cbcr_ratio_low_limit[11:0];
    } ISP_DEMOSAIC_CBCR_RATIO_LIMIT @ 0x3406C;

    reg {
        name = "Demosaic FCR blending ratio RAY_RATIO register";
        desc = "ISP_DEMOSAIC_FCR_GRAY_RATIO is a demosaic FCR blending ratio register.

Data sheet 10.6 ISP_DEMOSAIC_FCR_GRAY_RATIO (offset 0x44070, printed page 10-333, `hi3516cv300--Hi3516CV300-Hi3516EV100-Datasheet.txt` line 59622).";

        field {
            name = "fcr_gray_ratio";
            desc = "Demosaic FCR blending ratio. The value ranges from 0 to 16.";
            sw = rw;
            hw = r;
            reset = 0x4;
        } fcr_gray_ratio[4:0];
    } ISP_DEMOSAIC_FCR_GRAY_RATIO @ 0x34070;

    reg {
        name = "Demosaic FCR calculated maximum EL value select register";
        desc = "ISP_DEMOSAIC_FCR_SEL is a demosaic FCR calculated maximum value select register.

Data sheet 10.6 ISP_DEMOSAIC_FCR_SEL (offset 0x44074, printed page 10-333, `hi3516cv300--Hi3516CV300-Hi3516EV100-Datasheet.txt` line 59642).";

        field {
            name = "fcr_cmax_sel";
            desc = "FCR CMAX select. The value range is [0, 8].";
            sw = rw;
            hw = r;
            reset = 0x2;
        } fcr_cmax_sel[7:4];

        field {
            name = "fcr_detg_sel";
            desc = "FCR DETG select. The value range is [0, 8].";
            sw = rw;
            hw = r;
            reset = 0x0;
        } fcr_detg_sel[3:0];
    } ISP_DEMOSAIC_FCR_SEL @ 0x34074;

    reg {
        name = "Demosaic same-channel blending _RATIO ratio configuration register";
        desc = "ISP_DEMOSAIC_BLEND_RATIO is a demosaic same-channel blending ratio configuration register. Hi3516C V300/Hi3516E V100 Professional HD IP Camera SoC

Data sheet 10.6 ISP_DEMOSAIC_BLEND_RATIO (offset 0x44078, printed page 10-334, `hi3516cv300--Hi3516CV300-Hi3516EV100-Datasheet.txt` line 59670).";

        field {
            name = "var_blend_th";
            desc = "Same-channel blending threshold. The value range is [0, 256].";
            sw = rw;
            hw = r;
            reset = 0xC8;
        } var_blend_th[28:20];

        field {
            name = "dif_blend_ratio1";
            desc = "Same-channel blending ratio 1. The value range is [0, 256].";
            sw = rw;
            hw = r;
            reset = 0x100;
        } dif_blend_ratio1[18:10];

        field {
            name = "dif_blend_ratio0";
            desc = "Same-channel blending ratio 0. The value range is [0, 256].";
            sw = rw;
            hw = r;
            reset = 0x0;
        } dif_blend_ratio0[8:0];
    } ISP_DEMOSAIC_BLEND_RATIO @ 0x34078;

    reg {
        name = "Demosaic same-channel blending _DIF_LIMIT limit configuration register";
        desc = "ISP_DEMOSAIC_BLEND_DIF_LIMIT is a demosaic same-channel blending limit configuration register.

Data sheet 10.6 ISP_DEMOSAIC_BLEND_DIF_LIMIT (offset 0x4407C, printed page 10-334, `hi3516cv300--Hi3516CV300-Hi3516EV100-Datasheet.txt` line 59698).";

        field {
            name = "dif2max_res_th";
            desc = "DIF MAX threshold";
            sw = rw;
            hw = r;
            reset = 0x64;
        } dif2max_res_th[25:16];

        field {
            name = "dif_blend_limit1";
            desc = "Same-channel blending limit 1. The value range is [0, 255].";
            sw = rw;
            hw = r;
            reset = 0x20;
        } dif_blend_limit1[15:8];

        field {
            name = "dif_blend_limit0";
            desc = "Same-channel blending limit 0. The value range is [0, 255].";
            sw = rw;
            hw = r;
            reset = 0x14;
        } dif_blend_limit0[7:0];
    } ISP_DEMOSAIC_BLEND_DIF_LIMIT @ 0x3407C;

    reg {
        name = "HF filtering threshold configuration P_TH register";
        desc = "ISP_DEMOSAIC_HF_INTP_TH is an HF filtering threshold configuration register. Hi3516C V300/Hi3516E V100 Professional HD IP Camera SoC

Data sheet 10.6 ISP_DEMOSAIC_HF_INTP_TH (offset 0x44110, printed page 10-335, `hi3516cv300--Hi3516CV300-Hi3516EV100-Datasheet.txt` line 59728).";

        field {
            name = "hf_intp_th_high";
            desc = "High threshold of high-frequency interpolation judgment";
            sw = rw;
            hw = r;
            reset = 0x10;
        } hf_intp_th_high[25:16];

        field {
            name = "hf_intp_th_low";
            desc = "Low threshold of high-frequency interpolation judgment";
            sw = rw;
            hw = r;
            reset = 0x30;
        } hf_intp_th_low[9:0];
    } ISP_DEMOSAIC_HF_INTP_TH @ 0x34110;

    reg {
        name = "HF filtering threshold configuration P_BLD register";
        desc = "ISP_DEMOSAIC_HF_INTP_BLD is an HF filtering threshold configuration register.

Data sheet 10.6 ISP_DEMOSAIC_HF_INTP_BLD (offset 0x44114, printed page 10-335, `hi3516cv300--Hi3516CV300-Hi3516EV100-Datasheet.txt` line 59750).";

        field {
            name = "hf_intp_bld_high";
            desc = "Low threshold of the high-frequency interpolation ratio. The value range is [0, 256].";
            sw = rw;
            hw = r;
            reset = 0x0;
        } hf_intp_bld_high[24:16];

        field {
            name = "hf_intp_bld_low";
            desc = "High threshold of the high-frequency interpolation ratio. The value range is [0, 256].";
            sw = rw;
            hw = r;
            reset = 0x100;
        } hf_intp_bld_low[8:0];
    } ISP_DEMOSAIC_HF_INTP_BLD @ 0x34114;

    reg {
        name = "HF filtering threshold configuration P_TH1 register 1";
        desc = "ISP_DEMOSAIC_HF_INTP_TH1 is an HF filtering threshold configuration register 1. Hi3516C V300/Hi3516E V100 Professional HD IP Camera SoC

Data sheet 10.6 ISP_DEMOSAIC_HF_INTP_TH1 (offset 0x44118, printed page 10-336, `hi3516cv300--Hi3516CV300-Hi3516EV100-Datasheet.txt` line 59785).";

        field {
            name = "hf_intp_th_high1";
            desc = "Low threshold 1 of high-frequency interpolation judgment";
            sw = rw;
            hw = r;
            reset = 0x136;
        } hf_intp_th_high1[25:16];

        field {
            name = "hf_intp_th_low1";
            desc = "High threshold 1 of high-frequency interpolation judgment";
            sw = rw;
            hw = r;
            reset = 0x12C;
        } hf_intp_th_low1[9:0];
    } ISP_DEMOSAIC_HF_INTP_TH1 @ 0x34118;

    reg {
        name = "HF filtering ratio 1 register P_RATIO0";
        desc = "ISP_DEMOSAIC_HF_INTP_RATIO0 is an HF filtering ratio 1 register.

Data sheet 10.6 ISP_DEMOSAIC_HF_INTP_RATIO0 (offset 0x4411C, printed page 10-336, `hi3516cv300--Hi3516CV300-Hi3516EV100-Datasheet.txt` line 59807).";

        field {
            name = "interp_ratio";
            desc = "HF filtering ratio 1 (S9.8)";
            sw = rw;
            hw = r;
            reset = 0x10;
        } interp_ratio[16:0];
    } ISP_DEMOSAIC_HF_INTP_RATIO0 @ 0x3411C;

    reg {
        name = "HF filtering ratio 2 register P_RATIO1";
        desc = "ISP_DEMOSAIC_HF_INTP_RATIO1 is an HF filtering ratio 2 register.

Data sheet 10.6 ISP_DEMOSAIC_HF_INTP_RATIO1 (offset 0x44120, printed page 10-336, `hi3516cv300--Hi3516CV300-Hi3516EV100-Datasheet.txt` line 59827).";

        field {
            name = "interp_ratio";
            desc = "HF filtering ratio 2 (S9.8)";
            sw = rw;
            hw = r;
            reset = 0x0001FFF3;
        } interp_ratio[16:0];
    } ISP_DEMOSAIC_HF_INTP_RATIO1 @ 0x34120;

    reg {
        name = "ISP demosaic control F";
        desc = "[inferred] ISP demosaic control F. Not in the data sheet. Source: OpenIPC openhisilicon `kernel/isp/arch/hi3516cv300/firmware/vreg/arch/hi3516cv300/isp_reg_define.h` (GPL-3.0 repository, HiSilicon copyright, nManager-generated 2015-12-22 \"Define all registers/tables for Hi3519\"; local copy sources/openhisilicon), union `U_ISP_DEMOSAIC_CTRL_F`, struct offset 0x341E0 (GPL-3.0 repository; header offsets are ISP-core relative (data sheet offset - 0x20000), 632 of 775 data-sheet registers match it by name and offset (ISP_BLC_CFG is at 0x21100 in the data sheet and 0x1000+0x20000 in the header)). Reset value and access type unknown (modelled RW, no reset). Confidence: medium (vendor header for this chip family, not hardware verified).";

        field {
            name = "rggb_cfg";
            desc = "[inferred] Rggb configuration. (vendor header `isp_reg_define.h` field `rggb_cfg`; access and reset unknown, modelled RW)";
            sw = rw;
            hw = r;
        } rggb_cfg[1:0];
    } ISP_DEMOSAIC_CTRL_F @ 0x341E0;

    reg {
        name = "ISP demosaic control I";
        desc = "[inferred] ISP demosaic control I. Not in the data sheet. Source: OpenIPC openhisilicon `kernel/isp/arch/hi3516cv300/firmware/vreg/arch/hi3516cv300/isp_reg_define.h` (GPL-3.0 repository, HiSilicon copyright, nManager-generated 2015-12-22 \"Define all registers/tables for Hi3519\"; local copy sources/openhisilicon), union `U_ISP_DEMOSAIC_CTRL_I`, struct offset 0x341E4 (GPL-3.0 repository; header offsets are ISP-core relative (data sheet offset - 0x20000), 632 of 775 data-sheet registers match it by name and offset (ISP_BLC_CFG is at 0x21100 in the data sheet and 0x1000+0x20000 in the header)). Reset value and access type unknown (modelled RW, no reset). Confidence: medium (vendor header for this chip family, not hardware verified).";

        field {
            name = "update_mode";
            desc = "[inferred] Update mode. (vendor header `isp_reg_define.h` field `update_mode`; access and reset unknown, modelled RW)";
            sw = rw;
            hw = r;
        } update_mode[0:0];
    } ISP_DEMOSAIC_CTRL_I @ 0x341E4;

    reg {
        name = "ISP demosaic TIMING";
        desc = "[inferred] ISP demosaic TIMING. Not in the data sheet. Source: OpenIPC openhisilicon `kernel/isp/arch/hi3516cv300/firmware/vreg/arch/hi3516cv300/isp_reg_define.h` (GPL-3.0 repository, HiSilicon copyright, nManager-generated 2015-12-22 \"Define all registers/tables for Hi3519\"; local copy sources/openhisilicon), union `U_ISP_DEMOSAIC_TIMING`, struct offset 0x341E8 (GPL-3.0 repository; header offsets are ISP-core relative (data sheet offset - 0x20000), 632 of 775 data-sheet registers match it by name and offset (ISP_BLC_CFG is at 0x21100 in the data sheet and 0x1000+0x20000 in the header)). Reset value and access type unknown (modelled RW, no reset). Confidence: medium (vendor header for this chip family, not hardware verified).";

        field {
            name = "cpi_fix_timing_stat";
            desc = "[inferred] Cpi fix timing status. (vendor header `isp_reg_define.h` field `cpi_fix_timing_stat`; access and reset unknown, modelled RW)";
            sw = rw;
            hw = r;
        } cpi_fix_timing_stat[13:1];
    } ISP_DEMOSAIC_TIMING @ 0x341E8;

    reg {
        name = "ISP demosaic UPDATE";
        desc = "[inferred] ISP demosaic UPDATE. Not in the data sheet. Source: OpenIPC openhisilicon `kernel/isp/arch/hi3516cv300/firmware/vreg/arch/hi3516cv300/isp_reg_define.h` (GPL-3.0 repository, HiSilicon copyright, nManager-generated 2015-12-22 \"Define all registers/tables for Hi3519\"; local copy sources/openhisilicon), union `U_ISP_DEMOSAIC_UPDATE`, struct offset 0x341EC (GPL-3.0 repository; header offsets are ISP-core relative (data sheet offset - 0x20000), 632 of 775 data-sheet registers match it by name and offset (ISP_BLC_CFG is at 0x21100 in the data sheet and 0x1000+0x20000 in the header)). Reset value and access type unknown (modelled RW, no reset). Confidence: medium (vendor header for this chip family, not hardware verified).";

        field {
            name = "update";
            desc = "[inferred] Update. (vendor header `isp_reg_define.h` field `update`; access and reset unknown, modelled RW)";
            sw = rw;
            hw = r;
        } update[0:0];
    } ISP_DEMOSAIC_UPDATE @ 0x341EC;

    reg {
        name = "Demosaic picture size register";
        desc = "ISP_DEMOSAIC_SIZE is a demosaic picture size register.

Data sheet 10.6 ISP_DEMOSAIC_SIZE (offset 0x441F0, printed page 10-337, `hi3516cv300--Hi3516CV300-Hi3516EV100-Datasheet.txt` line 59856).";

        field {
            name = "height";
            desc = "Picture height The configured value is the actual value minus 1. For example, if the actual picture height is 1920, set this field to 1919.";
            sw = rw;
            hw = r;
            reset = 0x437;
        } height[28:16];

        field {
            name = "width";
            desc = "Picture width The configured value is the actual value minus 1. For example, if the actual picture width is 1080, set this field to 1079.";
            sw = rw;
            hw = r;
            reset = 0x77F;
        } width[12:0];
    } ISP_DEMOSAIC_SIZE @ 0x341F0;

    reg {
        name = "Sharpen control register";
        desc = "ISP_SHARPEN_CFG is a sharpen control register.

Data sheet 10.6 ISP_SHARPEN_CFG (offset 0x45200, printed page 10-337, `hi3516cv300--Hi3516CV300-Hi3516EV100-Datasheet.txt` line 59890).";

        enum ISP_SHARPEN_CFG_en_enum {
            DISABLED = 0 { name = "Disabled"; desc = "disabled"; };
            ENABLED = 1 { name = "Enabled"; desc = "enabled"; };
        };

        field {
            name = "en";
            desc = "Sharpen enable";
            sw = rw;
            hw = r;
            encode = ISP_SHARPEN_CFG_en_enum;
            reset = 0x0;
        } en[0:0];
    } ISP_SHARPEN_CFG @ 0x35200;

    reg {
        name = "ISP sharpen VERSION";
        desc = "[inferred] ISP sharpen VERSION. Not in the data sheet. Source: OpenIPC openhisilicon `kernel/isp/arch/hi3516cv300/firmware/vreg/arch/hi3516cv300/isp_reg_define.h` (GPL-3.0 repository, HiSilicon copyright, nManager-generated 2015-12-22 \"Define all registers/tables for Hi3519\"; local copy sources/openhisilicon), union `U_ISP_SHARPEN_VERSION`, struct offset 0x3520C (GPL-3.0 repository; header offsets are ISP-core relative (data sheet offset - 0x20000), 632 of 775 data-sheet registers match it by name and offset (ISP_BLC_CFG is at 0x21100 in the data sheet and 0x1000+0x20000 in the header)). Reset value and access type unknown (modelled RW, no reset). Confidence: medium (vendor header for this chip family, not hardware verified).";

        field {
            name = "version";
            desc = "[inferred] Version. (vendor header `isp_reg_define.h` field `version`; access and reset unknown, modelled RW)";
            sw = rw;
            hw = r;
        } version[31:0];
    } ISP_SHARPEN_VERSION @ 0x3520C;

    reg {
        name = "Sharpen strength register";
        desc = "ISP_SHARPEN_AMT is a sharpen strength register.

Data sheet 10.6 ISP_SHARPEN_AMT (offset 0x45210, printed page 10-338, `hi3516cv300--Hi3516CV300-Hi3516EV100-Datasheet.txt` line 59921).";

        field {
            name = "edge_amt";
            desc = "Edge enhancement strength (U12.0)";
            sw = rw;
            hw = r;
            reset = 0x1CC;
        } edge_amt[27:16];

        field {
            name = "sharp_amt";
            desc = "Detail enhancement strength (U12.0)";
            sw = rw;
            hw = r;
            reset = 0x12D;
        } sharp_amt[11:0];
    } ISP_SHARPEN_AMT @ 0x35210;

    reg {
        name = "Sharpen threshold register 1";
        desc = "ISP_SHARPEN_THD1 is sharpen threshold register 1.

Data sheet 10.6 ISP_SHARPEN_THD1 (offset 0x45214, printed page 10-338, `hi3516cv300--Hi3516CV300-Hi3516EV100-Datasheet.txt` line 59943).";

        field {
            name = "edge_thd1";
            desc = "Edge enhancement threshold (U10.0)";
            sw = rw;
            hw = r;
            reset = 0x14;
        } edge_thd1[25:16];

        field {
            name = "sharp_thd1";
            desc = "Detail enhancement threshold (U10.0)";
            sw = rw;
            hw = r;
            reset = 0x96;
        } sharp_thd1[9:0];
    } ISP_SHARPEN_THD1 @ 0x35214;

    reg {
        name = "Sharpen threshold register 2";
        desc = "ISP_SHARPEN_THD2 is a sharpen threshold 2 register.

Data sheet 10.6 ISP_SHARPEN_THD2 (offset 0x45218, printed page 10-339, `hi3516cv300--Hi3516CV300-Hi3516EV100-Datasheet.txt` line 59971).";

        field {
            name = "edge_thd2";
            desc = "Edge enhancement threshold (U10.0)";
            sw = rw;
            hw = r;
            reset = 0x0;
        } edge_thd2[25:16];

        field {
            name = "sharp_thd2";
            desc = "Detail enhancement threshold (U10.0)";
            sw = rw;
            hw = r;
            reset = 0x64;
        } sharp_thd2[9:0];
    } ISP_SHARPEN_THD2 @ 0x35218;

    reg {
        name = "ISP sharpen coefficient";
        desc = "[inferred] ISP sharpen coefficient. Not in the data sheet. Source: OpenIPC openhisilicon `kernel/isp/arch/hi3516cv300/firmware/vreg/arch/hi3516cv300/isp_reg_define.h` (GPL-3.0 repository, HiSilicon copyright, nManager-generated 2015-12-22 \"Define all registers/tables for Hi3519\"; local copy sources/openhisilicon), union `U_ISP_SHARPEN_COEF`, struct offset 0x3521C (GPL-3.0 repository; header offsets are ISP-core relative (data sheet offset - 0x20000), 632 of 775 data-sheet registers match it by name and offset (ISP_BLC_CFG is at 0x21100 in the data sheet and 0x1000+0x20000 in the header)). Reset value and access type unknown (modelled RW, no reset). Confidence: medium (vendor header for this chip family, not hardware verified).";

        field {
            name = "edge_coef";
            desc = "[inferred] Edge coefficient. (vendor header `isp_reg_define.h` field `edge_coef`; access and reset unknown, modelled RW)";
            sw = rw;
            hw = r;
        } edge_coef[27:16];

        field {
            name = "sharp_coef";
            desc = "[inferred] Sharp coefficient. (vendor header `isp_reg_define.h` field `sharp_coef`; access and reset unknown, modelled RW)";
            sw = rw;
            hw = r;
        } sharp_coef[11:0];
    } ISP_SHARPEN_COEF @ 0x3521C;

    reg {
        name = "Sharpen shoot AMT control register MT";
        desc = "ISP_SHARPEN_SHOOTAMT is a sharpen shoot AMT control register.

Data sheet 10.6 ISP_SHARPEN_SHOOTAMT (offset 0x45220, printed page 10-339, `hi3516cv300--Hi3516CV300-Hi3516EV100-Datasheet.txt` line 59993).";

        field {
            name = "over_amt";
            desc = "Overshoot control coefficient (U8.0)";
            sw = rw;
            hw = r;
            reset = 0xB4;
        } over_amt[23:16];

        field {
            name = "under_amt";
            desc = "Undershoot control coefficient (U8.0)";
            sw = rw;
            hw = r;
            reset = 0xF5;
        } under_amt[7:0];
    } ISP_SHARPEN_SHOOTAMT @ 0x35220;

    reg {
        name = "Aliasing control threshold parameter register";
        desc = "ISP_SHARPEN_JAGTHD is an aliasing control threshold parameter register. Hi3516C V300/Hi3516E V100 Professional HD IP Camera SoC

Data sheet 10.6 ISP_SHARPEN_JAGTHD (offset 0x45224, printed page 10-340, `hi3516cv300--Hi3516CV300-Hi3516EV100-Datasheet.txt` line 60023).";

        field {
            name = "varjagthd2";
            desc = "Aliasing control threshold 2 (U10.0)";
            sw = rw;
            hw = r;
            reset = 0x1C2;
        } varjagthd2[25:16];

        field {
            name = "varjagthd1";
            desc = "Aliasing control threshold 1 (U10.0)";
            sw = rw;
            hw = r;
            reset = 0x190;
        } varjagthd1[9:0];
    } ISP_SHARPEN_JAGTHD @ 0x35224;

    reg {
        name = "Aliasing high-frequency parameter G register";
        desc = "ISP_SHARPEN_EDGEJAG is an aliasing high-frequency parameter register.

Data sheet 10.6 ISP_SHARPEN_EDGEJAG (offset 0x45228, printed page 10-340, `hi3516cv300--Hi3516CV300-Hi3516EV100-Datasheet.txt` line 60045).";

        field {
            name = "edgejagmulcoef";
            desc = "[inferred] Edgejagmulcoef. (bits reserved in the data sheet; vendor header `isp_reg_define.h` field `edgejagmulcoef`; access and reset unknown, modelled RW)";
            sw = rw;
            hw = r;
        } edgejagmulcoef[28:16];

        field {
            name = "edgejagamt";
            desc = "Aliasing high-frequency gain (U12.0)";
            sw = rw;
            hw = r;
            reset = 0x32;
        } edgejagamt[11:0];
    } ISP_SHARPEN_EDGEJAG @ 0x35228;

    reg {
        name = "Aliasing overshoot register G";
        desc = "ISP_SHARPEN_OSHTJAG is an aliasing overshoot parameter register. Hi3516C V300/Hi3516E V100 Professional HD IP Camera SoC

Data sheet 10.6 ISP_SHARPEN_OSHTJAG (offset 0x4522C, printed page 10-341, `hi3516cv300--Hi3516CV300-Hi3516EV100-Datasheet.txt` line 60074).";

        field {
            name = "oshtjagmulcoef";
            desc = "[inferred] Oshtjagmulcoef. (bits reserved in the data sheet; vendor header `isp_reg_define.h` field `oshtjagmulcoef`; access and reset unknown, modelled RW)";
            sw = rw;
            hw = r;
        } oshtjagmulcoef[28:16];

        field {
            name = "oshtjagamt";
            desc = "Aliasing overshoot gain (U8.8)";
            sw = rw;
            hw = r;
            reset = 0xB4;
        } oshtjagamt[7:0];
    } ISP_SHARPEN_OSHTJAG @ 0x3522C;

    reg {
        name = "Aliasing undershoot register G";
        desc = "ISP_SHARPEN_USHTJAG is an aliasing undershoot parameter register.

Data sheet 10.6 ISP_SHARPEN_USHTJAG (offset 0x45230, printed page 10-341, `hi3516cv300--Hi3516CV300-Hi3516EV100-Datasheet.txt` line 60095).";

        field {
            name = "ushtjagmulcoef";
            desc = "[inferred] Ushtjagmulcoef. (bits reserved in the data sheet; vendor header `isp_reg_define.h` field `ushtjagmulcoef`; access and reset unknown, modelled RW)";
            sw = rw;
            hw = r;
        } ushtjagmulcoef[28:16];

        field {
            name = "ushtjagamt";
            desc = "Aliasing undershoot gain (U8.8)";
            sw = rw;
            hw = r;
            reset = 0xF5;
        } ushtjagamt[7:0];
    } ISP_SHARPEN_USHTJAG @ 0x35230;

    reg {
        name = "Sharpen intermediate-frequency (IF) filtering coefficient register";
        desc = "ISP_SHARPEN_MID0 is a sharpen IF filtering coefficient register.

Data sheet 10.6 ISP_SHARPEN_MID0 (offset 0x45234, printed page 10-341, `hi3516cv300--Hi3516CV300-Hi3516EV100-Datasheet.txt` line 60115).";

        field {
            name = "mid_tmp02";
            desc = "IF filtering coefficient 02 (S8.0)";
            sw = rw;
            hw = r;
            reset = 0xF0;
        } mid_tmp02[23:16];

        field {
            name = "mid_tmp01";
            desc = "IF filtering coefficient 01 (S8.0)";
            sw = rw;
            hw = r;
            reset = 0xF0;
        } mid_tmp01[15:8];

        field {
            name = "mid_tmp00";
            desc = "IF filtering coefficient 00 (S8.0)";
            sw = rw;
            hw = r;
            reset = 0xF0;
        } mid_tmp00[7:0];
    } ISP_SHARPEN_MID0 @ 0x35234;

    reg {
        name = "Sharpen IF filtering coefficient register";
        desc = "ISP_SHARPEN_MID1 is a sharpen IF filtering coefficient register.

Data sheet 10.6 ISP_SHARPEN_MID1 (offset 0x45238, printed page 10-342, `hi3516cv300--Hi3516CV300-Hi3516EV100-Datasheet.txt` line 60144).";

        field {
            name = "mid_tmp12";
            desc = "IF filtering coefficient 12 (S8.0)";
            sw = rw;
            hw = r;
            reset = 0x1C;
        } mid_tmp12[23:16];

        field {
            name = "mid_tmp11";
            desc = "IF filtering coefficient 11 (S8.0)";
            sw = rw;
            hw = r;
            reset = 0x1C;
        } mid_tmp11[15:8];

        field {
            name = "mid_tmp10";
            desc = "IF filtering coefficient 10 (S8.0)";
            sw = rw;
            hw = r;
            reset = 0xF0;
        } mid_tmp10[7:0];
    } ISP_SHARPEN_MID1 @ 0x35238;

    reg {
        name = "Sharpen IF filtering coefficient register";
        desc = "ISP_SHARPEN_MID2 is a sharpen IF filtering coefficient register.

Data sheet 10.6 ISP_SHARPEN_MID2 (offset 0x4523C, printed page 10-342, `hi3516cv300--Hi3516CV300-Hi3516EV100-Datasheet.txt` line 60166).";

        field {
            name = "mid_tmp22";
            desc = "IF filtering coefficient 22 (S8.0)";
            sw = rw;
            hw = r;
            reset = 0x20;
        } mid_tmp22[23:16];

        field {
            name = "mid_tmp21";
            desc = "IF filtering coefficient 21 (S8.0)";
            sw = rw;
            hw = r;
            reset = 0x1C;
        } mid_tmp21[15:8];

        field {
            name = "mid_tmp20";
            desc = "IF filtering coefficient 20 (S8.0)";
            sw = rw;
            hw = r;
            reset = 0xF0;
        } mid_tmp20[7:0];
    } ISP_SHARPEN_MID2 @ 0x3523C;

    reg {
        name = "SHARPEN control register";
        desc = "ISP_SHARPEN_CTRL is a sharpen control register.

Data sheet 10.6 ISP_SHARPEN_CTRL (offset 0x45244, printed page 10-343, `hi3516cv300--Hi3516CV300-Hi3516EV100-Datasheet.txt` line 60194).";

        field {
            name = "pixsel";
            desc = "Overshoot reference value. The value range is [0, 31].";
            sw = rw;
            hw = r;
            reset = 0x0;
        } pixsel[12:8];

        enum ISP_SHARPEN_CTRL_lowbandesm_en_enum {
            DISABLED = 0 { name = "Disabled"; desc = "disabled"; };
            ENABLED = 1 { name = "Enabled"; desc = "enabled"; };
        };

        field {
            name = "lowbandesm_en";
            desc = "Low-pass filter select enable";
            sw = rw;
            hw = r;
            encode = ISP_SHARPEN_CTRL_lowbandesm_en_enum;
            reset = 0x0;
        } lowbandesm_en[7:7];

        enum ISP_SHARPEN_CTRL_rgbshp_en_enum {
            DISABLED = 0 { name = "Disabled"; desc = "disabled"; };
            ENABLED = 1 { name = "Enabled"; desc = "enabled"; };
        };

        field {
            name = "rgbshp_en";
            desc = "RGB sharpening enable";
            sw = rw;
            hw = r;
            encode = ISP_SHARPEN_CTRL_rgbshp_en_enum;
            reset = 0x0;
        } rgbshp_en[6:6];

        enum ISP_SHARPEN_CTRL_shadsup_en_enum {
            DISABLED = 0 { name = "Disabled"; desc = "disabled"; };
            ENABLED = 1 { name = "Enabled"; desc = "enabled"; };
        };

        field {
            name = "shadsup_en";
            desc = "Shadow region noise suppression enable";
            sw = rw;
            hw = r;
            encode = ISP_SHARPEN_CTRL_shadsup_en_enum;
            reset = 0x0;
        } shadsup_en[5:5];

        enum ISP_SHARPEN_CTRL_jagctrl_enum {
            DISABLED = 0 { name = "Disabled"; desc = "disabled"; };
            ENABLED = 1 { name = "Enabled"; desc = "enabled"; };
        };

        field {
            name = "jagctrl";
            desc = "Aliasing control enable";
            sw = rw;
            hw = r;
            encode = ISP_SHARPEN_CTRL_jagctrl_enum;
            reset = 0x0;
        } jagctrl[4:4];

        enum ISP_SHARPEN_CTRL_lumactrlnoise_enum {
            DISABLED = 0 { name = "Disabled"; desc = "disabled"; };
            ENABLED = 1 { name = "Enabled"; desc = "enabled"; };
        };

        field {
            name = "lumactrlnoise";
            desc = "Noise threshold control based on the luminance";
            sw = rw;
            hw = r;
            encode = ISP_SHARPEN_CTRL_lumactrlnoise_enum;
            reset = 0x0;
        } lumactrlnoise[3:3];

        enum ISP_SHARPEN_CTRL_shtvarctrl_enum {
            DISABLED = 0 { name = "Disabled"; desc = "disabled"; };
            ENABLED = 1 { name = "Enabled"; desc = "enabled"; };
        };

        field {
            name = "shtvarctrl";
            desc = "Variance control";
            sw = rw;
            hw = r;
            encode = ISP_SHARPEN_CTRL_shtvarctrl_enum;
            reset = 0x0;
        } shtvarctrl[2:2];

        enum ISP_SHARPEN_CTRL_lumactrl_enum {
            DISABLED = 0 { name = "Disabled"; desc = "disabled"; };
            ENABLED = 1 { name = "Enabled"; desc = "enabled"; };
        };

        field {
            name = "lumactrl";
            desc = "Sharpening strength control based on the luminance";
            sw = rw;
            hw = r;
            encode = ISP_SHARPEN_CTRL_lumactrl_enum;
            reset = 0x0;
        } lumactrl[1:1];

        enum ISP_SHARPEN_CTRL_skinctrl_enum {
            DISABLED = 0 { name = "Disabled"; desc = "disabled"; };
            ENABLED = 1 { name = "Enabled"; desc = "enabled"; };
        };

        field {
            name = "skinctrl";
            desc = "Complexion detection and complexion sharpening decreasing enable";
            sw = rw;
            hw = r;
            encode = ISP_SHARPEN_CTRL_skinctrl_enum;
            reset = 0x0;
        } skinctrl[0:0];
    } ISP_SHARPEN_CTRL @ 0x35244;

    reg {
        name = "Shift register";
        desc = "ISP_SHARPEN_SHIFT is a shift parameter register.

Data sheet 10.6 ISP_SHARPEN_SHIFT (offset 0x45248, printed page 10-344, `hi3516cv300--Hi3516CV300-Hi3516EV100-Datasheet.txt` line 60257).";

        field {
            name = "maxshift";
            desc = "Maximum offset (S8.0). The value range is [-128, 127].";
            sw = rw;
            hw = r;
            reset = 0x0;
        } maxshift[15:8];

        field {
            name = "minshift";
            desc = "Minimum offset (S8.0). The value range is [-128, 127].";
            sw = rw;
            hw = r;
            reset = 0x0;
        } minshift[7:0];
    } ISP_SHARPEN_SHIFT @ 0x35248;

    reg {
        name = "Sharpen strength control register";
        desc = "ISP_SHARPEN_ST is a sharpen strength control parameter register.

Data sheet 10.6 ISP_SHARPEN_ST (offset 0x4524C, printed page 10-344, `hi3516cv300--Hi3516CV300-Hi3516EV100-Datasheet.txt` line 60278).";

        field {
            name = "dirrlyshft";
            desc = "[inferred] Dirrlyshft. (bits reserved in the data sheet; vendor header `isp_reg_define.h` field `dirrlyshft`; access and reset unknown, modelled RW)";
            sw = rw;
            hw = r;
        } dirrlyshft[18:16];

        field {
            name = "luma_nost";
            desc = "Noise threshold strength control based on the luminance";
            sw = rw;
            hw = r;
            reset = 0x0;
        } luma_nost[10:8];

        field {
            name = "luma_limit";
            desc = "IF noise coring strength control based on the luminance";
            sw = rw;
            hw = r;
            reset = 0x0;
        } luma_limit[4:0];
    } ISP_SHARPEN_ST @ 0x3524C;

    reg {
        name = "Variance threshold parameter 0 RTH register";
        desc = "ISP_SHARPEN_OSHTVARTH is a variance threshold parameter 0 register.

Data sheet 10.6 ISP_SHARPEN_OSHTVARTH (offset 0x45250, printed page 10-345, `hi3516cv300--Hi3516CV300-Hi3516EV100-Datasheet.txt` line 60314).";

        field {
            name = "overvarth1";
            desc = "Overshoot variance threshold 1";
            sw = rw;
            hw = r;
            reset = 0x12C;
        } overvarth1[25:16];

        field {
            name = "overvarth0";
            desc = "Overshoot variance threshold 0";
            sw = rw;
            hw = r;
            reset = 0x7D;
        } overvarth0[9:0];
    } ISP_SHARPEN_OSHTVARTH @ 0x35250;

    reg {
        name = "Overshoot variance parameter 0 R register";
        desc = "ISP_SHARPEN_OSHTVAR is an overshoot variance parameter 0 register.

Data sheet 10.6 ISP_SHARPEN_OSHTVAR (offset 0x45254, printed page 10-345, `hi3516cv300--Hi3516CV300-Hi3516EV100-Datasheet.txt` line 60335).";

        field {
            name = "overvarmul";
            desc = "[inferred] Overvarmul. (bits reserved in the data sheet; vendor header `isp_reg_define.h` field `overvarmul`; access and reset unknown, modelled RW)";
            sw = rw;
            hw = r;
        } overvarmul[28:16];

        field {
            name = "overvaramt";
            desc = "Overshoot variance gain";
            sw = rw;
            hw = r;
            reset = 0xFF;
        } overvaramt[7:0];
    } ISP_SHARPEN_OSHTVAR @ 0x35254;

    reg {
        name = "Variance threshold parameter 1 RTH register";
        desc = "ISP_SHARPEN_USHTVARTH is a variance threshold parameter 1 register. Hi3516C V300/Hi3516E V100 Professional HD IP Camera SoC

Data sheet 10.6 ISP_SHARPEN_USHTVARTH (offset 0x45258, printed page 10-346, `hi3516cv300--Hi3516CV300-Hi3516EV100-Datasheet.txt` line 60368).";

        field {
            name = "undervarth1";
            desc = "Undershoot variance threshold 1";
            sw = rw;
            hw = r;
            reset = 0x12C;
        } undervarth1[25:16];

        field {
            name = "undervarth0";
            desc = "Undershoot variance threshold 0";
            sw = rw;
            hw = r;
            reset = 0x7D;
        } undervarth0[9:0];
    } ISP_SHARPEN_USHTVARTH @ 0x35258;

    reg {
        name = "Overshoot variance parameter 1 R register";
        desc = "ISP_SHARPEN_USHTVAR is an undershoot variance parameter 1 register.

Data sheet 10.6 ISP_SHARPEN_USHTVAR (offset 0x4525C, printed page 10-346, `hi3516cv300--Hi3516CV300-Hi3516EV100-Datasheet.txt` line 60390).";

        field {
            name = "undervarmul";
            desc = "[inferred] Undervarmul. (bits reserved in the data sheet; vendor header `isp_reg_define.h` field `undervarmul`; access and reset unknown, modelled RW)";
            sw = rw;
            hw = r;
        } undervarmul[28:16];

        field {
            name = "undervaramt";
            desc = "Undershoot variance gain";
            sw = rw;
            hw = r;
            reset = 0xFF;
        } undervaramt[7:0];
    } ISP_SHARPEN_USHTVAR @ 0x3525C;

    reg {
        name = "Luminance weight parameter 0 GT0 register";
        desc = "ISP_SHARPEN_LUMAWGT0 is a luminance weight parameter 0 register. Hi3516C V300/Hi3516E V100 Professional HD IP Camera SoC

Data sheet 10.6 ISP_SHARPEN_LUMAWGT0 (offset 0x45260, printed page 10-347, `hi3516cv300--Hi3516CV300-Hi3516EV100-Datasheet.txt` line 60424).";

        field {
            name = "lumawgt3";
            desc = "Luminance weight 3";
            sw = rw;
            hw = r;
            reset = 0xFF;
        } lumawgt3[31:24];

        field {
            name = "lumawgt2";
            desc = "Luminance weight 2";
            sw = rw;
            hw = r;
            reset = 0xFF;
        } lumawgt2[23:16];

        field {
            name = "lumawgt1";
            desc = "Luminance weight 1";
            sw = rw;
            hw = r;
            reset = 0xFF;
        } lumawgt1[15:8];

        field {
            name = "lumawgt0";
            desc = "Luminance weight 0";
            sw = rw;
            hw = r;
            reset = 0xFF;
        } lumawgt0[7:0];
    } ISP_SHARPEN_LUMAWGT0 @ 0x35260;

    reg {
        name = "Luminance weight parameter 1 GT1 register";
        desc = "ISP_SHARPEN_LUMAWGT1 is a luminance weight parameter 1 register.

Data sheet 10.6 ISP_SHARPEN_LUMAWGT1 (offset 0x45264, printed page 10-347, `hi3516cv300--Hi3516CV300-Hi3516EV100-Datasheet.txt` line 60446).";

        field {
            name = "lumawgt7";
            desc = "Luminance weight 7";
            sw = rw;
            hw = r;
            reset = 0xFF;
        } lumawgt7[31:24];

        field {
            name = "lumawgt6";
            desc = "Luminance weight 6";
            sw = rw;
            hw = r;
            reset = 0xFF;
        } lumawgt6[23:16];

        field {
            name = "lumawgt5";
            desc = "Luminance weight 5";
            sw = rw;
            hw = r;
            reset = 0xFF;
        } lumawgt5[15:8];

        field {
            name = "lumawgt4";
            desc = "Luminance weight 4";
            sw = rw;
            hw = r;
            reset = 0xFF;
        } lumawgt4[7:0];
    } ISP_SHARPEN_LUMAWGT1 @ 0x35264;

    reg {
        name = "Luminance weight parameter 2 GT2 register";
        desc = "ISP_SHARPEN_LUMAWGT2 is a luminance weight parameter 2 register. Hi3516C V300/Hi3516E V100 Professional HD IP Camera SoC

Data sheet 10.6 ISP_SHARPEN_LUMAWGT2 (offset 0x45268, printed page 10-348, `hi3516cv300--Hi3516CV300-Hi3516EV100-Datasheet.txt` line 60477).";

        field {
            name = "lumawgt11";
            desc = "Luminance weight 11";
            sw = rw;
            hw = r;
            reset = 0xFF;
        } lumawgt11[31:24];

        field {
            name = "lumawgt10";
            desc = "Luminance weight 10";
            sw = rw;
            hw = r;
            reset = 0xFF;
        } lumawgt10[23:16];

        field {
            name = "lumawgt9";
            desc = "Luminance weight 9";
            sw = rw;
            hw = r;
            reset = 0xFF;
        } lumawgt9[15:8];

        field {
            name = "lumawgt8";
            desc = "Luminance weight 8";
            sw = rw;
            hw = r;
            reset = 0xFF;
        } lumawgt8[7:0];
    } ISP_SHARPEN_LUMAWGT2 @ 0x35268;

    reg {
        name = "Luminance weight parameter 3 GT3 register";
        desc = "ISP_SHARPEN_LUMAWGT3 is a luminance weight parameter 3 register.

Data sheet 10.6 ISP_SHARPEN_LUMAWGT3 (offset 0x4526C, printed page 10-348, `hi3516cv300--Hi3516CV300-Hi3516EV100-Datasheet.txt` line 60499).";

        field {
            name = "lumawgt15";
            desc = "Luminance weight 15";
            sw = rw;
            hw = r;
            reset = 0xFF;
        } lumawgt15[31:24];

        field {
            name = "lumawgt14";
            desc = "Luminance weight 14";
            sw = rw;
            hw = r;
            reset = 0xFF;
        } lumawgt14[23:16];

        field {
            name = "lumawgt13";
            desc = "Luminance weight 13";
            sw = rw;
            hw = r;
            reset = 0xFF;
        } lumawgt13[15:8];

        field {
            name = "lumawgt12";
            desc = "Luminance weight 12";
            sw = rw;
            hw = r;
            reset = 0xFF;
        } lumawgt12[7:0];
    } ISP_SHARPEN_LUMAWGT3 @ 0x3526C;

    reg {
        name = "Luminance weight parameter 4 GT4 register";
        desc = "ISP_SHARPEN_LUMAWGT4 is a luminance weight parameter 4 register. Hi3516C V300/Hi3516E V100 Professional HD IP Camera SoC

Data sheet 10.6 ISP_SHARPEN_LUMAWGT4 (offset 0x45270, printed page 10-349, `hi3516cv300--Hi3516CV300-Hi3516EV100-Datasheet.txt` line 60530).";

        field {
            name = "lumawgt19";
            desc = "Luminance weight 19";
            sw = rw;
            hw = r;
            reset = 0xFF;
        } lumawgt19[31:24];

        field {
            name = "lumawgt18";
            desc = "Luminance weight 18";
            sw = rw;
            hw = r;
            reset = 0xFF;
        } lumawgt18[23:16];

        field {
            name = "lumawgt17";
            desc = "Luminance weight 17";
            sw = rw;
            hw = r;
            reset = 0xFF;
        } lumawgt17[15:8];

        field {
            name = "lumawgt16";
            desc = "Luminance weight 16";
            sw = rw;
            hw = r;
            reset = 0xFF;
        } lumawgt16[7:0];
    } ISP_SHARPEN_LUMAWGT4 @ 0x35270;

    reg {
        name = "Luminance weight parameter 5 GT5 register";
        desc = "ISP_SHARPEN_LUMAWGT5 is a luminance weight parameter 5 register.

Data sheet 10.6 ISP_SHARPEN_LUMAWGT5 (offset 0x45274, printed page 10-349, `hi3516cv300--Hi3516CV300-Hi3516EV100-Datasheet.txt` line 60552).";

        field {
            name = "lumawgt23";
            desc = "Luminance weight 23";
            sw = rw;
            hw = r;
            reset = 0xFF;
        } lumawgt23[31:24];

        field {
            name = "lumawgt22";
            desc = "Luminance weight 22";
            sw = rw;
            hw = r;
            reset = 0xFF;
        } lumawgt22[23:16];

        field {
            name = "lumawgt21";
            desc = "Luminance weight 21";
            sw = rw;
            hw = r;
            reset = 0xFF;
        } lumawgt21[15:8];

        field {
            name = "lumawgt20";
            desc = "Luminance weight 20";
            sw = rw;
            hw = r;
            reset = 0xFF;
        } lumawgt20[7:0];
    } ISP_SHARPEN_LUMAWGT5 @ 0x35274;

    reg {
        name = "Luminance weight parameter 6 GT6 register";
        desc = "ISP_SHARPEN_LUMAWGT6 is a luminance weight parameter 6 register. Hi3516C V300/Hi3516E V100 Professional HD IP Camera SoC

Data sheet 10.6 ISP_SHARPEN_LUMAWGT6 (offset 0x45278, printed page 10-350, `hi3516cv300--Hi3516CV300-Hi3516EV100-Datasheet.txt` line 60583).";

        field {
            name = "lumawgt27";
            desc = "Luminance weight 27";
            sw = rw;
            hw = r;
            reset = 0xFF;
        } lumawgt27[31:24];

        field {
            name = "lumawgt26";
            desc = "Luminance weight 26";
            sw = rw;
            hw = r;
            reset = 0xFF;
        } lumawgt26[23:16];

        field {
            name = "lumawgt25";
            desc = "Luminance weight 25";
            sw = rw;
            hw = r;
            reset = 0xFF;
        } lumawgt25[15:8];

        field {
            name = "lumawgt24";
            desc = "Luminance weight 24";
            sw = rw;
            hw = r;
            reset = 0xFF;
        } lumawgt24[7:0];
    } ISP_SHARPEN_LUMAWGT6 @ 0x35278;

    reg {
        name = "Luminance weight parameter 7 GT7 register";
        desc = "ISP_SHARPEN_LUMAWGT7 is a luminance weight parameter 7 register.

Data sheet 10.6 ISP_SHARPEN_LUMAWGT7 (offset 0x4527C, printed page 10-350, `hi3516cv300--Hi3516CV300-Hi3516EV100-Datasheet.txt` line 60605).";

        field {
            name = "lumawgt31";
            desc = "Luminance weight 31";
            sw = rw;
            hw = r;
            reset = 0xFF;
        } lumawgt31[31:24];

        field {
            name = "lumawgt30";
            desc = "Luminance weight 30";
            sw = rw;
            hw = r;
            reset = 0xFF;
        } lumawgt30[23:16];

        field {
            name = "lumawgt29";
            desc = "Luminance weight 29";
            sw = rw;
            hw = r;
            reset = 0xFF;
        } lumawgt29[15:8];

        field {
            name = "lumawgt28";
            desc = "Luminance weight 28";
            sw = rw;
            hw = r;
            reset = 0xFF;
        } lumawgt28[7:0];
    } ISP_SHARPEN_LUMAWGT7 @ 0x3527C;

    reg {
        name = "ISP sharpen control I";
        desc = "[inferred] ISP sharpen control I. Not in the data sheet. Source: OpenIPC openhisilicon `kernel/isp/arch/hi3516cv300/firmware/vreg/arch/hi3516cv300/isp_reg_define.h` (GPL-3.0 repository, HiSilicon copyright, nManager-generated 2015-12-22 \"Define all registers/tables for Hi3519\"; local copy sources/openhisilicon), union `U_ISP_SHARPEN_CTRL_I`, struct offset 0x352E4 (GPL-3.0 repository; header offsets are ISP-core relative (data sheet offset - 0x20000), 632 of 775 data-sheet registers match it by name and offset (ISP_BLC_CFG is at 0x21100 in the data sheet and 0x1000+0x20000 in the header)). Reset value and access type unknown (modelled RW, no reset). Confidence: medium (vendor header for this chip family, not hardware verified).";

        field {
            name = "update_mode";
            desc = "[inferred] Update mode. (vendor header `isp_reg_define.h` field `update_mode`; access and reset unknown, modelled RW)";
            sw = rw;
            hw = r;
        } update_mode[0:0];
    } ISP_SHARPEN_CTRL_I @ 0x352E4;

    reg {
        name = "ISP sharpen TIMING";
        desc = "[inferred] ISP sharpen TIMING. Not in the data sheet. Source: OpenIPC openhisilicon `kernel/isp/arch/hi3516cv300/firmware/vreg/arch/hi3516cv300/isp_reg_define.h` (GPL-3.0 repository, HiSilicon copyright, nManager-generated 2015-12-22 \"Define all registers/tables for Hi3519\"; local copy sources/openhisilicon), union `U_ISP_SHARPEN_TIMING`, struct offset 0x352E8 (GPL-3.0 repository; header offsets are ISP-core relative (data sheet offset - 0x20000), 632 of 775 data-sheet registers match it by name and offset (ISP_BLC_CFG is at 0x21100 in the data sheet and 0x1000+0x20000 in the header)). Reset value and access type unknown (modelled RW, no reset). Confidence: medium (vendor header for this chip family, not hardware verified).";

        field {
            name = "cpi_fix_timing_stat";
            desc = "[inferred] Cpi fix timing status. (vendor header `isp_reg_define.h` field `cpi_fix_timing_stat`; access and reset unknown, modelled RW)";
            sw = rw;
            hw = r;
        } cpi_fix_timing_stat[13:1];
    } ISP_SHARPEN_TIMING @ 0x352E8;

    reg {
        name = "ISP sharpen UPDATE";
        desc = "[inferred] ISP sharpen UPDATE. Not in the data sheet. Source: OpenIPC openhisilicon `kernel/isp/arch/hi3516cv300/firmware/vreg/arch/hi3516cv300/isp_reg_define.h` (GPL-3.0 repository, HiSilicon copyright, nManager-generated 2015-12-22 \"Define all registers/tables for Hi3519\"; local copy sources/openhisilicon), union `U_ISP_SHARPEN_UPDATE`, struct offset 0x352EC (GPL-3.0 repository; header offsets are ISP-core relative (data sheet offset - 0x20000), 632 of 775 data-sheet registers match it by name and offset (ISP_BLC_CFG is at 0x21100 in the data sheet and 0x1000+0x20000 in the header)). Reset value and access type unknown (modelled RW, no reset). Confidence: medium (vendor header for this chip family, not hardware verified).";

        field {
            name = "update";
            desc = "[inferred] Update. (vendor header `isp_reg_define.h` field `update`; access and reset unknown, modelled RW)";
            sw = rw;
            hw = r;
        } update[0:0];
    } ISP_SHARPEN_UPDATE @ 0x352EC;

    reg {
        name = "Sharpen picture size register";
        desc = "ISP_SHARPEN_SIZE is a sharpen picture size register. Hi3516C V300/Hi3516E V100 Professional HD IP Camera SoC

Data sheet 10.6 ISP_SHARPEN_SIZE (offset 0x452F0, printed page 10-351, `hi3516cv300--Hi3516CV300-Hi3516EV100-Datasheet.txt` line 60636).";

        field {
            name = "height";
            desc = "Picture height. The configured value is the actual value minus 1. For example, for the 1080P picture, set the height to 1079.";
            sw = rw;
            hw = r;
            reset = 0x437;
        } height[28:16];

        field {
            name = "width";
            desc = "Picture width. The configured value is the actual value minus 1. For example, for the 1080P picture, set the width to 1919.";
            sw = rw;
            hw = r;
            reset = 0x77F;
        } width[12:0];
    } ISP_SHARPEN_SIZE @ 0x352F0;

    reg {
        name = "ISP sharpen SKIN count";
        desc = "[inferred] ISP sharpen SKIN count. Not in the data sheet. Source: OpenIPC openhisilicon `kernel/isp/arch/hi3516cv300/firmware/vreg/arch/hi3516cv300/isp_reg_define.h` (GPL-3.0 repository, HiSilicon copyright, nManager-generated 2015-12-22 \"Define all registers/tables for Hi3519\"; local copy sources/openhisilicon), union `U_ISP_SHARPEN_SKIN_CNT`, struct offset 0x35310 (GPL-3.0 repository; header offsets are ISP-core relative (data sheet offset - 0x20000), 632 of 775 data-sheet registers match it by name and offset (ISP_BLC_CFG is at 0x21100 in the data sheet and 0x1000+0x20000 in the header)). Reset value and access type unknown (modelled RW, no reset). Confidence: medium (vendor header for this chip family, not hardware verified).";

        field {
            name = "skincntmulcoef";
            desc = "[inferred] Skincntmulcoef. (vendor header `isp_reg_define.h` field `skincntmulcoef`; access and reset unknown, modelled RW)";
            sw = rw;
            hw = r;
        } skincntmulcoef[12:8];

        field {
            name = "skin_cnt_th2";
            desc = "[inferred] Skin count th2. (vendor header `isp_reg_define.h` field `skin_cnt_th2`; access and reset unknown, modelled RW)";
            sw = rw;
            hw = r;
        } skin_cnt_th2[7:4];

        field {
            name = "skin_cnt_th1";
            desc = "[inferred] Skin count th1. (vendor header `isp_reg_define.h` field `skin_cnt_th1`; access and reset unknown, modelled RW)";
            sw = rw;
            hw = r;
        } skin_cnt_th1[3:0];
    } ISP_SHARPEN_SKIN_CNT @ 0x35310;

    reg {
        name = "Complexion variance threshold ARTH register";
        desc = "ISP_SHARPEN_SKIN_VARTH is a complexion variance threshold register.

Data sheet 10.6 ISP_SHARPEN_SKIN_VARTH (offset 0x45314, printed page 10-351, `hi3516cv300--Hi3516CV300-Hi3516EV100-Datasheet.txt` line 60665).";

        field {
            name = "skin_var_th2";
            desc = "Complexion variance threshold 2";
            sw = rw;
            hw = r;
            reset = 0x96;
        } skin_var_th2[25:16];

        field {
            name = "skin_var_th1";
            desc = "Complexion variance threshold 1";
            sw = rw;
            hw = r;
            reset = 0x0;
        } skin_var_th1[9:0];
    } ISP_SHARPEN_SKIN_VARTH @ 0x35314;

    reg {
        name = "Complexion weight register ARWGT";
        desc = "ISP_SHARPEN_SKIN_VARWGT is a complexion weight register. Hi3516C V300/Hi3516E V100 Professional HD IP Camera SoC

Data sheet 10.6 ISP_SHARPEN_SKIN_VARWGT (offset 0x45318, printed page 10-352, `hi3516cv300--Hi3516CV300-Hi3516EV100-Datasheet.txt` line 60696).";

        field {
            name = "skinvarwgtmulcoef";
            desc = "Complexion weight coefficient. The format is S13.0 and the value range is [-4096, 4095].";
            sw = rw;
            hw = r;
            reset = 0xFFB;
        } skinvarwgtmulcoef[28:16];

        field {
            name = "skin_var_wgt2";
            desc = "Complexion weight 2";
            sw = rw;
            hw = r;
            reset = 0x20;
        } skin_var_wgt2[15:8];

        field {
            name = "skin_var_wgt1";
            desc = "Complexion weight 1";
            sw = rw;
            hw = r;
            reset = 0x50;
        } skin_var_wgt1[7:0];
    } ISP_SHARPEN_SKIN_VARWGT @ 0x35318;

    reg {
        name = "Complexion U threshold register";
        desc = "ISP_SHARPEN_SKIN_U is a complexion U threshold register.

Data sheet 10.6 ISP_SHARPEN_SKIN_U (offset 0x4531C, printed page 10-352, `hi3516cv300--Hi3516CV300-Hi3516EV100-Datasheet.txt` line 60723).";

        field {
            name = "skin_u_max";
            desc = "Maximum threshold of complexion U";
            sw = rw;
            hw = r;
            reset = 0x7F;
        } skin_u_max[23:16];

        field {
            name = "skin_u_min";
            desc = "Minimum threshold of complexion U";
            sw = rw;
            hw = r;
            reset = 0x64;
        } skin_u_min[7:0];
    } ISP_SHARPEN_SKIN_U @ 0x3531C;

    reg {
        name = "Complexion V threshold register";
        desc = "ISP_SHARPEN_SKIN_V is a complexion V threshold register. Hi3516C V300/Hi3516E V100 Professional HD IP Camera SoC

Data sheet 10.6 ISP_SHARPEN_SKIN_V (offset 0x45320, printed page 10-353, `hi3516cv300--Hi3516CV300-Hi3516EV100-Datasheet.txt` line 60754).";

        field {
            name = "skin_v_max";
            desc = "Maximum threshold of complexion V";
            sw = rw;
            hw = r;
            reset = 0x96;
        } skin_v_max[23:16];

        field {
            name = "skin_v_min";
            desc = "Minimum threshold of complexion V";
            sw = rw;
            hw = r;
            reset = 0x87;
        } skin_v_min[7:0];
    } ISP_SHARPEN_SKIN_V @ 0x35320;

    reg {
        name = "ISP sharpen SKIN length";
        desc = "[inferred] ISP sharpen SKIN length. Not in the data sheet. Source: OpenIPC openhisilicon `kernel/isp/arch/hi3516cv300/firmware/vreg/arch/hi3516cv300/isp_reg_define.h` (GPL-3.0 repository, HiSilicon copyright, nManager-generated 2015-12-22 \"Define all registers/tables for Hi3519\"; local copy sources/openhisilicon), union `U_ISP_SHARPEN_SKIN_LEN`, struct offset 0x35324 (GPL-3.0 repository; header offsets are ISP-core relative (data sheet offset - 0x20000), 632 of 775 data-sheet registers match it by name and offset (ISP_BLC_CFG is at 0x21100 in the data sheet and 0x1000+0x20000 in the header)). Reset value and access type unknown (modelled RW, no reset). Confidence: medium (vendor header for this chip family, not hardware verified).";

        field {
            name = "skin_len";
            desc = "[inferred] Skin length. (vendor header `isp_reg_define.h` field `skin_len`; access and reset unknown, modelled RW)";
            sw = rw;
            hw = r;
        } skin_len[3:0];
    } ISP_SHARPEN_SKIN_LEN @ 0x35324;

    reg {
        name = "Edge filter parameter register";
        desc = "ISP_SHARPEN_EDGSM is an edge filter parameter register.

Data sheet 10.6 ISP_SHARPEN_EDGSM (offset 0x45328, printed page 10-353, `hi3516cv300--Hi3516CV300-Hi3516EV100-Datasheet.txt` line 60776).";

        enum ISP_SHARPEN_EDGSM_edgsm_en_enum {
            DISABLED = 0 { name = "Disabled"; desc = "disabled"; };
            ENABLED = 1 { name = "Enabled"; desc = "enabled"; };
        };

        field {
            name = "edgsm_en";
            desc = "Edge filtering enable";
            sw = rw;
            hw = r;
            encode = ISP_SHARPEN_EDGSM_edgsm_en_enum;
            reset = 0x0;
        } edgsm_en[24:24];

        field {
            name = "edgsm_str";
            desc = "Edge filtering strength";
            sw = rw;
            hw = r;
            reset = 0x1;
        } edgsm_str[16:12];

        field {
            name = "diff_thd";
            desc = "Edge noise threshold";
            sw = rw;
            hw = r;
            reset = 0x2;
        } diff_thd[11:4];

        field {
            name = "diff_mul";
            desc = "Edge strength multiple";
            sw = rw;
            hw = r;
            reset = 0x2;
        } diff_mul[3:0];
    } ISP_SHARPEN_EDGSM @ 0x35328;

    reg {
        name = "ISP sharpen SHPGAIN MUL";
        desc = "[inferred] ISP sharpen SHPGAIN MUL. Not in the data sheet. Source: OpenIPC openhisilicon `kernel/isp/arch/hi3516cv300/firmware/vreg/arch/hi3516cv300/isp_reg_define.h` (GPL-3.0 repository, HiSilicon copyright, nManager-generated 2015-12-22 \"Define all registers/tables for Hi3519\"; local copy sources/openhisilicon), union `U_ISP_SHARPEN_SHPGAIN_MUL`, struct offset 0x3532C (GPL-3.0 repository; header offsets are ISP-core relative (data sheet offset - 0x20000), 632 of 775 data-sheet registers match it by name and offset (ISP_BLC_CFG is at 0x21100 in the data sheet and 0x1000+0x20000 in the header)). Reset value and access type unknown (modelled RW, no reset). Confidence: medium (vendor header for this chip family, not hardware verified).";

        field {
            name = "rshpgainmul";
            desc = "[inferred] Rshpgainmul. (vendor header `isp_reg_define.h` field `rshpgainmul`; access and reset unknown, modelled RW)";
            sw = rw;
            hw = r;
        } rshpgainmul[26:16];

        field {
            name = "bshpgainmul";
            desc = "[inferred] Bshpgainmul. (vendor header `isp_reg_define.h` field `bshpgainmul`; access and reset unknown, modelled RW)";
            sw = rw;
            hw = r;
        } bshpgainmul[10:0];
    } ISP_SHARPEN_SHPGAIN_MUL @ 0x3532C;

    reg {
        name = "Overshoot control variance threshold AR register";
        desc = "ISP_SHARPEN_OSUP_VAR is an overshoot control variance threshold register. Hi3516C V300/Hi3516E V100 Professional HD IP Camera SoC

Data sheet 10.6 ISP_SHARPEN_OSUP_VAR (offset 0x45330, printed page 10-354, `hi3516cv300--Hi3516CV300-Hi3516EV100-Datasheet.txt` line 60814).";

        field {
            name = "oshtvarmax";
            desc = "Maximum overshoot control variance";
            sw = rw;
            hw = r;
            reset = 0x5;
        } oshtvarmax[23:16];

        field {
            name = "oshtvarmin";
            desc = "Minimum overshoot control variance";
            sw = rw;
            hw = r;
            reset = 0x0;
        } oshtvarmin[7:0];
    } ISP_SHARPEN_OSUP_VAR @ 0x35330;

    reg {
        name = "Overshoot control variance ARCOEF coefficient register";
        desc = "ISP_SHARPEN_OSUP_VARCOEF is an overshoot control variance coefficient register.

Data sheet 10.6 ISP_SHARPEN_OSUP_VARCOEF (offset 0x45334, printed page 10-354, `hi3516cv300--Hi3516CV300-Hi3516EV100-Datasheet.txt` line 60836).";

        field {
            name = "oshtwgtmin";
            desc = "Minimum weight of the overshoot control variance";
            sw = rw;
            hw = r;
            reset = 0x0;
        } oshtwgtmin[23:16];

        field {
            name = "oshtsupmul";
            desc = "[inferred] Oshtsupmul. (bits reserved in the data sheet; vendor header `isp_reg_define.h` field `oshtsupmul`; access and reset unknown, modelled RW)";
            sw = rw;
            hw = r;
        } oshtsupmul[11:0];
    } ISP_SHARPEN_OSUP_VARCOEF @ 0x35334;

    reg {
        name = "Undershoot control variance AR threshold register";
        desc = "ISP_SHARPEN_USUP_VAR is an undershoot control variance threshold register. Hi3516C V300/Hi3516E V100 Professional HD IP Camera SoC

Data sheet 10.6 ISP_SHARPEN_USUP_VAR (offset 0x45338, printed page 10-355, `hi3516cv300--Hi3516CV300-Hi3516EV100-Datasheet.txt` line 60867).";

        field {
            name = "ushtvarmax";
            desc = "Maximum undershoot control variance";
            sw = rw;
            hw = r;
            reset = 0x5;
        } ushtvarmax[23:16];

        field {
            name = "ushtvarmin";
            desc = "Minimum undershoot control variance";
            sw = rw;
            hw = r;
            reset = 0x0;
        } ushtvarmin[7:0];
    } ISP_SHARPEN_USUP_VAR @ 0x35338;

    reg {
        name = "Undershoot control variance ARCOEF coefficient register";
        desc = "ISP_SHARPEN_USUP_VARCOEF is an undershoot control variance coefficient register.

Data sheet 10.6 ISP_SHARPEN_USUP_VARCOEF (offset 0x4533C, printed page 10-355, `hi3516cv300--Hi3516CV300-Hi3516EV100-Datasheet.txt` line 60889).";

        field {
            name = "ushtwgtmin";
            desc = "Minimum weight of the undershoot control variance";
            sw = rw;
            hw = r;
            reset = 0x0;
        } ushtwgtmin[23:16];

        field {
            name = "ushtsupmul";
            desc = "[inferred] Ushtsupmul. (bits reserved in the data sheet; vendor header `isp_reg_define.h` field `ushtsupmul`; access and reset unknown, modelled RW)";
            sw = rw;
            hw = r;
        } ushtsupmul[11:0];
    } ISP_SHARPEN_USUP_VARCOEF @ 0x3533C;

    reg {
        name = "Overshoot control difference FF threshold register";
        desc = "ISP_SHARPEN_OSUP_DIFF is an overshoot control difference threshold register. Hi3516C V300/Hi3516E V100 Professional HD IP Camera SoC

Data sheet 10.6 ISP_SHARPEN_OSUP_DIFF (offset 0x45340, printed page 10-356, `hi3516cv300--Hi3516CV300-Hi3516EV100-Datasheet.txt` line 60920).";

        field {
            name = "oshtdiffmax";
            desc = "Maximum overshoot control difference";
            sw = rw;
            hw = r;
            reset = 0x19;
        } oshtdiffmax[23:16];

        field {
            name = "oshtdiffmin";
            desc = "Minimum overshoot control difference";
            sw = rw;
            hw = r;
            reset = 0xF;
        } oshtdiffmin[7:0];
    } ISP_SHARPEN_OSUP_DIFF @ 0x35340;

    reg {
        name = "Overshoot control difference FFCOEF coefficient register";
        desc = "ISP_SHARPEN_OSUP_DIFFCOEF is an overshoot control difference coefficient register.

Data sheet 10.6 ISP_SHARPEN_OSUP_DIFFCOEF (offset 0x45344, printed page 10-356, `hi3516cv300--Hi3516CV300-Hi3516EV100-Datasheet.txt` line 60942).";

        field {
            name = "oshtdiffwgtmin";
            desc = "Minimum weight of the overshoot control difference";
            sw = rw;
            hw = r;
            reset = 0x3C;
        } oshtdiffwgtmin[23:16];

        field {
            name = "oshtsupdiffmul";
            desc = "[inferred] Oshtsupdiffmul. (bits reserved in the data sheet; vendor header `isp_reg_define.h` field `oshtsupdiffmul`; access and reset unknown, modelled RW)";
            sw = rw;
            hw = r;
        } oshtsupdiffmul[12:0];
    } ISP_SHARPEN_OSUP_DIFFCOEF @ 0x35344;

    reg {
        name = "Undershoot control difference FF threshold register";
        desc = "ISP_SHARPEN_USUP_DIFF is an undershoot control difference threshold register. Hi3516C V300/Hi3516E V100 Professional HD IP Camera SoC

Data sheet 10.6 ISP_SHARPEN_USUP_DIFF (offset 0x45348, printed page 10-357, `hi3516cv300--Hi3516CV300-Hi3516EV100-Datasheet.txt` line 60976).";

        field {
            name = "ushtdiffmax";
            desc = "Maximum undershoot control difference";
            sw = rw;
            hw = r;
            reset = 0x19;
        } ushtdiffmax[23:16];

        field {
            name = "ushtdiffmin";
            desc = "Minimum undershoot control difference";
            sw = rw;
            hw = r;
            reset = 0xF;
        } ushtdiffmin[7:0];
    } ISP_SHARPEN_USUP_DIFF @ 0x35348;

    reg {
        name = "Undershoot control difference FFCOEF coefficient register";
        desc = "ISP_SHARPEN_USUP_DIFFCOEF is an undershoot control difference coefficient register.

Data sheet 10.6 ISP_SHARPEN_USUP_DIFFCOEF (offset 0x4534C, printed page 10-357, `hi3516cv300--Hi3516CV300-Hi3516EV100-Datasheet.txt` line 60998).";

        field {
            name = "ushtdiffwgtmin";
            desc = "Minimum weight of the undershoot control difference";
            sw = rw;
            hw = r;
            reset = 0x3C;
        } ushtdiffwgtmin[23:16];

        field {
            name = "ushtsupdiffmul";
            desc = "[inferred] Ushtsupdiffmul. (bits reserved in the data sheet; vendor header `isp_reg_define.h` field `ushtsupdiffmul`; access and reset unknown, modelled RW)";
            sw = rw;
            hw = r;
        } ushtsupdiffmul[12:0];
    } ISP_SHARPEN_USUP_DIFFCOEF @ 0x3534C;

    reg {
        name = "Shoot control noise threshold S register";
        desc = "ISP_SHARPEN_SUP_NOS is a shoot control noise threshold register. Hi3516C V300/Hi3516E V100 Professional HD IP Camera SoC

Data sheet 10.6 ISP_SHARPEN_SUP_NOS (offset 0x45350, printed page 10-358, `hi3516cv300--Hi3516CV300-Hi3516EV100-Datasheet.txt` line 61032).";

        field {
            name = "maxnosthd";
            desc = "Maximum threshold of shoot noises";
            sw = rw;
            hw = r;
            reset = 0x2;
        } maxnosthd[23:16];

        field {
            name = "minnosthd";
            desc = "Minimum threshold of shoot noises";
            sw = rw;
            hw = r;
            reset = 0x1;
        } minnosthd[7:0];
    } ISP_SHARPEN_SUP_NOS @ 0x35350;

    reg {
        name = "Shoot control blending parameter DR register";
        desc = "ISP_SHARPEN_SUP_BLDR is a shoot control blending parameter register.

Data sheet 10.6 ISP_SHARPEN_SUP_BLDR (offset 0x45354, printed page 10-358, `hi3516cv300--Hi3516CV300-Hi3516EV100-Datasheet.txt` line 61054).";

        field {
            name = "shtmax_en";
            desc = "Maximum shoot control enable";
            sw = rw;
            hw = r;
            reset = 0x1;
        } shtmax_en[17:17];

        field {
            name = "shtsup_en";
            desc = "Shoot control enable";
            sw = rw;
            hw = r;
            reset = 0x1;
        } shtsup_en[16:16];

        field {
            name = "shtsupbldr";
            desc = "Shoot control blending ratio";
            sw = rw;
            hw = r;
            reset = 0x9;
        } shtsupbldr[3:0];
    } ISP_SHARPEN_SUP_BLDR @ 0x35354;

    reg {
        name = "Directionless high frequency detail AIN control register";
        desc = "ISP_SHARPEN_UDHFGAIN is a directionless high-frequency detail control register. Hi3516C V300/Hi3516E V100 Professional HD IP Camera SoC

Data sheet 10.6 ISP_SHARPEN_UDHFGAIN (offset 0x45358, printed page 10-359, `hi3516cv300--Hi3516CV300-Hi3516EV100-Datasheet.txt` line 61091).";

        field {
            name = "udhfgain";
            desc = "Directionless high-frequency detail control";
            sw = rw;
            hw = r;
            reset = 0x10;
        } udhfgain[9:0];
    } ISP_SHARPEN_UDHFGAIN @ 0x35358;

    reg {
        name = "Shoot maximum limit parameter X register";
        desc = "ISP_SHARPEN_SHTMAX is a shoot maximum limit parameter register.

Data sheet 10.6 ISP_SHARPEN_SHTMAX (offset 0x4535C, printed page 10-359, `hi3516cv300--Hi3516CV300-Hi3516EV100-Datasheet.txt` line 61111).";

        field {
            name = "ushtmaxchg";
            desc = "Maximum undershoot limit";
            sw = rw;
            hw = r;
            reset = 0x0;
        } ushtmaxchg[31:24];

        field {
            name = "oshtmaxchg";
            desc = "Maximum overshoot limit";
            sw = rw;
            hw = r;
            reset = 0x64;
        } oshtmaxchg[23:16];

        field {
            name = "ushtmaxvargain";
            desc = "Maximum limit gain of the undershoot variance";
            sw = rw;
            hw = r;
            reset = 0x12;
        } ushtmaxvargain[15:8];

        field {
            name = "oshtmaxvargain";
            desc = "Maximum limit gain of the overshoot variance";
            sw = rw;
            hw = r;
            reset = 0x12;
        } oshtmaxvargain[7:0];
    } ISP_SHARPEN_SHTMAX @ 0x3535C;

    reg {
        name = "Shadow region noise variance AR threshold register";
        desc = "ISP_SHARPEN_SHADVAR is a shadow region noise variance threshold register.

Data sheet 10.6 ISP_SHARPEN_SHADVAR (offset 0x45360, printed page 10-359, `hi3516cv300--Hi3516CV300-Hi3516EV100-Datasheet.txt` line 61132).";

        field {
            name = "shadvar2";
            desc = "Shadow region noise variance threshold 2";
            sw = rw;
            hw = r;
            reset = 0x3C;
        } shadvar2[25:16];

        field {
            name = "shadvar1";
            desc = "Shadow region noise variance threshold 1";
            sw = rw;
            hw = r;
            reset = 0x2;
        } shadvar1[9:0];
    } ISP_SHARPEN_SHADVAR @ 0x35360;

    reg {
        name = "Shadow region noise gradient HD threshold register";
        desc = "ISP_SHARPEN_GRADTHD is a shadow region noise gradient threshold register.

Data sheet 10.6 ISP_SHARPEN_GRADTHD (offset 0x45364, printed page 10-360, `hi3516cv300--Hi3516CV300-Hi3516EV100-Datasheet.txt` line 61163).";

        field {
            name = "gradthd2";
            desc = "Shadow region noise gradient threshold 2";
            sw = rw;
            hw = r;
            reset = 0x10;
        } gradthd2[20:16];

        field {
            name = "gradthd1";
            desc = "Shadow region noise gradient threshold 1";
            sw = rw;
            hw = r;
            reset = 0xA;
        } gradthd1[4:0];
    } ISP_SHARPEN_GRADTHD @ 0x35364;

    reg {
        name = "Shadow region noise weight EF coefficient register";
        desc = "ISP_SHARPEN_WGTCOEF is a shadow region noise weight coefficient register.

Data sheet 10.6 ISP_SHARPEN_WGTCOEF (offset 0x45368, printed page 10-360, `hi3516cv300--Hi3516CV300-Hi3516EV100-Datasheet.txt` line 61185).";

        field {
            name = "wgtmul";
            desc = "[inferred] Wgtmul. (bits reserved in the data sheet; vendor header `isp_reg_define.h` field `wgtmul`; access and reset unknown, modelled RW)";
            sw = rw;
            hw = r;
        } wgtmul[23:16];

        field {
            name = "wgtthd2";
            desc = "Shadow region noise gradient weight threshold 2";
            sw = rw;
            hw = r;
            reset = 0x1F;
        } wgtthd2[12:8];

        field {
            name = "wgtthd1";
            desc = "Shadow region noise gradient weight threshold 1";
            sw = rw;
            hw = r;
            reset = 0x0;
        } wgtthd1[4:0];
    } ISP_SHARPEN_WGTCOEF @ 0x35368;

    reg {
        name = "R sharpening threshold coefficient register";
        desc = "ISP_SHARPEN_RC is an red sharpening threshold coefficient register.

Data sheet 10.6 ISP_SHARPEN_RC (offset 0x4536C, printed page 10-361, `hi3516cv300--Hi3516CV300-Hi3516EV100-Datasheet.txt` line 61222).";

        field {
            name = "rcrmin";
            desc = "Minimum threshold of red V. The value range is [0, 144].";
            sw = rw;
            hw = r;
            reset = 0x60;
        } rcrmin[31:24];

        field {
            name = "rcbmin";
            desc = "Minimum threshold of red U. The value range is [0, 144].";
            sw = rw;
            hw = r;
            reset = 0x0;
        } rcbmin[23:16];

        field {
            name = "rcrmax";
            desc = "Maximum threshold of red V. The value range is [0, 144].";
            sw = rw;
            hw = r;
            reset = 0x90;
        } rcrmax[15:8];

        field {
            name = "rcbmax";
            desc = "Maximum threshold of red U. The value range is [0, 144].";
            sw = rw;
            hw = r;
            reset = 0x90;
        } rcbmax[7:0];
    } ISP_SHARPEN_RC @ 0x3536C;

    reg {
        name = "B sharpening threshold coefficient register";
        desc = "ISP_SHARPEN_BC is a blue sharpening threshold coefficient register.

Data sheet 10.6 ISP_SHARPEN_BC (offset 0x45370, printed page 10-361, `hi3516cv300--Hi3516CV300-Hi3516EV100-Datasheet.txt` line 61244).";

        field {
            name = "bcrmin";
            desc = "Minimum threshold of blue V. The value range is [0, 144].";
            sw = rw;
            hw = r;
            reset = 0x2C;
        } bcrmin[31:24];

        field {
            name = "bcbmin";
            desc = "Minimum threshold of blue U. The value range is [0, 144].";
            sw = rw;
            hw = r;
            reset = 0x52;
        } bcbmin[23:16];

        field {
            name = "bcrmax";
            desc = "Maximum threshold of blue V. The value range is [0, 144].";
            sw = rw;
            hw = r;
            reset = 0x46;
        } bcrmax[15:8];

        field {
            name = "bcbmax";
            desc = "Maximum threshold of blue U. The value range is [0, 144].";
            sw = rw;
            hw = r;
            reset = 0x62;
        } bcbmax[7:0];
    } ISP_SHARPEN_BC @ 0x35370;

    reg {
        name = "G sharpening threshold coefficient register";
        desc = "ISP_SHARPEN_GC is a green sharpening threshold coefficient register.

Data sheet 10.6 ISP_SHARPEN_GC (offset 0x45374, printed page 10-362, `hi3516cv300--Hi3516CV300-Hi3516EV100-Datasheet.txt` line 61272).";

        field {
            name = "gcrmin";
            desc = "Minimum threshold of green V. The value range is [0, 144].";
            sw = rw;
            hw = r;
            reset = 0x32;
        } gcrmin[31:24];

        field {
            name = "gcbmin";
            desc = "Minimum threshold of green U. The value range is [0, 144].";
            sw = rw;
            hw = r;
            reset = 0x22;
        } gcbmin[23:16];

        field {
            name = "gcrmax";
            desc = "Maximum threshold of green V. The value range is [0, 144].";
            sw = rw;
            hw = r;
            reset = 0x4A;
        } gcrmax[15:8];

        field {
            name = "gcbmax";
            desc = "Maximum threshold of green U. The value range is [0, 144].";
            sw = rw;
            hw = r;
            reset = 0x44;
        } gcbmax[7:0];
    } ISP_SHARPEN_GC @ 0x35374;

    reg {
        name = "RGB sharpening gain coefficient T register";
        desc = "ISP_SHARPEN_RGBWGT is an RGB color sharpening gain coefficient register.

Data sheet 10.6 ISP_SHARPEN_RGBWGT (offset 0x45378, printed page 10-362, `hi3516cv300--Hi3516CV300-Hi3516EV100-Datasheet.txt` line 61294).";

        field {
            name = "rwgt";
            desc = "Maximum sharpening value of red. The value range is [0, 31].";
            sw = rw;
            hw = r;
            reset = 0x1F;
        } rwgt[20:16];

        field {
            name = "bwgt";
            desc = "Maximum sharpening value of blue. The value range is [0, 31].";
            sw = rw;
            hw = r;
            reset = 0x1F;
        } bwgt[12:8];

        field {
            name = "gwgt";
            desc = "Maximum sharpening value of green. The value range is [0, 15].";
            sw = rw;
            hw = r;
            reset = 0x4;
        } gwgt[3:0];
    } ISP_SHARPEN_RGBWGT @ 0x35378;

    reg {
        name = "RB sharpening gain difference and threshold register";
        desc = "ISP_SHARPEN_RBCOEF is an RGB sharpening gain difference and threshold register.

Data sheet 10.6 ISP_SHARPEN_RBCOEF (offset 0x4537C, printed page 10-363, `hi3516cv300--Hi3516CV300-Hi3516EV100-Datasheet.txt` line 61327).";

        field {
            name = "rcrthd";
            desc = "Threshold of red V. The value range is [0, 144].";
            sw = rw;
            hw = r;
            reset = 0x76;
        } rcrthd[31:24];

        field {
            name = "bcbthd";
            desc = "Threshold of blue U. The value range is [0, 144].";
            sw = rw;
            hw = r;
            reset = 0x57;
        } bcbthd[23:16];

        field {
            name = "rshpgainsft";
            desc = "Red high- and intermediate-frequency sharpening gain difference. The format is S6.0 and the value range is [-32, 31].";
            sw = rw;
            hw = r;
            reset = 0x1F;
        } rshpgainsft[13:8];

        field {
            name = "bshpgainsft";
            desc = "Blue high- and intermediate-frequency sharpening gain difference. The format is S6.0 and the value range is [-32, 31].";
            sw = rw;
            hw = r;
            reset = 0x1F;
        } bshpgainsft[5:0];
    } ISP_SHARPEN_RBCOEF @ 0x3537C;

    reg {
        name = "ISP sharpen SKIN control I";
        desc = "[inferred] ISP sharpen SKIN control I. Not in the data sheet. Source: OpenIPC openhisilicon `kernel/isp/arch/hi3516cv300/firmware/vreg/arch/hi3516cv300/isp_reg_define.h` (GPL-3.0 repository, HiSilicon copyright, nManager-generated 2015-12-22 \"Define all registers/tables for Hi3519\"; local copy sources/openhisilicon), union `U_ISP_SHARPEN_SKIN_CTRL_I`, struct offset 0x353E4 (GPL-3.0 repository; header offsets are ISP-core relative (data sheet offset - 0x20000), 632 of 775 data-sheet registers match it by name and offset (ISP_BLC_CFG is at 0x21100 in the data sheet and 0x1000+0x20000 in the header)). Reset value and access type unknown (modelled RW, no reset). Confidence: medium (vendor header for this chip family, not hardware verified).";

        field {
            name = "update_mode";
            desc = "[inferred] Update mode. (vendor header `isp_reg_define.h` field `update_mode`; access and reset unknown, modelled RW)";
            sw = rw;
            hw = r;
        } update_mode[0:0];
    } ISP_SHARPEN_SKIN_CTRL_I @ 0x353E4;

    reg {
        name = "ISP sharpen SKIN UPDATE";
        desc = "[inferred] ISP sharpen SKIN UPDATE. Not in the data sheet. Source: OpenIPC openhisilicon `kernel/isp/arch/hi3516cv300/firmware/vreg/arch/hi3516cv300/isp_reg_define.h` (GPL-3.0 repository, HiSilicon copyright, nManager-generated 2015-12-22 \"Define all registers/tables for Hi3519\"; local copy sources/openhisilicon), union `U_ISP_SHARPEN_SKIN_UPDATE`, struct offset 0x353EC (GPL-3.0 repository; header offsets are ISP-core relative (data sheet offset - 0x20000), 632 of 775 data-sheet registers match it by name and offset (ISP_BLC_CFG is at 0x21100 in the data sheet and 0x1000+0x20000 in the header)). Reset value and access type unknown (modelled RW, no reset). Confidence: medium (vendor header for this chip family, not hardware verified).";

        field {
            name = "update";
            desc = "[inferred] Update. (vendor header `isp_reg_define.h` field `update`; access and reset unknown, modelled RW)";
            sw = rw;
            hw = r;
        } update[0:0];
    } ISP_SHARPEN_SKIN_UPDATE @ 0x353EC;

    reg {
        name = "NDDM control register";
        desc = "ISP_NDDM_CFG is an NDDM control register.

Data sheet 10.6 ISP_NDDM_CFG (offset 0x45600, printed page 10-363, `hi3516cv300--Hi3516CV300-Hi3516EV100-Datasheet.txt` line 61358).";

        enum ISP_NDDM_CFG_cac_blend_en_enum {
            DISABLED = 0 { name = "Disabled"; desc = "disabled"; };
            ENABLED = 1 { name = "Enabled"; desc = "enabled"; };
        };

        field {
            name = "cac_blend_en";
            desc = "CAC blending enable";
            sw = rw;
            hw = r;
            encode = ISP_NDDM_CFG_cac_blend_en_enum;
            reset = 0x0;
        } cac_blend_en[16:16];

        enum ISP_NDDM_CFG_en_enum {
            DISABLED = 0 { name = "Disabled"; desc = "disabled"; };
            ENABLED = 1 { name = "Enabled"; desc = "enabled"; };
        };

        field {
            name = "en";
            desc = "NDDM enable";
            sw = rw;
            hw = r;
            encode = ISP_NDDM_CFG_en_enum;
            reset = 0x0;
        } en[0:0];
    } ISP_NDDM_CFG @ 0x35600;

    reg {
        name = "NDDM filtering strength range control register";
        desc = "ISP_NDDM_GF_TH is an NDDM filtering strength range control register.

Data sheet 10.6 ISP_NDDM_GF_TH (offset 0x45604, printed page 10-364, `hi3516cv300--Hi3516CV300-Hi3516EV100-Datasheet.txt` line 61401).";

        field {
            name = "gf_th_high";
            desc = "High threshold";
            sw = rw;
            hw = r;
            reset = 0x100;
        } gf_th_high[24:16];

        field {
            name = "gf_th_low";
            desc = "Low threshold";
            sw = rw;
            hw = r;
            reset = 0x0;
        } gf_th_low[8:0];
    } ISP_NDDM_GF_TH @ 0x35604;

    reg {
        name = "Filtering window 5x5 and 9x9 blending ratio control register";
        desc = "ISP_NDDM_GF_BLDR is a filtering window 5x5 and 9x9 blending ratio control register.

Data sheet 10.6 ISP_NDDM_GF_BLDR (offset 0x45608, printed page 10-364, `hi3516cv300--Hi3516CV300-Hi3516EV100-Datasheet.txt` line 61423).";

        field {
            name = "bldr_cbcr";
            desc = "Cb & Cr window ratio control";
            sw = rw;
            hw = r;
            reset = 0x8;
        } bldr_cbcr[20:16];

        field {
            name = "bldr_var_str";
            desc = "9x9 and 5x5 window variance ratio control";
            sw = rw;
            hw = r;
            reset = 0x3;
        } bldr_var_str[12:8];

        field {
            name = "bldr_gf_str";
            desc = "R & G & B window ratio control";
            sw = rw;
            hw = r;
            reset = 0x3;
        } bldr_gf_str[4:0];
    } ISP_NDDM_GF_BLDR @ 0x35608;

    reg {
        name = "Saturation control filtering strength register";
        desc = "ISP_NDDM_GF_CHRM is a saturation control filtering strength register.

Data sheet 10.6 ISP_NDDM_GF_CHRM (offset 0x4560C, printed page 10-365, `hi3516cv300--Hi3516CV300-Hi3516EV100-Datasheet.txt` line 61459).";

        field {
            name = "chrm_fix";
            desc = "Maximum enhancement gain";
            sw = rw;
            hw = r;
            reset = 0x4;
        } chrm_fix[23:20];

        field {
            name = "chrm_high";
            desc = "High threshold of saturation";
            sw = rw;
            hw = r;
            reset = 0xBE;
        } chrm_high[18:10];

        field {
            name = "chrm_low";
            desc = "Low threshold of saturation";
            sw = rw;
            hw = r;
            reset = 0x82;
        } chrm_low[8:0];
    } ISP_NDDM_GF_CHRM @ 0x3560C;

    reg {
        name = "USM strengthening control register";
        desc = "ISP_NDDM_USM_CFG is a USM enhancement control register. Hi3516C V300/Hi3516E V100 Professional HD IP Camera SoC

Data sheet 10.6 ISP_NDDM_USM_CFG (offset 0x45610, printed page 10-366, `hi3516cv300--Hi3516CV300-Hi3516EV100-Datasheet.txt` line 61496).";

        field {
            name = "multi_mf";
            desc = "USM gain (U3.2)";
            sw = rw;
            hw = r;
            reset = 0x6;
        } multi_mf[20:16];

        field {
            name = "clip_usm";
            desc = "USM clipping threshold (U12.0)";
            sw = rw;
            hw = r;
            reset = 0x100;
        } clip_usm[11:0];
    } ISP_NDDM_USM_CFG @ 0x35610;

    reg {
        name = "Saturation attenuation USM strength register";
        desc = "ISP_NDDM_USM_SATU is a saturation attenuation USM strength register.

Data sheet 10.6 ISP_NDDM_USM_SATU (offset 0x45614, printed page 10-366, `hi3516cv300--Hi3516CV300-Hi3516EV100-Datasheet.txt` line 61518).";

        field {
            name = "satu_th_fix";
            desc = "Maximum gain";
            sw = rw;
            hw = r;
            reset = 0xA4;
        } satu_th_fix[28:20];

        field {
            name = "satu_th_high";
            desc = "High threshold of saturation";
            sw = rw;
            hw = r;
            reset = 0xC8;
        } satu_th_high[18:10];

        field {
            name = "satu_th_low";
            desc = "Low threshold of saturation";
            sw = rw;
            hw = r;
            reset = 0x82;
        } satu_th_low[8:0];
    } ISP_NDDM_USM_SATU @ 0x35614;

    reg {
        name = "Gray attenuation SUM strength register";
        desc = "ISP_NDDM_USM_GRAY is a gray attenuation USM strength register. Hi3516C V300/Hi3516E V100 Professional HD IP Camera SoC

Data sheet 10.6 ISP_NDDM_USM_GRAY (offset 0x45618, printed page 10-367, `hi3516cv300--Hi3516CV300-Hi3516EV100-Datasheet.txt` line 61554).";

        field {
            name = "gray_th_fix";
            desc = "Minimum USM gain";
            sw = rw;
            hw = r;
            reset = 0x20;
        } gray_th_fix[28:20];

        field {
            name = "gray_th_high";
            desc = "High threshold of gray";
            sw = rw;
            hw = r;
            reset = 0x14;
        } gray_th_high[18:10];

        field {
            name = "gray_th_low";
            desc = "Low threshold of gray";
            sw = rw;
            hw = r;
            reset = 0x0;
        } gray_th_low[8:0];
    } ISP_NDDM_USM_GRAY @ 0x35618;

    reg {
        name = "Adaptive filtering and interpolation BLD GbGr blending register";
        desc = "ISP_NDDM_APT_INTP_BLD is an adaptive filtering and interpolation Gb and Gr blending register.

Data sheet 10.6 ISP_NDDM_APT_INTP_BLD (offset 0x4561C, printed page 10-367, `hi3516cv300--Hi3516CV300-Hi3516EV100-Datasheet.txt` line 61582).";

        field {
            name = "bldr_gr_gb";
            desc = "Gb and Gr blending ratio";
            sw = rw;
            hw = r;
            reset = 0x4;
        } bldr_gr_gb[3:0];
    } ISP_NDDM_APT_INTP_BLD @ 0x3561C;

    reg {
        name = "Dither control register G";
        desc = "ISP_NDDM_DITHER_CFG is a dither control register. Hi3516C V300/Hi3516E V100 Professional HD IP Camera SoC

Data sheet 10.6 ISP_NDDM_DITHER_CFG (offset 0x45624, printed page 10-368, `hi3516cv300--Hi3516CV300-Hi3516EV100-Datasheet.txt` line 61610).";

        field {
            name = "dith_max";
            desc = "Maximum dither value";
            sw = rw;
            hw = r;
            reset = 0x2;
        } dith_max[23:16];

        field {
            name = "dith_ratio";
            desc = "Dither overlapping ratio";
            sw = rw;
            hw = r;
            reset = 0x20;
        } dith_ratio[15:8];

        field {
            name = "dith_mask";
            desc = "Dither mask";
            sw = rw;
            hw = r;
            reset = 0xF;
        } dith_mask[7:0];
    } ISP_NDDM_DITHER_CFG @ 0x35624;

    reg {
        name = "FCR anti-moire protection range register";
        desc = "ISP_NDDM_FCR_LIMIT is an FCR de-moire protection range register.

Data sheet 10.6 ISP_NDDM_FCR_LIMIT (offset 0x45628, printed page 10-368, `hi3516cv300--Hi3516CV300-Hi3516EV100-Datasheet.txt` line 61632).";

        field {
            name = "fcr_limit_high";
            desc = "High threshold";
            sw = rw;
            hw = r;
            reset = 0x100;
        } fcr_limit_high[27:16];

        field {
            name = "fcr_limit_low";
            desc = "Low threshold";
            sw = rw;
            hw = r;
            reset = 0x80;
        } fcr_limit_low[11:0];
    } ISP_NDDM_FCR_LIMIT @ 0x35628;

    reg {
        name = "FCR function control register";
        desc = "ISP_NDDM_FCR_GAIN is an FCR function control register. Hi3516C V300/Hi3516E V100 Professional HD IP Camera SoC

Data sheet 10.6 ISP_NDDM_FCR_GAIN (offset 0x4562C, printed page 10-369, `hi3516cv300--Hi3516CV300-Hi3516EV100-Datasheet.txt` line 61663).";

        field {
            name = "fcr_det_low";
            desc = "FCR effective threshold";
            sw = rw;
            hw = r;
            reset = 0x96;
        } fcr_det_low[27:16];

        field {
            name = "fcr_gf_gain";
            desc = "FCR strength control of the filter";
            sw = rw;
            hw = r;
            reset = 0x4;
        } fcr_gf_gain[4:0];
    } ISP_NDDM_FCR_GAIN @ 0x3562C;

    reg {
        name = "FCR anti-moire scale register";
        desc = "ISP_NDDM_FCR_SCALE is an FCR de-moire scale register.

Data sheet 10.6 ISP_NDDM_FCR_SCALE (offset 0x45630, printed page 10-369, `hi3516cv300--Hi3516CV300-Hi3516EV100-Datasheet.txt` line 61685).";

        field {
            name = "scale";
            desc = "Scale";
            sw = rw;
            hw = r;
            reset = 0x2;
        } scale[3:0];
    } ISP_NDDM_FCR_SCALE @ 0x35630;

    reg {
        name = "CAC VHDM ratio register TE";
        desc = "ISP_NDDM_DM_BLDRATE is a CAC VHDM ratio register.

Data sheet 10.6 ISP_NDDM_DM_BLDRATE (offset 0x45634, printed page 10-369, `hi3516cv300--Hi3516CV300-Hi3516EV100-Datasheet.txt` line 61705).";

        field {
            name = "cac_blend_rate";
            desc = "VHDM ratio";
            sw = rw;
            hw = r;
            reset = 0x100;
        } cac_blend_rate[8:0];
    } ISP_NDDM_DM_BLDRATE @ 0x35634;

    reg {
        name = "NDDM filter fuzzy table update DATE configuration register";
        desc = "ISP_NDDM_GF_LUT_UPDATE is an NDDM filter fuzzy table update configuration register.

Data sheet 10.6 ISP_NDDM_GF_LUT_UPDATE (offset 0x45638, printed page 10-370, `hi3516cv300--Hi3516CV300-Hi3516EV100-Datasheet.txt` line 61734).";

        field {
            name = "update";
            desc = "Update of the filter fuzzy table";
            sw = rw;
            hw = r;
            reset = 0x0;
        } update[0:0];
    } ISP_NDDM_GF_LUT_UPDATE @ 0x35638;

    reg {
        name = "NDDM strength table update UPDATE configuration register";
        desc = "ISP_NDDM_USM_LUT_UPDATE is an NDDM strength table update configuration register.

Data sheet 10.6 ISP_NDDM_USM_LUT_UPDATE (offset 0x45640, printed page 10-370, `hi3516cv300--Hi3516CV300-Hi3516EV100-Datasheet.txt` line 61754).";

        field {
            name = "update";
            desc = "Update of the USM strength table";
            sw = rw;
            hw = r;
            reset = 0x0;
        } update[0:0];
    } ISP_NDDM_USM_LUT_UPDATE @ 0x35640;

    reg {
        name = "Gray attenuation USM gain 2 _TH_FIX2 register";
        desc = "ISP_NDDM_USM_GRAY_TH_FIX2 is a gray attenuation USM gain 2 register. Hi3516C V300/Hi3516E V100 Professional HD IP Camera SoC

Data sheet 10.6 ISP_NDDM_USM_GRAY_TH_FIX2 (offset 0x45644, printed page 10-371, `hi3516cv300--Hi3516CV300-Hi3516EV100-Datasheet.txt` line 61784).";

        field {
            name = "gray_th_fix2";
            desc = "Maximum USM gain. The value range is [0, 256].";
            sw = rw;
            hw = r;
            reset = 0x100;
        } gray_th_fix2[8:0];
    } ISP_NDDM_USM_GRAY_TH_FIX2 @ 0x35644;

    reg {
        name = "Adaptive filtering and interpolation CLIP2 threshold register 2";
        desc = "ISP_NDDM_APT_INTP_CLIP2 is adaptive filtering the interpolation threshold register 2.

Data sheet 10.6 ISP_NDDM_APT_INTP_CLIP2 (offset 0x45648, printed page 10-371, `hi3516cv300--Hi3516CV300-Hi3516EV100-Datasheet.txt` line 61804).";

        field {
            name = "clip_delta_gain";
            desc = "Adaptive filtering and interpolation gain";
            sw = rw;
            hw = r;
            reset = 0x2;
        } clip_delta_gain[23:16];

        field {
            name = "clip_adjust_max";
            desc = "Maximum value of adaptive filtering and interpolation";
            sw = rw;
            hw = r;
            reset = 0x28;
        } clip_adjust_max[7:0];
    } ISP_NDDM_APT_INTP_CLIP2 @ 0x35648;

    reg {
        name = "Adaptive filtering configuration CFG_0 register 0";
        desc = "ISP_NDDM_APT_AVG_CFG_0 is adaptive filtering configuration register 0. Hi3516C V300/Hi3516E V100 Professional HD IP Camera SoC

Data sheet 10.6 ISP_NDDM_APT_AVG_CFG_0 (offset 0x4564C, printed page 10-372, `hi3516cv300--Hi3516CV300-Hi3516EV100-Datasheet.txt` line 61834).";

        field {
            name = "filter_str_intpclip_delta_intp_hig";
            desc = "Strength of non-linear interpolation";
            sw = rw;
            hw = r;
            reset = 0x10;
        } filter_str_intpclip_delta_intp_hig[28:24];

        field {
            name = "clip_delta_intp_high";
            desc = "High threshold of non-linear interpolation";
            sw = rw;
            hw = r;
            reset = 0xA;
        } clip_delta_intp_high[23:12];

        field {
            name = "clip_delta_intp_lowLow";
            desc = "clip_delta_intp_lowLow";
            sw = rw;
            hw = r;
            reset = 0xA;
        } clip_delta_intp_lowLow[11:0];
    } ISP_NDDM_APT_AVG_CFG_0 @ 0x3564C;

    reg {
        name = "Adaptive filtering configuration CFG_1 register 1";
        desc = "ISP_NDDM_APT_AVG_CFG_1 is adaptive filtering configuration register 0.

Data sheet 10.6 ISP_NDDM_APT_AVG_CFG_1 (offset 0x45650, printed page 10-372, `hi3516cv300--Hi3516CV300-Hi3516EV100-Datasheet.txt` line 61861).";

        field {
            name = "filter_str_filt";
            desc = "Strength of non-linear filtering";
            sw = rw;
            hw = r;
            reset = 0x10;
        } filter_str_filt[28:24];

        field {
            name = "clip_delta_filt_high";
            desc = "High threshold of non-linear filtering";
            sw = rw;
            hw = r;
            reset = 0xA;
        } clip_delta_filt_high[23:12];

        field {
            name = "clip_delta_filt_low";
            desc = "Low threshold of non-linear filtering";
            sw = rw;
            hw = r;
            reset = 0xA;
        } clip_delta_filt_low[11:0];
    } ISP_NDDM_APT_AVG_CFG_1 @ 0x35650;

    reg {
        name = "Variance offset control register T_CFG";
        desc = "ISP_NDDM_VAR_OFFSET_CFG is a variance offset control register. Hi3516C V300/Hi3516E V100 Professional HD IP Camera SoC

Data sheet 10.6 ISP_NDDM_VAR_OFFSET_CFG (offset 0x45654, printed page 10-373, `hi3516cv300--Hi3516CV300-Hi3516EV100-Datasheet.txt` line 61896).";

        field {
            name = "var_offset_low";
            desc = "Variance threshold";
            sw = rw;
            hw = r;
            reset = 0x12C;
        } var_offset_low[31:8];

        field {
            name = "var_offset_gain";
            desc = "Variance offset gain";
            sw = rw;
            hw = r;
            reset = 0x20;
        } var_offset_gain[7:0];
    } ISP_NDDM_VAR_OFFSET_CFG @ 0x35654;

    reg {
        name = "Black and white border suppression control register";
        desc = "ISP_NDDM_SHT_CTRL is a black and white border suppression control register.

Data sheet 10.6 ISP_NDDM_SHT_CTRL (offset 0x45658, printed page 10-373, `hi3516cv300--Hi3516CV300-Hi3516EV100-Datasheet.txt` line 61916).";

        field {
            name = "sht_ctrl_th";
            desc = "Black and white border suppression control threshold";
            sw = rw;
            hw = r;
            reset = 0x200;
        } sht_ctrl_th[27:16];

        field {
            name = "sht_ctrl_gain";
            desc = "Black and white border suppression control gain. The value range is [0, 8].";
            sw = rw;
            hw = r;
            reset = 0x6;
        } sht_ctrl_gain[3:0];
    } ISP_NDDM_SHT_CTRL @ 0x35658;

    reg {
        name = "R channel black and white border R suppression threshold configuration register";
        desc = "ISP_NDDM_SHT_CLIP_R is an R channel black and white border suppression threshold configuration register. Hi3516C V300/Hi3516E V100 Professional HD IP Camera SoC

Data sheet 10.6 ISP_NDDM_SHT_CLIP_R (offset 0x4565C, printed page 10-374, `hi3516cv300--Hi3516CV300-Hi3516EV100-Datasheet.txt` line 61949).";

        field {
            name = "clip_r_ov_sht";
            desc = "Upper threshold for R channel black and white border suppression";
            sw = rw;
            hw = r;
            reset = 0x100;
        } clip_r_ov_sht[27:16];

        field {
            name = "clip_r_ud_sht";
            desc = "Lower threshold for R channel black and white border suppression";
            sw = rw;
            hw = r;
            reset = 0x400;
        } clip_r_ud_sht[11:0];
    } ISP_NDDM_SHT_CLIP_R @ 0x3565C;

    reg {
        name = "B channel black and white border B suppression threshold configuration register";
        desc = "ISP_NDDM_SHT_CLIP_B is a B channel black and white border suppression threshold configuration register.

Data sheet 10.6 ISP_NDDM_SHT_CLIP_B (offset 0x45660, printed page 10-374, `hi3516cv300--Hi3516CV300-Hi3516EV100-Datasheet.txt` line 61972).";

        field {
            name = "clip_b_ov_sht";
            desc = "Upper threshold for B channel black and white border suppression";
            sw = rw;
            hw = r;
            reset = 0x100;
        } clip_b_ov_sht[27:16];

        field {
            name = "clip_b_ud_sht";
            desc = "Lower threshold for B channel black and white border suppression";
            sw = rw;
            hw = r;
            reset = 0x400;
        } clip_b_ud_sht[11:0];
    } ISP_NDDM_SHT_CLIP_B @ 0x35660;

    reg {
        name = "R/B channel USM strengthening RB control register";
        desc = "ISP_NDDM_MULTI_MF_RB is an R and B channel USM enhancement control register. Hi3516C V300/Hi3516E V100 Professional HD IP Camera SoC

Data sheet 10.6 ISP_NDDM_MULTI_MF_RB (offset 0x45664, printed page 10-375, `hi3516cv300--Hi3516CV300-Hi3516EV100-Datasheet.txt` line 62002).";

        field {
            name = "multi_mf_b";
            desc = "Enhancement of channel B";
            sw = rw;
            hw = r;
            reset = 0xC;
        } multi_mf_b[12:8];

        field {
            name = "multi_mf_r";
            desc = "Enhancement of channel R";
            sw = rw;
            hw = r;
            reset = 0xC;
        } multi_mf_r[4:0];
    } ISP_NDDM_MULTI_MF_RB @ 0x35664;

    reg {
        name = "R channel saturation attenuation _R USM strength register";
        desc = "ISP_NDDM_USM_SATU_R is an R channel saturation attenuation USM strength register.

Data sheet 10.6 ISP_NDDM_USM_SATU_R (offset 0x45668, printed page 10-375, `hi3516cv300--Hi3516CV300-Hi3516EV100-Datasheet.txt` line 62027).";

        field {
            name = "satu_r_th_fix";
            desc = "Maximum gain of the R component. The value range is [0, 256].";
            sw = rw;
            hw = r;
            reset = 0x5C;
        } satu_r_th_fix[28:20];

        field {
            name = "satu_r_th_high";
            desc = "High threshold of the R component saturation. The value range is [0, 256].";
            sw = rw;
            hw = r;
            reset = 0xC8;
        } satu_r_th_high[18:10];

        field {
            name = "satu_r_th_low";
            desc = "Low threshold of the R component saturation. The value range is [0, 256].";
            sw = rw;
            hw = r;
            reset = 0x82;
        } satu_r_th_low[8:0];
    } ISP_NDDM_USM_SATU_R @ 0x35668;

    reg {
        name = "B channel saturation attenuation _B USM strength register";
        desc = "ISP_NDDM_USM_SATU_B is a B channel saturation attenuation USM strength register.

Data sheet 10.6 ISP_NDDM_USM_SATU_B (offset 0x4566C, printed page 10-376, `hi3516cv300--Hi3516CV300-Hi3516EV100-Datasheet.txt` line 62065).";

        field {
            name = "satu_b_th_fix";
            desc = "Maximum gain of the B component. The value range is [0, 256].";
            sw = rw;
            hw = r;
            reset = 0x5C;
        } satu_b_th_fix[28:20];

        field {
            name = "satu_b_th_high";
            desc = "High threshold of the B component saturation. The value range is [0, 256].";
            sw = rw;
            hw = r;
            reset = 0xC8;
        } satu_b_th_high[18:10];

        field {
            name = "satu_b_th_low";
            desc = "Low threshold of the B component saturation. The value range is [0, 256].";
            sw = rw;
            hw = r;
            reset = 0x82;
        } satu_b_th_low[8:0];
    } ISP_NDDM_USM_SATU_B @ 0x3566C;

    reg {
        name = "Saturation control luminance gain EHCY register";
        desc = "ISP_NDDM_SATU_FIX_EHCY is a saturation control luminance gain register.

Data sheet 10.6 ISP_NDDM_SATU_FIX_EHCY (offset 0x45670, printed page 10-376, `hi3516cv300--Hi3516CV300-Hi3516EV100-Datasheet.txt` line 62096).";

        field {
            name = "satu_fix_ehcy";
            desc = "Luminance gain in regions with high saturation. The value range is [-256, 256].";
            sw = rw;
            hw = r;
            reset = 0x40;
        } satu_fix_ehcy[9:0];
    } ISP_NDDM_SATU_FIX_EHCY @ 0x35670;

    reg {
        name = "NDDM fuzzy table write address ADDR register";
        desc = "ISP_NDDM_GF_LUT_WADDR is an NDDM fuzzy table write address register.

Data sheet 10.6 ISP_NDDM_GF_LUT_WADDR (offset 0x45680, printed page 10-377, `hi3516cv300--Hi3516CV300-Hi3516EV100-Datasheet.txt` line 62124).";

        field {
            name = "gf_lut_waddr";
            desc = "Write address of the NDDM filter fuzzy table. The value range is [0, 16].";
            sw = rw;
            hw = r;
            reset = 0x0;
        } gf_lut_waddr[4:0];
    } ISP_NDDM_GF_LUT_WADDR @ 0x35680;

    reg {
        name = "NDDM fuzzy table write data DATA register";
        desc = "ISP_NDDM_GF_LUT_WDATA is an NDDM fuzzy table write data register.

Data sheet 10.6 ISP_NDDM_GF_LUT_WDATA (offset 0x45684, printed page 10-377, `hi3516cv300--Hi3516CV300-Hi3516EV100-Datasheet.txt` line 62146).";

        field {
            name = "gf_lut_wdata";
            desc = "Write data of the NDDM filter fuzzy table";
            sw = rw;
            hw = r;
            reset = 0x0;
        } gf_lut_wdata[11:0];
    } ISP_NDDM_GF_LUT_WDATA @ 0x35684;

    reg {
        name = "NDDM fuzzy table read address DDR register";
        desc = "ISP_NDDM_GF_LUT_RADDR is an NDDM fuzzy table read address register. Hi3516C V300/Hi3516E V100 Professional HD IP Camera SoC

Data sheet 10.6 ISP_NDDM_GF_LUT_RADDR (offset 0x45688, printed page 10-378, `hi3516cv300--Hi3516CV300-Hi3516EV100-Datasheet.txt` line 62175).";

        field {
            name = "gf_lut_raddr";
            desc = "Read address of the NDDM filter fuzzy table. The value range is [0, 16].";
            sw = rw;
            hw = r;
            reset = 0x0;
        } gf_lut_raddr[4:0];
    } ISP_NDDM_GF_LUT_RADDR @ 0x35688;

    reg {
        name = "NDDM fuzzy table read data register ATA";
        desc = "ISP_NDDM_GF_LUT_RDATA is an NDDM fuzzy table read data register.

Data sheet 10.6 ISP_NDDM_GF_LUT_RDATA (offset 0x4568C, printed page 10-378, `hi3516cv300--Hi3516CV300-Hi3516EV100-Datasheet.txt` line 62197).";

        field {
            name = "gf_lut_rdata";
            desc = "Read data of the NDDM filter fuzzy table";
            sw = r;
            hw = w;
            reset = 0x0;
        } gf_lut_rdata[11:0];
    } ISP_NDDM_GF_LUT_RDATA @ 0x3568C;

    reg {
        name = "NDDM strength table write address WADDR register";
        desc = "ISP_NDDM_USM_LUT_WADDR is an NDDM strength table write address register.

Data sheet 10.6 ISP_NDDM_USM_LUT_WADDR (offset 0x45690, printed page 10-378, `hi3516cv300--Hi3516CV300-Hi3516EV100-Datasheet.txt` line 62214).";

        field {
            name = "usm_lut_waddr";
            desc = "Write address of the NDDM USM strength table. The value range is [0, 16].";
            sw = rw;
            hw = r;
            reset = 0x0;
        } usm_lut_waddr[4:0];
    } ISP_NDDM_USM_LUT_WADDR @ 0x35690;

    reg {
        name = "NDDM strength table write data WDATA register";
        desc = "ISP_NDDM_USM_LUT_WDATA is an NDDM strength table write data register.

Data sheet 10.6 ISP_NDDM_USM_LUT_WDATA (offset 0x45694, printed page 10-379, `hi3516cv300--Hi3516CV300-Hi3516EV100-Datasheet.txt` line 62241).";

        field {
            name = "usm_lut_wdata";
            desc = "Write data of the NDDM USM strength table";
            sw = rw;
            hw = r;
            reset = 0x0;
        } usm_lut_wdata[7:0];
    } ISP_NDDM_USM_LUT_WDATA @ 0x35694;

    reg {
        name = "NDDM strength table read address RADDR register";
        desc = "ISP_NDDM_USM_LUT_RADDR is an NDDM strength table read address register.

Data sheet 10.6 ISP_NDDM_USM_LUT_RADDR (offset 0x45698, printed page 10-379, `hi3516cv300--Hi3516CV300-Hi3516EV100-Datasheet.txt` line 62261).";

        field {
            name = "usm_lut_raddr";
            desc = "Read address of the NDDM USM strength table. The value range is [0, 16].";
            sw = rw;
            hw = r;
            reset = 0x0;
        } usm_lut_raddr[4:0];
    } ISP_NDDM_USM_LUT_RADDR @ 0x35698;

    reg {
        name = "NDDM strength table read data RDATA register";
        desc = "ISP_NDDM_USM_LUT_RDATA is an NDDM strength table read data register. Hi3516C V300/Hi3516E V100 Professional HD IP Camera SoC

Data sheet 10.6 ISP_NDDM_USM_LUT_RDATA (offset 0x4569C, printed page 10-380, `hi3516cv300--Hi3516CV300-Hi3516EV100-Datasheet.txt` line 62291).";

        field {
            name = "usm_lut_rdata";
            desc = "Read data of the NDDM USM strength table";
            sw = r;
            hw = w;
            reset = 0x0;
        } usm_lut_rdata[7:0];
    } ISP_NDDM_USM_LUT_RDATA @ 0x3569C;

    reg {
        name = "ISP NDDM control F";
        desc = "[inferred] ISP NDDM control F. Not in the data sheet. Source: OpenIPC openhisilicon `kernel/isp/arch/hi3516cv300/firmware/vreg/arch/hi3516cv300/isp_reg_define.h` (GPL-3.0 repository, HiSilicon copyright, nManager-generated 2015-12-22 \"Define all registers/tables for Hi3519\"; local copy sources/openhisilicon), union `U_ISP_NDDM_CTRL_F`, struct offset 0x356E0 (GPL-3.0 repository; header offsets are ISP-core relative (data sheet offset - 0x20000), 632 of 775 data-sheet registers match it by name and offset (ISP_BLC_CFG is at 0x21100 in the data sheet and 0x1000+0x20000 in the header)). Reset value and access type unknown (modelled RW, no reset). Confidence: medium (vendor header for this chip family, not hardware verified).";

        field {
            name = "rggb_cfg";
            desc = "[inferred] Rggb configuration. (vendor header `isp_reg_define.h` field `rggb_cfg`; access and reset unknown, modelled RW)";
            sw = rw;
            hw = r;
        } rggb_cfg[1:0];
    } ISP_NDDM_CTRL_F @ 0x356E0;

    reg {
        name = "ISP NDDM control I";
        desc = "[inferred] ISP NDDM control I. Not in the data sheet. Source: OpenIPC openhisilicon `kernel/isp/arch/hi3516cv300/firmware/vreg/arch/hi3516cv300/isp_reg_define.h` (GPL-3.0 repository, HiSilicon copyright, nManager-generated 2015-12-22 \"Define all registers/tables for Hi3519\"; local copy sources/openhisilicon), union `U_ISP_NDDM_CTRL_I`, struct offset 0x356E4 (GPL-3.0 repository; header offsets are ISP-core relative (data sheet offset - 0x20000), 632 of 775 data-sheet registers match it by name and offset (ISP_BLC_CFG is at 0x21100 in the data sheet and 0x1000+0x20000 in the header)). Reset value and access type unknown (modelled RW, no reset). Confidence: medium (vendor header for this chip family, not hardware verified).";

        field {
            name = "update_mode";
            desc = "[inferred] Update mode. (vendor header `isp_reg_define.h` field `update_mode`; access and reset unknown, modelled RW)";
            sw = rw;
            hw = r;
        } update_mode[0:0];
    } ISP_NDDM_CTRL_I @ 0x356E4;

    reg {
        name = "ISP NDDM TIMING";
        desc = "[inferred] ISP NDDM TIMING. Not in the data sheet. Source: OpenIPC openhisilicon `kernel/isp/arch/hi3516cv300/firmware/vreg/arch/hi3516cv300/isp_reg_define.h` (GPL-3.0 repository, HiSilicon copyright, nManager-generated 2015-12-22 \"Define all registers/tables for Hi3519\"; local copy sources/openhisilicon), union `U_ISP_NDDM_TIMING`, struct offset 0x356E8 (GPL-3.0 repository; header offsets are ISP-core relative (data sheet offset - 0x20000), 632 of 775 data-sheet registers match it by name and offset (ISP_BLC_CFG is at 0x21100 in the data sheet and 0x1000+0x20000 in the header)). Reset value and access type unknown (modelled RW, no reset). Confidence: medium (vendor header for this chip family, not hardware verified).";

        field {
            name = "cpi_fix_timing_stat";
            desc = "[inferred] Cpi fix timing status. (vendor header `isp_reg_define.h` field `cpi_fix_timing_stat`; access and reset unknown, modelled RW)";
            sw = rw;
            hw = r;
        } cpi_fix_timing_stat[13:1];
    } ISP_NDDM_TIMING @ 0x356E8;

    reg {
        name = "ISP NDDM UPDATE";
        desc = "[inferred] ISP NDDM UPDATE. Not in the data sheet. Source: OpenIPC openhisilicon `kernel/isp/arch/hi3516cv300/firmware/vreg/arch/hi3516cv300/isp_reg_define.h` (GPL-3.0 repository, HiSilicon copyright, nManager-generated 2015-12-22 \"Define all registers/tables for Hi3519\"; local copy sources/openhisilicon), union `U_ISP_NDDM_UPDATE`, struct offset 0x356EC (GPL-3.0 repository; header offsets are ISP-core relative (data sheet offset - 0x20000), 632 of 775 data-sheet registers match it by name and offset (ISP_BLC_CFG is at 0x21100 in the data sheet and 0x1000+0x20000 in the header)). Reset value and access type unknown (modelled RW, no reset). Confidence: medium (vendor header for this chip family, not hardware verified).";

        field {
            name = "update";
            desc = "[inferred] Update. (vendor header `isp_reg_define.h` field `update`; access and reset unknown, modelled RW)";
            sw = rw;
            hw = r;
        } update[0:0];
    } ISP_NDDM_UPDATE @ 0x356EC;

    reg {
        name = "NDDM picture size register";
        desc = "ISP_NDDM_SIZE is an NDDM picture size register.

Data sheet 10.6 ISP_NDDM_SIZE (offset 0x456F0, printed page 10-380, `hi3516cv300--Hi3516CV300-Hi3516EV100-Datasheet.txt` line 62311).";

        field {
            name = "height";
            desc = "Picture height The configured value is the actual value minus 1. For example, if the actual height is 1920, set this field to 1919.";
            sw = rw;
            hw = r;
            reset = 0x437;
        } height[28:16];

        field {
            name = "width";
            desc = "Picture width The configured value is the actual value minus 1. For example, if the actual width is 1080, set this field to 1079.";
            sw = rw;
            hw = r;
            reset = 0x77F;
        } width[12:0];
    } ISP_NDDM_SIZE @ 0x356F0;

    reg {
        name = "Dehaze enable register";
        desc = "ISP_DEHAZE_CFG is a dehaze enable register. Hi3516C V300/Hi3516E V100 Professional HD IP Camera SoC

Data sheet 10.6 ISP_DEHAZE_CFG (offset 0x46700, printed page 10-381, `hi3516cv300--Hi3516CV300-Hi3516EV100-Datasheet.txt` line 62349).";

        enum ISP_DEHAZE_CFG_en_enum {
            DISABLED = 0 { name = "Disabled"; desc = "disabled"; };
            ENABLED = 1 { name = "Enabled"; desc = "enabled"; };
        };

        field {
            name = "en";
            desc = "Dehaze enable";
            sw = rw;
            hw = r;
            encode = ISP_DEHAZE_CFG_en_enum;
            reset = 0x0;
        } en[0:0];
    } ISP_DEHAZE_CFG @ 0x36700;

    reg {
        name = "ISP dehaze VERSION";
        desc = "[inferred] ISP dehaze VERSION. Not in the data sheet. Source: OpenIPC openhisilicon `kernel/isp/arch/hi3516cv300/firmware/vreg/arch/hi3516cv300/isp_reg_define.h` (GPL-3.0 repository, HiSilicon copyright, nManager-generated 2015-12-22 \"Define all registers/tables for Hi3519\"; local copy sources/openhisilicon), union `U_ISP_DEHAZE_VERSION`, struct offset 0x3670C (GPL-3.0 repository; header offsets are ISP-core relative (data sheet offset - 0x20000), 632 of 775 data-sheet registers match it by name and offset (ISP_BLC_CFG is at 0x21100 in the data sheet and 0x1000+0x20000 in the header)). Reset value and access type unknown (modelled RW, no reset). Confidence: medium (vendor header for this chip family, not hardware verified).";

        field {
            name = "version";
            desc = "[inferred] Version. (vendor header `isp_reg_define.h` field `version`; access and reset unknown, modelled RW)";
            sw = rw;
            hw = r;
        } version[31:0];
    } ISP_DEHAZE_VERSION @ 0x3670C;

    reg {
        name = "Dehaze statistical result update ATE register";
        desc = "ISP_DEHAZE_PRE_UPDATE is a dehaze statistical result update register.

Data sheet 10.6 ISP_DEHAZE_PRE_UPDATE (offset 0x46710, printed page 10-381, `hi3516cv300--Hi3516CV300-Hi3516EV100-Datasheet.txt` line 62371).";

        field {
            name = "pre_update";
            desc = "Dehaze statistical result update. This bit is automatically cleared for each frame.";
            sw = rw;
            hw = r;
            reset = 0x0;
        } pre_update[0:0];
    } ISP_DEHAZE_PRE_UPDATE @ 0x36710;

    reg {
        name = "Dehaze block size configuration register";
        desc = "ISP_DEHAZE_BLK_SIZE is a dehaze block size configuration register. Hi3516C V300/Hi3516E V100 Professional HD IP Camera SoC

Data sheet 10.6 ISP_DEHAZE_BLK_SIZE (offset 0x46714, printed page 10-382, `hi3516cv300--Hi3516CV300-Hi3516EV100-Datasheet.txt` line 62408).";

        field {
            name = "block_sizeh";
            desc = "Horizontal block size. The configured value is the actual value minus 1.";
            sw = rw;
            hw = r;
            reset = 0x0;
        } block_sizeh[24:16];

        field {
            name = "block_sizev";
            desc = "Vertical block size. The configured value is the actual value minus 1.";
            sw = rw;
            hw = r;
            reset = 0x0;
        } block_sizev[8:0];
    } ISP_DEHAZE_BLK_SIZE @ 0x36714;

    reg {
        name = "Dehaze block number register";
        desc = "ISP_DEHAZE_BLK_SUM is a dehaze block number register.

Data sheet 10.6 ISP_DEHAZE_BLK_SUM (offset 0x46718, printed page 10-382, `hi3516cv300--Hi3516CV300-Hi3516EV100-Datasheet.txt` line 62434).";

        field {
            name = "block_sum";
            desc = "Number of dehaze blocks. block_sum = Number of horizontal zones x (Number of vertical zones - 1)";
            sw = rw;
            hw = r;
            reset = 0x0;
        } block_sum[10:0];
    } ISP_DEHAZE_BLK_SUM @ 0x36718;

    reg {
        name = "Dehaze bilinear interpolation point quantity configuration register";
        desc = "ISP_DEHAZE_DC_SIZE is a dehaze bilinear interpolation point quantity configuration register. Hi3516C V300/Hi3516E V100 Professional HD IP Camera SoC

Data sheet 10.6 ISP_DEHAZE_DC_SIZE (offset 0x4671C, printed page 10-383, `hi3516cv300--Hi3516CV300-Hi3516EV100-Datasheet.txt` line 62466).";

        field {
            name = "dc_numh";
            desc = "Number of bilinear interpolation horizontal points. The configured value is the number of horizontal zones minus 1.";
            sw = rw;
            hw = r;
            reset = 0x0;
        } dc_numh[9:5];

        field {
            name = "dc_numv";
            desc = "Number of bilinear interpolation vertical points. The configured value is the number of vertical zones minus 1.";
            sw = rw;
            hw = r;
            reset = 0x0;
        } dc_numv[4:0];
    } ISP_DEHAZE_DC_SIZE @ 0x3671C;

    reg {
        name = "Configuration register for the horizontal phase difference between the pixels of the dehaze enlarged picture";
        desc = "ISP_DEHAZE_X is a configuration register for the horizontal phase difference between the pixels of the dehaze enlarged picture.

Data sheet 10.6 ISP_DEHAZE_X (offset 0x46720, printed page 10-383, `hi3516cv300--Hi3516CV300-Hi3516EV100-Datasheet.txt` line 62492).";

        field {
            name = "phase_x";
            desc = "Horizontal phase difference between the pixels of the enlarged picture (unsigned integer) phase_x = Size of the horizontal zone x (1<<22)";
            sw = rw;
            hw = r;
            reset = 0x0;
        } phase_x[23:0];
    } ISP_DEHAZE_X @ 0x36720;

    reg {
        name = "Configuration register for the vertical phase difference between the pixels of the dehaze enlarged picture";
        desc = "ISP_DEHAZE_Y is a configuration register for the vertical phase difference between the pixels of the dehaze enlarged picture. Hi3516C V300/Hi3516E V100 Professional HD IP Camera SoC

Data sheet 10.6 ISP_DEHAZE_Y (offset 0x46724, printed page 10-384, `hi3516cv300--Hi3516CV300-Hi3516EV100-Datasheet.txt` line 62524).";

        field {
            name = "phase_y";
            desc = "Vertical phase difference between the pixels of the enlarged picture (unsigned integer) phase_y = Size of the vertical zone x (1<<22)";
            sw = rw;
            hw = r;
            reset = 0x0;
        } phase_y[23:0];
    } ISP_DEHAZE_Y @ 0x36724;

    reg {
        name = "Dehaze statistics module control DE register";
        desc = "ISP_DEHAZE_STAT_MODE is a dehaze statistics module control register.

Data sheet 10.6 ISP_DEHAZE_STAT_MODE (offset 0x46728, printed page 10-384, `hi3516cv300--Hi3516CV300-Hi3516EV100-Datasheet.txt` line 62546).";

        enum ISP_DEHAZE_STAT_MODE_max_mode_enum {
            MEAN_FILTERING_PERFORMED = 0 { name = "Mean Filtering Performed"; desc = "Mean filtering is performed on RGB components, and then the RGB components corresponding to the maximum RGB sum of each window are counted."; };
            RGB_COMPONENTS_CORRESPONDING = 1 { name = "Rgb Components Corresponding"; desc = "The RGB components corresponding to the maximum RGB sum of each window are counted."; };
        };

        field {
            name = "max_mode";
            desc = "Maximum value statistics control";
            sw = rw;
            hw = r;
            encode = ISP_DEHAZE_STAT_MODE_max_mode_enum;
            reset = 0x0;
        } max_mode[0:0];
    } ISP_DEHAZE_STAT_MODE @ 0x36728;

    reg {
        name = "Dehaze inversion control register DE";
        desc = "ISP_DEHAZE_NEG_MODE is a dehaze inversion control register. Hi3516C V300/Hi3516E V100 Professional HD IP Camera SoC

Data sheet 10.6 ISP_DEHAZE_NEG_MODE (offset 0x4672C, printed page 10-385, `hi3516cv300--Hi3516CV300-Hi3516EV100-Datasheet.txt` line 62586).";

        enum ISP_DEHAZE_NEG_MODE_neg_mode_enum {
            NORMAL_MODE = 0 { name = "Normal Mode"; desc = "normal mode"; };
            INVERSION_MODE = 1 { name = "Inversion Mode"; desc = "inversion mode"; };
        };

        field {
            name = "neg_mode";
            desc = "Inversion mode control";
            sw = rw;
            hw = r;
            encode = ISP_DEHAZE_NEG_MODE_neg_mode_enum;
            reset = 0x0;
        } neg_mode[0:0];
    } ISP_DEHAZE_NEG_MODE @ 0x3672C;

    reg {
        name = "Dehaze airglow configuration register";
        desc = "ISP_DEHAZE_AIR is a dehaze airglow configuration register.

Data sheet 10.6 ISP_DEHAZE_AIR (offset 0x46730, printed page 10-385, `hi3516cv300--Hi3516CV300-Hi3516EV100-Datasheet.txt` line 62613).";

        field {
            name = "air_r";
            desc = "Airglow A corresponding to the R channel";
            sw = rw;
            hw = r;
            reset = 0x0;
        } air_r[29:20];

        field {
            name = "air_g";
            desc = "Airglow A corresponding to the G channel";
            sw = rw;
            hw = r;
            reset = 0x0;
        } air_g[19:10];

        field {
            name = "air_b";
            desc = "Airglow A corresponding to the B channel";
            sw = rw;
            hw = r;
            reset = 0x0;
        } air_b[9:0];
    } ISP_DEHAZE_AIR @ 0x36730;

    reg {
        name = "Dehaze T threshold coefficient configuration register";
        desc = "ISP_DEHAZE_THLD is a dehaze T threshold coefficient configuration register. Hi3516C V300/Hi3516E V100 Professional HD IP Camera SoC

Data sheet 10.6 ISP_DEHAZE_THLD (offset 0x46734, printed page 10-386, `hi3516cv300--Hi3516CV300-Hi3516EV100-Datasheet.txt` line 62648).";

        field {
            name = "thld";
            desc = "T threshold coefficient, unsigned integer";
            sw = rw;
            hw = r;
            reset = 0x0;
        } thld[9:0];
    } ISP_DEHAZE_THLD @ 0x36734;

    reg {
        name = "Dehaze global strength coefficient register";
        desc = "ISP_DEHAZE_GSTRTH is a dehaze global strength coefficient register.

Data sheet 10.6 ISP_DEHAZE_GSTRTH (offset 0x46738, printed page 10-386, `hi3516cv300--Hi3516CV300-Hi3516EV100-Datasheet.txt` line 62668).";

        field {
            name = "gstrth";
            desc = "G calculation coefficient, unsigned integer";
            sw = rw;
            hw = r;
            reset = 0x0;
        } gstrth[7:0];
    } ISP_DEHAZE_GSTRTH @ 0x36738;

    reg {
        name = "Dehaze minimum value filtering threshold coefficient configuration register";
        desc = "ISP_DEHAZE_BLTHLD is a dehaze minimum value filtering threshold coefficient configuration register.

Data sheet 10.6 ISP_DEHAZE_BLTHLD (offset 0x4673C, printed page 10-386, `hi3516cv300--Hi3516CV300-Hi3516EV100-Datasheet.txt` line 62688).";

        field {
            name = "blthld";
            desc = "Minimum value filtering threshold coefficient, unsigned integer";
            sw = rw;
            hw = r;
            reset = 0x0;
        } blthld[9:0];
    } ISP_DEHAZE_BLTHLD @ 0x3673C;

    reg {
        name = "Dehaze strength table update register _UPDATE";
        desc = "ISP_DEHAZE_STR_LUT_UPDATE is a dehaze strength table update register.

Data sheet 10.6 ISP_DEHAZE_STR_LUT_UPDATE (offset 0x46740, printed page 10-387, `hi3516cv300--Hi3516CV300-Hi3516EV100-Datasheet.txt` line 62717).";

        field {
            name = "str_lut_update";
            desc = "Update of the dehaze strength table configuration. This bit is automatically cleared for each frame.";
            sw = rw;
            hw = r;
            reset = 0x0;
        } str_lut_update[0:0];
    } ISP_DEHAZE_STR_LUT_UPDATE @ 0x36740;

    reg {
        name = "Dehaze minimum value statistics _WADDR write address register";
        desc = "ISP_DEHAZE_MINSTAT_WADDR is a dehaze minimum value statistics write address register.

Data sheet 10.6 ISP_DEHAZE_MINSTAT_WADDR (offset 0x46780, printed page 10-387, `hi3516cv300--Hi3516CV300-Hi3516EV100-Datasheet.txt` line 62746).";

        field {
            name = "minstat_waddr";
            desc = "Write address of the dehaze minimum value statistics. The value range is [0, 511].";
            sw = rw;
            hw = r;
            reset = 0x0;
        } minstat_waddr[8:0];
    } ISP_DEHAZE_MINSTAT_WADDR @ 0x36780;

    reg {
        name = "Dehaze minimum value statistics _WDATA write data register";
        desc = "ISP_DEHAZE_MINSTAT_WDATA is a dehaze minimum value statistics write data register. Hi3516C V300/Hi3516E V100 Professional HD IP Camera SoC

Data sheet 10.6 ISP_DEHAZE_MINSTAT_WDATA (offset 0x46784, printed page 10-388, `hi3516cv300--Hi3516CV300-Hi3516EV100-Datasheet.txt` line 62774).";

        field {
            name = "minstat_wdata_h";
            desc = "Write data of dehaze minimum value statistics, high block number";
            sw = rw;
            hw = r;
            reset = 0x0;
        } minstat_wdata_h[25:16];

        field {
            name = "minstat_wdata_l";
            desc = "Write data of dehaze minimum value statistics, low block number";
            sw = rw;
            hw = r;
            reset = 0x0;
        } minstat_wdata_l[9:0];
    } ISP_DEHAZE_MINSTAT_WDATA @ 0x36784;

    reg {
        name = "Dehaze minimum value statistics _RADDR read address register";
        desc = "ISP_DEHAZE_MINSTAT_RADDR is a dehaze minimum value statistics read address register.

Data sheet 10.6 ISP_DEHAZE_MINSTAT_RADDR (offset 0x46788, printed page 10-388, `hi3516cv300--Hi3516CV300-Hi3516EV100-Datasheet.txt` line 62797).";

        field {
            name = "minstat_raddr";
            desc = "Read address of dehaze minimum value statistics. The value range is [0, 511].";
            sw = rw;
            hw = r;
            reset = 0x0;
        } minstat_raddr[8:0];
    } ISP_DEHAZE_MINSTAT_RADDR @ 0x36788;

    reg {
        name = "Dehaze minimum value statistics _RDATA read data register";
        desc = "ISP_DEHAZE_MINSTAT_RDATA is a dehaze minimum value statistics read data register. Hi3516C V300/Hi3516E V100 Professional HD IP Camera SoC

Data sheet 10.6 ISP_DEHAZE_MINSTAT_RDATA (offset 0x4678C, printed page 10-389, `hi3516cv300--Hi3516CV300-Hi3516EV100-Datasheet.txt` line 62827).";

        field {
            name = "minstat_rdata_h";
            desc = "Read data of dehaze minimum value statistics, high block number";
            sw = r;
            hw = w;
            reset = 0x0;
        } minstat_rdata_h[25:16];

        field {
            name = "minstat_rdata_l";
            desc = "Read data of dehaze minimum value statistics, low block number";
            sw = r;
            hw = w;
            reset = 0x0;
        } minstat_rdata_l[9:0];
    } ISP_DEHAZE_MINSTAT_RDATA @ 0x3678C;

    reg {
        name = "Dehaze maximum value statistics T_WADDR write address register";
        desc = "ISP_DEHAZE_MAXSTAT_WADDR is a dehaze maximum value statistics write address register.

Data sheet 10.6 ISP_DEHAZE_MAXSTAT_WADDR (offset 0x46790, printed page 10-389, `hi3516cv300--Hi3516CV300-Hi3516EV100-Datasheet.txt` line 62850).";

        field {
            name = "maxstat_waddr";
            desc = "Write address of dehaze maximum value statistics. The value range is [0, 1023].";
            sw = rw;
            hw = r;
            reset = 0x0;
        } maxstat_waddr[9:0];
    } ISP_DEHAZE_MAXSTAT_WADDR @ 0x36790;

    reg {
        name = "Dehaze maximum value statistics T_WDATA write data register";
        desc = "ISP_DEHAZE_MAXSTAT_WDATA is a dehaze maximum value statistics write data register. Hi3516C V300/Hi3516E V100 Professional HD IP Camera SoC

Data sheet 10.6 ISP_DEHAZE_MAXSTAT_WDATA (offset 0x46794, printed page 10-390, `hi3516cv300--Hi3516CV300-Hi3516EV100-Datasheet.txt` line 62880).";

        field {
            name = "maxstat_wdata";
            desc = "Write data of dehaze maximum value statistics";
            sw = rw;
            hw = r;
            reset = 0x0;
        } maxstat_wdata[29:0];
    } ISP_DEHAZE_MAXSTAT_WDATA @ 0x36794;

    reg {
        name = "Dehaze maximum value statistics T_RADDR read address register";
        desc = "ISP_DEHAZE_MAXSTAT_RADDR is a dehaze maximum value statistics read address register.

Data sheet 10.6 ISP_DEHAZE_MAXSTAT_RADDR (offset 0x46798, printed page 10-390, `hi3516cv300--Hi3516CV300-Hi3516EV100-Datasheet.txt` line 62904).";

        field {
            name = "maxstat_raddr";
            desc = "Read address of dehaze maximum value statistics. The value range is [0, 1023].";
            sw = rw;
            hw = r;
            reset = 0x0;
        } maxstat_raddr[9:0];
    } ISP_DEHAZE_MAXSTAT_RADDR @ 0x36798;

    reg {
        name = "Dehaze maximum value statistics T_RDATA read data register";
        desc = "ISP_DEHAZE_MAXSTAT_RDATA is a dehaze maximum value statistics read data register. Hi3516C V300/Hi3516E V100 Professional HD IP Camera SoC

Data sheet 10.6 ISP_DEHAZE_MAXSTAT_RDATA (offset 0x4679C, printed page 10-391, `hi3516cv300--Hi3516CV300-Hi3516EV100-Datasheet.txt` line 62934).";

        field {
            name = "maxstat_rdata";
            desc = "Read data of dehaze maximum value statistics R: bit[29:20] G: bit[19:10] B: bit[9:0]";
            sw = r;
            hw = w;
            reset = 0x0;
        } maxstat_rdata[29:0];
    } ISP_DEHAZE_MAXSTAT_RDATA @ 0x3679C;

    reg {
        name = "Dehaze previous frame minimum _WADDR value statistics write address register";
        desc = "ISP_DEHAZE_PRESTAT_WADDR is a dehaze previous frame minimum value statistics write address register.

Data sheet 10.6 ISP_DEHAZE_PRESTAT_WADDR (offset 0x467A0, printed page 10-391, `hi3516cv300--Hi3516CV300-Hi3516EV100-Datasheet.txt` line 62960).";

        field {
            name = "prestat_waddr";
            desc = "Write address of dehaze previous frame minimum value statistics. The value range is [0, 511].";
            sw = rw;
            hw = r;
            reset = 0x0;
        } prestat_waddr[9:0];
    } ISP_DEHAZE_PRESTAT_WADDR @ 0x367A0;

    reg {
        name = "Dehaze previous frame minimum _WDATA value statistics write data register";
        desc = "ISP_DEHAZE_PRESTAT_WDATA is a dehaze previous frame minimum value statistics write data register. Hi3516C V300/Hi3516E V100 Professional HD IP Camera SoC

Data sheet 10.6 ISP_DEHAZE_PRESTAT_WDATA (offset 0x467A4, printed page 10-392, `hi3516cv300--Hi3516CV300-Hi3516EV100-Datasheet.txt` line 62991).";

        field {
            name = "prestat_wdata_h";
            desc = "Write data of dehaze previous frame minimum value statistics";
            sw = rw;
            hw = r;
            reset = 0x0;
        } prestat_wdata_h[25:16];

        field {
            name = "prestat_wdata_l";
            desc = "Write data of dehaze previous frame minimum value statistics";
            sw = rw;
            hw = r;
            reset = 0x0;
        } prestat_wdata_l[9:0];
    } ISP_DEHAZE_PRESTAT_WDATA @ 0x367A4;

    reg {
        name = "Dehaze previous frame minimum _RADDR value statistics read address register";
        desc = "ISP_DEHAZE_PRESTAT_RADDR is a dehaze previous frame minimum value statistics read address register.

Data sheet 10.6 ISP_DEHAZE_PRESTAT_RADDR (offset 0x467A8, printed page 10-392, `hi3516cv300--Hi3516CV300-Hi3516EV100-Datasheet.txt` line 63014).";

        field {
            name = "prestat_raddr";
            desc = "Read address of dehaze previous frame minimum value statistics. The value range is [0, 511].";
            sw = rw;
            hw = r;
            reset = 0x0;
        } prestat_raddr[9:0];
    } ISP_DEHAZE_PRESTAT_RADDR @ 0x367A8;

    reg {
        name = "Dehaze previous frame minimum _RDATA value statistics read data register";
        desc = "ISP_DEHAZE_PRESTAT_RDATA is a dehaze previous frame minimum value statistics read data register. Hi3516C V300/Hi3516E V100 Professional HD IP Camera SoC

Data sheet 10.6 ISP_DEHAZE_PRESTAT_RDATA (offset 0x467AC, printed page 10-393, `hi3516cv300--Hi3516CV300-Hi3516EV100-Datasheet.txt` line 63045).";

        field {
            name = "prestat_rdata_h";
            desc = "Read data of dehaze previous frame minimum value statistics, high block number";
            sw = r;
            hw = w;
            reset = 0x0;
        } prestat_rdata_h[25:16];

        field {
            name = "prestat_rdata_l";
            desc = "Read data of dehaze previous frame minimum value statistics, low block number";
            sw = r;
            hw = w;
            reset = 0x0;
        } prestat_rdata_l[9:0];
    } ISP_DEHAZE_PRESTAT_RDATA @ 0x367AC;

    reg {
        name = "Dehaze strength LUT information DDR write address register";
        desc = "ISP_DEHAZE_LUT_WADDR is a dehaze strength LUT information write address register.

Data sheet 10.6 ISP_DEHAZE_LUT_WADDR (offset 0x467B0, printed page 10-393, `hi3516cv300--Hi3516CV300-Hi3516EV100-Datasheet.txt` line 63071).";

        field {
            name = "lut_waddr";
            desc = "Write address of the dehaze strength LUT information. The value range is [0, 255].";
            sw = rw;
            hw = r;
            reset = 0x0;
        } lut_waddr[7:0];
    } ISP_DEHAZE_LUT_WADDR @ 0x367B0;

    reg {
        name = "Dehaze strength LUT information ATA write data register";
        desc = "ISP_DEHAZE_LUT_WDATA is a dehaze strength LUT information write data register. Hi3516C V300/Hi3516E V100 Professional HD IP Camera SoC

Data sheet 10.6 ISP_DEHAZE_LUT_WDATA (offset 0x467B4, printed page 10-394, `hi3516cv300--Hi3516CV300-Hi3516EV100-Datasheet.txt` line 63102).";

        field {
            name = "lut_wdata";
            desc = "Write data of the dehaze strength LUT information";
            sw = rw;
            hw = r;
            reset = 0x0;
        } lut_wdata[7:0];
    } ISP_DEHAZE_LUT_WDATA @ 0x367B4;

    reg {
        name = "Dehaze strength LUT information DR read address register";
        desc = "ISP_DEHAZE_LUT_RADDR is a dehaze strength LUT information read address register.

Data sheet 10.6 ISP_DEHAZE_LUT_RADDR (offset 0x467B8, printed page 10-394, `hi3516cv300--Hi3516CV300-Hi3516EV100-Datasheet.txt` line 63122).";

        field {
            name = "lut_raddr";
            desc = "Read address of the dehaze strength LUT information. The value range is [0, 255].";
            sw = rw;
            hw = r;
            reset = 0x0;
        } lut_raddr[7:0];
    } ISP_DEHAZE_LUT_RADDR @ 0x367B8;

    reg {
        name = "Dehaze strength LUT information TA read data register";
        desc = "ISP_DEHAZE_LUT_RDATA is a dehaze strength LUT information read data register.

Data sheet 10.6 ISP_DEHAZE_LUT_RDATA (offset 0x467BC, printed page 10-394, `hi3516cv300--Hi3516CV300-Hi3516EV100-Datasheet.txt` line 63143).";

        field {
            name = "lut_rdata";
            desc = "Read data of the dehaze strength LUT information";
            sw = r;
            hw = w;
            reset = 0x0;
        } lut_rdata[7:0];
    } ISP_DEHAZE_LUT_RDATA @ 0x367BC;

    reg {
        name = "ISP dehaze control I";
        desc = "[inferred] ISP dehaze control I. Not in the data sheet. Source: OpenIPC openhisilicon `kernel/isp/arch/hi3516cv300/firmware/vreg/arch/hi3516cv300/isp_reg_define.h` (GPL-3.0 repository, HiSilicon copyright, nManager-generated 2015-12-22 \"Define all registers/tables for Hi3519\"; local copy sources/openhisilicon), union `U_ISP_DEHAZE_CTRL_I`, struct offset 0x367E4 (GPL-3.0 repository; header offsets are ISP-core relative (data sheet offset - 0x20000), 632 of 775 data-sheet registers match it by name and offset (ISP_BLC_CFG is at 0x21100 in the data sheet and 0x1000+0x20000 in the header)). Reset value and access type unknown (modelled RW, no reset). Confidence: medium (vendor header for this chip family, not hardware verified).";

        field {
            name = "update_mode";
            desc = "[inferred] Update mode. (vendor header `isp_reg_define.h` field `update_mode`; access and reset unknown, modelled RW)";
            sw = rw;
            hw = r;
        } update_mode[0:0];
    } ISP_DEHAZE_CTRL_I @ 0x367E4;

    reg {
        name = "ISP dehaze UPDATE";
        desc = "[inferred] ISP dehaze UPDATE. Not in the data sheet. Source: OpenIPC openhisilicon `kernel/isp/arch/hi3516cv300/firmware/vreg/arch/hi3516cv300/isp_reg_define.h` (GPL-3.0 repository, HiSilicon copyright, nManager-generated 2015-12-22 \"Define all registers/tables for Hi3519\"; local copy sources/openhisilicon), union `U_ISP_DEHAZE_UPDATE`, struct offset 0x367EC (GPL-3.0 repository; header offsets are ISP-core relative (data sheet offset - 0x20000), 632 of 775 data-sheet registers match it by name and offset (ISP_BLC_CFG is at 0x21100 in the data sheet and 0x1000+0x20000 in the header)). Reset value and access type unknown (modelled RW, no reset). Confidence: medium (vendor header for this chip family, not hardware verified).";

        field {
            name = "newer";
            desc = "[inferred] Newer. (vendor header `isp_reg_define.h` field `newer`; access and reset unknown, modelled RW)";
            sw = rw;
            hw = r;
        } newer[0:0];
    } ISP_DEHAZE_UPDATE @ 0x367EC;

    reg {
        name = "Dehaze picture size register";
        desc = "ISP_DEHAZE_SIZE is a dehaze picture size register.

Data sheet 10.6 ISP_DEHAZE_SIZE (offset 0x467F0, printed page 10-395, `hi3516cv300--Hi3516CV300-Hi3516EV100-Datasheet.txt` line 63169).";

        field {
            name = "height";
            desc = "Window height (unit: row) The configured value is the actual value minus 1.";
            sw = rw;
            hw = r;
            reset = 0x437;
        } height[28:16];

        field {
            name = "width";
            desc = "Window width (unit: pixel) The configured value is the actual value minus 1.";
            sw = rw;
            hw = r;
            reset = 0x77F;
        } width[12:0];
    } ISP_DEHAZE_SIZE @ 0x367F0;

    reg {
        name = "Gamma control register";
        desc = "ISP_GAMMA_CFG is a gamma control register.

Data sheet 10.6 ISP_GAMMA_CFG (offset 0x46A00, printed page 10-395, `hi3516cv300--Hi3516CV300-Hi3516EV100-Datasheet.txt` line 63198).";

        enum ISP_GAMMA_CFG_en_enum {
            DISABLED = 0 { name = "Disabled"; desc = "disabled"; };
            ENABLED = 1 { name = "Enabled"; desc = "enabled"; };
        };

        field {
            name = "en";
            desc = "Gamma enable";
            sw = rw;
            hw = r;
            encode = ISP_GAMMA_CFG_en_enum;
            reset = 0x0;
        } en[0:0];
    } ISP_GAMMA_CFG @ 0x36A00;

    reg {
        name = "ISP gamma VERSION";
        desc = "[inferred] ISP gamma VERSION. Not in the data sheet. Source: OpenIPC openhisilicon `kernel/isp/arch/hi3516cv300/firmware/vreg/arch/hi3516cv300/isp_reg_define.h` (GPL-3.0 repository, HiSilicon copyright, nManager-generated 2015-12-22 \"Define all registers/tables for Hi3519\"; local copy sources/openhisilicon), union `U_ISP_GAMMA_VERSION`, struct offset 0x36A0C (GPL-3.0 repository; header offsets are ISP-core relative (data sheet offset - 0x20000), 632 of 775 data-sheet registers match it by name and offset (ISP_BLC_CFG is at 0x21100 in the data sheet and 0x1000+0x20000 in the header)). Reset value and access type unknown (modelled RW, no reset). Confidence: medium (vendor header for this chip family, not hardware verified).";

        field {
            name = "version";
            desc = "[inferred] Version. (vendor header `isp_reg_define.h` field `version`; access and reset unknown, modelled RW)";
            sw = rw;
            hw = r;
        } version[31:0];
    } ISP_GAMMA_VERSION @ 0x36A0C;

    reg {
        name = "Gamma LUT update register ATE";
        desc = "ISP_GAMMA_LUT_UPDATE is a gamma LUT update register. Hi3516C V300/Hi3516E V100 Professional HD IP Camera SoC

Data sheet 10.6 ISP_GAMMA_LUT_UPDATE (offset 0x46A10, printed page 10-396, `hi3516cv300--Hi3516CV300-Hi3516EV100-Datasheet.txt` line 63227).";

        field {
            name = "update";
            desc = "Gamma LUT update This bit is automatically cleared for each frame.";
            sw = rw;
            hw = r;
            reset = 0x0;
        } update[0:0];
    } ISP_GAMMA_LUT_UPDATE @ 0x36A10;

    reg {
        name = "Gamma LUT write address register";
        desc = "ISP_GAMMA_WADDR is a gamma LUT write address register.

Data sheet 10.6 ISP_GAMMA_WADDR (offset 0x46A80, printed page 10-396, `hi3516cv300--Hi3516CV300-Hi3516EV100-Datasheet.txt` line 63250).";

        field {
            name = "gamma_waddr";
            desc = "Write address of the gamma 257-entry LUT";
            sw = rw;
            hw = r;
            reset = 0x0;
        } gamma_waddr[31:0];
    } ISP_GAMMA_WADDR @ 0x36A80;

    reg {
        name = "Gamma LUT write data register";
        desc = "ISP_GAMMA_WDATA is a gamma LUT write data register.

Data sheet 10.6 ISP_GAMMA_WDATA (offset 0x46A84, printed page 10-396, `hi3516cv300--Hi3516CV300-Hi3516EV100-Datasheet.txt` line 63268).";

        field {
            name = "gamma_wdata";
            desc = "Write data of the gamma 257-entry LUT";
            sw = w;
            hw = r;
            reset = 0x0;
        } gamma_wdata[31:0];
    } ISP_GAMMA_WDATA @ 0x36A84;

    reg {
        name = "Gamma LUT read address register";
        desc = "ISP_GAMMA_RADDR is a gamma LUT read address register.

Data sheet 10.6 ISP_GAMMA_RADDR (offset 0x46A88, printed page 10-397, `hi3516cv300--Hi3516CV300-Hi3516EV100-Datasheet.txt` line 63293).";

        field {
            name = "gamma_raddr";
            desc = "Read address of the gamma 257-entry LUT";
            sw = rw;
            hw = r;
            reset = 0x0;
        } gamma_raddr[31:0];
    } ISP_GAMMA_RADDR @ 0x36A88;

    reg {
        name = "Gamma LUT read data register";
        desc = "ISP_GAMMA_RDATA is a gamma LUT read data register.

Data sheet 10.6 ISP_GAMMA_RDATA (offset 0x46A8C, printed page 10-397, `hi3516cv300--Hi3516CV300-Hi3516EV100-Datasheet.txt` line 63312).";

        field {
            name = "gamma_rdata";
            desc = "Read data of the gamma 257-entry LUT";
            sw = r;
            hw = w;
            reset = 0x0;
        } gamma_rdata[31:0];
    } ISP_GAMMA_RDATA @ 0x36A8C;

    reg {
        name = "ISP gamma control I";
        desc = "[inferred] ISP gamma control I. Not in the data sheet. Source: OpenIPC openhisilicon `kernel/isp/arch/hi3516cv300/firmware/vreg/arch/hi3516cv300/isp_reg_define.h` (GPL-3.0 repository, HiSilicon copyright, nManager-generated 2015-12-22 \"Define all registers/tables for Hi3519\"; local copy sources/openhisilicon), union `U_ISP_GAMMA_CTRL_I`, struct offset 0x36AE4 (GPL-3.0 repository; header offsets are ISP-core relative (data sheet offset - 0x20000), 632 of 775 data-sheet registers match it by name and offset (ISP_BLC_CFG is at 0x21100 in the data sheet and 0x1000+0x20000 in the header)). Reset value and access type unknown (modelled RW, no reset). Confidence: medium (vendor header for this chip family, not hardware verified).";

        field {
            name = "update_mode";
            desc = "[inferred] Update mode. (vendor header `isp_reg_define.h` field `update_mode`; access and reset unknown, modelled RW)";
            sw = rw;
            hw = r;
        } update_mode[0:0];
    } ISP_GAMMA_CTRL_I @ 0x36AE4;

    reg {
        name = "ISP gamma UPDATE";
        desc = "[inferred] ISP gamma UPDATE. Not in the data sheet. Source: OpenIPC openhisilicon `kernel/isp/arch/hi3516cv300/firmware/vreg/arch/hi3516cv300/isp_reg_define.h` (GPL-3.0 repository, HiSilicon copyright, nManager-generated 2015-12-22 \"Define all registers/tables for Hi3519\"; local copy sources/openhisilicon), union `U_ISP_GAMMA_UPDATE`, struct offset 0x36AEC (GPL-3.0 repository; header offsets are ISP-core relative (data sheet offset - 0x20000), 632 of 775 data-sheet registers match it by name and offset (ISP_BLC_CFG is at 0x21100 in the data sheet and 0x1000+0x20000 in the header)). Reset value and access type unknown (modelled RW, no reset). Confidence: medium (vendor header for this chip family, not hardware verified).";

        field {
            name = "update";
            desc = "[inferred] Update. (vendor header `isp_reg_define.h` field `update`; access and reset unknown, modelled RW)";
            sw = rw;
            hw = r;
        } update[0:0];
    } ISP_GAMMA_UPDATE @ 0x36AEC;

    reg {
        name = "CA enable register";
        desc = "ISP_CA_CFG is a CA enable register.

Data sheet 10.6 ISP_CA_CFG (offset 0x47000, printed page 10-397, `hi3516cv300--Hi3516CV300-Hi3516EV100-Datasheet.txt` line 63330).";

        enum ISP_CA_CFG_en_enum {
            DISABLED = 0 { name = "Disabled"; desc = "disabled"; };
            ENABLED = 1 { name = "Enabled"; desc = "enabled"; };
        };

        field {
            name = "en";
            desc = "CA enable (U1)";
            sw = rw;
            hw = r;
            encode = ISP_CA_CFG_en_enum;
            reset = 0x0;
        } en[0:0];
    } ISP_CA_CFG @ 0x37000;

    reg {
        name = "CA control register";
        desc = "ISP_CA_CTRL is a CA control register.

Data sheet 10.6 ISP_CA_CTRL (offset 0x47010, printed page 10-398, `hi3516cv300--Hi3516CV300-Hi3516EV100-Datasheet.txt` line 63362).";

        enum ISP_CA_CTRL_llhcproc_en_enum {
            DISABLED = 0 { name = "Disabled"; desc = "disabled"; };
            ENABLED = 1 { name = "Enabled"; desc = "enabled"; };
        };

        field {
            name = "llhcproc_en";
            desc = "Dark high-saturation region protection enable (U1)";
            sw = rw;
            hw = r;
            encode = ISP_CA_CTRL_llhcproc_en_enum;
            reset = 0x1;
        } llhcproc_en[24:24];

        enum ISP_CA_CTRL_skinproc_en_enum {
            DISABLED = 0 { name = "Disabled"; desc = "disabled"; };
            ENABLED = 1 { name = "Enabled"; desc = "enabled"; };
        };

        field {
            name = "skinproc_en";
            desc = "Complexion protection enable (U1)";
            sw = rw;
            hw = r;
            encode = ISP_CA_CTRL_skinproc_en_enum;
            reset = 0x1;
        } skinproc_en[16:16];

        enum ISP_CA_CTRL_colorproc_en_enum {
            DISABLED = 0 { name = "Disabled"; desc = "disabled"; };
            ENABLED = 1 { name = "Enabled"; desc = "enabled"; };
        };

        field {
            name = "colorproc_en";
            desc = "Color protection enable (U1)";
            sw = rw;
            hw = r;
            encode = ISP_CA_CTRL_colorproc_en_enum;
            reset = 0x0;
        } colorproc_en[8:8];

        enum ISP_CA_CTRL_satadj_en_enum {
            DISABLED = 0 { name = "Disabled"; desc = "disabled"; };
            ENABLED = 1 { name = "Enabled"; desc = "enabled"; };
        };

        field {
            name = "satadj_en";
            desc = "Saturation adjustment enable (U1)";
            sw = rw;
            hw = r;
            encode = ISP_CA_CTRL_satadj_en_enum;
            reset = 0x1;
        } satadj_en[0:0];
    } ISP_CA_CTRL @ 0x37010;

    reg {
        name = "Luminance threshold register";
        desc = "ISP_CA_LUMATH is a luminance threshold register.

Data sheet 10.6 ISP_CA_LUMATH (offset 0x47014, printed page 10-399, `hi3516cv300--Hi3516CV300-Hi3516EV100-Datasheet.txt` line 63409).";

        field {
            name = "lumath_low";
            desc = "Low threshold of the luminance (U10)";
            sw = rw;
            hw = r;
            reset = 0xFA;
        } lumath_low[25:16];

        field {
            name = "lumath_high";
            desc = "High threshold of the luminance (U10)";
            sw = rw;
            hw = r;
            reset = 0x190;
        } lumath_high[9:0];
    } ISP_CA_LUMATH @ 0x37014;

    reg {
        name = "Dark region chrominance threshold _TH register";
        desc = "ISP_CA_DARKCHROMA_TH is a dark region chrominance threshold register.

Data sheet 10.6 ISP_CA_DARKCHROMA_TH (offset 0x47018, printed page 10-399, `hi3516cv300--Hi3516CV300-Hi3516EV100-Datasheet.txt` line 63431).";

        field {
            name = "darkchromath_low";
            desc = "Low threshold of the dark region chrominance (U10)";
            sw = rw;
            hw = r;
            reset = 0x21C;
        } darkchromath_low[25:16];

        field {
            name = "darkchromath_high";
            desc = "High threshold of the dark region chrominance (U10)";
            sw = rw;
            hw = r;
            reset = 0x228;
        } darkchromath_high[9:0];
    } ISP_CA_DARKCHROMA_TH @ 0x37018;

    reg {
        name = "Bright and dark transition region A_TH chrominance threshold register";
        desc = "ISP_CA_SDARKCHROMA_TH is a bright and dark transition region chrominance threshold register. Hi3516C V300/Hi3516E V100 Professional HD IP Camera SoC

Data sheet 10.6 ISP_CA_SDARKCHROMA_TH (offset 0x4701C, printed page 10-400, `hi3516cv300--Hi3516CV300-Hi3516EV100-Datasheet.txt` line 63462).";

        field {
            name = "sdarkchromath_low";
            desc = "Low threshold of chrominance in the bright and dark transition region (U10)";
            sw = rw;
            hw = r;
            reset = 0x21C;
        } sdarkchromath_low[25:16];

        field {
            name = "sdarkchromath_high";
            desc = "High threshold of chrominance in the bright and dark transition region (U10)";
            sw = rw;
            hw = r;
            reset = 0x230;
        } sdarkchromath_high[9:0];
    } ISP_CA_SDARKCHROMA_TH @ 0x3701C;

    reg {
        name = "Low luminance high saturation region gain register";
        desc = "ISP_CA_LLHC_RATIO is a low luminance and high saturation region gain register.

Data sheet 10.6 ISP_CA_LLHC_RATIO (offset 0x47020, printed page 10-400, `hi3516cv300--Hi3516CV300-Hi3516EV100-Datasheet.txt` line 63488).";

        field {
            name = "lumaratio_low";
            desc = "Gain of the dark high-chrominance region (U10)";
            sw = rw;
            hw = r;
            reset = 0x320;
        } lumaratio_low[26:16];

        field {
            name = "lumaratio_high";
            desc = "Gain of the bright high-chrominance region (U10)";
            sw = rw;
            hw = r;
            reset = 0x2C4;
        } lumaratio_high[10:0];
    } ISP_CA_LLHC_RATIO @ 0x37020;

    reg {
        name = "ISO gain register";
        desc = "ISP_CA_ISORATIO is an ISO gain register. Hi3516C V300/Hi3516E V100 Professional HD IP Camera SoC

Data sheet 10.6 ISP_CA_ISORATIO (offset 0x47024, printed page 10-401, `hi3516cv300--Hi3516CV300-Hi3516EV100-Datasheet.txt` line 63519).";

        field {
            name = "isoratio";
            desc = "ISO gain of the chrominance component (U10)";
            sw = rw;
            hw = r;
            reset = 0x578;
        } isoratio[10:0];
    } ISP_CA_ISORATIO @ 0x37024;

    reg {
        name = "LUT update register";
        desc = "ISP_CA_LUT_UPDATE is an LUT update register.

Data sheet 10.6 ISP_CA_LUT_UPDATE (offset 0x47028, printed page 10-401, `hi3516cv300--Hi3516CV300-Hi3516EV100-Datasheet.txt` line 63539).";

        field {
            name = "lut_update";
            desc = "LUT update control (U10). This bit is automatically cleared for each frame.";
            sw = rw;
            hw = r;
            reset = 0x0;
        } lut_update[0:0];
    } ISP_CA_LUT_UPDATE @ 0x37028;

    reg {
        name = "YUV-to-RGB conversion coefficient F0 register 0";
        desc = "ISP_CA_YUV2RGB_COEF0 is a YUV-to-RGB conversion coefficient register 0. Hi3516C V300/Hi3516E V100 Professional HD IP Camera SoC

Data sheet 10.6 ISP_CA_YUV2RGB_COEF0 (offset 0x4702C, printed page 10-402, `hi3516cv300--Hi3516CV300-Hi3516EV100-Datasheet.txt` line 63576).";

        field {
            name = "yuv2rgb_coef00";
            desc = "YUV-to-RGB conversion coefficient 00 (S5.10)";
            sw = rw;
            hw = r;
            reset = 0x400;
        } yuv2rgb_coef00[30:16];

        field {
            name = "yuv2rgb_coef01";
            desc = "YUV-to-RGB conversion coefficient 01 (S5.10)";
            sw = rw;
            hw = r;
            reset = 0x0;
        } yuv2rgb_coef01[14:0];
    } ISP_CA_YUV2RGB_COEF0 @ 0x3702C;

    reg {
        name = "YUV-to-RGB conversion coefficient F1 register 1";
        desc = "ISP_CA_YUV2RGB_COEF1 is YUV-to-RGB conversion coefficient register 1.

Data sheet 10.6 ISP_CA_YUV2RGB_COEF1 (offset 0x47030, printed page 10-402, `hi3516cv300--Hi3516CV300-Hi3516EV100-Datasheet.txt` line 63601).";

        field {
            name = "yuv2rgb_coef02";
            desc = "YUV-to-RGB conversion coefficient 02 (S5.10)";
            sw = rw;
            hw = r;
            reset = 0x64C;
        } yuv2rgb_coef02[30:16];

        field {
            name = "yuv2rgb_coef10";
            desc = "YUV-to-RGB conversion coefficient 10 (S5.10)";
            sw = rw;
            hw = r;
            reset = 0x400;
        } yuv2rgb_coef10[14:0];
    } ISP_CA_YUV2RGB_COEF1 @ 0x37030;

    reg {
        name = "YUV-to-RGB conversion coefficient F2 register 2";
        desc = "ISP_CA_YUV2RGB_COEF2 is YUV-to-RGB conversion coefficient register 2. Hi3516C V300/Hi3516E V100 Professional HD IP Camera SoC

Data sheet 10.6 ISP_CA_YUV2RGB_COEF2 (offset 0x47034, printed page 10-403, `hi3516cv300--Hi3516CV300-Hi3516EV100-Datasheet.txt` line 63636).";

        field {
            name = "yuv2rgb_coef11";
            desc = "YUV-to-RGB conversion coefficient 11 (S5.10)";
            sw = rw;
            hw = r;
            reset = 0x7F41;
        } yuv2rgb_coef11[30:16];

        field {
            name = "yuv2rgb_coef12";
            desc = "YUV-to-RGB conversion coefficient 12 (S5.10)";
            sw = rw;
            hw = r;
            reset = 0x7E21;
        } yuv2rgb_coef12[14:0];
    } ISP_CA_YUV2RGB_COEF2 @ 0x37034;

    reg {
        name = "YUV-to-RGB conversion coefficient F3 register 3";
        desc = "ISP_CA_YUV2RGB_COEF3 is YUV-to-RGB conversion coefficient register 3.

Data sheet 10.6 ISP_CA_YUV2RGB_COEF3 (offset 0x47038, printed page 10-403, `hi3516cv300--Hi3516CV300-Hi3516EV100-Datasheet.txt` line 63661).";

        field {
            name = "yuv2rgb_coef20";
            desc = "YUV-to-RGB conversion coefficient 20 (S5.10)";
            sw = rw;
            hw = r;
            reset = 0x400;
        } yuv2rgb_coef20[30:16];

        field {
            name = "yuv2rgb_coef21";
            desc = "YUV-to-RGB conversion coefficient 21 (S5.10)";
            sw = rw;
            hw = r;
            reset = 0x76C;
        } yuv2rgb_coef21[14:0];
    } ISP_CA_YUV2RGB_COEF3 @ 0x37038;

    reg {
        name = "YUV-to-RGB conversion coefficient F4 register 4";
        desc = "ISP_CA_YUV2RGB_COEF4 is YUV-to-RGB conversion coefficient register 4. Hi3516C V300/Hi3516E V100 Professional HD IP Camera SoC

Data sheet 10.6 ISP_CA_YUV2RGB_COEF4 (offset 0x4703C, printed page 10-404, `hi3516cv300--Hi3516CV300-Hi3516EV100-Datasheet.txt` line 63696).";

        field {
            name = "yuv2rgb_coef22";
            desc = "YUV-to-RGB conversion coefficient 22 (S5.10)";
            sw = rw;
            hw = r;
            reset = 0x0;
        } yuv2rgb_coef22[14:0];
    } ISP_CA_YUV2RGB_COEF4 @ 0x3703C;

    reg {
        name = "YUV-to-RGB conversion input C0 offset register 0";
        desc = "ISP_CA_YUV2RGB_INDC0 is YUV-to-RGB conversion input offset register 0

Data sheet 10.6 ISP_CA_YUV2RGB_INDC0 (offset 0x47040, printed page 10-404, `hi3516cv300--Hi3516CV300-Hi3516EV100-Datasheet.txt` line 63716).";

        field {
            name = "yuv2rgb_indc0";
            desc = "Input offset 0 of YUV-to-RGB conversion (S11)";
            sw = rw;
            hw = r;
            reset = 0x0;
        } yuv2rgb_indc0[26:16];

        field {
            name = "yuv2rgb_indc1";
            desc = "Input offset 1 of YUV-to-RGB conversion (S11)";
            sw = rw;
            hw = r;
            reset = 0x600;
        } yuv2rgb_indc1[10:0];
    } ISP_CA_YUV2RGB_INDC0 @ 0x37040;

    reg {
        name = "YUV-to-RGB conversion input C1 offset register 1";
        desc = "ISP_CA_YUV2RGB_INDC1 is YUV-to-RGB conversion input offset register 1.

Data sheet 10.6 ISP_CA_YUV2RGB_INDC1 (offset 0x47044, printed page 10-404, `hi3516cv300--Hi3516CV300-Hi3516EV100-Datasheet.txt` line 63737).";

        field {
            name = "yuv2rgb_indc2";
            desc = "Input offset 2 of YUV-to-RGB conversion (S11)";
            sw = rw;
            hw = r;
            reset = 0x600;
        } yuv2rgb_indc2[10:0];
    } ISP_CA_YUV2RGB_INDC1 @ 0x37044;

    reg {
        name = "YUV-to-RGB conversion output DC0 offset register 0";
        desc = "ISP_CA_YUV2RGB_OUTDC0 is YUV-to-RGB conversion output offset register 0.

Data sheet 10.6 ISP_CA_YUV2RGB_OUTDC0 (offset 0x47048, printed page 10-405, `hi3516cv300--Hi3516CV300-Hi3516EV100-Datasheet.txt` line 63766).";

        field {
            name = "yuv2rgb_outdc0";
            desc = "Output offset 0 of YUV-to-RGB conversion (S11)";
            sw = rw;
            hw = r;
            reset = 0x0;
        } yuv2rgb_outdc0[26:16];

        field {
            name = "yuv2rgb_outdc1";
            desc = "Output offset 1 of YUV-to-RGB conversion (S11)";
            sw = rw;
            hw = r;
            reset = 0x0;
        } yuv2rgb_outdc1[10:0];
    } ISP_CA_YUV2RGB_OUTDC0 @ 0x37048;

    reg {
        name = "YUV-to-RGB conversion output DC1 offset register 1";
        desc = "ISP_CA_YUV2RGB_OUTDC1 is YUV-to-RGB conversion output offset register 1.

Data sheet 10.6 ISP_CA_YUV2RGB_OUTDC1 (offset 0x4704C, printed page 10-405, `hi3516cv300--Hi3516CV300-Hi3516EV100-Datasheet.txt` line 63788).";

        field {
            name = "yuv2rgb_outdc2";
            desc = "Output offset 2 of YUV-to-RGB conversion (S11)";
            sw = rw;
            hw = r;
            reset = 0x0;
        } yuv2rgb_outdc2[10:0];
    } ISP_CA_YUV2RGB_OUTDC1 @ 0x3704C;

    reg {
        name = "RGB-to-YUV conversion coefficient F0 register 0";
        desc = "ISP_CA_RGB2YUV_COEF0 is RGB-to-YUV conversion coefficient register 0. Hi3516C V300/Hi3516E V100 Professional HD IP Camera SoC

Data sheet 10.6 ISP_CA_RGB2YUV_COEF0 (offset 0x47050, printed page 10-406, `hi3516cv300--Hi3516CV300-Hi3516EV100-Datasheet.txt` line 63817).";

        field {
            name = "rgb2yuv_coef00";
            desc = "RGB-to-YUV conversion coefficient 00 (S5.10)";
            sw = rw;
            hw = r;
            reset = 0xDA;
        } rgb2yuv_coef00[30:16];

        field {
            name = "rgb2yuv_coef01";
            desc = "RGB-to-YUV conversion coefficient 01 (S5.10)";
            sw = rw;
            hw = r;
            reset = 0x2DC;
        } rgb2yuv_coef01[14:0];
    } ISP_CA_RGB2YUV_COEF0 @ 0x37050;

    reg {
        name = "RGB-to-YUV conversion coefficient F1 register 1";
        desc = "ISP_CA_RGB2YUV_COEF1 is RGB-to-YUV conversion coefficient register 1.

Data sheet 10.6 ISP_CA_RGB2YUV_COEF1 (offset 0x47054, printed page 10-406, `hi3516cv300--Hi3516CV300-Hi3516EV100-Datasheet.txt` line 63842).";

        field {
            name = "rgb2yuv_coef02";
            desc = "RGB-to-YUV conversion coefficient 02 (S5.10)";
            sw = rw;
            hw = r;
            reset = 0x49;
        } rgb2yuv_coef02[30:16];

        field {
            name = "rgb2yuv_coef10";
            desc = "RGB-to-YUV conversion coefficient 10 (S5.10)";
            sw = rw;
            hw = r;
            reset = 0x7F89;
        } rgb2yuv_coef10[14:0];
    } ISP_CA_RGB2YUV_COEF1 @ 0x37054;

    reg {
        name = "RGB-to-YUV conversion coefficient F2 register 2";
        desc = "ISP_CA_RGB2YUV_COEF2 is RGB-to-YUV conversion coefficient register 2. Hi3516C V300/Hi3516E V100 Professional HD IP Camera SoC

Data sheet 10.6 ISP_CA_RGB2YUV_COEF2 (offset 0x47058, printed page 10-407, `hi3516cv300--Hi3516CV300-Hi3516EV100-Datasheet.txt` line 63877).";

        field {
            name = "rgb2yuv_coef11";
            desc = "RGB-to-YUV conversion coefficient 11 (S5.10)";
            sw = rw;
            hw = r;
            reset = 0x7E6D;
        } rgb2yuv_coef11[30:16];

        field {
            name = "rgb2yuv_coef12";
            desc = "RGB-to-YUV conversion coefficient 12 (S5.10)";
            sw = rw;
            hw = r;
            reset = 0x20B;
        } rgb2yuv_coef12[14:0];
    } ISP_CA_RGB2YUV_COEF2 @ 0x37058;

    reg {
        name = "RGB-to-YUV conversion coefficient F3 register 3";
        desc = "ISP_CA_RGB2YUV_COEF3 is RGB-to-YUV conversion coefficient register 3.

Data sheet 10.6 ISP_CA_RGB2YUV_COEF3 (offset 0x4705C, printed page 10-407, `hi3516cv300--Hi3516CV300-Hi3516EV100-Datasheet.txt` line 63902).";

        field {
            name = "rgb2yuv_coef20";
            desc = "RGB-to-YUV conversion coefficient 20 (S5.10)";
            sw = rw;
            hw = r;
            reset = 0x20B;
        } rgb2yuv_coef20[30:16];

        field {
            name = "rgb2yuv_coef21";
            desc = "RGB-to-YUV conversion coefficient 21 (S5.10)";
            sw = rw;
            hw = r;
            reset = 0x7E25;
        } rgb2yuv_coef21[14:0];
    } ISP_CA_RGB2YUV_COEF3 @ 0x3705C;

    reg {
        name = "RGB-to-YUV conversion coefficient F4 register 4";
        desc = "ISP_CA_RGB2YUV_COEF4 is RGB-to-YUV conversion coefficient register 4. Hi3516C V300/Hi3516E V100 Professional HD IP Camera SoC

Data sheet 10.6 ISP_CA_RGB2YUV_COEF4 (offset 0x47060, printed page 10-408, `hi3516cv300--Hi3516CV300-Hi3516EV100-Datasheet.txt` line 63937).";

        field {
            name = "rgb2yuv_coef22";
            desc = "RGB-to-YUV conversion coefficient 22 (S5.10)";
            sw = rw;
            hw = r;
            reset = 0x7FD0;
        } rgb2yuv_coef22[14:0];
    } ISP_CA_RGB2YUV_COEF4 @ 0x37060;

    reg {
        name = "RGB-to-YUV conversion input C0 offset register 0";
        desc = "ISP_CA_RGB2YUV_INDC0 is RGB-to-YUV conversion input offset register 0.

Data sheet 10.6 ISP_CA_RGB2YUV_INDC0 (offset 0x47064, printed page 10-408, `hi3516cv300--Hi3516CV300-Hi3516EV100-Datasheet.txt` line 63957).";

        field {
            name = "rgb2yuv_indc0";
            desc = "Input offset 0 of RGB-to-YUV conversion (S11)";
            sw = rw;
            hw = r;
            reset = 0x0;
        } rgb2yuv_indc0[26:16];

        field {
            name = "rgb2yuv_indc1";
            desc = "Input offset 1 of RGB-to-YUV conversion (S11)";
            sw = rw;
            hw = r;
            reset = 0x0;
        } rgb2yuv_indc1[10:0];
    } ISP_CA_RGB2YUV_INDC0 @ 0x37064;

    reg {
        name = "RGB-to-YUV conversion input C1 offset register 1";
        desc = "ISP_CA_RGB2YUV_INDC1 is RGB-to-YUV conversion input offset register 1.

Data sheet 10.6 ISP_CA_RGB2YUV_INDC1 (offset 0x47068, printed page 10-408, `hi3516cv300--Hi3516CV300-Hi3516EV100-Datasheet.txt` line 63978).";

        field {
            name = "rgb2yuv_indc2";
            desc = "Input offset 2 of RGB-to-YUV conversion (S11)";
            sw = rw;
            hw = r;
            reset = 0x0;
        } rgb2yuv_indc2[10:0];
    } ISP_CA_RGB2YUV_INDC1 @ 0x37068;

    reg {
        name = "RGB-to-YUV conversion output DC0 offset register 0";
        desc = "ISP_CA_RGB2YUV_OUTDC0 is RGB-to-YUV conversion output offset register 0.

Data sheet 10.6 ISP_CA_RGB2YUV_OUTDC0 (offset 0x4706C, printed page 10-409, `hi3516cv300--Hi3516CV300-Hi3516EV100-Datasheet.txt` line 64007).";

        field {
            name = "rgb2yuv_outdc0";
            desc = "Output offset 0 of RGB-to-YUV conversion (S11)";
            sw = rw;
            hw = r;
            reset = 0x0;
        } rgb2yuv_outdc0[26:16];

        field {
            name = "rgb2yuv_outdc1";
            desc = "Output offset 1 of RGB-to-YUV conversion (S11)";
            sw = rw;
            hw = r;
            reset = 0x200;
        } rgb2yuv_outdc1[10:0];
    } ISP_CA_RGB2YUV_OUTDC0 @ 0x3706C;

    reg {
        name = "RGB-to-YUV conversion output DC1 offset register 1";
        desc = "ISP_CA_RGB2YUV_OUTDC1 is RGB-to-YUV conversion output offset register 1.

Data sheet 10.6 ISP_CA_RGB2YUV_OUTDC1 (offset 0x47070, printed page 10-409, `hi3516cv300--Hi3516CV300-Hi3516EV100-Datasheet.txt` line 64029).";

        field {
            name = "rgb2yuv_outdc2";
            desc = "Input offset 2 of RGB-to-YUV conversion (S11)";
            sw = rw;
            hw = r;
            reset = 0x200;
        } rgb2yuv_outdc2[10:0];
    } ISP_CA_RGB2YUV_OUTDC1 @ 0x37070;

    reg {
        name = "Complexion judgment dark region U TH component threshold register";
        desc = "ISP_CA_SKINLLUMA_UTH is a complexion judgment dark region U component threshold register. Hi3516C V300/Hi3516E V100 Professional HD IP Camera SoC

Data sheet 10.6 ISP_CA_SKINLLUMA_UTH (offset 0x47074, printed page 10-410, `hi3516cv300--Hi3516CV300-Hi3516EV100-Datasheet.txt` line 64059).";

        field {
            name = "skinlluma_umin";
            desc = "Low threshold of the U component in the complexion judgment dark region (U10)";
            sw = rw;
            hw = r;
            reset = 0x1CC;
        } skinlluma_umin[25:16];

        field {
            name = "skinlluma_umax";
            desc = "High threshold of the U component in the complexion judgment dark region (U10)";
            sw = rw;
            hw = r;
            reset = 0x200;
        } skinlluma_umax[9:0];
    } ISP_CA_SKINLLUMA_UTH @ 0x37074;

    reg {
        name = "Complexion judgment dark region U YTH corresponding Y component threshold register";
        desc = "ISP_CA_SKINLLUMA_UYTH is a complexion judgment dark region U corresponding Y component threshold register.

Data sheet 10.6 ISP_CA_SKINLLUMA_UYTH (offset 0x47078, printed page 10-410, `hi3516cv300--Hi3516CV300-Hi3516EV100-Datasheet.txt` line 64086).";

        field {
            name = "skinlluma_uymin";
            desc = "Low threshold of the Y component corresponding to the U in the complexion judgment dark region (U10)";
            sw = rw;
            hw = r;
            reset = 0x40;
        } skinlluma_uymin[25:16];

        field {
            name = "skinlluma_uymax";
            desc = "High threshold of the Y component corresponding to the U in the complexion judgment dark region (U10)";
            sw = rw;
            hw = r;
            reset = 0x190;
        } skinlluma_uymax[9:0];
    } ISP_CA_SKINLLUMA_UYTH @ 0x37078;

    reg {
        name = "Complexion judgment bright region TH U component threshold register";
        desc = "ISP_CA_SKINHLUMA_UTH is a complexion judgment bright region U component threshold register. Hi3516C V300/Hi3516E V100 Professional HD IP Camera SoC

Data sheet 10.6 ISP_CA_SKINHLUMA_UTH (offset 0x4707C, printed page 10-411, `hi3516cv300--Hi3516CV300-Hi3516EV100-Datasheet.txt` line 64122).";

        field {
            name = "skinhluma_umin";
            desc = "Low threshold of the U component in the complexion judgment bright region (U10)";
            sw = rw;
            hw = r;
            reset = 0x180;
        } skinhluma_umin[25:16];

        field {
            name = "skinhluma_umax";
            desc = "High threshold of the U component in the complexion judgment bright region (U10)";
            sw = rw;
            hw = r;
            reset = 0x200;
        } skinhluma_umax[9:0];
    } ISP_CA_SKINHLUMA_UTH @ 0x3707C;

    reg {
        name = "Gain LUT write address register DDR";
        desc = "ISP_CA_GAINLUT_WADDR is a gain LUT write address register.

Data sheet 10.6 ISP_CA_GAINLUT_WADDR (offset 0x47080, printed page 10-411, `hi3516cv300--Hi3516CV300-Hi3516EV100-Datasheet.txt` line 64148).";

        field {
            name = "gainlut_waddr";
            desc = "Write address of the gain LUT (U7)";
            sw = rw;
            hw = r;
            reset = 0x0;
        } gainlut_waddr[6:0];
    } ISP_CA_GAINLUT_WADDR @ 0x37080;

    reg {
        name = "Gain LUT write data register ATA";
        desc = "ISP_CA_GAINLUT_WDATA is a gain LUT write data register. Hi3516C V300/Hi3516E V100 Professional HD IP Camera SoC

Data sheet 10.6 ISP_CA_GAINLUT_WDATA (offset 0x47084, printed page 10-412, `hi3516cv300--Hi3516CV300-Hi3516EV100-Datasheet.txt` line 64177).";

        field {
            name = "gainlut_wdata";
            desc = "Write data of the gain LUT (U11)";
            sw = rw;
            hw = r;
            reset = 0x0;
        } gainlut_wdata[10:0];
    } ISP_CA_GAINLUT_WDATA @ 0x37084;

    reg {
        name = "Gain LUT read address register DR";
        desc = "ISP_CA_GAINLUT_RADDR is a gain LUT read address register.

Data sheet 10.6 ISP_CA_GAINLUT_RADDR (offset 0x47088, printed page 10-412, `hi3516cv300--Hi3516CV300-Hi3516EV100-Datasheet.txt` line 64197).";

        field {
            name = "gainlut_raddr";
            desc = "Read address of the gain LUT (U7)";
            sw = rw;
            hw = r;
            reset = 0x0;
        } gainlut_raddr[6:0];
    } ISP_CA_GAINLUT_RADDR @ 0x37088;

    reg {
        name = "Gain LUT read data register TA";
        desc = "ISP_CA_GAINLUT_RDATA is a gain LUT read data register.

Data sheet 10.6 ISP_CA_GAINLUT_RDATA (offset 0x4708C, printed page 10-412, `hi3516cv300--Hi3516CV300-Hi3516EV100-Datasheet.txt` line 64216).";

        field {
            name = "gainlut_rdata";
            desc = "Read data of the gain LUT (U11)";
            sw = r;
            hw = w;
            reset = 0x0;
        } gainlut_rdata[10:0];
    } ISP_CA_GAINLUT_RDATA @ 0x3708C;

    reg {
        name = "Complexion judgment bright region YTH U corresponding Y component threshold register";
        desc = "ISP_CA_SKINHLUMA_UYTH is a complexion judgment bright region U corresponding Y component threshold register.

Data sheet 10.6 ISP_CA_SKINHLUMA_UYTH (offset 0x47110, printed page 10-413, `hi3516cv300--Hi3516CV300-Hi3516EV100-Datasheet.txt` line 64243).";

        field {
            name = "skinhluma_uymin";
            desc = "Low threshold of the Y component corresponding to the U in the complexion judgment bright region (U10)";
            sw = rw;
            hw = r;
            reset = 0x190;
        } skinhluma_uymin[25:16];

        field {
            name = "skinhluma_uymax";
            desc = "High threshold of the Y component corresponding to the U in the complexion judgment bright region (U10)";
            sw = rw;
            hw = r;
            reset = 0x3C0;
        } skinhluma_uymax[9:0];
    } ISP_CA_SKINHLUMA_UYTH @ 0x37110;

    reg {
        name = "Complexion judgment dark region V TH component threshold register";
        desc = "ISP_CA_SKINLLUMA_VTH is a complexion judgment dark region V component threshold register.

Data sheet 10.6 ISP_CA_SKINLLUMA_VTH (offset 0x47114, printed page 10-413, `hi3516cv300--Hi3516CV300-Hi3516EV100-Datasheet.txt` line 64269).";

        field {
            name = "skinlluma_vmin";
            desc = "Low threshold of the V component in the complexion judgment dark region (U10)";
            sw = rw;
            hw = r;
            reset = 0x208;
        } skinlluma_vmin[25:16];

        field {
            name = "skinlluma_vmax";
            desc = "High threshold of the V component in the complexion judgment dark region (U10)";
            sw = rw;
            hw = r;
            reset = 0x272;
        } skinlluma_vmax[9:0];
    } ISP_CA_SKINLLUMA_VTH @ 0x37114;

    reg {
        name = "Complexion judgment dark region V YTH corresponding Y component threshold register";
        desc = "ISP_CA_SKINLLUMA_VYTH is a complexion judgment dark region V corresponding Y component threshold register.

Data sheet 10.6 ISP_CA_SKINLLUMA_VYTH (offset 0x47118, printed page 10-414, `hi3516cv300--Hi3516CV300-Hi3516EV100-Datasheet.txt` line 64302).";

        field {
            name = "skinlluma_vymin";
            desc = "Low threshold of the Y component corresponding to the V in the complexion judgment dark region (U10)";
            sw = rw;
            hw = r;
            reset = 0x40;
        } skinlluma_vymin[25:16];

        field {
            name = "skinlluma_vymax";
            desc = "High threshold of the Y component corresponding to the V in the complexion judgment dark region (U10)";
            sw = rw;
            hw = r;
            reset = 0x190;
        } skinlluma_vymax[9:0];
    } ISP_CA_SKINLLUMA_VYTH @ 0x37118;

    reg {
        name = "Complexion judgment bright region TH V component threshold register";
        desc = "ISP_CA_SKINHLUMA_VTH is a complexion judgment bright region V component threshold register.

Data sheet 10.6 ISP_CA_SKINHLUMA_VTH (offset 0x4711C, printed page 10-414, `hi3516cv300--Hi3516CV300-Hi3516EV100-Datasheet.txt` line 64328).";

        field {
            name = "skinhluma_vmin";
            desc = "Low threshold of the V component in the complexion judgment bright region (U10)";
            sw = rw;
            hw = r;
            reset = 0x208;
        } skinhluma_vmin[25:16];

        field {
            name = "skinhluma_vmax";
            desc = "High threshold of the V component in the complexion judgment dark region (U10)";
            sw = rw;
            hw = r;
            reset = 0x272;
        } skinhluma_vmax[9:0];
    } ISP_CA_SKINHLUMA_VTH @ 0x3711C;

    reg {
        name = "Complexion judgment bright region YTH V corresponding Y component threshold register";
        desc = "ISP_CA_SKINHLUMA_VYTH is a complexion judgment bright region V corresponding Y component threshold register.

Data sheet 10.6 ISP_CA_SKINHLUMA_VYTH (offset 0x47120, printed page 10-415, `hi3516cv300--Hi3516CV300-Hi3516EV100-Datasheet.txt` line 64361).";

        field {
            name = "skinhluma_vymin";
            desc = "Low threshold of the Y component corresponding to the V in the complexion judgment bright region (U10)";
            sw = rw;
            hw = r;
            reset = 0x190;
        } skinhluma_vymin[25:16];

        field {
            name = "skinhluma_vymax";
            desc = "High threshold of the Y component corresponding to the V in the complexion judgment bright region (U10)";
            sw = rw;
            hw = r;
            reset = 0x33F;
        } skinhluma_vymax[9:0];
    } ISP_CA_SKINHLUMA_VYTH @ 0x37120;

    reg {
        name = "Complexion judgment UV component difference register";
        desc = "ISP_CA_SKIN_UVDIFF is a complexion judgment UV component difference register.

Data sheet 10.6 ISP_CA_SKIN_UVDIFF (offset 0x47124, printed page 10-415, `hi3516cv300--Hi3516CV300-Hi3516EV100-Datasheet.txt` line 64386).";

        field {
            name = "skin_uvdiff";
            desc = "UV difference threshold for complexion judgment (S11)";
            sw = rw;
            hw = r;
            reset = 0x28;
        } skin_uvdiff[10:0];
    } ISP_CA_SKIN_UVDIFF @ 0x37124;

    reg {
        name = "Complexion protection gain 0 threshold register 0";
        desc = "ISP_CA_SKIN_RATIOTH0 is complexion protection gain threshold register 0. Hi3516C V300/Hi3516E V100 Professional HD IP Camera SoC

Data sheet 10.6 ISP_CA_SKIN_RATIOTH0 (offset 0x47128, printed page 10-416, `hi3516cv300--Hi3516CV300-Hi3516EV100-Datasheet.txt` line 64415).";

        field {
            name = "skinratioth_low";
            desc = "Low threshold of the complexion protection gain (U12). The maximum value is 1024.";
            sw = rw;
            hw = r;
            reset = 0x384;
        } skinratioth_low[27:16];

        field {
            name = "skinratioth_mid";
            desc = "Medium threshold of the complexion protection gain (U12)";
            sw = rw;
            hw = r;
            reset = 0x514;
        } skinratioth_mid[11:0];
    } ISP_CA_SKIN_RATIOTH0 @ 0x37128;

    reg {
        name = "Complexion protection gain 1 threshold register 1";
        desc = "ISP_CA_SKIN_RATIOTH1 is complexion protection gain threshold register 1.

Data sheet 10.6 ISP_CA_SKIN_RATIOTH1 (offset 0x4712C, printed page 10-416, `hi3516cv300--Hi3516CV300-Hi3516EV100-Datasheet.txt` line 64439).";

        field {
            name = "skinratioth_high";
            desc = "High threshold of the complexion protection gain (U12)";
            sw = rw;
            hw = r;
            reset = 0x5DC;
        } skinratioth_high[11:0];
    } ISP_CA_SKIN_RATIOTH1 @ 0x3712C;

    reg {
        name = "Color judgment dark region U _UTH component threshold register";
        desc = "ISP_CA_COLORLLUMA_UTH is a color judgment dark region U component threshold register. Hi3516C V300/Hi3516E V100 Professional HD IP Camera SoC

Data sheet 10.6 ISP_CA_COLORLLUMA_UTH (offset 0x47130, printed page 10-417, `hi3516cv300--Hi3516CV300-Hi3516EV100-Datasheet.txt` line 64468).";

        field {
            name = "colorlluma_umin";
            desc = "Low threshold of the U component in the color judgment dark region (U10)";
            sw = rw;
            hw = r;
            reset = 0x0;
        } colorlluma_umin[25:16];

        field {
            name = "colorlluma_umax";
            desc = "High threshold of the U component in the color judgment dark region (U10)";
            sw = rw;
            hw = r;
            reset = 0x0;
        } colorlluma_umax[9:0];
    } ISP_CA_COLORLLUMA_UTH @ 0x37130;

    reg {
        name = "Color judgment dark region U _UYTH corresponding Y component threshold register";
        desc = "ISP_CA_COLORLLUMA_UYTH is a color judgment dark region U corresponding Y component threshold register.

Data sheet 10.6 ISP_CA_COLORLLUMA_UYTH (offset 0x47134, printed page 10-417, `hi3516cv300--Hi3516CV300-Hi3516EV100-Datasheet.txt` line 64495).";

        field {
            name = "colorlluma_uymin";
            desc = "Low threshold of the Y component corresponding to the U in the color judgment dark region (U10)";
            sw = rw;
            hw = r;
            reset = 0x0;
        } colorlluma_uymin[25:16];

        field {
            name = "colorlluma_uymax";
            desc = "High threshold of the Y component corresponding to the U in the color judgment dark region (U10)";
            sw = rw;
            hw = r;
            reset = 0x0;
        } colorlluma_uymax[9:0];
    } ISP_CA_COLORLLUMA_UYTH @ 0x37134;

    reg {
        name = "Color judgment bright region U _UTH component threshold register";
        desc = "ISP_CA_COLORHLUMA_UTH is a color judgment bright region U component threshold register. Hi3516C V300/Hi3516E V100 Professional HD IP Camera SoC

Data sheet 10.6 ISP_CA_COLORHLUMA_UTH (offset 0x47138, printed page 10-418, `hi3516cv300--Hi3516CV300-Hi3516EV100-Datasheet.txt` line 64531).";

        field {
            name = "colorhluma_umin";
            desc = "Low threshold of the U component in the color judgment bright region (U10)";
            sw = rw;
            hw = r;
            reset = 0x0;
        } colorhluma_umin[25:16];

        field {
            name = "colorhluma_umax";
            desc = "High threshold of the U component in the color judgment bright region (U10)";
            sw = rw;
            hw = r;
            reset = 0x0;
        } colorhluma_umax[9:0];
    } ISP_CA_COLORHLUMA_UTH @ 0x37138;

    reg {
        name = "Color judgment bright region U _UYTH corresponding Y component threshold register";
        desc = "ISP_CA_COLORHLUMA_UYTH is a color judgment bright region U corresponding Y component threshold register.

Data sheet 10.6 ISP_CA_COLORHLUMA_UYTH (offset 0x4713C, printed page 10-418, `hi3516cv300--Hi3516CV300-Hi3516EV100-Datasheet.txt` line 64558).";

        field {
            name = "colorhluma_uymin";
            desc = "Low threshold of the Y component corresponding to the U in the color judgment bright region (U10)";
            sw = rw;
            hw = r;
            reset = 0x0;
        } colorhluma_uymin[25:16];

        field {
            name = "colorhluma_uymax";
            desc = "High threshold of the Y component corresponding to the U in the color judgment bright region (U10)";
            sw = rw;
            hw = r;
            reset = 0x0;
        } colorhluma_uymax[9:0];
    } ISP_CA_COLORHLUMA_UYTH @ 0x3713C;

    reg {
        name = "Color judgment dark region V _VTH component threshold register";
        desc = "ISP_CA_COLORLLUMA_VTH is a color judgment dark region V component threshold register. Hi3516C V300/Hi3516E V100 Professional HD IP Camera SoC

Data sheet 10.6 ISP_CA_COLORLLUMA_VTH (offset 0x47140, printed page 10-419, `hi3516cv300--Hi3516CV300-Hi3516EV100-Datasheet.txt` line 64594).";

        field {
            name = "colorlluma_vmin";
            desc = "Low threshold of the V component in the color judgment dark region (U10)";
            sw = rw;
            hw = r;
            reset = 0x0;
        } colorlluma_vmin[25:16];

        field {
            name = "colorlluma_vmax";
            desc = "High threshold of the V component in the color judgment dark region (U10)";
            sw = rw;
            hw = r;
            reset = 0x0;
        } colorlluma_vmax[9:0];
    } ISP_CA_COLORLLUMA_VTH @ 0x37140;

    reg {
        name = "Color judgment dark region V _VYTH corresponding Y component threshold register";
        desc = "ISP_CA_COLORLLUMA_VYTH is a color judgment dark region V corresponding Y component threshold register.

Data sheet 10.6 ISP_CA_COLORLLUMA_VYTH (offset 0x47144, printed page 10-419, `hi3516cv300--Hi3516CV300-Hi3516EV100-Datasheet.txt` line 64621).";

        field {
            name = "colorlluma_vymin";
            desc = "Low threshold of the Y component corresponding to the V in the color judgment dark region (U10)";
            sw = rw;
            hw = r;
            reset = 0x0;
        } colorlluma_vymin[25:16];

        field {
            name = "colorlluma_vymax";
            desc = "High threshold of the Y component corresponding to the V in the color judgment dark region (U10)";
            sw = rw;
            hw = r;
            reset = 0x0;
        } colorlluma_vymax[9:0];
    } ISP_CA_COLORLLUMA_VYTH @ 0x37144;

    reg {
        name = "Color judgment bright region V _VTH component threshold register";
        desc = "ISP_CA_COLORHLUMA_VTH is a color judgment bright region V component threshold register. Hi3516C V300/Hi3516E V100 Professional HD IP Camera SoC

Data sheet 10.6 ISP_CA_COLORHLUMA_VTH (offset 0x47148, printed page 10-420, `hi3516cv300--Hi3516CV300-Hi3516EV100-Datasheet.txt` line 64657).";

        field {
            name = "colorhluma_vmin";
            desc = "Low threshold of the V component in the color judgment bright region (U10)";
            sw = rw;
            hw = r;
            reset = 0x0;
        } colorhluma_vmin[25:16];

        field {
            name = "colorhluma_vmax";
            desc = "High threshold of the V component in the color judgment bright region (U10)";
            sw = rw;
            hw = r;
            reset = 0x0;
        } colorhluma_vmax[9:0];
    } ISP_CA_COLORHLUMA_VTH @ 0x37148;

    reg {
        name = "Color judgment bright region V _VYTH corresponding Y component threshold register";
        desc = "ISP_CA_COLORHLUMA_VYTH is a color judgment bright region V corresponding Y component threshold register.

Data sheet 10.6 ISP_CA_COLORHLUMA_VYTH (offset 0x4714C, printed page 10-420, `hi3516cv300--Hi3516CV300-Hi3516EV100-Datasheet.txt` line 64684).";

        field {
            name = "colorhluma_vymin";
            desc = "Low threshold of the Y component corresponding to the V in the color judgment bright region (U10)";
            sw = rw;
            hw = r;
            reset = 0x0;
        } colorhluma_vymin[25:16];

        field {
            name = "colorhluma_vymax";
            desc = "High threshold of the Y component corresponding to the V in the color judgment bright region (U10)";
            sw = rw;
            hw = r;
            reset = 0x0;
        } colorhluma_vymax[9:0];
    } ISP_CA_COLORHLUMA_VYTH @ 0x3714C;

    reg {
        name = "Color judgment UV component F difference register";
        desc = "ISP_CA_COLOR_UVDIFF is a color judgment UV component difference register. Hi3516C V300/Hi3516E V100 Professional HD IP Camera SoC

Data sheet 10.6 ISP_CA_COLOR_UVDIFF (offset 0x47150, printed page 10-421, `hi3516cv300--Hi3516CV300-Hi3516EV100-Datasheet.txt` line 64719).";

        field {
            name = "color_uvdiff";
            desc = "UV difference threshold for color judgment (S11)";
            sw = rw;
            hw = r;
            reset = 0x0;
        } color_uvdiff[10:0];
    } ISP_CA_COLOR_UVDIFF @ 0x37150;

    reg {
        name = "Color protection gain threshold TH0 register 0";
        desc = "ISP_CA_COLOR_RATIOTH0 is color protection gain threshold register 0.

Data sheet 10.6 ISP_CA_COLOR_RATIOTH0 (offset 0x47154, printed page 10-421, `hi3516cv300--Hi3516CV300-Hi3516EV100-Datasheet.txt` line 64739).";

        field {
            name = "colorratioth_low";
            desc = "Low threshold of the color protection gain (U12). The maximum value is 1024.";
            sw = rw;
            hw = r;
            reset = 0x0;
        } colorratioth_low[27:16];

        field {
            name = "colorratioth_mid";
            desc = "Medium threshold of the color protection gain (U12)";
            sw = rw;
            hw = r;
            reset = 0x0;
        } colorratioth_mid[11:0];
    } ISP_CA_COLOR_RATIOTH0 @ 0x37154;

    reg {
        name = "Color protection gain threshold TH1 register 1";
        desc = "ISP_CA_COLOR_RATIOTH1 is color protection gain threshold register 1. Hi3516C V300/Hi3516E V100 Professional HD IP Camera SoC

Data sheet 10.6 ISP_CA_COLOR_RATIOTH1 (offset 0x47158, printed page 10-422, `hi3516cv300--Hi3516CV300-Hi3516EV100-Datasheet.txt` line 64771).";

        field {
            name = "colorratioth_high";
            desc = "High threshold of the color protection gain (U12)";
            sw = rw;
            hw = r;
            reset = 0x0;
        } colorratioth_high[11:0];
    } ISP_CA_COLOR_RATIOTH1 @ 0x37158;

    reg {
        name = "ISP colour adjust control I";
        desc = "[inferred] ISP colour adjust control I. Not in the data sheet. Source: OpenIPC openhisilicon `kernel/isp/arch/hi3516cv300/firmware/vreg/arch/hi3516cv300/isp_reg_define.h` (GPL-3.0 repository, HiSilicon copyright, nManager-generated 2015-12-22 \"Define all registers/tables for Hi3519\"; local copy sources/openhisilicon), union `U_ISP_CA_CTRL_I`, struct offset 0x371E4 (GPL-3.0 repository; header offsets are ISP-core relative (data sheet offset - 0x20000), 632 of 775 data-sheet registers match it by name and offset (ISP_BLC_CFG is at 0x21100 in the data sheet and 0x1000+0x20000 in the header)). Reset value and access type unknown (modelled RW, no reset). Confidence: medium (vendor header for this chip family, not hardware verified).";

        field {
            name = "update_mode";
            desc = "[inferred] Update mode. (vendor header `isp_reg_define.h` field `update_mode`; access and reset unknown, modelled RW)";
            sw = rw;
            hw = r;
        } update_mode[0:0];
    } ISP_CA_CTRL_I @ 0x371E4;

    reg {
        name = "ISP colour adjust UPDATE";
        desc = "[inferred] ISP colour adjust UPDATE. Not in the data sheet. Source: OpenIPC openhisilicon `kernel/isp/arch/hi3516cv300/firmware/vreg/arch/hi3516cv300/isp_reg_define.h` (GPL-3.0 repository, HiSilicon copyright, nManager-generated 2015-12-22 \"Define all registers/tables for Hi3519\"; local copy sources/openhisilicon), union `U_ISP_CA_UPDATE`, struct offset 0x371EC (GPL-3.0 repository; header offsets are ISP-core relative (data sheet offset - 0x20000), 632 of 775 data-sheet registers match it by name and offset (ISP_BLC_CFG is at 0x21100 in the data sheet and 0x1000+0x20000 in the header)). Reset value and access type unknown (modelled RW, no reset). Confidence: medium (vendor header for this chip family, not hardware verified).";

        field {
            name = "update";
            desc = "[inferred] Update. (vendor header `isp_reg_define.h` field `update`; access and reset unknown, modelled RW)";
            sw = rw;
            hw = r;
        } update[0:0];
    } ISP_CA_UPDATE @ 0x371EC;

    reg {
        name = "CA picture size register";
        desc = "ISP_CA_SIZE is a CA picture size register.

Data sheet 10.6 ISP_CA_SIZE (offset 0x471F0, printed page 10-422, `hi3516cv300--Hi3516CV300-Hi3516EV100-Datasheet.txt` line 64791).";

        field {
            name = "height";
            desc = "Picture height The configured value is the actual value minus 1. For example, if the actual height is 720, set this field to 719.";
            sw = rw;
            hw = r;
            reset = 0x2CF;
        } height[28:16];

        field {
            name = "width";
            desc = "Picture width The configured value is the actual value minus 1. For example, if the actual width is 1280, set this field to 1279.";
            sw = rw;
            hw = r;
            reset = 0x4FF;
        } width[12:0];
    } ISP_CA_SIZE @ 0x371F0;

    reg {
        name = "HLDC enable register";
        desc = "ISP_HLDC_CFG is an HLDC enable register. Hi3516C V300/Hi3516E V100 Professional HD IP Camera SoC

Data sheet 10.6 ISP_HLDC_CFG (offset 0x51300, printed page 10-423, `hi3516cv300--Hi3516CV300-Hi3516EV100-Datasheet.txt` line 64829).";

        enum ISP_HLDC_CFG_hldc_l_en_enum {
            DISABLED = 0 { name = "Disabled"; desc = "disabled"; };
            ENABLED = 1 { name = "Enabled"; desc = "enabled"; };
        };

        field {
            name = "hldc_l_en";
            desc = "HLDC luminance enable";
            sw = rw;
            hw = r;
            encode = ISP_HLDC_CFG_hldc_l_en_enum;
            reset = 0x0;
        } hldc_l_en[31:31];

        enum ISP_HLDC_CFG_hldc_c_en_enum {
            DISABLED = 0 { name = "Disabled"; desc = "disabled"; };
            ENABLED = 1 { name = "Enabled"; desc = "enabled"; };
        };

        field {
            name = "hldc_c_en";
            desc = "HLDC chrominance enable";
            sw = rw;
            hw = r;
            encode = ISP_HLDC_CFG_hldc_c_en_enum;
            reset = 0x0;
        } hldc_c_en[30:30];

        enum ISP_HLDC_CFG_hldc_in_b422_enum {
            YUV420 = 0 { name = "Yuv420"; desc = "yuv420"; };
            YUV422 = 1 { name = "Yuv422"; desc = "yuv422"; };
        };

        field {
            name = "hldc_in_b422";
            desc = "Format of data processed by the HLDC";
            sw = rw;
            hw = r;
            encode = ISP_HLDC_CFG_hldc_in_b422_enum;
            reset = 0x0;
        } hldc_in_b422[0:0];
    } ISP_HLDC_CFG @ 0x41300;

    reg {
        name = "HLDC luminance size configuration register";
        desc = "ISP_HLDC_SIZE is an HLDC luminance size configuration register.

Data sheet 10.6 ISP_HLDC_SIZE (offset 0x51310, printed page 10-423, `hi3516cv300--Hi3516CV300-Hi3516EV100-Datasheet.txt` line 64863).";

        field {
            name = "height";
            desc = "Height of a picture luminance column (in pixel). The configured value is the actual value minus 1.";
            sw = rw;
            hw = r;
            reset = 0x0;
        } height[28:16];

        field {
            name = "width";
            desc = "Width of a picture luminance row (in pixel). The configured value is the actual value minus 1.";
            sw = rw;
            hw = r;
            reset = 0x0;
        } width[12:0];
    } ISP_HLDC_SIZE @ 0x41310;

    reg {
        name = "HLDC center coordinate parameter register";
        desc = "ISP_HLDC_CENTER is an HLDC center coordinate parameter register.

Data sheet 10.6 ISP_HLDC_CENTER (offset 0x51320, printed page 10-424, `hi3516cv300--Hi3516CV300-Hi3516EV100-Datasheet.txt` line 64902).";

        field {
            name = "ldc_norcoef";
            desc = "Normalization parameter";
            sw = rw;
            hw = r;
            reset = 0x0;
        } ldc_norcoef[31:24];

        field {
            name = "ldc_y_center";
            desc = "Vertical central coordinate";
            sw = rw;
            hw = r;
            reset = 0x0;
        } ldc_y_center[23:12];

        field {
            name = "ldc_x_center";
            desc = "Horizontal central coordinate";
            sw = rw;
            hw = r;
            reset = 0x0;
        } ldc_x_center[11:0];
    } ISP_HLDC_CENTER @ 0x41320;

    reg {
        name = "HLDC configuration parameter register";
        desc = "ISP_HLDC_PARA is an HLDC configuration parameter register.

Data sheet 10.6 ISP_HLDC_PARA (offset 0x51324, printed page 10-424, `hi3516cv300--Hi3516CV300-Hi3516EV100-Datasheet.txt` line 64923).";

        enum ISP_HLDC_PARA_ldc_mode_enum {
            BARREL_MODE = 0 { name = "Barrel Mode"; desc = "barrel mode"; };
            PINCUSHION_MODE = 1 { name = "Pincushion Mode"; desc = "pincushion mode"; };
        };

        field {
            name = "ldc_mode";
            desc = "LDC mode";
            sw = rw;
            hw = r;
            encode = ISP_HLDC_PARA_ldc_mode_enum;
            reset = 0x0;
        } ldc_mode[23:23];

        enum ISP_HLDC_PARA_ldc_barrel_mode_enum {
            FORWARD = 0 { name = "Forward"; desc = "forward"; };
            REVERSE = 1 { name = "Reverse"; desc = "reverse"; };
        };

        field {
            name = "ldc_barrel_mode";
            desc = "LDC barrel mode";
            sw = rw;
            hw = r;
            encode = ISP_HLDC_PARA_ldc_barrel_mode_enum;
            reset = 0x0;
        } ldc_barrel_mode[22:22];

        field {
            name = "ldc_black_mode";
            desc = "[inferred] Ldc black mode. (bits reserved in the data sheet; vendor header `isp_reg_define.h` field `ldc_black_mode`; access and reset unknown, modelled RW)";
            sw = rw;
            hw = r;
        } ldc_black_mode[21:21];

        field {
            name = "shift_right";
            desc = "Number of right shift bits for the denominator";
            sw = rw;
            hw = r;
            reset = 0x0;
        } shift_right[20:16];

        field {
            name = "ratio";
            desc = "Distortion coefficient";
            sw = rw;
            hw = r;
            reset = 0x0;
        } ratio[15:7];

        field {
            name = "scale";
            desc = "Scaling ratio";
            sw = rw;
            hw = r;
            reset = 0x0;
        } scale[6:0];
    } ISP_HLDC_PARA @ 0x41324;

    reg {
        name = "ACM control register";
        desc = "ISP_ACM_CTRL is an ACM control register.

Data sheet 10.6 ISP_ACM_CTRL (offset 0x51400, printed page 10-425, `hi3516cv300--Hi3516CV300-Hi3516EV100-Datasheet.txt` line 64970).";

        enum ISP_ACM_CTRL_acm_en_enum {
            DISABLED = 0 { name = "Disabled"; desc = "disabled (data output bypassed)"; };
            ENABLED = 1 { name = "Enabled"; desc = "enabled (implementing luminance and contrast adjustment)"; };
        };

        field {
            name = "acm_en";
            desc = "ACM enable";
            sw = rw;
            hw = r;
            encode = ISP_ACM_CTRL_acm_en_enum;
            reset = 0x0;
        } acm_en[31:31];

        field {
            name = "acm_dbg_en";
            desc = "ACM debugging enable. When acm_dbg_en is valid, the original picture is displayed on the left part of the screen, and the picture processed by ABC is displayed on the right part of the screen.";
            sw = rw;
            hw = r;
            reset = 0x0;
        } acm_dbg_en[30:30];

        enum ISP_ACM_CTRL_acm_stretch_enum {
            Y_64_940 = 0 { name = "Y 64 940"; desc = "Y 64-940, C 64-960"; };
            Y_0_1023 = 1 { name = "Y 0 1023"; desc = "Y 0-1023, C 0-1023"; };
        };

        field {
            name = "acm_stretch";
            desc = "Input pixel range";
            sw = rw;
            hw = r;
            encode = ISP_ACM_CTRL_acm_stretch_enum;
            reset = 0x0;
        } acm_stretch[29:29];

        enum ISP_ACM_CTRL_acm_cliprange_enum {
            Y_64_940 = 0 { name = "Y 64 940"; desc = "Y 64-940, C 64-960"; };
            Y_0_1023 = 1 { name = "Y 0 1023"; desc = "Y 0-1023, C 0-1023"; };
        };

        field {
            name = "acm_cliprange";
            desc = "Output pixel range";
            sw = rw;
            hw = r;
            encode = ISP_ACM_CTRL_acm_cliprange_enum;
            reset = 0x0;
        } acm_cliprange[28:28];

        enum ISP_ACM_CTRL_acm_cliporwrap_enum {
            HUE_COMPONENT_WRAPPED = 0 { name = "Hue Component Wrapped"; desc = "The hue component is wrapped around to fall within [0, 1023]."; };
            HUE_COMPONENT_CLIPPED = 1 { name = "Hue Component Clipped"; desc = "The hue component is clipped to fall within [0, 1023]."; };
        };

        field {
            name = "acm_cliporwrap";
            desc = "Hue component value limit after ACM";
            sw = rw;
            hw = r;
            encode = ISP_ACM_CTRL_acm_cliporwrap_enum;
            reset = 0x0;
        } acm_cliporwrap[27:27];

        field {
            name = "ACM_dbg_pos";
            desc = "ACM debugging position";
            sw = rw;
            hw = r;
            reset = 0x0;
        } ACM_dbg_pos[22:10];

        enum ISP_ACM_CTRL_ACM_dbg_mode_enum {
            LEFT_PICTURE_ORIGINAL = 0 { name = "Left Picture Original"; desc = "The left picture is the original picture and the right picture is the one after ACM processing."; };
            RIGHT_PICTURE_ORIGINAL = 1 { name = "Right Picture Original"; desc = "The right picture is the original picture and the left picture is the one after ACM processing."; };
        };

        field {
            name = "ACM_dbg_mode";
            desc = "ACM debugging mode";
            sw = rw;
            hw = r;
            encode = ISP_ACM_CTRL_ACM_dbg_mode_enum;
            reset = 0x0;
        } ACM_dbg_mode[9:9];

        field {
            name = "acm_cbcrthr";
            desc = "ACM algorithm adjustment enable threshold. It is a 9-bit unsigned number and ranges from 0 to 255.";
            sw = rw;
            hw = r;
            reset = 0x0;
        } acm_cbcrthr[8:0];
    } ISP_ACM_CTRL @ 0x41400;

    reg {
        name = "ACM processed pixel change register";
        desc = "ISP_ACM_ADJ is an ACM processed pixel change register.

Data sheet 10.6 ISP_ACM_ADJ (offset 0x51404, printed page 10-426, `hi3516cv300--Hi3516CV300-Hi3516EV100-Datasheet.txt` line 65029).";

        field {
            name = "acm_gain0";
            desc = "Control coefficient of the luminance adjustment range. The value range is 0-512.";
            sw = rw;
            hw = r;
            reset = 0x0;
        } acm_gain0[29:20];

        field {
            name = "acm_gain1";
            desc = "Control coefficient of the hue adjustment range. The value range is 0-512.";
            sw = rw;
            hw = r;
            reset = 0x0;
        } acm_gain1[19:10];

        field {
            name = "acm_gain2";
            desc = "Control coefficient of the saturation adjustment range. The value range is 0-512.";
            sw = rw;
            hw = r;
            reset = 0x0;
        } acm_gain2[9:0];
    } ISP_ACM_ADJ @ 0x41404;

    reg {
        name = "ACM coefficient read enable register";
        desc = "ISP_ACM_PARA_REN is an ACM coefficient read enable register.

Data sheet 10.6 ISP_ACM_PARA_REN (offset 0x51408, printed page 10-427, `hi3516cv300--Hi3516CV300-Hi3516EV100-Datasheet.txt` line 65066).";

        field {
            name = "ACM_para_rd_en";
            desc = "ACM coefficient read enable";
            sw = rw;
            hw = r;
            reset = 0x0;
        } ACM_para_rd_en[0:0];
    } ISP_ACM_PARA_REN @ 0x41408;

    reg {
        name = "ACM coefficient read data register";
        desc = "ISP_ACM_PARA_DATA is an ACM coefficient read data register.

Data sheet 10.6 ISP_ACM_PARA_DATA (offset 0x5140C, printed page 10-427, `hi3516cv300--Hi3516CV300-Hi3516EV100-Datasheet.txt` line 65093).";

        field {
            name = "ACM_para_data";
            desc = "Read data of the ACM coefficient";
            sw = r;
            hw = w;
            reset = 0x0;
        } ACM_para_data[31:0];
    } ISP_ACM_PARA_DATA @ 0x4140C;

    reg {
        name = "ACM processing picture size register";
        desc = "ISP_ACM_SIZE is an ACM processing picture size register. Hi3516C V300/Hi3516E V100 Professional HD IP Camera SoC

Data sheet 10.6 ISP_ACM_SIZE (offset 0x51410, printed page 10-428, `hi3516cv300--Hi3516CV300-Hi3516EV100-Datasheet.txt` line 65120).";

        field {
            name = "height";
            desc = "Picture height (in pixel) The configured value is the actual value minus 1.";
            sw = rw;
            hw = r;
            reset = 0x0;
        } height[28:16];

        field {
            name = "width";
            desc = "Picture width (in pixel) The configured value is the actual value minus 1.";
            sw = rw;
            hw = r;
            reset = 0x0;
        } width[12:0];
    } ISP_ACM_SIZE @ 0x41410;

    reg {
        name = "ISP ACM PARA address";
        desc = "[inferred] ISP ACM PARA address. Not in the data sheet. Source: OpenIPC openhisilicon `kernel/isp/arch/hi3516cv300/firmware/vreg/arch/hi3516cv300/isp_reg_define.h` (GPL-3.0 repository, HiSilicon copyright, nManager-generated 2015-12-22 \"Define all registers/tables for Hi3519\"; local copy sources/openhisilicon), union `U_ISP_ACM_PARA_ADDR`, struct offset 0x41414 (GPL-3.0 repository; header offsets are ISP-core relative (data sheet offset - 0x20000), 632 of 775 data-sheet registers match it by name and offset (ISP_BLC_CFG is at 0x21100 in the data sheet and 0x1000+0x20000 in the header)). Reset value and access type unknown (modelled RW, no reset). Confidence: medium (vendor header for this chip family, not hardware verified).";

        field {
            name = "acm_para_addr";
            desc = "[inferred] ACM para address. (vendor header `isp_reg_define.h` field `acm_para_addr`; access and reset unknown, modelled RW)";
            sw = rw;
            hw = r;
        } acm_para_addr[31:0];
    } ISP_ACM_PARA_ADDR @ 0x41414;

    reg {
        name = "ACM coefficient configuration update register";
        desc = "ISP_ACM_PARA_UP is an ACM coefficient configuration update register.

Data sheet 10.6 ISP_ACM_PARA_UP (offset 0x51420, printed page 10-428, `hi3516cv300--Hi3516CV300-Hi3516EV100-Datasheet.txt` line 65149).";

        field {
            name = "para_up";
            desc = "Parameter update. This bit is automatically cleared for each frame.";
            sw = rw;
            hw = r;
            reset = 0x0;
        } para_up[0:0];
    } ISP_ACM_PARA_UP @ 0x41420;

    reg {
        name = "DCI control register";
        desc = "ISP_VPDCICTRL is a DCI control register. Hi3516C V300/Hi3516E V100 Professional HD IP Camera SoC

Data sheet 10.6 ISP_VPDCICTRL (offset 0x51C00, printed page 10-429, `hi3516cv300--Hi3516CV300-Hi3516EV100-Datasheet.txt` line 65180).";

        enum ISP_VPDCICTRL_dci_en_enum {
            DISABLED = 0 { name = "Disabled"; desc = "disabled (data output bypassed)"; };
            ENABLED = 1 { name = "Enabled"; desc = "enabled (implementing luminance and contrast adjustment)"; };
        };

        field {
            name = "dci_en";
            desc = "DCI enable";
            sw = rw;
            hw = r;
            encode = ISP_VPDCICTRL_dci_en_enum;
            reset = 0x0;
        } dci_en[31:31];

        enum ISP_VPDCICTRL_dci_dbg_en_enum {
            DISABLED = 0 { name = "Disabled"; desc = "disabled"; };
            ORIGINAL_PICTURE_DISPLAYED = 1 { name = "Original Picture Displayed"; desc = "The original picture is displayed on the left part of the screen, and the picture processed by the DCI is displayed on the right part of the screen."; };
        };

        field {
            name = "dci_dbg_en";
            desc = "DCI demo mode enable";
            sw = rw;
            hw = r;
            encode = ISP_VPDCICTRL_dci_dbg_en_enum;
            reset = 0x0;
        } dci_dbg_en[30:30];

        enum ISP_VPDCICTRL_dci_scene_flg_enum {
            DISABLED = 0 { name = "Disabled"; desc = "disabled"; };
            ENABLED = 1 { name = "Enabled"; desc = "enabled"; };
        };

        field {
            name = "dci_scene_flg";
            desc = "DCI scenario switch enable";
            sw = rw;
            hw = r;
            encode = ISP_VPDCICTRL_dci_scene_flg_enum;
            reset = 0x0;
        } dci_scene_flg[29:29];

        enum ISP_VPDCICTRL_dci_man_adj0_enum {
            AUTOMATIC_MODE_RESULT = 0 { name = "Automatic Mode Result"; desc = "automatic mode. The result calculated by hardware is used."; };
            MANUAL_MODE_RESULT = 1 { name = "Manual Mode Result"; desc = "manual mode. The result configured by software is used."; };
        };

        field {
            name = "dci_man_adj0";
            desc = "Adjustment mode of curve 0";
            sw = rw;
            hw = r;
            encode = ISP_VPDCICTRL_dci_man_adj0_enum;
            reset = 0x0;
        } dci_man_adj0[28:28];

        enum ISP_VPDCICTRL_dci_man_adj1_enum {
            AUTOMATIC_MODE_RESULT = 0 { name = "Automatic Mode Result"; desc = "automatic mode. The result calculated by hardware is used."; };
            MANUAL_MODE_RESULT = 1 { name = "Manual Mode Result"; desc = "manual mode. The result configured by software is used."; };
        };

        field {
            name = "dci_man_adj1";
            desc = "Adjustment mode of curve 1";
            sw = rw;
            hw = r;
            encode = ISP_VPDCICTRL_dci_man_adj1_enum;
            reset = 0x0;
        } dci_man_adj1[27:27];

        enum ISP_VPDCICTRL_dci_man_adj2_enum {
            AUTOMATIC_MODE_RESULT = 0 { name = "Automatic Mode Result"; desc = "automatic mode. The result calculated by hardware is used."; };
            MANUAL_MODE_RESULT = 1 { name = "Manual Mode Result"; desc = "manual mode. The result configured by software is used."; };
        };

        field {
            name = "dci_man_adj2";
            desc = "Adjustment mode of curve 2";
            sw = rw;
            hw = r;
            encode = ISP_VPDCICTRL_dci_man_adj2_enum;
            reset = 0x0;
        } dci_man_adj2[26:26];

        enum ISP_VPDCICTRL_dci_cbcrcmp_en_enum {
            DCI_ALGORITHM_DOES = 0 { name = "Dci Algorithm Does"; desc = "The DCI algorithm does not adjust the chrominance component."; };
            DCI_ALGORITHM_ADJUSTS = 1 { name = "Dci Algorithm Adjusts"; desc = "The DCI algorithm adjusts the chrominance component."; };
        };

        field {
            name = "dci_cbcrcmp_en";
            desc = "DCI chrominance compensation enable";
            sw = rw;
            hw = r;
            encode = ISP_VPDCICTRL_dci_cbcrcmp_en_enum;
            reset = 0x1;
        } dci_cbcrcmp_en[25:25];

        enum ISP_VPDCICTRL_dci_cbcrsta_en_enum {
            HISTOGRAM_STATISTICS_COLLECTED = 0 { name = "Histogram Statistics Collected"; desc = "Histogram statistics are collected only on the luminance component."; };
            HISTOGRAM_STATISTICS_COLLECTED_2 = 1 { name = "Histogram Statistics Collected 2"; desc = "Histogram statistics are collected on the weighted Y, Cb, and Cr components."; };
        };

        field {
            name = "dci_cbcrsta_en";
            desc = "Histogram statistics select";
            sw = rw;
            hw = r;
            encode = ISP_VPDCICTRL_dci_cbcrsta_en_enum;
            reset = 0x0;
        } dci_cbcrsta_en[24:24];

        enum ISP_VPDCICTRL_dci_in_range_enum {
            LIMITED_RANGE = 0 { name = "Limited Range"; desc = "limited range (Y ranges from 64 to 940 and C ranges from 64 to 960 for the input 10-bit pixel data)"; };
            FULL_RANGE = 1 { name = "Full Range"; desc = "full range (Y ranges from 0 to 1023 and C ranges from 0 to 1023 for the input 10-bit pixel data)"; };
        };

        field {
            name = "dci_in_range";
            desc = "Input range";
            sw = rw;
            hw = r;
            encode = ISP_VPDCICTRL_dci_in_range_enum;
            reset = 0x1;
        } dci_in_range[23:23];

        enum ISP_VPDCICTRL_dci_out_range_enum {
            LIMITED_RANGE = 0 { name = "Limited Range"; desc = "limited range (Y ranges from 64 to 940 and C ranges from 64 to 960 for the output 10-bit pixel data)"; };
            FULL_RANGE = 1 { name = "Full Range"; desc = "full range (Y ranges from 0 to 1023 and C ranges from 0 to 1023 for the output 10-bit pixel data)"; };
        };

        field {
            name = "dci_out_range";
            desc = "Output range";
            sw = rw;
            hw = r;
            encode = ISP_VPDCICTRL_dci_out_range_enum;
            reset = 0x1;
        } dci_out_range[22:22];

        enum ISP_VPDCICTRL_dci_shift_ctrl_enum {
            SHIFTED_RIGHTWARDS_6 = 0 { name = "Shifted Rightwards 6"; desc = "shifted rightwards by 6 bits"; };
            SHIFTED_RIGHTWARDS_7 = 1 { name = "Shifted Rightwards 7"; desc = "shifted rightwards by 7 bits"; };
            SHIFTED_RIGHTWARDS_8 = 2 { name = "Shifted Rightwards 8"; desc = "shifted rightwards by 8 bits"; };
            SHIFTED_RIGHTWARDS_9 = 3 { name = "Shifted Rightwards 9"; desc = "shifted rightwards by 9 bits"; };
        };

        field {
            name = "dci_shift_ctrl";
            desc = "DCI histogram statistics shift control";
            sw = rw;
            hw = r;
            encode = ISP_VPDCICTRL_dci_shift_ctrl_enum;
            reset = 0x2;
        } dci_shift_ctrl[21:20];

        enum ISP_VPDCICTRL_dci_histlpf_en_enum {
            DISABLED = 0 { name = "Disabled"; desc = "disabled"; };
            ENABLED = 1 { name = "Enabled"; desc = "enabled"; };
        };

        field {
            name = "dci_histlpf_en";
            desc = "Histogram low-pass filtering enable";
            sw = rw;
            hw = r;
            encode = ISP_VPDCICTRL_dci_histlpf_en_enum;
            reset = 0x0;
        } dci_histlpf_en[19:19];
    } ISP_VPDCICTRL @ 0x41C00;

    reg {
        name = "DCI algorithm horizontal adjustment region register";
        desc = "ISP_VPDCIHPOS is a DCI algorithm horizontal adjustment region register.

Data sheet 10.6 ISP_VPDCIHPOS (offset 0x51C04, printed page 10-430, `hi3516cv300--Hi3516CV300-Hi3516EV100-Datasheet.txt` line 65262).";

        field {
            name = "dci_hstart";
            desc = "Start value of the DCI algorithm horizontal active region";
            sw = rw;
            hw = r;
            reset = 0x0;
        } dci_hstart[31:20];

        field {
            name = "dci_hend";
            desc = "End value of the DCI algorithm horizontal active region";
            sw = rw;
            hw = r;
            reset = 0x780;
        } dci_hend[19:8];
    } ISP_VPDCIHPOS @ 0x41C04;

    reg {
        name = "DCI algorithm vertical adjustment region register";
        desc = "ISP_VPDCIVPOS is a DCI algorithm vertical adjustment region register.

Data sheet 10.6 ISP_VPDCIVPOS (offset 0x51C08, printed page 10-431, `hi3516cv300--Hi3516CV300-Hi3516EV100-Datasheet.txt` line 65288).";

        field {
            name = "dci_vstart";
            desc = "Start value of the DCI algorithm vertical active region";
            sw = rw;
            hw = r;
            reset = 0x0;
        } dci_vstart[31:20];

        field {
            name = "dci_vend";
            desc = "End value of the DCI algorithm vertical active region";
            sw = rw;
            hw = r;
            reset = 0x438;
        } dci_vend[19:8];
    } ISP_VPDCIVPOS @ 0x41C08;

    reg {
        name = "DCI histogram statistics weighted coefficient register";
        desc = "ISP_VPDCIHISBLD is a DCI histogram statistics weighted coefficient register.

Data sheet 10.6 ISP_VPDCIHISBLD (offset 0x51C0C, printed page 10-431, `hi3516cv300--Hi3516CV300-Hi3516EV100-Datasheet.txt` line 65309).";

        field {
            name = "dci_cbcrsta_y";
            desc = "Weighted coefficient of the Y component when histogram statistics are added. It is an 8-bit signed number and the most significant bit (MSB) is the sign bit.";
            sw = rw;
            hw = r;
            reset = 0x40;
        } dci_cbcrsta_y[31:24];

        field {
            name = "dci_cbcrsta_cb";
            desc = "Weighted coefficient of the Cb component when histogram statistics are added. It is an 8-bit signed number and the MSB is the sign bit.";
            sw = rw;
            hw = r;
            reset = 0x0;
        } dci_cbcrsta_cb[23:16];

        field {
            name = "dci_cbcrsta_cr";
            desc = "Weighted coefficient of the Cr component when histogram statistics are added. It is an 8-bit signed number and the MSB is the sign bit.";
            sw = rw;
            hw = r;
            reset = 0x0;
        } dci_cbcrsta_cr[15:8];
    } ISP_VPDCIHISBLD @ 0x41C0C;

    reg {
        name = "DCI histogram statistics offset register";
        desc = "ISP_VPDCIHISOFT is a DCI histogram statistics offset register. Hi3516C V300/Hi3516E V100 Professional HD IP Camera SoC

Data sheet 10.6 ISP_VPDCIHISOFT (offset 0x51C10, printed page 10-432, `hi3516cv300--Hi3516CV300-Hi3516EV100-Datasheet.txt` line 65345).";

        field {
            name = "dci_cbcrsta_oft";
            desc = "dci_cbcrsta_oft";
            sw = rw;
            hw = r;
            reset = 0x0;
        } dci_cbcrsta_oft[31:23];
    } ISP_VPDCIHISOFT @ 0x41C10;

    reg {
        name = "DCI histogram coring register";
        desc = "ISP_VPDCIHISCOR is a DCI histogram coring register.

Data sheet 10.6 ISP_VPDCIHISCOR (offset 0x51C14, printed page 10-432, `hi3516cv300--Hi3516CV300-Hi3516EV100-Datasheet.txt` line 65367).";

        field {
            name = "dci_histcor_thr0";
            desc = "Coring threshold for histogram 0";
            sw = rw;
            hw = r;
            reset = 0x3;
        } dci_histcor_thr0[31:24];

        field {
            name = "dci_histcor_thr1";
            desc = "Coring threshold for histogram 1";
            sw = rw;
            hw = r;
            reset = 0x3;
        } dci_histcor_thr1[23:16];

        field {
            name = "dci_histcor_thr2";
            desc = "Coring threshold for histogram 2";
            sw = rw;
            hw = r;
            reset = 0x3;
        } dci_histcor_thr2[15:8];
    } ISP_VPDCIHISCOR @ 0x41C14;

    reg {
        name = "DCI adjustment unit blend value register";
        desc = "ISP_VPDCIMERBLD is a DCI adjustment unit blend value register. Hi3516C V300/Hi3516E V100 Professional HD IP Camera SoC

Data sheet 10.6 ISP_VPDCIMERBLD (offset 0x51C18, printed page 10-433, `hi3516cv300--Hi3516CV300-Hi3516EV100-Datasheet.txt` line 65397).";

        field {
            name = "dci_metrc_abld0";
            desc = "Weighted alpha blend value of the current frame for metric 0";
            sw = rw;
            hw = r;
            reset = 0x11;
        } dci_metrc_abld0[31:26];

        field {
            name = "dci_metrc_abld1";
            desc = "Weighted alpha blend value of the current frame for metric 1";
            sw = rw;
            hw = r;
            reset = 0x11;
        } dci_metrc_abld1[25:20];

        field {
            name = "dci_metrc_abld2";
            desc = "Weighted alpha blend value of the current frame for metric 2";
            sw = rw;
            hw = r;
            reset = 0x11;
        } dci_metrc_abld2[19:14];

        field {
            name = "dci_hist_abld";
            desc = "Weighted alpha blend value of the current histogram and the previous histogram";
            sw = rw;
            hw = r;
            reset = 0x10;
        } dci_hist_abld[13:8];

        field {
            name = "dci_org_abld";
            desc = "Alpha blend value when the luminance component is adjusted";
            sw = rw;
            hw = r;
            reset = 0x12;
        } dci_org_abld[7:2];
    } ISP_VPDCIMERBLD @ 0x41C18;

    reg {
        name = "DCI manually configured curve weight register";
        desc = "ISP_VPDCIADJWGT is a DCI manually configured curve weight register.

Data sheet 10.6 ISP_VPDCIADJWGT (offset 0x51C1C, printed page 10-433, `hi3516cv300--Hi3516CV300-Hi3516EV100-Datasheet.txt` line 65425).";

        field {
            name = "dci_man_adjwgt0";
            desc = "Weighted value of curve 0 in manual mode";
            sw = rw;
            hw = r;
            reset = 0xC8;
        } dci_man_adjwgt0[31:24];

        field {
            name = "dci_man_adjwgt1";
            desc = "Weighted value of curve 1 in manual mode";
            sw = rw;
            hw = r;
            reset = 0x64;
        } dci_man_adjwgt1[23:16];

        field {
            name = "dci_man_adjwgt2";
            desc = "Weighted value of curve 2 in manual mode";
            sw = rw;
            hw = r;
            reset = 0xE6;
        } dci_man_adjwgt2[15:8];
    } ISP_VPDCIADJWGT @ 0x41C1C;

    reg {
        name = "DCI curve 0 weight range register";
        desc = "ISP_VPDCICLIP0 is a DCI curve 0 weight range register. Hi3516C V300/Hi3516E V100 Professional HD IP Camera SoC

Data sheet 10.6 ISP_VPDCICLIP0 (offset 0x51C20, printed page 10-434, `hi3516cv300--Hi3516CV300-Hi3516EV100-Datasheet.txt` line 65455).";

        field {
            name = "dci_wgt_cliplow0";
            desc = "Lower limit of the weighted value of curve 0";
            sw = rw;
            hw = r;
            reset = 0x0;
        } dci_wgt_cliplow0[31:24];

        field {
            name = "dci_wgt_cliphigh0";
            desc = "Upper limit of the weighted value of curve 0";
            sw = rw;
            hw = r;
            reset = 0xFF;
        } dci_wgt_cliphigh0[23:16];
    } ISP_VPDCICLIP0 @ 0x41C20;

    reg {
        name = "DCI curve 1 weight range register";
        desc = "ISP_VPDCICLIP1 is a DCI curve 1 weight range register.

Data sheet 10.6 ISP_VPDCICLIP1 (offset 0x51C24, printed page 10-434, `hi3516cv300--Hi3516CV300-Hi3516EV100-Datasheet.txt` line 65476).";

        field {
            name = "dci_wgt_cliplow1";
            desc = "Lower limit of the weighted value of curve 1";
            sw = rw;
            hw = r;
            reset = 0x0;
        } dci_wgt_cliplow1[31:24];

        field {
            name = "dci_wgt_cliphigh1";
            desc = "Upper limit of the weighted value of curve 1";
            sw = rw;
            hw = r;
            reset = 0xFF;
        } dci_wgt_cliphigh1[23:16];
    } ISP_VPDCICLIP1 @ 0x41C24;

    reg {
        name = "DCI curve 2 weight range register";
        desc = "ISP_VPDCICLIP2 is a DCI curve 2 weight range register.

Data sheet 10.6 ISP_VPDCICLIP2 (offset 0x51C28, printed page 10-434, `hi3516cv300--Hi3516CV300-Hi3516EV100-Datasheet.txt` line 65496).";

        field {
            name = "dci_wgt_cliplow2";
            desc = "Lower limit of the weighted value of curve 2";
            sw = rw;
            hw = r;
            reset = 0x0;
        } dci_wgt_cliplow2[31:24];

        field {
            name = "dci_wgt_cliphigh2";
            desc = "Upper limit of the weighted value of curve 2";
            sw = rw;
            hw = r;
            reset = 0xFF;
        } dci_wgt_cliphigh2[23:16];
    } ISP_VPDCICLIP2 @ 0x41C28;

    reg {
        name = "DCI luminance adjustment unit global gain register";
        desc = "ISP_VPDCIGLBGAIN is a DCI luminance adjustment unit global gain register.

Data sheet 10.6 ISP_VPDCIGLBGAIN (offset 0x51C2C, printed page 10-435, `hi3516cv300--Hi3516CV300-Hi3516EV100-Datasheet.txt` line 65526).";

        field {
            name = "dci_glb_gain0";
            desc = "Global gain 0 when the luminance component is adjusted";
            sw = rw;
            hw = r;
            reset = 0x20;
        } dci_glb_gain0[31:26];

        field {
            name = "dci_glb_gain1";
            desc = "Global gain 1 when the luminance component is adjusted";
            sw = rw;
            hw = r;
            reset = 0x20;
        } dci_glb_gain1[25:20];

        field {
            name = "dci_glb_gain2";
            desc = "Global gain 2 when the luminance component is adjusted";
            sw = rw;
            hw = r;
            reset = 0x20;
        } dci_glb_gain2[19:14];
    } ISP_VPDCIGLBGAIN @ 0x41C2C;

    reg {
        name = "DCI adjustment unit threshold register 0 during positive adjustment";
        desc = "ISP_VPDCIPOSTHR0 is DCI adjustment unit threshold register 0 during positive adjustment.

Data sheet 10.6 ISP_VPDCIPOSTHR0 (offset 0x51C30, printed page 10-435, `hi3516cv300--Hi3516CV300-Hi3516EV100-Datasheet.txt` line 65548).";

        field {
            name = "dci_gainpos_thr1";
            desc = "Threshold 1 for luminance Y when the picture is adjusted from dark to bright";
            sw = rw;
            hw = r;
            reset = 0x14;
        } dci_gainpos_thr1[31:24];

        field {
            name = "dci_gainpos_thr2";
            desc = "Threshold 2 for luminance Y when the picture is adjusted from dark to bright";
            sw = rw;
            hw = r;
            reset = 0x1E;
        } dci_gainpos_thr2[23:16];

        field {
            name = "dci_gainpos_thr3";
            desc = "Threshold 3 for luminance Y when the picture is adjusted from dark to bright";
            sw = rw;
            hw = r;
            reset = 0x28;
        } dci_gainpos_thr3[15:8];

        field {
            name = "dci_gainpos_thr4";
            desc = "Threshold 4 for luminance Y when the picture is adjusted from dark to bright";
            sw = rw;
            hw = r;
            reset = 0x32;
        } dci_gainpos_thr4[7:0];
    } ISP_VPDCIPOSTHR0 @ 0x41C30;

    reg {
        name = "DCI adjustment unit threshold register 1 during positive adjustment";
        desc = "ISP_VPDCIPOSTHR1 is DCI adjustment unit threshold register 1 during positive adjustment.

Data sheet 10.6 ISP_VPDCIPOSTHR1 (offset 0x51C34, printed page 10-436, `hi3516cv300--Hi3516CV300-Hi3516EV100-Datasheet.txt` line 65584).";

        field {
            name = "dci_gainpos_thr5";
            desc = "Threshold 5 for luminance Y when the picture is adjusted from dark to bright";
            sw = rw;
            hw = r;
            reset = 0x3C;
        } dci_gainpos_thr5[31:24];

        field {
            name = "dci_gainpos_thr6";
            desc = "Threshold 6 for luminance Y when the picture is adjusted from dark to bright";
            sw = rw;
            hw = r;
            reset = 0x46;
        } dci_gainpos_thr6[23:16];

        field {
            name = "dci_gainpos_thr7";
            desc = "Threshold 7 for luminance Y when the picture is adjusted from dark to bright";
            sw = rw;
            hw = r;
            reset = 0x73;
        } dci_gainpos_thr7[15:8];

        field {
            name = "dci_gainpos_thr4";
            desc = "[inferred] Dci gainpos thr4. (bits reserved in the data sheet; vendor header `isp_reg_define.h` field `dci_gainpos_thr4`; access and reset unknown, modelled RW)";
            sw = rw;
            hw = r;
        } dci_gainpos_thr4[7:0];
    } ISP_VPDCIPOSTHR1 @ 0x41C34;

    reg {
        name = "DCI adjustment unit gain register 0 during positive adjustment";
        desc = "ISP_VPDCIPOSGAIN0 is DCI adjustment unit gain register 0 during positive adjustment.

Data sheet 10.6 ISP_VPDCIPOSGAIN0 (offset 0x51C38, printed page 10-436, `hi3516cv300--Hi3516CV300-Hi3516EV100-Datasheet.txt` line 65612).";

        field {
            name = "dci_gainpos_cbcr0";
            desc = "Chrominance compensation gain of threshold 0 when the picture is adjusted from dark to bright";
            sw = rw;
            hw = r;
            reset = 0x0;
        } dci_gainpos_cbcr0[31:28];

        field {
            name = "dci_gainpos_cbcr1";
            desc = "Chrominance compensation gain of threshold 1 when the picture is adjusted from dark to bright";
            sw = rw;
            hw = r;
            reset = 0x2;
        } dci_gainpos_cbcr1[27:24];

        field {
            name = "dci_gainpos_cbcr2";
            desc = "Chrominance compensation gain of threshold 2 when the picture is adjusted from dark to bright";
            sw = rw;
            hw = r;
            reset = 0x3;
        } dci_gainpos_cbcr2[23:20];

        field {
            name = "dci_gainpos_cbcr3";
            desc = "Chrominance compensation gain of threshold 3 when the picture is adjusted from dark to bright";
            sw = rw;
            hw = r;
            reset = 0x4;
        } dci_gainpos_cbcr3[19:16];

        field {
            name = "dci_gainpos_cbcr4";
            desc = "Chrominance compensation gain of threshold 4 when the picture is adjusted from dark to bright";
            sw = rw;
            hw = r;
            reset = 0x5;
        } dci_gainpos_cbcr4[15:12];

        field {
            name = "dci_gainpos_cbcr5";
            desc = "Chrominance compensation gain of threshold 5 when the picture is adjusted from dark to bright";
            sw = rw;
            hw = r;
            reset = 0x6;
        } dci_gainpos_cbcr5[11:8];

        field {
            name = "dci_gainpos_cbcr6";
            desc = "Chrominance compensation gain of threshold 6 when the picture is adjusted from dark to bright";
            sw = rw;
            hw = r;
            reset = 0x7;
        } dci_gainpos_cbcr6[7:4];

        field {
            name = "dci_gainpos_cbcr7";
            desc = "Chrominance compensation gain of threshold 7 when the picture is adjusted from dark to bright";
            sw = rw;
            hw = r;
            reset = 0x8;
        } dci_gainpos_cbcr7[3:0];
    } ISP_VPDCIPOSGAIN0 @ 0x41C38;

    reg {
        name = "DCI adjustment unit gain register 1 during positive adjustment";
        desc = "ISP_VPDCIPOSGAIN1 is DCI adjustment unit gain register 1 during positive adjustment.

Data sheet 10.6 ISP_VPDCIPOSGAIN1 (offset 0x51C3C, printed page 10-437, `hi3516cv300--Hi3516CV300-Hi3516EV100-Datasheet.txt` line 65665).";

        field {
            name = "dci_gainpos_cbcr8";
            desc = "Chrominance compensation gain of threshold 8 when the picture is adjusted from dark to bright";
            sw = rw;
            hw = r;
            reset = 0x9;
        } dci_gainpos_cbcr8[31:28];

        field {
            name = "dci_gainpos_cbcr1";
            desc = "[inferred] Dci gainpos cbcr1. (bits reserved in the data sheet; vendor header `isp_reg_define.h` field `dci_gainpos_cbcr1`; access and reset unknown, modelled RW)";
            sw = rw;
            hw = r;
        } dci_gainpos_cbcr1[27:24];

        field {
            name = "dci_gainpos_cbcr2";
            desc = "[inferred] Dci gainpos cbcr2. (bits reserved in the data sheet; vendor header `isp_reg_define.h` field `dci_gainpos_cbcr2`; access and reset unknown, modelled RW)";
            sw = rw;
            hw = r;
        } dci_gainpos_cbcr2[23:20];

        field {
            name = "dci_gainpos_cbcr3";
            desc = "[inferred] Dci gainpos cbcr3. (bits reserved in the data sheet; vendor header `isp_reg_define.h` field `dci_gainpos_cbcr3`; access and reset unknown, modelled RW)";
            sw = rw;
            hw = r;
        } dci_gainpos_cbcr3[19:16];

        field {
            name = "dci_gainpos_cbcr4";
            desc = "[inferred] Dci gainpos cbcr4. (bits reserved in the data sheet; vendor header `isp_reg_define.h` field `dci_gainpos_cbcr4`; access and reset unknown, modelled RW)";
            sw = rw;
            hw = r;
        } dci_gainpos_cbcr4[15:12];

        field {
            name = "dci_gainpos_cbcr5";
            desc = "[inferred] Dci gainpos cbcr5. (bits reserved in the data sheet; vendor header `isp_reg_define.h` field `dci_gainpos_cbcr5`; access and reset unknown, modelled RW)";
            sw = rw;
            hw = r;
        } dci_gainpos_cbcr5[11:8];

        field {
            name = "dci_gainpos_cbcr6";
            desc = "[inferred] Dci gainpos cbcr6. (bits reserved in the data sheet; vendor header `isp_reg_define.h` field `dci_gainpos_cbcr6`; access and reset unknown, modelled RW)";
            sw = rw;
            hw = r;
        } dci_gainpos_cbcr6[7:4];

        field {
            name = "dci_gainpos_cbcr7";
            desc = "[inferred] Dci gainpos cbcr7. (bits reserved in the data sheet; vendor header `isp_reg_define.h` field `dci_gainpos_cbcr7`; access and reset unknown, modelled RW)";
            sw = rw;
            hw = r;
        } dci_gainpos_cbcr7[3:0];
    } ISP_VPDCIPOSGAIN1 @ 0x41C3C;

    reg {
        name = "DCI adjustment unit slope register 0 during positive adjustment";
        desc = "ISP_VPDCIPOSSLP0 is DCI adjustment unit slope register 0 during positive adjustment.

Data sheet 10.6 ISP_VPDCIPOSSLP0 (offset 0x51C40, printed page 10-437, `hi3516cv300--Hi3516CV300-Hi3516EV100-Datasheet.txt` line 65688).";

        field {
            name = "dci_gainpos_slp0";
            desc = "Slope of region 1 when the picture is adjusted from dark to bright, 10-bit signed number";
            sw = rw;
            hw = r;
            reset = 0x19;
        } dci_gainpos_slp0[31:22];

        field {
            name = "dci_gainpos_slp1";
            desc = "Slope of region 2 when the picture is adjusted from dark to bright, 10-bit signed number";
            sw = rw;
            hw = r;
            reset = 0x19;
        } dci_gainpos_slp1[21:12];

        field {
            name = "dci_gainpos_slp2";
            desc = "Slope of region 3 when the picture is adjusted from dark to bright, 10-bit signed number";
            sw = rw;
            hw = r;
            reset = 0x19;
        } dci_gainpos_slp2[11:2];
    } ISP_VPDCIPOSSLP0 @ 0x41C40;

    reg {
        name = "DCI adjustment unit slope register 1 during positive adjustment";
        desc = "ISP_VPDCIPOSSLP1 is DCI adjustment unit slope register 1 during positive adjustment.

Data sheet 10.6 ISP_VPDCIPOSSLP1 (offset 0x51C44, printed page 10-438, `hi3516cv300--Hi3516CV300-Hi3516EV100-Datasheet.txt` line 65726).";

        field {
            name = "dci_gainpos_slp3";
            desc = "Slope of region 4 when the picture is adjusted from dark to bright, 10-bit signed number";
            sw = rw;
            hw = r;
            reset = 0x19;
        } dci_gainpos_slp3[31:22];

        field {
            name = "dci_gainpos_slp4";
            desc = "Slope of region 5 when the picture is adjusted from dark to bright, 10-bit signed number";
            sw = rw;
            hw = r;
            reset = 0x19;
        } dci_gainpos_slp4[21:12];

        field {
            name = "dci_gainpos_slp5";
            desc = "Slope of region 6 when the picture is adjusted from dark to bright, 10-bit signed number";
            sw = rw;
            hw = r;
            reset = 0x19;
        } dci_gainpos_slp5[11:2];
    } ISP_VPDCIPOSSLP1 @ 0x41C44;

    reg {
        name = "DCI adjustment unit slope register 2 during positive adjustment";
        desc = "ISP_VPDCIPOSSLP2 is DCI adjustment unit slope register 2 during positive adjustment.

Data sheet 10.6 ISP_VPDCIPOSSLP2 (offset 0x51C48, printed page 10-438, `hi3516cv300--Hi3516CV300-Hi3516EV100-Datasheet.txt` line 65756).";

        field {
            name = "dci_gainpos_slp6";
            desc = "Slope of region 7 when the picture is adjusted from dark to bright, 10-bit signed number";
            sw = rw;
            hw = r;
            reset = 0x5;
        } dci_gainpos_slp6[31:22];

        field {
            name = "dci_gainpos_slp7";
            desc = "Slope of region 8 when the picture is adjusted from dark to bright, 10-bit signed number";
            sw = rw;
            hw = r;
            reset = 0x1;
        } dci_gainpos_slp7[21:12];

        field {
            name = "dci_gainpos_slp2";
            desc = "[inferred] Dci gainpos slp2. (bits reserved in the data sheet; vendor header `isp_reg_define.h` field `dci_gainpos_slp2`; access and reset unknown, modelled RW)";
            sw = rw;
            hw = r;
        } dci_gainpos_slp2[11:2];
    } ISP_VPDCIPOSSLP2 @ 0x41C48;

    reg {
        name = "DCI adjustment unit threshold register 0 during negative adjustment";
        desc = "ISP_VPDCINEGTHR0 is DCI adjustment unit threshold register 0 during negative adjustment.

Data sheet 10.6 ISP_VPDCINEGTHR0 (offset 0x51C4C, printed page 10-439, `hi3516cv300--Hi3516CV300-Hi3516EV100-Datasheet.txt` line 65792).";

        field {
            name = "dci_gainneg_thr1";
            desc = "Threshold 1 for luminance Y when the picture is adjusted from bright to dark";
            sw = rw;
            hw = r;
            reset = 0x1E;
        } dci_gainneg_thr1[31:24];

        field {
            name = "dci_gainneg_thr2";
            desc = "Threshold 2 for luminance Y when the picture is adjusted from bright to dark";
            sw = rw;
            hw = r;
            reset = 0x32;
        } dci_gainneg_thr2[23:16];

        field {
            name = "dci_gainneg_thr3";
            desc = "Threshold 3 for luminance Y when the picture is adjusted from bright to dark";
            sw = rw;
            hw = r;
            reset = 0x46;
        } dci_gainneg_thr3[15:8];

        field {
            name = "dci_gainneg_thr4";
            desc = "Threshold 4 for luminance Y when the picture is adjusted from bright to dark";
            sw = rw;
            hw = r;
            reset = 0x5A;
        } dci_gainneg_thr4[7:0];
    } ISP_VPDCINEGTHR0 @ 0x41C4C;

    reg {
        name = "DCI adjustment unit threshold register 1 during negative adjustment";
        desc = "ISP_VPDCINEGTHR1 is DCI adjustment unit threshold register 1 during negative adjustment.

Data sheet 10.6 ISP_VPDCINEGTHR1 (offset 0x51C50, printed page 10-439, `hi3516cv300--Hi3516CV300-Hi3516EV100-Datasheet.txt` line 65823).";

        field {
            name = "dci_gainneg_thr5";
            desc = "Threshold 5 for luminance Y when the picture is adjusted from bright to dark";
            sw = rw;
            hw = r;
            reset = 0x82;
        } dci_gainneg_thr5[31:24];

        field {
            name = "dci_gainneg_thr6";
            desc = "Threshold 6 for luminance Y when the picture is adjusted from bright to dark";
            sw = rw;
            hw = r;
            reset = 0x96;
        } dci_gainneg_thr6[23:16];

        field {
            name = "dci_gainneg_thr7";
            desc = "Threshold 7 for luminance Y when the picture is adjusted from bright to dark";
            sw = rw;
            hw = r;
            reset = 0xAA;
        } dci_gainneg_thr7[15:8];

        field {
            name = "dci_gainneg_thr4";
            desc = "[inferred] Dci gainneg thr4. (bits reserved in the data sheet; vendor header `isp_reg_define.h` field `dci_gainneg_thr4`; access and reset unknown, modelled RW)";
            sw = rw;
            hw = r;
        } dci_gainneg_thr4[7:0];
    } ISP_VPDCINEGTHR1 @ 0x41C50;

    reg {
        name = "DCI adjustment unit gain register 0 during negative adjustment";
        desc = "ISP_VPDCINEGGAIN0 is DCI adjustment unit gain register 0 during negative adjustment.

Data sheet 10.6 ISP_VPDCINEGGAIN0 (offset 0x51C54, printed page 10-440, `hi3516cv300--Hi3516CV300-Hi3516EV100-Datasheet.txt` line 65860).";

        field {
            name = "dci_gainneg_cbcr0";
            desc = "Chrominance compensation gain of threshold 0 when the picture is adjusted from bright to dark";
            sw = rw;
            hw = r;
            reset = 0x0;
        } dci_gainneg_cbcr0[31:28];

        field {
            name = "dci_gainneg_cbcr1";
            desc = "Chrominance compensation gain of threshold 1 when the picture is adjusted from bright to dark";
            sw = rw;
            hw = r;
            reset = 0x1;
        } dci_gainneg_cbcr1[27:24];

        field {
            name = "dci_gainneg_cbcr2";
            desc = "Chrominance compensation gain of threshold 2 when the picture is adjusted from bright to dark";
            sw = rw;
            hw = r;
            reset = 0x2;
        } dci_gainneg_cbcr2[23:20];

        field {
            name = "dci_gainneg_cbcr3";
            desc = "Chrominance compensation gain of threshold 3 when the picture is adjusted from bright to dark";
            sw = rw;
            hw = r;
            reset = 0x3;
        } dci_gainneg_cbcr3[19:16];

        field {
            name = "dci_gainneg_cbcr4";
            desc = "Chrominance compensation gain of threshold 4 when the picture is adjusted from bright to dark";
            sw = rw;
            hw = r;
            reset = 0x3;
        } dci_gainneg_cbcr4[15:12];

        field {
            name = "dci_gainneg_cbcr5";
            desc = "Chrominance compensation gain of threshold 5 when the picture is adjusted from bright to dark";
            sw = rw;
            hw = r;
            reset = 0x4;
        } dci_gainneg_cbcr5[11:8];

        field {
            name = "dci_gainneg_cbcr6";
            desc = "Chrominance compensation gain of threshold 6 when the picture is adjusted from bright to dark";
            sw = rw;
            hw = r;
            reset = 0x5;
        } dci_gainneg_cbcr6[7:4];

        field {
            name = "dci_gainneg_cbcr7";
            desc = "Chrominance compensation gain of threshold 7 when the picture is adjusted from bright to dark";
            sw = rw;
            hw = r;
            reset = 0x6;
        } dci_gainneg_cbcr7[3:0];
    } ISP_VPDCINEGGAIN0 @ 0x41C54;

    reg {
        name = "DCI adjustment unit gain register 1 during negative adjustment";
        desc = "ISP_VPDCINEGGAIN1 is DCI adjustment unit gain register 1 during negative adjustment. Hi3516C V300/Hi3516E V100 Professional HD IP Camera SoC

Data sheet 10.6 ISP_VPDCINEGGAIN1 (offset 0x51C58, printed page 10-441, `hi3516cv300--Hi3516CV300-Hi3516EV100-Datasheet.txt` line 65913).";

        field {
            name = "dci_gainneg_cbcr8";
            desc = "Chrominance compensation gain of threshold 8 when the picture is adjusted from bright to dark";
            sw = rw;
            hw = r;
            reset = 0x6;
        } dci_gainneg_cbcr8[31:28];

        field {
            name = "dci_gainneg_cbcr1";
            desc = "[inferred] Dci gainneg cbcr1. (bits reserved in the data sheet; vendor header `isp_reg_define.h` field `dci_gainneg_cbcr1`; access and reset unknown, modelled RW)";
            sw = rw;
            hw = r;
        } dci_gainneg_cbcr1[27:24];

        field {
            name = "dci_gainneg_cbcr2";
            desc = "[inferred] Dci gainneg cbcr2. (bits reserved in the data sheet; vendor header `isp_reg_define.h` field `dci_gainneg_cbcr2`; access and reset unknown, modelled RW)";
            sw = rw;
            hw = r;
        } dci_gainneg_cbcr2[23:20];

        field {
            name = "dci_gainneg_cbcr3";
            desc = "[inferred] Dci gainneg cbcr3. (bits reserved in the data sheet; vendor header `isp_reg_define.h` field `dci_gainneg_cbcr3`; access and reset unknown, modelled RW)";
            sw = rw;
            hw = r;
        } dci_gainneg_cbcr3[19:16];

        field {
            name = "dci_gainneg_cbcr4";
            desc = "[inferred] Dci gainneg cbcr4. (bits reserved in the data sheet; vendor header `isp_reg_define.h` field `dci_gainneg_cbcr4`; access and reset unknown, modelled RW)";
            sw = rw;
            hw = r;
        } dci_gainneg_cbcr4[15:12];

        field {
            name = "dci_gainneg_cbcr5";
            desc = "[inferred] Dci gainneg cbcr5. (bits reserved in the data sheet; vendor header `isp_reg_define.h` field `dci_gainneg_cbcr5`; access and reset unknown, modelled RW)";
            sw = rw;
            hw = r;
        } dci_gainneg_cbcr5[11:8];

        field {
            name = "dci_gainneg_cbcr6";
            desc = "[inferred] Dci gainneg cbcr6. (bits reserved in the data sheet; vendor header `isp_reg_define.h` field `dci_gainneg_cbcr6`; access and reset unknown, modelled RW)";
            sw = rw;
            hw = r;
        } dci_gainneg_cbcr6[7:4];

        field {
            name = "dci_gainneg_cbcr7";
            desc = "[inferred] Dci gainneg cbcr7. (bits reserved in the data sheet; vendor header `isp_reg_define.h` field `dci_gainneg_cbcr7`; access and reset unknown, modelled RW)";
            sw = rw;
            hw = r;
        } dci_gainneg_cbcr7[3:0];
    } ISP_VPDCINEGGAIN1 @ 0x41C58;

    reg {
        name = "DCI adjustment unit slope register 0 during negative adjustment";
        desc = "ISP_VPDCINEGSLP0 is DCI adjustment unit slope register 0 during negative adjustment.

Data sheet 10.6 ISP_VPDCINEGSLP0 (offset 0x51C5C, printed page 10-441, `hi3516cv300--Hi3516CV300-Hi3516EV100-Datasheet.txt` line 65937).";

        field {
            name = "dci_gainneg_slp0";
            desc = "Slope of region 1 when the picture is adjusted from bright to dark, 10-bit signed number";
            sw = rw;
            hw = r;
            reset = 0x8;
        } dci_gainneg_slp0[31:22];

        field {
            name = "dci_gainneg_slp1";
            desc = "Slope of region 2 when the picture is adjusted from bright to dark, 10-bit signed number";
            sw = rw;
            hw = r;
            reset = 0xC;
        } dci_gainneg_slp1[21:12];

        field {
            name = "dci_gainneg_slp2";
            desc = "Slope of region 3 when the picture is adjusted from bright to dark, 10-bit signed number";
            sw = rw;
            hw = r;
            reset = 0xC;
        } dci_gainneg_slp2[11:2];
    } ISP_VPDCINEGSLP0 @ 0x41C5C;

    reg {
        name = "DCI adjustment unit slope register 1 during negative adjustment";
        desc = "ISP_VPDCINEGSLP1 is DCI adjustment unit slope register 1 during negative adjustment. Hi3516C V300/Hi3516E V100 Professional HD IP Camera SoC

Data sheet 10.6 ISP_VPDCINEGSLP1 (offset 0x51C60, printed page 10-442, `hi3516cv300--Hi3516CV300-Hi3516EV100-Datasheet.txt` line 65978).";

        field {
            name = "dci_gainneg_slp3";
            desc = "Slope of region 4 when the picture is adjusted from bright to dark, 10-bit signed number";
            sw = rw;
            hw = r;
            reset = 0x0;
        } dci_gainneg_slp3[31:22];

        field {
            name = "dci_gainneg_slp4";
            desc = "Slope of region 5 when the picture is adjusted from bright to dark, 10-bit signed number";
            sw = rw;
            hw = r;
            reset = 0x6;
        } dci_gainneg_slp4[21:12];

        field {
            name = "dci_gainneg_slp5";
            desc = "Slope of region 6 when the picture is adjusted from bright to dark, 10-bit signed number";
            sw = rw;
            hw = r;
            reset = 0xC;
        } dci_gainneg_slp5[11:2];
    } ISP_VPDCINEGSLP1 @ 0x41C60;

    reg {
        name = "DCI adjustment unit slope register 2 during negative adjustment";
        desc = "ISP_VPDCINEGSLP2 is DCI adjustment unit slope register 2 during negative adjustment.

Data sheet 10.6 ISP_VPDCINEGSLP2 (offset 0x51C64, printed page 10-442, `hi3516cv300--Hi3516CV300-Hi3516EV100-Datasheet.txt` line 66008).";

        field {
            name = "dci_gainneg_slp6";
            desc = "Slope of region 7 when the picture is adjusted from bright to dark, 10-bit signed number";
            sw = rw;
            hw = r;
            reset = 0xC;
        } dci_gainneg_slp6[31:22];

        field {
            name = "dci_gainneg_slp7";
            desc = "Slope of region 8 when the picture is adjusted from bright to dark, 10-bit signed number";
            sw = rw;
            hw = r;
            reset = 0x0;
        } dci_gainneg_slp7[21:12];

        field {
            name = "dci_gainneg_slp2";
            desc = "[inferred] Dci gainneg slp2. (bits reserved in the data sheet; vendor header `isp_reg_define.h` field `dci_gainneg_slp2`; access and reset unknown, modelled RW)";
            sw = rw;
            hw = r;
        } dci_gainneg_slp2[11:2];
    } ISP_VPDCINEGSLP2 @ 0x41C64;
};

`endif
