`ifndef HISI_VPSS_RDL
`define HISI_VPSS_RDL

addrmap aHISI_VPSS {
    name = "HiSilicon VPSS (registers not described)";
    desc = "Not described: no register of this block is described in any data sheet [BOARD-READ Hi3518E V200 2026-11-11: with PERI_CRG18 reset pulsed and clock on, +0x000..+0x7FC, +0x3F0, +0x404, +0x410 and +0x4004 read 0 except +0x144, +0x15C and +0x18C = 2; there is no ID word and none of the Hi3520D non-zero defaults (+0x200..+0x270, +0x410, +0x4004) appears: the EV200 VPSS is a different layout.]  (every data sheet that has the block lists only the 64 KB memory-map window, the interrupt number and the clock/reset/QoS bits of the integration registers; the registers exist only in closed vendor libraries and modules). The 64 KB window is kept so that the block base address and size exist in the address map (STUB). Instances (data-sheet memory maps and interrupt tables, cross-chip audit 2026-11-11, docs/rdl-campaign/vpss.md): 0x20600000 on Hi3520D/Hi3515A/Hi3515C (GIC 69), Hi3516C V100 and Hi3518 A/C V100 (interrupt 17), Hi3516A/Hi3516D (GIC 68), Hi3518E V200/Hi3516C V200 (interrupt 17); 0x11180000 on Hi3516A V200 and Hi3519 V101 (GIC 64); 0x11040000 on Hi3516A V300 (GIC 75); 0x11250000 on Hi3516C V300 and Hi3516E V100 (interrupt 17). Hi3511/Hi3515 V100/Hi3516 V100/Hi3520 V100 have no VPSS. The data-sheet feature texts show at least three generations: (1) Hi3520D, Hi3516C V100, Hi3518 V100, Hi3518E V100: 3D Gaussian noise reduction, image enhancement (Hi3520D only), de-interlace, sharpening, border (Hi3520D only), block processing of wide pictures, scaling, register linked list, YUV420/YUV422; (2) Hi3516A/D, Hi3518E V200/Hi3516C V200: NR, up to 3 encoding channels plus 1 display channel, 8 cover regions per channel, cropping, linked-list configuration (offline) or APB (online mode with VICAP); (3) Hi3516A V200/V300, Hi3519, Hi3516C V300: one input, up to three outputs, online or offline with VI. Register layouts across generations are unknown and must not be assumed equal; the Hi3520D edition with the vendor-derived registers is aHISI_VPSS_V100 below. Video process subsystem data sheet text for the Hi3520D: chapter 8.2 (original Chinese issue 02), overview and features only. The vendor Hi3531-family `platform.h` gives only VPSS0_REG_BASE 0x20600000 (and a VPSS1 at 0x20680000, which is Reserved in the Hi3520D table). Listed as an open item in docs/rdl-sweep/PORT-BLOCKS.md.";

    reg {
        name = "VPSS mask";
        desc = "Provenance: offset, access direction and written value are PROVEN from hi3518e_vpss.ko (OpenIPC package, Hi3518EV200_MPP_V1.0.5.0) function VPSS_HAL_SetMask (store only) (static analysis, not run on hardware); seen in the Hi3518E V200 module only (same set as the VGS of that chip and the Hi3516C V300 VPSS_V2 job-control file, eHISI_VPSS_V2); the role is INFERRED from the function name.";
        field {
            name = "mask";
            desc = "VPSS mask. Bit layout not known, treated as one value (GUESS for any finer meaning).";
            sw = rw;
            hw = r;
        } mask[31:0];
    } VPSS_MASK @ 0x1FC;

    reg {
        name = "VPSS next node address";
        desc = "Provenance: offset, access direction and written value are PROVEN from hi3518e_vpss.ko (OpenIPC package, Hi3518EV200_MPP_V1.0.5.0) function VPSS_HAL_Start (value written, read back and compared with a cache barrier, a printk and retry counter on mismatch, then 0x300 is written); physical address of the first register-image node of the job list (INFERRED from the VGS/CV300 analogy and the HAL name) (static analysis, not run on hardware); seen in the Hi3518E V200 module only (same set as the VGS of that chip and the Hi3516C V300 VPSS_V2 job-control file, eHISI_VPSS_V2); the role is INFERRED from the function name.";
        field {
            name = "next_node";
            desc = "VPSS next node address. Bit layout not known, treated as one value (GUESS for any finer meaning).";
            sw = rw;
            hw = r;
        } next_node[31:0];
    } VPSS_NEXT_NODE @ 0x2FC;

    reg {
        name = "VPSS start";
        desc = "Provenance: offset, access direction and written value are PROVEN from hi3518e_vpss.ko (OpenIPC package, Hi3518EV200_MPP_V1.0.5.0) function VPSS_HAL_Start: writes 1, or 3 when its third argument is non-zero; bit 0 = start (INFERRED), bit 1 = unknown mode (GUESS) (static analysis, not run on hardware); seen in the Hi3518E V200 module only (same set as the VGS of that chip and the Hi3516C V300 VPSS_V2 job-control file, eHISI_VPSS_V2); the role is INFERRED from the function name.";
        field {
            name = "start";
            desc = "VPSS start. Bit layout not known, treated as one value (GUESS for any finer meaning).";
            sw = rw;
            hw = r;
        } start[1:0];
    } VPSS_START @ 0x300;

    reg {
        name = "VPSS interrupt status";
        desc = "Provenance: offset, access direction and written value are PROVEN from hi3518e_vpss.ko (OpenIPC package, Hi3518EV200_MPP_V1.0.5.0) function VPSS_HAL_GetIntStatus (load only); bit meaning unknown (static analysis, not run on hardware); seen in the Hi3518E V200 module only (same set as the VGS of that chip and the Hi3516C V300 VPSS_V2 job-control file, eHISI_VPSS_V2); the role is INFERRED from the function name.";
        field {
            name = "int_status";
            desc = "VPSS interrupt status. Bit layout not known, treated as one value (GUESS for any finer meaning).";
            sw = r;
            hw = r;
        } int_status[31:0];
    } VPSS_INT_STATUS @ 0x304;

    reg {
        name = "VPSS interrupt clear";
        desc = "Provenance: offset, access direction and written value are PROVEN from hi3518e_vpss.ko (OpenIPC package, Hi3518EV200_MPP_V1.0.5.0) function VPSS_HAL_ClrInt (writes 0xFFFFFFFF); write-1-to-clear INFERRED (static analysis, not run on hardware); seen in the Hi3518E V200 module only (same set as the VGS of that chip and the Hi3516C V300 VPSS_V2 job-control file, eHISI_VPSS_V2); the role is INFERRED from the function name.";
        field {
            name = "int_clear";
            desc = "VPSS interrupt clear. Bit layout not known, treated as one value (GUESS for any finer meaning).";
            sw = rw;
            hw = r;
        } int_clear[31:0];
    } VPSS_INT_CLEAR @ 0x308;

    reg {
        name = "VPSS raw interrupt status";
        desc = "Provenance: offset, access direction and written value are PROVEN from hi3518e_vpss.ko (OpenIPC package, Hi3518EV200_MPP_V1.0.5.0) function VPSS_HAL_GetRawIntStatus (load only); bit meaning unknown (static analysis, not run on hardware); seen in the Hi3518E V200 module only (same set as the VGS of that chip and the Hi3516C V300 VPSS_V2 job-control file, eHISI_VPSS_V2); the role is INFERRED from the function name.";
        field {
            name = "raw_int_status";
            desc = "VPSS raw interrupt status. Bit layout not known, treated as one value (GUESS for any finer meaning).";
            sw = r;
            hw = r;
        } raw_int_status[31:0];
    } VPSS_RAW_INT_STATUS @ 0x30C;

    reg {
        name = "VPSS AXI outstanding";
        desc = "Provenance: offset, access direction and written value are PROVEN from hi3518e_vpss.ko (OpenIPC package, Hi3518EV200_MPP_V1.0.5.0) function VPSS_HAL_SetOutstanding (store only); AXI outstanding-request count INFERRED from the name (static analysis, not run on hardware); seen in the Hi3518E V200 module only (same set as the VGS of that chip and the Hi3516C V300 VPSS_V2 job-control file, eHISI_VPSS_V2); the role is INFERRED from the function name.";
        field {
            name = "outstanding";
            desc = "VPSS AXI outstanding. Bit layout not known, treated as one value (GUESS for any finer meaning).";
            sw = rw;
            hw = r;
        } outstanding[31:0];
    } VPSS_OUTSTANDING @ 0x314;

    external mem {
        name = "Undocumented register window";
        desc = "The rest of the 64 KB window (0x400-0xFFFF). Register layout unknown; placeholder so the block base address and size exist in the map. Only the job-control registers at 0x1FC-0x314 are known (Hi3518E V200 vendor-module code, see their descriptions).";
        mementries = 16128;
        memwidth = 32;
        sw = rw;
    } REGS @ 0x400;
};

addrmap aHISI_VPSS_V100 {
    name = "HiSilicon VPSS (Hi3520D V100 edition, vendor-derived registers)";
    desc = "VPSS, Hi3520D V100 edition, vendor-derived, NOT VERIFIED ON HARDWARE. The data sheet has no VPSS register table. Derived by static disassembly of hi3520D_vpss.ko (Hi3520D_MPP_V2.0.5.1, OpenIPC copy with local symbols; the Xiongmai NBD7804T-F copy has the same code), docs/rdl-campaign/vpss.md. CONFIRMED FACTS (vendor code, HIGH): VPSS_HAL_Init ioremaps 0x20600000 for 0x4060 bytes (the vendor code touches nothing above 0x405F); VPSS_DRV_GetIrqId returns 69; the module is one 'group' per VPSS node: software builds a register-image node in DDR (the HAL functions VPSS_HAL_SetCtrl/SetSrcImgSize/SetCurPicAddr/SetDieCfg/SetChn* write bit fields into such a node image, which mirrors the register layout and is 0x420 bytes or more), links nodes through the word at node offset 0x3F0, and starts the hardware with the node address (linked-list register configuration as the data sheet describes). Only seven locations are accessed through the ioremapped window and are listed here as UNK_ registers: 0x0E0 (node ID read back), 0x3F0 (next node address), 0x400 (start), 0x404 (interrupt status), 0x408 (interrupt clear), 0x414 (outstanding configuration), 0x4000 (debug word). Everything else in the window is not described (SECOND PASS 2026-11-11: the DDR node image is now documented in eHISI_VPSS_V100_NODE; the VPSS bring-up order from the vendor SYS calls is PERI_CRG18 (0x20030048) bit 0 = 1 then 0 (reset pulse) THEN bit 1 = 1 (clock on): reset is released BEFORE the clock is enabled, unlike TDE/VEDU; HIGH, VPSS_DRV_AbolishReset). The names VPSS_* are GUESSES (the per-node configuration registers live in the node images; whether they are also memory-mapped is unknown). The names are placeholders (UNK_<offset>), the purposes come from the function names of the vendor HAL. The Hi3516C V100/Hi3518 V100/Hi3518E V100 VPSS sits at the same base and has the same feature list, but no register-level comparison is possible, so only the Hi3520D family files (Hi3520D, Hi3515A, Hi3515C; the Hi3515A/C instantiation is inferred) use this edition.";

    reg {
        name = "VPSS_NODE_ID";
        desc = "VPSS_NODE_ID (GUESS: the name is inferred from the vendor HAL function name; it is not a vendor register name). NOT IN THE DATA SHEET. Source: hi3520D_vpss.ko VPSS_HAL_GetNodeID (0x185d4): one word read from the ioremapped window, called from the interrupt path after VPSS_HAL_GetIntStatus/ClrInt (VPSS_COMM_IrqProc 0x1d430); the same offset in the node image is written by VPSS_HAL_SetNodeID (0x17698). Vendor meaning: ID of the node the hardware just finished. Confidence MEDIUM (offset and read HIGH, meaning inferred from the function name), not verified on hardware. SECOND PASS (2026-11-11, docs/rdl-campaign/vpss-vendor.md): read once per interrupt after the status read and the clear; the interrupt handler compares it with the ID of the node it expects (VPSS_COMM_IrqProc logs a mismatch and still runs the list completion, HIGH for the access pattern). GUESS: node ID of the last completed node (MEDIUM).";

        field {
            name = "unk";
            desc = "Unknown 32-bit value (vendor: node ID of the completed node).";
            sw = r;
            hw = w;
        } unk[31:0];

    } VPSS_NODE_ID @ 0x0E0;

    reg {
        name = "VPSS_NEXT_NODE";
        desc = "VPSS_NEXT_NODE (GUESS: the name is inferred from the vendor HAL function name; it is not a vendor register name). NOT IN THE DATA SHEET. Source: hi3520D_vpss.ko VPSS_HAL_Start (0x186f0): writes the node address (physical address of the DDR node image) to this word and reads it back in a loop until it equals the written value (retry with printk on mismatch), then writes 1 to 0x400. VPSS_HAL_GetNextInfo (0x184b0) reads it. In the node image the same offset is the pointer to the next node (VPSS_HAL_SetNext 0x17684). Vendor meaning: address of the first or next node of the linked list. Confidence MEDIUM (offsets and access pattern HIGH, meaning from the function names), not verified on hardware. SECOND PASS: the start sequence writes the first node address here and reads it back until it matches (a retry loop with a printk), so the register is a latch that may take time to accept the write (HIGH for the pattern; the reason is unknown). GUESS: next/first node address (MEDIUM).";

        field {
            name = "unk";
            desc = "Node address (vendor-derived, MEDIUM).";
            sw = rw;
            hw = r;
        } unk[31:0];

    } VPSS_NEXT_NODE @ 0x3F0;

    reg {
        name = "VPSS_START";
        desc = "VPSS_START (GUESS: the name is inferred from the vendor HAL function name; it is not a vendor register name). NOT IN THE DATA SHEET. Source: hi3520D_vpss.ko VPSS_HAL_Start (0x186f0): after the node address was written to 0x3F0 and verified, the value 1 is written here (the only value ever written). Vendor meaning: start. Confidence MEDIUM, not verified on hardware. SECOND PASS: GUESS: start trigger (MEDIUM). Written once per list, always after the node address was verified.";

        field {
            name = "unk";
            desc = "Written with 1 to start processing the linked list (vendor-derived, MEDIUM). Read behavior unknown.";
            sw = rw;
            hw = r;
        } unk[31:0];

    } VPSS_START @ 0x400;

    reg {
        name = "VPSS_INT_STATUS";
        desc = "VPSS_INT_STATUS (GUESS: the name is inferred from the vendor HAL function name; it is not a vendor register name). NOT IN THE DATA SHEET. Source: hi3520D_vpss.ko VPSS_HAL_GetIntStatus (0x18574): reads the whole word; called by VPSS_COMM_IrqProc (0x1d430, the interrupt handler path, IRQ 69) before the node ID is read and the interrupt cleared. Vendor meaning: interrupt status; bit meanings not seen in the HAL (the whole word is passed up). Confidence MEDIUM, not verified on hardware. SECOND PASS: the vendor classifier VPSS_DRV_IsWrongInt looks only at bits [3:0]: the value 4 is treated as an abnormal interrupt (logged, counted, not processed as a completion), 2 is an assertion failure (panic: never expected), 0 is logged but processed, everything else (for example bit 0 or bit 3) is a normal completion. So bit 2 is probably an error (timeout or bus error) and bit 0 or 3 the completion (INFERRED, LOW-MEDIUM).";

        field {
            name = "unk";
            desc = "Interrupt status word (vendor-derived, MEDIUM; bits not decoded).";
            sw = r;
            hw = w;
        } unk[31:0];

    } VPSS_INT_STATUS @ 0x404;

    reg {
        name = "VPSS_INT_CLEAR";
        desc = "VPSS_INT_CLEAR (GUESS: the name is inferred from the vendor HAL function name; it is not a vendor register name). NOT IN THE DATA SHEET. Source: hi3520D_vpss.ko VPSS_HAL_ClrInt (0x18690): writes 0xFFFFFFFF (all ones) to this word, called from the interrupt path. Vendor meaning: interrupt clear (write 1 to clear is assumed, the vendor writes all ones). Confidence MEDIUM, not verified on hardware. SECOND PASS: GUESS: interrupt clear, written before the node ID is read (MEDIUM).";

        field {
            name = "unk";
            desc = "Interrupt clear (vendor writes 0xFFFFFFFF; vendor-derived, MEDIUM).";
            sw = w;
            hw = r;
        } unk[31:0];

    } VPSS_INT_CLEAR @ 0x408;

    reg {
        name = "VPSS_OUTSTANDING";
        desc = "VPSS_OUTSTANDING (GUESS: the name is inferred from the vendor HAL function name; it is not a vendor register name). NOT IN THE DATA SHEET. Source: hi3520D_vpss.ko VPSS_HAL_SetOutstanding (0x18634): writes one whole word (argument r1) to this location of the ioremapped window. The node image has a word at the same offset (VPSS_HAL_SetMiscellaneous 0x17664 sets bits [23:16] in it, 'miscellaneous', values 3 and 100 seen in VPSS_DRV_SetModelParam 0x1610c). The data sheet says only that the block supports 'outstanding configuration'. Vendor meaning: outstanding (AXI) configuration. Confidence MEDIUM, not verified on hardware. SECOND PASS: the same offset in the node image is a word whose bits [23:16] hold a vendor 'miscellaneous' value (see eHISI_VPSS_V100_NODE N_MISC). GUESS (MEDIUM).";

        field {
            name = "unk";
            desc = "Outstanding configuration word (vendor-derived, MEDIUM).";
            sw = rw;
            hw = r;
        } unk[31:0];

    } VPSS_OUTSTANDING @ 0x414;

    reg {
        name = "VPSS_DEBUG";
        desc = "VPSS_DEBUG (GUESS: the name is inferred from the vendor HAL function name; it is not a vendor register name). NOT IN THE DATA SHEET. Source: hi3520D_vpss.ko VPSS_HAL_GetDbgInfo (0x18510): one word read (offset 0x4000 formed as a 16384 register-offset operand), exposed through the module's debug/proc output. The vendor ioremap is 0x4060 bytes, so 0x4000..0x405F exist. Vendor meaning: debug/status word. Confidence LOW, not verified on hardware. SECOND PASS: still LOW.";

        field {
            name = "unk";
            desc = "Debug word (vendor-derived, LOW).";
            sw = r;
            hw = w;
        } unk[31:0];

    } VPSS_DEBUG @ 0x4000;

    external mem {
        name = "Rest of the window (not described)";
        desc = "The rest of the 64 KB window above 0x4004 and the gaps between the registers listed above (no vendor access seen through the window). Kept so that the block size exists in the map. No registers are described.";
        mementries = 12287;
        memwidth = 32;
        sw = rw;
    } REST @ 0x4004;
};

regfile eHISI_VPSS_V100_NODE {
    name = "HiSilicon VPSS, Hi3520D job node image (in DDR, NOT MMIO registers)";
    desc = "NOT A REGISTER FILE: layout of one hardware node (register image) in DDR as built by the vendor HAL (VPSS_HAL_Set* functions of hi3520D_vpss.ko, docs/rdl-campaign/vpss-vendor.md), described as a regfile only to document offsets and bit fields. NOT INSTANTIATED. NOT VERIFIED ON HARDWARE. Confidence: every offset and bit position is read from the instruction stream of the HAL setters (HIGH); every NAME and MEANING is inferred from the vendor function name, the data-sheet feature list or the HiSTB-style conventions, and marked GUESS or INFERRED (LOW unless stated). The image is 0x420 bytes or more (highest word 0x41C): the vendor allocates a model buffer per node (VPSS_DRV_MallocModelBuf); the VPSS_HAL_NodeQueue* functions keep free/wait/busy lists of them. VPSS_COMM_HalListInt links the nodes through NEXT (offset 0x3F0), stamps NODE_ID (0xE0), sets MASK (0xEC) to 0 for all nodes but the last (7) and writes the first node's physical address into the MMIO register VPSS_NEXT_NODE followed by 1 into VPSS_START. Which words are fetched by the hardware (all 0x420 bytes or only the words selected by MASK) is NOT known. Words the vendor HAL never writes are not described. The Hi3520D HAL setters VPSS_HAL_SetIeCfg, SetDieCfg and SetChnSpCfg are EMPTY functions (no node fields), so image enhancement, de-interlace and sharpening parameters are not set through this HAL on this chip (INFERRED: the vendor build either keeps them at their reset values or controls them through CTRL bits only; the 3D noise reduction fields are likewise not identified). Hardware-side coefficient tables are DDR buffers referenced by address (16-byte aligned).";
    reg {
        name = "Control flags (node word 0)";
        desc = "Node image offset 0x000. 22 one-bit flags at bits 0..21 and three 2-bit fields at [25:24], [27:26], [29:28], written by VPSS_HAL_SetCtrl from a 25-word argument structure (argument index to bit: 0->5, 1->6, 2->7, 3->9, 4->10, 5->11, 6->12, 7->0, 8->1, 9->2, 10->3, 11->13, 12->14, 13->15, 14->16, 15->17, 16->18, 17->19, 18->20, 19->21, 20->4, 21->8, 22 -> [25:24] with 23 -> [27:26], 24 -> [29:28]). The vendor argument names are not in the module, so the bits are not named; by the data-sheet feature list they are probably enables of the processing stages (3D NR, de-interlace, image enhancement, sharpening, border, the channels) but no bit can be assigned to a stage (GUESS, LOW).  Source: hi3520D_vpss.ko. Not verified on hardware. CTRL bit sources (round 7, PROVEN by EXECUTING VPSS_DRV_SetModelCfg of hi3520D_vpss.ko under qemu-arm with the ko-harness and sweeping every input field one at a time; this CORRECTS the earlier static reading of the bit order): group attribute fields (VpssCheckGrpAttr layout, +0x14 bIeEn, +0x18 bNrEn, +0x1C bHistEn, +0x20 DieMode): bit 5 = IeEn; bit 6 and bit 8 = any of NrEn, HistEn, DieMode non-zero (both always together: reference/state buffers needed); bit 7 = HistEn == 1; bit 13 = DieMode == 1; bit 21 = the model word at attribute +0x24 non-zero (name unknown); bit 4 = attribute word +0x310 == 2; bit 15 = node-list mode word (+0x270 of the per-job structure) == 1; bits 16, 17, 18, 19, 20 = 'filter mode == 18' of the words at attribute +0x290, +0x2B8, +0x240, +0x268, +0x1C8 (five scaler filter selections; 18 is the vendor ZoomType constant); channel records (stride 0x4C, first at attribute +0x2C): record 0 -> enable bit 2 and, when its second word is also non-zero, bit 11; record 1 -> bits 3 and 12; record 2 -> bits 0 and 9; record 3 -> bits 1 and 10; bit 14 is always 1; [25:24] = 2 and [27:26] = 3 constant in this driver; bits 22, 23 and [29:28], 30, 31 were never set by any single-field change (unresolved, probably combinations). Meanings of the groups are INFERRED from the field names only. Executed values are what the vendor DRIVER computes, not proof of what the hardware does with them. Vendor check strings show NrEn, DieMode, DrEn, DbEn, IeEn, HistEn, SpEn, FrmWkEn, CropEn exist as separate settings and that 'HistEn/NrEn/Die and Dr/Db cannot be enabled at the same time'.";
        field {
            name = "flag0";
            desc = "Control flag, purpose unknown. POSITION seen in hi3520D_vpss.ko (HIGH); MEANING INFERRED from the HAL function name only (LOW) Not verified on hardware.";
            sw = rw;
            hw = r;
        } flag0[0:0];
        field {
            name = "flag1";
            desc = "Control flag, purpose unknown. POSITION seen in hi3520D_vpss.ko (HIGH); MEANING INFERRED from the HAL function name only (LOW) Not verified on hardware.";
            sw = rw;
            hw = r;
        } flag1[1:1];
        field {
            name = "flag2";
            desc = "Control flag, purpose unknown. POSITION seen in hi3520D_vpss.ko (HIGH); MEANING INFERRED from the HAL function name only (LOW) Not verified on hardware.";
            sw = rw;
            hw = r;
        } flag2[2:2];
        field {
            name = "flag3";
            desc = "Control flag, purpose unknown. POSITION seen in hi3520D_vpss.ko (HIGH); MEANING INFERRED from the HAL function name only (LOW) Not verified on hardware.";
            sw = rw;
            hw = r;
        } flag3[3:3];
        field {
            name = "flag4";
            desc = "Control flag, purpose unknown. POSITION seen in hi3520D_vpss.ko (HIGH); MEANING INFERRED from the HAL function name only (LOW) Not verified on hardware.";
            sw = rw;
            hw = r;
        } flag4[4:4];
        field {
            name = "flag5";
            desc = "Control flag, purpose unknown. POSITION seen in hi3520D_vpss.ko (HIGH); MEANING INFERRED from the HAL function name only (LOW) Not verified on hardware.";
            sw = rw;
            hw = r;
        } flag5[5:5];
        field {
            name = "flag6";
            desc = "Control flag, purpose unknown. POSITION seen in hi3520D_vpss.ko (HIGH); MEANING INFERRED from the HAL function name only (LOW) Not verified on hardware.";
            sw = rw;
            hw = r;
        } flag6[6:6];
        field {
            name = "flag7";
            desc = "Control flag, purpose unknown. POSITION seen in hi3520D_vpss.ko (HIGH); MEANING INFERRED from the HAL function name only (LOW) Not verified on hardware.";
            sw = rw;
            hw = r;
        } flag7[7:7];
        field {
            name = "flag8";
            desc = "Control flag, purpose unknown. POSITION seen in hi3520D_vpss.ko (HIGH); MEANING INFERRED from the HAL function name only (LOW) Not verified on hardware.";
            sw = rw;
            hw = r;
        } flag8[8:8];
        field {
            name = "flag9";
            desc = "Control flag, purpose unknown. POSITION seen in hi3520D_vpss.ko (HIGH); MEANING INFERRED from the HAL function name only (LOW) Not verified on hardware.";
            sw = rw;
            hw = r;
        } flag9[9:9];
        field {
            name = "flag10";
            desc = "Control flag, purpose unknown. POSITION seen in hi3520D_vpss.ko (HIGH); MEANING INFERRED from the HAL function name only (LOW) Not verified on hardware.";
            sw = rw;
            hw = r;
        } flag10[10:10];
        field {
            name = "flag11";
            desc = "Control flag, purpose unknown. POSITION seen in hi3520D_vpss.ko (HIGH); MEANING INFERRED from the HAL function name only (LOW) Not verified on hardware.";
            sw = rw;
            hw = r;
        } flag11[11:11];
        field {
            name = "flag12";
            desc = "Control flag, purpose unknown. POSITION seen in hi3520D_vpss.ko (HIGH); MEANING INFERRED from the HAL function name only (LOW) Not verified on hardware.";
            sw = rw;
            hw = r;
        } flag12[12:12];
        field {
            name = "flag13";
            desc = "Control flag, purpose unknown. POSITION seen in hi3520D_vpss.ko (HIGH); MEANING INFERRED from the HAL function name only (LOW) Not verified on hardware.";
            sw = rw;
            hw = r;
        } flag13[13:13];
        field {
            name = "flag14";
            desc = "Control flag, purpose unknown. POSITION seen in hi3520D_vpss.ko (HIGH); MEANING INFERRED from the HAL function name only (LOW) Not verified on hardware.";
            sw = rw;
            hw = r;
        } flag14[14:14];
        field {
            name = "flag15";
            desc = "Control flag, purpose unknown. POSITION seen in hi3520D_vpss.ko (HIGH); MEANING INFERRED from the HAL function name only (LOW) Not verified on hardware.";
            sw = rw;
            hw = r;
        } flag15[15:15];
        field {
            name = "flag16";
            desc = "Control flag, purpose unknown. POSITION seen in hi3520D_vpss.ko (HIGH); MEANING INFERRED from the HAL function name only (LOW) Not verified on hardware.";
            sw = rw;
            hw = r;
        } flag16[16:16];
        field {
            name = "flag17";
            desc = "Control flag, purpose unknown. POSITION seen in hi3520D_vpss.ko (HIGH); MEANING INFERRED from the HAL function name only (LOW) Not verified on hardware.";
            sw = rw;
            hw = r;
        } flag17[17:17];
        field {
            name = "flag18";
            desc = "Control flag, purpose unknown. POSITION seen in hi3520D_vpss.ko (HIGH); MEANING INFERRED from the HAL function name only (LOW) Not verified on hardware.";
            sw = rw;
            hw = r;
        } flag18[18:18];
        field {
            name = "flag19";
            desc = "Control flag, purpose unknown. POSITION seen in hi3520D_vpss.ko (HIGH); MEANING INFERRED from the HAL function name only (LOW) Not verified on hardware.";
            sw = rw;
            hw = r;
        } flag19[19:19];
        field {
            name = "flag20";
            desc = "Control flag, purpose unknown. POSITION seen in hi3520D_vpss.ko (HIGH); MEANING INFERRED from the HAL function name only (LOW) Not verified on hardware.";
            sw = rw;
            hw = r;
        } flag20[20:20];
        field {
            name = "flag21";
            desc = "Control flag, purpose unknown. POSITION seen in hi3520D_vpss.ko (HIGH); MEANING INFERRED from the HAL function name only (LOW) Not verified on hardware.";
            sw = rw;
            hw = r;
        } flag21[21:21];
        field {
            name = "mode_a";
            desc = "2-bit control field, purpose unknown. POSITION seen in hi3520D_vpss.ko (HIGH); MEANING INFERRED from the HAL function name only (LOW) Not verified on hardware.";
            sw = rw;
            hw = r;
        } mode_a[25:24];
        field {
            name = "mode_b";
            desc = "2-bit control field, purpose unknown. POSITION seen in hi3520D_vpss.ko (HIGH); MEANING INFERRED from the HAL function name only (LOW) Not verified on hardware.";
            sw = rw;
            hw = r;
        } mode_b[27:26];
        field {
            name = "mode_c";
            desc = "2-bit control field, purpose unknown. POSITION seen in hi3520D_vpss.ko (HIGH); MEANING INFERRED from the HAL function name only (LOW) Not verified on hardware.";
            sw = rw;
            hw = r;
        } mode_c[29:28];
    } N_CTRL @ 0x000;

    reg {
        name = "Source image size (VPSS_HAL_SetSrcImgSize)";
        desc = "Node image offset 0x004.  Source: hi3520D_vpss.ko. Not verified on hardware.";
        field {
            name = "width";
            desc = "Width. POSITION seen in hi3520D_vpss.ko (HIGH); MEANING INFERRED from the HAL function name only (LOW) Not verified on hardware.";
            sw = rw;
            hw = r;
        } width[11:0];
        field {
            name = "height";
            desc = "Height. POSITION seen in hi3520D_vpss.ko (HIGH); MEANING INFERRED from the HAL function name only (LOW) Not verified on hardware.";
            sw = rw;
            hw = r;
        } height[27:16];
    } N_SRC_IMG_SIZE @ 0x004;

    reg {
        name = "Channel image size, one of four (VPSS_HAL_SetChnImgSize)";
        desc = "Node image offset 0x008. The four words are the four channel slots of the 4-case jump table; which slot is which channel number was not resolved (the compiler may have reordered the cases), so the index in the name is the word order, not a channel number. The data sheet lists 3 encoding channels plus 1 display/extra channel for the later generation and up to 3 scaled outputs for this one (GUESS, LOW).  Source: hi3520D_vpss.ko. Not verified on hardware.";
        field {
            name = "width";
            desc = "Width. POSITION seen in hi3520D_vpss.ko (HIGH); MEANING INFERRED from the HAL function name only (LOW) Not verified on hardware.";
            sw = rw;
            hw = r;
        } width[11:0];
        field {
            name = "height";
            desc = "Height. POSITION seen in hi3520D_vpss.ko (HIGH); MEANING INFERRED from the HAL function name only (LOW) Not verified on hardware.";
            sw = rw;
            hw = r;
        } height[27:16];
    } N_CH_IMG_SIZE_0 @ 0x008;

    reg {
        name = "Channel image size, one of four (VPSS_HAL_SetChnImgSize)";
        desc = "Node image offset 0x00C. The four words are the four channel slots of the 4-case jump table; which slot is which channel number was not resolved (the compiler may have reordered the cases), so the index in the name is the word order, not a channel number. The data sheet lists 3 encoding channels plus 1 display/extra channel for the later generation and up to 3 scaled outputs for this one (GUESS, LOW).  Source: hi3520D_vpss.ko. Not verified on hardware.";
        field {
            name = "width";
            desc = "Width. POSITION seen in hi3520D_vpss.ko (HIGH); MEANING INFERRED from the HAL function name only (LOW) Not verified on hardware.";
            sw = rw;
            hw = r;
        } width[11:0];
        field {
            name = "height";
            desc = "Height. POSITION seen in hi3520D_vpss.ko (HIGH); MEANING INFERRED from the HAL function name only (LOW) Not verified on hardware.";
            sw = rw;
            hw = r;
        } height[27:16];
    } N_CH_IMG_SIZE_1 @ 0x00C;

    reg {
        name = "Channel image size, one of four (VPSS_HAL_SetChnImgSize)";
        desc = "Node image offset 0x010. The four words are the four channel slots of the 4-case jump table; which slot is which channel number was not resolved (the compiler may have reordered the cases), so the index in the name is the word order, not a channel number. The data sheet lists 3 encoding channels plus 1 display/extra channel for the later generation and up to 3 scaled outputs for this one (GUESS, LOW).  Source: hi3520D_vpss.ko. Not verified on hardware.";
        field {
            name = "width";
            desc = "Width. POSITION seen in hi3520D_vpss.ko (HIGH); MEANING INFERRED from the HAL function name only (LOW) Not verified on hardware.";
            sw = rw;
            hw = r;
        } width[11:0];
        field {
            name = "height";
            desc = "Height. POSITION seen in hi3520D_vpss.ko (HIGH); MEANING INFERRED from the HAL function name only (LOW) Not verified on hardware.";
            sw = rw;
            hw = r;
        } height[27:16];
    } N_CH_IMG_SIZE_2 @ 0x010;

    reg {
        name = "Channel image size, one of four (VPSS_HAL_SetChnImgSize)";
        desc = "Node image offset 0x014. The four words are the four channel slots of the 4-case jump table; which slot is which channel number was not resolved (the compiler may have reordered the cases), so the index in the name is the word order, not a channel number. The data sheet lists 3 encoding channels plus 1 display/extra channel for the later generation and up to 3 scaled outputs for this one (GUESS, LOW).  Source: hi3520D_vpss.ko. Not verified on hardware.";
        field {
            name = "width";
            desc = "Width. POSITION seen in hi3520D_vpss.ko (HIGH); MEANING INFERRED from the HAL function name only (LOW) Not verified on hardware.";
            sw = rw;
            hw = r;
        } width[11:0];
        field {
            name = "height";
            desc = "Height. POSITION seen in hi3520D_vpss.ko (HIGH); MEANING INFERRED from the HAL function name only (LOW) Not verified on hardware.";
            sw = rw;
            hw = r;
        } height[27:16];
    } N_CH_IMG_SIZE_3 @ 0x014;

    reg {
        name = "Source crop (VPSS_HAL_SetSrcImgCrop)";
        desc = "Node image offset 0x018.  Source: hi3520D_vpss.ko. Not verified on hardware.";
        field {
            name = "x";
            desc = "Crop start X. POSITION seen in hi3520D_vpss.ko (HIGH); MEANING INFERRED from the HAL function name only (LOW) Not verified on hardware.";
            sw = rw;
            hw = r;
        } x[11:0];
        field {
            name = "y";
            desc = "Crop start Y. POSITION seen in hi3520D_vpss.ko (HIGH); MEANING INFERRED from the HAL function name only (LOW) Not verified on hardware.";
            sw = rw;
            hw = r;
        } y[27:16];
    } N_SRC_IMG_CROP @ 0x018;

    reg {
        name = "Channel crop, one of four (VPSS_HAL_SetChnCrop)";
        desc = "Node image offset 0x01C. Slot order as CH_IMG_SIZE.  Source: hi3520D_vpss.ko. Not verified on hardware.";
        field {
            name = "x";
            desc = "Crop start X. POSITION seen in hi3520D_vpss.ko (HIGH); MEANING INFERRED from the HAL function name only (LOW) Not verified on hardware.";
            sw = rw;
            hw = r;
        } x[11:0];
        field {
            name = "y";
            desc = "Crop start Y. POSITION seen in hi3520D_vpss.ko (HIGH); MEANING INFERRED from the HAL function name only (LOW) Not verified on hardware.";
            sw = rw;
            hw = r;
        } y[27:16];
    } N_CH_CROP_0 @ 0x01C;

    reg {
        name = "Channel crop, one of four (VPSS_HAL_SetChnCrop)";
        desc = "Node image offset 0x020. Slot order as CH_IMG_SIZE.  Source: hi3520D_vpss.ko. Not verified on hardware.";
        field {
            name = "x";
            desc = "Crop start X. POSITION seen in hi3520D_vpss.ko (HIGH); MEANING INFERRED from the HAL function name only (LOW) Not verified on hardware.";
            sw = rw;
            hw = r;
        } x[11:0];
        field {
            name = "y";
            desc = "Crop start Y. POSITION seen in hi3520D_vpss.ko (HIGH); MEANING INFERRED from the HAL function name only (LOW) Not verified on hardware.";
            sw = rw;
            hw = r;
        } y[27:16];
    } N_CH_CROP_1 @ 0x020;

    reg {
        name = "Channel crop, one of four (VPSS_HAL_SetChnCrop)";
        desc = "Node image offset 0x024. Slot order as CH_IMG_SIZE.  Source: hi3520D_vpss.ko. Not verified on hardware.";
        field {
            name = "x";
            desc = "Crop start X. POSITION seen in hi3520D_vpss.ko (HIGH); MEANING INFERRED from the HAL function name only (LOW) Not verified on hardware.";
            sw = rw;
            hw = r;
        } x[11:0];
        field {
            name = "y";
            desc = "Crop start Y. POSITION seen in hi3520D_vpss.ko (HIGH); MEANING INFERRED from the HAL function name only (LOW) Not verified on hardware.";
            sw = rw;
            hw = r;
        } y[27:16];
    } N_CH_CROP_2 @ 0x024;

    reg {
        name = "Channel crop, one of four (VPSS_HAL_SetChnCrop)";
        desc = "Node image offset 0x028. Slot order as CH_IMG_SIZE.  Source: hi3520D_vpss.ko. Not verified on hardware.";
        field {
            name = "x";
            desc = "Crop start X. POSITION seen in hi3520D_vpss.ko (HIGH); MEANING INFERRED from the HAL function name only (LOW) Not verified on hardware.";
            sw = rw;
            hw = r;
        } x[11:0];
        field {
            name = "y";
            desc = "Crop start Y. POSITION seen in hi3520D_vpss.ko (HIGH); MEANING INFERRED from the HAL function name only (LOW) Not verified on hardware.";
            sw = rw;
            hw = r;
        } y[27:16];
    } N_CH_CROP_3 @ 0x028;

    reg {
        name = "Channel frame-work words (VPSS_HAL_SetChnFrameWork), part 1";
        desc = "Node image offset 0x02C. VPSS_HAL_SetChnFrameWork writes six words in four jump-table cases: 0x2C and 0x38 each hold two 4x4-bit groups (a channel pair uses [31:16], the other [15:0]), 0x30/0x34/0x3C/0x40 hold three bytes at [7:0], [15:8], [23:16]. 'Frame work' is the vendor name of a per-channel structure (probably the output frame geometry/format handling: the byte triples look like per-plane or per-field values); the semantic was UNKNOWN. Vendor pass 2026-11-11 (VpssCalcFramework, VPSS_DRV_CheckChnFrameWork): 'frame work' is a per-channel BORDER drawn around the picture: the four nibbles are four border widths (each must be even and <= 14, checked by VPSS_DRV_CheckChnFrameWork, error 'frame width'), the byte triple is the border color in Y [7:0], Cb [15:8], Cr [23:16] (software converts a 24-bit RGB color with the BT.601 integer formula Y=((66R+129G+25B)>>8)+16, Cb=((-38R-74G+112B)>>8)+128, Cr=((112R-94G-18B)>>8)+128; all four colors of a channel must be equal). Channel to word map (HAL jump table): chn0 = 0x2C[15:0] + color 0x30, chn1 = 0x2C[31:16] + color 0x34, chn2 = 0x38[15:0] + color 0x3C, chn3 = 0x38[31:16] + color 0x40. Confidence: word/bit layout HIGH, 'border' meaning MEDIUM (inferred from the check function and the RGB conversion; which nibble is top/bottom/left/right is not known).  Source: hi3520D_vpss.ko. Not verified on hardware.";
        field {
            name = "nib0";
            desc = "4-bit value. POSITION seen in hi3520D_vpss.ko (HIGH); MEANING INFERRED from the HAL function name only (LOW) Not verified on hardware.";
            sw = rw;
            hw = r;
        } nib0[3:0];
        field {
            name = "nib1";
            desc = "4-bit value. POSITION seen in hi3520D_vpss.ko (HIGH); MEANING INFERRED from the HAL function name only (LOW) Not verified on hardware.";
            sw = rw;
            hw = r;
        } nib1[7:4];
        field {
            name = "nib2";
            desc = "4-bit value. POSITION seen in hi3520D_vpss.ko (HIGH); MEANING INFERRED from the HAL function name only (LOW) Not verified on hardware.";
            sw = rw;
            hw = r;
        } nib2[11:8];
        field {
            name = "nib3";
            desc = "4-bit value. POSITION seen in hi3520D_vpss.ko (HIGH); MEANING INFERRED from the HAL function name only (LOW) Not verified on hardware.";
            sw = rw;
            hw = r;
        } nib3[15:12];
        field {
            name = "nib4";
            desc = "4-bit value. POSITION seen in hi3520D_vpss.ko (HIGH); MEANING INFERRED from the HAL function name only (LOW) Not verified on hardware.";
            sw = rw;
            hw = r;
        } nib4[19:16];
        field {
            name = "nib5";
            desc = "4-bit value. POSITION seen in hi3520D_vpss.ko (HIGH); MEANING INFERRED from the HAL function name only (LOW) Not verified on hardware.";
            sw = rw;
            hw = r;
        } nib5[23:20];
        field {
            name = "nib6";
            desc = "4-bit value. POSITION seen in hi3520D_vpss.ko (HIGH); MEANING INFERRED from the HAL function name only (LOW) Not verified on hardware.";
            sw = rw;
            hw = r;
        } nib6[27:24];
        field {
            name = "nib7";
            desc = "4-bit value. POSITION seen in hi3520D_vpss.ko (HIGH); MEANING INFERRED from the HAL function name only (LOW) Not verified on hardware.";
            sw = rw;
            hw = r;
        } nib7[31:28];
    } N_CH_FRAMEWORK_A @ 0x02C;

    reg {
        name = "Channel frame-work words, part 2";
        desc = "Node image offset 0x030. See CH_FRAMEWORK_A.  Source: hi3520D_vpss.ko. Not verified on hardware.";
        field {
            name = "b0";
            desc = "Byte. POSITION seen in hi3520D_vpss.ko (HIGH); MEANING INFERRED from the HAL function name only (LOW) Not verified on hardware.";
            sw = rw;
            hw = r;
        } b0[7:0];
        field {
            name = "b1";
            desc = "Byte. POSITION seen in hi3520D_vpss.ko (HIGH); MEANING INFERRED from the HAL function name only (LOW) Not verified on hardware.";
            sw = rw;
            hw = r;
        } b1[15:8];
        field {
            name = "b2";
            desc = "Byte. POSITION seen in hi3520D_vpss.ko (HIGH); MEANING INFERRED from the HAL function name only (LOW) Not verified on hardware.";
            sw = rw;
            hw = r;
        } b2[23:16];
    } N_CH_FRAMEWORK_B @ 0x030;

    reg {
        name = "Channel frame-work words, part 3";
        desc = "Node image offset 0x034. See CH_FRAMEWORK_A.  Source: hi3520D_vpss.ko. Not verified on hardware.";
        field {
            name = "b0";
            desc = "Byte. POSITION seen in hi3520D_vpss.ko (HIGH); MEANING INFERRED from the HAL function name only (LOW) Not verified on hardware.";
            sw = rw;
            hw = r;
        } b0[7:0];
        field {
            name = "b1";
            desc = "Byte. POSITION seen in hi3520D_vpss.ko (HIGH); MEANING INFERRED from the HAL function name only (LOW) Not verified on hardware.";
            sw = rw;
            hw = r;
        } b1[15:8];
        field {
            name = "b2";
            desc = "Byte. POSITION seen in hi3520D_vpss.ko (HIGH); MEANING INFERRED from the HAL function name only (LOW) Not verified on hardware.";
            sw = rw;
            hw = r;
        } b2[23:16];
    } N_CH_FRAMEWORK_C @ 0x034;

    reg {
        name = "Channel frame-work words, part 4";
        desc = "Node image offset 0x038. See CH_FRAMEWORK_A.  Source: hi3520D_vpss.ko. Not verified on hardware.";
        field {
            name = "nib0";
            desc = "4-bit value. POSITION seen in hi3520D_vpss.ko (HIGH); MEANING INFERRED from the HAL function name only (LOW) Not verified on hardware.";
            sw = rw;
            hw = r;
        } nib0[3:0];
        field {
            name = "nib1";
            desc = "4-bit value. POSITION seen in hi3520D_vpss.ko (HIGH); MEANING INFERRED from the HAL function name only (LOW) Not verified on hardware.";
            sw = rw;
            hw = r;
        } nib1[7:4];
        field {
            name = "nib2";
            desc = "4-bit value. POSITION seen in hi3520D_vpss.ko (HIGH); MEANING INFERRED from the HAL function name only (LOW) Not verified on hardware.";
            sw = rw;
            hw = r;
        } nib2[11:8];
        field {
            name = "nib3";
            desc = "4-bit value. POSITION seen in hi3520D_vpss.ko (HIGH); MEANING INFERRED from the HAL function name only (LOW) Not verified on hardware.";
            sw = rw;
            hw = r;
        } nib3[15:12];
        field {
            name = "nib4";
            desc = "4-bit value. POSITION seen in hi3520D_vpss.ko (HIGH); MEANING INFERRED from the HAL function name only (LOW) Not verified on hardware.";
            sw = rw;
            hw = r;
        } nib4[19:16];
        field {
            name = "nib5";
            desc = "4-bit value. POSITION seen in hi3520D_vpss.ko (HIGH); MEANING INFERRED from the HAL function name only (LOW) Not verified on hardware.";
            sw = rw;
            hw = r;
        } nib5[23:20];
        field {
            name = "nib6";
            desc = "4-bit value. POSITION seen in hi3520D_vpss.ko (HIGH); MEANING INFERRED from the HAL function name only (LOW) Not verified on hardware.";
            sw = rw;
            hw = r;
        } nib6[27:24];
        field {
            name = "nib7";
            desc = "4-bit value. POSITION seen in hi3520D_vpss.ko (HIGH); MEANING INFERRED from the HAL function name only (LOW) Not verified on hardware.";
            sw = rw;
            hw = r;
        } nib7[31:28];
    } N_CH_FRAMEWORK_D @ 0x038;

    reg {
        name = "Channel frame-work words, part 5";
        desc = "Node image offset 0x03C. See CH_FRAMEWORK_A.  Source: hi3520D_vpss.ko. Not verified on hardware.";
        field {
            name = "b0";
            desc = "Byte. POSITION seen in hi3520D_vpss.ko (HIGH); MEANING INFERRED from the HAL function name only (LOW) Not verified on hardware.";
            sw = rw;
            hw = r;
        } b0[7:0];
        field {
            name = "b1";
            desc = "Byte. POSITION seen in hi3520D_vpss.ko (HIGH); MEANING INFERRED from the HAL function name only (LOW) Not verified on hardware.";
            sw = rw;
            hw = r;
        } b1[15:8];
        field {
            name = "b2";
            desc = "Byte. POSITION seen in hi3520D_vpss.ko (HIGH); MEANING INFERRED from the HAL function name only (LOW) Not verified on hardware.";
            sw = rw;
            hw = r;
        } b2[23:16];
    } N_CH_FRAMEWORK_E @ 0x03C;

    reg {
        name = "Channel frame-work words, part 6";
        desc = "Node image offset 0x040. See CH_FRAMEWORK_A.  Source: hi3520D_vpss.ko. Not verified on hardware.";
        field {
            name = "b0";
            desc = "Byte. POSITION seen in hi3520D_vpss.ko (HIGH); MEANING INFERRED from the HAL function name only (LOW) Not verified on hardware.";
            sw = rw;
            hw = r;
        } b0[7:0];
        field {
            name = "b1";
            desc = "Byte. POSITION seen in hi3520D_vpss.ko (HIGH); MEANING INFERRED from the HAL function name only (LOW) Not verified on hardware.";
            sw = rw;
            hw = r;
        } b1[15:8];
        field {
            name = "b2";
            desc = "Byte. POSITION seen in hi3520D_vpss.ko (HIGH); MEANING INFERRED from the HAL function name only (LOW) Not verified on hardware.";
            sw = rw;
            hw = r;
        } b2[23:16];
    } N_CH_FRAMEWORK_F @ 0x040;

    reg {
        name = "Current picture luma address";
        desc = "Node image offset 0x060. VPSS_HAL_SetCurPicAddr: first word of the picture triple.  Source: hi3520D_vpss.ko. Not verified on hardware.";
        field {
            name = "val";
            desc = "Physical address. POSITION seen in hi3520D_vpss.ko (HIGH); MEANING INFERRED from the HAL function name only (LOW) Not verified on hardware.";
            sw = rw;
            hw = r;
        } val[31:0];
    } N_CUR_PIC_Y @ 0x060;

    reg {
        name = "Current picture chroma address";
        desc = "Node image offset 0x064. Second word of the triple.  Source: hi3520D_vpss.ko. Not verified on hardware.";
        field {
            name = "val";
            desc = "Physical address. POSITION seen in hi3520D_vpss.ko (HIGH); MEANING INFERRED from the HAL function name only (LOW) Not verified on hardware.";
            sw = rw;
            hw = r;
        } val[31:0];
    } N_CUR_PIC_C @ 0x064;

    reg {
        name = "Current picture strides";
        desc = "Node image offset 0x068. Third word of the triple.  Source: hi3520D_vpss.ko. Not verified on hardware.";
        field {
            name = "y_stride";
            desc = "Luma stride. POSITION seen in hi3520D_vpss.ko (HIGH); MEANING INFERRED from the HAL function name only (LOW) Not verified on hardware.";
            sw = rw;
            hw = r;
        } y_stride[15:0];
        field {
            name = "c_stride";
            desc = "Chroma stride. POSITION seen in hi3520D_vpss.ko (HIGH); MEANING INFERRED from the HAL function name only (LOW) Not verified on hardware.";
            sw = rw;
            hw = r;
        } c_stride[31:16];
    } N_CUR_PIC_STRIDE @ 0x068;

    reg {
        name = "Reference picture luma address";
        desc = "Node image offset 0x06C. VPSS_HAL_SetRefPicAddr: first word of the picture triple.  Source: hi3520D_vpss.ko. Not verified on hardware.";
        field {
            name = "val";
            desc = "Physical address. POSITION seen in hi3520D_vpss.ko (HIGH); MEANING INFERRED from the HAL function name only (LOW) Not verified on hardware.";
            sw = rw;
            hw = r;
        } val[31:0];
    } N_REF_PIC_Y @ 0x06C;

    reg {
        name = "Reference picture chroma address";
        desc = "Node image offset 0x070. Second word of the triple.  Source: hi3520D_vpss.ko. Not verified on hardware.";
        field {
            name = "val";
            desc = "Physical address. POSITION seen in hi3520D_vpss.ko (HIGH); MEANING INFERRED from the HAL function name only (LOW) Not verified on hardware.";
            sw = rw;
            hw = r;
        } val[31:0];
    } N_REF_PIC_C @ 0x070;

    reg {
        name = "Reference picture strides";
        desc = "Node image offset 0x074. Third word of the triple.  Source: hi3520D_vpss.ko. Not verified on hardware.";
        field {
            name = "y_stride";
            desc = "Luma stride. POSITION seen in hi3520D_vpss.ko (HIGH); MEANING INFERRED from the HAL function name only (LOW) Not verified on hardware.";
            sw = rw;
            hw = r;
        } y_stride[15:0];
        field {
            name = "c_stride";
            desc = "Chroma stride. POSITION seen in hi3520D_vpss.ko (HIGH); MEANING INFERRED from the HAL function name only (LOW) Not verified on hardware.";
            sw = rw;
            hw = r;
        } c_stride[31:16];
    } N_REF_PIC_STRIDE @ 0x074;

    reg {
        name = "Motion-analysis (MAD) read address";
        desc = "Node image offset 0x078. VPSS_HAL_SetMadAddr writes the same address to 0x78 and 0x7C (read/write MAD buffers) and the stride at 0x80 [15:0]. Probably the 3D-NR / de-interlace motion data buffer (GUESS, LOW).  Source: hi3520D_vpss.ko. Not verified on hardware.";
        field {
            name = "val";
            desc = "Physical address. POSITION seen in hi3520D_vpss.ko (HIGH); MEANING INFERRED from the HAL function name only (LOW) Not verified on hardware.";
            sw = rw;
            hw = r;
        } val[31:0];
    } N_MAD_ADDR_RD @ 0x078;

    reg {
        name = "Motion-analysis (MAD) write address";
        desc = "Node image offset 0x07C. See MAD_ADDR_RD.  Source: hi3520D_vpss.ko. Not verified on hardware.";
        field {
            name = "val";
            desc = "Physical address. POSITION seen in hi3520D_vpss.ko (HIGH); MEANING INFERRED from the HAL function name only (LOW) Not verified on hardware.";
            sw = rw;
            hw = r;
        } val[31:0];
    } N_MAD_ADDR_WR @ 0x07C;

    reg {
        name = "Motion-analysis stride";
        desc = "Node image offset 0x080.  Source: hi3520D_vpss.ko. Not verified on hardware.";
        field {
            name = "stride";
            desc = "Stride. POSITION seen in hi3520D_vpss.ko (HIGH); MEANING INFERRED from the HAL function name only (LOW) Not verified on hardware.";
            sw = rw;
            hw = r;
        } stride[15:0];
    } N_MAD_STRIDE @ 0x080;

    reg {
        name = "De-interlace / ST buffer read address (VPSS_HAL_SetDieAddr, SetStAddr)";
        desc = "Node image offset 0x084. SetDieAddr writes 0x84 and 0x88 and the stride into 0x8C [15:0]; SetStAddr writes the same address to both (ST = state buffer, probably the DEI/NR history; GUESS, LOW).  Source: hi3520D_vpss.ko. Not verified on hardware.";
        field {
            name = "val";
            desc = "Physical address. POSITION seen in hi3520D_vpss.ko (HIGH); MEANING INFERRED from the HAL function name only (LOW) Not verified on hardware.";
            sw = rw;
            hw = r;
        } val[31:0];
    } N_DIE_ADDR_RD @ 0x084;

    reg {
        name = "De-interlace / ST buffer write address";
        desc = "Node image offset 0x088. See DIE_ADDR_RD.  Source: hi3520D_vpss.ko. Not verified on hardware.";
        field {
            name = "val";
            desc = "Physical address. POSITION seen in hi3520D_vpss.ko (HIGH); MEANING INFERRED from the HAL function name only (LOW) Not verified on hardware.";
            sw = rw;
            hw = r;
        } val[31:0];
    } N_DIE_ADDR_WR @ 0x088;

    reg {
        name = "De-interlace / ST stride";
        desc = "Node image offset 0x08C.  Source: hi3520D_vpss.ko. Not verified on hardware.";
        field {
            name = "stride";
            desc = "Stride. POSITION seen in hi3520D_vpss.ko (HIGH); MEANING INFERRED from the HAL function name only (LOW) Not verified on hardware.";
            sw = rw;
            hw = r;
        } stride[15:0];
    } N_DIE_STRIDE @ 0x08C;

    reg {
        name = "Histogram buffer address 0 (VPSS_HAL_SetHistAddr)";
        desc = "Node image offset 0x090. Two histogram buffer addresses (the vendor driver swaps them each frame: VPSS_DRV_HistBuffSwapStrategy).  Source: hi3520D_vpss.ko. Not verified on hardware.";
        field {
            name = "val";
            desc = "Physical address. POSITION seen in hi3520D_vpss.ko (HIGH); MEANING INFERRED from the HAL function name only (LOW) Not verified on hardware.";
            sw = rw;
            hw = r;
        } val[31:0];
    } N_HIST_ADDR_0 @ 0x090;

    reg {
        name = "Histogram buffer address 1";
        desc = "Node image offset 0x094.  Source: hi3520D_vpss.ko. Not verified on hardware.";
        field {
            name = "val";
            desc = "Physical address. POSITION seen in hi3520D_vpss.ko (HIGH); MEANING INFERRED from the HAL function name only (LOW) Not verified on hardware.";
            sw = rw;
            hw = r;
        } val[31:0];
    } N_HIST_ADDR_1 @ 0x094;

    reg {
        name = "Channel output 0 luma address (VPSS_HAL_SetChnPicAddr)";
        desc = "Node image offset 0x0A0. Slot order as CH_IMG_SIZE (word order, not a verified channel number). Per channel a triple (Y address, C address, strides); the stride word of the fourth triple is at 0xD0, not at 0xCC (as seen in the code).  Source: hi3520D_vpss.ko. Not verified on hardware.";
        field {
            name = "val";
            desc = "Physical address. POSITION seen in hi3520D_vpss.ko (HIGH); MEANING INFERRED from the HAL function name only (LOW) Not verified on hardware.";
            sw = rw;
            hw = r;
        } val[31:0];
    } N_CH0_Y @ 0x0A0;

    reg {
        name = "Channel output 0 chroma address";
        desc = "Node image offset 0x0A4.  Source: hi3520D_vpss.ko. Not verified on hardware.";
        field {
            name = "val";
            desc = "Physical address. POSITION seen in hi3520D_vpss.ko (HIGH); MEANING INFERRED from the HAL function name only (LOW) Not verified on hardware.";
            sw = rw;
            hw = r;
        } val[31:0];
    } N_CH0_C @ 0x0A4;

    reg {
        name = "Channel output 0 strides";
        desc = "Node image offset 0x0A8.  Source: hi3520D_vpss.ko. Not verified on hardware.";
        field {
            name = "y_stride";
            desc = "Luma stride. POSITION seen in hi3520D_vpss.ko (HIGH); MEANING INFERRED from the HAL function name only (LOW) Not verified on hardware.";
            sw = rw;
            hw = r;
        } y_stride[15:0];
        field {
            name = "c_stride";
            desc = "Chroma stride. POSITION seen in hi3520D_vpss.ko (HIGH); MEANING INFERRED from the HAL function name only (LOW) Not verified on hardware.";
            sw = rw;
            hw = r;
        } c_stride[31:16];
    } N_CH0_STRIDE @ 0x0A8;

    reg {
        name = "Channel output 1 luma address (VPSS_HAL_SetChnPicAddr)";
        desc = "Node image offset 0x0AC. Slot order as CH_IMG_SIZE (word order, not a verified channel number). Per channel a triple (Y address, C address, strides); the stride word of the fourth triple is at 0xD0, not at 0xCC (as seen in the code).  Source: hi3520D_vpss.ko. Not verified on hardware.";
        field {
            name = "val";
            desc = "Physical address. POSITION seen in hi3520D_vpss.ko (HIGH); MEANING INFERRED from the HAL function name only (LOW) Not verified on hardware.";
            sw = rw;
            hw = r;
        } val[31:0];
    } N_CH1_Y @ 0x0AC;

    reg {
        name = "Channel output 1 chroma address";
        desc = "Node image offset 0x0B0.  Source: hi3520D_vpss.ko. Not verified on hardware.";
        field {
            name = "val";
            desc = "Physical address. POSITION seen in hi3520D_vpss.ko (HIGH); MEANING INFERRED from the HAL function name only (LOW) Not verified on hardware.";
            sw = rw;
            hw = r;
        } val[31:0];
    } N_CH1_C @ 0x0B0;

    reg {
        name = "Channel output 1 strides";
        desc = "Node image offset 0x0B4.  Source: hi3520D_vpss.ko. Not verified on hardware.";
        field {
            name = "y_stride";
            desc = "Luma stride. POSITION seen in hi3520D_vpss.ko (HIGH); MEANING INFERRED from the HAL function name only (LOW) Not verified on hardware.";
            sw = rw;
            hw = r;
        } y_stride[15:0];
        field {
            name = "c_stride";
            desc = "Chroma stride. POSITION seen in hi3520D_vpss.ko (HIGH); MEANING INFERRED from the HAL function name only (LOW) Not verified on hardware.";
            sw = rw;
            hw = r;
        } c_stride[31:16];
    } N_CH1_STRIDE @ 0x0B4;

    reg {
        name = "Channel output 2 luma address (VPSS_HAL_SetChnPicAddr)";
        desc = "Node image offset 0x0B8. Slot order as CH_IMG_SIZE (word order, not a verified channel number). Per channel a triple (Y address, C address, strides); the stride word of the fourth triple is at 0xD0, not at 0xCC (as seen in the code).  Source: hi3520D_vpss.ko. Not verified on hardware.";
        field {
            name = "val";
            desc = "Physical address. POSITION seen in hi3520D_vpss.ko (HIGH); MEANING INFERRED from the HAL function name only (LOW) Not verified on hardware.";
            sw = rw;
            hw = r;
        } val[31:0];
    } N_CH2_Y @ 0x0B8;

    reg {
        name = "Channel output 2 chroma address";
        desc = "Node image offset 0x0BC.  Source: hi3520D_vpss.ko. Not verified on hardware.";
        field {
            name = "val";
            desc = "Physical address. POSITION seen in hi3520D_vpss.ko (HIGH); MEANING INFERRED from the HAL function name only (LOW) Not verified on hardware.";
            sw = rw;
            hw = r;
        } val[31:0];
    } N_CH2_C @ 0x0BC;

    reg {
        name = "Channel output 2 strides";
        desc = "Node image offset 0x0C0.  Source: hi3520D_vpss.ko. Not verified on hardware.";
        field {
            name = "y_stride";
            desc = "Luma stride. POSITION seen in hi3520D_vpss.ko (HIGH); MEANING INFERRED from the HAL function name only (LOW) Not verified on hardware.";
            sw = rw;
            hw = r;
        } y_stride[15:0];
        field {
            name = "c_stride";
            desc = "Chroma stride. POSITION seen in hi3520D_vpss.ko (HIGH); MEANING INFERRED from the HAL function name only (LOW) Not verified on hardware.";
            sw = rw;
            hw = r;
        } c_stride[31:16];
    } N_CH2_STRIDE @ 0x0C0;

    reg {
        name = "Channel output 3 luma address (VPSS_HAL_SetChnPicAddr)";
        desc = "Node image offset 0x0C4. Slot order as CH_IMG_SIZE (word order, not a verified channel number). Per channel a triple (Y address, C address, strides); the stride word of the fourth triple is at 0xD0, not at 0xCC (as seen in the code).  Source: hi3520D_vpss.ko. Not verified on hardware.";
        field {
            name = "val";
            desc = "Physical address. POSITION seen in hi3520D_vpss.ko (HIGH); MEANING INFERRED from the HAL function name only (LOW) Not verified on hardware.";
            sw = rw;
            hw = r;
        } val[31:0];
    } N_CH3_Y @ 0x0C4;

    reg {
        name = "Channel output 3 chroma address";
        desc = "Node image offset 0x0C8.  Source: hi3520D_vpss.ko. Not verified on hardware.";
        field {
            name = "val";
            desc = "Physical address. POSITION seen in hi3520D_vpss.ko (HIGH); MEANING INFERRED from the HAL function name only (LOW) Not verified on hardware.";
            sw = rw;
            hw = r;
        } val[31:0];
    } N_CH3_C @ 0x0C8;

    reg {
        name = "Channel output 3 strides";
        desc = "Node image offset 0x0D0.  Source: hi3520D_vpss.ko. Not verified on hardware.";
        field {
            name = "y_stride";
            desc = "Luma stride. POSITION seen in hi3520D_vpss.ko (HIGH); MEANING INFERRED from the HAL function name only (LOW) Not verified on hardware.";
            sw = rw;
            hw = r;
        } y_stride[15:0];
        field {
            name = "c_stride";
            desc = "Chroma stride. POSITION seen in hi3520D_vpss.ko (HIGH); MEANING INFERRED from the HAL function name only (LOW) Not verified on hardware.";
            sw = rw;
            hw = r;
        } c_stride[31:16];
    } N_CH3_STRIDE @ 0x0D0;

    reg {
        name = "Reference-frame-read picture luma address";
        desc = "Node image offset 0x0D4. VPSS_HAL_SetRfrPicAddr: first word of the picture triple.  Source: hi3520D_vpss.ko. Not verified on hardware.";
        field {
            name = "val";
            desc = "Physical address. POSITION seen in hi3520D_vpss.ko (HIGH); MEANING INFERRED from the HAL function name only (LOW) Not verified on hardware.";
            sw = rw;
            hw = r;
        } val[31:0];
    } N_RFR_PIC_Y @ 0x0D4;

    reg {
        name = "Reference-frame-read picture chroma address";
        desc = "Node image offset 0x0D8. Second word of the triple.  Source: hi3520D_vpss.ko. Not verified on hardware.";
        field {
            name = "val";
            desc = "Physical address. POSITION seen in hi3520D_vpss.ko (HIGH); MEANING INFERRED from the HAL function name only (LOW) Not verified on hardware.";
            sw = rw;
            hw = r;
        } val[31:0];
    } N_RFR_PIC_C @ 0x0D8;

    reg {
        name = "Reference-frame-read picture strides";
        desc = "Node image offset 0x0DC. Third word of the triple.  Source: hi3520D_vpss.ko. Not verified on hardware.";
        field {
            name = "y_stride";
            desc = "Luma stride. POSITION seen in hi3520D_vpss.ko (HIGH); MEANING INFERRED from the HAL function name only (LOW) Not verified on hardware.";
            sw = rw;
            hw = r;
        } y_stride[15:0];
        field {
            name = "c_stride";
            desc = "Chroma stride. POSITION seen in hi3520D_vpss.ko (HIGH); MEANING INFERRED from the HAL function name only (LOW) Not verified on hardware.";
            sw = rw;
            hw = r;
        } c_stride[31:16];
    } N_RFR_PIC_STRIDE @ 0x0DC;

    reg {
        name = "Node ID";
        desc = "Node image offset 0x0E0. VPSS_HAL_SetNodeID writes it into the node; the MMIO word at the same offset (VPSS_V100 VPSS_NODE_ID) reads back the ID of the node just completed (INFERRED, MEDIUM).  Source: hi3520D_vpss.ko. Not verified on hardware.";
        field {
            name = "val";
            desc = "Node ID chosen by software (a running counter in VPSS_COMM_HalListInt). POSITION seen in hi3520D_vpss.ko (HIGH); MEANING INFERRED from the HAL function name only (LOW) Not verified on hardware.";
            sw = rw;
            hw = r;
        } val[31:0];
    } N_NODE_ID @ 0x0E0;

    reg {
        name = "Per-node mask";
        desc = "Node image offset 0x0EC. VPSS_HAL_SetMask: VPSS_COMM_HalListInt writes 0 to every node of a list except the last, which gets 7. Most likely the interrupt/completion enable of the node (INFERRED, LOW-MEDIUM); the three set bits [2:0] could be the three outputs.  Source: hi3520D_vpss.ko. Not verified on hardware.";
        field {
            name = "mask";
            desc = "Mask word; 0 for intermediate nodes, 7 for the last. POSITION seen in hi3520D_vpss.ko (HIGH); MEANING INFERRED from the HAL function name only (LOW) Not verified on hardware.";
            sw = rw;
            hw = r;
        } mask[31:0];
    } N_MASK @ 0x0EC;

    reg {
        name = "Channel scaler block 0, word 0 (VPSS_HAL_SetChnSclCfg)";
        desc = "Node image offset 0x200. Four 8-word scaler blocks at 0x200, 0x220, 0x240, 0x260 (slot order as CH_IMG_SIZE). The vendor argument names are not in the module; the data sheet lists scaling and sharpening/peaking for the Hi3520D, so the blocks probably hold the horizontal/vertical scale factors, filter selects and enables of one channel (GUESS, LOW).  Source: hi3520D_vpss.ko. Not verified on hardware.";
        field {
            name = "v0";
            desc = "24-bit value (likely a scaler setting). POSITION seen in hi3520D_vpss.ko (HIGH); MEANING INFERRED from the HAL function name only (LOW) Not verified on hardware.";
            sw = rw;
            hw = r;
        } v0[23:0];
        field {
            name = "flag25";
            desc = "Flag. POSITION seen in hi3520D_vpss.ko (HIGH); MEANING INFERRED from the HAL function name only (LOW) Not verified on hardware.";
            sw = rw;
            hw = r;
        } flag25[25:25];
        field {
            name = "flag26";
            desc = "Flag. POSITION seen in hi3520D_vpss.ko (HIGH); MEANING INFERRED from the HAL function name only (LOW) Not verified on hardware.";
            sw = rw;
            hw = r;
        } flag26[26:26];
        field {
            name = "flag28";
            desc = "Flag. POSITION seen in hi3520D_vpss.ko (HIGH); MEANING INFERRED from the HAL function name only (LOW) Not verified on hardware.";
            sw = rw;
            hw = r;
        } flag28[28:28];
        field {
            name = "flag29";
            desc = "Flag. POSITION seen in hi3520D_vpss.ko (HIGH); MEANING INFERRED from the HAL function name only (LOW) Not verified on hardware.";
            sw = rw;
            hw = r;
        } flag29[29:29];
        field {
            name = "flag30";
            desc = "Flag. POSITION seen in hi3520D_vpss.ko (HIGH); MEANING INFERRED from the HAL function name only (LOW) Not verified on hardware.";
            sw = rw;
            hw = r;
        } flag30[30:30];
        field {
            name = "flag31";
            desc = "Flag. POSITION seen in hi3520D_vpss.ko (HIGH); MEANING INFERRED from the HAL function name only (LOW) Not verified on hardware.";
            sw = rw;
            hw = r;
        } flag31[31:31];
    } N_SCL0_CFG0 @ 0x200;

    reg {
        name = "Channel scaler block 0, word 1";
        desc = "Node image offset 0x204. Probably the horizontal scale factor (28-bit, GUESS, LOW).  Source: hi3520D_vpss.ko. Not verified on hardware.";
        field {
            name = "v";
            desc = "28-bit value. POSITION seen in hi3520D_vpss.ko (HIGH); MEANING INFERRED from the HAL function name only (LOW) Not verified on hardware.";
            sw = rw;
            hw = r;
        } v[27:0];
    } N_SCL0_CFG1 @ 0x204;

    reg {
        name = "Channel scaler block 0, word 2";
        desc = "Node image offset 0x208. Probably the vertical scale factor (28-bit, GUESS, LOW).  Source: hi3520D_vpss.ko. Not verified on hardware.";
        field {
            name = "v";
            desc = "28-bit value. POSITION seen in hi3520D_vpss.ko (HIGH); MEANING INFERRED from the HAL function name only (LOW) Not verified on hardware.";
            sw = rw;
            hw = r;
        } v[27:0];
    } N_SCL0_CFG2 @ 0x208;

    reg {
        name = "Channel scaler block 0, word 3";
        desc = "Node image offset 0x20C. Mixed fields.  Source: hi3520D_vpss.ko. Not verified on hardware.";
        field {
            name = "f19";
            desc = "2-bit field. POSITION seen in hi3520D_vpss.ko (HIGH); MEANING INFERRED from the HAL function name only (LOW) Not verified on hardware.";
            sw = rw;
            hw = r;
        } f19[20:19];
        field {
            name = "f21";
            desc = "2-bit field. POSITION seen in hi3520D_vpss.ko (HIGH); MEANING INFERRED from the HAL function name only (LOW) Not verified on hardware.";
            sw = rw;
            hw = r;
        } f21[22:21];
        field {
            name = "f23";
            desc = "Flag. POSITION seen in hi3520D_vpss.ko (HIGH); MEANING INFERRED from the HAL function name only (LOW) Not verified on hardware.";
            sw = rw;
            hw = r;
        } f23[23:23];
        field {
            name = "f24";
            desc = "Flag. POSITION seen in hi3520D_vpss.ko (HIGH); MEANING INFERRED from the HAL function name only (LOW) Not verified on hardware.";
            sw = rw;
            hw = r;
        } f24[24:24];
        field {
            name = "f26";
            desc = "Flag. POSITION seen in hi3520D_vpss.ko (HIGH); MEANING INFERRED from the HAL function name only (LOW) Not verified on hardware.";
            sw = rw;
            hw = r;
        } f26[26:26];
        field {
            name = "f28";
            desc = "Flag. POSITION seen in hi3520D_vpss.ko (HIGH); MEANING INFERRED from the HAL function name only (LOW) Not verified on hardware.";
            sw = rw;
            hw = r;
        } f28[28:28];
        field {
            name = "f29";
            desc = "Flag. POSITION seen in hi3520D_vpss.ko (HIGH); MEANING INFERRED from the HAL function name only (LOW) Not verified on hardware.";
            sw = rw;
            hw = r;
        } f29[29:29];
        field {
            name = "f30";
            desc = "Flag. POSITION seen in hi3520D_vpss.ko (HIGH); MEANING INFERRED from the HAL function name only (LOW) Not verified on hardware.";
            sw = rw;
            hw = r;
        } f30[30:30];
        field {
            name = "f31";
            desc = "Flag. POSITION seen in hi3520D_vpss.ko (HIGH); MEANING INFERRED from the HAL function name only (LOW) Not verified on hardware.";
            sw = rw;
            hw = r;
        } f31[31:31];
    } N_SCL0_CFG3 @ 0x20C;

    reg {
        name = "Channel scaler block 0, word 4";
        desc = "Node image offset 0x210.  Source: hi3520D_vpss.ko. Not verified on hardware.";
        field {
            name = "v";
            desc = "16-bit value. POSITION seen in hi3520D_vpss.ko (HIGH); MEANING INFERRED from the HAL function name only (LOW) Not verified on hardware.";
            sw = rw;
            hw = r;
        } v[15:0];
    } N_SCL0_CFG4 @ 0x210;

    reg {
        name = "Channel scaler block 0, word 5";
        desc = "Node image offset 0x214.  Source: hi3520D_vpss.ko. Not verified on hardware.";
        field {
            name = "lo";
            desc = "16-bit value. POSITION seen in hi3520D_vpss.ko (HIGH); MEANING INFERRED from the HAL function name only (LOW) Not verified on hardware.";
            sw = rw;
            hw = r;
        } lo[15:0];
        field {
            name = "hi";
            desc = "16-bit value. POSITION seen in hi3520D_vpss.ko (HIGH); MEANING INFERRED from the HAL function name only (LOW) Not verified on hardware.";
            sw = rw;
            hw = r;
        } hi[31:16];
    } N_SCL0_CFG5 @ 0x214;

    reg {
        name = "Channel scaler block 0, word 6";
        desc = "Node image offset 0x218.  Source: hi3520D_vpss.ko. Not verified on hardware.";
        field {
            name = "a";
            desc = "12-bit value (size/offset-like). POSITION seen in hi3520D_vpss.ko (HIGH); MEANING INFERRED from the HAL function name only (LOW) Not verified on hardware.";
            sw = rw;
            hw = r;
        } a[11:0];
        field {
            name = "b";
            desc = "12-bit value. POSITION seen in hi3520D_vpss.ko (HIGH); MEANING INFERRED from the HAL function name only (LOW) Not verified on hardware.";
            sw = rw;
            hw = r;
        } b[23:12];
    } N_SCL0_CFG6 @ 0x218;

    reg {
        name = "Channel scaler block 0, word 7";
        desc = "Node image offset 0x21C.  Source: hi3520D_vpss.ko. Not verified on hardware.";
        field {
            name = "a";
            desc = "12-bit value. POSITION seen in hi3520D_vpss.ko (HIGH); MEANING INFERRED from the HAL function name only (LOW) Not verified on hardware.";
            sw = rw;
            hw = r;
        } a[11:0];
        field {
            name = "b";
            desc = "12-bit value. POSITION seen in hi3520D_vpss.ko (HIGH); MEANING INFERRED from the HAL function name only (LOW) Not verified on hardware.";
            sw = rw;
            hw = r;
        } b[23:12];
    } N_SCL0_CFG7 @ 0x21C;

    reg {
        name = "Channel scaler block 1, word 0 (VPSS_HAL_SetChnSclCfg)";
        desc = "Node image offset 0x220. Four 8-word scaler blocks at 0x200, 0x220, 0x240, 0x260 (slot order as CH_IMG_SIZE). The vendor argument names are not in the module; the data sheet lists scaling and sharpening/peaking for the Hi3520D, so the blocks probably hold the horizontal/vertical scale factors, filter selects and enables of one channel (GUESS, LOW).  Source: hi3520D_vpss.ko. Not verified on hardware.";
        field {
            name = "v0";
            desc = "24-bit value (likely a scaler setting). POSITION seen in hi3520D_vpss.ko (HIGH); MEANING INFERRED from the HAL function name only (LOW) Not verified on hardware.";
            sw = rw;
            hw = r;
        } v0[23:0];
        field {
            name = "flag25";
            desc = "Flag. POSITION seen in hi3520D_vpss.ko (HIGH); MEANING INFERRED from the HAL function name only (LOW) Not verified on hardware.";
            sw = rw;
            hw = r;
        } flag25[25:25];
        field {
            name = "flag26";
            desc = "Flag. POSITION seen in hi3520D_vpss.ko (HIGH); MEANING INFERRED from the HAL function name only (LOW) Not verified on hardware.";
            sw = rw;
            hw = r;
        } flag26[26:26];
        field {
            name = "flag28";
            desc = "Flag. POSITION seen in hi3520D_vpss.ko (HIGH); MEANING INFERRED from the HAL function name only (LOW) Not verified on hardware.";
            sw = rw;
            hw = r;
        } flag28[28:28];
        field {
            name = "flag29";
            desc = "Flag. POSITION seen in hi3520D_vpss.ko (HIGH); MEANING INFERRED from the HAL function name only (LOW) Not verified on hardware.";
            sw = rw;
            hw = r;
        } flag29[29:29];
        field {
            name = "flag30";
            desc = "Flag. POSITION seen in hi3520D_vpss.ko (HIGH); MEANING INFERRED from the HAL function name only (LOW) Not verified on hardware.";
            sw = rw;
            hw = r;
        } flag30[30:30];
        field {
            name = "flag31";
            desc = "Flag. POSITION seen in hi3520D_vpss.ko (HIGH); MEANING INFERRED from the HAL function name only (LOW) Not verified on hardware.";
            sw = rw;
            hw = r;
        } flag31[31:31];
    } N_SCL1_CFG0 @ 0x220;

    reg {
        name = "Channel scaler block 1, word 1";
        desc = "Node image offset 0x224. Probably the horizontal scale factor (28-bit, GUESS, LOW).  Source: hi3520D_vpss.ko. Not verified on hardware.";
        field {
            name = "v";
            desc = "28-bit value. POSITION seen in hi3520D_vpss.ko (HIGH); MEANING INFERRED from the HAL function name only (LOW) Not verified on hardware.";
            sw = rw;
            hw = r;
        } v[27:0];
    } N_SCL1_CFG1 @ 0x224;

    reg {
        name = "Channel scaler block 1, word 2";
        desc = "Node image offset 0x228. Probably the vertical scale factor (28-bit, GUESS, LOW).  Source: hi3520D_vpss.ko. Not verified on hardware.";
        field {
            name = "v";
            desc = "28-bit value. POSITION seen in hi3520D_vpss.ko (HIGH); MEANING INFERRED from the HAL function name only (LOW) Not verified on hardware.";
            sw = rw;
            hw = r;
        } v[27:0];
    } N_SCL1_CFG2 @ 0x228;

    reg {
        name = "Channel scaler block 1, word 3";
        desc = "Node image offset 0x22C. Mixed fields.  Source: hi3520D_vpss.ko. Not verified on hardware.";
        field {
            name = "f19";
            desc = "2-bit field. POSITION seen in hi3520D_vpss.ko (HIGH); MEANING INFERRED from the HAL function name only (LOW) Not verified on hardware.";
            sw = rw;
            hw = r;
        } f19[20:19];
        field {
            name = "f21";
            desc = "2-bit field. POSITION seen in hi3520D_vpss.ko (HIGH); MEANING INFERRED from the HAL function name only (LOW) Not verified on hardware.";
            sw = rw;
            hw = r;
        } f21[22:21];
        field {
            name = "f23";
            desc = "Flag. POSITION seen in hi3520D_vpss.ko (HIGH); MEANING INFERRED from the HAL function name only (LOW) Not verified on hardware.";
            sw = rw;
            hw = r;
        } f23[23:23];
        field {
            name = "f24";
            desc = "Flag. POSITION seen in hi3520D_vpss.ko (HIGH); MEANING INFERRED from the HAL function name only (LOW) Not verified on hardware.";
            sw = rw;
            hw = r;
        } f24[24:24];
        field {
            name = "f26";
            desc = "Flag. POSITION seen in hi3520D_vpss.ko (HIGH); MEANING INFERRED from the HAL function name only (LOW) Not verified on hardware.";
            sw = rw;
            hw = r;
        } f26[26:26];
        field {
            name = "f28";
            desc = "Flag. POSITION seen in hi3520D_vpss.ko (HIGH); MEANING INFERRED from the HAL function name only (LOW) Not verified on hardware.";
            sw = rw;
            hw = r;
        } f28[28:28];
        field {
            name = "f29";
            desc = "Flag. POSITION seen in hi3520D_vpss.ko (HIGH); MEANING INFERRED from the HAL function name only (LOW) Not verified on hardware.";
            sw = rw;
            hw = r;
        } f29[29:29];
        field {
            name = "f30";
            desc = "Flag. POSITION seen in hi3520D_vpss.ko (HIGH); MEANING INFERRED from the HAL function name only (LOW) Not verified on hardware.";
            sw = rw;
            hw = r;
        } f30[30:30];
        field {
            name = "f31";
            desc = "Flag. POSITION seen in hi3520D_vpss.ko (HIGH); MEANING INFERRED from the HAL function name only (LOW) Not verified on hardware.";
            sw = rw;
            hw = r;
        } f31[31:31];
    } N_SCL1_CFG3 @ 0x22C;

    reg {
        name = "Channel scaler block 1, word 4";
        desc = "Node image offset 0x230.  Source: hi3520D_vpss.ko. Not verified on hardware.";
        field {
            name = "v";
            desc = "16-bit value. POSITION seen in hi3520D_vpss.ko (HIGH); MEANING INFERRED from the HAL function name only (LOW) Not verified on hardware.";
            sw = rw;
            hw = r;
        } v[15:0];
    } N_SCL1_CFG4 @ 0x230;

    reg {
        name = "Channel scaler block 1, word 5";
        desc = "Node image offset 0x234.  Source: hi3520D_vpss.ko. Not verified on hardware.";
        field {
            name = "lo";
            desc = "16-bit value. POSITION seen in hi3520D_vpss.ko (HIGH); MEANING INFERRED from the HAL function name only (LOW) Not verified on hardware.";
            sw = rw;
            hw = r;
        } lo[15:0];
        field {
            name = "hi";
            desc = "16-bit value. POSITION seen in hi3520D_vpss.ko (HIGH); MEANING INFERRED from the HAL function name only (LOW) Not verified on hardware.";
            sw = rw;
            hw = r;
        } hi[31:16];
    } N_SCL1_CFG5 @ 0x234;

    reg {
        name = "Channel scaler block 1, word 6";
        desc = "Node image offset 0x238.  Source: hi3520D_vpss.ko. Not verified on hardware.";
        field {
            name = "a";
            desc = "12-bit value (size/offset-like). POSITION seen in hi3520D_vpss.ko (HIGH); MEANING INFERRED from the HAL function name only (LOW) Not verified on hardware.";
            sw = rw;
            hw = r;
        } a[11:0];
        field {
            name = "b";
            desc = "12-bit value. POSITION seen in hi3520D_vpss.ko (HIGH); MEANING INFERRED from the HAL function name only (LOW) Not verified on hardware.";
            sw = rw;
            hw = r;
        } b[23:12];
    } N_SCL1_CFG6 @ 0x238;

    reg {
        name = "Channel scaler block 1, word 7";
        desc = "Node image offset 0x23C.  Source: hi3520D_vpss.ko. Not verified on hardware.";
        field {
            name = "a";
            desc = "12-bit value. POSITION seen in hi3520D_vpss.ko (HIGH); MEANING INFERRED from the HAL function name only (LOW) Not verified on hardware.";
            sw = rw;
            hw = r;
        } a[11:0];
        field {
            name = "b";
            desc = "12-bit value. POSITION seen in hi3520D_vpss.ko (HIGH); MEANING INFERRED from the HAL function name only (LOW) Not verified on hardware.";
            sw = rw;
            hw = r;
        } b[23:12];
    } N_SCL1_CFG7 @ 0x23C;

    reg {
        name = "Channel scaler block 2, word 0 (VPSS_HAL_SetChnSclCfg)";
        desc = "Node image offset 0x240. Four 8-word scaler blocks at 0x200, 0x220, 0x240, 0x260 (slot order as CH_IMG_SIZE). The vendor argument names are not in the module; the data sheet lists scaling and sharpening/peaking for the Hi3520D, so the blocks probably hold the horizontal/vertical scale factors, filter selects and enables of one channel (GUESS, LOW).  Source: hi3520D_vpss.ko. Not verified on hardware.";
        field {
            name = "v0";
            desc = "24-bit value (likely a scaler setting). POSITION seen in hi3520D_vpss.ko (HIGH); MEANING INFERRED from the HAL function name only (LOW) Not verified on hardware.";
            sw = rw;
            hw = r;
        } v0[23:0];
        field {
            name = "flag25";
            desc = "Flag. POSITION seen in hi3520D_vpss.ko (HIGH); MEANING INFERRED from the HAL function name only (LOW) Not verified on hardware.";
            sw = rw;
            hw = r;
        } flag25[25:25];
        field {
            name = "flag26";
            desc = "Flag. POSITION seen in hi3520D_vpss.ko (HIGH); MEANING INFERRED from the HAL function name only (LOW) Not verified on hardware.";
            sw = rw;
            hw = r;
        } flag26[26:26];
        field {
            name = "flag28";
            desc = "Flag. POSITION seen in hi3520D_vpss.ko (HIGH); MEANING INFERRED from the HAL function name only (LOW) Not verified on hardware.";
            sw = rw;
            hw = r;
        } flag28[28:28];
        field {
            name = "flag29";
            desc = "Flag. POSITION seen in hi3520D_vpss.ko (HIGH); MEANING INFERRED from the HAL function name only (LOW) Not verified on hardware.";
            sw = rw;
            hw = r;
        } flag29[29:29];
        field {
            name = "flag30";
            desc = "Flag. POSITION seen in hi3520D_vpss.ko (HIGH); MEANING INFERRED from the HAL function name only (LOW) Not verified on hardware.";
            sw = rw;
            hw = r;
        } flag30[30:30];
        field {
            name = "flag31";
            desc = "Flag. POSITION seen in hi3520D_vpss.ko (HIGH); MEANING INFERRED from the HAL function name only (LOW) Not verified on hardware.";
            sw = rw;
            hw = r;
        } flag31[31:31];
    } N_SCL2_CFG0 @ 0x240;

    reg {
        name = "Channel scaler block 2, word 1";
        desc = "Node image offset 0x244. Probably the horizontal scale factor (28-bit, GUESS, LOW).  Source: hi3520D_vpss.ko. Not verified on hardware.";
        field {
            name = "v";
            desc = "28-bit value. POSITION seen in hi3520D_vpss.ko (HIGH); MEANING INFERRED from the HAL function name only (LOW) Not verified on hardware.";
            sw = rw;
            hw = r;
        } v[27:0];
    } N_SCL2_CFG1 @ 0x244;

    reg {
        name = "Channel scaler block 2, word 2";
        desc = "Node image offset 0x248. Probably the vertical scale factor (28-bit, GUESS, LOW).  Source: hi3520D_vpss.ko. Not verified on hardware.";
        field {
            name = "v";
            desc = "28-bit value. POSITION seen in hi3520D_vpss.ko (HIGH); MEANING INFERRED from the HAL function name only (LOW) Not verified on hardware.";
            sw = rw;
            hw = r;
        } v[27:0];
    } N_SCL2_CFG2 @ 0x248;

    reg {
        name = "Channel scaler block 2, word 3";
        desc = "Node image offset 0x24C. Mixed fields.  Source: hi3520D_vpss.ko. Not verified on hardware.";
        field {
            name = "f19";
            desc = "2-bit field. POSITION seen in hi3520D_vpss.ko (HIGH); MEANING INFERRED from the HAL function name only (LOW) Not verified on hardware.";
            sw = rw;
            hw = r;
        } f19[20:19];
        field {
            name = "f21";
            desc = "2-bit field. POSITION seen in hi3520D_vpss.ko (HIGH); MEANING INFERRED from the HAL function name only (LOW) Not verified on hardware.";
            sw = rw;
            hw = r;
        } f21[22:21];
        field {
            name = "f23";
            desc = "Flag. POSITION seen in hi3520D_vpss.ko (HIGH); MEANING INFERRED from the HAL function name only (LOW) Not verified on hardware.";
            sw = rw;
            hw = r;
        } f23[23:23];
        field {
            name = "f24";
            desc = "Flag. POSITION seen in hi3520D_vpss.ko (HIGH); MEANING INFERRED from the HAL function name only (LOW) Not verified on hardware.";
            sw = rw;
            hw = r;
        } f24[24:24];
        field {
            name = "f26";
            desc = "Flag. POSITION seen in hi3520D_vpss.ko (HIGH); MEANING INFERRED from the HAL function name only (LOW) Not verified on hardware.";
            sw = rw;
            hw = r;
        } f26[26:26];
        field {
            name = "f28";
            desc = "Flag. POSITION seen in hi3520D_vpss.ko (HIGH); MEANING INFERRED from the HAL function name only (LOW) Not verified on hardware.";
            sw = rw;
            hw = r;
        } f28[28:28];
        field {
            name = "f29";
            desc = "Flag. POSITION seen in hi3520D_vpss.ko (HIGH); MEANING INFERRED from the HAL function name only (LOW) Not verified on hardware.";
            sw = rw;
            hw = r;
        } f29[29:29];
        field {
            name = "f30";
            desc = "Flag. POSITION seen in hi3520D_vpss.ko (HIGH); MEANING INFERRED from the HAL function name only (LOW) Not verified on hardware.";
            sw = rw;
            hw = r;
        } f30[30:30];
        field {
            name = "f31";
            desc = "Flag. POSITION seen in hi3520D_vpss.ko (HIGH); MEANING INFERRED from the HAL function name only (LOW) Not verified on hardware.";
            sw = rw;
            hw = r;
        } f31[31:31];
    } N_SCL2_CFG3 @ 0x24C;

    reg {
        name = "Channel scaler block 2, word 4";
        desc = "Node image offset 0x250.  Source: hi3520D_vpss.ko. Not verified on hardware.";
        field {
            name = "v";
            desc = "16-bit value. POSITION seen in hi3520D_vpss.ko (HIGH); MEANING INFERRED from the HAL function name only (LOW) Not verified on hardware.";
            sw = rw;
            hw = r;
        } v[15:0];
    } N_SCL2_CFG4 @ 0x250;

    reg {
        name = "Channel scaler block 2, word 5";
        desc = "Node image offset 0x254.  Source: hi3520D_vpss.ko. Not verified on hardware.";
        field {
            name = "lo";
            desc = "16-bit value. POSITION seen in hi3520D_vpss.ko (HIGH); MEANING INFERRED from the HAL function name only (LOW) Not verified on hardware.";
            sw = rw;
            hw = r;
        } lo[15:0];
        field {
            name = "hi";
            desc = "16-bit value. POSITION seen in hi3520D_vpss.ko (HIGH); MEANING INFERRED from the HAL function name only (LOW) Not verified on hardware.";
            sw = rw;
            hw = r;
        } hi[31:16];
    } N_SCL2_CFG5 @ 0x254;

    reg {
        name = "Channel scaler block 2, word 6";
        desc = "Node image offset 0x258.  Source: hi3520D_vpss.ko. Not verified on hardware.";
        field {
            name = "a";
            desc = "12-bit value (size/offset-like). POSITION seen in hi3520D_vpss.ko (HIGH); MEANING INFERRED from the HAL function name only (LOW) Not verified on hardware.";
            sw = rw;
            hw = r;
        } a[11:0];
        field {
            name = "b";
            desc = "12-bit value. POSITION seen in hi3520D_vpss.ko (HIGH); MEANING INFERRED from the HAL function name only (LOW) Not verified on hardware.";
            sw = rw;
            hw = r;
        } b[23:12];
    } N_SCL2_CFG6 @ 0x258;

    reg {
        name = "Channel scaler block 2, word 7";
        desc = "Node image offset 0x25C.  Source: hi3520D_vpss.ko. Not verified on hardware.";
        field {
            name = "a";
            desc = "12-bit value. POSITION seen in hi3520D_vpss.ko (HIGH); MEANING INFERRED from the HAL function name only (LOW) Not verified on hardware.";
            sw = rw;
            hw = r;
        } a[11:0];
        field {
            name = "b";
            desc = "12-bit value. POSITION seen in hi3520D_vpss.ko (HIGH); MEANING INFERRED from the HAL function name only (LOW) Not verified on hardware.";
            sw = rw;
            hw = r;
        } b[23:12];
    } N_SCL2_CFG7 @ 0x25C;

    reg {
        name = "Channel scaler block 3, word 0 (VPSS_HAL_SetChnSclCfg)";
        desc = "Node image offset 0x260. Four 8-word scaler blocks at 0x200, 0x220, 0x240, 0x260 (slot order as CH_IMG_SIZE). The vendor argument names are not in the module; the data sheet lists scaling and sharpening/peaking for the Hi3520D, so the blocks probably hold the horizontal/vertical scale factors, filter selects and enables of one channel (GUESS, LOW).  Source: hi3520D_vpss.ko. Not verified on hardware.";
        field {
            name = "v0";
            desc = "24-bit value (likely a scaler setting). POSITION seen in hi3520D_vpss.ko (HIGH); MEANING INFERRED from the HAL function name only (LOW) Not verified on hardware.";
            sw = rw;
            hw = r;
        } v0[23:0];
        field {
            name = "flag25";
            desc = "Flag. POSITION seen in hi3520D_vpss.ko (HIGH); MEANING INFERRED from the HAL function name only (LOW) Not verified on hardware.";
            sw = rw;
            hw = r;
        } flag25[25:25];
        field {
            name = "flag26";
            desc = "Flag. POSITION seen in hi3520D_vpss.ko (HIGH); MEANING INFERRED from the HAL function name only (LOW) Not verified on hardware.";
            sw = rw;
            hw = r;
        } flag26[26:26];
        field {
            name = "flag28";
            desc = "Flag. POSITION seen in hi3520D_vpss.ko (HIGH); MEANING INFERRED from the HAL function name only (LOW) Not verified on hardware.";
            sw = rw;
            hw = r;
        } flag28[28:28];
        field {
            name = "flag29";
            desc = "Flag. POSITION seen in hi3520D_vpss.ko (HIGH); MEANING INFERRED from the HAL function name only (LOW) Not verified on hardware.";
            sw = rw;
            hw = r;
        } flag29[29:29];
        field {
            name = "flag30";
            desc = "Flag. POSITION seen in hi3520D_vpss.ko (HIGH); MEANING INFERRED from the HAL function name only (LOW) Not verified on hardware.";
            sw = rw;
            hw = r;
        } flag30[30:30];
        field {
            name = "flag31";
            desc = "Flag. POSITION seen in hi3520D_vpss.ko (HIGH); MEANING INFERRED from the HAL function name only (LOW) Not verified on hardware.";
            sw = rw;
            hw = r;
        } flag31[31:31];
    } N_SCL3_CFG0 @ 0x260;

    reg {
        name = "Channel scaler block 3, word 1";
        desc = "Node image offset 0x264. Probably the horizontal scale factor (28-bit, GUESS, LOW).  Source: hi3520D_vpss.ko. Not verified on hardware.";
        field {
            name = "v";
            desc = "28-bit value. POSITION seen in hi3520D_vpss.ko (HIGH); MEANING INFERRED from the HAL function name only (LOW) Not verified on hardware.";
            sw = rw;
            hw = r;
        } v[27:0];
    } N_SCL3_CFG1 @ 0x264;

    reg {
        name = "Channel scaler block 3, word 2";
        desc = "Node image offset 0x268. Probably the vertical scale factor (28-bit, GUESS, LOW).  Source: hi3520D_vpss.ko. Not verified on hardware.";
        field {
            name = "v";
            desc = "28-bit value. POSITION seen in hi3520D_vpss.ko (HIGH); MEANING INFERRED from the HAL function name only (LOW) Not verified on hardware.";
            sw = rw;
            hw = r;
        } v[27:0];
    } N_SCL3_CFG2 @ 0x268;

    reg {
        name = "Channel scaler block 3, word 3";
        desc = "Node image offset 0x26C. Mixed fields.  Source: hi3520D_vpss.ko. Not verified on hardware.";
        field {
            name = "f19";
            desc = "2-bit field. POSITION seen in hi3520D_vpss.ko (HIGH); MEANING INFERRED from the HAL function name only (LOW) Not verified on hardware.";
            sw = rw;
            hw = r;
        } f19[20:19];
        field {
            name = "f21";
            desc = "2-bit field. POSITION seen in hi3520D_vpss.ko (HIGH); MEANING INFERRED from the HAL function name only (LOW) Not verified on hardware.";
            sw = rw;
            hw = r;
        } f21[22:21];
        field {
            name = "f23";
            desc = "Flag. POSITION seen in hi3520D_vpss.ko (HIGH); MEANING INFERRED from the HAL function name only (LOW) Not verified on hardware.";
            sw = rw;
            hw = r;
        } f23[23:23];
        field {
            name = "f24";
            desc = "Flag. POSITION seen in hi3520D_vpss.ko (HIGH); MEANING INFERRED from the HAL function name only (LOW) Not verified on hardware.";
            sw = rw;
            hw = r;
        } f24[24:24];
        field {
            name = "f26";
            desc = "Flag. POSITION seen in hi3520D_vpss.ko (HIGH); MEANING INFERRED from the HAL function name only (LOW) Not verified on hardware.";
            sw = rw;
            hw = r;
        } f26[26:26];
        field {
            name = "f28";
            desc = "Flag. POSITION seen in hi3520D_vpss.ko (HIGH); MEANING INFERRED from the HAL function name only (LOW) Not verified on hardware.";
            sw = rw;
            hw = r;
        } f28[28:28];
        field {
            name = "f29";
            desc = "Flag. POSITION seen in hi3520D_vpss.ko (HIGH); MEANING INFERRED from the HAL function name only (LOW) Not verified on hardware.";
            sw = rw;
            hw = r;
        } f29[29:29];
        field {
            name = "f30";
            desc = "Flag. POSITION seen in hi3520D_vpss.ko (HIGH); MEANING INFERRED from the HAL function name only (LOW) Not verified on hardware.";
            sw = rw;
            hw = r;
        } f30[30:30];
        field {
            name = "f31";
            desc = "Flag. POSITION seen in hi3520D_vpss.ko (HIGH); MEANING INFERRED from the HAL function name only (LOW) Not verified on hardware.";
            sw = rw;
            hw = r;
        } f31[31:31];
    } N_SCL3_CFG3 @ 0x26C;

    reg {
        name = "Channel scaler block 3, word 4";
        desc = "Node image offset 0x270.  Source: hi3520D_vpss.ko. Not verified on hardware.";
        field {
            name = "v";
            desc = "16-bit value. POSITION seen in hi3520D_vpss.ko (HIGH); MEANING INFERRED from the HAL function name only (LOW) Not verified on hardware.";
            sw = rw;
            hw = r;
        } v[15:0];
    } N_SCL3_CFG4 @ 0x270;

    reg {
        name = "Channel scaler block 3, word 5";
        desc = "Node image offset 0x274.  Source: hi3520D_vpss.ko. Not verified on hardware.";
        field {
            name = "lo";
            desc = "16-bit value. POSITION seen in hi3520D_vpss.ko (HIGH); MEANING INFERRED from the HAL function name only (LOW) Not verified on hardware.";
            sw = rw;
            hw = r;
        } lo[15:0];
        field {
            name = "hi";
            desc = "16-bit value. POSITION seen in hi3520D_vpss.ko (HIGH); MEANING INFERRED from the HAL function name only (LOW) Not verified on hardware.";
            sw = rw;
            hw = r;
        } hi[31:16];
    } N_SCL3_CFG5 @ 0x274;

    reg {
        name = "Channel scaler block 3, word 6";
        desc = "Node image offset 0x278.  Source: hi3520D_vpss.ko. Not verified on hardware.";
        field {
            name = "a";
            desc = "12-bit value (size/offset-like). POSITION seen in hi3520D_vpss.ko (HIGH); MEANING INFERRED from the HAL function name only (LOW) Not verified on hardware.";
            sw = rw;
            hw = r;
        } a[11:0];
        field {
            name = "b";
            desc = "12-bit value. POSITION seen in hi3520D_vpss.ko (HIGH); MEANING INFERRED from the HAL function name only (LOW) Not verified on hardware.";
            sw = rw;
            hw = r;
        } b[23:12];
    } N_SCL3_CFG6 @ 0x278;

    reg {
        name = "Channel scaler block 3, word 7";
        desc = "Node image offset 0x27C.  Source: hi3520D_vpss.ko. Not verified on hardware.";
        field {
            name = "a";
            desc = "12-bit value. POSITION seen in hi3520D_vpss.ko (HIGH); MEANING INFERRED from the HAL function name only (LOW) Not verified on hardware.";
            sw = rw;
            hw = r;
        } a[11:0];
        field {
            name = "b";
            desc = "12-bit value. POSITION seen in hi3520D_vpss.ko (HIGH); MEANING INFERRED from the HAL function name only (LOW) Not verified on hardware.";
            sw = rw;
            hw = r;
        } b[23:12];
    } N_SCL3_CFG7 @ 0x27C;

    reg {
        name = "Pre-scaler configuration word 0 (VPSS_HAL_SetPreSclCfg)";
        desc = "Node image offset 0x280. One pre-scaler block at 0x280 (the data sheet's block processing / half-size pre-scale of wide pictures; GUESS, LOW).  Source: hi3520D_vpss.ko. Not verified on hardware.";
        field {
            name = "flag25";
            desc = "Flag. POSITION seen in hi3520D_vpss.ko (HIGH); MEANING INFERRED from the HAL function name only (LOW) Not verified on hardware.";
            sw = rw;
            hw = r;
        } flag25[25:25];
        field {
            name = "flag26";
            desc = "Flag. POSITION seen in hi3520D_vpss.ko (HIGH); MEANING INFERRED from the HAL function name only (LOW) Not verified on hardware.";
            sw = rw;
            hw = r;
        } flag26[26:26];
        field {
            name = "flag28";
            desc = "Flag. POSITION seen in hi3520D_vpss.ko (HIGH); MEANING INFERRED from the HAL function name only (LOW) Not verified on hardware.";
            sw = rw;
            hw = r;
        } flag28[28:28];
        field {
            name = "flag29";
            desc = "Flag. POSITION seen in hi3520D_vpss.ko (HIGH); MEANING INFERRED from the HAL function name only (LOW) Not verified on hardware.";
            sw = rw;
            hw = r;
        } flag29[29:29];
    } N_PRESCL_CFG0 @ 0x280;

    reg {
        name = "Pre-scaler word 1";
        desc = "Node image offset 0x284.  Source: hi3520D_vpss.ko. Not verified on hardware.";
        field {
            name = "v";
            desc = "28-bit value. POSITION seen in hi3520D_vpss.ko (HIGH); MEANING INFERRED from the HAL function name only (LOW) Not verified on hardware.";
            sw = rw;
            hw = r;
        } v[27:0];
    } N_PRESCL_CFG1 @ 0x284;

    reg {
        name = "Pre-scaler word 2";
        desc = "Node image offset 0x288.  Source: hi3520D_vpss.ko. Not verified on hardware.";
        field {
            name = "v";
            desc = "28-bit value. POSITION seen in hi3520D_vpss.ko (HIGH); MEANING INFERRED from the HAL function name only (LOW) Not verified on hardware.";
            sw = rw;
            hw = r;
        } v[27:0];
    } N_PRESCL_CFG2 @ 0x288;

    reg {
        name = "Pre-scaler word 3";
        desc = "Node image offset 0x28C.  Source: hi3520D_vpss.ko. Not verified on hardware.";
        field {
            name = "v";
            desc = "13-bit value. POSITION seen in hi3520D_vpss.ko (HIGH); MEANING INFERRED from the HAL function name only (LOW) Not verified on hardware.";
            sw = rw;
            hw = r;
        } v[12:0];
    } N_PRESCL_CFG3 @ 0x28C;

    reg {
        name = "Histogram configuration (VPSS_HAL_SetHistCfg)";
        desc = "Node image offset 0x2F0.  Source: hi3520D_vpss.ko. Not verified on hardware.";
        field {
            name = "v0";
            desc = "8-bit value. POSITION seen in hi3520D_vpss.ko (HIGH); MEANING INFERRED from the HAL function name only (LOW) Not verified on hardware.";
            sw = rw;
            hw = r;
        } v0[7:0];
        field {
            name = "v1";
            desc = "4-bit value. POSITION seen in hi3520D_vpss.ko (HIGH); MEANING INFERRED from the HAL function name only (LOW) Not verified on hardware.";
            sw = rw;
            hw = r;
        } v1[11:8];
        field {
            name = "v2";
            desc = "8-bit value. POSITION seen in hi3520D_vpss.ko (HIGH); MEANING INFERRED from the HAL function name only (LOW) Not verified on hardware.";
            sw = rw;
            hw = r;
        } v2[23:16];
        field {
            name = "v3";
            desc = "4-bit value. POSITION seen in hi3520D_vpss.ko (HIGH); MEANING INFERRED from the HAL function name only (LOW) Not verified on hardware.";
            sw = rw;
            hw = r;
        } v3[27:24];
    } N_HIST_CFG @ 0x2F0;

    reg {
        name = "Pre-scaler coefficient table address 0 (VPSS_HAL_SetPreSclCoeff)";
        desc = "Node image offset 0x3A0. Physical address of a coefficient table in DDR; the HAL panics if (addr & 15) != 0, so 16-byte aligned.  Source: hi3520D_vpss.ko. Not verified on hardware.";
        field {
            name = "val";
            desc = "Table address, 16-byte aligned. POSITION seen in hi3520D_vpss.ko (HIGH); MEANING INFERRED from the HAL function name only (LOW) Not verified on hardware.";
            sw = rw;
            hw = r;
        } val[31:0];
    } N_PRESCL_COEF_0 @ 0x3A0;

    reg {
        name = "Pre-scaler coefficient table address 1";
        desc = "Node image offset 0x3A8. See PRESCL_COEF_0.  Source: hi3520D_vpss.ko. Not verified on hardware.";
        field {
            name = "val";
            desc = "Table address, 16-byte aligned. POSITION seen in hi3520D_vpss.ko (HIGH); MEANING INFERRED from the HAL function name only (LOW) Not verified on hardware.";
            sw = rw;
            hw = r;
        } val[31:0];
    } N_PRESCL_COEF_1 @ 0x3A8;

    reg {
        name = "Channel scaler coefficient table address 0.0 (VPSS_HAL_SetChnSclCoeff)";
        desc = "Node image offset 0x3B0. Four table addresses per channel slot (SetChnSclCoeff takes four pointers and requires each 16-byte aligned; order +0 hor luma, +4 ver luma, +8 hor chroma, +12 ver chroma: PROVEN, GenSclCfg). Slot order as CH_IMG_SIZE. COEFFICIENT TABLE FORMAT (vendor pass 2026-11-11, InitSclCoeff and vpss_scl*coef_to_dut, HIGH for the packing, MEDIUM for which pointer is which): the four tables of a channel are horizontal luma (8 taps), horizontal chroma (4 taps), vertical luma (6 taps) and vertical chroma (4 taps) (pointer order PROVEN from GenSclCfg 0x14924, which fills the four pointers: +0 horizontal luma, +4 vertical luma, +8 horizontal chroma, +12 vertical chroma). Each table has 17 phases (1/16 pel steps, phase 0..16); a tap is a signed 10-bit value (two's complement masked to 10 bits), unity = 512 (every phase sums to 512 in the vendor tables, phase 0 of a few tables sums to 511). Packing (little endian 32-bit words): 8-tap luma = 3 words per phase: w0 = c0 | c1<<10 | c2<<20, w1 = c3 | c4<<10 | c5<<20, w2 = c6 | c7<<10 (51 words, 204 bytes); 6-tap = 3 words per phase, taps paired as c0 | c1<<16 (51 words); 4-tap = 2 words per phase, c0 | c1<<16, c2 | c3<<16 (34 words, 136 bytes); a 2-tap converter exists (1 word per phase, 17 words) but is unused by InitSclCoeff. The vendor allocates one 5888-byte (0x1700) buffer and places tables at 256-byte slots: slots 0-5 horizontal luma (lanczos3, cubic, lanczos2, 3M_a19, 2M_a05, 1.5M_a05 low-pass variants), 6-10 horizontal chroma 4-tap, 11-17 vertical luma 6-tap, 18-22 vertical chroma 4-tap. Slot selection (PROVEN, GenSclCfg 0x14924; r = output/input size, horizontal 12.20, vertical 20.12): horizontal luma: r > 1 slot 0, r == 1 slot 1, 0.5 <= r < 1 slot 2, 1/3 < r < 0.5 slot 3, 0.25 <= r <= 1/3 slot 4, r < 0.25 slot 5; horizontal chroma: r > 1 slot 6, == 1 slot 7, 0.5 <= r < 1 slot 6, 1/3 < r < 0.5 slot 9, else slot 10; vertical luma: r > 1 slot 11, == 1 slot 12, >= 0.75 slot 13, >= 0.5 slot 14, > 1/3 slot 15, >= 0.25 slot 16, else slot 17; vertical chroma: r > 1 slot 18, == 1 slot 19, >= 0.5 slot 18, > 1/3 slot 21, else slot 22. The pre-scaler pointers (+0x3A0 horizontal, +0x3A8 vertical) are always slot 2 and slot 6. Steps (in/out): horizontal luma = (in << 20) / out, vertical luma = (in << 12) / out, chroma the same with the chroma sizes; the 28-bit step fields of the 8-word scaler blocks (0x204/0x208 + 0x20*ch) take these (INFERRED which of the two words is which). Not verified on hardware.  Source: hi3520D_vpss.ko. Not verified on hardware.";
        field {
            name = "val";
            desc = "Table address, 16-byte aligned. POSITION seen in hi3520D_vpss.ko (HIGH); MEANING INFERRED from the HAL function name only (LOW) Not verified on hardware.";
            sw = rw;
            hw = r;
        } val[31:0];
    } N_CH0_COEF_0 @ 0x3B0;

    reg {
        name = "Channel scaler coefficient table address 0.1 (VPSS_HAL_SetChnSclCoeff)";
        desc = "Node image offset 0x3B4. Four table addresses per channel slot (SetChnSclCoeff takes four pointers and requires each 16-byte aligned; order +0 hor luma, +4 ver luma, +8 hor chroma, +12 ver chroma: PROVEN, GenSclCfg). Slot order as CH_IMG_SIZE. COEFFICIENT TABLE FORMAT (vendor pass 2026-11-11, InitSclCoeff and vpss_scl*coef_to_dut, HIGH for the packing, MEDIUM for which pointer is which): the four tables of a channel are horizontal luma (8 taps), horizontal chroma (4 taps), vertical luma (6 taps) and vertical chroma (4 taps) (pointer order PROVEN from GenSclCfg 0x14924, which fills the four pointers: +0 horizontal luma, +4 vertical luma, +8 horizontal chroma, +12 vertical chroma). Each table has 17 phases (1/16 pel steps, phase 0..16); a tap is a signed 10-bit value (two's complement masked to 10 bits), unity = 512 (every phase sums to 512 in the vendor tables, phase 0 of a few tables sums to 511). Packing (little endian 32-bit words): 8-tap luma = 3 words per phase: w0 = c0 | c1<<10 | c2<<20, w1 = c3 | c4<<10 | c5<<20, w2 = c6 | c7<<10 (51 words, 204 bytes); 6-tap = 3 words per phase, taps paired as c0 | c1<<16 (51 words); 4-tap = 2 words per phase, c0 | c1<<16, c2 | c3<<16 (34 words, 136 bytes); a 2-tap converter exists (1 word per phase, 17 words) but is unused by InitSclCoeff. The vendor allocates one 5888-byte (0x1700) buffer and places tables at 256-byte slots: slots 0-5 horizontal luma (lanczos3, cubic, lanczos2, 3M_a19, 2M_a05, 1.5M_a05 low-pass variants), 6-10 horizontal chroma 4-tap, 11-17 vertical luma 6-tap, 18-22 vertical chroma 4-tap. Slot selection (PROVEN, GenSclCfg 0x14924; r = output/input size, horizontal 12.20, vertical 20.12): horizontal luma: r > 1 slot 0, r == 1 slot 1, 0.5 <= r < 1 slot 2, 1/3 < r < 0.5 slot 3, 0.25 <= r <= 1/3 slot 4, r < 0.25 slot 5; horizontal chroma: r > 1 slot 6, == 1 slot 7, 0.5 <= r < 1 slot 6, 1/3 < r < 0.5 slot 9, else slot 10; vertical luma: r > 1 slot 11, == 1 slot 12, >= 0.75 slot 13, >= 0.5 slot 14, > 1/3 slot 15, >= 0.25 slot 16, else slot 17; vertical chroma: r > 1 slot 18, == 1 slot 19, >= 0.5 slot 18, > 1/3 slot 21, else slot 22. The pre-scaler pointers (+0x3A0 horizontal, +0x3A8 vertical) are always slot 2 and slot 6. Steps (in/out): horizontal luma = (in << 20) / out, vertical luma = (in << 12) / out, chroma the same with the chroma sizes; the 28-bit step fields of the 8-word scaler blocks (0x204/0x208 + 0x20*ch) take these (INFERRED which of the two words is which). Not verified on hardware.  Source: hi3520D_vpss.ko. Not verified on hardware.";
        field {
            name = "val";
            desc = "Table address, 16-byte aligned. POSITION seen in hi3520D_vpss.ko (HIGH); MEANING INFERRED from the HAL function name only (LOW) Not verified on hardware.";
            sw = rw;
            hw = r;
        } val[31:0];
    } N_CH0_COEF_1 @ 0x3B4;

    reg {
        name = "Channel scaler coefficient table address 0.2 (VPSS_HAL_SetChnSclCoeff)";
        desc = "Node image offset 0x3B8. Four table addresses per channel slot (SetChnSclCoeff takes four pointers and requires each 16-byte aligned; order +0 hor luma, +4 ver luma, +8 hor chroma, +12 ver chroma: PROVEN, GenSclCfg). Slot order as CH_IMG_SIZE. COEFFICIENT TABLE FORMAT (vendor pass 2026-11-11, InitSclCoeff and vpss_scl*coef_to_dut, HIGH for the packing, MEDIUM for which pointer is which): the four tables of a channel are horizontal luma (8 taps), horizontal chroma (4 taps), vertical luma (6 taps) and vertical chroma (4 taps) (pointer order PROVEN from GenSclCfg 0x14924, which fills the four pointers: +0 horizontal luma, +4 vertical luma, +8 horizontal chroma, +12 vertical chroma). Each table has 17 phases (1/16 pel steps, phase 0..16); a tap is a signed 10-bit value (two's complement masked to 10 bits), unity = 512 (every phase sums to 512 in the vendor tables, phase 0 of a few tables sums to 511). Packing (little endian 32-bit words): 8-tap luma = 3 words per phase: w0 = c0 | c1<<10 | c2<<20, w1 = c3 | c4<<10 | c5<<20, w2 = c6 | c7<<10 (51 words, 204 bytes); 6-tap = 3 words per phase, taps paired as c0 | c1<<16 (51 words); 4-tap = 2 words per phase, c0 | c1<<16, c2 | c3<<16 (34 words, 136 bytes); a 2-tap converter exists (1 word per phase, 17 words) but is unused by InitSclCoeff. The vendor allocates one 5888-byte (0x1700) buffer and places tables at 256-byte slots: slots 0-5 horizontal luma (lanczos3, cubic, lanczos2, 3M_a19, 2M_a05, 1.5M_a05 low-pass variants), 6-10 horizontal chroma 4-tap, 11-17 vertical luma 6-tap, 18-22 vertical chroma 4-tap. Slot selection (PROVEN, GenSclCfg 0x14924; r = output/input size, horizontal 12.20, vertical 20.12): horizontal luma: r > 1 slot 0, r == 1 slot 1, 0.5 <= r < 1 slot 2, 1/3 < r < 0.5 slot 3, 0.25 <= r <= 1/3 slot 4, r < 0.25 slot 5; horizontal chroma: r > 1 slot 6, == 1 slot 7, 0.5 <= r < 1 slot 6, 1/3 < r < 0.5 slot 9, else slot 10; vertical luma: r > 1 slot 11, == 1 slot 12, >= 0.75 slot 13, >= 0.5 slot 14, > 1/3 slot 15, >= 0.25 slot 16, else slot 17; vertical chroma: r > 1 slot 18, == 1 slot 19, >= 0.5 slot 18, > 1/3 slot 21, else slot 22. The pre-scaler pointers (+0x3A0 horizontal, +0x3A8 vertical) are always slot 2 and slot 6. Steps (in/out): horizontal luma = (in << 20) / out, vertical luma = (in << 12) / out, chroma the same with the chroma sizes; the 28-bit step fields of the 8-word scaler blocks (0x204/0x208 + 0x20*ch) take these (INFERRED which of the two words is which). Not verified on hardware.  Source: hi3520D_vpss.ko. Not verified on hardware.";
        field {
            name = "val";
            desc = "Table address, 16-byte aligned. POSITION seen in hi3520D_vpss.ko (HIGH); MEANING INFERRED from the HAL function name only (LOW) Not verified on hardware.";
            sw = rw;
            hw = r;
        } val[31:0];
    } N_CH0_COEF_2 @ 0x3B8;

    reg {
        name = "Channel scaler coefficient table address 0.3 (VPSS_HAL_SetChnSclCoeff)";
        desc = "Node image offset 0x3BC. Four table addresses per channel slot (SetChnSclCoeff takes four pointers and requires each 16-byte aligned; order +0 hor luma, +4 ver luma, +8 hor chroma, +12 ver chroma: PROVEN, GenSclCfg). Slot order as CH_IMG_SIZE. COEFFICIENT TABLE FORMAT (vendor pass 2026-11-11, InitSclCoeff and vpss_scl*coef_to_dut, HIGH for the packing, MEDIUM for which pointer is which): the four tables of a channel are horizontal luma (8 taps), horizontal chroma (4 taps), vertical luma (6 taps) and vertical chroma (4 taps) (pointer order PROVEN from GenSclCfg 0x14924, which fills the four pointers: +0 horizontal luma, +4 vertical luma, +8 horizontal chroma, +12 vertical chroma). Each table has 17 phases (1/16 pel steps, phase 0..16); a tap is a signed 10-bit value (two's complement masked to 10 bits), unity = 512 (every phase sums to 512 in the vendor tables, phase 0 of a few tables sums to 511). Packing (little endian 32-bit words): 8-tap luma = 3 words per phase: w0 = c0 | c1<<10 | c2<<20, w1 = c3 | c4<<10 | c5<<20, w2 = c6 | c7<<10 (51 words, 204 bytes); 6-tap = 3 words per phase, taps paired as c0 | c1<<16 (51 words); 4-tap = 2 words per phase, c0 | c1<<16, c2 | c3<<16 (34 words, 136 bytes); a 2-tap converter exists (1 word per phase, 17 words) but is unused by InitSclCoeff. The vendor allocates one 5888-byte (0x1700) buffer and places tables at 256-byte slots: slots 0-5 horizontal luma (lanczos3, cubic, lanczos2, 3M_a19, 2M_a05, 1.5M_a05 low-pass variants), 6-10 horizontal chroma 4-tap, 11-17 vertical luma 6-tap, 18-22 vertical chroma 4-tap. Slot selection (PROVEN, GenSclCfg 0x14924; r = output/input size, horizontal 12.20, vertical 20.12): horizontal luma: r > 1 slot 0, r == 1 slot 1, 0.5 <= r < 1 slot 2, 1/3 < r < 0.5 slot 3, 0.25 <= r <= 1/3 slot 4, r < 0.25 slot 5; horizontal chroma: r > 1 slot 6, == 1 slot 7, 0.5 <= r < 1 slot 6, 1/3 < r < 0.5 slot 9, else slot 10; vertical luma: r > 1 slot 11, == 1 slot 12, >= 0.75 slot 13, >= 0.5 slot 14, > 1/3 slot 15, >= 0.25 slot 16, else slot 17; vertical chroma: r > 1 slot 18, == 1 slot 19, >= 0.5 slot 18, > 1/3 slot 21, else slot 22. The pre-scaler pointers (+0x3A0 horizontal, +0x3A8 vertical) are always slot 2 and slot 6. Steps (in/out): horizontal luma = (in << 20) / out, vertical luma = (in << 12) / out, chroma the same with the chroma sizes; the 28-bit step fields of the 8-word scaler blocks (0x204/0x208 + 0x20*ch) take these (INFERRED which of the two words is which). Not verified on hardware.  Source: hi3520D_vpss.ko. Not verified on hardware.";
        field {
            name = "val";
            desc = "Table address, 16-byte aligned. POSITION seen in hi3520D_vpss.ko (HIGH); MEANING INFERRED from the HAL function name only (LOW) Not verified on hardware.";
            sw = rw;
            hw = r;
        } val[31:0];
    } N_CH0_COEF_3 @ 0x3BC;

    reg {
        name = "Channel scaler coefficient table address 1.0 (VPSS_HAL_SetChnSclCoeff)";
        desc = "Node image offset 0x3C0. Four table addresses per channel slot (SetChnSclCoeff takes four pointers and requires each 16-byte aligned; order +0 hor luma, +4 ver luma, +8 hor chroma, +12 ver chroma: PROVEN, GenSclCfg). Slot order as CH_IMG_SIZE. COEFFICIENT TABLE FORMAT (vendor pass 2026-11-11, InitSclCoeff and vpss_scl*coef_to_dut, HIGH for the packing, MEDIUM for which pointer is which): the four tables of a channel are horizontal luma (8 taps), horizontal chroma (4 taps), vertical luma (6 taps) and vertical chroma (4 taps) (pointer order PROVEN from GenSclCfg 0x14924, which fills the four pointers: +0 horizontal luma, +4 vertical luma, +8 horizontal chroma, +12 vertical chroma). Each table has 17 phases (1/16 pel steps, phase 0..16); a tap is a signed 10-bit value (two's complement masked to 10 bits), unity = 512 (every phase sums to 512 in the vendor tables, phase 0 of a few tables sums to 511). Packing (little endian 32-bit words): 8-tap luma = 3 words per phase: w0 = c0 | c1<<10 | c2<<20, w1 = c3 | c4<<10 | c5<<20, w2 = c6 | c7<<10 (51 words, 204 bytes); 6-tap = 3 words per phase, taps paired as c0 | c1<<16 (51 words); 4-tap = 2 words per phase, c0 | c1<<16, c2 | c3<<16 (34 words, 136 bytes); a 2-tap converter exists (1 word per phase, 17 words) but is unused by InitSclCoeff. The vendor allocates one 5888-byte (0x1700) buffer and places tables at 256-byte slots: slots 0-5 horizontal luma (lanczos3, cubic, lanczos2, 3M_a19, 2M_a05, 1.5M_a05 low-pass variants), 6-10 horizontal chroma 4-tap, 11-17 vertical luma 6-tap, 18-22 vertical chroma 4-tap. Slot selection (PROVEN, GenSclCfg 0x14924; r = output/input size, horizontal 12.20, vertical 20.12): horizontal luma: r > 1 slot 0, r == 1 slot 1, 0.5 <= r < 1 slot 2, 1/3 < r < 0.5 slot 3, 0.25 <= r <= 1/3 slot 4, r < 0.25 slot 5; horizontal chroma: r > 1 slot 6, == 1 slot 7, 0.5 <= r < 1 slot 6, 1/3 < r < 0.5 slot 9, else slot 10; vertical luma: r > 1 slot 11, == 1 slot 12, >= 0.75 slot 13, >= 0.5 slot 14, > 1/3 slot 15, >= 0.25 slot 16, else slot 17; vertical chroma: r > 1 slot 18, == 1 slot 19, >= 0.5 slot 18, > 1/3 slot 21, else slot 22. The pre-scaler pointers (+0x3A0 horizontal, +0x3A8 vertical) are always slot 2 and slot 6. Steps (in/out): horizontal luma = (in << 20) / out, vertical luma = (in << 12) / out, chroma the same with the chroma sizes; the 28-bit step fields of the 8-word scaler blocks (0x204/0x208 + 0x20*ch) take these (INFERRED which of the two words is which). Not verified on hardware.  Source: hi3520D_vpss.ko. Not verified on hardware.";
        field {
            name = "val";
            desc = "Table address, 16-byte aligned. POSITION seen in hi3520D_vpss.ko (HIGH); MEANING INFERRED from the HAL function name only (LOW) Not verified on hardware.";
            sw = rw;
            hw = r;
        } val[31:0];
    } N_CH1_COEF_0 @ 0x3C0;

    reg {
        name = "Channel scaler coefficient table address 1.1 (VPSS_HAL_SetChnSclCoeff)";
        desc = "Node image offset 0x3C4. Four table addresses per channel slot (SetChnSclCoeff takes four pointers and requires each 16-byte aligned; order +0 hor luma, +4 ver luma, +8 hor chroma, +12 ver chroma: PROVEN, GenSclCfg). Slot order as CH_IMG_SIZE. COEFFICIENT TABLE FORMAT (vendor pass 2026-11-11, InitSclCoeff and vpss_scl*coef_to_dut, HIGH for the packing, MEDIUM for which pointer is which): the four tables of a channel are horizontal luma (8 taps), horizontal chroma (4 taps), vertical luma (6 taps) and vertical chroma (4 taps) (pointer order PROVEN from GenSclCfg 0x14924, which fills the four pointers: +0 horizontal luma, +4 vertical luma, +8 horizontal chroma, +12 vertical chroma). Each table has 17 phases (1/16 pel steps, phase 0..16); a tap is a signed 10-bit value (two's complement masked to 10 bits), unity = 512 (every phase sums to 512 in the vendor tables, phase 0 of a few tables sums to 511). Packing (little endian 32-bit words): 8-tap luma = 3 words per phase: w0 = c0 | c1<<10 | c2<<20, w1 = c3 | c4<<10 | c5<<20, w2 = c6 | c7<<10 (51 words, 204 bytes); 6-tap = 3 words per phase, taps paired as c0 | c1<<16 (51 words); 4-tap = 2 words per phase, c0 | c1<<16, c2 | c3<<16 (34 words, 136 bytes); a 2-tap converter exists (1 word per phase, 17 words) but is unused by InitSclCoeff. The vendor allocates one 5888-byte (0x1700) buffer and places tables at 256-byte slots: slots 0-5 horizontal luma (lanczos3, cubic, lanczos2, 3M_a19, 2M_a05, 1.5M_a05 low-pass variants), 6-10 horizontal chroma 4-tap, 11-17 vertical luma 6-tap, 18-22 vertical chroma 4-tap. Slot selection (PROVEN, GenSclCfg 0x14924; r = output/input size, horizontal 12.20, vertical 20.12): horizontal luma: r > 1 slot 0, r == 1 slot 1, 0.5 <= r < 1 slot 2, 1/3 < r < 0.5 slot 3, 0.25 <= r <= 1/3 slot 4, r < 0.25 slot 5; horizontal chroma: r > 1 slot 6, == 1 slot 7, 0.5 <= r < 1 slot 6, 1/3 < r < 0.5 slot 9, else slot 10; vertical luma: r > 1 slot 11, == 1 slot 12, >= 0.75 slot 13, >= 0.5 slot 14, > 1/3 slot 15, >= 0.25 slot 16, else slot 17; vertical chroma: r > 1 slot 18, == 1 slot 19, >= 0.5 slot 18, > 1/3 slot 21, else slot 22. The pre-scaler pointers (+0x3A0 horizontal, +0x3A8 vertical) are always slot 2 and slot 6. Steps (in/out): horizontal luma = (in << 20) / out, vertical luma = (in << 12) / out, chroma the same with the chroma sizes; the 28-bit step fields of the 8-word scaler blocks (0x204/0x208 + 0x20*ch) take these (INFERRED which of the two words is which). Not verified on hardware.  Source: hi3520D_vpss.ko. Not verified on hardware.";
        field {
            name = "val";
            desc = "Table address, 16-byte aligned. POSITION seen in hi3520D_vpss.ko (HIGH); MEANING INFERRED from the HAL function name only (LOW) Not verified on hardware.";
            sw = rw;
            hw = r;
        } val[31:0];
    } N_CH1_COEF_1 @ 0x3C4;

    reg {
        name = "Channel scaler coefficient table address 1.2 (VPSS_HAL_SetChnSclCoeff)";
        desc = "Node image offset 0x3C8. Four table addresses per channel slot (SetChnSclCoeff takes four pointers and requires each 16-byte aligned; order +0 hor luma, +4 ver luma, +8 hor chroma, +12 ver chroma: PROVEN, GenSclCfg). Slot order as CH_IMG_SIZE. COEFFICIENT TABLE FORMAT (vendor pass 2026-11-11, InitSclCoeff and vpss_scl*coef_to_dut, HIGH for the packing, MEDIUM for which pointer is which): the four tables of a channel are horizontal luma (8 taps), horizontal chroma (4 taps), vertical luma (6 taps) and vertical chroma (4 taps) (pointer order PROVEN from GenSclCfg 0x14924, which fills the four pointers: +0 horizontal luma, +4 vertical luma, +8 horizontal chroma, +12 vertical chroma). Each table has 17 phases (1/16 pel steps, phase 0..16); a tap is a signed 10-bit value (two's complement masked to 10 bits), unity = 512 (every phase sums to 512 in the vendor tables, phase 0 of a few tables sums to 511). Packing (little endian 32-bit words): 8-tap luma = 3 words per phase: w0 = c0 | c1<<10 | c2<<20, w1 = c3 | c4<<10 | c5<<20, w2 = c6 | c7<<10 (51 words, 204 bytes); 6-tap = 3 words per phase, taps paired as c0 | c1<<16 (51 words); 4-tap = 2 words per phase, c0 | c1<<16, c2 | c3<<16 (34 words, 136 bytes); a 2-tap converter exists (1 word per phase, 17 words) but is unused by InitSclCoeff. The vendor allocates one 5888-byte (0x1700) buffer and places tables at 256-byte slots: slots 0-5 horizontal luma (lanczos3, cubic, lanczos2, 3M_a19, 2M_a05, 1.5M_a05 low-pass variants), 6-10 horizontal chroma 4-tap, 11-17 vertical luma 6-tap, 18-22 vertical chroma 4-tap. Slot selection (PROVEN, GenSclCfg 0x14924; r = output/input size, horizontal 12.20, vertical 20.12): horizontal luma: r > 1 slot 0, r == 1 slot 1, 0.5 <= r < 1 slot 2, 1/3 < r < 0.5 slot 3, 0.25 <= r <= 1/3 slot 4, r < 0.25 slot 5; horizontal chroma: r > 1 slot 6, == 1 slot 7, 0.5 <= r < 1 slot 6, 1/3 < r < 0.5 slot 9, else slot 10; vertical luma: r > 1 slot 11, == 1 slot 12, >= 0.75 slot 13, >= 0.5 slot 14, > 1/3 slot 15, >= 0.25 slot 16, else slot 17; vertical chroma: r > 1 slot 18, == 1 slot 19, >= 0.5 slot 18, > 1/3 slot 21, else slot 22. The pre-scaler pointers (+0x3A0 horizontal, +0x3A8 vertical) are always slot 2 and slot 6. Steps (in/out): horizontal luma = (in << 20) / out, vertical luma = (in << 12) / out, chroma the same with the chroma sizes; the 28-bit step fields of the 8-word scaler blocks (0x204/0x208 + 0x20*ch) take these (INFERRED which of the two words is which). Not verified on hardware.  Source: hi3520D_vpss.ko. Not verified on hardware.";
        field {
            name = "val";
            desc = "Table address, 16-byte aligned. POSITION seen in hi3520D_vpss.ko (HIGH); MEANING INFERRED from the HAL function name only (LOW) Not verified on hardware.";
            sw = rw;
            hw = r;
        } val[31:0];
    } N_CH1_COEF_2 @ 0x3C8;

    reg {
        name = "Channel scaler coefficient table address 1.3 (VPSS_HAL_SetChnSclCoeff)";
        desc = "Node image offset 0x3CC. Four table addresses per channel slot (SetChnSclCoeff takes four pointers and requires each 16-byte aligned; order +0 hor luma, +4 ver luma, +8 hor chroma, +12 ver chroma: PROVEN, GenSclCfg). Slot order as CH_IMG_SIZE. COEFFICIENT TABLE FORMAT (vendor pass 2026-11-11, InitSclCoeff and vpss_scl*coef_to_dut, HIGH for the packing, MEDIUM for which pointer is which): the four tables of a channel are horizontal luma (8 taps), horizontal chroma (4 taps), vertical luma (6 taps) and vertical chroma (4 taps) (pointer order PROVEN from GenSclCfg 0x14924, which fills the four pointers: +0 horizontal luma, +4 vertical luma, +8 horizontal chroma, +12 vertical chroma). Each table has 17 phases (1/16 pel steps, phase 0..16); a tap is a signed 10-bit value (two's complement masked to 10 bits), unity = 512 (every phase sums to 512 in the vendor tables, phase 0 of a few tables sums to 511). Packing (little endian 32-bit words): 8-tap luma = 3 words per phase: w0 = c0 | c1<<10 | c2<<20, w1 = c3 | c4<<10 | c5<<20, w2 = c6 | c7<<10 (51 words, 204 bytes); 6-tap = 3 words per phase, taps paired as c0 | c1<<16 (51 words); 4-tap = 2 words per phase, c0 | c1<<16, c2 | c3<<16 (34 words, 136 bytes); a 2-tap converter exists (1 word per phase, 17 words) but is unused by InitSclCoeff. The vendor allocates one 5888-byte (0x1700) buffer and places tables at 256-byte slots: slots 0-5 horizontal luma (lanczos3, cubic, lanczos2, 3M_a19, 2M_a05, 1.5M_a05 low-pass variants), 6-10 horizontal chroma 4-tap, 11-17 vertical luma 6-tap, 18-22 vertical chroma 4-tap. Slot selection (PROVEN, GenSclCfg 0x14924; r = output/input size, horizontal 12.20, vertical 20.12): horizontal luma: r > 1 slot 0, r == 1 slot 1, 0.5 <= r < 1 slot 2, 1/3 < r < 0.5 slot 3, 0.25 <= r <= 1/3 slot 4, r < 0.25 slot 5; horizontal chroma: r > 1 slot 6, == 1 slot 7, 0.5 <= r < 1 slot 6, 1/3 < r < 0.5 slot 9, else slot 10; vertical luma: r > 1 slot 11, == 1 slot 12, >= 0.75 slot 13, >= 0.5 slot 14, > 1/3 slot 15, >= 0.25 slot 16, else slot 17; vertical chroma: r > 1 slot 18, == 1 slot 19, >= 0.5 slot 18, > 1/3 slot 21, else slot 22. The pre-scaler pointers (+0x3A0 horizontal, +0x3A8 vertical) are always slot 2 and slot 6. Steps (in/out): horizontal luma = (in << 20) / out, vertical luma = (in << 12) / out, chroma the same with the chroma sizes; the 28-bit step fields of the 8-word scaler blocks (0x204/0x208 + 0x20*ch) take these (INFERRED which of the two words is which). Not verified on hardware.  Source: hi3520D_vpss.ko. Not verified on hardware.";
        field {
            name = "val";
            desc = "Table address, 16-byte aligned. POSITION seen in hi3520D_vpss.ko (HIGH); MEANING INFERRED from the HAL function name only (LOW) Not verified on hardware.";
            sw = rw;
            hw = r;
        } val[31:0];
    } N_CH1_COEF_3 @ 0x3CC;

    reg {
        name = "Channel scaler coefficient table address 2.0 (VPSS_HAL_SetChnSclCoeff)";
        desc = "Node image offset 0x3D0. Four table addresses per channel slot (SetChnSclCoeff takes four pointers and requires each 16-byte aligned; order +0 hor luma, +4 ver luma, +8 hor chroma, +12 ver chroma: PROVEN, GenSclCfg). Slot order as CH_IMG_SIZE. COEFFICIENT TABLE FORMAT (vendor pass 2026-11-11, InitSclCoeff and vpss_scl*coef_to_dut, HIGH for the packing, MEDIUM for which pointer is which): the four tables of a channel are horizontal luma (8 taps), horizontal chroma (4 taps), vertical luma (6 taps) and vertical chroma (4 taps) (pointer order PROVEN from GenSclCfg 0x14924, which fills the four pointers: +0 horizontal luma, +4 vertical luma, +8 horizontal chroma, +12 vertical chroma). Each table has 17 phases (1/16 pel steps, phase 0..16); a tap is a signed 10-bit value (two's complement masked to 10 bits), unity = 512 (every phase sums to 512 in the vendor tables, phase 0 of a few tables sums to 511). Packing (little endian 32-bit words): 8-tap luma = 3 words per phase: w0 = c0 | c1<<10 | c2<<20, w1 = c3 | c4<<10 | c5<<20, w2 = c6 | c7<<10 (51 words, 204 bytes); 6-tap = 3 words per phase, taps paired as c0 | c1<<16 (51 words); 4-tap = 2 words per phase, c0 | c1<<16, c2 | c3<<16 (34 words, 136 bytes); a 2-tap converter exists (1 word per phase, 17 words) but is unused by InitSclCoeff. The vendor allocates one 5888-byte (0x1700) buffer and places tables at 256-byte slots: slots 0-5 horizontal luma (lanczos3, cubic, lanczos2, 3M_a19, 2M_a05, 1.5M_a05 low-pass variants), 6-10 horizontal chroma 4-tap, 11-17 vertical luma 6-tap, 18-22 vertical chroma 4-tap. Slot selection (PROVEN, GenSclCfg 0x14924; r = output/input size, horizontal 12.20, vertical 20.12): horizontal luma: r > 1 slot 0, r == 1 slot 1, 0.5 <= r < 1 slot 2, 1/3 < r < 0.5 slot 3, 0.25 <= r <= 1/3 slot 4, r < 0.25 slot 5; horizontal chroma: r > 1 slot 6, == 1 slot 7, 0.5 <= r < 1 slot 6, 1/3 < r < 0.5 slot 9, else slot 10; vertical luma: r > 1 slot 11, == 1 slot 12, >= 0.75 slot 13, >= 0.5 slot 14, > 1/3 slot 15, >= 0.25 slot 16, else slot 17; vertical chroma: r > 1 slot 18, == 1 slot 19, >= 0.5 slot 18, > 1/3 slot 21, else slot 22. The pre-scaler pointers (+0x3A0 horizontal, +0x3A8 vertical) are always slot 2 and slot 6. Steps (in/out): horizontal luma = (in << 20) / out, vertical luma = (in << 12) / out, chroma the same with the chroma sizes; the 28-bit step fields of the 8-word scaler blocks (0x204/0x208 + 0x20*ch) take these (INFERRED which of the two words is which). Not verified on hardware.  Source: hi3520D_vpss.ko. Not verified on hardware.";
        field {
            name = "val";
            desc = "Table address, 16-byte aligned. POSITION seen in hi3520D_vpss.ko (HIGH); MEANING INFERRED from the HAL function name only (LOW) Not verified on hardware.";
            sw = rw;
            hw = r;
        } val[31:0];
    } N_CH2_COEF_0 @ 0x3D0;

    reg {
        name = "Channel scaler coefficient table address 2.1 (VPSS_HAL_SetChnSclCoeff)";
        desc = "Node image offset 0x3D4. Four table addresses per channel slot (SetChnSclCoeff takes four pointers and requires each 16-byte aligned; order +0 hor luma, +4 ver luma, +8 hor chroma, +12 ver chroma: PROVEN, GenSclCfg). Slot order as CH_IMG_SIZE. COEFFICIENT TABLE FORMAT (vendor pass 2026-11-11, InitSclCoeff and vpss_scl*coef_to_dut, HIGH for the packing, MEDIUM for which pointer is which): the four tables of a channel are horizontal luma (8 taps), horizontal chroma (4 taps), vertical luma (6 taps) and vertical chroma (4 taps) (pointer order PROVEN from GenSclCfg 0x14924, which fills the four pointers: +0 horizontal luma, +4 vertical luma, +8 horizontal chroma, +12 vertical chroma). Each table has 17 phases (1/16 pel steps, phase 0..16); a tap is a signed 10-bit value (two's complement masked to 10 bits), unity = 512 (every phase sums to 512 in the vendor tables, phase 0 of a few tables sums to 511). Packing (little endian 32-bit words): 8-tap luma = 3 words per phase: w0 = c0 | c1<<10 | c2<<20, w1 = c3 | c4<<10 | c5<<20, w2 = c6 | c7<<10 (51 words, 204 bytes); 6-tap = 3 words per phase, taps paired as c0 | c1<<16 (51 words); 4-tap = 2 words per phase, c0 | c1<<16, c2 | c3<<16 (34 words, 136 bytes); a 2-tap converter exists (1 word per phase, 17 words) but is unused by InitSclCoeff. The vendor allocates one 5888-byte (0x1700) buffer and places tables at 256-byte slots: slots 0-5 horizontal luma (lanczos3, cubic, lanczos2, 3M_a19, 2M_a05, 1.5M_a05 low-pass variants), 6-10 horizontal chroma 4-tap, 11-17 vertical luma 6-tap, 18-22 vertical chroma 4-tap. Slot selection (PROVEN, GenSclCfg 0x14924; r = output/input size, horizontal 12.20, vertical 20.12): horizontal luma: r > 1 slot 0, r == 1 slot 1, 0.5 <= r < 1 slot 2, 1/3 < r < 0.5 slot 3, 0.25 <= r <= 1/3 slot 4, r < 0.25 slot 5; horizontal chroma: r > 1 slot 6, == 1 slot 7, 0.5 <= r < 1 slot 6, 1/3 < r < 0.5 slot 9, else slot 10; vertical luma: r > 1 slot 11, == 1 slot 12, >= 0.75 slot 13, >= 0.5 slot 14, > 1/3 slot 15, >= 0.25 slot 16, else slot 17; vertical chroma: r > 1 slot 18, == 1 slot 19, >= 0.5 slot 18, > 1/3 slot 21, else slot 22. The pre-scaler pointers (+0x3A0 horizontal, +0x3A8 vertical) are always slot 2 and slot 6. Steps (in/out): horizontal luma = (in << 20) / out, vertical luma = (in << 12) / out, chroma the same with the chroma sizes; the 28-bit step fields of the 8-word scaler blocks (0x204/0x208 + 0x20*ch) take these (INFERRED which of the two words is which). Not verified on hardware.  Source: hi3520D_vpss.ko. Not verified on hardware.";
        field {
            name = "val";
            desc = "Table address, 16-byte aligned. POSITION seen in hi3520D_vpss.ko (HIGH); MEANING INFERRED from the HAL function name only (LOW) Not verified on hardware.";
            sw = rw;
            hw = r;
        } val[31:0];
    } N_CH2_COEF_1 @ 0x3D4;

    reg {
        name = "Channel scaler coefficient table address 2.2 (VPSS_HAL_SetChnSclCoeff)";
        desc = "Node image offset 0x3D8. Four table addresses per channel slot (SetChnSclCoeff takes four pointers and requires each 16-byte aligned; order +0 hor luma, +4 ver luma, +8 hor chroma, +12 ver chroma: PROVEN, GenSclCfg). Slot order as CH_IMG_SIZE. COEFFICIENT TABLE FORMAT (vendor pass 2026-11-11, InitSclCoeff and vpss_scl*coef_to_dut, HIGH for the packing, MEDIUM for which pointer is which): the four tables of a channel are horizontal luma (8 taps), horizontal chroma (4 taps), vertical luma (6 taps) and vertical chroma (4 taps) (pointer order PROVEN from GenSclCfg 0x14924, which fills the four pointers: +0 horizontal luma, +4 vertical luma, +8 horizontal chroma, +12 vertical chroma). Each table has 17 phases (1/16 pel steps, phase 0..16); a tap is a signed 10-bit value (two's complement masked to 10 bits), unity = 512 (every phase sums to 512 in the vendor tables, phase 0 of a few tables sums to 511). Packing (little endian 32-bit words): 8-tap luma = 3 words per phase: w0 = c0 | c1<<10 | c2<<20, w1 = c3 | c4<<10 | c5<<20, w2 = c6 | c7<<10 (51 words, 204 bytes); 6-tap = 3 words per phase, taps paired as c0 | c1<<16 (51 words); 4-tap = 2 words per phase, c0 | c1<<16, c2 | c3<<16 (34 words, 136 bytes); a 2-tap converter exists (1 word per phase, 17 words) but is unused by InitSclCoeff. The vendor allocates one 5888-byte (0x1700) buffer and places tables at 256-byte slots: slots 0-5 horizontal luma (lanczos3, cubic, lanczos2, 3M_a19, 2M_a05, 1.5M_a05 low-pass variants), 6-10 horizontal chroma 4-tap, 11-17 vertical luma 6-tap, 18-22 vertical chroma 4-tap. Slot selection (PROVEN, GenSclCfg 0x14924; r = output/input size, horizontal 12.20, vertical 20.12): horizontal luma: r > 1 slot 0, r == 1 slot 1, 0.5 <= r < 1 slot 2, 1/3 < r < 0.5 slot 3, 0.25 <= r <= 1/3 slot 4, r < 0.25 slot 5; horizontal chroma: r > 1 slot 6, == 1 slot 7, 0.5 <= r < 1 slot 6, 1/3 < r < 0.5 slot 9, else slot 10; vertical luma: r > 1 slot 11, == 1 slot 12, >= 0.75 slot 13, >= 0.5 slot 14, > 1/3 slot 15, >= 0.25 slot 16, else slot 17; vertical chroma: r > 1 slot 18, == 1 slot 19, >= 0.5 slot 18, > 1/3 slot 21, else slot 22. The pre-scaler pointers (+0x3A0 horizontal, +0x3A8 vertical) are always slot 2 and slot 6. Steps (in/out): horizontal luma = (in << 20) / out, vertical luma = (in << 12) / out, chroma the same with the chroma sizes; the 28-bit step fields of the 8-word scaler blocks (0x204/0x208 + 0x20*ch) take these (INFERRED which of the two words is which). Not verified on hardware.  Source: hi3520D_vpss.ko. Not verified on hardware.";
        field {
            name = "val";
            desc = "Table address, 16-byte aligned. POSITION seen in hi3520D_vpss.ko (HIGH); MEANING INFERRED from the HAL function name only (LOW) Not verified on hardware.";
            sw = rw;
            hw = r;
        } val[31:0];
    } N_CH2_COEF_2 @ 0x3D8;

    reg {
        name = "Channel scaler coefficient table address 2.3 (VPSS_HAL_SetChnSclCoeff)";
        desc = "Node image offset 0x3DC. Four table addresses per channel slot (SetChnSclCoeff takes four pointers and requires each 16-byte aligned; order +0 hor luma, +4 ver luma, +8 hor chroma, +12 ver chroma: PROVEN, GenSclCfg). Slot order as CH_IMG_SIZE. COEFFICIENT TABLE FORMAT (vendor pass 2026-11-11, InitSclCoeff and vpss_scl*coef_to_dut, HIGH for the packing, MEDIUM for which pointer is which): the four tables of a channel are horizontal luma (8 taps), horizontal chroma (4 taps), vertical luma (6 taps) and vertical chroma (4 taps) (pointer order PROVEN from GenSclCfg 0x14924, which fills the four pointers: +0 horizontal luma, +4 vertical luma, +8 horizontal chroma, +12 vertical chroma). Each table has 17 phases (1/16 pel steps, phase 0..16); a tap is a signed 10-bit value (two's complement masked to 10 bits), unity = 512 (every phase sums to 512 in the vendor tables, phase 0 of a few tables sums to 511). Packing (little endian 32-bit words): 8-tap luma = 3 words per phase: w0 = c0 | c1<<10 | c2<<20, w1 = c3 | c4<<10 | c5<<20, w2 = c6 | c7<<10 (51 words, 204 bytes); 6-tap = 3 words per phase, taps paired as c0 | c1<<16 (51 words); 4-tap = 2 words per phase, c0 | c1<<16, c2 | c3<<16 (34 words, 136 bytes); a 2-tap converter exists (1 word per phase, 17 words) but is unused by InitSclCoeff. The vendor allocates one 5888-byte (0x1700) buffer and places tables at 256-byte slots: slots 0-5 horizontal luma (lanczos3, cubic, lanczos2, 3M_a19, 2M_a05, 1.5M_a05 low-pass variants), 6-10 horizontal chroma 4-tap, 11-17 vertical luma 6-tap, 18-22 vertical chroma 4-tap. Slot selection (PROVEN, GenSclCfg 0x14924; r = output/input size, horizontal 12.20, vertical 20.12): horizontal luma: r > 1 slot 0, r == 1 slot 1, 0.5 <= r < 1 slot 2, 1/3 < r < 0.5 slot 3, 0.25 <= r <= 1/3 slot 4, r < 0.25 slot 5; horizontal chroma: r > 1 slot 6, == 1 slot 7, 0.5 <= r < 1 slot 6, 1/3 < r < 0.5 slot 9, else slot 10; vertical luma: r > 1 slot 11, == 1 slot 12, >= 0.75 slot 13, >= 0.5 slot 14, > 1/3 slot 15, >= 0.25 slot 16, else slot 17; vertical chroma: r > 1 slot 18, == 1 slot 19, >= 0.5 slot 18, > 1/3 slot 21, else slot 22. The pre-scaler pointers (+0x3A0 horizontal, +0x3A8 vertical) are always slot 2 and slot 6. Steps (in/out): horizontal luma = (in << 20) / out, vertical luma = (in << 12) / out, chroma the same with the chroma sizes; the 28-bit step fields of the 8-word scaler blocks (0x204/0x208 + 0x20*ch) take these (INFERRED which of the two words is which). Not verified on hardware.  Source: hi3520D_vpss.ko. Not verified on hardware.";
        field {
            name = "val";
            desc = "Table address, 16-byte aligned. POSITION seen in hi3520D_vpss.ko (HIGH); MEANING INFERRED from the HAL function name only (LOW) Not verified on hardware.";
            sw = rw;
            hw = r;
        } val[31:0];
    } N_CH2_COEF_3 @ 0x3DC;

    reg {
        name = "Channel scaler coefficient table address 3.0 (VPSS_HAL_SetChnSclCoeff)";
        desc = "Node image offset 0x3E0. Four table addresses per channel slot (SetChnSclCoeff takes four pointers and requires each 16-byte aligned; order +0 hor luma, +4 ver luma, +8 hor chroma, +12 ver chroma: PROVEN, GenSclCfg). Slot order as CH_IMG_SIZE. COEFFICIENT TABLE FORMAT (vendor pass 2026-11-11, InitSclCoeff and vpss_scl*coef_to_dut, HIGH for the packing, MEDIUM for which pointer is which): the four tables of a channel are horizontal luma (8 taps), horizontal chroma (4 taps), vertical luma (6 taps) and vertical chroma (4 taps) (pointer order PROVEN from GenSclCfg 0x14924, which fills the four pointers: +0 horizontal luma, +4 vertical luma, +8 horizontal chroma, +12 vertical chroma). Each table has 17 phases (1/16 pel steps, phase 0..16); a tap is a signed 10-bit value (two's complement masked to 10 bits), unity = 512 (every phase sums to 512 in the vendor tables, phase 0 of a few tables sums to 511). Packing (little endian 32-bit words): 8-tap luma = 3 words per phase: w0 = c0 | c1<<10 | c2<<20, w1 = c3 | c4<<10 | c5<<20, w2 = c6 | c7<<10 (51 words, 204 bytes); 6-tap = 3 words per phase, taps paired as c0 | c1<<16 (51 words); 4-tap = 2 words per phase, c0 | c1<<16, c2 | c3<<16 (34 words, 136 bytes); a 2-tap converter exists (1 word per phase, 17 words) but is unused by InitSclCoeff. The vendor allocates one 5888-byte (0x1700) buffer and places tables at 256-byte slots: slots 0-5 horizontal luma (lanczos3, cubic, lanczos2, 3M_a19, 2M_a05, 1.5M_a05 low-pass variants), 6-10 horizontal chroma 4-tap, 11-17 vertical luma 6-tap, 18-22 vertical chroma 4-tap. Slot selection (PROVEN, GenSclCfg 0x14924; r = output/input size, horizontal 12.20, vertical 20.12): horizontal luma: r > 1 slot 0, r == 1 slot 1, 0.5 <= r < 1 slot 2, 1/3 < r < 0.5 slot 3, 0.25 <= r <= 1/3 slot 4, r < 0.25 slot 5; horizontal chroma: r > 1 slot 6, == 1 slot 7, 0.5 <= r < 1 slot 6, 1/3 < r < 0.5 slot 9, else slot 10; vertical luma: r > 1 slot 11, == 1 slot 12, >= 0.75 slot 13, >= 0.5 slot 14, > 1/3 slot 15, >= 0.25 slot 16, else slot 17; vertical chroma: r > 1 slot 18, == 1 slot 19, >= 0.5 slot 18, > 1/3 slot 21, else slot 22. The pre-scaler pointers (+0x3A0 horizontal, +0x3A8 vertical) are always slot 2 and slot 6. Steps (in/out): horizontal luma = (in << 20) / out, vertical luma = (in << 12) / out, chroma the same with the chroma sizes; the 28-bit step fields of the 8-word scaler blocks (0x204/0x208 + 0x20*ch) take these (INFERRED which of the two words is which). Not verified on hardware.  Source: hi3520D_vpss.ko. Not verified on hardware.";
        field {
            name = "val";
            desc = "Table address, 16-byte aligned. POSITION seen in hi3520D_vpss.ko (HIGH); MEANING INFERRED from the HAL function name only (LOW) Not verified on hardware.";
            sw = rw;
            hw = r;
        } val[31:0];
    } N_CH3_COEF_0 @ 0x3E0;

    reg {
        name = "Channel scaler coefficient table address 3.1 (VPSS_HAL_SetChnSclCoeff)";
        desc = "Node image offset 0x3E4. Four table addresses per channel slot (SetChnSclCoeff takes four pointers and requires each 16-byte aligned; order +0 hor luma, +4 ver luma, +8 hor chroma, +12 ver chroma: PROVEN, GenSclCfg). Slot order as CH_IMG_SIZE. COEFFICIENT TABLE FORMAT (vendor pass 2026-11-11, InitSclCoeff and vpss_scl*coef_to_dut, HIGH for the packing, MEDIUM for which pointer is which): the four tables of a channel are horizontal luma (8 taps), horizontal chroma (4 taps), vertical luma (6 taps) and vertical chroma (4 taps) (pointer order PROVEN from GenSclCfg 0x14924, which fills the four pointers: +0 horizontal luma, +4 vertical luma, +8 horizontal chroma, +12 vertical chroma). Each table has 17 phases (1/16 pel steps, phase 0..16); a tap is a signed 10-bit value (two's complement masked to 10 bits), unity = 512 (every phase sums to 512 in the vendor tables, phase 0 of a few tables sums to 511). Packing (little endian 32-bit words): 8-tap luma = 3 words per phase: w0 = c0 | c1<<10 | c2<<20, w1 = c3 | c4<<10 | c5<<20, w2 = c6 | c7<<10 (51 words, 204 bytes); 6-tap = 3 words per phase, taps paired as c0 | c1<<16 (51 words); 4-tap = 2 words per phase, c0 | c1<<16, c2 | c3<<16 (34 words, 136 bytes); a 2-tap converter exists (1 word per phase, 17 words) but is unused by InitSclCoeff. The vendor allocates one 5888-byte (0x1700) buffer and places tables at 256-byte slots: slots 0-5 horizontal luma (lanczos3, cubic, lanczos2, 3M_a19, 2M_a05, 1.5M_a05 low-pass variants), 6-10 horizontal chroma 4-tap, 11-17 vertical luma 6-tap, 18-22 vertical chroma 4-tap. Slot selection (PROVEN, GenSclCfg 0x14924; r = output/input size, horizontal 12.20, vertical 20.12): horizontal luma: r > 1 slot 0, r == 1 slot 1, 0.5 <= r < 1 slot 2, 1/3 < r < 0.5 slot 3, 0.25 <= r <= 1/3 slot 4, r < 0.25 slot 5; horizontal chroma: r > 1 slot 6, == 1 slot 7, 0.5 <= r < 1 slot 6, 1/3 < r < 0.5 slot 9, else slot 10; vertical luma: r > 1 slot 11, == 1 slot 12, >= 0.75 slot 13, >= 0.5 slot 14, > 1/3 slot 15, >= 0.25 slot 16, else slot 17; vertical chroma: r > 1 slot 18, == 1 slot 19, >= 0.5 slot 18, > 1/3 slot 21, else slot 22. The pre-scaler pointers (+0x3A0 horizontal, +0x3A8 vertical) are always slot 2 and slot 6. Steps (in/out): horizontal luma = (in << 20) / out, vertical luma = (in << 12) / out, chroma the same with the chroma sizes; the 28-bit step fields of the 8-word scaler blocks (0x204/0x208 + 0x20*ch) take these (INFERRED which of the two words is which). Not verified on hardware.  Source: hi3520D_vpss.ko. Not verified on hardware.";
        field {
            name = "val";
            desc = "Table address, 16-byte aligned. POSITION seen in hi3520D_vpss.ko (HIGH); MEANING INFERRED from the HAL function name only (LOW) Not verified on hardware.";
            sw = rw;
            hw = r;
        } val[31:0];
    } N_CH3_COEF_1 @ 0x3E4;

    reg {
        name = "Channel scaler coefficient table address 3.2 (VPSS_HAL_SetChnSclCoeff)";
        desc = "Node image offset 0x3E8. Four table addresses per channel slot (SetChnSclCoeff takes four pointers and requires each 16-byte aligned; order +0 hor luma, +4 ver luma, +8 hor chroma, +12 ver chroma: PROVEN, GenSclCfg). Slot order as CH_IMG_SIZE. COEFFICIENT TABLE FORMAT (vendor pass 2026-11-11, InitSclCoeff and vpss_scl*coef_to_dut, HIGH for the packing, MEDIUM for which pointer is which): the four tables of a channel are horizontal luma (8 taps), horizontal chroma (4 taps), vertical luma (6 taps) and vertical chroma (4 taps) (pointer order PROVEN from GenSclCfg 0x14924, which fills the four pointers: +0 horizontal luma, +4 vertical luma, +8 horizontal chroma, +12 vertical chroma). Each table has 17 phases (1/16 pel steps, phase 0..16); a tap is a signed 10-bit value (two's complement masked to 10 bits), unity = 512 (every phase sums to 512 in the vendor tables, phase 0 of a few tables sums to 511). Packing (little endian 32-bit words): 8-tap luma = 3 words per phase: w0 = c0 | c1<<10 | c2<<20, w1 = c3 | c4<<10 | c5<<20, w2 = c6 | c7<<10 (51 words, 204 bytes); 6-tap = 3 words per phase, taps paired as c0 | c1<<16 (51 words); 4-tap = 2 words per phase, c0 | c1<<16, c2 | c3<<16 (34 words, 136 bytes); a 2-tap converter exists (1 word per phase, 17 words) but is unused by InitSclCoeff. The vendor allocates one 5888-byte (0x1700) buffer and places tables at 256-byte slots: slots 0-5 horizontal luma (lanczos3, cubic, lanczos2, 3M_a19, 2M_a05, 1.5M_a05 low-pass variants), 6-10 horizontal chroma 4-tap, 11-17 vertical luma 6-tap, 18-22 vertical chroma 4-tap. Slot selection (PROVEN, GenSclCfg 0x14924; r = output/input size, horizontal 12.20, vertical 20.12): horizontal luma: r > 1 slot 0, r == 1 slot 1, 0.5 <= r < 1 slot 2, 1/3 < r < 0.5 slot 3, 0.25 <= r <= 1/3 slot 4, r < 0.25 slot 5; horizontal chroma: r > 1 slot 6, == 1 slot 7, 0.5 <= r < 1 slot 6, 1/3 < r < 0.5 slot 9, else slot 10; vertical luma: r > 1 slot 11, == 1 slot 12, >= 0.75 slot 13, >= 0.5 slot 14, > 1/3 slot 15, >= 0.25 slot 16, else slot 17; vertical chroma: r > 1 slot 18, == 1 slot 19, >= 0.5 slot 18, > 1/3 slot 21, else slot 22. The pre-scaler pointers (+0x3A0 horizontal, +0x3A8 vertical) are always slot 2 and slot 6. Steps (in/out): horizontal luma = (in << 20) / out, vertical luma = (in << 12) / out, chroma the same with the chroma sizes; the 28-bit step fields of the 8-word scaler blocks (0x204/0x208 + 0x20*ch) take these (INFERRED which of the two words is which). Not verified on hardware.  Source: hi3520D_vpss.ko. Not verified on hardware.";
        field {
            name = "val";
            desc = "Table address, 16-byte aligned. POSITION seen in hi3520D_vpss.ko (HIGH); MEANING INFERRED from the HAL function name only (LOW) Not verified on hardware.";
            sw = rw;
            hw = r;
        } val[31:0];
    } N_CH3_COEF_2 @ 0x3E8;

    reg {
        name = "Channel scaler coefficient table address 3.3 (VPSS_HAL_SetChnSclCoeff)";
        desc = "Node image offset 0x3EC. Four table addresses per channel slot (SetChnSclCoeff takes four pointers and requires each 16-byte aligned; order +0 hor luma, +4 ver luma, +8 hor chroma, +12 ver chroma: PROVEN, GenSclCfg). Slot order as CH_IMG_SIZE. COEFFICIENT TABLE FORMAT (vendor pass 2026-11-11, InitSclCoeff and vpss_scl*coef_to_dut, HIGH for the packing, MEDIUM for which pointer is which): the four tables of a channel are horizontal luma (8 taps), horizontal chroma (4 taps), vertical luma (6 taps) and vertical chroma (4 taps) (pointer order PROVEN from GenSclCfg 0x14924, which fills the four pointers: +0 horizontal luma, +4 vertical luma, +8 horizontal chroma, +12 vertical chroma). Each table has 17 phases (1/16 pel steps, phase 0..16); a tap is a signed 10-bit value (two's complement masked to 10 bits), unity = 512 (every phase sums to 512 in the vendor tables, phase 0 of a few tables sums to 511). Packing (little endian 32-bit words): 8-tap luma = 3 words per phase: w0 = c0 | c1<<10 | c2<<20, w1 = c3 | c4<<10 | c5<<20, w2 = c6 | c7<<10 (51 words, 204 bytes); 6-tap = 3 words per phase, taps paired as c0 | c1<<16 (51 words); 4-tap = 2 words per phase, c0 | c1<<16, c2 | c3<<16 (34 words, 136 bytes); a 2-tap converter exists (1 word per phase, 17 words) but is unused by InitSclCoeff. The vendor allocates one 5888-byte (0x1700) buffer and places tables at 256-byte slots: slots 0-5 horizontal luma (lanczos3, cubic, lanczos2, 3M_a19, 2M_a05, 1.5M_a05 low-pass variants), 6-10 horizontal chroma 4-tap, 11-17 vertical luma 6-tap, 18-22 vertical chroma 4-tap. Slot selection (PROVEN, GenSclCfg 0x14924; r = output/input size, horizontal 12.20, vertical 20.12): horizontal luma: r > 1 slot 0, r == 1 slot 1, 0.5 <= r < 1 slot 2, 1/3 < r < 0.5 slot 3, 0.25 <= r <= 1/3 slot 4, r < 0.25 slot 5; horizontal chroma: r > 1 slot 6, == 1 slot 7, 0.5 <= r < 1 slot 6, 1/3 < r < 0.5 slot 9, else slot 10; vertical luma: r > 1 slot 11, == 1 slot 12, >= 0.75 slot 13, >= 0.5 slot 14, > 1/3 slot 15, >= 0.25 slot 16, else slot 17; vertical chroma: r > 1 slot 18, == 1 slot 19, >= 0.5 slot 18, > 1/3 slot 21, else slot 22. The pre-scaler pointers (+0x3A0 horizontal, +0x3A8 vertical) are always slot 2 and slot 6. Steps (in/out): horizontal luma = (in << 20) / out, vertical luma = (in << 12) / out, chroma the same with the chroma sizes; the 28-bit step fields of the 8-word scaler blocks (0x204/0x208 + 0x20*ch) take these (INFERRED which of the two words is which). Not verified on hardware.  Source: hi3520D_vpss.ko. Not verified on hardware.";
        field {
            name = "val";
            desc = "Table address, 16-byte aligned. POSITION seen in hi3520D_vpss.ko (HIGH); MEANING INFERRED from the HAL function name only (LOW) Not verified on hardware.";
            sw = rw;
            hw = r;
        } val[31:0];
    } N_CH3_COEF_3 @ 0x3EC;

    reg {
        name = "Next node address";
        desc = "Node image offset 0x3F0. VPSS_HAL_SetNext writes the physical address of the next node here, 0 ends the list (the same offset is the MMIO next-node register that the start sequence loads with the first node address). INFERRED, MEDIUM.  Source: hi3520D_vpss.ko. Not verified on hardware.";
        field {
            name = "val";
            desc = "Next node physical address, 0 = last node. POSITION seen in hi3520D_vpss.ko (HIGH); MEANING INFERRED from the HAL function name only (LOW) Not verified on hardware.";
            sw = rw;
            hw = r;
        } val[31:0];
    } N_NEXT @ 0x3F0;

    reg {
        name = "Gamma table address (VPSS_HAL_SetGammaAddr)";
        desc = "Node image offset 0x3F4. Candidate content (vendor pass 2026-11-11, LOW): the module carries a 256-byte monotonic byte table aGamma (values 24 .. 215, a luma range-compressing curve) that no code in hi3520D_vpss.ko references by name; which buffer the caller passes here was not traced.  Source: hi3520D_vpss.ko. Not verified on hardware.";
        field {
            name = "val";
            desc = "Physical address. POSITION seen in hi3520D_vpss.ko (HIGH); MEANING INFERRED from the HAL function name only (LOW) Not verified on hardware.";
            sw = rw;
            hw = r;
        } val[31:0];
    } N_GAMMA_ADDR @ 0x3F4;

    reg {
        name = "Miscellaneous word (VPSS_HAL_SetMiscellaneous)";
        desc = "Node image offset 0x414. Bits [23:16] set by SetMiscellaneous from the model parameter (values 3 and 100 appear in VPSS_DRV_SetModelParam). The MMIO register at the same offset is written by VPSS_HAL_SetOutstanding (see VPSS_OUTSTANDING).  Source: hi3520D_vpss.ko. Not verified on hardware.";
        field {
            name = "misc";
            desc = "8-bit value. POSITION seen in hi3520D_vpss.ko (HIGH); MEANING INFERRED from the HAL function name only (LOW) Not verified on hardware.";
            sw = rw;
            hw = r;
        } misc[23:16];
    } N_MISC @ 0x414;

    reg {
        name = "Node timeout (VPSS_HAL_SetTimeOut)";
        desc = "Node image offset 0x41C.  Source: hi3520D_vpss.ko. Not verified on hardware.";
        field {
            name = "val";
            desc = "Timeout value (unit unknown). POSITION seen in hi3520D_vpss.ko (HIGH); MEANING INFERRED from the HAL function name only (LOW) Not verified on hardware.";
            sw = rw;
            hw = r;
        } val[31:0];
    } N_TIMEOUT @ 0x41C;

};

`endif
