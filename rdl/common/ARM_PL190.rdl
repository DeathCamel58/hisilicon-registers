`ifndef ARM_PL190_RDL
`define ARM_PL190_RDL

regfile eARM_PL190 {
    name = "Vectored interrupt controller (ARM PrimeCell PL190)";
    desc = "
    Vectored interrupt controller of the Hi3518E V20X / Hi3516C V200 at 0x100D0000, 32 interrupt sources, ARM926EJ-S IRQ/FIQ (data sheet issue 02, section 3.4). The registers
    the data sheet documents (INT_IRQSTATUS 0x000 .. INT_PROTECTION 0x020, Table 3-9) are exactly the register set of the **ARM PrimeCell PL190 VIC** (the vendor device tree uses
    `arm,pl190-vic` at `reg = <0x100d0000 0x1000>`, so mainline's `irq-vic` driver applies; a PL192 would additionally have SWPRIORITYMASK 0x024 / PRIORITYDAISY 0x028 and VICADDRESS at 0xF00).
    The data sheet does **not** document the vector registers: VICADDRESS (0x030), VICDEFVECTADDR (0x034), VICVECTADDR0..15 (0x100), VICVECTCNTL0..15 (0x200), the test registers (0x300..) and the PrimeCell ID
    registers (0xFE0..0xFFC) are added from the PL190 TRM (marked \"not in the data sheet\"); whether the hardware implements the vectored part and what its ID registers read is unverified.
    The data sheet uses its own register names (`INT_*`, DS Table 3-9); the PL190 names are given in each description.

    **Interrupt source allocation (data sheet Table 3-8, bit n of the status/enable registers):** 0 global soft interrupt, 1 watchdog, 2 RTC / Temper_Cap, 3 Timer0/Timer1, 4 Timer2/Timer3, 5 UART0,
    6 SSP0, 7 SSP1, 8 GZIP / SDIO1, 9 AIAO, 10 USB device, 11 FMC, 12 ETH, 13 CIPHER, 14 DMAC, 15 USB EHCI, 16 USB OHCI, 17 VPSS, 18 SDIO0, 19 IR / SAR ADC, 20 I2C0/I2C1/I2C2, 21 IVE, 22 VICAP,
    23 VDP, 24 AVC, 25 UART2, 26 JPGE, 27 TDE, 28 MIPI, 29 VGS, 30 UART1, 31 GPIO0-GPIO8 (shared lines: the individual source must be read from the peripheral).

    Source: data sheet 3.4 (`hi3518ev200--Hi3518EV20X-Hi3516CV200-Datasheet.txt` lines 24659-25083). All 32-bit; the 32 bits of the INT_* registers are one bit per source.
    ";

    reg {
        name = "IRQ interrupt status register";
        desc = "INT_IRQSTATUS is an IRQ interrupt status register. The 32 bits correspond to 32 interrupt sources (see the interrupt source allocation, data sheet Table 3-8).

PL190 name: VICIRQSTATUS.

Data sheet 3.4.3 INT_IRQSTATUS (offset 0x0, printed page 3-47, `hi3518ev200--Hi3518EV20X-Hi3516CV200-Datasheet.txt` line 24749).";

        enum INT_IRQSTATUS_irqstatus_enum {
            NO_INTERRUPT_GENERATED = 0x0 { name = "No Interrupt Generated"; desc = "No interrupt is generated."; };
            IRQ_INTERRUPT_GENERATED = 0x1 { name = "Irq Interrupt Generated"; desc = "An IRQ interrupt is generated and sent to the processor."; };
        };

        field {
            name = "irqstatus";
            desc = "Status of the IRQ interrupt source";
            sw = r;
            hw = w;
            encode = INT_IRQSTATUS_irqstatus_enum;
            reset = 0x0;
        } irqstatus[31:0];
    } INT_IRQSTATUS @ 0x0;

    reg {
        name = "FIQ interrupt status register";
        desc = "INT_FIQSTATUS is an FIQ interrupt status register. The 32 bits correspond to 32 interrupt sources.

PL190 name: VICFIQSTATUS.

Data sheet 3.4.3 INT_FIQSTATUS (offset 0x4, printed page 3-48, `hi3518ev200--Hi3518EV20X-Hi3516CV200-Datasheet.txt` line 24780).";

        enum INT_FIQSTATUS_fiqstatus_enum {
            NO_INTERRUPT_GENERATED = 0x0 { name = "No Interrupt Generated"; desc = "No interrupt is generated."; };
            FIQ_INTERRUPT_GENERATED = 0x1 { name = "Fiq Interrupt Generated"; desc = "An FIQ interrupt is generated and sent to the processor."; };
        };

        field {
            name = "fiqstatus";
            desc = "Status of the FIQ interrupt source";
            sw = r;
            hw = w;
            encode = INT_FIQSTATUS_fiqstatus_enum;
            reset = 0x0;
        } fiqstatus[31:0];
    } INT_FIQSTATUS @ 0x4;

    reg {
        name = "Raw interrupt status register";
        desc = "INT_RAWINTR is a raw interrupt status register. It shows the status of raw interrupt requests and the status of the software interrupts that are generated by configuring INT_SOFTINT. The 32 bits correspond to 32 interrupt sources.

PL190 name: VICRAWINTR.

Data sheet 3.4.3 INT_RAWINTR (offset 0x8, printed page 3-48, `hi3518ev200--Hi3518EV20X-Hi3516CV200-Datasheet.txt` line 24803).";

        enum INT_RAWINTR_rawinterrupt_enum {
            NO_INTERRUPT_GENERATED = 0x0 { name = "No Interrupt Generated"; desc = "No interrupt is generated."; };
            INTERRUPT_GENERATED = 0x1 { name = "Interrupt Generated"; desc = "An interrupt is generated."; };
        };

        field {
            name = "rawinterrupt";
            desc = "Status of the raw interrupt source request";
            sw = r;
            hw = w;
            encode = INT_RAWINTR_rawinterrupt_enum;
            reset = 0x0;
        } rawinterrupt[31:0];
    } INT_RAWINTR @ 0x8;

    reg {
        name = "Interrupt source select register";
        desc = "PL190 name: VICINTSELECT.

Data sheet 3.4.3 INT_INTSELECT (offset 0xC, printed page 3-49, `hi3518ev200--Hi3518EV20X-Hi3516CV200-Datasheet.txt` line 24836).";

        enum INT_INTSELECT_intselect_enum {
            IRQ_INTERRUPT = 0x0 { name = "Irq Interrupt"; desc = "IRQ interrupt"; };
            FIQ_INTERRUPT = 0x1 { name = "Fiq Interrupt"; desc = "FIQ interrupt"; };
        };

        field {
            name = "intselect";
            desc = "Interrupt request type of the interrupt source";
            sw = rw;
            hw = r;
            encode = INT_INTSELECT_intselect_enum;
            reset = 0x0;
        } intselect[31:0];
    } INT_INTSELECT @ 0xC;

    reg {
        name = "Interrupt enable register";
        desc = "INT_INTENABLE is an interrupt enable register. It is used to enable interrupt request lines. During reset, the value of INT_INTENABLE is changed to 0x0000_0000. As a result, all interrupt sources are masked. The 32 bits correspond to 32 interrupt sources.

PL190 name: VICINTENABLE.

Data sheet 3.4.3 INT_INTENABLE (offset 0x10, printed page 3-49, `hi3518ev200--Hi3518EV20X-Hi3516CV200-Datasheet.txt` line 24859).";

        field {
            name = "intenable";
            desc = "The mask status of each interrupt source is returned when this register is read. 0: masked 1: not masked The interrupt source is enabled by bit when this register is written. 0: The current value of the corresponding bit is not affected. 1: The corresponding bit is set to 1 to enable the corresponding interrupt request.";
            sw = rw;
            hw = r;
            reset = 0x0;
        } intenable[31:0];
    } INT_INTENABLE @ 0x10;

    reg {
        name = "Interrupt enable clear register";
        desc = "INT_INTENCLEAR is an interrupt enable clear register. It is used to clear the corresponding bits of INT_INTENABLE. INT_INTENCLEAR is write-only and has no default reset value.

PL190 name: VICINTENCLEAR.

Data sheet 3.4.3 INT_INTENCLEAR (offset 0x14, printed page 3-50, `hi3518ev200--Hi3518EV20X-Hi3516CV200-Datasheet.txt` line 24897).";

        enum INT_INTENCLEAR_intenableclear_enum {
            CURRENT_VALUE_CORRESPONDING = 0x0 { name = "Current Value Corresponding"; desc = "The current value of the corresponding bit of INT_INTENABLE is not affected."; };
            CORRESPONDING_BIT_INT = 0x1 { name = "Corresponding Bit Int"; desc = "The corresponding bit of INT_INTENABLE is cleared and the corresponding interrupt request is masked."; };
        };

        field {
            name = "intenableclear";
            desc = "Mask of the interrupt source corresponding to INT_INTENABLE";
            sw = w;
            hw = r;
            encode = INT_INTENCLEAR_intenableclear_enum;
        } intenableclear[31:0];
    } INT_INTENCLEAR @ 0x14;

    reg {
        name = "Software interrupt register";
        desc = "INT_SOFTINT is a software interrupt register. It controls whether the interrupt source input line generates software interrupts by using software. The software interrupts can be cleared by writing INT_SOFTINTCLEAR after the interrupt service routine (ISR) ends.

PL190 name: VICSOFTINT.

Data sheet 3.4.3 INT_SOFTINT (offset 0x18, printed page 3-50, `hi3518ev200--Hi3518EV20X-Hi3516CV200-Datasheet.txt` line 24922).";

        enum INT_SOFTINT_softint_enum {
            CURRENT_VALUE_CORRESPONDING = 0x0 { name = "Current Value Corresponding"; desc = "The current value of the corresponding bit is not affected."; };
            CORRESPONDING_BIT_SET = 0x1 { name = "Corresponding Bit Set"; desc = "The corresponding bit is set to 1 and a software interrupt request is generated."; };
        };

        field {
            name = "softint";
            desc = "Generation of a raw software interrupt on a specified interrupt source";
            sw = rw;
            hw = r;
            encode = INT_SOFTINT_softint_enum;
            reset = 0x0;
        } softint[31:0];
    } INT_SOFTINT @ 0x18;

    reg {
        name = "Software interrupt clear register";
        desc = "INT_SOFTINTCLEAR is a software interrupt clear register. It is used to clear the corresponding bit of INT_SOFTINT. INT_SOFTINTCLEAR is write-only and has no default reset value.

PL190 name: VICSOFTINTCLEAR.

Data sheet 3.4.3 INT_SOFTINTCLEAR (offset 0x1C, printed page 3-51, `hi3518ev200--Hi3518EV20X-Hi3516CV200-Datasheet.txt` line 24957).";

        enum INT_SOFTINTCLEAR_softintclear_enum {
            CORRESPONDING_BIT_INT = 0x0 { name = "Corresponding Bit Int"; desc = "The corresponding bit of INT_SOFTINT is not affected."; };
            CORRESPONDING_BIT_INT_2 = 0x1 { name = "Corresponding Bit Int 2"; desc = "The corresponding bit of INT_SOFTINT is cleared and the corresponding interrupt request is masked."; };
        };

        field {
            name = "softintclear";
            desc = "Mask of the interrupt request corresponding to INT_SOFTINT";
            sw = w;
            hw = r;
            encode = INT_SOFTINTCLEAR_softintclear_enum;
        } softintclear[31:0];
    } INT_SOFTINTCLEAR @ 0x1C;

    reg {
        name = "Protection enable register";
        desc = "INT_PROTECTION is a protection enable register. It is used to enable or disable the access to protected registers.     This register is cleared during reset and the INT registers can be accessed in user mode or privileged mode.     When the CPU fails to generate the correct protection information (HPROT), the INT registers can be accessed in user mode after this register is reset.

PL190 name: VICPROTECTION.

Data sheet 3.4.3 INT_PROTECTION (offset 0x20, printed page 3-51, `hi3518ev200--Hi3518EV20X-Hi3516CV200-Datasheet.txt` line 24988).";

        enum INT_PROTECTION_protection_enum {
            DISABLED_CPU_CAN = 0 { name = "Disabled Cpu Can"; desc = "disabled. The CPU can access INT registers in user mode or privileged mode."; };
            ENABLED_CPU_CAN = 1 { name = "Enabled Cpu Can"; desc = "enabled. The CPU can access INT registers only in privileged mode."; };
        };

        field {
            name = "protection";
            desc = "Register access protection enable";
            sw = rw;
            hw = r;
            encode = INT_PROTECTION_protection_enum;
            reset = 0x0;
        } protection[0:0];
    } INT_PROTECTION @ 0x20;

    reg {
        name = "Vector address register";
        desc = "INT_VECTADDR (PL190 VICADDRESS). Reading returns the address of the currently active interrupt's ISR (from INT_VECTADDRn or INT_DEFVECTADDR) and marks it being serviced; writing any value at the end of the ISR clears the current priority level. In non-vectored use (Linux `irq-vic` for pl190) software reads INT_IRQSTATUS and writes this register at the end of the interrupt.

ARM PrimeCell Vectored Interrupt Controller (PL190) TRM; not in the Hi3518E V20X data sheet, not hardware verified.";

        field {
            name = "vectaddr";
            desc = "Vector address of the active interrupt (read), any value written re-enables lower-priority interrupts.";
            sw = rw;
            hw = r;
            reset = 0x0;
        } vectaddr[31:0];
    } INT_VECTADDR @ 0x30;

    reg {
        name = "Default vector address register";
        desc = "INT_DEFVECTADDR (PL190 VICDEFVECTADDR). Address returned by INT_VECTADDR when an active IRQ source has no vector slot enabled.

ARM PrimeCell Vectored Interrupt Controller (PL190) TRM; not in the Hi3518E V20X data sheet, not hardware verified.";

        field {
            name = "defvectaddr";
            desc = "Default ISR address.";
            sw = rw;
            hw = r;
            reset = 0x0;
        } defvectaddr[31:0];
    } INT_DEFVECTADDR @ 0x34;

    reg {
        name = "Vector address registers";
        desc = "INT_VECTADDR_n (PL190 VICVECTADDR0-15, offset 0x100 + 4 x n). ISR address of vectored interrupt slot n (slot 0 has the highest priority).

ARM PrimeCell Vectored Interrupt Controller (PL190) TRM; not in the Hi3518E V20X data sheet, not hardware verified.";

        field {
            name = "vectaddr";
            desc = "ISR address for vector slot n.";
            sw = rw;
            hw = r;
            reset = 0x0;
        } vectaddr[31:0];
    } INT_VECTADDR_n[16] @ 0x100 += 0x4;

    reg {
        name = "Vector control registers";
        desc = "INT_VECTCNTL_n (PL190 VICVECTCNTL0-15, offset 0x200 + 4 x n). Binds an interrupt source to vector slot n and enables the slot.

ARM PrimeCell Vectored Interrupt Controller (PL190) TRM; not in the Hi3518E V20X data sheet, not hardware verified.";

        field {
            name = "enable";
            desc = "Vector slot enable. 0: disabled. 1: enabled.";
            sw = rw;
            hw = r;
            reset = 0x0;
        } enable[5:5];

        field {
            name = "source";
            desc = "Interrupt source number (0-31) assigned to this slot.";
            sw = rw;
            hw = r;
            reset = 0x0;
        } source[4:0];
    } INT_VECTCNTL_n[16] @ 0x200 += 0x4;

    reg {
        name = "Test control register";
        desc = "INT_ITCR (PL190 VICITCR). Bit 0 = 1 enables test mode (the VIC ignores its inputs and is driven from INT_ITIP1/2).

ARM PrimeCell Vectored Interrupt Controller (PL190) TRM; not in the Hi3518E V20X data sheet, not hardware verified.";

        field {
            name = "test_enable";
            desc = "Test mode enable. 0: normal. 1: test mode.";
            sw = rw;
            hw = r;
            reset = 0x0;
        } test_enable[0:0];
    } INT_ITCR @ 0x300;

    reg {
        name = "Test input register 1";
        desc = "INT_ITIP1 (PL190 VICITIP1): interrupt input values used instead of the pins in test mode (INT_ITCR.test_enable = 1). Bit layout not modelled; plain 32-bit register.

ARM PrimeCell Vectored Interrupt Controller (PL190) TRM; not in the Hi3518E V20X data sheet, not hardware verified.";

        field {
            name = "itip1";
            desc = "Test input value.";
            sw = rw;
            hw = r;
            reset = 0x0;
        } itip1[31:0];
    } INT_ITIP1 @ 0x304;

    reg {
        name = "Test input register 2";
        desc = "INT_ITIP2 (PL190 VICITIP2): second test input register (see the TRM). Plain 32-bit register.

ARM PrimeCell Vectored Interrupt Controller (PL190) TRM; not in the Hi3518E V20X data sheet, not hardware verified.";

        field {
            name = "itip2";
            desc = "Test input value.";
            sw = rw;
            hw = r;
            reset = 0x0;
        } itip2[31:0];
    } INT_ITIP2 @ 0x308;

    reg {
        name = "Test output register 1";
        desc = "INT_ITOP1 (PL190 VICITOP1): test output observation register (see the TRM). Plain 32-bit read-only register.

ARM PrimeCell Vectored Interrupt Controller (PL190) TRM; not in the Hi3518E V20X data sheet, not hardware verified.";

        field {
            name = "itop1";
            desc = "Test output value.";
            sw = r;
            hw = w;
        } itop1[31:0];
    } INT_ITOP1 @ 0x30C;

    reg {
        name = "Test output register 2";
        desc = "INT_ITOP2 (PL190 VICITOP2): second test output observation register (see the TRM). Plain 32-bit read-only register.

ARM PrimeCell Vectored Interrupt Controller (PL190) TRM; not in the Hi3518E V20X data sheet, not hardware verified.";

        field {
            name = "itop2";
            desc = "Test output value.";
            sw = r;
            hw = w;
        } itop2[31:0];
    } INT_ITOP2 @ 0x310;

    reg {
        name = "Identification register PERIPHID0";
        desc = "Part number [7:0] = 0x90. Read-only.

ARM PrimeCell Vectored Interrupt Controller (PL190) TRM; not in the Hi3518E V20X data sheet, not hardware verified.";

        field {
            name = "id";
            desc = "Identification byte.";
            sw = r;
            hw = w;
            reset = 0x90;
        } id[7:0];
    } INT_PERIPHID0 @ 0xFE0;

    reg {
        name = "Identification register PERIPHID1";
        desc = "Designer [3:0] = 0x1 (ARM), part number [11:8] = 0x1. Read-only.

ARM PrimeCell Vectored Interrupt Controller (PL190) TRM; not in the Hi3518E V20X data sheet, not hardware verified.";

        field {
            name = "id";
            desc = "Identification byte.";
            sw = r;
            hw = w;
            reset = 0x11;
        } id[7:0];
    } INT_PERIPHID1 @ 0xFE4;

    reg {
        name = "Identification register PERIPHID2";
        desc = "Revision [7:4] (implementation dependent) and designer [7:4] = 0x4 (ARM). Read-only.

ARM PrimeCell Vectored Interrupt Controller (PL190) TRM; not in the Hi3518E V20X data sheet, not hardware verified. Revision-dependent byte: no reset value given.";

        field {
            name = "id";
            desc = "Identification byte.";
            sw = r;
            hw = w;
        } id[7:0];
    } INT_PERIPHID2 @ 0xFE8;

    reg {
        name = "Identification register PERIPHID3";
        desc = "Configuration. Read-only.

ARM PrimeCell Vectored Interrupt Controller (PL190) TRM; not in the Hi3518E V20X data sheet, not hardware verified.";

        field {
            name = "id";
            desc = "Identification byte.";
            sw = r;
            hw = w;
            reset = 0x0;
        } id[7:0];
    } INT_PERIPHID3 @ 0xFEC;

    reg {
        name = "Identification register PCELLID0";
        desc = "PrimeCell ID 0. Read-only.

ARM PrimeCell Vectored Interrupt Controller (PL190) TRM; not in the Hi3518E V20X data sheet, not hardware verified.";

        field {
            name = "id";
            desc = "Identification byte.";
            sw = r;
            hw = w;
            reset = 0xD;
        } id[7:0];
    } INT_PCELLID0 @ 0xFF0;

    reg {
        name = "Identification register PCELLID1";
        desc = "PrimeCell ID 1. Read-only.

ARM PrimeCell Vectored Interrupt Controller (PL190) TRM; not in the Hi3518E V20X data sheet, not hardware verified.";

        field {
            name = "id";
            desc = "Identification byte.";
            sw = r;
            hw = w;
            reset = 0xF0;
        } id[7:0];
    } INT_PCELLID1 @ 0xFF4;

    reg {
        name = "Identification register PCELLID2";
        desc = "PrimeCell ID 2. Read-only.

ARM PrimeCell Vectored Interrupt Controller (PL190) TRM; not in the Hi3518E V20X data sheet, not hardware verified.";

        field {
            name = "id";
            desc = "Identification byte.";
            sw = r;
            hw = w;
            reset = 0x5;
        } id[7:0];
    } INT_PCELLID2 @ 0xFF8;

    reg {
        name = "Identification register PCELLID3";
        desc = "PrimeCell ID 3. Read-only.

ARM PrimeCell Vectored Interrupt Controller (PL190) TRM; not in the Hi3518E V20X data sheet, not hardware verified.";

        field {
            name = "id";
            desc = "Identification byte.";
            sw = r;
            hw = w;
            reset = 0xB1;
        } id[7:0];
    } INT_PCELLID3 @ 0xFFC;

};

`endif
