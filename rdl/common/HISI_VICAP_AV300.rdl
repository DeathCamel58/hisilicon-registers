`ifndef HISI_VICAP_AV300_RDL
`define HISI_VICAP_AV300_RDL


regfile eHISI_VICAP_AV300 {
    name = "VICAP (video capture, Hi3516A V300)";
    desc = "Video capture unit (VICAP) of the Hi3516A V300 at 0x11300000 (data sheet chapter 9.1; interrupt 88 in the data sheet interrupt table). Port, channel and ISP front-end registers; the PT (port) block sits at 0x1000 and online/slave blocks are new against the V2 family. The data sheet of this chip is Chinese-only: this block transcribes register offsets, names, bit ranges, access types and reset values from the data sheet register tables; the Chinese description text and value encodings were NOT translated, so every description here is generated from the register or field name. Generated 2026-11-15 by scripts/rdl-extract/gen_m_cells.py from the data sheet register tables (ds_extract2 + description extraction from the PDF); PROVENANCE: PROVEN = offsets, names, bit fields, access and reset values from the data sheet tables; nothing here is hardware verified.

    Register sources: 90 registers from the data sheet (hi3516av300--Hi3516AV300-Datasheet.txt, section 9.1.6). ";

    reg {
        name = "WK_MODE";
        desc = "Data sheet 9.1.6 WK_MODE (offset 0x0, printed page 9-19, `hi3516av300--Hi3516AV300-Datasheet.txt` line 34155).";

        field {
            name = "power_mode";
            desc = "Power mode. Chinese-only data sheet: description and value encoding not translated.";
            sw = rw;
            hw = r;
            reset = 0x1;
        } power_mode[0:0];
    } WK_MODE @ 0x0;

    reg {
        name = "AXI_CFG";
        desc = "Data sheet 9.1.6 AXI_CFG (offset 0x10, printed page 9-19, `hi3516av300--Hi3516AV300-Datasheet.txt` line 34181).";

        field {
            name = "w_outstanding";
            desc = "W outstanding. Chinese-only data sheet: description and value encoding not translated.";
            sw = rw;
            hw = r;
            reset = 0x0;
        } w_outstanding[7:4];
    } AXI_CFG @ 0x10;

    reg {
        name = "AXI_WR_PROT";
        desc = "Data sheet 9.1.6 AXI_WR_PROT (offset 0x1C, printed page 9-20, `hi3516av300--Hi3516AV300-Datasheet.txt` line 34208).";

        field {
            name = "isp3_stt_prot";
            desc = "Isp3 statistics prot. Chinese-only data sheet: description and value encoding not translated.";
            sw = rw;
            hw = r;
            reset = 0x0;
        } isp3_stt_prot[11:11];

        field {
            name = "isp2_stt_prot";
            desc = "Isp2 statistics prot. Chinese-only data sheet: description and value encoding not translated.";
            sw = rw;
            hw = r;
            reset = 0x0;
        } isp2_stt_prot[10:10];

        field {
            name = "isp1_stt_prot";
            desc = "Isp1 statistics prot. Chinese-only data sheet: description and value encoding not translated.";
            sw = rw;
            hw = r;
            reset = 0x0;
        } isp1_stt_prot[9:9];

        field {
            name = "isp0_stt_prot";
            desc = "Isp0 statistics prot. Chinese-only data sheet: description and value encoding not translated.";
            sw = rw;
            hw = r;
            reset = 0x0;
        } isp0_stt_prot[8:8];

        field {
            name = "Coch3_prot";
            desc = "Coch3 prot. Chinese-only data sheet: description and value encoding not translated.";
            sw = rw;
            hw = r;
            reset = 0x0;
        } Coch3_prot[3:3];

        field {
            name = "ch2_prot";
            desc = "Ch2 prot. Chinese-only data sheet: description and value encoding not translated.";
            sw = rw;
            hw = r;
            reset = 0x0;
        } ch2_prot[2:2];

        field {
            name = "ch1_prot";
            desc = "Ch1 prot. Chinese-only data sheet: description and value encoding not translated.";
            sw = rw;
            hw = r;
            reset = 0x0;
        } ch1_prot[1:1];

        field {
            name = "ch0_prot";
            desc = "Ch0 prot. Chinese-only data sheet: description and value encoding not translated.";
            sw = rw;
            hw = r;
            reset = 0x0;
        } ch0_prot[0:0];
    } AXI_WR_PROT @ 0x1C;

    reg {
        name = "CMUX_SEL";
        desc = "Data sheet 9.1.6 CMUX_SEL (offset 0x50, printed page 9-21, `hi3516av300--Hi3516AV300-Datasheet.txt` line 34278).";

        field {
            name = "chn3_sel";
            desc = "Chn3 select. Chinese-only data sheet: description and value encoding not translated.";
            sw = rw;
            hw = r;
            reset = 0x3;
        } chn3_sel[15:12];

        field {
            name = "chn2_sel";
            desc = "Chn2 select. Chinese-only data sheet: description and value encoding not translated.";
            sw = rw;
            hw = r;
            reset = 0x2;
        } chn2_sel[11:8];

        field {
            name = "chn1_sel";
            desc = "Chn1 select. Chinese-only data sheet: description and value encoding not translated.";
            sw = rw;
            hw = r;
            reset = 0x1;
        } chn1_sel[7:4];

        field {
            name = "chn0_sel";
            desc = "Chn0 select. Chinese-only data sheet: description and value encoding not translated.";
            sw = rw;
            hw = r;
            reset = 0x0;
        } chn0_sel[3:0];
    } CMUX_SEL @ 0x50;

    reg {
        name = "CMUX_ID_CFG";
        desc = "Data sheet 9.1.6 CMUX_ID_CFG (offset 0x54, printed page 9-21, `hi3516av300--Hi3516AV300-Datasheet.txt` line 34328).";

        field {
            name = "chn3_id";
            desc = "Chn3 id. Chinese-only data sheet: description and value encoding not translated.";
            sw = rw;
            hw = r;
            reset = 0xF;
        } chn3_id[15:12];

        field {
            name = "chn2_id";
            desc = "Chn2 id. Chinese-only data sheet: description and value encoding not translated.";
            sw = rw;
            hw = r;
            reset = 0xF;
        } chn2_id[11:8];

        field {
            name = "chn1_id";
            desc = "Chn1 id. Chinese-only data sheet: description and value encoding not translated.";
            sw = rw;
            hw = r;
            reset = 0xF;
        } chn1_id[7:4];

        field {
            name = "chn0_id";
            desc = "Chn0 id. Chinese-only data sheet: description and value encoding not translated.";
            sw = rw;
            hw = r;
            reset = 0xF;
        } chn0_id[3:0];
    } CMUX_ID_CFG @ 0x54;

    reg {
        name = "ISP_MODE";
        desc = "Data sheet 9.1.6 ISP_MODE (offset 0x58, printed page 9-22, `hi3516av300--Hi3516AV300-Datasheet.txt` line 34403).";

        field {
            name = "isp3_in_yuv_mode";
            desc = "Isp3 in yuv mode. Chinese-only data sheet: description and value encoding not translated.";
            sw = rw;
            hw = r;
            reset = 0x0;
        } isp3_in_yuv_mode[19:19];

        field {
            name = "isp2_in_yuv_mode";
            desc = "Isp2 in yuv mode. Chinese-only data sheet: description and value encoding not translated.";
            sw = rw;
            hw = r;
            reset = 0x0;
        } isp2_in_yuv_mode[18:18];

        field {
            name = "isp1_in_yuv_mode";
            desc = "Isp1 in yuv mode. Chinese-only data sheet: description and value encoding not translated.";
            sw = rw;
            hw = r;
            reset = 0x0;
        } isp1_in_yuv_mode[17:17];

        field {
            name = "isp0_in_yuv_mode";
            desc = "Isp0 in yuv mode. Chinese-only data sheet: description and value encoding not translated.";
            sw = rw;
            hw = r;
            reset = 0x0;
        } isp0_in_yuv_mode[16:16];

        field {
            name = "isp3_mode";
            desc = "Isp3 mode. Chinese-only data sheet: description and value encoding not translated.";
            sw = rw;
            hw = r;
            reset = 0x0;
        } isp3_mode[3:3];

        field {
            name = "isp2_mode";
            desc = "Isp2 mode. Chinese-only data sheet: description and value encoding not translated.";
            sw = rw;
            hw = r;
            reset = 0x0;
        } isp2_mode[2:2];

        field {
            name = "isp1_mode";
            desc = "Isp1 mode. Chinese-only data sheet: description and value encoding not translated.";
            sw = rw;
            hw = r;
            reset = 0x0;
        } isp1_mode[1:1];

        field {
            name = "isp0_mode";
            desc = "Isp0 mode. Chinese-only data sheet: description and value encoding not translated.";
            sw = rw;
            hw = r;
            reset = 0x0;
        } isp0_mode[0:0];
    } ISP_MODE @ 0x58;

    reg {
        name = "VICAP_INT";
        desc = "Data sheet 9.1.6 VICAP_INT (offset 0xF0, printed page 9-23, `hi3516av300--Hi3516AV300-Datasheet.txt` line 34472).";

        field {
            name = "int_dbg";
            desc = "Interrupt dbg. Chinese-only data sheet: description and value encoding not translated.";
            sw = r;
            hw = w;
            reset = 0x0;
        } int_dbg[26:26];

        field {
            name = "int_isp3";
            desc = "Interrupt isp3. Chinese-only data sheet: description and value encoding not translated.";
            sw = r;
            hw = w;
            reset = 0x0;
        } int_isp3[19:19];

        field {
            name = "int_isp2";
            desc = "Interrupt isp2. Chinese-only data sheet: description and value encoding not translated.";
            sw = r;
            hw = w;
            reset = 0x0;
        } int_isp2[18:18];

        field {
            name = "int_isp1";
            desc = "Interrupt isp1. Chinese-only data sheet: description and value encoding not translated.";
            sw = r;
            hw = w;
            reset = 0x0;
        } int_isp1[17:17];

        field {
            name = "int_isp0";
            desc = "Interrupt isp0. Chinese-only data sheet: description and value encoding not translated.";
            sw = r;
            hw = w;
            reset = 0x0;
        } int_isp0[16:16];

        field {
            name = "int_ch3";
            desc = "Interrupt ch3. Chinese-only data sheet: description and value encoding not translated.";
            sw = r;
            hw = w;
            reset = 0x0;
        } int_ch3[11:11];

        field {
            name = "int_ch2";
            desc = "Interrupt ch2. Chinese-only data sheet: description and value encoding not translated.";
            sw = r;
            hw = w;
            reset = 0x0;
        } int_ch2[10:10];

        field {
            name = "int_ch1";
            desc = "Interrupt ch1. Chinese-only data sheet: description and value encoding not translated.";
            sw = r;
            hw = w;
            reset = 0x0;
        } int_ch1[9:9];

        field {
            name = "int_ch0";
            desc = "Interrupt ch0. Chinese-only data sheet: description and value encoding not translated.";
            sw = r;
            hw = w;
            reset = 0x0;
        } int_ch0[8:8];

        field {
            name = "int_pt1";
            desc = "Interrupt pt1. Chinese-only data sheet: description and value encoding not translated.";
            sw = r;
            hw = w;
            reset = 0x0;
        } int_pt1[1:1];

        field {
            name = "int_pt0";
            desc = "Interrupt pt0. Chinese-only data sheet: description and value encoding not translated.";
            sw = r;
            hw = w;
            reset = 0x0;
        } int_pt0[0:0];
    } VICAP_INT @ 0xF0;

    reg {
        name = "VICAP_INT_MASK";
        desc = "Data sheet 9.1.6 VICAP_INT_MASK (offset 0xF8, printed page 9-25, `hi3516av300--Hi3516AV300-Datasheet.txt` line 34565).";

        field {
            name = "mask_dbg";
            desc = "Mask dbg. Chinese-only data sheet: description and value encoding not translated.";
            sw = rw;
            hw = r;
            reset = 0x0;
        } mask_dbg[26:26];

        field {
            name = "mask_isp3";
            desc = "Mask isp3. Chinese-only data sheet: description and value encoding not translated.";
            sw = rw;
            hw = r;
            reset = 0x0;
        } mask_isp3[19:19];

        field {
            name = "mask_isp2";
            desc = "Mask isp2. Chinese-only data sheet: description and value encoding not translated.";
            sw = rw;
            hw = r;
            reset = 0x0;
        } mask_isp2[18:18];

        field {
            name = "bumask_isp1Co";
            desc = "Bumask isp1Co. Chinese-only data sheet: description and value encoding not translated.";
            sw = rw;
            hw = r;
            reset = 0x0;
        } bumask_isp1Co[17:17];

        field {
            name = "mask_isp0";
            desc = "Mask isp0. Chinese-only data sheet: description and value encoding not translated.";
            sw = rw;
            hw = r;
            reset = 0x0;
        } mask_isp0[16:16];

        field {
            name = "mask_ch3";
            desc = "Mask ch3. Chinese-only data sheet: description and value encoding not translated.";
            sw = rw;
            hw = r;
            reset = 0x0;
        } mask_ch3[11:11];

        field {
            name = "mask_ch2";
            desc = "Mask ch2. Chinese-only data sheet: description and value encoding not translated.";
            sw = rw;
            hw = r;
            reset = 0x0;
        } mask_ch2[10:10];

        field {
            name = "mask_ch1";
            desc = "Mask ch1. Chinese-only data sheet: description and value encoding not translated.";
            sw = rw;
            hw = r;
            reset = 0x0;
        } mask_ch1[9:9];

        field {
            name = "mask_ch0";
            desc = "Mask ch0. Chinese-only data sheet: description and value encoding not translated.";
            sw = rw;
            hw = r;
            reset = 0x0;
        } mask_ch0[8:8];

        field {
            name = "mask_pt1";
            desc = "Mask pt1. Chinese-only data sheet: description and value encoding not translated.";
            sw = rw;
            hw = r;
            reset = 0x0;
        } mask_pt1[1:1];

        field {
            name = "mask_pt0";
            desc = "Mask pt0. Chinese-only data sheet: description and value encoding not translated.";
            sw = rw;
            hw = r;
            reset = 0x0;
        } mask_pt0[0:0];
    } VICAP_INT_MASK @ 0xF8;

    reg {
        name = "SLAVE0_MODE_CFG";
        desc = "Data sheet 9.1.6 SLAVE0_MODE_CFG (offset 0x100, printed page 9-26, `hi3516av300--Hi3516AV300-Datasheet.txt` line 34658).";

        field {
            name = "slave0_vs_enable";
            desc = "Slave0 vertical sync enable. Chinese-only data sheet: description and value encoding not translated.";
            sw = rw;
            hw = r;
            reset = 0x0;
        } slave0_vs_enable[31:31];

        field {
            name = "slave0_hs_enable";
            desc = "Slave0 horizontal sync enable. Chinese-only data sheet: description and value encoding not translated.";
            sw = rw;
            hw = r;
            reset = 0x0;
        } slave0_hs_enable[30:30];

        field {
            name = "slave0_vs_out_enable";
            desc = "Slave0 vertical sync out enable. Chinese-only data sheet: description and value encoding not translated.";
            sw = rw;
            hw = r;
            reset = 0x0;
        } slave0_vs_out_enable[29:29];

        field {
            name = "slave0_vs_inv";
            desc = "Slave0 vertical sync invert. Chinese-only data sheet: description and value encoding not translated.";
            sw = rw;
            hw = r;
            reset = 0x0;
        } slave0_vs_inv[17:17];

        field {
            name = "slave0_hs_inv";
            desc = "Slave0 horizontal sync invert. Chinese-only data sheet: description and value encoding not translated.";
            sw = rw;
            hw = r;
            reset = 0x0;
        } slave0_hs_inv[16:16];

        field {
            name = "slave0_vs_out_inv";
            desc = "Slave0 vertical sync out invert. Chinese-only data sheet: description and value encoding not translated.";
            sw = rw;
            hw = r;
            reset = 0x0;
        } slave0_vs_out_inv[15:15];

        field {
            name = "slave0_vs_mux";
            desc = "Slave0 vertical sync mux. Chinese-only data sheet: description and value encoding not translated.";
            sw = rw;
            hw = r;
            reset = 0x0;
        } slave0_vs_mux[14:14];

        field {
            name = "slave0_update_mode";
            desc = "Slave0 update mode. Chinese-only data sheet: description and value encoding not translated.";
            sw = rw;
            hw = r;
            reset = 0x0;
        } slave0_update_mode[0:0];
    } SLAVE0_MODE_CFG @ 0x100;

    reg {
        name = "SLAVE0_MODE_VS_TIME_H";
        desc = "Data sheet 9.1.6 SLAVE0_MODE_VS_TIME_H (offset 0x104, printed page 9-27, `hi3516av300--Hi3516AV300-Datasheet.txt` line 34727).";

        field {
            name = "slave0_vs_time_h";
            desc = "Slave0 vertical sync time h. Chinese-only data sheet: description and value encoding not translated.";
            sw = rw;
            hw = r;
            reset = 0x0;
        } slave0_vs_time_h[31:0];
    } SLAVE0_MODE_VS_TIME_H @ 0x104;

    reg {
        name = "SLAVE0_MODE_VS_TIME_L";
        desc = "Data sheet 9.1.6 SLAVE0_MODE_VS_TIME_L (offset 0x108, printed page 9-27, `hi3516av300--Hi3516AV300-Datasheet.txt` line 34747).";

        field {
            name = "slave0_vs_time_l";
            desc = "Slave0 vertical sync time l. Chinese-only data sheet: description and value encoding not translated.";
            sw = rw;
            hw = r;
            reset = 0x0;
        } slave0_vs_time_l[31:0];
    } SLAVE0_MODE_VS_TIME_L @ 0x108;

    reg {
        name = "SLAVE0_MODE_HS_TIME";
        desc = "Data sheet 9.1.6 SLAVE0_MODE_HS_TIME (offset 0x10C, printed page 9-28, `hi3516av300--Hi3516AV300-Datasheet.txt` line 34764).";

        field {
            name = "slave0_hs_time";
            desc = "Slave0 horizontal sync time. Chinese-only data sheet: description and value encoding not translated.";
            sw = rw;
            hw = r;
            reset = 0x0;
        } slave0_hs_time[31:0];
    } SLAVE0_MODE_HS_TIME @ 0x10C;

    reg {
        name = "SLAVE0_MODE_VS_OUT_TIME_H";
        desc = "Data sheet 9.1.6 SLAVE0_MODE_VS_OUT_TIME_H (offset 0x110, printed page 9-28, `hi3516av300--Hi3516AV300-Datasheet.txt` line 34777).";

        field {
            name = "slave0_vs_out_time_h";
            desc = "Slave0 vertical sync out time h. Chinese-only data sheet: description and value encoding not translated.";
            sw = rw;
            hw = r;
            reset = 0x0;
        } slave0_vs_out_time_h[31:0];
    } SLAVE0_MODE_VS_OUT_TIME_H @ 0x110;

    reg {
        name = "SLAVE0_MODE_VS_OUT_TIME_L";
        desc = "Data sheet 9.1.6 SLAVE0_MODE_VS_OUT_TIME_L (offset 0x114, printed page 9-28, `hi3516av300--Hi3516AV300-Datasheet.txt` line 34795).";

        field {
            name = "slave0_vs_out_time_lgo";
            desc = "Slave0 vertical sync out time lgo. Chinese-only data sheet: description and value encoding not translated.";
            sw = rw;
            hw = r;
            reset = 0x0;
        } slave0_vs_out_time_lgo[31:0];
    } SLAVE0_MODE_VS_OUT_TIME_L @ 0x114;

    reg {
        name = "SLAVE0_MODE_VS_CYC_H";
        desc = "Data sheet 9.1.6 SLAVE0_MODE_VS_CYC_H (offset 0x118, printed page 9-28, `hi3516av300--Hi3516AV300-Datasheet.txt` line 34815).";

        field {
            name = "slave0_vs_cyc_h";
            desc = "Slave0 vertical sync cyc h. Chinese-only data sheet: description and value encoding not translated.";
            sw = rw;
            hw = r;
            reset = 0x0;
        } slave0_vs_cyc_h[31:0];
    } SLAVE0_MODE_VS_CYC_H @ 0x118;

    reg {
        name = "SLAVE0_MODE_VS_CYC_L";
        desc = "Data sheet 9.1.6 SLAVE0_MODE_VS_CYC_L (offset 0x11C, printed page 9-29, `hi3516av300--Hi3516AV300-Datasheet.txt` line 34833).";

        field {
            name = "slave0_vs_cyc_l";
            desc = "Slave0 vertical sync cyc l. Chinese-only data sheet: description and value encoding not translated.";
            sw = rw;
            hw = r;
            reset = 0x0;
        } slave0_vs_cyc_l[31:0];
    } SLAVE0_MODE_VS_CYC_L @ 0x11C;

    reg {
        name = "SLAVE0_MODE_HS_CYC";
        desc = "Data sheet 9.1.6 SLAVE0_MODE_HS_CYC (offset 0x120, printed page 9-29, `hi3516av300--Hi3516AV300-Datasheet.txt` line 34847).";

        field {
            name = "slave0_hs_cyc";
            desc = "Slave0 horizontal sync cyc. Chinese-only data sheet: description and value encoding not translated.";
            sw = rw;
            hw = r;
            reset = 0x0;
        } slave0_hs_cyc[31:0];
    } SLAVE0_MODE_HS_CYC @ 0x120;

    reg {
        name = "SLAVE0_MODE_VS_OUT_CYC_H";
        desc = "Data sheet 9.1.6 SLAVE0_MODE_VS_OUT_CYC_H (offset 0x124, printed page 9-29, `hi3516av300--Hi3516AV300-Datasheet.txt` line 34867).";

        field {
            name = "slave0_vs_out_cyc_hgo";
            desc = "Slave0 vertical sync out cyc hgo. Chinese-only data sheet: description and value encoding not translated.";
            sw = rw;
            hw = r;
            reset = 0x0;
        } slave0_vs_out_cyc_hgo[31:0];
    } SLAVE0_MODE_VS_OUT_CYC_H @ 0x124;

    reg {
        name = "SLAVE0_MODE_VS_OUT_CYC_L";
        desc = "Data sheet 9.1.6 SLAVE0_MODE_VS_OUT_CYC_L (offset 0x128, printed page 9-29, `hi3516av300--Hi3516AV300-Datasheet.txt` line 34888).";

        field {
            name = "slave0_vs_out_cyc_l";
            desc = "Slave0 vertical sync out cyc l. Chinese-only data sheet: description and value encoding not translated.";
            sw = rw;
            hw = r;
            reset = 0x0;
        } slave0_vs_out_cyc_l[31:0];
    } SLAVE0_MODE_VS_OUT_CYC_L @ 0x128;

    reg {
        name = "SLAVE0_MODE_HS_DLY_CYC";
        desc = "Data sheet 9.1.6 SLAVE0_MODE_HS_DLY_CYC (offset 0x12C, printed page 9-30, `hi3516av300--Hi3516AV300-Datasheet.txt` line 34909).";

        field {
            name = "slave0_hs_dly_cyc";
            desc = "Slave0 horizontal sync delay cyc. Chinese-only data sheet: description and value encoding not translated.";
            sw = rw;
            hw = r;
            reset = 0x0;
        } slave0_hs_dly_cyc[31:0];
    } SLAVE0_MODE_HS_DLY_CYC @ 0x12C;

    reg {
        name = "SLAVE0_MODE_VS_OUT_DLY_CYC_H";
        desc = "Data sheet 9.1.6 SLAVE0_MODE_VS_OUT_DLY_CYC_H (offset 0x130, printed page 9-30, `hi3516av300--Hi3516AV300-Datasheet.txt` line 34923).";

        field {
            name = "slave0_vs_out_dly_c";
            desc = "Slave0 vertical sync out delay c. Chinese-only data sheet: description and value encoding not translated.";
            sw = rw;
            hw = r;
            reset = 0x0;
        } slave0_vs_out_dly_c[31:0];
    } SLAVE0_MODE_VS_OUT_DLY_CYC_H @ 0x130;

    reg {
        name = "SLAVE0_MODE_VS_OUT_DLY_CYC_L";
        desc = "Data sheet 9.1.6 SLAVE0_MODE_VS_OUT_DLY_CYC_L (offset 0x134, printed page 9-30, `hi3516av300--Hi3516AV300-Datasheet.txt` line 34947).";

        field {
            name = "slave0_vs_out_dly_cyc_l";
            desc = "Slave0 vertical sync out delay cyc l. Chinese-only data sheet: description and value encoding not translated.";
            sw = rw;
            hw = r;
            reset = 0x0;
        } slave0_vs_out_dly_cyc_l[31:0];
    } SLAVE0_MODE_VS_OUT_DLY_CYC_L @ 0x134;

    reg {
        name = "SLAVE_MODE_SYN";
        desc = "Data sheet 9.1.6 SLAVE_MODE_SYN (offset 0x1FC, printed page 9-30, `hi3516av300--Hi3516AV300-Datasheet.txt` line 34971).";

        field {
            name = "sensor1_sync";
            desc = "Sensor1 sync. Chinese-only data sheet: description and value encoding not translated.";
            sw = rw;
            hw = r;
            reset = 0x0;
        } sensor1_sync[1:1];

        field {
            name = "sensor0_sync";
            desc = "Sensor0 sync. Chinese-only data sheet: description and value encoding not translated.";
            sw = rw;
            hw = r;
            reset = 0x0;
        } sensor0_sync[0:0];
    } SLAVE_MODE_SYN @ 0x1FC;

    reg {
        name = "ONLINE0_CFG";
        desc = "Data sheet 9.1.6 ONLINE0_CFG (offset 0x200, printed page 9-31, `hi3516av300--Hi3516AV300-Datasheet.txt` line 34994).";

        field {
            name = "online0_en";
            desc = "Online0 enable. Chinese-only data sheet: description and value encoding not translated.";
            sw = rw;
            hw = r;
            reset = 0x0;
        } online0_en[31:31];

        field {
            name = "online0_vsync_mode";
            desc = "Online0 vertical sync mode. Chinese-only data sheet: description and value encoding not translated.";
            sw = rw;
            hw = r;
            reset = 0x1;
        } online0_vsync_mode[1:1];

        field {
            name = "online0_hsync_mode";
            desc = "Online0 horizontal sync mode. Chinese-only data sheet: description and value encoding not translated.";
            sw = rw;
            hw = r;
            reset = 0x1;
        } online0_hsync_mode[0:0];
    } ONLINE0_CFG @ 0x200;

    reg {
        name = "ONLINE0_SIZE";
        desc = "Data sheet 9.1.6 ONLINE0_SIZE (offset 0x2AC, printed page 9-31, `hi3516av300--Hi3516AV300-Datasheet.txt` line 35028).";

        field {
            name = "online0_height";
            desc = "Online0 height. Chinese-only data sheet: description and value encoding not translated.";
            sw = r;
            hw = w;
            reset = 0x0;
        } online0_height[31:16];

        field {
            name = "online0_width";
            desc = "Online0 width. Chinese-only data sheet: description and value encoding not translated.";
            sw = r;
            hw = w;
            reset = 0x0;
        } online0_width[15:0];
    } ONLINE0_SIZE @ 0x2AC;

    reg {
        name = "VICAP_AXI0_WR_ERROR";
        desc = "Data sheet 9.1.6 VICAP_AXI0_WR_ERROR (offset 0xFE4, printed page 9-31, `hi3516av300--Hi3516AV300-Datasheet.txt` line 35044).";

        field {
            name = "isp3_stt_bus_err";
            desc = "Isp3 statistics bus error. Chinese-only data sheet: description and value encoding not translated.";
            sw = rw;
            hw = w;
            onwrite = woclr;
            reset = 0x0;
        } isp3_stt_bus_err[25:25];

        field {
            name = "isp2_stt_bus_err";
            desc = "Isp2 statistics bus error. Chinese-only data sheet: description and value encoding not translated.";
            sw = rw;
            hw = w;
            onwrite = woclr;
            reset = 0x0;
        } isp2_stt_bus_err[24:24];

        field {
            name = "isp1_stt_bus_err";
            desc = "Isp1 statistics bus error. Chinese-only data sheet: description and value encoding not translated.";
            sw = rw;
            hw = w;
            onwrite = woclr;
            reset = 0x0;
        } isp1_stt_bus_err[23:23];

        field {
            name = "isp0_stt_bus_err";
            desc = "Isp0 statistics bus error. Chinese-only data sheet: description and value encoding not translated.";
            sw = rw;
            hw = w;
            onwrite = woclr;
            reset = 0x0;
        } isp0_stt_bus_err[22:22];

        field {
            name = "ch3_y_bus_err";
            desc = "Ch3 y bus error. Chinese-only data sheet: description and value encoding not translated.";
            sw = rw;
            hw = w;
            onwrite = woclr;
            reset = 0x0;
        } ch3_y_bus_err[6:6];

        field {
            name = "ch2_c_bus_err";
            desc = "Ch2 c bus error. Chinese-only data sheet: description and value encoding not translated.";
            sw = rw;
            hw = w;
            onwrite = woclr;
            reset = 0x0;
        } ch2_c_bus_err[5:5];

        field {
            name = "ch2_y_bus_err";
            desc = "Ch2 y bus error. Chinese-only data sheet: description and value encoding not translated.";
            sw = rw;
            hw = w;
            onwrite = woclr;
            reset = 0x0;
        } ch2_y_bus_err[4:4];

        field {
            name = "ch1_y_bus_err";
            desc = "Ch1 y bus error. Chinese-only data sheet: description and value encoding not translated.";
            sw = rw;
            hw = w;
            onwrite = woclr;
            reset = 0x0;
        } ch1_y_bus_err[2:2];

        field {
            name = "ch0_y_bus_err";
            desc = "Ch0 y bus error. Chinese-only data sheet: description and value encoding not translated.";
            sw = rw;
            hw = w;
            onwrite = woclr;
            reset = 0x0;
        } ch0_y_bus_err[0:0];
    } VICAP_AXI0_WR_ERROR @ 0xFE4;

    reg {
        name = "VICAP_DBG_INT";
        desc = "Data sheet 9.1.6 VICAP_DBG_INT (offset 0xFF0, printed page 9-32, `hi3516av300--Hi3516AV300-Datasheet.txt` line 35090).";

        field {
            name = "apb_bus_err";
            desc = "Apb bus error. Chinese-only data sheet: description and value encoding not translated.";
            sw = rw;
            hw = w;
            onwrite = woclr;
            reset = 0x0;
        } apb_bus_err[1:1];

        field {
            name = "axi_bus_err";
            desc = "Axi bus error. Chinese-only data sheet: description and value encoding not translated.";
            sw = rw;
            hw = w;
            onwrite = woclr;
            reset = 0x0;
        } axi_bus_err[0:0];
    } VICAP_DBG_INT @ 0xFF0;

    reg {
        name = "VICAP_DBG_INT_MASK";
        desc = "Data sheet 9.1.6 VICAP_DBG_INT_MASK (offset 0xFF8, printed page 9-32, `hi3516av300--Hi3516AV300-Datasheet.txt` line 35115).";

        field {
            name = "apb_bus_err_mask";
            desc = "Apb bus error mask. Chinese-only data sheet: description and value encoding not translated.";
            sw = rw;
            hw = r;
            reset = 0x0;
        } apb_bus_err_mask[1:1];

        field {
            name = "axi_bus_err_mask";
            desc = "Axi bus error mask. Chinese-only data sheet: description and value encoding not translated.";
            sw = rw;
            hw = r;
            reset = 0x0;
        } axi_bus_err_mask[0:0];
    } VICAP_DBG_INT_MASK @ 0xFF8;

    reg {
        name = "PT_INTF_MOD";
        desc = "Data sheet 9.1.6 PT_INTF_MOD (offset 0x1000, printed page 9-33, `hi3516av300--Hi3516AV300-Datasheet.txt` line 35141).";

        field {
            name = "pt_enable";
            desc = "Pt enable. Chinese-only data sheet: description and value encoding not translated.";
            sw = rw;
            hw = r;
            reset = 0x0;
        } pt_enable[31:31];

        field {
            name = "pt_mode";
            desc = "Pt mode. Chinese-only data sheet: description and value encoding not translated.";
            sw = rw;
            hw = r;
            reset = 0x0;
        } pt_mode[0:0];
    } PT_INTF_MOD @ 0x1000;

    reg {
        name = "PT_OFFSET0";
        desc = "Data sheet 9.1.6 PT_OFFSET0 (offset 0x1010, printed page 9-33, `hi3516av300--Hi3516AV300-Datasheet.txt` line 35174).";

        field {
            name = "offset0_mask";
            desc = "Offset0 mask. Chinese-only data sheet: description and value encoding not translated.";
            sw = rw;
            hw = r;
            reset = 0xFFF0;
        } offset0_mask[31:16];

        field {
            name = "offset0_rev";
            desc = "Offset0 rev. Chinese-only data sheet: description and value encoding not translated.";
            sw = rw;
            hw = r;
            reset = 0x0;
        } offset0_rev[15:15];

        field {
            name = "offset0";
            desc = "Offset0. Chinese-only data sheet: description and value encoding not translated.";
            sw = rw;
            hw = r;
            reset = 0x0;
        } offset0[5:0];
    } PT_OFFSET0 @ 0x1010;

    reg {
        name = "PT_OFFSET1";
        desc = "Data sheet 9.1.6 PT_OFFSET1 (offset 0x1014, printed page 9-34, `hi3516av300--Hi3516AV300-Datasheet.txt` line 35203).";

        field {
            name = "offset1_mask";
            desc = "Offset1 mask. Chinese-only data sheet: description and value encoding not translated.";
            sw = rw;
            hw = r;
            reset = 0xFFF0;
        } offset1_mask[31:16];

        field {
            name = "offset1_rev";
            desc = "Offset1 rev. Chinese-only data sheet: description and value encoding not translated.";
            sw = rw;
            hw = r;
            reset = 0x0;
        } offset1_rev[15:15];

        field {
            name = "offset1";
            desc = "Offset1. Chinese-only data sheet: description and value encoding not translated.";
            sw = rw;
            hw = r;
            reset = 0x10;
        } offset1[5:0];
    } PT_OFFSET1 @ 0x1014;

    reg {
        name = "PT_OFFSET2";
        desc = "Data sheet 9.1.6 PT_OFFSET2 (offset 0x1018, printed page 9-34, `hi3516av300--Hi3516AV300-Datasheet.txt` line 35226).";

        field {
            name = "offset2_mask";
            desc = "Offset2 mask. Chinese-only data sheet: description and value encoding not translated.";
            sw = rw;
            hw = r;
            reset = 0xFFF0;
        } offset2_mask[31:16];

        field {
            name = "offset2_rev";
            desc = "Offset2 rev. Chinese-only data sheet: description and value encoding not translated.";
            sw = rw;
            hw = r;
            reset = 0x0;
        } offset2_rev[15:15];

        field {
            name = "offset2";
            desc = "Offset2. Chinese-only data sheet: description and value encoding not translated.";
            sw = rw;
            hw = r;
            reset = 0x20;
        } offset2[5:0];
    } PT_OFFSET2 @ 0x1018;

    reg {
        name = "PT_BT656_CFG";
        desc = "Data sheet 9.1.6 PT_BT656_CFG (offset 0x1020, printed page 9-34, `hi3516av300--Hi3516AV300-Datasheet.txt` line 35253).";

        field {
            name = "bt656_enable";
            desc = "Bt656 enable. Chinese-only data sheet: description and value encoding not translated.";
            sw = rw;
            hw = r;
            reset = 0x0;
        } bt656_enable[31:31];

        field {
            name = "bt656_field_inv";
            desc = "Bt656 field invert. Chinese-only data sheet: description and value encoding not translated.";
            sw = rw;
            hw = r;
            reset = 0x0;
        } bt656_field_inv[10:10];

        field {
            name = "bt656_vsync_inv";
            desc = "Bt656 vertical sync invert. Chinese-only data sheet: description and value encoding not translated.";
            sw = rw;
            hw = r;
            reset = 0x1;
        } bt656_vsync_inv[9:9];

        field {
            name = "bt656_hsync_inv";
            desc = "Bt656 horizontal sync invert. Chinese-only data sheet: description and value encoding not translated.";
            sw = rw;
            hw = r;
            reset = 0x1;
        } bt656_hsync_inv[8:8];

        field {
            name = "bt656_mode";
            desc = "Bt656 mode. Chinese-only data sheet: description and value encoding not translated.";
            sw = rw;
            hw = r;
            reset = 0x3;
        } bt656_mode[3:0];
    } PT_BT656_CFG @ 0x1020;

    reg {
        name = "PT_UNIFY_TIMING_CFG";
        desc = "Data sheet 9.1.6 PT_UNIFY_TIMING_CFG (offset 0x1038, printed page 9-35, `hi3516av300--Hi3516AV300-Datasheet.txt` line 35321).";

        field {
            name = "unify_field_inv";
            desc = "Unify field invert. Chinese-only data sheet: description and value encoding not translated.";
            sw = rw;
            hw = r;
            reset = 0x0;
        } unify_field_inv[26:26];

        field {
            name = "unify_field_sel";
            desc = "Unify field select. Chinese-only data sheet: description and value encoding not translated.";
            sw = rw;
            hw = r;
            reset = 0x0;
        } unify_field_sel[25:24];

        field {
            name = "unify_vsync_mode";
            desc = "Unify vertical sync mode. Chinese-only data sheet: description and value encoding not translated.";
            sw = rw;
            hw = r;
            reset = 0x0;
        } unify_vsync_mode[20:19];

        field {
            name = "unify_vsync_inv";
            desc = "Unify vertical sync invert. Chinese-only data sheet: description and value encoding not translated.";
            sw = rw;
            hw = r;
            reset = 0x0;
        } unify_vsync_inv[18:18];

        field {
            name = "unify_vsync_sel";
            desc = "Unify vertical sync select. Chinese-only data sheet: description and value encoding not translated.";
            sw = rw;
            hw = r;
            reset = 0x0;
        } unify_vsync_sel[17:16];

        field {
            name = "buunify_hsync_modeCo";
            desc = "Buunify horizontal sync modeCo. Chinese-only data sheet: description and value encoding not translated.";
            sw = rw;
            hw = r;
            reset = 0x0;
        } buunify_hsync_modeCo[14:13];

        field {
            name = "unify_hsync_and";
            desc = "Unify horizontal sync and. Chinese-only data sheet: description and value encoding not translated.";
            sw = rw;
            hw = r;
            reset = 0x0;
        } unify_hsync_and[12:11];

        field {
            name = "unify_hsync_inv";
            desc = "Unify horizontal sync invert. Chinese-only data sheet: description and value encoding not translated.";
            sw = rw;
            hw = r;
            reset = 0x0;
        } unify_hsync_inv[10:10];

        field {
            name = "unify_hsync_sel";
            desc = "Unify horizontal sync select. Chinese-only data sheet: description and value encoding not translated.";
            sw = rw;
            hw = r;
            reset = 0x0;
        } unify_hsync_sel[9:8];

        field {
            name = "unify_de_inv";
            desc = "Unify de invert. Chinese-only data sheet: description and value encoding not translated.";
            sw = rw;
            hw = r;
            reset = 0x0;
        } unify_de_inv[2:2];

        field {
            name = "unify_de_sel";
            desc = "Unify de select. Chinese-only data sheet: description and value encoding not translated.";
            sw = rw;
            hw = r;
            reset = 0x0;
        } unify_de_sel[1:0];
    } PT_UNIFY_TIMING_CFG @ 0x1038;

    reg {
        name = "PT_GEN_TIMING_CFG";
        desc = "Data sheet 9.1.6 PT_GEN_TIMING_CFG (offset 0x103C, printed page 9-37, `hi3516av300--Hi3516AV300-Datasheet.txt` line 35440).";

        field {
            name = "gen_enable";
            desc = "Gen enable. Chinese-only data sheet: description and value encoding not translated.";
            sw = rw;
            hw = r;
            reset = 0x0;
        } gen_enable[31:31];

        field {
            name = "gen_mode";
            desc = "Gen mode. Chinese-only data sheet: description and value encoding not translated.";
            sw = rw;
            hw = r;
            reset = 0x1;
        } gen_mode[30:30];

        field {
            name = "gen_vsync_mode";
            desc = "Gen vertical sync mode. Chinese-only data sheet: description and value encoding not translated.";
            sw = rw;
            hw = r;
            reset = 0x1;
        } gen_vsync_mode[2:2];

        field {
            name = "gen_hsync_mode";
            desc = "Gen horizontal sync mode. Chinese-only data sheet: description and value encoding not translated.";
            sw = rw;
            hw = r;
            reset = 0x1;
        } gen_hsync_mode[1:1];
    } PT_GEN_TIMING_CFG @ 0x103C;

    reg {
        name = "PT_UNIFY_DATA_CFG";
        desc = "Data sheet 9.1.6 PT_UNIFY_DATA_CFG (offset 0x1040, printed page 9-38, `hi3516av300--Hi3516AV300-Datasheet.txt` line 35488).";

        field {
            name = "unify_data_enable";
            desc = "Unify data enable. Chinese-only data sheet: description and value encoding not translated.";
            sw = rw;
            hw = r;
            reset = 0x0;
        } unify_data_enable[31:31];

        field {
            name = "unify_data_uv_seq";
            desc = "Unify data uv seq. Chinese-only data sheet: description and value encoding not translated.";
            sw = rw;
            hw = r;
            reset = 0x0;
        } unify_data_uv_seq[3:3];

        field {
            name = "unify_data_yc_seq";
            desc = "Unify data yc seq. Chinese-only data sheet: description and value encoding not translated.";
            sw = rw;
            hw = r;
            reset = 0x0;
        } unify_data_yc_seq[2:2];

        field {
            name = "mbu";
            desc = "Mbu. Chinese-only data sheet: description and value encoding not translated.";
            sw = rw;
            hw = r;
            reset = 0x0;
        } mbu[1:0];
    } PT_UNIFY_DATA_CFG @ 0x1040;

    reg {
        name = "PT_GEN_DATA_CFG";
        desc = "Data sheet 9.1.6 PT_GEN_DATA_CFG (offset 0x1044, printed page 9-38, `hi3516av300--Hi3516AV300-Datasheet.txt` line 35534).";

        field {
            name = "gen_data_enable";
            desc = "Gen data enable. Chinese-only data sheet: description and value encoding not translated.";
            sw = rw;
            hw = r;
            reset = 0x0;
        } gen_data_enable[31:31];

        field {
            name = "gen_data0_move";
            desc = "Gen data0 move. Chinese-only data sheet: description and value encoding not translated.";
            sw = rw;
            hw = r;
            reset = 0x1;
        } gen_data0_move[7:7];

        field {
            name = "gen_data1_move";
            desc = "Gen data1 move. Chinese-only data sheet: description and value encoding not translated.";
            sw = rw;
            hw = r;
            reset = 0x1;
        } gen_data1_move[6:6];

        field {
            name = "gen_data2_move";
            desc = "Gen data2 move. Chinese-only data sheet: description and value encoding not translated.";
            sw = rw;
            hw = r;
            reset = 0x1;
        } gen_data2_move[5:5];

        field {
            name = "gen_data_vsync_reset";
            desc = "Gen data vertical sync reset. Chinese-only data sheet: description and value encoding not translated.";
            sw = rw;
            hw = r;
            reset = 0x0;
        } gen_data_vsync_reset[4:4];

        field {
            name = "gen_data_hsync_reset";
            desc = "Gen data horizontal sync reset. Chinese-only data sheet: description and value encoding not translated.";
            sw = rw;
            hw = r;
            reset = 0x1;
        } gen_data_hsync_reset[3:3];

        field {
            name = "gen_data_vsync_move";
            desc = "Gen data vertical sync move. Chinese-only data sheet: description and value encoding not translated.";
            sw = rw;
            hw = r;
            reset = 0x0;
        } gen_data_vsync_move[2:2];

        field {
            name = "gen_data_hsync_mobuve";
            desc = "Gen data horizontal sync mobuve. Chinese-only data sheet: description and value encoding not translated.";
            sw = rw;
            hw = r;
            reset = 0x0;
        } gen_data_hsync_mobuve[1:1];

        field {
            name = "gen_data_de_move";
            desc = "Gen data de move. Chinese-only data sheet: description and value encoding not translated.";
            sw = rw;
            hw = r;
            reset = 0x1;
        } gen_data_de_move[0:0];
    } PT_GEN_DATA_CFG @ 0x1044;

    reg {
        name = "PT_GEN_DATA_COEF";
        desc = "Data sheet 9.1.6 PT_GEN_DATA_COEF (offset 0x1048, printed page 9-39, `hi3516av300--Hi3516AV300-Datasheet.txt` line 35612).";

        field {
            name = "inc_frame";
            desc = "Inc frame. Chinese-only data sheet: description and value encoding not translated.";
            sw = rw;
            hw = r;
            reset = 0x1;
        } inc_frame[31:24];

        field {
            name = "step_frame";
            desc = "Step frame. Chinese-only data sheet: description and value encoding not translated.";
            sw = rw;
            hw = r;
            reset = 0x0;
        } step_frame[23:16];

        field {
            name = "inc_space";
            desc = "Inc space. Chinese-only data sheet: description and value encoding not translated.";
            sw = rw;
            hw = r;
            reset = 0x1;
        } inc_space[15:8];

        field {
            name = "step_space";
            desc = "Step space. Chinese-only data sheet: description and value encoding not translated.";
            sw = rw;
            hw = r;
            reset = 0x0;
        } step_space[7:0];
    } PT_GEN_DATA_COEF @ 0x1048;

    reg {
        name = "PT_GEN_DATA_INIT";
        desc = "Data sheet 9.1.6 PT_GEN_DATA_INIT (offset 0x104C, printed page 9-40, `hi3516av300--Hi3516AV300-Datasheet.txt` line 35645).";

        field {
            name = "data2";
            desc = "Data2. Chinese-only data sheet: description and value encoding not translated.";
            sw = rw;
            hw = r;
            reset = 0x0;
        } data2[23:16];

        field {
            name = "data1";
            desc = "Data1. Chinese-only data sheet: description and value encoding not translated.";
            sw = rw;
            hw = r;
            reset = 0x0;
        } data1[15:8];

        field {
            name = "data0";
            desc = "Data0. Chinese-only data sheet: description and value encoding not translated.";
            sw = rw;
            hw = r;
            reset = 0x0;
        } data0[7:0];
    } PT_GEN_DATA_INIT @ 0x104C;

    reg {
        name = "PT_YUV444_CFG";
        desc = "Data sheet 9.1.6 PT_YUV444_CFG (offset 0x1050, printed page 9-40, `hi3516av300--Hi3516AV300-Datasheet.txt` line 35671).";

        field {
            name = "yuv44_enable";
            desc = "Yuv44 enable. Chinese-only data sheet: description and value encoding not translated.";
            sw = rw;
            hw = r;
            reset = 0x0;
        } yuv44_enable[31:31];
    } PT_YUV444_CFG @ 0x1050;

    reg {
        name = "PT_FSTART_DLY";
        desc = "Data sheet 9.1.6 PT_FSTART_DLY (offset 0x1060, printed page 9-41, `hi3516av300--Hi3516AV300-Datasheet.txt` line 35697).";

        field {
            name = "pt_fstart_dly";
            desc = "Pt fstart delay. Chinese-only data sheet: description and value encoding not translated.";
            sw = rw;
            hw = r;
            reset = 0x0;
        } pt_fstart_dly[31:0];
    } PT_FSTART_DLY @ 0x1060;

    reg {
        name = "PT_FSTART_H_DLY";
        desc = "Data sheet 9.1.6 PT_FSTART_H_DLY (offset 0x1064, printed page 9-41, `hi3516av300--Hi3516AV300-Datasheet.txt` line 35709).";

        field {
            name = "fstart_h_dly";
            desc = "Fstart h delay. Chinese-only data sheet: description and value encoding not translated.";
            sw = rw;
            hw = r;
            reset = 0x0;
        } fstart_h_dly[31:16];

        field {
            name = "fstart_h_dly_id";
            desc = "Fstart h delay id. Chinese-only data sheet: description and value encoding not translated.";
            sw = rw;
            hw = r;
            reset = 0x0;
        } fstart_h_dly_id[3:0];
    } PT_FSTART_H_DLY @ 0x1064;

    reg {
        name = "PT_INTF_HFB";
        desc = "Data sheet 9.1.6 PT_INTF_HFB (offset 0x1080, printed page 9-41, `hi3516av300--Hi3516AV300-Datasheet.txt` line 35743).";

        field {
            name = "hfb";
            desc = "Hfb. Chinese-only data sheet: description and value encoding not translated.";
            sw = rw;
            hw = r;
            reset = 0x58;
        } hfb[15:0];
    } PT_INTF_HFB @ 0x1080;

    reg {
        name = "PT_INTF_HACT";
        desc = "Data sheet 9.1.6 PT_INTF_HACT (offset 0x1084, printed page 9-41, `hi3516av300--Hi3516AV300-Datasheet.txt` line 35761).";

        field {
            name = "hact";
            desc = "Hact. Chinese-only data sheet: description and value encoding not translated.";
            sw = rw;
            hw = r;
            reset = 0x780;
        } hact[31:0];
    } PT_INTF_HACT @ 0x1084;

    reg {
        name = "PT_INTF_HBB";
        desc = "Data sheet 9.1.6 PT_INTF_HBB (offset 0x1088, printed page 9-42, `hi3516av300--Hi3516AV300-Datasheet.txt` line 35781).";

        field {
            name = "hbb";
            desc = "Hbb. Chinese-only data sheet: description and value encoding not translated.";
            sw = rw;
            hw = r;
            reset = 0xC0;
        } hbb[15:0];
    } PT_INTF_HBB @ 0x1088;

    reg {
        name = "PT_INTF_VFB";
        desc = "Data sheet 9.1.6 PT_INTF_VFB (offset 0x108C, printed page 9-42, `hi3516av300--Hi3516AV300-Datasheet.txt` line 35795).";

        field {
            name = "vfb";
            desc = "Vfb. Chinese-only data sheet: description and value encoding not translated.";
            sw = rw;
            hw = r;
            reset = 0x4;
        } vfb[15:0];
    } PT_INTF_VFB @ 0x108C;

    reg {
        name = "PT_INTF_VACT";
        desc = "Data sheet 9.1.6 PT_INTF_VACT (offset 0x1090, printed page 9-42, `hi3516av300--Hi3516AV300-Datasheet.txt` line 35817).";

        field {
            name = "vact";
            desc = "Vact. Chinese-only data sheet: description and value encoding not translated.";
            sw = rw;
            hw = r;
            reset = 0x438;
        } vact[15:0];
    } PT_INTF_VACT @ 0x1090;

    reg {
        name = "PT_INTF_VBB";
        desc = "Data sheet 9.1.6 PT_INTF_VBB (offset 0x1094, printed page 9-42, `hi3516av300--Hi3516AV300-Datasheet.txt` line 35836).";

        field {
            name = "vbb";
            desc = "Vbb. Chinese-only data sheet: description and value encoding not translated.";
            sw = rw;
            hw = r;
            reset = 0x29;
        } vbb[15:0];
    } PT_INTF_VBB @ 0x1094;

    reg {
        name = "PT_INTF_VBFB";
        desc = "Data sheet 9.1.6 PT_INTF_VBFB (offset 0x1098, printed page 9-43, `hi3516av300--Hi3516AV300-Datasheet.txt` line 35858).";

        field {
            name = "vbfb";
            desc = "Vbfb. Chinese-only data sheet: description and value encoding not translated.";
            sw = rw;
            hw = r;
            reset = 0x4;
        } vbfb[15:0];
    } PT_INTF_VBFB @ 0x1098;

    reg {
        name = "PT_INTF_VBACT";
        desc = "Data sheet 9.1.6 PT_INTF_VBACT (offset 0x109C, printed page 9-43, `hi3516av300--Hi3516AV300-Datasheet.txt` line 35873).";

        field {
            name = "vbact";
            desc = "Vbact. Chinese-only data sheet: description and value encoding not translated.";
            sw = rw;
            hw = r;
            reset = 0x438;
        } vbact[15:0];
    } PT_INTF_VBACT @ 0x109C;

    reg {
        name = "PT_INTF_VBBB";
        desc = "Data sheet 9.1.6 PT_INTF_VBBB (offset 0x10A0, printed page 9-43, `hi3516av300--Hi3516AV300-Datasheet.txt` line 35893).";

        field {
            name = "vbbb";
            desc = "Vbbb. Chinese-only data sheet: description and value encoding not translated.";
            sw = rw;
            hw = r;
            reset = 0x29;
        } vbbb[15:0];
    } PT_INTF_VBBB @ 0x10A0;

    reg {
        name = "PT_ID_CFG";
        desc = "Data sheet 9.1.6 PT_ID_CFG (offset 0x10A4, printed page 9-43, `hi3516av300--Hi3516AV300-Datasheet.txt` line 35909).";

        field {
            name = "id_enable";
            desc = "Id enable. Chinese-only data sheet: description and value encoding not translated.";
            sw = rw;
            hw = r;
            reset = 0x0;
        } id_enable[31:31];

        field {
            name = "id_mode";
            desc = "Id mode. Chinese-only data sheet: description and value encoding not translated.";
            sw = rw;
            hw = r;
            reset = 0x0;
        } id_mode[30:30];

        field {
            name = "id_reset";
            desc = "Id reset. Chinese-only data sheet: description and value encoding not translated.";
            sw = w;
            hw = r;
            reset = 0x0;
        } id_reset[29:29];

        field {
            name = "id_max";
            desc = "Id max. Chinese-only data sheet: description and value encoding not translated.";
            sw = rw;
            hw = r;
            reset = 0x0;
        } id_max[3:2];

        field {
            name = "id";
            desc = "Id. Chinese-only data sheet: description and value encoding not translated.";
            sw = rw;
            hw = r;
            reset = 0x0;
        } id[1:0];
    } PT_ID_CFG @ 0x10A4;

    reg {
        name = "PT_FLASH_CFG";
        desc = "Data sheet 9.1.6 PT_FLASH_CFG (offset 0x10C0, printed page 9-44, `hi3516av300--Hi3516AV300-Datasheet.txt` line 35947).";

        field {
            name = "id_sel";
            desc = "Id select. Chinese-only data sheet: description and value encoding not translated.";
            sw = rw;
            hw = r;
            reset = 0x1;
        } id_sel[31:28];

        field {
            name = "shutter_times";
            desc = "Shutter times. Chinese-only data sheet: description and value encoding not translated.";
            sw = rw;
            hw = r;
            reset = 0x0;
        } shutter_times[18:18];

        field {
            name = "shutter_phase";
            desc = "Shutter phase. Chinese-only data sheet: description and value encoding not translated.";
            sw = rw;
            hw = r;
            reset = 0x0;
        } shutter_phase[17:17];

        field {
            name = "shutter_en";
            desc = "Shutter enable. Chinese-only data sheet: description and value encoding not translated.";
            sw = w;
            hw = r;
            reset = 0x0;
        } shutter_en[16:16];

        field {
            name = "flash_phase";
            desc = "Flash phase. Chinese-only data sheet: description and value encoding not translated.";
            sw = rw;
            hw = r;
            reset = 0x0;
        } flash_phase[1:1];

        field {
            name = "flash_en";
            desc = "Flash enable. Chinese-only data sheet: description and value encoding not translated.";
            sw = w;
            hw = r;
            reset = 0x0;
        } flash_en[0:0];
    } PT_FLASH_CFG @ 0x10C0;

    reg {
        name = "PT_FLASH_CYC0";
        desc = "Data sheet 9.1.6 PT_FLASH_CYC0 (offset 0x10C4, printed page 9-45, `hi3516av300--Hi3516AV300-Datasheet.txt` line 36004).";

        field {
            name = "pt_flash_cyc0";
            desc = "Pt flash cyc0. Chinese-only data sheet: description and value encoding not translated.";
            sw = rw;
            hw = r;
            reset = 0x0;
        } pt_flash_cyc0[31:0];
    } PT_FLASH_CYC0 @ 0x10C4;

    reg {
        name = "PT_FLASH_CYC1";
        desc = "Data sheet 9.1.6 PT_FLASH_CYC1 (offset 0x10C8, printed page 9-45, `hi3516av300--Hi3516AV300-Datasheet.txt` line 36026).";

        field {
            name = "pt_flash_cyc1";
            desc = "Pt flash cyc1. Chinese-only data sheet: description and value encoding not translated.";
            sw = rw;
            hw = r;
            reset = 0x0;
        } pt_flash_cyc1[31:0];
    } PT_FLASH_CYC1 @ 0x10C8;

    reg {
        name = "PT_SHUTTER_CYC0";
        desc = "Data sheet 9.1.6 PT_SHUTTER_CYC0 (offset 0x10D0, printed page 9-45, `hi3516av300--Hi3516AV300-Datasheet.txt` line 36046).";

        field {
            name = "pt_shutter_cyc0";
            desc = "Pt shutter cyc0. Chinese-only data sheet: description and value encoding not translated.";
            sw = rw;
            hw = r;
            reset = 0x0;
        } pt_shutter_cyc0[31:0];
    } PT_SHUTTER_CYC0 @ 0x10D0;

    reg {
        name = "PT_SHUTTER_CYC1";
        desc = "Data sheet 9.1.6 PT_SHUTTER_CYC1 (offset 0x10D4, printed page 9-46, `hi3516av300--Hi3516AV300-Datasheet.txt` line 36068).";

        field {
            name = "pt_shutter_cyc1";
            desc = "Pt shutter cyc1. Chinese-only data sheet: description and value encoding not translated.";
            sw = rw;
            hw = r;
            reset = 0x0;
        } pt_shutter_cyc1[31:0];
    } PT_SHUTTER_CYC1 @ 0x10D4;

    reg {
        name = "PT_SHUTTER_CYC2";
        desc = "Data sheet 9.1.6 PT_SHUTTER_CYC2 (offset 0x10D8, printed page 9-46, `hi3516av300--Hi3516AV300-Datasheet.txt` line 36083).";

        field {
            name = "pt_shutter_cyc2";
            desc = "Pt shutter cyc2. Chinese-only data sheet: description and value encoding not translated.";
            sw = rw;
            hw = r;
            reset = 0x0;
        } pt_shutter_cyc2[31:0];
    } PT_SHUTTER_CYC2 @ 0x10D8;

    reg {
        name = "PT_SHUTTER_CYC3";
        desc = "Data sheet 9.1.6 PT_SHUTTER_CYC3 (offset 0x10DC, printed page 9-46, `hi3516av300--Hi3516AV300-Datasheet.txt` line 36103).";

        field {
            name = "pt_shutter_cyc3";
            desc = "Pt shutter cyc3. Chinese-only data sheet: description and value encoding not translated.";
            sw = rw;
            hw = r;
            reset = 0x0;
        } pt_shutter_cyc3[31:0];
    } PT_SHUTTER_CYC3 @ 0x10DC;

    reg {
        name = "PT_STATUS";
        desc = "Data sheet 9.1.6 PT_STATUS (offset 0x10E0, printed page 9-46, `hi3516av300--Hi3516AV300-Datasheet.txt` line 36121).";

        field {
            name = "pt_status_id";
            desc = "Pt status id. Chinese-only data sheet: description and value encoding not translated.";
            sw = r;
            hw = w;
            reset = 0x0;
        } pt_status_id[5:4];

        field {
            name = "pt_status_field";
            desc = "Pt status field. Chinese-only data sheet: description and value encoding not translated.";
            sw = r;
            hw = w;
            reset = 0x0;
        } pt_status_field[3:3];

        field {
            name = "pt_status_vsync";
            desc = "Pt status vertical sync. Chinese-only data sheet: description and value encoding not translated.";
            sw = r;
            hw = w;
            reset = 0x0;
        } pt_status_vsync[2:2];

        field {
            name = "pt_status_hsync";
            desc = "Pt status horizontal sync. Chinese-only data sheet: description and value encoding not translated.";
            sw = r;
            hw = w;
            reset = 0x0;
        } pt_status_hsync[1:1];

        field {
            name = "pt_status_de";
            desc = "Pt status de. Chinese-only data sheet: description and value encoding not translated.";
            sw = r;
            hw = w;
            reset = 0x0;
        } pt_status_de[0:0];
    } PT_STATUS @ 0x10E0;

    reg {
        name = "PT_BT656_STATUS";
        desc = "Data sheet 9.1.6 PT_BT656_STATUS (offset 0x10E4, printed page 9-47, `hi3516av300--Hi3516AV300-Datasheet.txt` line 36151).";

        field {
            name = "pt_bt656_seav";
            desc = "Pt bt656 seav. Chinese-only data sheet: description and value encoding not translated.";
            sw = r;
            hw = w;
            reset = 0x0;
        } pt_bt656_seav[15:8];
    } PT_BT656_STATUS @ 0x10E4;

    reg {
        name = "PT_SIZE";
        desc = "Data sheet 9.1.6 PT_SIZE (offset 0x10EC, printed page 9-47, `hi3516av300--Hi3516AV300-Datasheet.txt` line 36175).";

        field {
            name = "pt_height";
            desc = "Pt height. Chinese-only data sheet: description and value encoding not translated.";
            sw = r;
            hw = w;
            reset = 0x0;
        } pt_height[31:16];

        field {
            name = "pt_width";
            desc = "Pt width. Chinese-only data sheet: description and value encoding not translated.";
            sw = r;
            hw = w;
            reset = 0x0;
        } pt_width[15:0];
    } PT_SIZE @ 0x10EC;

    reg {
        name = "PT_INT";
        desc = "Data sheet 9.1.6 PT_INT (offset 0x10F0, printed page 9-47, `hi3516av300--Hi3516AV300-Datasheet.txt` line 36195).";

        field {
            name = "pt_fstart_h_dly";
            desc = "Pt fstart h delay. Chinese-only data sheet: description and value encoding not translated.";
            sw = rw;
            hw = w;
            onwrite = woclr;
            reset = 0x0;
        } pt_fstart_h_dly[3:3];

        field {
            name = "pt_height_err";
            desc = "Pt height error. Chinese-only data sheet: description and value encoding not translated.";
            sw = rw;
            hw = w;
            onwrite = woclr;
            reset = 0x0;
        } pt_height_err[2:2];

        field {
            name = "pt_width_err";
            desc = "Pt width error. Chinese-only data sheet: description and value encoding not translated.";
            sw = rw;
            hw = w;
            onwrite = woclr;
            reset = 0x0;
        } pt_width_err[1:1];

        field {
            name = "pt_fstart";
            desc = "Pt fstart. Chinese-only data sheet: description and value encoding not translated.";
            sw = rw;
            hw = w;
            onwrite = woclr;
            reset = 0x0;
        } pt_fstart[0:0];
    } PT_INT @ 0x10F0;

    reg {
        name = "PT_INT_MASK";
        desc = "Data sheet 9.1.6 PT_INT_MASK (offset 0x10F8, printed page 9-48, `hi3516av300--Hi3516AV300-Datasheet.txt` line 36234).";

        field {
            name = "pt_mask_fstart_h_dly";
            desc = "Pt mask fstart h delay. Chinese-only data sheet: description and value encoding not translated.";
            sw = rw;
            hw = r;
            reset = 0x0;
        } pt_mask_fstart_h_dly[3:3];

        field {
            name = "pt_mask_height_err";
            desc = "Pt mask height error. Chinese-only data sheet: description and value encoding not translated.";
            sw = rw;
            hw = r;
            reset = 0x0;
        } pt_mask_height_err[2:2];

        field {
            name = "pt_mask_width_err";
            desc = "Pt mask width error. Chinese-only data sheet: description and value encoding not translated.";
            sw = rw;
            hw = r;
            reset = 0x0;
        } pt_mask_width_err[1:1];

        field {
            name = "pt_mask_fstart";
            desc = "Pt mask fstart. Chinese-only data sheet: description and value encoding not translated.";
            sw = rw;
            hw = r;
            reset = 0x0;
        } pt_mask_fstart[0:0];
    } PT_INT_MASK @ 0x10F8;

    reg {
        name = "CH_CTRL";
        desc = "Data sheet 9.1.6 CH_CTRL (offset 0x10000, printed page 9-49, `hi3516av300--Hi3516AV300-Datasheet.txt` line 36277).";

        field {
            name = "ch_enable";
            desc = "Ch enable. Chinese-only data sheet: description and value encoding not translated.";
            sw = rw;
            hw = r;
            reset = 0x0;
        } ch_enable[31:31];

        field {
            name = "ch_reg_newer_mode";
            desc = "Ch reg newer mode. Chinese-only data sheet: description and value encoding not translated.";
            sw = rw;
            hw = r;
            reset = 0x0;
        } ch_reg_newer_mode[30:30];

        field {
            name = "ch_finish_mode";
            desc = "Ch finish mode. Chinese-only data sheet: description and value encoding not translated.";
            sw = rw;
            hw = r;
            reset = 0x1;
        } ch_finish_mode[17:17];
    } CH_CTRL @ 0x10000;

    reg {
        name = "CH_REG_NEWER";
        desc = "Data sheet 9.1.6 CH_REG_NEWER (offset 0x10004, printed page 9-49, `hi3516av300--Hi3516AV300-Datasheet.txt` line 36308).";

        field {
            name = "ch_reg_newer";
            desc = "Ch reg newer. Chinese-only data sheet: description and value encoding not translated.";
            sw = rw;
            hw = r;
            reset = 0x0;
        } ch_reg_newer[0:0];
    } CH_REG_NEWER @ 0x10004;

    reg {
        name = "CH_DLY_CFG";
        desc = "Data sheet 9.1.6 CH_DLY_CFG (offset 0x10034, printed page 9-49, `hi3516av300--Hi3516AV300-Datasheet.txt` line 36328).";

        field {
            name = "ch_v_dly_cfg";
            desc = "Ch v delay configuration. Chinese-only data sheet: description and value encoding not translated.";
            sw = rw;
            hw = r;
            reset = 0x10;
        } ch_v_dly_cfg[31:16];
    } CH_DLY_CFG @ 0x10034;

    reg {
        name = "CH_CROP_CFG";
        desc = "Data sheet 9.1.6 CH_CROP_CFG (offset 0x10040, printed page 9-50, `hi3516av300--Hi3516AV300-Datasheet.txt` line 36346).";

        field {
            name = "ch_crop_n0_en";
            desc = "Ch crop n0 enable. Chinese-only data sheet: description and value encoding not translated.";
            sw = rw;
            hw = r;
            reset = 0x0;
        } ch_crop_n0_en[0:0];
    } CH_CROP_CFG @ 0x10040;

    reg {
        name = "CH_CROP0_START";
        desc = "Data sheet 9.1.6 CH_CROP0_START (offset 0x10044, printed page 9-50, `hi3516av300--Hi3516AV300-Datasheet.txt` line 36362).";

        field {
            name = "ch_crop_y_start";
            desc = "Ch crop y start. Chinese-only data sheet: description and value encoding not translated.";
            sw = rw;
            hw = r;
            reset = 0x0;
        } ch_crop_y_start[31:16];

        field {
            name = "ch_crop_x_start";
            desc = "Ch crop x start. Chinese-only data sheet: description and value encoding not translated.";
            sw = rw;
            hw = r;
            reset = 0x0;
        } ch_crop_x_start[15:0];
    } CH_CROP0_START @ 0x10044;

    reg {
        name = "CH_CROP0_SIZE";
        desc = "Data sheet 9.1.6 CH_CROP0_SIZE (offset 0x10048, printed page 9-50, `hi3516av300--Hi3516AV300-Datasheet.txt` line 36384).";

        field {
            name = "ch_crop_height";
            desc = "Ch crop height. Chinese-only data sheet: description and value encoding not translated.";
            sw = rw;
            hw = r;
            reset = 0x0;
        } ch_crop_height[31:16];

        field {
            name = "ch_crop_width";
            desc = "Ch crop width. Chinese-only data sheet: description and value encoding not translated.";
            sw = rw;
            hw = r;
            reset = 0x0;
        } ch_crop_width[15:0];
    } CH_CROP0_SIZE @ 0x10048;

    reg {
        name = "CH_SKIP_Y_CFG";
        desc = "Data sheet 9.1.6 CH_SKIP_Y_CFG (offset 0x10050, printed page 9-50, `hi3516av300--Hi3516AV300-Datasheet.txt` line 36407).";

        field {
            name = "ch_skipy_cfg";
            desc = "Ch skipy configuration. Chinese-only data sheet: description and value encoding not translated.";
            sw = rw;
            hw = r;
            reset = 0xFFFFFFFF;
        } ch_skipy_cfg[31:0];
    } CH_SKIP_Y_CFG @ 0x10050;

    reg {
        name = "CH_SKIP_C_CFG";
        desc = "Data sheet 9.1.6 CH_SKIP_C_CFG (offset 0x10058, printed page 9-51, `hi3516av300--Hi3516AV300-Datasheet.txt` line 36427).";

        field {
            name = "ch_skipc_cfg";
            desc = "Ch skipc configuration. Chinese-only data sheet: description and value encoding not translated.";
            sw = rw;
            hw = r;
            reset = 0xFFFFFFFF;
        } ch_skipc_cfg[31:0];
    } CH_SKIP_C_CFG @ 0x10058;

    reg {
        name = "CH_WCH_Y_CFG";
        desc = "Data sheet 9.1.6 CH_WCH_Y_CFG (offset 0x10080, printed page 9-51, `hi3516av300--Hi3516AV300-Datasheet.txt` line 36439).";

        field {
            name = "wch_y_enable";
            desc = "Wch y enable. Chinese-only data sheet: description and value encoding not translated.";
            sw = rw;
            hw = r;
            reset = 0x0;
        } wch_y_enable[31:31];

        field {
            name = "wch_y_wrap_line";
            desc = "Wch y wrap line. Chinese-only data sheet: description and value encoding not translated.";
            sw = rw;
            hw = r;
            reset = 0x0;
        } wch_y_wrap_line[28:15];

        field {
            name = "wch_y_wrap_en";
            desc = "Wch y wrap enable. Chinese-only data sheet: description and value encoding not translated.";
            sw = rw;
            hw = r;
            reset = 0x0;
        } wch_y_wrap_en[14:14];

        field {
            name = "wch_y_cmp_mode";
            desc = "Wch y compare mode. Chinese-only data sheet: description and value encoding not translated.";
            sw = rw;
            hw = r;
            reset = 0x0;
        } wch_y_cmp_mode[13:13];

        field {
            name = "wch_y_cmp_en";
            desc = "Wch y compare enable. Chinese-only data sheet: description and value encoding not translated.";
            sw = rw;
            hw = r;
            reset = 0x0;
        } wch_y_cmp_en[12:12];

        field {
            name = "wch_y_bit_width";
            desc = "Wch y bit width. Chinese-only data sheet: description and value encoding not translated.";
            sw = rw;
            hw = r;
            reset = 0x0;
        } wch_y_bit_width[5:0];
    } CH_WCH_Y_CFG @ 0x10080;

    reg {
        name = "CH_WCH_Y_SIZE";
        desc = "Data sheet 9.1.6 CH_WCH_Y_SIZE (offset 0x10084, printed page 9-52, `hi3516av300--Hi3516AV300-Datasheet.txt` line 36504).";

        field {
            name = "wch_y_height";
            desc = "Wch y height. Chinese-only data sheet: description and value encoding not translated.";
            sw = rw;
            hw = r;
            reset = 0x0;
        } wch_y_height[31:16];

        field {
            name = "wch_y_width";
            desc = "Wch y width. Chinese-only data sheet: description and value encoding not translated.";
            sw = rw;
            hw = r;
            reset = 0x0;
        } wch_y_width[15:0];
    } CH_WCH_Y_SIZE @ 0x10084;

    reg {
        name = "CH_WCH_Y_FADDR_L";
        desc = "Data sheet 9.1.6 CH_WCH_Y_FADDR_L (offset 0x10094, printed page 9-52, `hi3516av300--Hi3516AV300-Datasheet.txt` line 36527).";

        field {
            name = "wch_y_faddr_l";
            desc = "Wch y faddr l. Chinese-only data sheet: description and value encoding not translated.";
            sw = rw;
            hw = r;
            reset = 0x0;
        } wch_y_faddr_l[31:0];
    } CH_WCH_Y_FADDR_L @ 0x10094;

    reg {
        name = "CH_WCH_Y_STRIDE";
        desc = "Data sheet 9.1.6 CH_WCH_Y_STRIDE (offset 0x100A0, printed page 9-52, `hi3516av300--Hi3516AV300-Datasheet.txt` line 36546).";

        field {
            name = "wch_y_stride";
            desc = "Wch y stride. Chinese-only data sheet: description and value encoding not translated.";
            sw = rw;
            hw = r;
            reset = 0x0;
        } wch_y_stride[15:0];
    } CH_WCH_Y_STRIDE @ 0x100A0;

    reg {
        name = "CH_WCH_C_CFG";
        desc = "Data sheet 9.1.6 CH_WCH_C_CFG (offset 0x100B0, printed page 9-53, `hi3516av300--Hi3516AV300-Datasheet.txt` line 36566).";

        field {
            name = "wch_c_enable";
            desc = "Wch c enable. Chinese-only data sheet: description and value encoding not translated.";
            sw = rw;
            hw = r;
            reset = 0x0;
        } wch_c_enable[31:31];

        field {
            name = "wch_c_bit_width";
            desc = "Wch c bit width. Chinese-only data sheet: description and value encoding not translated.";
            sw = rw;
            hw = r;
            reset = 0x0;
        } wch_c_bit_width[5:0];
    } CH_WCH_C_CFG @ 0x100B0;

    reg {
        name = "CH_WCH_C_SIZE";
        desc = "Data sheet 9.1.6 CH_WCH_C_SIZE (offset 0x100B4, printed page 9-53, `hi3516av300--Hi3516AV300-Datasheet.txt` line 36596).";

        field {
            name = "wch_c_height";
            desc = "Wch c height. Chinese-only data sheet: description and value encoding not translated.";
            sw = rw;
            hw = r;
            reset = 0x0;
        } wch_c_height[31:16];

        field {
            name = "wch_c_width";
            desc = "Wch c width. Chinese-only data sheet: description and value encoding not translated.";
            sw = rw;
            hw = r;
            reset = 0x0;
        } wch_c_width[15:0];
    } CH_WCH_C_SIZE @ 0x100B4;

    reg {
        name = "CH_WCH_C_FADDR_L";
        desc = "Data sheet 9.1.6 CH_WCH_C_FADDR_L (offset 0x100C4, printed page 9-53, `hi3516av300--Hi3516AV300-Datasheet.txt` line 36621).";

        field {
            name = "wch_c_faddr_l";
            desc = "Wch c faddr l. Chinese-only data sheet: description and value encoding not translated.";
            sw = rw;
            hw = r;
            reset = 0x0;
        } wch_c_faddr_l[31:0];
    } CH_WCH_C_FADDR_L @ 0x100C4;

    reg {
        name = "CH_WCH_C_STRIDE";
        desc = "Data sheet 9.1.6 CH_WCH_C_STRIDE (offset 0x100D0, printed page 9-54, `hi3516av300--Hi3516AV300-Datasheet.txt` line 36637).";

        field {
            name = "wch_c_stride";
            desc = "Wch c stride. Chinese-only data sheet: description and value encoding not translated.";
            sw = rw;
            hw = r;
            reset = 0x0;
        } wch_c_stride[15:0];
    } CH_WCH_C_STRIDE @ 0x100D0;

    reg {
        name = "CH_Y_ACT_SIZE";
        desc = "Data sheet 9.1.6 CH_Y_ACT_SIZE (offset 0x100E8, printed page 9-54, `hi3516av300--Hi3516AV300-Datasheet.txt` line 36653).";

        field {
            name = "ch_y_height_act";
            desc = "Ch y height act. Chinese-only data sheet: description and value encoding not translated.";
            sw = r;
            hw = w;
            reset = 0x0;
        } ch_y_height_act[31:16];

        field {
            name = "ch_y_width_act";
            desc = "Ch y width act. Chinese-only data sheet: description and value encoding not translated.";
            sw = r;
            hw = w;
            reset = 0x0;
        } ch_y_width_act[15:0];
    } CH_Y_ACT_SIZE @ 0x100E8;

    reg {
        name = "CH_C_ACT_SIZE";
        desc = "Data sheet 9.1.6 CH_C_ACT_SIZE (offset 0x100EC, printed page 9-54, `hi3516av300--Hi3516AV300-Datasheet.txt` line 36672).";

        field {
            name = "ch_c_height_act";
            desc = "Ch c height act. Chinese-only data sheet: description and value encoding not translated.";
            sw = r;
            hw = w;
            reset = 0x0;
        } ch_c_height_act[31:16];

        field {
            name = "Coch_c_width_act";
            desc = "Coch c width act. Chinese-only data sheet: description and value encoding not translated.";
            sw = r;
            hw = w;
            reset = 0x0;
        } Coch_c_width_act[15:0];
    } CH_C_ACT_SIZE @ 0x100EC;

    reg {
        name = "CH_INT";
        desc = "Data sheet 9.1.6 CH_INT (offset 0x100F0, printed page 9-54, `hi3516av300--Hi3516AV300-Datasheet.txt` line 36693).";

        field {
            name = "ch_stt_ae_finish";
            desc = "Ch statistics AE finish. Chinese-only data sheet: description and value encoding not translated.";
            sw = rw;
            hw = w;
            onwrite = woclr;
            reset = 0x0;
        } ch_stt_ae_finish[16:16];

        field {
            name = "ch_int_fstart_dly";
            desc = "Ch interrupt fstart delay. Chinese-only data sheet: description and value encoding not translated.";
            sw = rw;
            hw = w;
            onwrite = woclr;
            reset = 0x0;
        } ch_int_fstart_dly[15:15];

        field {
            name = "ch_int_update_cfg";
            desc = "Ch interrupt update configuration. Chinese-only data sheet: description and value encoding not translated.";
            sw = rw;
            hw = w;
            onwrite = woclr;
            reset = 0x0;
        } ch_int_update_cfg[4:4];

        field {
            name = "ch_int_field_throw";
            desc = "Ch interrupt field throw. Chinese-only data sheet: description and value encoding not translated.";
            sw = rw;
            hw = w;
            onwrite = woclr;
            reset = 0x0;
        } ch_int_field_throw[3:3];

        field {
            name = "ch_int_buf_ovf";
            desc = "Ch interrupt buf overflow. Chinese-only data sheet: description and value encoding not translated.";
            sw = rw;
            hw = w;
            onwrite = woclr;
            reset = 0x0;
        } ch_int_buf_ovf[2:2];

        field {
            name = "ch_int_cc_int";
            desc = "Ch interrupt cc interrupt. Chinese-only data sheet: description and value encoding not translated.";
            sw = rw;
            hw = w;
            onwrite = woclr;
            reset = 0x0;
        } ch_int_cc_int[1:1];

        field {
            name = "ch_int_fstart";
            desc = "Ch interrupt fstart. Chinese-only data sheet: description and value encoding not translated.";
            sw = rw;
            hw = w;
            onwrite = woclr;
            reset = 0x0;
        } ch_int_fstart[0:0];
    } CH_INT @ 0x100F0;

    reg {
        name = "CH_INT_MASK";
        desc = "Data sheet 9.1.6 CH_INT_MASK (offset 0x100F8, printed page 9-55, `hi3516av300--Hi3516AV300-Datasheet.txt` line 36758).";

        field {
            name = "mask_stt_ae_finish";
            desc = "Mask statistics AE finish. Chinese-only data sheet: description and value encoding not translated.";
            sw = rw;
            hw = r;
            reset = 0x0;
        } mask_stt_ae_finish[16:16];

        field {
            name = "mask_fstart_dly";
            desc = "Mask fstart delay. Chinese-only data sheet: description and value encoding not translated.";
            sw = rw;
            hw = r;
            reset = 0x0;
        } mask_fstart_dly[15:15];

        field {
            name = "mask_update_cfg";
            desc = "Mask update configuration. Chinese-only data sheet: description and value encoding not translated.";
            sw = rw;
            hw = r;
            reset = 0x0;
        } mask_update_cfg[4:4];

        field {
            name = "mask_field_throw";
            desc = "Mask field throw. Chinese-only data sheet: description and value encoding not translated.";
            sw = rw;
            hw = r;
            reset = 0x0;
        } mask_field_throw[3:3];

        field {
            name = "mask_buf_ovf";
            desc = "Mask buf overflow. Chinese-only data sheet: description and value encoding not translated.";
            sw = rw;
            hw = r;
            reset = 0x0;
        } mask_buf_ovf[2:2];

        field {
            name = "mask_cc_int";
            desc = "Mask cc interrupt. Chinese-only data sheet: description and value encoding not translated.";
            sw = rw;
            hw = r;
            reset = 0x0;
        } mask_cc_int[1:1];

        field {
            name = "mask_fstart";
            desc = "Mask fstart. Chinese-only data sheet: description and value encoding not translated.";
            sw = rw;
            hw = r;
            reset = 0x0;
        } mask_fstart[0:0];
    } CH_INT_MASK @ 0x100F8;

    reg {
        name = "CH_WCH_STT_CFG";
        desc = "Data sheet 9.1.6 CH_WCH_STT_CFG (offset 0x10200, printed page 9-56, `hi3516av300--Hi3516AV300-Datasheet.txt` line 36820).";

        field {
            name = "ch_wch_stt_32b_align";
            desc = "Ch wch statistics 32b align. Chinese-only data sheet: description and value encoding not translated.";
            sw = rw;
            hw = r;
            reset = 0x0;
        } ch_wch_stt_32b_align[30:30];
    } CH_WCH_STT_CFG @ 0x10200;

    reg {
        name = "CH_WCH_STT_AE_HIST_ADDR_L";
        desc = "Data sheet 9.1.6 CH_WCH_STT_AE_HIST_ADDR_L (offset 0x10208, printed page 9-56, `hi3516av300--Hi3516AV300-Datasheet.txt` line 36846).";

        field {
            name = "ch_wch_stt_ae_hist_addr_l";
            desc = "Ch wch statistics AE histogram address l. Chinese-only data sheet: description and value encoding not translated.";
            sw = rw;
            hw = r;
            reset = 0x0;
        } ch_wch_stt_ae_hist_addr_l[31:0];
    } CH_WCH_STT_AE_HIST_ADDR_L @ 0x10208;

    reg {
        name = "CH_WCH_STT_AE_AVER_R_GR_ADDR_L";
        desc = "Data sheet 9.1.6 CH_WCH_STT_AE_AVER_R_GR_ADDR_L (offset 0x10210, printed page 9-57, `hi3516av300--Hi3516AV300-Datasheet.txt` line 36869).";

        field {
            name = "ch_wch_stt_ae_aver_r_gr_addr_l";
            desc = "Ch wch statistics AE aver r gr address l. Chinese-only data sheet: description and value encoding not translated.";
            sw = rw;
            hw = r;
            reset = 0x0;
        } ch_wch_stt_ae_aver_r_gr_addr_l[31:0];
    } CH_WCH_STT_AE_AVER_R_GR_ADDR_L @ 0x10210;

    reg {
        name = "CH_WCH_STT_AE_AVER_GB_B_ADDR_L";
        desc = "Data sheet 9.1.6 CH_WCH_STT_AE_AVER_GB_B_ADDR_L (offset 0x10218, printed page 9-57, `hi3516av300--Hi3516AV300-Datasheet.txt` line 36890).";

        field {
            name = "ch_wch_stt_ae_aver";
            desc = "Ch wch statistics AE aver. Chinese-only data sheet: description and value encoding not translated.";
            sw = rw;
            hw = r;
            reset = 0x0;
        } ch_wch_stt_ae_aver[31:0];
    } CH_WCH_STT_AE_AVER_GB_B_ADDR_L @ 0x10218;

    reg {
        name = "CH_WCH_STT_AF_STAT_H1_ADDR_L";
        desc = "Data sheet 9.1.6 CH_WCH_STT_AF_STAT_H1_ADDR_L (offset 0x10220, printed page 9-57, `hi3516av300--Hi3516AV300-Datasheet.txt` line 36916).";

        field {
            name = "ch_wch_stt_af_stat_h1_addr_l";
            desc = "Ch wch statistics AF status h1 address l. Chinese-only data sheet: description and value encoding not translated.";
            sw = rw;
            hw = r;
            reset = 0x0;
        } ch_wch_stt_af_stat_h1_addr_l[31:0];
    } CH_WCH_STT_AF_STAT_H1_ADDR_L @ 0x10220;

    reg {
        name = "CH_WCH_STT_AF_STAT_H2_ADDR_L";
        desc = "Data sheet 9.1.6 CH_WCH_STT_AF_STAT_H2_ADDR_L (offset 0x10228, printed page 9-58, `hi3516av300--Hi3516AV300-Datasheet.txt` line 36941).";

        field {
            name = "lo";
            desc = "Lo. Chinese-only data sheet: description and value encoding not translated.";
            sw = rw;
            hw = r;
            reset = 0x0;
        } lo[31:0];
    } CH_WCH_STT_AF_STAT_H2_ADDR_L @ 0x10228;
};

`endif
