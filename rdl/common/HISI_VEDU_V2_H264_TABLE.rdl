`ifndef HISI_VEDU_V2_H264_TABLE_RDL
`define HISI_VEDU_V2_H264_TABLE_RDL

regfile eHISI_VEDU_V2_H264_TABLE {
    name = "H.264 register table (NOT A REGISTER FILE)";
    desc = "NOT A REGISTER FILE and NOT INSTANTIATED: the per-frame DDR register table of the H.264 encoder of the Hi3516C V300 / E V100 (vendor module hi3516cv300_h264e.ko, Xiongmai V4.02.R12). The module keeps a pointer to the table in its channel context (offset 0x3DC) and fills it in HH264E_DRV_UpdateRegConfigParam, InitRegConfigParam, UpdateLowerPowerCfg and UpdateOsdRoiConfigParam; only a few registers are written to MMIO directly by HH264E_DRV_WriteRegs (0x04 interrupt mask, 0x14 mode, 0x30 clock/power, 0x20, 0x3C, 0x160, 0x188, 0x1B8, 0xC28 and others). Offsets are table (byte) offsets, assumed equal to the MMIO register offsets of the same register file (INFERRED from the 0x4/0x14/0x30 words that both paths write and from the same scheme on the Hi3520D and Hi3518E V200, docs/rdl-campaign/vedu-vendor.md and docs/research/hi3518ev200-blocks.md section 15). Produced by a scripted symbolic trace over the ARM instruction stream (build/tmp/cv300-xm/symtrace.py, tablemap.py): per word the PROVEN facts are the offset, which bytes are stored (strb/strh/str) and the bit extents cleared with bic masks; the constants listed are values ORed in by the code; the meaning of every field is UNKNOWN (the source values come from module-private structs without names; no header exists in any corpus). Branches are linearized, so a word may show alternative writes of different code paths. Reconciled 2026-11-12 with the path-sensitive arm-re engine (docs/research/arm-re-rediff.md): words confirmed, new words added, words the engine does not produce are marked. Not hardware verified.";

    reg {
        name = "Table word 0x0";
        desc = "Word 0x0 of the H.264 register table. PROVENANCE: PROVEN offset; PROVEN stored byte lanes 0123 (lane 0 = bits [7:0]); PROVEN cleared bit extents [11:6] (lower bound of the fields); constants ORed in: none; written by UpdateLowerPowerCfg, UpdateRegConfigParam (3 stores).  arm-re rediff (2026-11-12): confirmed by the path-sensitive run (4 stores, extents none seen). Field meanings UNKNOWN.";
        field {
            name = "word";
            desc = "32-bit table word.";
            sw = rw;
            hw = r;
        } word[31:0];
    } TBL_000 @ 0x0;

    reg {
        name = "Table word 0x4";
        desc = "Word 0x4 of the H.264 register table. PROVENANCE: PROVEN offset; PROVEN stored byte lanes 0123 (lane 0 = bits [7:0]); PROVEN cleared bit extents [9:6] [13:11] (lower bound of the fields); constants ORed in: 0x280, 0x400, 0x4000; written by UpdateLowerPowerCfg, UpdateRegConfigParam (5 stores).  arm-re rediff (2026-11-12): confirmed by the path-sensitive run (7 stores, extents [9:6] [13:11]). Field meanings UNKNOWN.";
        field {
            name = "word";
            desc = "32-bit table word.";
            sw = rw;
            hw = r;
        } word[31:0];
    } TBL_004 @ 0x4;

    reg {
        name = "Table word 0x8";
        desc = "Word 0x8 of the H.264 register table. PROVENANCE: PROVEN offset; PROVEN stored byte lanes 0123 (lane 0 = bits [7:0]); PROVEN cleared bit extents [14:14] [28:16] [30:30] (lower bound of the fields); constants ORed in: 0x4000, 0x3200000, 0x10000000; written by UpdateLowerPowerCfg, UpdateRegConfigParam (10 stores).  arm-re rediff (2026-11-12): confirmed by the path-sensitive run (12 stores, extents [14:14] [20:20] [27:20] [23:22] [27:26] [28:28] [30:30]). Field meanings UNKNOWN.";
        field {
            name = "word";
            desc = "32-bit table word.";
            sw = rw;
            hw = r;
        } word[31:0];
    } TBL_008 @ 0x8;

    reg {
        name = "Table word 0xC";
        desc = "Word 0xC of the H.264 register table. PROVENANCE: PROVEN offset; PROVEN stored byte lanes 01 (lane 0 = bits [7:0]); PROVEN cleared bit extents none seen (lower bound of the fields); constants ORed in: none; written by UpdateLowerPowerCfg (1 stores). NOTE: not produced by the arm-re run of the four builder functions (source unknown), carried over from the earlier linear scan: UNCONFIRMED. Field meanings UNKNOWN.";
        field {
            name = "word";
            desc = "32-bit table word.";
            sw = rw;
            hw = r;
        } word[31:0];
    } TBL_00C @ 0xC;

    reg {
        name = "Table word 0x10";
        desc = "Word 0x10 of the H.264 register table. PROVENANCE: PROVEN offset; PROVEN stored byte lanes 02 (lane 0 = bits [7:0]); PROVEN cleared bit extents [6:0] [21:16] (lower bound of the fields); constants ORed in: none; written by UpdateRegConfigParam (2 stores).  arm-re rediff (2026-11-12): confirmed by the path-sensitive run (2 stores, extents [6:0] [21:16]). Field meanings UNKNOWN.";
        field {
            name = "word";
            desc = "32-bit table word.";
            sw = rw;
            hw = r;
        } word[31:0];
    } TBL_010 @ 0x10;

    reg {
        name = "Table word 0x14";
        desc = "Word 0x14 of the H.264 register table. PROVENANCE: PROVEN offset; PROVEN stored byte lanes 0123 (lane 0 = bits [7:0]); PROVEN cleared bit extents none seen (lower bound of the fields); constants ORed in: 0x3; written by UpdateRegConfigParam (1 stores).  arm-re rediff (2026-11-12): confirmed by the path-sensitive run (2 stores, extents none seen). Field meanings UNKNOWN.";
        field {
            name = "word";
            desc = "32-bit table word.";
            sw = rw;
            hw = r;
        } word[31:0];
    } TBL_014 @ 0x14;

    reg {
        name = "Table word 0x18";
        desc = "Word 0x18 of the H.264 register table. PROVENANCE: PROVEN offset; PROVEN stored byte lanes 012 (lane 0 = bits [7:0]); PROVEN cleared bit extents [8:5] [20:20] (lower bound of the fields); constants ORed in: 0x10, 0x200, 0x100000; written by UpdateRegConfigParam (5 stores).  arm-re rediff (2026-11-12): confirmed by the path-sensitive run (8 stores, extents [8:5] [20:20]). Field meanings UNKNOWN.";
        field {
            name = "word";
            desc = "32-bit table word.";
            sw = rw;
            hw = r;
        } word[31:0];
    } TBL_018 @ 0x18;

    reg {
        name = "Table word 0x20";
        desc = "Word 0x20 of the H.264 register table. PROVENANCE: PROVEN offset; PROVEN stored byte lanes 01 (lane 0 = bits [7:0]); PROVEN cleared bit extents [8:1] (lower bound of the fields); constants ORed in: none; written by UpdateRegConfigParam (2 stores).  arm-re rediff (2026-11-12): confirmed by the path-sensitive run (5 stores, extents [0:0] [8:1]). Field meanings UNKNOWN.";
        field {
            name = "word";
            desc = "32-bit table word.";
            sw = rw;
            hw = r;
        } word[31:0];
    } TBL_020 @ 0x20;

    reg {
        name = "Table word 0x24";
        desc = "Word 0x24 of the H.264 register table. PROVENANCE: PROVEN offset; PROVEN stored byte lanes 0123 (lane 0 = bits [7:0]); PROVEN cleared bit extents none seen (lower bound of the fields); constants ORed in: none; written by UpdateRegConfigParam (1 stores).  arm-re rediff (2026-11-12): confirmed by the path-sensitive run (6 stores, extents [12:0] [13:13] [31:16]). Field meanings UNKNOWN.";
        field {
            name = "word";
            desc = "32-bit table word.";
            sw = rw;
            hw = r;
        } word[31:0];
    } TBL_024 @ 0x24;

    reg {
        name = "Table word 0x28";
        desc = "Word 0x28 of the H.264 register table. PROVENANCE: PROVEN offset; PROVEN stored byte lanes 0123 (lane 0 = bits [7:0]); PROVEN cleared bit extents none seen (lower bound of the fields); constants ORed in: none; written by UpdateRegConfigParam (1 stores).  arm-re rediff (2026-11-12): confirmed by the path-sensitive run (4 stores, extents none seen). Field meanings UNKNOWN.";
        field {
            name = "word";
            desc = "32-bit table word.";
            sw = rw;
            hw = r;
        } word[31:0];
    } TBL_028 @ 0x28;

    reg {
        name = "Table word 0x2C";
        desc = "Word 0x2C of the H.264 register table. PROVENANCE: PROVEN offset; PROVEN stored byte lanes 0123 (lane 0 = bits [7:0]); PROVEN cleared bit extents none seen (lower bound of the fields); constants ORed in: none; written by UpdateRegConfigParam (1 stores).  arm-re rediff (2026-11-12): confirmed by the path-sensitive run (7 stores, extents none seen). Field meanings UNKNOWN.";
        field {
            name = "word";
            desc = "32-bit table word.";
            sw = rw;
            hw = r;
        } word[31:0];
    } TBL_02C @ 0x2C;

    reg {
        name = "Table word 0x30";
        desc = "Word 0x30 of the H.264 register table. PROVENANCE: PROVEN offset; PROVEN stored byte lanes 0123 (lane 0 = bits [7:0]); PROVEN cleared bit extents none seen (lower bound of the fields); constants ORed in: none; written by UpdateRegConfigParam (1 stores).  arm-re rediff (2026-11-12): confirmed by the path-sensitive run (1 stores, extents none seen). Field meanings UNKNOWN.";
        field {
            name = "word";
            desc = "32-bit table word.";
            sw = rw;
            hw = r;
        } word[31:0];
    } TBL_030 @ 0x30;

    reg {
        name = "Table word 0x34";
        desc = "Word 0x34 of the H.264 register table. PROVENANCE: PROVEN offset; PROVEN stored byte lanes 0123 (lane 0 = bits [7:0]); PROVEN cleared bit extents none seen (lower bound of the fields); constants ORed in: none; written by UpdateRegConfigParam (1 stores).  arm-re rediff (2026-11-12): confirmed by the path-sensitive run (1 stores, extents none seen). Field meanings UNKNOWN.";
        field {
            name = "word";
            desc = "32-bit table word.";
            sw = rw;
            hw = r;
        } word[31:0];
    } TBL_034 @ 0x34;

    reg {
        name = "Table word 0x38";
        desc = "Word 0x38 of the H.264 register table. PROVENANCE: PROVEN offset; PROVEN stored byte lanes 0123 (lane 0 = bits [7:0]); PROVEN cleared bit extents none seen (lower bound of the fields); constants ORed in: none; written by InitRegConfigParam (1 stores).  arm-re rediff (2026-11-12): confirmed by the path-sensitive run (1 stores, extents none seen). Field meanings UNKNOWN.";
        field {
            name = "word";
            desc = "32-bit table word.";
            sw = rw;
            hw = r;
        } word[31:0];
    } TBL_038 @ 0x38;

    reg {
        name = "Table word 0x3C";
        desc = "Word 0x3C of the H.264 register table. PROVENANCE: PROVEN offset; PROVEN stored byte lanes 0123 (lane 0 = bits [7:0]); PROVEN cleared bit extents none seen (lower bound of the fields); constants ORed in: none; written by InitRegConfigParam (1 stores).  arm-re rediff (2026-11-12): confirmed by the path-sensitive run (1 stores, extents none seen). Field meanings UNKNOWN.";
        field {
            name = "word";
            desc = "32-bit table word.";
            sw = rw;
            hw = r;
        } word[31:0];
    } TBL_03C @ 0x3C;

    reg {
        name = "Table word 0x40";
        desc = "Word 0x40 of the H.264 register table. PROVENANCE: PROVEN offset; PROVEN stored byte lanes 0123 (lane 0 = bits [7:0]); PROVEN cleared bit extents none seen (lower bound of the fields); constants ORed in: none; written by InitRegConfigParam (1 stores).  arm-re rediff (2026-11-12): confirmed by the path-sensitive run (1 stores, extents none seen). Field meanings UNKNOWN.";
        field {
            name = "word";
            desc = "32-bit table word.";
            sw = rw;
            hw = r;
        } word[31:0];
    } TBL_040 @ 0x40;

    reg {
        name = "Table word 0x44";
        desc = "Word 0x44 of the H.264 register table. PROVENANCE: PROVEN offset; PROVEN stored byte lanes 0123 (lane 0 = bits [7:0]); PROVEN cleared bit extents none seen (lower bound of the fields); constants ORed in: none; written by InitRegConfigParam (1 stores).  arm-re rediff (2026-11-12): confirmed by the path-sensitive run (1 stores, extents none seen). Field meanings UNKNOWN.";
        field {
            name = "word";
            desc = "32-bit table word.";
            sw = rw;
            hw = r;
        } word[31:0];
    } TBL_044 @ 0x44;

    reg {
        name = "Table word 0x48";
        desc = "Word 0x48 of the H.264 register table. PROVENANCE: PROVEN offset; PROVEN stored byte lanes 01 (lane 0 = bits [7:0]); PROVEN cleared bit extents [1:0] [5:4] [12:12] (lower bound of the fields); constants ORed in: none; written by UpdateRegConfigParam (7 stores).  arm-re rediff (2026-11-12): confirmed by the path-sensitive run (7 stores, extents [1:0] [5:4] [12:12]). Field meanings UNKNOWN.";
        field {
            name = "word";
            desc = "32-bit table word.";
            sw = rw;
            hw = r;
        } word[31:0];
    } TBL_048 @ 0x48;

    reg {
        name = "Table word 0x4C";
        desc = "Word 0x4C of the H.264 register table. PROVENANCE: PROVEN offset; PROVEN stored byte lanes 02 (lane 0 = bits [7:0]); PROVEN cleared bit extents [0:0] (lower bound of the fields); constants ORed in: 0x1; written by UpdateRegConfigParam (4 stores).  arm-re rediff (2026-11-12): confirmed by the path-sensitive run (4 stores, extents [0:0]). Field meanings UNKNOWN.";
        field {
            name = "word";
            desc = "32-bit table word.";
            sw = rw;
            hw = r;
        } word[31:0];
    } TBL_04C @ 0x4C;

    reg {
        name = "Table word 0x50";
        desc = "Word 0x50 of the H.264 register table. PROVENANCE: PROVEN offset; PROVEN stored byte lanes 0123 (lane 0 = bits [7:0]); PROVEN cleared bit extents none seen (lower bound of the fields); constants ORed in: none; written by UpdateRegConfigParam (1 stores).  arm-re rediff (2026-11-12): confirmed by the path-sensitive run (2 stores, extents none seen). Field meanings UNKNOWN.";
        field {
            name = "word";
            desc = "32-bit table word.";
            sw = rw;
            hw = r;
        } word[31:0];
    } TBL_050 @ 0x50;

    reg {
        name = "Table word 0x54";
        desc = "Word 0x54 of the H.264 register table. PROVENANCE: PROVEN offset; PROVEN stored byte lanes 0123 (lane 0 = bits [7:0]); PROVEN cleared bit extents none seen (lower bound of the fields); constants ORed in: none; written by UpdateRegConfigParam (1 stores).  arm-re rediff (2026-11-12): confirmed by the path-sensitive run (2 stores, extents none seen). Field meanings UNKNOWN.";
        field {
            name = "word";
            desc = "32-bit table word.";
            sw = rw;
            hw = r;
        } word[31:0];
    } TBL_054 @ 0x54;

    reg {
        name = "Table word 0x58";
        desc = "Word 0x58 of the H.264 register table. PROVENANCE: PROVEN offset; PROVEN stored byte lanes 0123 (lane 0 = bits [7:0]); PROVEN cleared bit extents none seen (lower bound of the fields); constants ORed in: none; written by UpdateRegConfigParam (1 stores).  arm-re rediff (2026-11-12): confirmed by the path-sensitive run (1 stores, extents none seen). Field meanings UNKNOWN.";
        field {
            name = "word";
            desc = "32-bit table word.";
            sw = rw;
            hw = r;
        } word[31:0];
    } TBL_058 @ 0x58;

    reg {
        name = "Table word 0x5C";
        desc = "Word 0x5C of the H.264 register table. PROVENANCE: PROVEN offset; PROVEN stored byte lanes 0123 (lane 0 = bits [7:0]); PROVEN cleared bit extents none seen (lower bound of the fields); constants ORed in: none; written by UpdateRegConfigParam (1 stores).  arm-re rediff (2026-11-12): confirmed by the path-sensitive run (1 stores, extents none seen). Field meanings UNKNOWN.";
        field {
            name = "word";
            desc = "32-bit table word.";
            sw = rw;
            hw = r;
        } word[31:0];
    } TBL_05C @ 0x5C;

    reg {
        name = "Table word 0x60";
        desc = "Word 0x60 of the H.264 register table. PROVENANCE: PROVEN offset; PROVEN stored byte lanes 0123 (lane 0 = bits [7:0]); PROVEN cleared bit extents none seen (lower bound of the fields); constants ORed in: none; written by UpdateRegConfigParam (1 stores).  arm-re rediff (2026-11-12): confirmed by the path-sensitive run (1 stores, extents none seen). Field meanings UNKNOWN.";
        field {
            name = "word";
            desc = "32-bit table word.";
            sw = rw;
            hw = r;
        } word[31:0];
    } TBL_060 @ 0x60;

    reg {
        name = "Table word 0x64";
        desc = "Word 0x64 of the H.264 register table. PROVENANCE: PROVEN offset; PROVEN stored byte lanes 0123 (lane 0 = bits [7:0]); PROVEN cleared bit extents none seen (lower bound of the fields); constants ORed in: none; written by UpdateRegConfigParam (2 stores).  arm-re rediff (2026-11-12): confirmed by the path-sensitive run (2 stores, extents none seen). Field meanings UNKNOWN.";
        field {
            name = "word";
            desc = "32-bit table word.";
            sw = rw;
            hw = r;
        } word[31:0];
    } TBL_064 @ 0x64;

    reg {
        name = "Table word 0x68";
        desc = "Word 0x68 of the H.264 register table. PROVENANCE: PROVEN offset; PROVEN stored byte lanes 0123 (lane 0 = bits [7:0]); PROVEN cleared bit extents none seen (lower bound of the fields); constants ORed in: none; written by UpdateRegConfigParam (2 stores).  arm-re rediff (2026-11-12): confirmed by the path-sensitive run (2 stores, extents none seen). Field meanings UNKNOWN.";
        field {
            name = "word";
            desc = "32-bit table word.";
            sw = rw;
            hw = r;
        } word[31:0];
    } TBL_068 @ 0x68;

    reg {
        name = "Table word 0x6C";
        desc = "Word 0x6C of the H.264 register table. PROVENANCE: PROVEN offset; PROVEN stored byte lanes 0123 (lane 0 = bits [7:0]); PROVEN cleared bit extents none seen (lower bound of the fields); constants ORed in: none; written by UpdateRegConfigParam (2 stores).  arm-re rediff (2026-11-12): confirmed by the path-sensitive run (2 stores, extents none seen). Field meanings UNKNOWN.";
        field {
            name = "word";
            desc = "32-bit table word.";
            sw = rw;
            hw = r;
        } word[31:0];
    } TBL_06C @ 0x6C;

    reg {
        name = "Table word 0x70";
        desc = "Word 0x70 of the H.264 register table. PROVENANCE: PROVEN offset; PROVEN stored byte lanes 0123 (lane 0 = bits [7:0]); PROVEN cleared bit extents none seen (lower bound of the fields); constants ORed in: none; written by UpdateRegConfigParam (2 stores).  arm-re rediff (2026-11-12): confirmed by the path-sensitive run (2 stores, extents none seen). Field meanings UNKNOWN.";
        field {
            name = "word";
            desc = "32-bit table word.";
            sw = rw;
            hw = r;
        } word[31:0];
    } TBL_070 @ 0x70;

    reg {
        name = "Table word 0x74";
        desc = "Word 0x74 of the H.264 register table. PROVENANCE: PROVEN offset; PROVEN stored byte lanes 0123 (lane 0 = bits [7:0]); PROVEN cleared bit extents none seen (lower bound of the fields); constants ORed in: none; written by UpdateRegConfigParam (2 stores).  arm-re rediff (2026-11-12): confirmed by the path-sensitive run (2 stores, extents none seen). Field meanings UNKNOWN.";
        field {
            name = "word";
            desc = "32-bit table word.";
            sw = rw;
            hw = r;
        } word[31:0];
    } TBL_074 @ 0x74;

    reg {
        name = "Table word 0x78";
        desc = "Word 0x78 of the H.264 register table. PROVENANCE: PROVEN offset; PROVEN stored byte lanes 0123 (lane 0 = bits [7:0]); PROVEN cleared bit extents [6:0] (lower bound of the fields); constants ORed in: 0x1, 0x3; written by UpdateRegConfigParam (2 stores).  arm-re rediff (2026-11-12): confirmed by the path-sensitive run (2 stores, extents none seen). Field meanings UNKNOWN.";
        field {
            name = "word";
            desc = "32-bit table word.";
            sw = rw;
            hw = r;
        } word[31:0];
    } TBL_078 @ 0x78;

    reg {
        name = "Table word 0x7C";
        desc = "Word 0x7C of the H.264 register table. PROVENANCE: PROVEN offset; PROVEN stored byte lanes 0123 (lane 0 = bits [7:0]); PROVEN cleared bit extents [6:6] (lower bound of the fields); constants ORed in: 0x80; written by UpdateRegConfigParam (2 stores).  arm-re rediff (2026-11-12): confirmed by the path-sensitive run (3 stores, extents [6:6]). Field meanings UNKNOWN.";
        field {
            name = "word";
            desc = "32-bit table word.";
            sw = rw;
            hw = r;
        } word[31:0];
    } TBL_07C @ 0x7C;

    reg {
        name = "Table word 0x80";
        desc = "Word 0x80 of the H.264 register table. PROVENANCE: PROVEN offset; PROVEN stored byte lanes 0123 (lane 0 = bits [7:0]); PROVEN cleared bit extents none seen (lower bound of the fields); constants ORed in: none; written by UpdateRegConfigParam (2 stores).  arm-re rediff (2026-11-12): confirmed by the path-sensitive run (3 stores, extents none seen). Field meanings UNKNOWN.";
        field {
            name = "word";
            desc = "32-bit table word.";
            sw = rw;
            hw = r;
        } word[31:0];
    } TBL_080 @ 0x80;

    reg {
        name = "Table word 0x84";
        desc = "Word 0x84 of the H.264 register table. PROVENANCE: PROVEN offset; PROVEN stored byte lanes 0123 (lane 0 = bits [7:0]); PROVEN cleared bit extents none seen (lower bound of the fields); constants ORed in: none; written by UpdateRegConfigParam (1 stores).  arm-re rediff (2026-11-12): confirmed by the path-sensitive run (1 stores, extents none seen). Field meanings UNKNOWN.";
        field {
            name = "word";
            desc = "32-bit table word.";
            sw = rw;
            hw = r;
        } word[31:0];
    } TBL_084 @ 0x84;

    reg {
        name = "Table word 0x88";
        desc = "Word 0x88 of the H.264 register table. PROVENANCE: PROVEN offset; PROVEN stored byte lanes 0123 (lane 0 = bits [7:0]); PROVEN cleared bit extents none seen (lower bound of the fields); constants ORed in: none; written by UpdateRegConfigParam (1 stores).  arm-re rediff (2026-11-12): confirmed by the path-sensitive run (1 stores, extents none seen). Field meanings UNKNOWN.";
        field {
            name = "word";
            desc = "32-bit table word.";
            sw = rw;
            hw = r;
        } word[31:0];
    } TBL_088 @ 0x88;

    reg {
        name = "Table word 0x90";
        desc = "Word 0x90 of the H.264 register table. PROVENANCE: PROVEN offset; PROVEN stored byte lanes 0123 (lane 0 = bits [7:0]); PROVEN cleared bit extents none seen (lower bound of the fields); constants ORed in: none; written by UpdateRegConfigParam (2 stores).  arm-re rediff (2026-11-12): confirmed by the path-sensitive run (2 stores, extents none seen). Field meanings UNKNOWN.";
        field {
            name = "word";
            desc = "32-bit table word.";
            sw = rw;
            hw = r;
        } word[31:0];
    } TBL_090 @ 0x90;

    reg {
        name = "Table word 0x94";
        desc = "Word 0x94 of the H.264 register table. PROVENANCE: PROVEN offset; PROVEN stored byte lanes 0123 (lane 0 = bits [7:0]); PROVEN cleared bit extents none seen (lower bound of the fields); constants ORed in: none; written by UpdateRegConfigParam (1 stores).  arm-re rediff (2026-11-12): confirmed by the path-sensitive run (2 stores, extents none seen). Field meanings UNKNOWN.";
        field {
            name = "word";
            desc = "32-bit table word.";
            sw = rw;
            hw = r;
        } word[31:0];
    } TBL_094 @ 0x94;

    reg {
        name = "Table word 0x98";
        desc = "Word 0x98 of the H.264 register table. PROVENANCE: PROVEN offset; PROVEN stored byte lanes 0123 (lane 0 = bits [7:0]); PROVEN cleared bit extents none seen (lower bound of the fields); constants ORed in: none; written by UpdateRegConfigParam (2 stores).  arm-re rediff (2026-11-12): confirmed by the path-sensitive run (2 stores, extents none seen). Field meanings UNKNOWN.";
        field {
            name = "word";
            desc = "32-bit table word.";
            sw = rw;
            hw = r;
        } word[31:0];
    } TBL_098 @ 0x98;

    reg {
        name = "Table word 0x9C";
        desc = "Word 0x9C of the H.264 register table. PROVENANCE: PROVEN offset; PROVEN stored byte lanes 0123 (lane 0 = bits [7:0]); PROVEN cleared bit extents none seen (lower bound of the fields); constants ORed in: none; written by UpdateRegConfigParam (1 stores).  arm-re rediff (2026-11-12): confirmed by the path-sensitive run (1 stores, extents none seen). Field meanings UNKNOWN.";
        field {
            name = "word";
            desc = "32-bit table word.";
            sw = rw;
            hw = r;
        } word[31:0];
    } TBL_09C @ 0x9C;

    reg {
        name = "Table word 0xA0";
        desc = "Word 0xA0 of the H.264 register table. PROVENANCE: PROVEN offset; PROVEN stored byte lanes 0123 (lane 0 = bits [7:0]); PROVEN cleared bit extents none seen (lower bound of the fields); constants ORed in: none; written by UpdateRegConfigParam (1 stores).  arm-re rediff (2026-11-12): confirmed by the path-sensitive run (1 stores, extents none seen). Field meanings UNKNOWN.";
        field {
            name = "word";
            desc = "32-bit table word.";
            sw = rw;
            hw = r;
        } word[31:0];
    } TBL_0A0 @ 0xA0;

    reg {
        name = "Table word 0xA4";
        desc = "Word 0xA4 of the H.264 register table. PROVENANCE: PROVEN offset; PROVEN stored byte lanes 0123 (lane 0 = bits [7:0]); PROVEN cleared bit extents none seen (lower bound of the fields); constants ORed in: none; written by UpdateRegConfigParam (1 stores).  arm-re rediff (2026-11-12): confirmed by the path-sensitive run (1 stores, extents none seen). Field meanings UNKNOWN.";
        field {
            name = "word";
            desc = "32-bit table word.";
            sw = rw;
            hw = r;
        } word[31:0];
    } TBL_0A4 @ 0xA4;

    reg {
        name = "Table word 0xA8";
        desc = "Word 0xA8 of the H.264 register table. PROVENANCE: PROVEN offset; PROVEN stored byte lanes 0123 (lane 0 = bits [7:0]); PROVEN cleared bit extents none seen (lower bound of the fields); constants ORed in: none; written by UpdateRegConfigParam (2 stores).  arm-re rediff (2026-11-12): confirmed by the path-sensitive run (2 stores, extents none seen). Field meanings UNKNOWN.";
        field {
            name = "word";
            desc = "32-bit table word.";
            sw = rw;
            hw = r;
        } word[31:0];
    } TBL_0A8 @ 0xA8;

    reg {
        name = "Table word 0xAC";
        desc = "Word 0xAC of the H.264 register table. PROVENANCE: PROVEN offset; PROVEN stored byte lanes 0123 (lane 0 = bits [7:0]); PROVEN cleared bit extents none seen (lower bound of the fields); constants ORed in: none; written by UpdateRegConfigParam (1 stores).  arm-re rediff (2026-11-12): confirmed by the path-sensitive run (1 stores, extents none seen). Field meanings UNKNOWN.";
        field {
            name = "word";
            desc = "32-bit table word.";
            sw = rw;
            hw = r;
        } word[31:0];
    } TBL_0AC @ 0xAC;

    reg {
        name = "Table word 0xB0";
        desc = "Word 0xB0 of the H.264 register table. PROVENANCE: PROVEN offset; PROVEN stored byte lanes 0123 (lane 0 = bits [7:0]); PROVEN cleared bit extents none seen (lower bound of the fields); constants ORed in: none; written by UpdateRegConfigParam (1 stores).  arm-re rediff (2026-11-12): confirmed by the path-sensitive run (1 stores, extents none seen). Field meanings UNKNOWN.";
        field {
            name = "word";
            desc = "32-bit table word.";
            sw = rw;
            hw = r;
        } word[31:0];
    } TBL_0B0 @ 0xB0;

    reg {
        name = "Table word 0xB4";
        desc = "Word 0xB4 of the H.264 register table. PROVENANCE: PROVEN offset; PROVEN stored byte lanes 01 (lane 0 = bits [7:0]); PROVEN cleared bit extents none seen (lower bound of the fields); constants ORed in: none; written by UpdateRegConfigParam (1 stores).  arm-re rediff (2026-11-12): confirmed by the path-sensitive run (1 stores, extents none seen). Field meanings UNKNOWN.";
        field {
            name = "word";
            desc = "32-bit table word.";
            sw = rw;
            hw = r;
        } word[31:0];
    } TBL_0B4 @ 0xB4;

    reg {
        name = "Table word 0xB8";
        desc = "Word 0xB8 of the H.264 register table. PROVENANCE: PROVEN offset; PROVEN stored byte lanes 0123 (lane 0 = bits [7:0]); PROVEN cleared bit extents none seen (lower bound of the fields); constants ORed in: none; written by UpdateRegConfigParam (2 stores).  arm-re rediff (2026-11-12): confirmed by the path-sensitive run (2 stores, extents none seen). Field meanings UNKNOWN.";
        field {
            name = "word";
            desc = "32-bit table word.";
            sw = rw;
            hw = r;
        } word[31:0];
    } TBL_0B8 @ 0xB8;

    reg {
        name = "Table word 0xBC";
        desc = "Word 0xBC of the H.264 register table. PROVENANCE: PROVEN offset; PROVEN stored byte lanes 0123 (lane 0 = bits [7:0]); PROVEN cleared bit extents none seen (lower bound of the fields); constants ORed in: none; written by UpdateRegConfigParam (2 stores).  arm-re rediff (2026-11-12): confirmed by the path-sensitive run (2 stores, extents none seen). Field meanings UNKNOWN.";
        field {
            name = "word";
            desc = "32-bit table word.";
            sw = rw;
            hw = r;
        } word[31:0];
    } TBL_0BC @ 0xBC;

    reg {
        name = "Table word 0xC0";
        desc = "Word 0xC0 of the H.264 register table. PROVENANCE: PROVEN offset; PROVEN stored byte lanes 0123 (lane 0 = bits [7:0]); PROVEN cleared bit extents none seen (lower bound of the fields); constants ORed in: none; written by UpdateRegConfigParam (2 stores).  arm-re rediff (2026-11-12): confirmed by the path-sensitive run (2 stores, extents none seen). Field meanings UNKNOWN.";
        field {
            name = "word";
            desc = "32-bit table word.";
            sw = rw;
            hw = r;
        } word[31:0];
    } TBL_0C0 @ 0xC0;

    reg {
        name = "Table word 0xC4";
        desc = "Word 0xC4 of the H.264 register table. PROVENANCE: PROVEN offset; PROVEN stored byte lanes 0123 (lane 0 = bits [7:0]); PROVEN cleared bit extents none seen (lower bound of the fields); constants ORed in: none; written by UpdateRegConfigParam (2 stores).  arm-re rediff (2026-11-12): confirmed by the path-sensitive run (2 stores, extents none seen). Field meanings UNKNOWN.";
        field {
            name = "word";
            desc = "32-bit table word.";
            sw = rw;
            hw = r;
        } word[31:0];
    } TBL_0C4 @ 0xC4;

    reg {
        name = "Table word 0xC8";
        desc = "Word 0xC8 of the H.264 register table. PROVENANCE: PROVEN offset; PROVEN stored byte lanes 0123 (lane 0 = bits [7:0]); PROVEN cleared bit extents none seen (lower bound of the fields); constants ORed in: none; written by UpdateRegConfigParam (2 stores).  arm-re rediff (2026-11-12): confirmed by the path-sensitive run (2 stores, extents none seen). Field meanings UNKNOWN.";
        field {
            name = "word";
            desc = "32-bit table word.";
            sw = rw;
            hw = r;
        } word[31:0];
    } TBL_0C8 @ 0xC8;

    reg {
        name = "Table word 0xCC";
        desc = "Word 0xCC of the H.264 register table. PROVENANCE: PROVEN offset; PROVEN stored byte lanes 0123 (lane 0 = bits [7:0]); PROVEN cleared bit extents none seen (lower bound of the fields); constants ORed in: none; written by UpdateRegConfigParam (3 stores).  arm-re rediff (2026-11-12): confirmed by the path-sensitive run (3 stores, extents none seen). Field meanings UNKNOWN.";
        field {
            name = "word";
            desc = "32-bit table word.";
            sw = rw;
            hw = r;
        } word[31:0];
    } TBL_0CC @ 0xCC;

    reg {
        name = "Table word 0xD0";
        desc = "Word 0xD0 of the H.264 register table. PROVENANCE: PROVEN offset; PROVEN stored byte lanes 0123 (lane 0 = bits [7:0]); PROVEN cleared bit extents none seen (lower bound of the fields); constants ORed in: none; written by UpdateRegConfigParam (1 stores).  arm-re rediff (2026-11-12): confirmed by the path-sensitive run (1 stores, extents none seen). Field meanings UNKNOWN.";
        field {
            name = "word";
            desc = "32-bit table word.";
            sw = rw;
            hw = r;
        } word[31:0];
    } TBL_0D0 @ 0xD0;

    reg {
        name = "Table word 0xD4";
        desc = "Word 0xD4 of the H.264 register table. PROVENANCE: PROVEN offset; PROVEN stored byte lanes 0123 (lane 0 = bits [7:0]); PROVEN cleared bit extents none seen (lower bound of the fields); constants ORed in: none; written by UpdateRegConfigParam (1 stores).  arm-re rediff (2026-11-12): confirmed by the path-sensitive run (1 stores, extents none seen). Field meanings UNKNOWN.";
        field {
            name = "word";
            desc = "32-bit table word.";
            sw = rw;
            hw = r;
        } word[31:0];
    } TBL_0D4 @ 0xD4;

    reg {
        name = "Table word 0xD8";
        desc = "Word 0xD8 of the H.264 register table. PROVENANCE: PROVEN offset; PROVEN stored byte lanes 0123 (lane 0 = bits [7:0]); PROVEN cleared bit extents none seen (lower bound of the fields); constants ORed in: none; written by UpdateRegConfigParam (1 stores).  arm-re rediff (2026-11-12): confirmed by the path-sensitive run (1 stores, extents none seen). Field meanings UNKNOWN.";
        field {
            name = "word";
            desc = "32-bit table word.";
            sw = rw;
            hw = r;
        } word[31:0];
    } TBL_0D8 @ 0xD8;

    reg {
        name = "Table word 0xDC";
        desc = "Word 0xDC of the H.264 register table. PROVENANCE: PROVEN offset; PROVEN stored byte lanes 0123 (lane 0 = bits [7:0]); PROVEN cleared bit extents none seen (lower bound of the fields); constants ORed in: none; written by UpdateRegConfigParam (1 stores).  arm-re rediff (2026-11-12): confirmed by the path-sensitive run (1 stores, extents none seen). Field meanings UNKNOWN.";
        field {
            name = "word";
            desc = "32-bit table word.";
            sw = rw;
            hw = r;
        } word[31:0];
    } TBL_0DC @ 0xDC;

    reg {
        name = "Table word 0xE4";
        desc = "Word 0xE4 of the H.264 register table. PROVENANCE: PROVEN offset; PROVEN stored byte lanes 0123 (lane 0 = bits [7:0]); PROVEN cleared bit extents none seen (lower bound of the fields); constants ORed in: none; written by UpdateRegConfigParam (2 stores).  arm-re rediff (2026-11-12): confirmed by the path-sensitive run (2 stores, extents none seen). Field meanings UNKNOWN.";
        field {
            name = "word";
            desc = "32-bit table word.";
            sw = rw;
            hw = r;
        } word[31:0];
    } TBL_0E4 @ 0xE4;

    reg {
        name = "Table word 0xE8";
        desc = "Word 0xE8 of the H.264 register table. PROVENANCE: PROVEN offset; PROVEN stored byte lanes 0123 (lane 0 = bits [7:0]); PROVEN cleared bit extents none seen (lower bound of the fields); constants ORed in: none; written by UpdateRegConfigParam (2 stores).  arm-re rediff (2026-11-12): confirmed by the path-sensitive run (2 stores, extents none seen). Field meanings UNKNOWN.";
        field {
            name = "word";
            desc = "32-bit table word.";
            sw = rw;
            hw = r;
        } word[31:0];
    } TBL_0E8 @ 0xE8;

    reg {
        name = "Table word 0xEC";
        desc = "Word 0xEC of the H.264 register table. PROVENANCE: PROVEN offset; PROVEN stored byte lanes 0123 (lane 0 = bits [7:0]); PROVEN cleared bit extents none seen (lower bound of the fields); constants ORed in: none; written by UpdateRegConfigParam (2 stores).  arm-re rediff (2026-11-12): confirmed by the path-sensitive run (2 stores, extents none seen). Field meanings UNKNOWN.";
        field {
            name = "word";
            desc = "32-bit table word.";
            sw = rw;
            hw = r;
        } word[31:0];
    } TBL_0EC @ 0xEC;

    reg {
        name = "Table word 0xF0";
        desc = "Word 0xF0 of the H.264 register table. PROVENANCE: PROVEN offset; PROVEN stored byte lanes 0123 (lane 0 = bits [7:0]); PROVEN cleared bit extents none seen (lower bound of the fields); constants ORed in: none; written by UpdateRegConfigParam (2 stores).  arm-re rediff (2026-11-12): confirmed by the path-sensitive run (2 stores, extents none seen). Field meanings UNKNOWN.";
        field {
            name = "word";
            desc = "32-bit table word.";
            sw = rw;
            hw = r;
        } word[31:0];
    } TBL_0F0 @ 0xF0;

    reg {
        name = "Table word 0xF4";
        desc = "Word 0xF4 of the H.264 register table. PROVENANCE: PROVEN offset; PROVEN stored byte lanes 0123 (lane 0 = bits [7:0]); PROVEN cleared bit extents none seen (lower bound of the fields); constants ORed in: none; written by UpdateRegConfigParam (2 stores).  arm-re rediff (2026-11-12): confirmed by the path-sensitive run (2 stores, extents none seen). Field meanings UNKNOWN.";
        field {
            name = "word";
            desc = "32-bit table word.";
            sw = rw;
            hw = r;
        } word[31:0];
    } TBL_0F4 @ 0xF4;

    reg {
        name = "Table word 0xF8";
        desc = "Word 0xF8 of the H.264 register table. PROVENANCE: PROVEN offset; PROVEN stored byte lanes 0123 (lane 0 = bits [7:0]); PROVEN cleared bit extents none seen (lower bound of the fields); constants ORed in: none; written by UpdateRegConfigParam (3 stores).  arm-re rediff (2026-11-12): confirmed by the path-sensitive run (3 stores, extents none seen). Field meanings UNKNOWN.";
        field {
            name = "word";
            desc = "32-bit table word.";
            sw = rw;
            hw = r;
        } word[31:0];
    } TBL_0F8 @ 0xF8;

    reg {
        name = "Table word 0xFC";
        desc = "Word 0xFC of the H.264 register table. PROVENANCE: PROVEN offset; PROVEN stored byte lanes 0123 (lane 0 = bits [7:0]); PROVEN cleared bit extents none seen (lower bound of the fields); constants ORed in: none; written by UpdateRegConfigParam (1 stores).  arm-re rediff (2026-11-12): confirmed by the path-sensitive run (1 stores, extents none seen). Field meanings UNKNOWN.";
        field {
            name = "word";
            desc = "32-bit table word.";
            sw = rw;
            hw = r;
        } word[31:0];
    } TBL_0FC @ 0xFC;

    reg {
        name = "Table word 0x100";
        desc = "Word 0x100 of the H.264 register table. PROVENANCE: PROVEN offset; PROVEN stored byte lanes 0123 (lane 0 = bits [7:0]); PROVEN cleared bit extents none seen (lower bound of the fields); constants ORed in: none; written by UpdateRegConfigParam (1 stores).  arm-re rediff (2026-11-12): confirmed by the path-sensitive run (1 stores, extents none seen). Field meanings UNKNOWN.";
        field {
            name = "word";
            desc = "32-bit table word.";
            sw = rw;
            hw = r;
        } word[31:0];
    } TBL_100 @ 0x100;

    reg {
        name = "Table word 0x104";
        desc = "Word 0x104 of the H.264 register table. PROVENANCE: PROVEN offset; PROVEN stored byte lanes 0123 (lane 0 = bits [7:0]); PROVEN cleared bit extents none seen (lower bound of the fields); constants ORed in: none; written by UpdateRegConfigParam (1 stores).  arm-re rediff (2026-11-12): confirmed by the path-sensitive run (1 stores, extents none seen). Field meanings UNKNOWN.";
        field {
            name = "word";
            desc = "32-bit table word.";
            sw = rw;
            hw = r;
        } word[31:0];
    } TBL_104 @ 0x104;

    reg {
        name = "Table word 0x108";
        desc = "Word 0x108 of the H.264 register table. PROVENANCE: PROVEN offset; PROVEN stored byte lanes 0123 (lane 0 = bits [7:0]); PROVEN cleared bit extents none seen (lower bound of the fields); constants ORed in: none; written by UpdateRegConfigParam (1 stores).  arm-re rediff (2026-11-12): confirmed by the path-sensitive run (1 stores, extents none seen). Field meanings UNKNOWN.";
        field {
            name = "word";
            desc = "32-bit table word.";
            sw = rw;
            hw = r;
        } word[31:0];
    } TBL_108 @ 0x108;

    reg {
        name = "Table word 0x10C";
        desc = "Word 0x10C of the H.264 register table. PROVENANCE: PROVEN offset; PROVEN stored byte lanes 0123 (lane 0 = bits [7:0]); PROVEN cleared bit extents none seen (lower bound of the fields); constants ORed in: none; written by UpdateRegConfigParam (1 stores).  arm-re rediff (2026-11-12): confirmed by the path-sensitive run (1 stores, extents none seen). Field meanings UNKNOWN.";
        field {
            name = "word";
            desc = "32-bit table word.";
            sw = rw;
            hw = r;
        } word[31:0];
    } TBL_10C @ 0x10C;

    reg {
        name = "Table word 0x110";
        desc = "Word 0x110 of the H.264 register table. PROVENANCE: PROVEN offset; PROVEN stored byte lanes 0123 (lane 0 = bits [7:0]); PROVEN cleared bit extents none seen (lower bound of the fields); constants ORed in: none; written by UpdateRegConfigParam (1 stores).  arm-re rediff (2026-11-12): confirmed by the path-sensitive run (1 stores, extents none seen). Field meanings UNKNOWN.";
        field {
            name = "word";
            desc = "32-bit table word.";
            sw = rw;
            hw = r;
        } word[31:0];
    } TBL_110 @ 0x110;

    reg {
        name = "Table word 0x114";
        desc = "Word 0x114 of the H.264 register table. PROVENANCE: PROVEN offset; PROVEN stored byte lanes 0123 (lane 0 = bits [7:0]); PROVEN cleared bit extents none seen (lower bound of the fields); constants ORed in: none; written by UpdateRegConfigParam (1 stores).  arm-re rediff (2026-11-12): confirmed by the path-sensitive run (1 stores, extents none seen). Field meanings UNKNOWN.";
        field {
            name = "word";
            desc = "32-bit table word.";
            sw = rw;
            hw = r;
        } word[31:0];
    } TBL_114 @ 0x114;

    reg {
        name = "Table word 0x118";
        desc = "Word 0x118 of the H.264 register table. PROVENANCE: PROVEN offset; PROVEN stored byte lanes 0123 (lane 0 = bits [7:0]); PROVEN cleared bit extents none seen (lower bound of the fields); constants ORed in: none; written by UpdateRegConfigParam (1 stores).  arm-re rediff (2026-11-12): confirmed by the path-sensitive run (1 stores, extents none seen). Field meanings UNKNOWN.";
        field {
            name = "word";
            desc = "32-bit table word.";
            sw = rw;
            hw = r;
        } word[31:0];
    } TBL_118 @ 0x118;

    reg {
        name = "Table word 0x11C";
        desc = "Word 0x11C of the H.264 register table. PROVENANCE: PROVEN offset; PROVEN stored byte lanes 0123 (lane 0 = bits [7:0]); PROVEN cleared bit extents none seen (lower bound of the fields); constants ORed in: none; written by UpdateRegConfigParam (1 stores).  arm-re rediff (2026-11-12): confirmed by the path-sensitive run (1 stores, extents none seen). Field meanings UNKNOWN.";
        field {
            name = "word";
            desc = "32-bit table word.";
            sw = rw;
            hw = r;
        } word[31:0];
    } TBL_11C @ 0x11C;

    reg {
        name = "Table word 0x120";
        desc = "Word 0x120 of the H.264 register table. PROVENANCE: PROVEN offset; PROVEN stored byte lanes 012 (lane 0 = bits [7:0]); PROVEN cleared bit extents [5:0] [13:8] [22:16] (lower bound of the fields); constants ORed in: none; written by UpdateRegConfigParam (3 stores).  arm-re rediff (2026-11-12): confirmed by the path-sensitive run (3 stores, extents [5:0] [13:8] [22:16]). Field meanings UNKNOWN.";
        field {
            name = "word";
            desc = "32-bit table word.";
            sw = rw;
            hw = r;
        } word[31:0];
    } TBL_120 @ 0x120;

    reg {
        name = "Table word 0x124";
        desc = "Word 0x124 of the H.264 register table. PROVENANCE: PROVEN offset; PROVEN stored byte lanes 0123 (lane 0 = bits [7:0]); PROVEN cleared bit extents [0:0] (lower bound of the fields); constants ORed in: 0x1; written by UpdateRegConfigParam (2 stores).  arm-re rediff (2026-11-12): confirmed by the path-sensitive run (3 stores, extents [0:0] [24:1]). Field meanings UNKNOWN.";
        field {
            name = "word";
            desc = "32-bit table word.";
            sw = rw;
            hw = r;
        } word[31:0];
    } TBL_124 @ 0x124;

    reg {
        name = "Table word 0x128";
        desc = "Word 0x128 of the H.264 register table. PROVENANCE: PROVEN offset; PROVEN stored byte lanes 0123 (lane 0 = bits [7:0]); PROVEN cleared bit extents none seen (lower bound of the fields); constants ORed in: none; written by UpdateRegConfigParam (1 stores).  arm-re rediff (2026-11-12): confirmed by the path-sensitive run (1 stores, extents none seen). Field meanings UNKNOWN.";
        field {
            name = "word";
            desc = "32-bit table word.";
            sw = rw;
            hw = r;
        } word[31:0];
    } TBL_128 @ 0x128;

    reg {
        name = "Table word 0x12C";
        desc = "Word 0x12C of the H.264 register table. PROVENANCE: PROVEN offset; PROVEN stored byte lanes 0123 (lane 0 = bits [7:0]); PROVEN cleared bit extents none seen (lower bound of the fields); constants ORed in: none; written by UpdateRegConfigParam (1 stores).  arm-re rediff (2026-11-12): confirmed by the path-sensitive run (1 stores, extents none seen). Field meanings UNKNOWN.";
        field {
            name = "word";
            desc = "32-bit table word.";
            sw = rw;
            hw = r;
        } word[31:0];
    } TBL_12C @ 0x12C;

    reg {
        name = "Table word 0x130";
        desc = "Word 0x130 of the H.264 register table. PROVENANCE: PROVEN offset; PROVEN stored byte lanes 0123 (lane 0 = bits [7:0]); PROVEN cleared bit extents none seen (lower bound of the fields); constants ORed in: none; written by UpdateRegConfigParam (1 stores).  arm-re rediff (2026-11-12): confirmed by the path-sensitive run (1 stores, extents none seen). Field meanings UNKNOWN.";
        field {
            name = "word";
            desc = "32-bit table word.";
            sw = rw;
            hw = r;
        } word[31:0];
    } TBL_130 @ 0x130;

    reg {
        name = "Table word 0x134";
        desc = "Word 0x134 of the H.264 register table. PROVENANCE: PROVEN offset; PROVEN stored byte lanes 0123 (lane 0 = bits [7:0]); PROVEN cleared bit extents none seen (lower bound of the fields); constants ORed in: none; written by UpdateRegConfigParam (1 stores).  arm-re rediff (2026-11-12): confirmed by the path-sensitive run (1 stores, extents none seen). Field meanings UNKNOWN.";
        field {
            name = "word";
            desc = "32-bit table word.";
            sw = rw;
            hw = r;
        } word[31:0];
    } TBL_134 @ 0x134;

    reg {
        name = "Table word 0x138";
        desc = "Word 0x138 of the H.264 register table. PROVENANCE: PROVEN offset; PROVEN stored byte lanes 0123 (lane 0 = bits [7:0]); PROVEN cleared bit extents none seen (lower bound of the fields); constants ORed in: none; written by UpdateRegConfigParam (1 stores).  arm-re rediff (2026-11-12): confirmed by the path-sensitive run (1 stores, extents none seen). Field meanings UNKNOWN.";
        field {
            name = "word";
            desc = "32-bit table word.";
            sw = rw;
            hw = r;
        } word[31:0];
    } TBL_138 @ 0x138;

    reg {
        name = "Table word 0x13C";
        desc = "Word 0x13C of the H.264 register table. PROVENANCE: PROVEN offset; PROVEN stored byte lanes 0123 (lane 0 = bits [7:0]); PROVEN cleared bit extents none seen (lower bound of the fields); constants ORed in: none; written by UpdateRegConfigParam (1 stores).  arm-re rediff (2026-11-12): confirmed by the path-sensitive run (1 stores, extents none seen). Field meanings UNKNOWN.";
        field {
            name = "word";
            desc = "32-bit table word.";
            sw = rw;
            hw = r;
        } word[31:0];
    } TBL_13C @ 0x13C;

    reg {
        name = "Table word 0x140";
        desc = "Word 0x140 of the H.264 register table. PROVENANCE: PROVEN offset; PROVEN stored byte lanes 0123 (lane 0 = bits [7:0]); PROVEN cleared bit extents none seen (lower bound of the fields); constants ORed in: none; written by UpdateRegConfigParam (1 stores).  arm-re rediff (2026-11-12): confirmed by the path-sensitive run (1 stores, extents none seen). Field meanings UNKNOWN.";
        field {
            name = "word";
            desc = "32-bit table word.";
            sw = rw;
            hw = r;
        } word[31:0];
    } TBL_140 @ 0x140;

    reg {
        name = "Table word 0x144";
        desc = "Word 0x144 of the H.264 register table. PROVENANCE: PROVEN offset; PROVEN stored byte lanes 0123 (lane 0 = bits [7:0]); PROVEN cleared bit extents none seen (lower bound of the fields); constants ORed in: none; written by UpdateRegConfigParam (1 stores).  arm-re rediff (2026-11-12): confirmed by the path-sensitive run (1 stores, extents none seen). Field meanings UNKNOWN.";
        field {
            name = "word";
            desc = "32-bit table word.";
            sw = rw;
            hw = r;
        } word[31:0];
    } TBL_144 @ 0x144;

    reg {
        name = "Table word 0x148";
        desc = "Word 0x148 of the H.264 register table. PROVENANCE: PROVEN offset; PROVEN stored byte lanes 012 (lane 0 = bits [7:0]); PROVEN cleared bit extents [5:0] [13:8] [22:16] (lower bound of the fields); constants ORed in: none; written by UpdateRegConfigParam (3 stores).  arm-re rediff (2026-11-12): confirmed by the path-sensitive run (3 stores, extents [5:0] [13:8] [22:16]). Field meanings UNKNOWN.";
        field {
            name = "word";
            desc = "32-bit table word.";
            sw = rw;
            hw = r;
        } word[31:0];
    } TBL_148 @ 0x148;

    reg {
        name = "Table word 0x204";
        desc = "Word 0x204 of the H.264 register table. PROVENANCE: PROVEN offset; PROVEN stored byte lanes 2 (lane 0 = bits [7:0]); PROVEN cleared bit extents [17:16] (lower bound of the fields); constants ORed in: none; written by UpdateRegConfigParam (2 stores).  arm-re rediff (2026-11-12): confirmed by the path-sensitive run (8 stores, extents [16:16] [17:17]). Field meanings UNKNOWN.";
        field {
            name = "word";
            desc = "32-bit table word.";
            sw = rw;
            hw = r;
        } word[31:0];
    } TBL_204 @ 0x204;

    reg {
        name = "Word at offset 0x208";
        desc = "Word 0x208 (NEW in the arm-re rediff 2026-11-12). PROVENANCE: PROVEN offset and stored byte lanes 01, cleared bit extents [3:0] [7:4] [9:8], written by H264E_DRV_UpdateRegConfigParam (3 stores) in the path-sensitive static run (conditional paths and indexed loop records folded into the word; some are loop-built or conditional and not individually proven). Meaning UNKNOWN.";
        field {
            name = "word";
            desc = "32-bit word.";
            sw = rw;
            hw = r;
        } word[31:0];
    } TBL_208 @ 0x208;
    reg {
        name = "Word at offset 0x210";
        desc = "Word 0x210 (NEW in the arm-re rediff 2026-11-12). PROVENANCE: PROVEN offset and stored byte lanes 01, cleared bit extents [3:0] [4:4] [5:5] [31:8], written by H264E_DRV_UpdateRegConfigParam (11 stores) in the path-sensitive static run (conditional paths and indexed loop records folded into the word; some are loop-built or conditional and not individually proven). Meaning UNKNOWN.";
        field {
            name = "word";
            desc = "32-bit word.";
            sw = rw;
            hw = r;
        } word[31:0];
    } TBL_210 @ 0x210;
    reg {
        name = "Table word 0x214";
        desc = "Word 0x214 of the H.264 register table. PROVENANCE: PROVEN offset; PROVEN stored byte lanes 0 (lane 0 = bits [7:0]); PROVEN cleared bit extents [1:0] (lower bound of the fields); constants ORed in: none; written by UpdateLowerPowerCfg (2 stores).  arm-re rediff (2026-11-12): confirmed by the path-sensitive run (7 stores, extents [0:0] [1:1] [2:2] [3:3] [4:4]). Field meanings UNKNOWN.";
        field {
            name = "word";
            desc = "32-bit table word.";
            sw = rw;
            hw = r;
        } word[31:0];
    } TBL_214 @ 0x214;

    reg {
        name = "Word at offset 0x218";
        desc = "Word 0x218 (NEW in the arm-re rediff 2026-11-12). PROVENANCE: PROVEN offset and stored byte lanes 0123, cleared bit extents none seen, written by H264E_DRV_UpdateLowerPowerCfg, H264E_DRV_UpdateRegConfigParam (5 stores) in the path-sensitive static run (conditional paths and indexed loop records folded into the word; some are loop-built or conditional and not individually proven). Meaning UNKNOWN.";
        field {
            name = "word";
            desc = "32-bit word.";
            sw = rw;
            hw = r;
        } word[31:0];
    } TBL_218 @ 0x218;
    reg {
        name = "Table word 0x21C";
        desc = "Word 0x21C of the H.264 register table. PROVENANCE: PROVEN offset; PROVEN stored byte lanes 23 (lane 0 = bits [7:0]); PROVEN cleared bit extents none seen (lower bound of the fields); constants ORed in: none; written by UpdateLowerPowerCfg (2 stores).  arm-re rediff (2026-11-12): confirmed by the path-sensitive run (4 stores, extents none seen). Field meanings UNKNOWN.";
        field {
            name = "word";
            desc = "32-bit table word.";
            sw = rw;
            hw = r;
        } word[31:0];
    } TBL_21C @ 0x21C;

    reg {
        name = "Table word 0x220";
        desc = "Word 0x220 of the H.264 register table. PROVENANCE: PROVEN offset; PROVEN stored byte lanes 023 (lane 0 = bits [7:0]); PROVEN cleared bit extents none seen (lower bound of the fields); constants ORed in: none; written by UpdateLowerPowerCfg (3 stores).  arm-re rediff (2026-11-12): confirmed by the path-sensitive run (7 stores, extents none seen). Field meanings UNKNOWN.";
        field {
            name = "word";
            desc = "32-bit table word.";
            sw = rw;
            hw = r;
        } word[31:0];
    } TBL_220 @ 0x220;

    reg {
        name = "Word at offset 0x224";
        desc = "Word 0x224 (NEW in the arm-re rediff 2026-11-12). PROVENANCE: PROVEN offset and stored byte lanes 0, cleared bit extents [1:1], written by H264E_DRV_UpdateRegConfigParam (1 stores) in the path-sensitive static run (conditional paths and indexed loop records folded into the word; some are loop-built or conditional and not individually proven). Meaning UNKNOWN.";
        field {
            name = "word";
            desc = "32-bit word.";
            sw = rw;
            hw = r;
        } word[31:0];
    } TBL_224 @ 0x224;
    reg {
        name = "Word at offset 0x228";
        desc = "Word 0x228 (NEW in the arm-re rediff 2026-11-12). PROVENANCE: PROVEN offset and stored byte lanes 0123, cleared bit extents none seen, written by H264E_DRV_UpdateRegConfigParam (1 stores) in the path-sensitive static run (conditional paths and indexed loop records folded into the word; some are loop-built or conditional and not individually proven). Meaning UNKNOWN.";
        field {
            name = "word";
            desc = "32-bit word.";
            sw = rw;
            hw = r;
        } word[31:0];
    } TBL_228 @ 0x228;
    reg {
        name = "Word at offset 0x22C";
        desc = "Word 0x22C (NEW in the arm-re rediff 2026-11-12). PROVENANCE: PROVEN offset and stored byte lanes 01, cleared bit extents [5:0] [11:6], written by H264E_DRV_UpdateLowerPowerCfg, H264E_DRV_UpdateRegConfigParam (4 stores) in the path-sensitive static run (conditional paths and indexed loop records folded into the word; some are loop-built or conditional and not individually proven). Meaning UNKNOWN.";
        field {
            name = "word";
            desc = "32-bit word.";
            sw = rw;
            hw = r;
        } word[31:0];
    } TBL_22C @ 0x22C;
    reg {
        name = "Word at offset 0x230";
        desc = "Word 0x230 (NEW in the arm-re rediff 2026-11-12). PROVENANCE: PROVEN offset and stored byte lanes 0123, cleared bit extents none seen, written by H264E_DRV_UpdateRegConfigParam (1 stores) in the path-sensitive static run (conditional paths and indexed loop records folded into the word; some are loop-built or conditional and not individually proven). Meaning UNKNOWN.";
        field {
            name = "word";
            desc = "32-bit word.";
            sw = rw;
            hw = r;
        } word[31:0];
    } TBL_230 @ 0x230;
    reg {
        name = "Word at offset 0x240";
        desc = "Word 0x240 (NEW in the arm-re rediff 2026-11-12). PROVENANCE: PROVEN offset and stored byte lanes 0, cleared bit extents [0:0], written by H264E_DRV_UpdateRegConfigParam (1 stores) in the path-sensitive static run (conditional paths and indexed loop records folded into the word; some are loop-built or conditional and not individually proven). Meaning UNKNOWN.";
        field {
            name = "word";
            desc = "32-bit word.";
            sw = rw;
            hw = r;
        } word[31:0];
    } TBL_240 @ 0x240;
    reg {
        name = "Word at offset 0x248";
        desc = "Word 0x248 (NEW in the arm-re rediff 2026-11-12). PROVENANCE: PROVEN offset and stored byte lanes 01, cleared bit extents none seen, written by H264E_DRV_UpdateRegConfigParam (2 stores) in the path-sensitive static run (conditional paths and indexed loop records folded into the word; some are loop-built or conditional and not individually proven). Meaning UNKNOWN.";
        field {
            name = "word";
            desc = "32-bit word.";
            sw = rw;
            hw = r;
        } word[31:0];
    } TBL_248 @ 0x248;
    reg {
        name = "Word at offset 0x24C";
        desc = "Word 0x24C (NEW in the arm-re rediff 2026-11-12). PROVENANCE: PROVEN offset and stored byte lanes 0123, cleared bit extents none seen, written by H264E_DRV_UpdateRegConfigParam (1 stores) in the path-sensitive static run (conditional paths and indexed loop records folded into the word; some are loop-built or conditional and not individually proven). Meaning UNKNOWN.";
        field {
            name = "word";
            desc = "32-bit word.";
            sw = rw;
            hw = r;
        } word[31:0];
    } TBL_24C @ 0x24C;
    reg {
        name = "Word at offset 0x250";
        desc = "Word 0x250 (NEW in the arm-re rediff 2026-11-12). PROVENANCE: PROVEN offset and stored byte lanes 012, cleared bit extents none seen, written by H264E_DRV_UpdateRegConfigParam (3 stores) in the path-sensitive static run (conditional paths and indexed loop records folded into the word; some are loop-built or conditional and not individually proven). Meaning UNKNOWN.";
        field {
            name = "word";
            desc = "32-bit word.";
            sw = rw;
            hw = r;
        } word[31:0];
    } TBL_250 @ 0x250;
    reg {
        name = "Word at offset 0x260";
        desc = "Word 0x260 (NEW in the arm-re rediff 2026-11-12). PROVENANCE: PROVEN offset and stored byte lanes 0123, cleared bit extents none seen, written by H264E_DRV_UpdateRegConfigParam (1 stores) in the path-sensitive static run (conditional paths and indexed loop records folded into the word; some are loop-built or conditional and not individually proven). Meaning UNKNOWN.";
        field {
            name = "word";
            desc = "32-bit word.";
            sw = rw;
            hw = r;
        } word[31:0];
    } TBL_260 @ 0x260;
    reg {
        name = "Word at offset 0x264";
        desc = "Word 0x264 (NEW in the arm-re rediff 2026-11-12). PROVENANCE: PROVEN offset and stored byte lanes 0123, cleared bit extents none seen, written by H264E_DRV_UpdateRegConfigParam (1 stores) in the path-sensitive static run (conditional paths and indexed loop records folded into the word; some are loop-built or conditional and not individually proven). Meaning UNKNOWN.";
        field {
            name = "word";
            desc = "32-bit word.";
            sw = rw;
            hw = r;
        } word[31:0];
    } TBL_264 @ 0x264;
    reg {
        name = "Word at offset 0x268";
        desc = "Word 0x268 (NEW in the arm-re rediff 2026-11-12). PROVENANCE: PROVEN offset and stored byte lanes 0123, cleared bit extents none seen, written by H264E_DRV_UpdateRegConfigParam (1 stores) in the path-sensitive static run (conditional paths and indexed loop records folded into the word; some are loop-built or conditional and not individually proven). Meaning UNKNOWN.";
        field {
            name = "word";
            desc = "32-bit word.";
            sw = rw;
            hw = r;
        } word[31:0];
    } TBL_268 @ 0x268;
    reg {
        name = "Word at offset 0x26C";
        desc = "Word 0x26C (NEW in the arm-re rediff 2026-11-12). PROVENANCE: PROVEN offset and stored byte lanes 0123, cleared bit extents none seen, written by H264E_DRV_UpdateRegConfigParam (1 stores) in the path-sensitive static run (conditional paths and indexed loop records folded into the word; some are loop-built or conditional and not individually proven). Meaning UNKNOWN.";
        field {
            name = "word";
            desc = "32-bit word.";
            sw = rw;
            hw = r;
        } word[31:0];
    } TBL_26C @ 0x26C;
    reg {
        name = "Word at offset 0x270";
        desc = "Word 0x270 (NEW in the arm-re rediff 2026-11-12). PROVENANCE: PROVEN offset and stored byte lanes 0123, cleared bit extents none seen, written by H264E_DRV_UpdateRegConfigParam (1 stores) in the path-sensitive static run (conditional paths and indexed loop records folded into the word; some are loop-built or conditional and not individually proven). Meaning UNKNOWN.";
        field {
            name = "word";
            desc = "32-bit word.";
            sw = rw;
            hw = r;
        } word[31:0];
    } TBL_270 @ 0x270;
    reg {
        name = "Word at offset 0x274";
        desc = "Word 0x274 (NEW in the arm-re rediff 2026-11-12). PROVENANCE: PROVEN offset and stored byte lanes 0123, cleared bit extents none seen, written by H264E_DRV_UpdateRegConfigParam (1 stores) in the path-sensitive static run (conditional paths and indexed loop records folded into the word; some are loop-built or conditional and not individually proven). Meaning UNKNOWN.";
        field {
            name = "word";
            desc = "32-bit word.";
            sw = rw;
            hw = r;
        } word[31:0];
    } TBL_274 @ 0x274;
    reg {
        name = "Word at offset 0x278";
        desc = "Word 0x278 (NEW in the arm-re rediff 2026-11-12). PROVENANCE: PROVEN offset and stored byte lanes 0123, cleared bit extents none seen, written by H264E_DRV_UpdateRegConfigParam (1 stores) in the path-sensitive static run (conditional paths and indexed loop records folded into the word; some are loop-built or conditional and not individually proven). Meaning UNKNOWN.";
        field {
            name = "word";
            desc = "32-bit word.";
            sw = rw;
            hw = r;
        } word[31:0];
    } TBL_278 @ 0x278;
    reg {
        name = "Word at offset 0x27C";
        desc = "Word 0x27C (NEW in the arm-re rediff 2026-11-12). PROVENANCE: PROVEN offset and stored byte lanes 0123, cleared bit extents none seen, written by H264E_DRV_UpdateRegConfigParam (1 stores) in the path-sensitive static run (conditional paths and indexed loop records folded into the word; some are loop-built or conditional and not individually proven). Meaning UNKNOWN.";
        field {
            name = "word";
            desc = "32-bit word.";
            sw = rw;
            hw = r;
        } word[31:0];
    } TBL_27C @ 0x27C;
    reg {
        name = "Word at offset 0x300";
        desc = "Word 0x300 (NEW in the arm-re rediff 2026-11-12). PROVENANCE: PROVEN offset and stored byte lanes 0123, cleared bit extents [7:0] [24:0] [16:16], written by H264E_DRV_UpdateOsdRoiConfigParam (4 stores) in the path-sensitive static run (conditional paths and indexed loop records folded into the word; some are loop-built or conditional and not individually proven). Meaning UNKNOWN.";
        field {
            name = "word";
            desc = "32-bit word.";
            sw = rw;
            hw = r;
        } word[31:0];
    } TBL_300 @ 0x300;
    reg {
        name = "Word at offset 0x304";
        desc = "Word 0x304 (NEW in the arm-re rediff 2026-11-12). PROVENANCE: PROVEN offset and stored byte lanes 0123, cleared bit extents [28:16], written by H264E_DRV_UpdateOsdRoiConfigParam (2 stores) in the path-sensitive static run (conditional paths and indexed loop records folded into the word; some are loop-built or conditional and not individually proven). Meaning UNKNOWN.";
        field {
            name = "word";
            desc = "32-bit word.";
            sw = rw;
            hw = r;
        } word[31:0];
    } TBL_304 @ 0x304;
    reg {
        name = "Word at offset 0x324";
        desc = "Word 0x324 (NEW in the arm-re rediff 2026-11-12). PROVENANCE: PROVEN offset and stored byte lanes 0123, cleared bit extents [28:16], written by H264E_DRV_UpdateOsdRoiConfigParam (2 stores) in the path-sensitive static run (conditional paths and indexed loop records folded into the word; some are loop-built or conditional and not individually proven). Meaning UNKNOWN.";
        field {
            name = "word";
            desc = "32-bit word.";
            sw = rw;
            hw = r;
        } word[31:0];
    } TBL_324 @ 0x324;
    reg {
        name = "Word at offset 0x344";
        desc = "Word 0x344 (NEW in the arm-re rediff 2026-11-12). PROVENANCE: PROVEN offset and stored byte lanes 0123, cleared bit extents [2:0] [6:4] [10:8] [14:12] [18:16] [22:20] [26:24] [30:28], written by H264E_DRV_UpdateOsdRoiConfigParam (1 stores) in the path-sensitive static run (conditional paths and indexed loop records folded into the word; some are loop-built or conditional and not individually proven). Meaning UNKNOWN.";
        field {
            name = "word";
            desc = "32-bit word.";
            sw = rw;
            hw = r;
        } word[31:0];
    } TBL_344 @ 0x344;
    reg {
        name = "Word at offset 0x348";
        desc = "Word 0x348 (NEW in the arm-re rediff 2026-11-12). PROVENANCE: PROVEN offset and stored byte lanes 0123, cleared bit extents [27:0], written by H264E_DRV_UpdateOsdRoiConfigParam (3 stores) in the path-sensitive static run (conditional paths and indexed loop records folded into the word; some are loop-built or conditional and not individually proven). Meaning UNKNOWN.";
        field {
            name = "word";
            desc = "32-bit word.";
            sw = rw;
            hw = r;
        } word[31:0];
    } TBL_348 @ 0x348;
    reg {
        name = "Word at offset 0x34C";
        desc = "Word 0x34C (NEW in the arm-re rediff 2026-11-12). PROVENANCE: PROVEN offset and stored byte lanes 0123, cleared bit extents [27:0], written by H264E_DRV_UpdateOsdRoiConfigParam (2 stores) in the path-sensitive static run (conditional paths and indexed loop records folded into the word; some are loop-built or conditional and not individually proven). Meaning UNKNOWN.";
        field {
            name = "word";
            desc = "32-bit word.";
            sw = rw;
            hw = r;
        } word[31:0];
    } TBL_34C @ 0x34C;
    reg {
        name = "Word at offset 0x350";
        desc = "Word 0x350 (NEW in the arm-re rediff 2026-11-12). PROVENANCE: PROVEN offset and stored byte lanes 0123, cleared bit extents [31:0], written by H264E_DRV_UpdateOsdRoiConfigParam (1 stores) in the path-sensitive static run (conditional paths and indexed loop records folded into the word; some are loop-built or conditional and not individually proven). Meaning UNKNOWN.";
        field {
            name = "word";
            desc = "32-bit word.";
            sw = rw;
            hw = r;
        } word[31:0];
    } TBL_350 @ 0x350;
    reg {
        name = "Word at offset 0x354";
        desc = "Word 0x354 (NEW in the arm-re rediff 2026-11-12). PROVENANCE: PROVEN offset and stored byte lanes 0123, cleared bit extents [31:0], written by H264E_DRV_UpdateOsdRoiConfigParam (1 stores) in the path-sensitive static run (conditional paths and indexed loop records folded into the word; some are loop-built or conditional and not individually proven). Meaning UNKNOWN.";
        field {
            name = "word";
            desc = "32-bit word.";
            sw = rw;
            hw = r;
        } word[31:0];
    } TBL_354 @ 0x354;
    reg {
        name = "Word at offset 0x358";
        desc = "Word 0x358 (NEW in the arm-re rediff 2026-11-12). PROVENANCE: PROVEN offset and stored byte lanes 0123, cleared bit extents [31:0], written by H264E_DRV_UpdateOsdRoiConfigParam (1 stores) in the path-sensitive static run (conditional paths and indexed loop records folded into the word; some are loop-built or conditional and not individually proven). Meaning UNKNOWN.";
        field {
            name = "word";
            desc = "32-bit word.";
            sw = rw;
            hw = r;
        } word[31:0];
    } TBL_358 @ 0x358;
    reg {
        name = "Word at offset 0x35C";
        desc = "Word 0x35C (NEW in the arm-re rediff 2026-11-12). PROVENANCE: PROVEN offset and stored byte lanes 0123, cleared bit extents [31:0], written by H264E_DRV_UpdateOsdRoiConfigParam (1 stores) in the path-sensitive static run (conditional paths and indexed loop records folded into the word; some are loop-built or conditional and not individually proven). Meaning UNKNOWN.";
        field {
            name = "word";
            desc = "32-bit word.";
            sw = rw;
            hw = r;
        } word[31:0];
    } TBL_35C @ 0x35C;
    reg {
        name = "Word at offset 0x360";
        desc = "Word 0x360 (NEW in the arm-re rediff 2026-11-12). PROVENANCE: PROVEN offset and stored byte lanes 0123, cleared bit extents none seen, written by H264E_DRV_UpdateOsdRoiConfigParam (1 stores) in the path-sensitive static run (conditional paths and indexed loop records folded into the word; some are loop-built or conditional and not individually proven). Meaning UNKNOWN.";
        field {
            name = "word";
            desc = "32-bit word.";
            sw = rw;
            hw = r;
        } word[31:0];
    } TBL_360 @ 0x360;
    reg {
        name = "Word at offset 0x364";
        desc = "Word 0x364 (NEW in the arm-re rediff 2026-11-12). PROVENANCE: PROVEN offset and stored byte lanes 0123, cleared bit extents none seen, written by H264E_DRV_UpdateOsdRoiConfigParam (1 stores) in the path-sensitive static run (conditional paths and indexed loop records folded into the word; some are loop-built or conditional and not individually proven). Meaning UNKNOWN.";
        field {
            name = "word";
            desc = "32-bit word.";
            sw = rw;
            hw = r;
        } word[31:0];
    } TBL_364 @ 0x364;
    reg {
        name = "Word at offset 0x368";
        desc = "Word 0x368 (NEW in the arm-re rediff 2026-11-12). PROVENANCE: PROVEN offset and stored byte lanes 0123, cleared bit extents none seen, written by H264E_DRV_UpdateOsdRoiConfigParam (2 stores) in the path-sensitive static run (conditional paths and indexed loop records folded into the word; some are loop-built or conditional and not individually proven). Meaning UNKNOWN.";
        field {
            name = "word";
            desc = "32-bit word.";
            sw = rw;
            hw = r;
        } word[31:0];
    } TBL_368 @ 0x368;
    reg {
        name = "Word at offset 0x388";
        desc = "Word 0x388 (NEW in the arm-re rediff 2026-11-12). PROVENANCE: PROVEN offset and stored byte lanes 0123, cleared bit extents none seen, written by H264E_DRV_UpdateOsdRoiConfigParam (2 stores) in the path-sensitive static run (conditional paths and indexed loop records folded into the word; some are loop-built or conditional and not individually proven). Meaning UNKNOWN.";
        field {
            name = "word";
            desc = "32-bit word.";
            sw = rw;
            hw = r;
        } word[31:0];
    } TBL_388 @ 0x388;
    reg {
        name = "Table word 0x400";
        desc = "Word 0x400 of the H.264 register table. PROVENANCE: PROVEN offset; PROVEN stored byte lanes 2 (lane 0 = bits [7:0]); PROVEN cleared bit extents none seen (lower bound of the fields); constants ORed in: 0xFF0000; written by UpdateOsdRoiConfigParam (3 stores).  arm-re rediff (2026-11-12): confirmed by the path-sensitive run (28 stores, extents [0:0] [1:1] [2:2] [3:3] [4:4] [5:5] [6:6] [7:7] [8:8] [9:9] [10:10] [11:11] [12:12] [13:13] [14:14] [15:15] [16:16] [24:24]). Field meanings UNKNOWN.";
        field {
            name = "word";
            desc = "32-bit table word.";
            sw = rw;
            hw = r;
        } word[31:0];
    } TBL_400 @ 0x400;

    reg {
        name = "Word at offset 0x404";
        desc = "Word 0x404 (NEW in the arm-re rediff 2026-11-12). PROVENANCE: PROVEN offset and stored byte lanes 0123, cleared bit extents [6:0] [14:8] [22:16] [30:24], written by H264E_DRV_UpdateOsdRoiConfigParam (8 stores) in the path-sensitive static run (conditional paths and indexed loop records folded into the word; some are loop-built or conditional and not individually proven). Meaning UNKNOWN.";
        field {
            name = "word";
            desc = "32-bit word.";
            sw = rw;
            hw = r;
        } word[31:0];
    } TBL_404 @ 0x404;
    reg {
        name = "Word at offset 0x408";
        desc = "Word 0x408 (NEW in the arm-re rediff 2026-11-12). PROVENANCE: PROVEN offset and stored byte lanes 0123, cleared bit extents [6:0] [14:8] [22:16] [30:24], written by H264E_DRV_UpdateOsdRoiConfigParam (8 stores) in the path-sensitive static run (conditional paths and indexed loop records folded into the word; some are loop-built or conditional and not individually proven). Meaning UNKNOWN.";
        field {
            name = "word";
            desc = "32-bit word.";
            sw = rw;
            hw = r;
        } word[31:0];
    } TBL_408 @ 0x408;
    reg {
        name = "Word at offset 0x40C";
        desc = "Word 0x40C (NEW in the arm-re rediff 2026-11-12). PROVENANCE: PROVEN offset and stored byte lanes 0123, cleared bit extents [9:0] [25:16] [31:16] [47:32], written by H264E_DRV_UpdateOsdRoiConfigParam (8 stores) in the path-sensitive static run (conditional paths and indexed loop records folded into the word; some are loop-built or conditional and not individually proven). Meaning UNKNOWN.";
        field {
            name = "word";
            desc = "32-bit word.";
            sw = rw;
            hw = r;
        } word[31:0];
    } TBL_40C @ 0x40C;
    reg {
        name = "Word at offset 0x42C";
        desc = "Word 0x42C (NEW in the arm-re rediff 2026-11-12). PROVENANCE: PROVEN offset and stored byte lanes 0123, cleared bit extents [8:0] [24:16] [31:16] [47:32], written by H264E_DRV_UpdateOsdRoiConfigParam (8 stores) in the path-sensitive static run (conditional paths and indexed loop records folded into the word; some are loop-built or conditional and not individually proven). Meaning UNKNOWN.";
        field {
            name = "word";
            desc = "32-bit word.";
            sw = rw;
            hw = r;
        } word[31:0];
    } TBL_42C @ 0x42C;
    reg {
        name = "Word at offset 0x500";
        desc = "Word 0x500 (NEW in the arm-re rediff 2026-11-12). PROVENANCE: PROVEN offset and stored byte lanes 0123, cleared bit extents none seen, written by H264E_DRV_InitRegConfigParam (2 stores) in the path-sensitive static run (conditional paths and indexed loop records folded into the word; some are loop-built or conditional and not individually proven). Meaning UNKNOWN.";
        field {
            name = "word";
            desc = "32-bit word.";
            sw = rw;
            hw = r;
        } word[31:0];
    } TBL_500 @ 0x500;
    reg {
        name = "Word at offset 0x720";
        desc = "Word 0x720 (NEW in the arm-re rediff 2026-11-12). PROVENANCE: PROVEN offset and stored byte lanes 0123, cleared bit extents [7:0] [11:0] [11:9], written by H264E_DRV_UpdateRegConfigParam (2 stores) in the path-sensitive static run (conditional paths and indexed loop records folded into the word; some are loop-built or conditional and not individually proven). Meaning UNKNOWN.";
        field {
            name = "word";
            desc = "32-bit word.";
            sw = rw;
            hw = r;
        } word[31:0];
    } TBL_720 @ 0x720;
    reg {
        name = "Word at offset 0x72C";
        desc = "Word 0x72C (NEW in the arm-re rediff 2026-11-12). PROVENANCE: PROVEN offset and stored byte lanes 0123, cleared bit extents [11:0], written by H264E_DRV_UpdateRegConfigParam (1 stores) in the path-sensitive static run (conditional paths and indexed loop records folded into the word; some are loop-built or conditional and not individually proven). Meaning UNKNOWN.";
        field {
            name = "word";
            desc = "32-bit word.";
            sw = rw;
            hw = r;
        } word[31:0];
    } TBL_72C @ 0x72C;
    reg {
        name = "Word at offset 0x738";
        desc = "Word 0x738 (NEW in the arm-re rediff 2026-11-12). PROVENANCE: PROVEN offset and stored byte lanes 0123, cleared bit extents [11:0], written by H264E_DRV_UpdateRegConfigParam (1 stores) in the path-sensitive static run (conditional paths and indexed loop records folded into the word; some are loop-built or conditional and not individually proven). Meaning UNKNOWN.";
        field {
            name = "word";
            desc = "32-bit word.";
            sw = rw;
            hw = r;
        } word[31:0];
    } TBL_738 @ 0x738;
    reg {
        name = "Table word 0x7E0";
        desc = "Word 0x7E0 of the H.264 register table. PROVENANCE: PROVEN offset; PROVEN stored byte lanes 0123 (lane 0 = bits [7:0]); PROVEN cleared bit extents none seen (lower bound of the fields); constants ORed in: none; written by InitRegConfigParam (1 stores).  arm-re rediff (2026-11-12): confirmed by the path-sensitive run (1 stores, extents none seen). Field meanings UNKNOWN.";
        field {
            name = "word";
            desc = "32-bit table word.";
            sw = rw;
            hw = r;
        } word[31:0];
    } TBL_7E0 @ 0x7E0;

    reg {
        name = "Table word 0x7E4";
        desc = "Word 0x7E4 of the H.264 register table. PROVENANCE: PROVEN offset; PROVEN stored byte lanes 0123 (lane 0 = bits [7:0]); PROVEN cleared bit extents none seen (lower bound of the fields); constants ORed in: none; written by InitRegConfigParam (1 stores).  arm-re rediff (2026-11-12): confirmed by the path-sensitive run (1 stores, extents none seen). Field meanings UNKNOWN.";
        field {
            name = "word";
            desc = "32-bit table word.";
            sw = rw;
            hw = r;
        } word[31:0];
    } TBL_7E4 @ 0x7E4;

    reg {
        name = "Table word 0x7E8";
        desc = "Word 0x7E8 of the H.264 register table. PROVENANCE: PROVEN offset; PROVEN stored byte lanes 0123 (lane 0 = bits [7:0]); PROVEN cleared bit extents none seen (lower bound of the fields); constants ORed in: none; written by InitRegConfigParam (1 stores).  arm-re rediff (2026-11-12): confirmed by the path-sensitive run (1 stores, extents none seen). Field meanings UNKNOWN.";
        field {
            name = "word";
            desc = "32-bit table word.";
            sw = rw;
            hw = r;
        } word[31:0];
    } TBL_7E8 @ 0x7E8;

    reg {
        name = "Word at offset 0x800";
        desc = "Word 0x800 (NEW in the arm-re rediff 2026-11-12). PROVENANCE: PROVEN offset and stored byte lanes 0, cleared bit extents [0:0], written by H264E_DRV_UpdateLowerPowerCfg, H264E_DRV_UpdateRegConfigParam (2 stores) in the path-sensitive static run (conditional paths and indexed loop records folded into the word; some are loop-built or conditional and not individually proven). Meaning UNKNOWN.";
        field {
            name = "word";
            desc = "32-bit word.";
            sw = rw;
            hw = r;
        } word[31:0];
    } TBL_800 @ 0x800;
    reg {
        name = "Word at offset 0x804";
        desc = "Word 0x804 (NEW in the arm-re rediff 2026-11-12). PROVENANCE: PROVEN offset and stored byte lanes 01, cleared bit extents none seen, written by H264E_DRV_UpdateLowerPowerCfg, H264E_DRV_UpdateRegConfigParam (2 stores) in the path-sensitive static run (conditional paths and indexed loop records folded into the word; some are loop-built or conditional and not individually proven). Meaning UNKNOWN.";
        field {
            name = "word";
            desc = "32-bit word.";
            sw = rw;
            hw = r;
        } word[31:0];
    } TBL_804 @ 0x804;
    reg {
        name = "Word at offset 0x808";
        desc = "Word 0x808 (NEW in the arm-re rediff 2026-11-12). PROVENANCE: PROVEN offset and stored byte lanes 01, cleared bit extents none seen, written by H264E_DRV_UpdateLowerPowerCfg, H264E_DRV_UpdateRegConfigParam (2 stores) in the path-sensitive static run (conditional paths and indexed loop records folded into the word; some are loop-built or conditional and not individually proven). Meaning UNKNOWN.";
        field {
            name = "word";
            desc = "32-bit word.";
            sw = rw;
            hw = r;
        } word[31:0];
    } TBL_808 @ 0x808;
    reg {
        name = "Word at offset 0x80C";
        desc = "Word 0x80C (NEW in the arm-re rediff 2026-11-12). PROVENANCE: PROVEN offset and stored byte lanes 01, cleared bit extents none seen, written by H264E_DRV_UpdateLowerPowerCfg, H264E_DRV_UpdateRegConfigParam (2 stores) in the path-sensitive static run (conditional paths and indexed loop records folded into the word; some are loop-built or conditional and not individually proven). Meaning UNKNOWN.";
        field {
            name = "word";
            desc = "32-bit word.";
            sw = rw;
            hw = r;
        } word[31:0];
    } TBL_80C @ 0x80C;
    reg {
        name = "Table word 0x810";
        desc = "Word 0x810 of the H.264 register table. PROVENANCE: PROVEN offset; PROVEN stored byte lanes 0123 (lane 0 = bits [7:0]); PROVEN cleared bit extents none seen (lower bound of the fields); constants ORed in: 0x7F; written by InitRegConfigParam (1 stores).  arm-re rediff (2026-11-12): confirmed by the path-sensitive run (1 stores, extents none seen). Field meanings UNKNOWN.";
        field {
            name = "word";
            desc = "32-bit table word.";
            sw = rw;
            hw = r;
        } word[31:0];
    } TBL_810 @ 0x810;

    reg {
        name = "Table word 0x814";
        desc = "Word 0x814 of the H.264 register table. PROVENANCE: PROVEN offset; PROVEN stored byte lanes 0123 (lane 0 = bits [7:0]); PROVEN cleared bit extents [17:9] (lower bound of the fields); constants ORed in: none; written by UpdateLowerPowerCfg (1 stores).  arm-re rediff (2026-11-12): confirmed by the path-sensitive run (6 stores, extents [17:9] [26:18]). Field meanings UNKNOWN.";
        field {
            name = "word";
            desc = "32-bit table word.";
            sw = rw;
            hw = r;
        } word[31:0];
    } TBL_814 @ 0x814;

    reg {
        name = "Table word 0x818";
        desc = "Word 0x818 of the H.264 register table. PROVENANCE: PROVEN offset; PROVEN stored byte lanes 012 (lane 0 = bits [7:0]); PROVEN cleared bit extents none seen (lower bound of the fields); constants ORed in: none; written by UpdateLowerPowerCfg (3 stores).  arm-re rediff (2026-11-12): confirmed by the path-sensitive run (6 stores, extents none seen). Field meanings UNKNOWN.";
        field {
            name = "word";
            desc = "32-bit table word.";
            sw = rw;
            hw = r;
        } word[31:0];
    } TBL_818 @ 0x818;

    reg {
        name = "Table word 0x81C";
        desc = "Word 0x81C of the H.264 register table. PROVENANCE: PROVEN offset; PROVEN stored byte lanes 0123 (lane 0 = bits [7:0]); PROVEN cleared bit extents [11:0] (lower bound of the fields); constants ORed in: none; written by InitRegConfigParam, UpdateLowerPowerCfg (4 stores).  arm-re rediff (2026-11-12): confirmed by the path-sensitive run (7 stores, extents [3:0] [7:4] [11:8]). Field meanings UNKNOWN.";
        field {
            name = "word";
            desc = "32-bit table word.";
            sw = rw;
            hw = r;
        } word[31:0];
    } TBL_81C @ 0x81C;

    reg {
        name = "Table word 0x820";
        desc = "Word 0x820 of the H.264 register table. PROVENANCE: PROVEN offset; PROVEN stored byte lanes 0123 (lane 0 = bits [7:0]); PROVEN cleared bit extents none seen (lower bound of the fields); constants ORed in: none; written by InitRegConfigParam (1 stores).  arm-re rediff (2026-11-12): confirmed by the path-sensitive run (2 stores, extents none seen). Field meanings UNKNOWN.";
        field {
            name = "word";
            desc = "32-bit table word.";
            sw = rw;
            hw = r;
        } word[31:0];
    } TBL_820 @ 0x820;

    reg {
        name = "Table word 0x824";
        desc = "Word 0x824 of the H.264 register table. PROVENANCE: PROVEN offset; PROVEN stored byte lanes 0123 (lane 0 = bits [7:0]); PROVEN cleared bit extents none seen (lower bound of the fields); constants ORed in: none; written by InitRegConfigParam (1 stores).  arm-re rediff (2026-11-12): confirmed by the path-sensitive run (1 stores, extents none seen). Field meanings UNKNOWN.";
        field {
            name = "word";
            desc = "32-bit table word.";
            sw = rw;
            hw = r;
        } word[31:0];
    } TBL_824 @ 0x824;

    reg {
        name = "Table word 0x828";
        desc = "Word 0x828 of the H.264 register table. PROVENANCE: PROVEN offset; PROVEN stored byte lanes 012 (lane 0 = bits [7:0]); PROVEN cleared bit extents none seen (lower bound of the fields); constants ORed in: 0x400, 0x3C0000; written by InitRegConfigParam (3 stores).  arm-re rediff (2026-11-12): confirmed by the path-sensitive run (3 stores, extents none seen). Field meanings UNKNOWN.";
        field {
            name = "word";
            desc = "32-bit table word.";
            sw = rw;
            hw = r;
        } word[31:0];
    } TBL_828 @ 0x828;

    reg {
        name = "Table word 0x830";
        desc = "Word 0x830 of the H.264 register table. PROVENANCE: PROVEN offset; PROVEN stored byte lanes 0123 (lane 0 = bits [7:0]); PROVEN cleared bit extents none seen (lower bound of the fields); constants ORed in: none; written by InitRegConfigParam (1 stores).  arm-re rediff (2026-11-12): confirmed by the path-sensitive run (1 stores, extents none seen). Field meanings UNKNOWN.";
        field {
            name = "word";
            desc = "32-bit table word.";
            sw = rw;
            hw = r;
        } word[31:0];
    } TBL_830 @ 0x830;

    reg {
        name = "Table word 0x834";
        desc = "Word 0x834 of the H.264 register table. PROVENANCE: PROVEN offset; PROVEN stored byte lanes 0123 (lane 0 = bits [7:0]); PROVEN cleared bit extents none seen (lower bound of the fields); constants ORed in: none; written by InitRegConfigParam (1 stores).  arm-re rediff (2026-11-12): confirmed by the path-sensitive run (1 stores, extents none seen). Field meanings UNKNOWN.";
        field {
            name = "word";
            desc = "32-bit table word.";
            sw = rw;
            hw = r;
        } word[31:0];
    } TBL_834 @ 0x834;

    reg {
        name = "Table word 0x838";
        desc = "Word 0x838 of the H.264 register table. PROVENANCE: PROVEN offset; PROVEN stored byte lanes 0123 (lane 0 = bits [7:0]); PROVEN cleared bit extents none seen (lower bound of the fields); constants ORed in: none; written by InitRegConfigParam (1 stores).  arm-re rediff (2026-11-12): confirmed by the path-sensitive run (3 stores, extents none seen). Field meanings UNKNOWN.";
        field {
            name = "word";
            desc = "32-bit table word.";
            sw = rw;
            hw = r;
        } word[31:0];
    } TBL_838 @ 0x838;

    reg {
        name = "Table word 0x83C";
        desc = "Word 0x83C of the H.264 register table. PROVENANCE: PROVEN offset; PROVEN stored byte lanes 0123 (lane 0 = bits [7:0]); PROVEN cleared bit extents none seen (lower bound of the fields); constants ORed in: 0x30; written by InitRegConfigParam (1 stores).  arm-re rediff (2026-11-12): confirmed by the path-sensitive run (1 stores, extents none seen). Field meanings UNKNOWN.";
        field {
            name = "word";
            desc = "32-bit table word.";
            sw = rw;
            hw = r;
        } word[31:0];
    } TBL_83C @ 0x83C;

    reg {
        name = "Table word 0x840";
        desc = "Word 0x840 of the H.264 register table. PROVENANCE: PROVEN offset; PROVEN stored byte lanes 0123 (lane 0 = bits [7:0]); PROVEN cleared bit extents [8:8] [21:10] (lower bound of the fields); constants ORed in: 0x1F, 0x200; written by UpdateRegConfigParam (2 stores).  arm-re rediff (2026-11-12): confirmed by the path-sensitive run (3 stores, extents [8:8] [21:10]). Field meanings UNKNOWN.";
        field {
            name = "word";
            desc = "32-bit table word.";
            sw = rw;
            hw = r;
        } word[31:0];
    } TBL_840 @ 0x840;

    reg {
        name = "Table word 0x848";
        desc = "Word 0x848 of the H.264 register table. PROVENANCE: PROVEN offset; PROVEN stored byte lanes 0123 (lane 0 = bits [7:0]); PROVEN cleared bit extents none seen (lower bound of the fields); constants ORed in: none; written by InitRegConfigParam (1 stores).  arm-re rediff (2026-11-12): confirmed by the path-sensitive run (2 stores, extents [13:12]). Field meanings UNKNOWN.";
        field {
            name = "word";
            desc = "32-bit table word.";
            sw = rw;
            hw = r;
        } word[31:0];
    } TBL_848 @ 0x848;

    reg {
        name = "Table word 0x84C";
        desc = "Word 0x84C of the H.264 register table. PROVENANCE: PROVEN offset; PROVEN stored byte lanes 0123 (lane 0 = bits [7:0]); PROVEN cleared bit extents none seen (lower bound of the fields); constants ORed in: none; written by InitRegConfigParam (1 stores).  arm-re rediff (2026-11-12): confirmed by the path-sensitive run (1 stores, extents none seen). Field meanings UNKNOWN.";
        field {
            name = "word";
            desc = "32-bit table word.";
            sw = rw;
            hw = r;
        } word[31:0];
    } TBL_84C @ 0x84C;

    reg {
        name = "Word at offset 0x850";
        desc = "Word 0x850 (NEW in the arm-re rediff 2026-11-12). PROVENANCE: PROVEN offset and stored byte lanes 0123, cleared bit extents none seen, written by H264E_DRV_UpdateLowerPowerCfg, H264E_DRV_UpdateRegConfigParam (4 stores) in the path-sensitive static run (conditional paths and indexed loop records folded into the word; some are loop-built or conditional and not individually proven). Meaning UNKNOWN.";
        field {
            name = "word";
            desc = "32-bit word.";
            sw = rw;
            hw = r;
        } word[31:0];
    } TBL_850 @ 0x850;
    reg {
        name = "Word at offset 0x854";
        desc = "Word 0x854 (NEW in the arm-re rediff 2026-11-12). PROVENANCE: PROVEN offset and stored byte lanes 0123, cleared bit extents none seen, written by H264E_DRV_UpdateLowerPowerCfg, H264E_DRV_UpdateRegConfigParam (4 stores) in the path-sensitive static run (conditional paths and indexed loop records folded into the word; some are loop-built or conditional and not individually proven). Meaning UNKNOWN.";
        field {
            name = "word";
            desc = "32-bit word.";
            sw = rw;
            hw = r;
        } word[31:0];
    } TBL_854 @ 0x854;
    reg {
        name = "Word at offset 0x858";
        desc = "Word 0x858 (NEW in the arm-re rediff 2026-11-12). PROVENANCE: PROVEN offset and stored byte lanes 0123, cleared bit extents none seen, written by H264E_DRV_UpdateLowerPowerCfg, H264E_DRV_UpdateRegConfigParam (4 stores) in the path-sensitive static run (conditional paths and indexed loop records folded into the word; some are loop-built or conditional and not individually proven). Meaning UNKNOWN.";
        field {
            name = "word";
            desc = "32-bit word.";
            sw = rw;
            hw = r;
        } word[31:0];
    } TBL_858 @ 0x858;
    reg {
        name = "Word at offset 0x85C";
        desc = "Word 0x85C (NEW in the arm-re rediff 2026-11-12). PROVENANCE: PROVEN offset and stored byte lanes 0123, cleared bit extents none seen, written by H264E_DRV_UpdateLowerPowerCfg, H264E_DRV_UpdateRegConfigParam (4 stores) in the path-sensitive static run (conditional paths and indexed loop records folded into the word; some are loop-built or conditional and not individually proven). Meaning UNKNOWN.";
        field {
            name = "word";
            desc = "32-bit word.";
            sw = rw;
            hw = r;
        } word[31:0];
    } TBL_85C @ 0x85C;
};

`endif
