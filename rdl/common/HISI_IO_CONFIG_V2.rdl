`ifndef HISI_IO_CONFIG_V2_RDL
`define HISI_IO_CONFIG_V2_RDL

regfile eHISI_IO_CONFIG_V2 {
    name = "IO configuration (pin multiplexing and pad control), Hi3518E V20X";
    desc = "
    0x200F0000..0x200F07FF: `muxctrl_regN` pin multiplexing control registers (one per pin, 66 registers; the field value selects the pin function, value 0 is the reset default and usually a GPIO or the primary function, see each register).
    0x200F0800..: `PADCTRL_REGn` pad control registers (slew rate, drive strength, Schmitt trigger, pull-up/down; 78 registers).
    Several pins (BOOTROM_SEL on MDCK, BOOT_SEL on EPHY_RST, SFC_DEVICE_MODE on SHUTTER_TRIG, SFC_EMMC_BOOT_MODE on FLASH_TRIG) double as boot strap inputs sampled at power-on (DS 1.3).
    Data sheet Hi3518E V20X/Hi3516C V200 issue 02, 2.3 (pin multiplexing) and 2.6 (pad control). The Hi3516C V200 part of the same data sheet has a different pin list.
    ";

    reg {
        name = "Multiplexing control register for the SENSOR_CLK pin";
        desc = "muxctrl_reg0 is a multiplexing control register for the SENSOR_CLK pin.

Data sheet 2.3.2 muxctrl_reg0 (offset 0x0, printed page 2-43, `hi3518ev200-datasheet.txt` line 3526).";

        enum muxctrl_reg0_muxctrl_reg0_enum {
            GPIO0_4 = 0 { name = "Gpio0 4"; desc = "GPIO0_4"; };
            SENSOR_CLK = 1 { name = "Sensor Clk"; desc = "SENSOR_CLK"; };
        };

        field {
            name = "muxctrl_reg0";
            desc = "Multiplexing control for the SENSOR_CLK pin";
            sw = rw;
            hw = r;
            encode = muxctrl_reg0_muxctrl_reg0_enum;
            reset = 0x0;
        } muxctrl_reg0[0:0];
    } muxctrl_reg0 @ 0x0;

    reg {
        name = "Multiplexing control register for the SENSOR_RSTN pin";
        desc = "muxctrl_reg1 is a multiplexing control register for the SENSOR_RSTN pin.

Data sheet 2.3.2 muxctrl_reg1 (offset 0x4, printed page 2-44, `hi3518ev200-datasheet.txt` line 3561).";

        enum muxctrl_reg1_muxctrl_reg1_enum {
            SENSOR_RSTN = 0 { name = "Sensor Rstn"; desc = "SENSOR_RSTN"; };
            GPIO0_5 = 1 { name = "Gpio0 5"; desc = "GPIO0_5"; };
        };

        field {
            name = "muxctrl_reg1";
            desc = "Multiplexing control for the SENSOR_RSTN pin";
            sw = rw;
            hw = r;
            encode = muxctrl_reg1_muxctrl_reg1_enum;
            reset = 0x0;
        } muxctrl_reg1[0:0];
    } muxctrl_reg1 @ 0x4;

    reg {
        name = "Multiplexing control register for the FLASH_TRIG pin";
        desc = "muxctrl_reg2 is a multiplexing control register for the FLASH_TRIG pin.

Data sheet 2.3.2 muxctrl_reg2 (offset 0x8, printed page 2-44, `hi3518ev200-datasheet.txt` line 3589).";

        enum muxctrl_reg2_muxctrl_reg2_enum {
            GPIO0_6 = 0 { name = "Gpio0 6"; desc = "GPIO0_6"; };
            FLASH_TRIG = 1 { name = "Flash Trig"; desc = "FLASH_TRIG"; };
            SFC_EMMC_BOOT = 2 { name = "Sfc Emmc Boot"; desc = "SFC_EMMC_BOOT_MODE"; };
            SPI1_CSN1 = 3 { name = "Spi1 Csn1"; desc = "SPI1_CSN1"; };
            VI_VS_BT1120 = 4 { name = "Vi Vs Bt1120"; desc = "VI_VS_BT1120 Other values: reserved"; };
        };

        field {
            name = "muxctrl_reg2";
            desc = "Multiplexing control for the FLASH_TRIG pin";
            sw = rw;
            hw = r;
            encode = muxctrl_reg2_muxctrl_reg2_enum;
            reset = 0x0;
        } muxctrl_reg2[2:0];
    } muxctrl_reg2 @ 0x8;

    reg {
        name = "Multiplexing control register for the SHUTTER_TRIG pin";
        desc = "muxctrl_reg3 is a multiplexing control register for the SHUTTER_TRIG pin.

Data sheet 2.3.2 muxctrl_reg3 (offset 0xC, printed page 2-45, `hi3518ev200-datasheet.txt` line 3630).";

        enum muxctrl_reg3_muxctrl_reg3_enum {
            GPIO0_7 = 0 { name = "Gpio0 7"; desc = "GPIO0_7"; };
            SHUTTER_TRIG = 1 { name = "Shutter Trig"; desc = "SHUTTER_TRIG"; };
            SFC_DEVICE_MODE = 2 { name = "Sfc Device Mode"; desc = "SFC_DEVICE_MODE"; };
            VI_HS_BT1120 = 4 { name = "Vi Hs Bt1120"; desc = "VI_HS_BT1120 Other values: reserved"; };
        };

        field {
            name = "muxctrl_reg3";
            desc = "Multiplexing control for the SHUTTER_TRIG pin";
            sw = rw;
            hw = r;
            encode = muxctrl_reg3_muxctrl_reg3_enum;
            reset = 0x0;
        } muxctrl_reg3[2:0];
    } muxctrl_reg3 @ 0xC;

    reg {
        name = "Multiplexing control register for the RMII_CLK pin";
        desc = "muxctrl_reg4 is a multiplexing control register for the RMII_CLK pin.

Data sheet 2.3.2 muxctrl_reg4 (offset 0x10, printed page 2-45, `hi3518ev200-datasheet.txt` line 3661).";

        enum muxctrl_reg4_muxctrl_reg4_enum {
            GPIO2_0 = 0 { name = "Gpio2 0"; desc = "GPIO2_0"; };
            RMII_CLK = 1 { name = "Rmii Clk"; desc = "RMII_CLK"; };
        };

        field {
            name = "muxctrl_reg4";
            desc = "Multiplexing control for the RMII_CLK pin";
            sw = rw;
            hw = r;
            encode = muxctrl_reg4_muxctrl_reg4_enum;
            reset = 0x0;
        } muxctrl_reg4[2:0];
    } muxctrl_reg4 @ 0x10;

    reg {
        name = "Multiplexing control register for the RMII_TX_EN pin";
        desc = "muxctrl_reg5 is a multiplexing control register for the RMII_TX_EN pin.

Data sheet 2.3.2 muxctrl_reg5 (offset 0x14, printed page 2-46, `hi3518ev200-datasheet.txt` line 3702).";

        enum muxctrl_reg5_muxctrl_reg5_enum {
            GPIO2_1 = 0 { name = "Gpio2 1"; desc = "GPIO2_1"; };
            RMII_TX_EN = 1 { name = "Rmii Tx En"; desc = "RMII_TX_EN"; };
            VO_VS = 3 { name = "Vo Vs"; desc = "VO_VS"; };
            SDIO1_CARD_DETECT = 4 { name = "Sdio1 Card Detect"; desc = "SDIO1_CARD_DETECT Other values: reserved"; };
        };

        field {
            name = "muxctrl_reg5";
            desc = "Multiplexing control for the RMII_TX_EN pin";
            sw = rw;
            hw = r;
            encode = muxctrl_reg5_muxctrl_reg5_enum;
            reset = 0x0;
        } muxctrl_reg5[2:0];
    } muxctrl_reg5 @ 0x14;

    reg {
        name = "Multiplexing control register for the RMII_TXD0 pin";
        desc = "muxctrl_reg6 is a multiplexing control register for the RMII_TXD0 pin.

Data sheet 2.3.2 muxctrl_reg6 (offset 0x18, printed page 2-46, `hi3518ev200-datasheet.txt` line 3733).";

        enum muxctrl_reg6_muxctrl_reg6_enum {
            GPIO2_2 = 0 { name = "Gpio2 2"; desc = "GPIO2_2"; };
            RMII_TXD0 = 1 { name = "Rmii Txd0"; desc = "RMII_TXD0"; };
            VO_DATA5 = 3 { name = "Vo Data5"; desc = "VO_DATA5"; };
            SDIO1_CWPR_OTHER = 4 { name = "Sdio1 Cwpr Other"; desc = "SDIO1_CWPR Other values: reserved"; };
        };

        field {
            name = "muxctrl_reg6";
            desc = "Multiplexing control for the RMII_TXD0 pin";
            sw = rw;
            hw = r;
            encode = muxctrl_reg6_muxctrl_reg6_enum;
            reset = 0x0;
        } muxctrl_reg6[2:0];
    } muxctrl_reg6 @ 0x18;

    reg {
        name = "Multiplexing control register for the RMII_TXD1 pin";
        desc = "muxctrl_reg7 is a multiplexing control register for the RMII_TXD1 pin.

Data sheet 2.3.2 muxctrl_reg7 (offset 0x1C, printed page 2-47, `hi3518ev200-datasheet.txt` line 3774).";

        enum muxctrl_reg7_muxctrl_reg7_enum {
            GPIO2_3 = 0 { name = "Gpio2 3"; desc = "GPIO2_3"; };
            RMII_TXD1 = 1 { name = "Rmii Txd1"; desc = "RMII_TXD1"; };
            VO_DE = 3 { name = "Vo De"; desc = "VO_DE"; };
            SDIO1_CDATA1_OTHER = 4 { name = "Sdio1 Cdata1 Other"; desc = "SDIO1_CDATA1 Other values: reserved"; };
        };

        field {
            name = "muxctrl_reg7";
            desc = "Multiplexing control for the RMII_TXD1 pin";
            sw = rw;
            hw = r;
            encode = muxctrl_reg7_muxctrl_reg7_enum;
            reset = 0x0;
        } muxctrl_reg7[2:0];
    } muxctrl_reg7 @ 0x1C;

    reg {
        name = "Multiplexing control register for the RMII_RX_DV pin";
        desc = "muxctrl_reg8 is a multiplexing control register for the RMII_RX_DV pin.

Data sheet 2.3.2 muxctrl_reg8 (offset 0x20, printed page 2-47, `hi3518ev200-datasheet.txt` line 3806).";

        enum muxctrl_reg8_muxctrl_reg8_enum {
            GPIO2_4 = 0 { name = "Gpio2 4"; desc = "GPIO2_4"; };
            RMII_RX_DV = 1 { name = "Rmii Rx Dv"; desc = "RMII_RX_DV"; };
            VO_DATA7 = 3 { name = "Vo Data7"; desc = "VO_DATA7"; };
            SDIO1_CDATA0_OTHER = 4 { name = "Sdio1 Cdata0 Other"; desc = "SDIO1_CDATA0 Other values: reserved"; };
        };

        field {
            name = "muxctrl_reg8";
            desc = "Multiplexing control for the RMII_RX_DV pin";
            sw = rw;
            hw = r;
            encode = muxctrl_reg8_muxctrl_reg8_enum;
            reset = 0x0;
        } muxctrl_reg8[2:0];
    } muxctrl_reg8 @ 0x20;

    reg {
        name = "Multiplexing control register for the RMII_RXD0 pin";
        desc = "muxctrl_reg9 is a multiplexing control register for the RMII_RXD0 pin.

Data sheet 2.3.2 muxctrl_reg9 (offset 0x24, printed page 2-48, `hi3518ev200-datasheet.txt` line 3844).";

        enum muxctrl_reg9_muxctrl_reg9_enum {
            GPIO2_5 = 0 { name = "Gpio2 5"; desc = "GPIO2_5"; };
            RMII_RXD0 = 1 { name = "Rmii Rxd0"; desc = "RMII_RXD0"; };
            VO_DATA2 = 3 { name = "Vo Data2"; desc = "VO_DATA2"; };
            SDIO1_CDATA3_OTHER = 4 { name = "Sdio1 Cdata3 Other"; desc = "SDIO1_CDATA3 Other values: reserved"; };
        };

        field {
            name = "muxctrl_reg9";
            desc = "Multiplexing control for the RMII_RXD0 pin";
            sw = rw;
            hw = r;
            encode = muxctrl_reg9_muxctrl_reg9_enum;
            reset = 0x0;
        } muxctrl_reg9[2:0];
    } muxctrl_reg9 @ 0x24;

    reg {
        name = "Multiplexing control register for the RMII_RXD1 pin";
        desc = "muxctrl_reg10 is a multiplexing control register for the RMII_RXD1 pin.

Data sheet 2.3.2 muxctrl_reg10 (offset 0x28, printed page 2-49, `hi3518ev200-datasheet.txt` line 3885).";

        enum muxctrl_reg10_muxctrl_reg10_enum {
            GPIO2_6 = 0 { name = "Gpio2 6"; desc = "GPIO2_6"; };
            RMII_RXD1 = 1 { name = "Rmii Rxd1"; desc = "RMII_RXD1"; };
            VO_DATA3 = 3 { name = "Vo Data3"; desc = "VO_DATA3"; };
            SDIO1_CCMD_OTHER = 4 { name = "Sdio1 Ccmd Other"; desc = "SDIO1_CCMD Other values: reserved"; };
        };

        field {
            name = "muxctrl_reg10";
            desc = "Multiplexing control for the RMII_RXD1 pin";
            sw = rw;
            hw = r;
            encode = muxctrl_reg10_muxctrl_reg10_enum;
            reset = 0x0;
        } muxctrl_reg10[2:0];
    } muxctrl_reg10 @ 0x28;

    reg {
        name = "Multiplexing control register for the EPHY_RST pin";
        desc = "muxctrl_reg11 is a multiplexing control register for the EPHY_RST pin.

Data sheet 2.3.2 muxctrl_reg11 (offset 0x2C, printed page 2-49, `hi3518ev200-datasheet.txt` line 3916).";

        enum muxctrl_reg11_muxctrl_reg11_enum {
            GPIO2_7 = 0 { name = "Gpio2 7"; desc = "GPIO2_7"; };
            EPHY_RST = 1 { name = "Ephy Rst"; desc = "EPHY_RST"; };
            BOOT_SEL = 2 { name = "Boot Sel"; desc = "BOOT_SEL"; };
            VO_HS = 3 { name = "Vo Hs"; desc = "VO_HS"; };
            SDIO1_CARD_POWER = 4 { name = "Sdio1 Card Power"; desc = "SDIO1_CARD_POWER_EN Other values: reserved"; };
        };

        field {
            name = "muxctrl_reg11";
            desc = "Multiplexing control for the EPHY_RST pin";
            sw = rw;
            hw = r;
            encode = muxctrl_reg11_muxctrl_reg11_enum;
            reset = 0x0;
        } muxctrl_reg11[2:0];
    } muxctrl_reg11 @ 0x2C;

    reg {
        name = "Multiplexing control register for the SPI1_CSN1 pin";
        desc = "muxctrl_reg12 is a multiplexing control register for the SPI1_CSN1 pin.

Data sheet 2.3.2 muxctrl_reg12 (offset 0x30, printed page 2-50, `hi3518ev200-datasheet.txt` line 3954).";

        enum muxctrl_reg12_muxctrl_reg12_enum {
            GPIO0_3 = 0 { name = "Gpio0 3"; desc = "GPIO0_3"; };
            SPI1_CSN1 = 1 { name = "Spi1 Csn1"; desc = "SPI1_CSN1"; };
            VO_DATA0_OTHER = 3 { name = "Vo Data0 Other"; desc = "VO_DATA0 Other values: reserved"; };
        };

        field {
            name = "muxctrl_reg12";
            desc = "Multiplexing control for the SPI1_CSN1 pin";
            sw = rw;
            hw = r;
            encode = muxctrl_reg12_muxctrl_reg12_enum;
            reset = 0x0;
        } muxctrl_reg12[1:0];
    } muxctrl_reg12 @ 0x30;

    reg {
        name = "Multiplexing control register for the EPHY_CLK pin";
        desc = "muxctrl_reg13 is a multiplexing control register for the EPHY_CLK pin.

Data sheet 2.3.2 muxctrl_reg13 (offset 0x34, printed page 2-50, `hi3518ev200-datasheet.txt` line 3983).";

        enum muxctrl_reg13_muxctrl_reg13_enum {
            GPIO3_0 = 0 { name = "Gpio3 0"; desc = "GPIO3_0"; };
            EPHY_CLK = 1 { name = "Ephy Clk"; desc = "EPHY_CLK"; };
            VO_DATA1 = 3 { name = "Vo Data1"; desc = "VO_DATA1"; };
            SDIO1_CDATA2_OTHER = 4 { name = "Sdio1 Cdata2 Other"; desc = "SDIO1_CDATA2 Other values: reserved"; };
        };

        field {
            name = "muxctrl_reg13";
            desc = "Multiplexing control for the EPHY_CLK pin";
            sw = rw;
            hw = r;
            encode = muxctrl_reg13_muxctrl_reg13_enum;
            reset = 0x0;
        } muxctrl_reg13[2:0];
    } muxctrl_reg13 @ 0x34;

    reg {
        name = "Multiplexing control register for the MDCK pin";
        desc = "muxctrl_reg14 is a multiplexing control register for the MDCK pin.

Data sheet 2.3.2 muxctrl_reg14 (offset 0x38, printed page 2-51, `hi3518ev200-datasheet.txt` line 4023).";

        enum muxctrl_reg14_muxctrl_reg14_enum {
            GPIO3_1 = 0 { name = "Gpio3 1"; desc = "GPIO3_1"; };
            MDCK = 1 { name = "Mdck"; desc = "MDCK"; };
            BOOTROM_SEL = 2 { name = "Bootrom Sel"; desc = "BOOTROM_SEL"; };
            VO_DATA6 = 3 { name = "Vo Data6"; desc = "VO_DATA6"; };
        };

        field {
            name = "muxctrl_reg14";
            desc = "Multiplexing control for the MDCK pin";
            sw = rw;
            hw = r;
            encode = muxctrl_reg14_muxctrl_reg14_enum;
            reset = 0x0;
        } muxctrl_reg14[1:0];
    } muxctrl_reg14 @ 0x38;

    reg {
        name = "Multiplexing control register for the MDIO pin";
        desc = "muxctrl_reg15 is a multiplexing control register for the MDIO pin.

Data sheet 2.3.2 muxctrl_reg15 (offset 0x3C, printed page 2-51, `hi3518ev200-datasheet.txt` line 4052).";

        enum muxctrl_reg15_muxctrl_reg15_enum {
            GPIO3_2 = 0 { name = "Gpio3 2"; desc = "GPIO3_2"; };
            MDIO = 1 { name = "Mdio"; desc = "MDIO"; };
            VO_DATA4 = 3 { name = "Vo Data4"; desc = "VO_DATA4"; };
        };

        field {
            name = "muxctrl_reg15";
            desc = "Multiplexing control for the MDIO pin";
            sw = rw;
            hw = r;
            encode = muxctrl_reg15_muxctrl_reg15_enum;
            reset = 0x0;
        } muxctrl_reg15[1:0];
    } muxctrl_reg15 @ 0x3C;

    reg {
        name = "Multiplexing control register for the SPI0_SCLK pin";
        desc = "muxctrl_reg16 is a multiplexing control register for the SPI0_SCLK pin.

Data sheet 2.3.2 muxctrl_reg16 (offset 0x40, printed page 2-52, `hi3518ev200-datasheet.txt` line 4092).";

        enum muxctrl_reg16_muxctrl_reg16_enum {
            GPIO3_3 = 0 { name = "Gpio3 3"; desc = "GPIO3_3"; };
            SPI0_SCLK = 1 { name = "Spi0 Sclk"; desc = "SPI0_SCLK"; };
            I2C0_SCL_OTHER = 2 { name = "I2C0 Scl Other"; desc = "I2C0_SCL Other values: reserved"; };
        };

        field {
            name = "muxctrl_reg16";
            desc = "Multiplexing control for the SPI0_SCLK pin";
            sw = rw;
            hw = r;
            encode = muxctrl_reg16_muxctrl_reg16_enum;
            reset = 0x0;
        } muxctrl_reg16[1:0];
    } muxctrl_reg16 @ 0x40;

    reg {
        name = "Multiplexing control register for the SPI0_SDO pin";
        desc = "muxctrl_reg17 is a multiplexing control register for the SPI0_SDO pin.

Data sheet 2.3.2 muxctrl_reg17 (offset 0x44, printed page 2-52, `hi3518ev200-datasheet.txt` line 4121).";

        enum muxctrl_reg17_muxctrl_reg17_enum {
            GPIO3_4 = 0 { name = "Gpio3 4"; desc = "GPIO3_4"; };
            SPI0_SDO = 1 { name = "Spi0 Sdo"; desc = "SPI0_SDO"; };
        };

        field {
            name = "muxctrl_reg17";
            desc = "Multiplexing control for the SPI0_SDO pin";
            sw = rw;
            hw = r;
            encode = muxctrl_reg17_muxctrl_reg17_enum;
            reset = 0x0;
        } muxctrl_reg17[1:0];
    } muxctrl_reg17 @ 0x44;

    reg {
        name = "Multiplexing control register for the SPI0_SDI pin";
        desc = "muxctrl_reg18 is a multiplexing control register for the SPI0_SDI pin.

Data sheet 2.3.2 muxctrl_reg18 (offset 0x48, printed page 2-53, `hi3518ev200-datasheet.txt` line 4160).";

        enum muxctrl_reg18_muxctrl_reg18_enum {
            GPIO3_5 = 0 { name = "Gpio3 5"; desc = "GPIO3_5"; };
            SPI0_SDI = 1 { name = "Spi0 Sdi"; desc = "SPI0_SDI"; };
        };

        field {
            name = "muxctrl_reg18";
            desc = "Multiplexing control for the SPI0_SDI pin";
            sw = rw;
            hw = r;
            encode = muxctrl_reg18_muxctrl_reg18_enum;
            reset = 0x0;
        } muxctrl_reg18[0:0];
    } muxctrl_reg18 @ 0x48;

    reg {
        name = "Multiplexing control register for the SPI0_CSN pin";
        desc = "muxctrl_reg19 is a multiplexing control register for the SPI0_CSN pin.

Data sheet 2.3.2 muxctrl_reg19 (offset 0x4C, printed page 2-53, `hi3518ev200-datasheet.txt` line 4187).";

        enum muxctrl_reg19_muxctrl_reg19_enum {
            GPIO3_6 = 0 { name = "Gpio3 6"; desc = "GPIO3_6"; };
            SPI0_CSN = 1 { name = "Spi0 Csn"; desc = "SPI0_CSN"; };
        };

        field {
            name = "muxctrl_reg19";
            desc = "Multiplexing control for the SPI0_CSN pin";
            sw = rw;
            hw = r;
            encode = muxctrl_reg19_muxctrl_reg19_enum;
            reset = 0x0;
        } muxctrl_reg19[0:0];
    } muxctrl_reg19 @ 0x4C;

    reg {
        name = "Multiplexing control register for the SPI1_SCLK pin";
        desc = "muxctrl_reg20 is a multiplexing control register for the SPI1_SCLK pin.

Data sheet 2.3.2 muxctrl_reg20 (offset 0x50, printed page 2-54, `hi3518ev200-datasheet.txt` line 4224).";

        enum muxctrl_reg20_muxctrl_reg20_enum {
            GPIO3_7 = 0 { name = "Gpio3 7"; desc = "GPIO3_7"; };
            SPI1_SCLK = 1 { name = "Spi1 Sclk"; desc = "SPI1_SCLK"; };
            I2C1_SCL_OTHER = 2 { name = "I2C1 Scl Other"; desc = "I2C1_SCL Other values: reserved"; };
        };

        field {
            name = "muxctrl_reg20";
            desc = "Multiplexing control for the SPI1_SCLK pin";
            sw = rw;
            hw = r;
            encode = muxctrl_reg20_muxctrl_reg20_enum;
            reset = 0x0;
        } muxctrl_reg20[1:0];
    } muxctrl_reg20 @ 0x50;

    reg {
        name = "Multiplexing control register for the SPI1_SDO pin";
        desc = "muxctrl_reg21 is a multiplexing control register for the SPI1_SDO pin.

Data sheet 2.3.2 muxctrl_reg21 (offset 0x54, printed page 2-54, `hi3518ev200-datasheet.txt` line 4253).";

        enum muxctrl_reg21_muxctrl_reg21_enum {
            GPIO4_0 = 0 { name = "Gpio4 0"; desc = "GPIO4_0"; };
            SPI1_SDO = 1 { name = "Spi1 Sdo"; desc = "SPI1_SDO"; };
            I2C1_SDA = 2 { name = "I2C1 Sda"; desc = "I2C1_SDA"; };
        };

        field {
            name = "muxctrl_reg21";
            desc = "Multiplexing control for the SPI1_SDO pin";
            sw = rw;
            hw = r;
            encode = muxctrl_reg21_muxctrl_reg21_enum;
            reset = 0x0;
        } muxctrl_reg21[1:0];
    } muxctrl_reg21 @ 0x54;

    reg {
        name = "Multiplexing control register for the SPI1_SDI pin";
        desc = "muxctrl_reg22 is a multiplexing control register for the SPI1_SDI pin.

Data sheet 2.3.2 muxctrl_reg22 (offset 0x58, printed page 2-55, `hi3518ev200-datasheet.txt` line 4293).";

        enum muxctrl_reg22_muxctrl_reg22_enum {
            GPIO4_1 = 0 { name = "Gpio4 1"; desc = "GPIO4_1"; };
            SPI1_SDI = 1 { name = "Spi1 Sdi"; desc = "SPI1_SDI"; };
        };

        field {
            name = "muxctrl_reg22";
            desc = "Multiplexing control for the SPI1_SDI pin";
            sw = rw;
            hw = r;
            encode = muxctrl_reg22_muxctrl_reg22_enum;
            reset = 0x0;
        } muxctrl_reg22[0:0];
    } muxctrl_reg22 @ 0x58;

    reg {
        name = "Multiplexing control register for the SPI1_CSN0 pin";
        desc = "muxctrl_reg23 is a multiplexing control register for the SPI1_CSN0 pin.

Data sheet 2.3.2 muxctrl_reg23 (offset 0x5C, printed page 2-55, `hi3518ev200-datasheet.txt` line 4321).";

        enum muxctrl_reg23_muxctrl_reg23_enum {
            GPIO4_2 = 0 { name = "Gpio4 2"; desc = "GPIO4_2"; };
            SPI1_CSN0 = 1 { name = "Spi1 Csn0"; desc = "SPI1_CSN0"; };
        };

        field {
            name = "muxctrl_reg23";
            desc = "Multiplexing control for the SPI1_CSN0 pin";
            sw = rw;
            hw = r;
            encode = muxctrl_reg23_muxctrl_reg23_enum;
            reset = 0x0;
        } muxctrl_reg23[0:0];
    } muxctrl_reg23 @ 0x5C;

    reg {
        name = "Multiplexing control register for the I2C2_SDA pin";
        desc = "muxctrl_reg24 is a multiplexing control register for the I2C2_SDA pin.

Data sheet 2.3.2 muxctrl_reg24 (offset 0x60, printed page 2-56, `hi3518ev200-datasheet.txt` line 4357).";

        enum muxctrl_reg24_muxctrl_reg24_enum {
            GPIO4_3 = 0 { name = "Gpio4 3"; desc = "GPIO4_3"; };
            I2C2_SDA = 1 { name = "I2C2 Sda"; desc = "I2C2_SDA"; };
        };

        field {
            name = "muxctrl_reg24";
            desc = "Multiplexing control for the I2C2_SDA pin";
            sw = rw;
            hw = r;
            encode = muxctrl_reg24_muxctrl_reg24_enum;
            reset = 0x0;
        } muxctrl_reg24[0:0];
    } muxctrl_reg24 @ 0x60;

    reg {
        name = "Multiplexing control register for the I2C2_SCL pin";
        desc = "muxctrl_reg25 is a multiplexing control register for the I2C2_SCL pin.

Data sheet 2.3.2 muxctrl_reg25 (offset 0x64, printed page 2-56, `hi3518ev200-datasheet.txt` line 4384).";

        enum muxctrl_reg25_muxctrl_reg25_enum {
            GPIO4_4 = 0 { name = "Gpio4 4"; desc = "GPIO4_4"; };
            I2C2_SCL = 1 { name = "I2C2 Scl"; desc = "I2C2_SCL"; };
        };

        field {
            name = "muxctrl_reg25";
            desc = "Multiplexing control for the I2C2_SCL pin";
            sw = rw;
            hw = r;
            encode = muxctrl_reg25_muxctrl_reg25_enum;
            reset = 0x0;
        } muxctrl_reg25[0:0];
    } muxctrl_reg25 @ 0x64;

    reg {
        name = "Multiplexing control register for the USB_OVRCUR pin";
        desc = "muxctrl_reg26 is a multiplexing control register for the USB_OVRCUR pin.

Data sheet 2.3.2 muxctrl_reg26 (offset 0x68, printed page 2-57, `hi3518ev200-datasheet.txt` line 4419).";

        enum muxctrl_reg26_muxctrl_reg26_enum {
            GPIO4_5 = 0 { name = "Gpio4 5"; desc = "GPIO4_5"; };
            USB_OVRCUR = 1 { name = "Usb Ovrcur"; desc = "USB_OVRCUR"; };
        };

        field {
            name = "muxctrl_reg26";
            desc = "Multiplexing control for the USB_OVRCUR pin";
            sw = rw;
            hw = r;
            encode = muxctrl_reg26_muxctrl_reg26_enum;
            reset = 0x0;
        } muxctrl_reg26[0:0];
    } muxctrl_reg26 @ 0x68;

    reg {
        name = "Multiplexing control register for the USB_PWREN pin";
        desc = "muxctrl_reg27 is a multiplexing control register for the USB_PWREN pin.

Data sheet 2.3.2 muxctrl_reg27 (offset 0x6C, printed page 2-57, `hi3518ev200-datasheet.txt` line 4446).";

        enum muxctrl_reg27_muxctrl_reg27_enum {
            GPIO4_6 = 0 { name = "Gpio4 6"; desc = "GPIO4_6"; };
            USB_PWREN = 1 { name = "Usb Pwren"; desc = "USB_PWREN"; };
        };

        field {
            name = "muxctrl_reg27";
            desc = "Multiplexing control for the USB_PWREN pin";
            sw = rw;
            hw = r;
            encode = muxctrl_reg27_muxctrl_reg27_enum;
            reset = 0x0;
        } muxctrl_reg27[0:0];
    } muxctrl_reg27 @ 0x6C;

    reg {
        name = "Multiplexing control register for the GPIO0_0 pin";
        desc = "muxctrl_reg28 is a multiplexing control register for the GPIO0_0 pin.

Data sheet 2.3.2 muxctrl_reg28 (offset 0x70, printed page 2-58, `hi3518ev200-datasheet.txt` line 4480).";

        enum muxctrl_reg28_muxctrl_reg28_enum {
            GPIO0_0 = 0 { name = "Gpio0 0"; desc = "GPIO0_0"; };
            IR = 1 { name = "Ir"; desc = "IR_IN"; };
            TEMPER_DQ_OTHER = 2 { name = "Temper Dq Other"; desc = "TEMPER_DQ Other values: reserved"; };
        };

        field {
            name = "muxctrl_reg28";
            desc = "Multiplexing control for the GPIO0_0 pin";
            sw = rw;
            hw = r;
            encode = muxctrl_reg28_muxctrl_reg28_enum;
            reset = 0x0;
        } muxctrl_reg28[1:0];
    } muxctrl_reg28 @ 0x70;

    reg {
        name = "Multiplexing control register for the GPIO0_1 pin";
        desc = "muxctrl_reg29 is a multiplexing control register for the GPIO0_1 pin.

Data sheet 2.3.2 muxctrl_reg29 (offset 0x74, printed page 2-58, `hi3518ev200-datasheet.txt` line 4509).";

        enum muxctrl_reg29_muxctrl_reg29_enum {
            GPIO0_1 = 0 { name = "Gpio0 1"; desc = "GPIO0_1"; };
            TEMPER_DQ_OTHER = 2 { name = "Temper Dq Other"; desc = "TEMPER_DQ Other values: reserved"; };
        };

        field {
            name = "muxctrl_reg29";
            desc = "Multiplexing control for the GPIO0_1 pin";
            sw = rw;
            hw = r;
            encode = muxctrl_reg29_muxctrl_reg29_enum;
            reset = 0x0;
        } muxctrl_reg29[1:0];
    } muxctrl_reg29 @ 0x74;

    reg {
        name = "Multiplexing control register for the GPIO0_2 pin";
        desc = "muxctrl_reg30 is a multiplexing control register for the GPIO0_2 pin.

Data sheet 2.3.2 muxctrl_reg30 (offset 0x78, printed page 2-59, `hi3518ev200-datasheet.txt` line 4545).";

        enum muxctrl_reg30_muxctrl_reg30_enum {
            GPIO0_2 = 0 { name = "Gpio0 2"; desc = "GPIO0_2"; };
            TEMPER_DQ_OTHER = 2 { name = "Temper Dq Other"; desc = "TEMPER_DQ Other values: reserved"; };
        };

        field {
            name = "muxctrl_reg30";
            desc = "Multiplexing control for the GPIO0_2 pin";
            sw = rw;
            hw = r;
            encode = muxctrl_reg30_muxctrl_reg30_enum;
            reset = 0x0;
        } muxctrl_reg30[1:0];
    } muxctrl_reg30 @ 0x78;

    reg {
        name = "Multiplexing control register for the GPIO1_0 pin";
        desc = "muxctrl_reg31 is a multiplexing control register for the GPIO1_0 pin.

Data sheet 2.3.2 muxctrl_reg31 (offset 0x7C, printed page 2-59, `hi3518ev200-datasheet.txt` line 4574).";

        enum muxctrl_reg31_muxctrl_reg31_enum {
            GPIO1_0 = 0 { name = "Gpio1 0"; desc = "GPIO1_0"; };
            VI_DATA13 = 1 { name = "Vi Data13"; desc = "VI_DATA13"; };
            I2S_BCLK_TX = 3 { name = "I2S Bclk Tx"; desc = "I2S_BCLK_TX"; };
            PWM0_OTHER_VALUES = 4 { name = "Pwm0 Other Values"; desc = "PWM0 Other values: reserved"; };
        };

        field {
            name = "muxctrl_reg31";
            desc = "Multiplexing control for the GPIO1_0 pin";
            sw = rw;
            hw = r;
            encode = muxctrl_reg31_muxctrl_reg31_enum;
            reset = 0x0;
        } muxctrl_reg31[2:0];
    } muxctrl_reg31 @ 0x7C;

    reg {
        name = "Multiplexing control register for the GPIO1_1 pin";
        desc = "muxctrl_reg32 is a multiplexing control register for the GPIO1_1 pin.

Data sheet 2.3.2 muxctrl_reg32 (offset 0x80, printed page 2-60, `hi3518ev200-datasheet.txt` line 4612).";

        enum muxctrl_reg32_muxctrl_reg32_enum {
            GPIO1_1 = 0 { name = "Gpio1 1"; desc = "GPIO1_1"; };
            VI_DATA10 = 1 { name = "Vi Data10"; desc = "VI_DATA10"; };
            I2S_SD_TX = 3 { name = "I2S Sd Tx"; desc = "I2S_SD_TX"; };
            UART1_TXD_OTHER = 4 { name = "Uart1 Txd Other"; desc = "UART1_TXD Other values: reserved"; };
        };

        field {
            name = "muxctrl_reg32";
            desc = "Multiplexing control for the GPIO1_1 pin";
            sw = rw;
            hw = r;
            encode = muxctrl_reg32_muxctrl_reg32_enum;
            reset = 0x0;
        } muxctrl_reg32[2:0];
    } muxctrl_reg32 @ 0x80;

    reg {
        name = "Multiplexing control register for the GPIO1_2 pin";
        desc = "muxctrl_reg33 is a multiplexing control register for the GPIO1_2 pin.

Data sheet 2.3.2 muxctrl_reg33 (offset 0x84, printed page 2-60, `hi3518ev200-datasheet.txt` line 4643).";

        enum muxctrl_reg33_muxctrl_reg33_enum {
            GPIO1_2 = 0 { name = "Gpio1 2"; desc = "GPIO1_2"; };
            VI_DATA12 = 1 { name = "Vi Data12"; desc = "VI_DATA12"; };
            I2S_MCLK = 3 { name = "I2S Mclk"; desc = "I2S_MCLK"; };
            UART1_CTSN = 4 { name = "Uart1 Ctsn"; desc = "UART1_CTSN"; };
        };

        field {
            name = "muxctrl_reg33";
            desc = "Multiplexing control for the GPIO1_2 pin";
            sw = rw;
            hw = r;
            encode = muxctrl_reg33_muxctrl_reg33_enum;
            reset = 0x0;
        } muxctrl_reg33[2:0];
    } muxctrl_reg33 @ 0x84;

    reg {
        name = "Multiplexing control register for the GPIO1_3 pin";
        desc = "muxctrl_reg34 is a multiplexing control register for the GPIO1_3 pin.

Data sheet 2.3.2 muxctrl_reg34 (offset 0x88, printed page 2-61, `hi3518ev200-datasheet.txt` line 4683).";

        enum muxctrl_reg34_muxctrl_reg34_enum {
            GPIO1_3 = 0 { name = "Gpio1 3"; desc = "GPIO1_3"; };
            VI_DATA11 = 1 { name = "Vi Data11"; desc = "VI_DATA11"; };
            I2S_WS_TX = 3 { name = "I2S Ws Tx"; desc = "I2S_WS_TX"; };
            UART2_RXD_OTHER = 4 { name = "Uart2 Rxd Other"; desc = "UART2_RXD Other values: reserved"; };
        };

        field {
            name = "muxctrl_reg34";
            desc = "Multiplexing control for the GPIO1_3 pin";
            sw = rw;
            hw = r;
            encode = muxctrl_reg34_muxctrl_reg34_enum;
            reset = 0x0;
        } muxctrl_reg34[2:0];
    } muxctrl_reg34 @ 0x88;

    reg {
        name = "Multiplexing control register for the GPIO1_4 pin";
        desc = "muxctrl_reg35 is a multiplexing control register for the GPIO1_4 pin.

Data sheet 2.3.2 muxctrl_reg35 (offset 0x8C, printed page 2-61, `hi3518ev200-datasheet.txt` line 4714).";

        field {
            name = "muxctrl_reg35";
            desc = "Multiplexing control for the GPIO1_4 pin 000: GPIO1_4";
            sw = rw;
            hw = r;
            reset = 0x0;
        } muxctrl_reg35[2:0];
    } muxctrl_reg35 @ 0x8C;

    reg {
        name = "Multiplexing control register for the GPIO1_5 pin";
        desc = "muxctrl_reg36 is a multiplexing control register for the GPIO1_5 pin.

Data sheet 2.3.2 muxctrl_reg36 (offset 0x90, printed page 2-62, `hi3518ev200-datasheet.txt` line 4756).";

        enum muxctrl_reg36_muxctrl_reg36_enum {
            GPIO1_5 = 0 { name = "Gpio1 5"; desc = "GPIO1_5"; };
            VI_DATA14 = 1 { name = "Vi Data14"; desc = "VI_DATA14"; };
            VI_HS_SEN = 2 { name = "Vi Hs Sen"; desc = "VI_HS_SEN"; };
            I2S_BCLK_RX = 3 { name = "I2S Bclk Rx"; desc = "I2S_BCLK_RX"; };
            UART1_RTSN_OTHER = 4 { name = "Uart1 Rtsn Other"; desc = "UART1_RTSN Other values: reserved"; };
        };

        field {
            name = "muxctrl_reg36";
            desc = "Multiplexing control for the GPIO1_5 pin";
            sw = rw;
            hw = r;
            encode = muxctrl_reg36_muxctrl_reg36_enum;
            reset = 0x0;
        } muxctrl_reg36[2:0];
    } muxctrl_reg36 @ 0x90;

    reg {
        name = "Multiplexing control register for the GPIO1_6 pin";
        desc = "muxctrl_reg37 is a multiplexing control register for the GPIO1_6 pin.

Data sheet 2.3.2 muxctrl_reg37 (offset 0x94, printed page 2-62, `hi3518ev200-datasheet.txt` line 4788).";

        enum muxctrl_reg37_muxctrl_reg37_enum {
            GPIO1_6 = 0 { name = "Gpio1 6"; desc = "GPIO1_6"; };
            VI_DATA9 = 1 { name = "Vi Data9"; desc = "VI_DATA9"; };
            I2S_SD_RX = 3 { name = "I2S Sd Rx"; desc = "I2S_SD_RX"; };
            UART2_TXD_OTHER = 4 { name = "Uart2 Txd Other"; desc = "UART2_TXD Other values: reserved"; };
        };

        field {
            name = "muxctrl_reg37";
            desc = "Multiplexing control for the GPIO1_6 pin";
            sw = rw;
            hw = r;
            encode = muxctrl_reg37_muxctrl_reg37_enum;
            reset = 0x0;
        } muxctrl_reg37[2:0];
    } muxctrl_reg37 @ 0x94;

    reg {
        name = "Multiplexing control register for the SDIO0_CARD_POWER_EN pin";
        desc = "muxctrl_reg38 is a multiplexing control register for the SDIO0_CARD_POWER_EN pin.

Data sheet 2.3.2 muxctrl_reg38 (offset 0x98, printed page 2-63, `hi3518ev200-datasheet.txt` line 4826).";

        enum muxctrl_reg38_muxctrl_reg38_enum {
            GPIO1_7 = 0 { name = "Gpio1 7"; desc = "GPIO1_7"; };
            SDIO0_CARD_POWER = 1 { name = "Sdio0 Card Power"; desc = "SDIO0_CARD_POWER_EN"; };
        };

        field {
            name = "muxctrl_reg38";
            desc = "Multiplexing control for the SDIO0_CARD_POWER_EN pin";
            sw = rw;
            hw = r;
            encode = muxctrl_reg38_muxctrl_reg38_enum;
            reset = 0x0;
        } muxctrl_reg38[0:0];
    } muxctrl_reg38 @ 0x98;

    reg {
        name = "Multiplexing control register for the SDIO0_CARD_DETECT pin";
        desc = "muxctrl_reg39 is a multiplexing control register for the SDIO0_CARD_DETECT pin.

Data sheet 2.3.2 muxctrl_reg39 (offset 0x9C, printed page 2-64, `hi3518ev200-datasheet.txt` line 4864).";

        enum muxctrl_reg39_muxctrl_reg39_enum {
            GPIO4_7 = 0 { name = "Gpio4 7"; desc = "GPIO4_7"; };
            SDIO0_CARD_DETECT = 1 { name = "Sdio0 Card Detect"; desc = "SDIO0_CARD_DETECT"; };
        };

        field {
            name = "muxctrl_reg39";
            desc = "Multiplexing control for the SDIO0_CARD_DETECT pin";
            sw = rw;
            hw = r;
            encode = muxctrl_reg39_muxctrl_reg39_enum;
            reset = 0x0;
        } muxctrl_reg39[0:0];
    } muxctrl_reg39 @ 0x9C;

    reg {
        name = "Multiplexing control register for the SDIO0_CWPR pin";
        desc = "muxctrl_reg40 is a multiplexing control register for the SDIO0_CWPR pin.

Data sheet 2.3.2 muxctrl_reg40 (offset 0xA0, printed page 2-64, `hi3518ev200-datasheet.txt` line 4891).";

        enum muxctrl_reg40_muxctrl_reg40_enum {
            GPIO5_0 = 0 { name = "Gpio5 0"; desc = "GPIO5_0"; };
            SDIO0_CWPR = 1 { name = "Sdio0 Cwpr"; desc = "SDIO0_CWPR"; };
        };

        field {
            name = "muxctrl_reg40";
            desc = "Multiplexing control for the SDIO0_CWPR pin";
            sw = rw;
            hw = r;
            encode = muxctrl_reg40_muxctrl_reg40_enum;
            reset = 0x0;
        } muxctrl_reg40[0:0];
    } muxctrl_reg40 @ 0xA0;

    reg {
        name = "Multiplexing control register for the SDIO0_CCLK_OUT pin";
        desc = "muxctrl_reg41 is a multiplexing control register for the SDIO0_CCLK_OUT pin.

Data sheet 2.3.2 muxctrl_reg41 (offset 0xA4, printed page 2-65, `hi3518ev200-datasheet.txt` line 4928).";

        enum muxctrl_reg41_muxctrl_reg41_enum {
            GPIO5_1 = 0 { name = "Gpio5 1"; desc = "GPIO5_1"; };
            SDIO0_CCLK_OUT = 1 { name = "Sdio0 Cclk Out"; desc = "SDIO0_CCLK_OUT"; };
        };

        field {
            name = "muxctrl_reg41";
            desc = "Multiplexing control for the SDIO0_CCLK_OUT pin";
            sw = rw;
            hw = r;
            encode = muxctrl_reg41_muxctrl_reg41_enum;
            reset = 0x0;
        } muxctrl_reg41[0:0];
    } muxctrl_reg41 @ 0xA4;

    reg {
        name = "Multiplexing control register for the SDIO0_CCMD pin";
        desc = "muxctrl_reg42 is a multiplexing control register for the SDIO0_CCMD pin.

Data sheet 2.3.2 muxctrl_reg42 (offset 0xA8, printed page 2-65, `hi3518ev200-datasheet.txt` line 4955).";

        enum muxctrl_reg42_muxctrl_reg42_enum {
            GPIO5_2 = 0 { name = "Gpio5 2"; desc = "GPIO5_2"; };
            SDIO0_CCMD = 1 { name = "Sdio0 Ccmd"; desc = "SDIO0_CCMD"; };
        };

        field {
            name = "muxctrl_reg42";
            desc = "Multiplexing control for the SDIO0_CCMD pin";
            sw = rw;
            hw = r;
            encode = muxctrl_reg42_muxctrl_reg42_enum;
            reset = 0x0;
        } muxctrl_reg42[0:0];
    } muxctrl_reg42 @ 0xA8;

    reg {
        name = "Multiplexing control register for the SDIO0_CDATA0 pin";
        desc = "muxctrl_reg43 is a multiplexing control register for the SDIO0_CDATA0 pin.

Data sheet 2.3.2 muxctrl_reg43 (offset 0xAC, printed page 2-66, `hi3518ev200-datasheet.txt` line 4992).";

        enum muxctrl_reg43_muxctrl_reg43_enum {
            GPIO5_3 = 0 { name = "Gpio5 3"; desc = "GPIO5_3"; };
            SDIO0_CDATA0 = 1 { name = "Sdio0 Cdata0"; desc = "SDIO0_CDATA0"; };
        };

        field {
            name = "muxctrl_reg43";
            desc = "Multiplexing control for the SDIO0_CDATA0 pin";
            sw = rw;
            hw = r;
            encode = muxctrl_reg43_muxctrl_reg43_enum;
            reset = 0x0;
        } muxctrl_reg43[0:0];
    } muxctrl_reg43 @ 0xAC;

    reg {
        name = "Multiplexing control register for the SDIO0_CDATA1 pin";
        desc = "muxctrl_reg44 is a multiplexing control register for the SDIO0_CDATA1 pin.

Data sheet 2.3.2 muxctrl_reg44 (offset 0xB0, printed page 2-66, `hi3518ev200-datasheet.txt` line 5020).";

        enum muxctrl_reg44_muxctrl_reg44_enum {
            TEST_CLK = 0 { name = "Test Clk"; desc = "TEST_CLK"; };
            SDIO0_CDATA1 = 1 { name = "Sdio0 Cdata1"; desc = "SDIO0_CDATA1"; };
            GPIO5_4_OTHER = 2 { name = "Gpio5 4 Other"; desc = "GPIO5_4 Other values: reserved"; };
        };

        field {
            name = "muxctrl_reg44";
            desc = "Multiplexing control for the SDIO0_CDATA1 pin";
            sw = rw;
            hw = r;
            encode = muxctrl_reg44_muxctrl_reg44_enum;
            reset = 0x0;
        } muxctrl_reg44[1:0];
    } muxctrl_reg44 @ 0xB0;

    reg {
        name = "Multiplexing control register for the SDIO0_CDATA2 pin";
        desc = "muxctrl_reg45 is a multiplexing control register for the SDIO0_CDATA2 pin.

Data sheet 2.3.2 muxctrl_reg45 (offset 0xB4, printed page 2-67, `hi3518ev200-datasheet.txt` line 5057).";

        enum muxctrl_reg45_muxctrl_reg45_enum {
            GPIO5_5 = 0 { name = "Gpio5 5"; desc = "GPIO5_5"; };
            SDIO0_CDATA2 = 1 { name = "Sdio0 Cdata2"; desc = "SDIO0_CDATA2"; };
        };

        field {
            name = "muxctrl_reg45";
            desc = "Multiplexing control for the SDIO0_CDATA2 pin";
            sw = rw;
            hw = r;
            encode = muxctrl_reg45_muxctrl_reg45_enum;
            reset = 0x0;
        } muxctrl_reg45[0:0];
    } muxctrl_reg45 @ 0xB4;

    reg {
        name = "Multiplexing control register for the SDIO0_CDATA3 pin";
        desc = "muxctrl_reg46 is a multiplexing control register for the SDIO0_CDATA3 pin.

Data sheet 2.3.2 muxctrl_reg46 (offset 0xB8, printed page 2-67, `hi3518ev200-datasheet.txt` line 5086).";

        enum muxctrl_reg46_muxctrl_reg46_enum {
            GPIO5_6 = 0 { name = "Gpio5 6"; desc = "GPIO5_6"; };
            SDIO0_CDATA3 = 1 { name = "Sdio0 Cdata3"; desc = "SDIO0_CDATA3"; };
        };

        field {
            name = "muxctrl_reg46";
            desc = "Multiplexing control for the SDIO0_CDATA3 pin";
            sw = rw;
            hw = r;
            encode = muxctrl_reg46_muxctrl_reg46_enum;
            reset = 0x0;
        } muxctrl_reg46[0:0];
    } muxctrl_reg46 @ 0xB8;

    reg {
        name = "Multiplexing control register for the UART1_RTSN pin";
        desc = "muxctrl_reg47 is a multiplexing control register for the UART1_RTSN pin.

Data sheet 2.3.2 muxctrl_reg47 (offset 0xBC, printed page 2-68, `hi3518ev200-datasheet.txt` line 5123).";

        enum muxctrl_reg47_muxctrl_reg47_enum {
            GPIO5_7 = 0 { name = "Gpio5 7"; desc = "GPIO5_7"; };
            EMMC_DATA6 = 1 { name = "Emmc Data6"; desc = "EMMC_DATA6"; };
            I2S_SD_TX = 2 { name = "I2S Sd Tx"; desc = "I2S_SD_TX"; };
            UART1_RTSN = 3 { name = "Uart1 Rtsn"; desc = "UART1_RTSN"; };
        };

        field {
            name = "muxctrl_reg47";
            desc = "Multiplexing control for the UART1_RTSN pin";
            sw = rw;
            hw = r;
            encode = muxctrl_reg47_muxctrl_reg47_enum;
            reset = 0x0;
        } muxctrl_reg47[1:0];
    } muxctrl_reg47 @ 0xBC;

    reg {
        name = "Multiplexing control register for the UART1_RXD pin";
        desc = "muxctrl_reg48 is a multiplexing control register for the UART1_RXD pin.

Data sheet 2.3.2 muxctrl_reg48 (offset 0xC0, printed page 2-68, `hi3518ev200-datasheet.txt` line 5152).";

        enum muxctrl_reg48_muxctrl_reg48_enum {
            GPIO6_0 = 0 { name = "Gpio6 0"; desc = "GPIO6_0"; };
            EMMC_DATA5 = 1 { name = "Emmc Data5"; desc = "EMMC_DATA5"; };
            I2S_WS_TX = 2 { name = "I2S Ws Tx"; desc = "I2S_WS_TX"; };
            UART1_RXD = 3 { name = "Uart1 Rxd"; desc = "UART1_RXD"; };
        };

        field {
            name = "muxctrl_reg48";
            desc = "Multiplexing control for the UART1_RXD pin";
            sw = rw;
            hw = r;
            encode = muxctrl_reg48_muxctrl_reg48_enum;
            reset = 0x0;
        } muxctrl_reg48[1:0];
    } muxctrl_reg48 @ 0xC0;

    reg {
        name = "Multiplexing control register for the UART1_CTSN pin";
        desc = "muxctrl_reg49 is a multiplexing control register for the UART1_CTSN pin.

Data sheet 2.3.2 muxctrl_reg49 (offset 0xC4, printed page 2-69, `hi3518ev200-datasheet.txt` line 5187).";

        enum muxctrl_reg49_muxctrl_reg49_enum {
            GPIO6_1 = 0 { name = "Gpio6 1"; desc = "GPIO6_1"; };
            EMMC_DATA7 = 1 { name = "Emmc Data7"; desc = "EMMC_DATA7"; };
            I2S_MCLK = 2 { name = "I2S Mclk"; desc = "I2S_MCLK"; };
            UART1_CTSN = 3 { name = "Uart1 Ctsn"; desc = "UART1_CTSN"; };
        };

        field {
            name = "muxctrl_reg49";
            desc = "Multiplexing control for the UART1_CTSN pin";
            sw = rw;
            hw = r;
            encode = muxctrl_reg49_muxctrl_reg49_enum;
            reset = 0x0;
        } muxctrl_reg49[1:0];
    } muxctrl_reg49 @ 0xC4;

    reg {
        name = "Multiplexing control register for the UART1_TXD pin";
        desc = "muxctrl_reg50 is a multiplexing control register for the UART1_TXD pin.

Data sheet 2.3.2 muxctrl_reg50 (offset 0xC8, printed page 2-69, `hi3518ev200-datasheet.txt` line 5216).";

        enum muxctrl_reg50_muxctrl_reg50_enum {
            GPIO6_2 = 0 { name = "Gpio6 2"; desc = "GPIO6_2"; };
            EMMC_DS = 1 { name = "Emmc Ds"; desc = "EMMC_DS"; };
            I2S_SD_RX = 2 { name = "I2S Sd Rx"; desc = "I2S_SD_RX"; };
            UART1_TXD = 3 { name = "Uart1 Txd"; desc = "UART1_TXD"; };
        };

        field {
            name = "muxctrl_reg50";
            desc = "Multiplexing control for the UART1_TXD pin";
            sw = rw;
            hw = r;
            encode = muxctrl_reg50_muxctrl_reg50_enum;
            reset = 0x0;
        } muxctrl_reg50[1:0];
    } muxctrl_reg50 @ 0xC8;

    reg {
        name = "Multiplexing control register for the UART2_RXD pin";
        desc = "muxctrl_reg51 is a multiplexing control register for the UART2_RXD pin.

Data sheet 2.3.2 muxctrl_reg51 (offset 0xCC, printed page 2-70, `hi3518ev200-datasheet.txt` line 5252).";

        enum muxctrl_reg51_muxctrl_reg51_enum {
            GPIO6_3 = 0 { name = "Gpio6 3"; desc = "GPIO6_3"; };
            EMMC_DATA1 = 1 { name = "Emmc Data1"; desc = "EMMC_DATA1"; };
            UART2_RXD_OTHER = 3 { name = "Uart2 Rxd Other"; desc = "UART2_RXD Other values: reserved"; };
        };

        field {
            name = "muxctrl_reg51";
            desc = "Multiplexing control for the UART2_RXD pin";
            sw = rw;
            hw = r;
            encode = muxctrl_reg51_muxctrl_reg51_enum;
            reset = 0x0;
        } muxctrl_reg51[1:0];
    } muxctrl_reg51 @ 0xCC;

    reg {
        name = "Multiplexing control register for the UART2_TXD pin";
        desc = "muxctrl_reg52 is a multiplexing control register for the UART2_TXD pin.

Data sheet 2.3.2 muxctrl_reg52 (offset 0xD0, printed page 2-70, `hi3518ev200-datasheet.txt` line 5281).";

        enum muxctrl_reg52_muxctrl_reg52_enum {
            GPIO6_4 = 0 { name = "Gpio6 4"; desc = "GPIO6_4"; };
            EMMC_DATA2 = 1 { name = "Emmc Data2"; desc = "EMMC_DATA2"; };
            I2S_BCLK_TX = 2 { name = "I2S Bclk Tx"; desc = "I2S_BCLK_TX"; };
            UART2_TXD = 3 { name = "Uart2 Txd"; desc = "UART2_TXD"; };
        };

        field {
            name = "muxctrl_reg52";
            desc = "Multiplexing control for the UART2_TXD pin";
            sw = rw;
            hw = r;
            encode = muxctrl_reg52_muxctrl_reg52_enum;
            reset = 0x0;
        } muxctrl_reg52[1:0];
    } muxctrl_reg52 @ 0xD0;

    reg {
        name = "Multiplexing control register for the JTAG_TRSTN pin";
        desc = "muxctrl_reg53 is a multiplexing control register for the JTAG_TRSTN pin.

Data sheet 2.3.2 muxctrl_reg53 (offset 0xD4, printed page 2-71, `hi3518ev200-datasheet.txt` line 5317).";

        enum muxctrl_reg53_muxctrl_reg53_enum {
            GPIO6_5 = 0 { name = "Gpio6 5"; desc = "GPIO6_5"; };
            JTAG_TRSTN = 1 { name = "Jtag Trstn"; desc = "JTAG_TRSTN"; };
            SPI1_CSN1 = 2 { name = "Spi1 Csn1"; desc = "SPI1_CSN1"; };
            I2S_MCLK = 3 { name = "I2S Mclk"; desc = "I2S_MCLK"; };
        };

        field {
            name = "muxctrl_reg53";
            desc = "Multiplexing control for the JTAG_TRSTN pin";
            sw = rw;
            hw = r;
            encode = muxctrl_reg53_muxctrl_reg53_enum;
            reset = 0x0;
        } muxctrl_reg53[1:0];
    } muxctrl_reg53 @ 0xD4;

    reg {
        name = "Multiplexing control register for the JTAG_TCK pin";
        desc = "muxctrl_reg54 is a multiplexing control register for the JTAG_TCK pin.

Data sheet 2.3.2 muxctrl_reg54 (offset 0xD8, printed page 2-71, `hi3518ev200-datasheet.txt` line 5346).";

        enum muxctrl_reg54_muxctrl_reg54_enum {
            GPIO6_6 = 0 { name = "Gpio6 6"; desc = "GPIO6_6"; };
            JTAG_TCK = 1 { name = "Jtag Tck"; desc = "JTAG_TCK"; };
            SPI1_SCLK = 2 { name = "Spi1 Sclk"; desc = "SPI1_SCLK"; };
            I2S_WS_TX = 3 { name = "I2S Ws Tx"; desc = "I2S_WS_TX"; };
            I2C1_SCL = 4 { name = "I2C1 Scl"; desc = "I2C1_SCL"; };
        };

        field {
            name = "muxctrl_reg54";
            desc = "Multiplexing control for the JTAG_TCK pin";
            sw = rw;
            hw = r;
            encode = muxctrl_reg54_muxctrl_reg54_enum;
            reset = 0x0;
        } muxctrl_reg54[2:0];
    } muxctrl_reg54 @ 0xD8;

    reg {
        name = "Multiplexing control register for the JTAG_TMS pin";
        desc = "muxctrl_reg55 is a multiplexing control register for the JTAG_TMS pin.

Data sheet 2.3.2 muxctrl_reg55 (offset 0xDC, printed page 2-72, `hi3518ev200-datasheet.txt` line 5388).";

        enum muxctrl_reg55_muxctrl_reg55_enum {
            GPIO6_7 = 0 { name = "Gpio6 7"; desc = "GPIO6_7"; };
            JTAG_TMS = 1 { name = "Jtag Tms"; desc = "JTAG_TMS"; };
            SPI1_CSN0 = 2 { name = "Spi1 Csn0"; desc = "SPI1_CSN0"; };
            I2S_SD_TX = 3 { name = "I2S Sd Tx"; desc = "I2S_SD_TX"; };
        };

        field {
            name = "muxctrl_reg55";
            desc = "Multiplexing control for the JTAG_TMS pin";
            sw = rw;
            hw = r;
            encode = muxctrl_reg55_muxctrl_reg55_enum;
            reset = 0x0;
        } muxctrl_reg55[1:0];
    } muxctrl_reg55 @ 0xDC;

    reg {
        name = "Multiplexing control register for the JTAG_TDO pin";
        desc = "muxctrl_reg56 is a multiplexing control register for the JTAG_TDO pin.

Data sheet 2.3.2 muxctrl_reg56 (offset 0xE0, printed page 2-72, `hi3518ev200-datasheet.txt` line 5417).";

        enum muxctrl_reg56_muxctrl_reg56_enum {
            GPIO7_0 = 0 { name = "Gpio7 0"; desc = "GPIO7_0"; };
            JTAG_TDO = 1 { name = "Jtag Tdo"; desc = "JTAG_TDO"; };
        };

        field {
            name = "muxctrl_reg56";
            desc = "Multiplexing control for the JTAG_TDO pin";
            sw = rw;
            hw = r;
            encode = muxctrl_reg56_muxctrl_reg56_enum;
            reset = 0x0;
        } muxctrl_reg56[2:0];
    } muxctrl_reg56 @ 0xE0;

    reg {
        name = "Multiplexing control register for the JTAG_TDI pin";
        desc = "muxctrl_reg57 is a multiplexing control register for the JTAG_TDI pin.

Data sheet 2.3.2 muxctrl_reg57 (offset 0xE4, printed page 2-73, `hi3518ev200-datasheet.txt` line 5458).";

        enum muxctrl_reg57_muxctrl_reg57_enum {
            GPIO7_1 = 0 { name = "Gpio7 1"; desc = "GPIO7_1"; };
            JTAG_TDI = 1 { name = "Jtag Tdi"; desc = "JTAG_TDI"; };
            SPI1_SDI = 2 { name = "Spi1 Sdi"; desc = "SPI1_SDI"; };
            I2S_BCLK_TX = 3 { name = "I2S Bclk Tx"; desc = "I2S_BCLK_TX"; };
        };

        field {
            name = "muxctrl_reg57";
            desc = "Multiplexing control for the JTAG_TDI pin";
            sw = rw;
            hw = r;
            encode = muxctrl_reg57_muxctrl_reg57_enum;
            reset = 0x0;
        } muxctrl_reg57[1:0];
    } muxctrl_reg57 @ 0xE4;

    reg {
        name = "Multiplexing control register for the PWM0 pin";
        desc = "muxctrl_reg58 is a multiplexing control register for the PWM0 pin.

Data sheet 2.3.2 muxctrl_reg58 (offset 0xE8, printed page 2-73, `hi3518ev200-datasheet.txt` line 5488).";

        enum muxctrl_reg58_muxctrl_reg58_enum {
            PMC_PWM = 0 { name = "Pmc Pwm"; desc = "PMC_PWM"; };
            GPIO7_2 = 1 { name = "Gpio7 2"; desc = "GPIO7_2"; };
            PWM0_OTHER_VALUES = 2 { name = "Pwm0 Other Values"; desc = "PWM0 Other values: reserved"; };
        };

        field {
            name = "muxctrl_reg58";
            desc = "Multiplexing control for the PWM0 pin";
            sw = rw;
            hw = r;
            encode = muxctrl_reg58_muxctrl_reg58_enum;
            reset = 0x0;
        } muxctrl_reg58[1:0];
    } muxctrl_reg58 @ 0xE8;

    reg {
        name = "Multiplexing control register for the PWM1 pin";
        desc = "muxctrl_reg59 is a multiplexing control register for the PWM1 pin.

Data sheet 2.3.2 muxctrl_reg59 (offset 0xEC, printed page 2-74, `hi3518ev200-datasheet.txt` line 5527).";

        enum muxctrl_reg59_muxctrl_reg59_enum {
            PWM1 = 0 { name = "Pwm1"; desc = "PWM1"; };
            GPIO7_3 = 1 { name = "Gpio7 3"; desc = "GPIO7_3"; };
        };

        field {
            name = "muxctrl_reg59";
            desc = "Multiplexing control for the PWM1 pin";
            sw = rw;
            hw = r;
            encode = muxctrl_reg59_muxctrl_reg59_enum;
            reset = 0x0;
        } muxctrl_reg59[0:0];
    } muxctrl_reg59 @ 0xEC;

    reg {
        name = "Multiplexing control register for the PWM2 pin";
        desc = "muxctrl_reg60 is a multiplexing control register for the PWM2 pin.

Data sheet 2.3.2 muxctrl_reg60 (offset 0xF0, printed page 2-74, `hi3518ev200-datasheet.txt` line 5555).";

        enum muxctrl_reg60_muxctrl_reg60_enum {
            PWM2 = 0 { name = "Pwm2"; desc = "PWM2"; };
            GPIO7_4 = 1 { name = "Gpio7 4"; desc = "GPIO7_4"; };
            SPI1_CSN1_OTHER = 2 { name = "Spi1 Csn1 Other"; desc = "SPI1_CSN1 Other values: reserved"; };
        };

        field {
            name = "muxctrl_reg60";
            desc = "Multiplexing control for the PWM2 pin";
            sw = rw;
            hw = r;
            encode = muxctrl_reg60_muxctrl_reg60_enum;
            reset = 0x0;
        } muxctrl_reg60[1:0];
    } muxctrl_reg60 @ 0xF0;

    reg {
        name = "Multiplexing control register for the PWM3 pin";
        desc = "muxctrl_reg61 is a multiplexing control register for the PWM3 pin.

Data sheet 2.3.2 muxctrl_reg61 (offset 0xF4, printed page 2-75, `hi3518ev200-datasheet.txt` line 5594).";

        enum muxctrl_reg61_muxctrl_reg61_enum {
            PWM3 = 0 { name = "Pwm3"; desc = "PWM3"; };
            GPIO7_5 = 1 { name = "Gpio7 5"; desc = "GPIO7_5"; };
        };

        field {
            name = "muxctrl_reg61";
            desc = "Multiplexing control for the PWM3 pin";
            sw = rw;
            hw = r;
            encode = muxctrl_reg61_muxctrl_reg61_enum;
            reset = 0x0;
        } muxctrl_reg61[0:0];
    } muxctrl_reg61 @ 0xF4;

    reg {
        name = "Multiplexing control register for the SAR_ADC_CH0 pin";
        desc = "muxctrl_reg62 is a multiplexing control register for the SAR_ADC_CH0 pin.

Data sheet 2.3.2 muxctrl_reg62 (offset 0xF8, printed page 2-75, `hi3518ev200-datasheet.txt` line 5623).";

        enum muxctrl_reg62_muxctrl_reg62_enum {
            SAR_ADC_CH0 = 0 { name = "Sar Adc Ch0"; desc = "SAR_ADC_CH0"; };
            GPIO7_6 = 1 { name = "Gpio7 6"; desc = "GPIO7_6"; };
        };

        field {
            name = "muxctrl_reg62";
            desc = "Multiplexing control for the SAR_ADC_CH0 pin";
            sw = rw;
            hw = r;
            encode = muxctrl_reg62_muxctrl_reg62_enum;
            reset = 0x0;
        } muxctrl_reg62[0:0];
    } muxctrl_reg62 @ 0xF8;

    reg {
        name = "Multiplexing control register for the SAR_ADC_CH1 pin";
        desc = "muxctrl_reg63 is a multiplexing control register for the SAR_ADC_CH1 pin.

Data sheet 2.3.2 muxctrl_reg63 (offset 0xFC, printed page 2-76, `hi3518ev200-datasheet.txt` line 5657).";

        enum muxctrl_reg63_muxctrl_reg63_enum {
            SAR_ADC_CH1 = 0 { name = "Sar Adc Ch1"; desc = "SAR_ADC_CH1"; };
            GPIO7_7 = 1 { name = "Gpio7 7"; desc = "GPIO7_7"; };
        };

        field {
            name = "muxctrl_reg63";
            desc = "Multiplexing control for the SAR_ADC_CH1 pin";
            sw = rw;
            hw = r;
            encode = muxctrl_reg63_muxctrl_reg63_enum;
            reset = 0x0;
        } muxctrl_reg63[0:0];
    } muxctrl_reg63 @ 0xFC;

    reg {
        name = "Multiplexing control register for the SAR_ADC_CH2 pin";
        desc = "muxctrl_reg64 is a multiplexing control register for the SAR_ADC_CH2 pin.

Data sheet 2.3.2 muxctrl_reg64 (offset 0x100, printed page 2-76, `hi3518ev200-datasheet.txt` line 5685).";

        enum muxctrl_reg64_muxctrl_reg64_enum {
            SAR_ADC_CH2 = 0 { name = "Sar Adc Ch2"; desc = "SAR_ADC_CH2"; };
            GPIO8_0 = 1 { name = "Gpio8 0"; desc = "GPIO8_0"; };
        };

        field {
            name = "muxctrl_reg64";
            desc = "Multiplexing control for the SAR_ADC_CH2 pin";
            sw = rw;
            hw = r;
            encode = muxctrl_reg64_muxctrl_reg64_enum;
            reset = 0x0;
        } muxctrl_reg64[0:0];
    } muxctrl_reg64 @ 0x100;

    reg {
        name = "Multiplexing control register for the SAR_ADC_CH3 pin";
        desc = "muxctrl_reg65 is a multiplexing control register for the SAR_ADC_CH3 pin.

Data sheet 2.3.2 muxctrl_reg65 (offset 0x104, printed page 2-77, `hi3518ev200-datasheet.txt` line 5719).";

        enum muxctrl_reg65_muxctrl_reg65_enum {
            SAR_ADC_CH3 = 0 { name = "Sar Adc Ch3"; desc = "SAR_ADC_CH3"; };
            GPIO8_1 = 1 { name = "Gpio8 1"; desc = "GPIO8_1"; };
        };

        field {
            name = "muxctrl_reg65";
            desc = "Multiplexing control for the SAR_ADC_CH3 pin";
            sw = rw;
            hw = r;
            encode = muxctrl_reg65_muxctrl_reg65_enum;
            reset = 0x0;
        } muxctrl_reg65[0:0];
    } muxctrl_reg65 @ 0x104;

    reg {
        name = "Control register for the SENSOR_CLK functional pin";
        desc = "PADCTRL_REG0 is a control register for the SENSOR_CLK functional pin.

Pad control register at 0x200F0800 + 0x%X. In the data sheet the polarity of the slew bit differs between registers: fields named `_sr` read 0 = fast edge / 1 = slow edge, fields named `_sl` read 0 = slow edge / 1 = fast edge; drive strength tables differ per pin (see the field).

Data sheet 2.6.2 PADCTRL_REG0 (offset 0x0, printed page 2-99, `hi3518ev200-datasheet.txt` line 6837).";

        enum PADCTRL_REG0_padctrl_reg0_sr_enum {
            FAST_EDGE = 0 { name = "Fast Edge"; desc = "fast edge"; };
            SLOW_EDGE = 1 { name = "Slow Edge"; desc = "slow edge"; };
        };

        field {
            name = "padctrl_reg0_sr";
            desc = "Rising/Falling speed control of the output signal";
            sw = rw;
            hw = r;
            encode = PADCTRL_REG0_padctrl_reg0_sr_enum;
            reset = 0x0;
        } padctrl_reg0_sr[7:7];

        enum PADCTRL_REG0_padctrl_reg0_ds_enum {
            V_12_MA = 0 { name = "V 12 Ma"; desc = "12 mA"; };
            V_11_MA = 1 { name = "V 11 Ma"; desc = "11 mA"; };
            V_9_MA = 2 { name = "V 9 Ma"; desc = "9 mA"; };
            V_8_MA = 3 { name = "V 8 Ma"; desc = "8 mA"; };
            V_5_MA = 4 { name = "V 5 Ma"; desc = "5 mA"; };
            V_4_MA = 5 { name = "V 4 Ma"; desc = "4 mA"; };
            V_2_MA = 6 { name = "V 2 Ma"; desc = "2 mA"; };
            V_1_MA = 7 { name = "V 1 Ma"; desc = "1 mA"; };
        };

        field {
            name = "padctrl_reg0_ds";
            desc = "Drive capability of the SENSOR_CLK pin";
            sw = rw;
            hw = r;
            encode = PADCTRL_REG0_padctrl_reg0_ds_enum;
            reset = 0x4;
        } padctrl_reg0_ds[6:4];
    } PADCTRL_REG0 @ 0x800;

    reg {
        name = "Control register for the SENSOR_RSTN functional pin";
        desc = "PADCTRL_REG1 is a control register for the SENSOR_RSTN functional pin.

Data sheet 2.6.2 PADCTRL_REG1 (offset 0x4, printed page 2-100, `hi3518ev200-datasheet.txt` line 6884).";

        enum PADCTRL_REG1_padctrl_reg1_sr_enum {
            FAST_EDGE = 0 { name = "Fast Edge"; desc = "fast edge"; };
            SLOW_EDGE = 1 { name = "Slow Edge"; desc = "slow edge"; };
        };

        field {
            name = "padctrl_reg1_sr";
            desc = "Rising/Falling speed control of the output signal";
            sw = rw;
            hw = r;
            encode = PADCTRL_REG1_padctrl_reg1_sr_enum;
            reset = 0x1;
        } padctrl_reg1_sr[7:7];

        enum PADCTRL_REG1_padctrl_reg1_ds_enum {
            V_4_MA = 0 { name = "V 4 Ma"; desc = "4 mA"; };
            V_3_MA = 1 { name = "V 3 Ma"; desc = "3 mA"; };
            V_2_MA = 2 { name = "V 2 Ma"; desc = "2 mA"; };
            V_1_MA = 3 { name = "V 1 Ma"; desc = "1 mA"; };
        };

        field {
            name = "padctrl_reg1_ds";
            desc = "Drive capability of the SENSOR_RSTN pin";
            sw = rw;
            hw = r;
            encode = PADCTRL_REG1_padctrl_reg1_ds_enum;
            reset = 0x1;
        } padctrl_reg1_ds[5:4];
    } PADCTRL_REG1 @ 0x804;

    reg {
        name = "Control register for the FLASH_TRIG functional pin";
        desc = "PADCTRL_REG2 is a control register for the FLASH_TRIG functional pin.

Data sheet 2.6.2 PADCTRL_REG2 (offset 0x8, printed page 2-100, `hi3518ev200-datasheet.txt` line 6920).";

        enum PADCTRL_REG2_padctrl_reg2_sl_enum {
            SLOW_EDGE = 0 { name = "Slow Edge"; desc = "slow edge"; };
            FAST_EDGE = 1 { name = "Fast Edge"; desc = "fast edge"; };
        };

        field {
            name = "padctrl_reg2_sl";
            desc = "Rising/Falling speed control of the output signal";
            sw = rw;
            hw = r;
            encode = PADCTRL_REG2_padctrl_reg2_sl_enum;
            reset = 0x0;
        } padctrl_reg2_sl[7:7];

        enum PADCTRL_REG2_padctrl_reg2_ds_enum {
            V_1_MA = 0 { name = "V 1 Ma"; desc = "1 mA"; };
            V_2_MA = 1 { name = "V 2 Ma"; desc = "2 mA"; };
            V_3_MA = 2 { name = "V 3 Ma"; desc = "3 mA"; };
            V_4_MA = 3 { name = "V 4 Ma"; desc = "4 mA"; };
        };

        field {
            name = "padctrl_reg2_ds";
            desc = "Drive capability of the FLASH_TRIG pin";
            sw = rw;
            hw = r;
            encode = PADCTRL_REG2_padctrl_reg2_ds_enum;
            reset = 0x0;
        } padctrl_reg2_ds[5:4];
    } PADCTRL_REG2 @ 0x808;

    reg {
        name = "Control register for the SHUTTER_TRIG functional pin";
        desc = "PADCTRL_REG3 is a control register for the SHUTTER_TRIG functional pin.

Data sheet 2.6.2 PADCTRL_REG3 (offset 0xC, printed page 2-101, `hi3518ev200-datasheet.txt` line 6961).";

        enum PADCTRL_REG3_padctrl_reg3_sl_enum {
            SLOW_EDGE = 0 { name = "Slow Edge"; desc = "slow edge"; };
            FAST_EDGE = 1 { name = "Fast Edge"; desc = "fast edge"; };
        };

        field {
            name = "padctrl_reg3_sl";
            desc = "Rising/Falling speed control of the output signal";
            sw = rw;
            hw = r;
            encode = PADCTRL_REG3_padctrl_reg3_sl_enum;
            reset = 0x0;
        } padctrl_reg3_sl[7:7];

        enum PADCTRL_REG3_padctrl_reg3_ds_enum {
            V_1_MA = 0 { name = "V 1 Ma"; desc = "1 mA"; };
            V_2_MA = 1 { name = "V 2 Ma"; desc = "2 mA"; };
            V_3_MA = 2 { name = "V 3 Ma"; desc = "3 mA"; };
            V_4_MA = 3 { name = "V 4 Ma"; desc = "4 mA"; };
        };

        field {
            name = "padctrl_reg3_ds";
            desc = "Drive capability of the SHUTTER_TRIG pin";
            sw = rw;
            hw = r;
            encode = PADCTRL_REG3_padctrl_reg3_ds_enum;
            reset = 0x0;
        } padctrl_reg3_ds[5:4];
    } PADCTRL_REG3 @ 0x80C;

    reg {
        name = "Control register for the RMII_CLK functional pin";
        desc = "PADCTRL_REG4 is a control register for the RMII_CLK functional pin.

Data sheet 2.6.2 PADCTRL_REG4 (offset 0x10, printed page 2-102, `hi3518ev200-datasheet.txt` line 7007).";

        enum PADCTRL_REG4_padctrl_reg4_sr_enum {
            FAST_EDGE = 0 { name = "Fast Edge"; desc = "fast edge"; };
            SLOW_EDGE = 1 { name = "Slow Edge"; desc = "slow edge"; };
        };

        field {
            name = "padctrl_reg4_sr";
            desc = "Rising/Falling speed control of the output signal";
            sw = rw;
            hw = r;
            encode = PADCTRL_REG4_padctrl_reg4_sr_enum;
            reset = 0x0;
        } padctrl_reg4_sr[7:7];

        enum PADCTRL_REG4_padctrl_reg4_ds_enum {
            V_12_MA = 0 { name = "V 12 Ma"; desc = "12 mA"; };
            V_11_MA = 1 { name = "V 11 Ma"; desc = "11 mA"; };
            V_9_MA = 2 { name = "V 9 Ma"; desc = "9 mA"; };
            V_8_MA = 3 { name = "V 8 Ma"; desc = "8 mA"; };
            V_5_MA = 4 { name = "V 5 Ma"; desc = "5 mA"; };
            V_4_MA = 5 { name = "V 4 Ma"; desc = "4 mA"; };
            V_2_MA = 6 { name = "V 2 Ma"; desc = "2 mA"; };
            V_1_MA = 7 { name = "V 1 Ma"; desc = "1 mA"; };
        };

        field {
            name = "padctrl_reg4_ds";
            desc = "Drive capability of the RMII_CLK pin";
            sw = rw;
            hw = r;
            encode = PADCTRL_REG4_padctrl_reg4_ds_enum;
            reset = 0x4;
        } padctrl_reg4_ds[6:4];
    } PADCTRL_REG4 @ 0x810;

    reg {
        name = "Control register for the RMII_TX_EN functional pin";
        desc = "PADCTRL_REG5 is a control register for the RMII_TX_EN functional pin.

Data sheet 2.6.2 PADCTRL_REG5 (offset 0x14, printed page 2-103, `hi3518ev200-datasheet.txt` line 7051).";

        enum PADCTRL_REG5_padctrl_reg5_sr_enum {
            FAST_EDGE = 0 { name = "Fast Edge"; desc = "fast edge"; };
            SLOW_EDGE = 1 { name = "Slow Edge"; desc = "slow edge"; };
        };

        field {
            name = "padctrl_reg5_sr";
            desc = "Rising/Falling speed control of the output signal";
            sw = rw;
            hw = r;
            encode = PADCTRL_REG5_padctrl_reg5_sr_enum;
            reset = 0x1;
        } padctrl_reg5_sr[7:7];

        enum PADCTRL_REG5_padctrl_reg5_ds_enum {
            V_4_MA = 0 { name = "V 4 Ma"; desc = "4 mA"; };
            V_3_MA = 1 { name = "V 3 Ma"; desc = "3 mA"; };
            V_2_MA = 2 { name = "V 2 Ma"; desc = "2 mA"; };
            V_1_MA = 3 { name = "V 1 Ma"; desc = "1 mA"; };
        };

        field {
            name = "padctrl_reg5_ds";
            desc = "Drive capability of the RMII_TX_EN pin";
            sw = rw;
            hw = r;
            encode = PADCTRL_REG5_padctrl_reg5_ds_enum;
            reset = 0x0;
        } padctrl_reg5_ds[5:4];
    } PADCTRL_REG5 @ 0x814;

    reg {
        name = "Control register for the RMII_TXD0 functional pin";
        desc = "PADCTRL_REG6 is a control register for the RMII_TXD0 functional pin.

Data sheet 2.6.2 PADCTRL_REG6 (offset 0x18, printed page 2-104, `hi3518ev200-datasheet.txt` line 7096).";

        enum PADCTRL_REG6_padctrl_reg6_sr_enum {
            FAST_EDGE = 0 { name = "Fast Edge"; desc = "fast edge"; };
            SLOW_EDGE = 1 { name = "Slow Edge"; desc = "slow edge"; };
        };

        field {
            name = "padctrl_reg6_sr";
            desc = "Rising/Falling speed control of the output signal";
            sw = rw;
            hw = r;
            encode = PADCTRL_REG6_padctrl_reg6_sr_enum;
            reset = 0x1;
        } padctrl_reg6_sr[7:7];

        enum PADCTRL_REG6_padctrl_reg6_ds_enum {
            V_4_MA = 0 { name = "V 4 Ma"; desc = "4 mA"; };
            V_3_MA = 1 { name = "V 3 Ma"; desc = "3 mA"; };
            V_2_MA = 2 { name = "V 2 Ma"; desc = "2 mA"; };
            V_1_MA = 3 { name = "V 1 Ma"; desc = "1 mA"; };
        };

        field {
            name = "padctrl_reg6_ds";
            desc = "Drive capability of the RMII_TXD0 pin";
            sw = rw;
            hw = r;
            encode = PADCTRL_REG6_padctrl_reg6_ds_enum;
            reset = 0x0;
        } padctrl_reg6_ds[5:4];
    } PADCTRL_REG6 @ 0x818;

    reg {
        name = "Control register for the RMII_TXD1 functional pin";
        desc = "PADCTRL_REG7 is a control register for the RMII_TXD1 functional pin.

Data sheet 2.6.2 PADCTRL_REG7 (offset 0x1C, printed page 2-104, `hi3518ev200-datasheet.txt` line 7132).";

        enum PADCTRL_REG7_padctrl_reg7_sr_enum {
            FAST_EDGE = 0 { name = "Fast Edge"; desc = "fast edge"; };
            SLOW_EDGE = 1 { name = "Slow Edge"; desc = "slow edge"; };
        };

        field {
            name = "padctrl_reg7_sr";
            desc = "Rising/Falling speed control of the output signal";
            sw = rw;
            hw = r;
            encode = PADCTRL_REG7_padctrl_reg7_sr_enum;
            reset = 0x1;
        } padctrl_reg7_sr[7:7];

        enum PADCTRL_REG7_padctrl_reg7_ds_enum {
            V_4_MA = 0 { name = "V 4 Ma"; desc = "4 mA"; };
            V_3_MA = 1 { name = "V 3 Ma"; desc = "3 mA"; };
            V_2_MA = 2 { name = "V 2 Ma"; desc = "2 mA"; };
            V_1_MA = 3 { name = "V 1 Ma"; desc = "1 mA"; };
        };

        field {
            name = "padctrl_reg7_ds";
            desc = "Drive capability of the RMII_TXD1 pin";
            sw = rw;
            hw = r;
            encode = PADCTRL_REG7_padctrl_reg7_ds_enum;
            reset = 0x0;
        } padctrl_reg7_ds[5:4];
    } PADCTRL_REG7 @ 0x81C;

    reg {
        name = "Control register for the RMII_RX_DV functional pin";
        desc = "PADCTRL_REG8 is a control register for the RMII_RX_DV functional pin.

Data sheet 2.6.2 PADCTRL_REG8 (offset 0x20, printed page 2-105, `hi3518ev200-datasheet.txt` line 7173).";

        enum PADCTRL_REG8_padctrl_reg8_sr_enum {
            FAST_EDGE = 0 { name = "Fast Edge"; desc = "fast edge"; };
            SLOW_EDGE = 1 { name = "Slow Edge"; desc = "slow edge"; };
        };

        field {
            name = "padctrl_reg8_sr";
            desc = "Rising/Falling speed control of the output signal";
            sw = rw;
            hw = r;
            encode = PADCTRL_REG8_padctrl_reg8_sr_enum;
            reset = 0x1;
        } padctrl_reg8_sr[7:7];

        enum PADCTRL_REG8_padctrl_reg8_ds0_enum {
            V_4_MA = 0 { name = "V 4 Ma"; desc = "4 mA"; };
            V_3_MA = 1 { name = "V 3 Ma"; desc = "3 mA"; };
            V_2_MA = 2 { name = "V 2 Ma"; desc = "2 mA"; };
            V_1_MA = 3 { name = "V 1 Ma"; desc = "1 mA"; };
        };

        field {
            name = "padctrl_reg8_ds0";
            desc = "Drive capability of the RMII_RX_DV pin";
            sw = rw;
            hw = r;
            encode = PADCTRL_REG8_padctrl_reg8_ds0_enum;
            reset = 0x0;
        } padctrl_reg8_ds0[5:4];
    } PADCTRL_REG8 @ 0x820;

    reg {
        name = "Control register for the RMII_RXD0 functional pin";
        desc = "PADCTRL_REG9 is a control register for the RMII_RXD0 functional pin.

Data sheet 2.6.2 PADCTRL_REG9 (offset 0x24, printed page 2-106, `hi3518ev200-datasheet.txt` line 7218).";

        enum PADCTRL_REG9_padctrl_reg9_sr_enum {
            FAST_EDGE = 0 { name = "Fast Edge"; desc = "fast edge"; };
            SLOW_EDGE = 1 { name = "Slow Edge"; desc = "slow edge"; };
        };

        field {
            name = "padctrl_reg9_sr";
            desc = "Rising/Falling speed control of the output signal";
            sw = rw;
            hw = r;
            encode = PADCTRL_REG9_padctrl_reg9_sr_enum;
            reset = 0x1;
        } padctrl_reg9_sr[7:7];

        enum PADCTRL_REG9_padctrl_reg9_ds_enum {
            V_4_MA = 0 { name = "V 4 Ma"; desc = "4 mA"; };
            V_3_MA = 1 { name = "V 3 Ma"; desc = "3 mA"; };
            V_2_MA = 2 { name = "V 2 Ma"; desc = "2 mA"; };
            V_1_MA = 3 { name = "V 1 Ma"; desc = "1 mA"; };
        };

        field {
            name = "padctrl_reg9_ds";
            desc = "Drive capability of the RMII_RXD0 pin";
            sw = rw;
            hw = r;
            encode = PADCTRL_REG9_padctrl_reg9_ds_enum;
            reset = 0x0;
        } padctrl_reg9_ds[5:4];
    } PADCTRL_REG9 @ 0x824;

    reg {
        name = "Control register for the RMII_RXD1 functional pin";
        desc = "PADCTRL_REG10 is a control register for the RMII_RXD1 functional pin.

Data sheet 2.6.2 PADCTRL_REG10 (offset 0x28, printed page 2-107, `hi3518ev200-datasheet.txt` line 7262).";

        enum PADCTRL_REG10_padctrl_reg10_sr_enum {
            FAST_EDGE = 0 { name = "Fast Edge"; desc = "fast edge"; };
            SLOW_EDGE = 1 { name = "Slow Edge"; desc = "slow edge"; };
        };

        field {
            name = "padctrl_reg10_sr";
            desc = "Rising/Falling speed control of the output signal";
            sw = rw;
            hw = r;
            encode = PADCTRL_REG10_padctrl_reg10_sr_enum;
            reset = 0x1;
        } padctrl_reg10_sr[7:7];

        enum PADCTRL_REG10_padctrl_reg10_ds_enum {
            V_4_MA = 0 { name = "V 4 Ma"; desc = "4 mA"; };
            V_3_MA = 1 { name = "V 3 Ma"; desc = "3 mA"; };
            V_2_MA = 2 { name = "V 2 Ma"; desc = "2 mA"; };
            V_1_MA = 3 { name = "V 1 Ma"; desc = "1 mA"; };
        };

        field {
            name = "padctrl_reg10_ds";
            desc = "Drive capability of the RMII_RXD1 pin";
            sw = rw;
            hw = r;
            encode = PADCTRL_REG10_padctrl_reg10_ds_enum;
            reset = 0x0;
        } padctrl_reg10_ds[5:4];
    } PADCTRL_REG10 @ 0x828;

    reg {
        name = "Control register for the EPHY_RST functional pin";
        desc = "PADCTRL_REG11 is a control register for the EPHY_RST functional pin.

Data sheet 2.6.2 PADCTRL_REG11 (offset 0x2C, printed page 2-107, `hi3518ev200-datasheet.txt` line 7298).";

        enum PADCTRL_REG11_padctrl_reg11_sr_enum {
            FAST_EDGE = 0 { name = "Fast Edge"; desc = "fast edge"; };
            SLOW_EDGE = 1 { name = "Slow Edge"; desc = "slow edge"; };
        };

        field {
            name = "padctrl_reg11_sr";
            desc = "Rising/Falling speed control of the output signal";
            sw = rw;
            hw = r;
            encode = PADCTRL_REG11_padctrl_reg11_sr_enum;
            reset = 0x1;
        } padctrl_reg11_sr[7:7];

        enum PADCTRL_REG11_padctrl_reg11_ds_enum {
            V_4_MA = 0 { name = "V 4 Ma"; desc = "4 mA"; };
            V_3_MA = 1 { name = "V 3 Ma"; desc = "3 mA"; };
            V_2_MA = 2 { name = "V 2 Ma"; desc = "2 mA"; };
            V_1_MA = 3 { name = "V 1 Ma"; desc = "1 mA"; };
        };

        field {
            name = "padctrl_reg11_ds";
            desc = "Drive capability of the EPHY_RST pin";
            sw = rw;
            hw = r;
            encode = PADCTRL_REG11_padctrl_reg11_ds_enum;
            reset = 0x2;
        } padctrl_reg11_ds[5:4];
    } PADCTRL_REG11 @ 0x82C;

    reg {
        name = "Control register for the SPI1_CSN1 functional pin";
        desc = "PADCTRL_REG12 is a control register for the SPI1_CSN1 functional pin.

Data sheet 2.6.2 PADCTRL_REG12 (offset 0x30, printed page 2-108, `hi3518ev200-datasheet.txt` line 7339).";

        enum PADCTRL_REG12_padctrl_reg12_sr_enum {
            FAST_EDGE = 0 { name = "Fast Edge"; desc = "fast edge"; };
            SLOW_EDGE = 1 { name = "Slow Edge"; desc = "slow edge"; };
        };

        field {
            name = "padctrl_reg12_sr";
            desc = "Rising/Falling speed control of the output signal";
            sw = rw;
            hw = r;
            encode = PADCTRL_REG12_padctrl_reg12_sr_enum;
            reset = 0x1;
        } padctrl_reg12_sr[7:7];

        enum PADCTRL_REG12_padctrl_reg12_ds_enum {
            V_4_MA = 0 { name = "V 4 Ma"; desc = "4 mA"; };
            V_3_MA = 1 { name = "V 3 Ma"; desc = "3 mA"; };
            V_2_MA = 2 { name = "V 2 Ma"; desc = "2 mA"; };
            V_1_MA = 3 { name = "V 1 Ma"; desc = "1 mA"; };
        };

        field {
            name = "padctrl_reg12_ds";
            desc = "Drive capability of the SPI1_CSN1 pin";
            sw = rw;
            hw = r;
            encode = PADCTRL_REG12_padctrl_reg12_ds_enum;
            reset = 0x2;
        } padctrl_reg12_ds[5:4];
    } PADCTRL_REG12 @ 0x830;

    reg {
        name = "Control register for the EPHY_CLK functional pin";
        desc = "PADCTRL_REG13 is a control register for the EPHY_CLK functional pin.

Data sheet 2.6.2 PADCTRL_REG13 (offset 0x34, printed page 2-109, `hi3518ev200-datasheet.txt` line 7385).";

        enum PADCTRL_REG13_padctrl_reg13_sr_enum {
            FAST_EDGE = 0 { name = "Fast Edge"; desc = "fast edge"; };
            SLOW_EDGE = 1 { name = "Slow Edge"; desc = "slow edge"; };
        };

        field {
            name = "padctrl_reg13_sr";
            desc = "Rising/Falling speed control of the output signal";
            sw = rw;
            hw = r;
            encode = PADCTRL_REG13_padctrl_reg13_sr_enum;
            reset = 0x0;
        } padctrl_reg13_sr[7:7];

        enum PADCTRL_REG13_padctrl_reg13_ds_enum {
            V_12_MA = 0 { name = "V 12 Ma"; desc = "12 mA"; };
            V_11_MA = 1 { name = "V 11 Ma"; desc = "11 mA"; };
            V_9_MA = 2 { name = "V 9 Ma"; desc = "9 mA"; };
            V_8_MA = 3 { name = "V 8 Ma"; desc = "8 mA"; };
            V_5_MA = 4 { name = "V 5 Ma"; desc = "5 mA"; };
            V_4_MA = 5 { name = "V 4 Ma"; desc = "4 mA"; };
            V_2_MA = 6 { name = "V 2 Ma"; desc = "2 mA"; };
            V_1_MA = 7 { name = "V 1 Ma"; desc = "1 mA"; };
        };

        field {
            name = "padctrl_reg13_ds";
            desc = "Drive capability of the EPHY_CLK pin";
            sw = rw;
            hw = r;
            encode = PADCTRL_REG13_padctrl_reg13_ds_enum;
            reset = 0x4;
        } padctrl_reg13_ds[6:4];
    } PADCTRL_REG13 @ 0x834;

    reg {
        name = "Control register for the MDCK functional pin";
        desc = "PADCTRL_REG14 is a control register for the MDCK functional pin.

Data sheet 2.6.2 PADCTRL_REG14 (offset 0x38, printed page 2-110, `hi3518ev200-datasheet.txt` line 7430).";

        enum PADCTRL_REG14_padctrl_reg14_sr_enum {
            FAST_EDGE = 0 { name = "Fast Edge"; desc = "fast edge"; };
            SLOW_EDGE = 1 { name = "Slow Edge"; desc = "slow edge"; };
        };

        field {
            name = "padctrl_reg14_sr";
            desc = "Rising/Falling speed control of the output signal";
            sw = rw;
            hw = r;
            encode = PADCTRL_REG14_padctrl_reg14_sr_enum;
            reset = 0x1;
        } padctrl_reg14_sr[7:7];

        enum PADCTRL_REG14_padctrl_reg14_ds_enum {
            V_4_MA = 0 { name = "V 4 Ma"; desc = "4 mA"; };
            V_3_MA = 1 { name = "V 3 Ma"; desc = "3 mA"; };
            V_2_MA = 2 { name = "V 2 Ma"; desc = "2 mA"; };
            V_1_MA = 3 { name = "V 1 Ma"; desc = "1 mA"; };
        };

        field {
            name = "padctrl_reg14_ds";
            desc = "Drive capability of the MDCK pin";
            sw = rw;
            hw = r;
            encode = PADCTRL_REG14_padctrl_reg14_ds_enum;
            reset = 0x0;
        } padctrl_reg14_ds[5:4];
    } PADCTRL_REG14 @ 0x838;

    reg {
        name = "Control register for the MDIO functional pin";
        desc = "PADCTRL_REG15 is a control register for the MDIO functional pin.

Data sheet 2.6.2 PADCTRL_REG15 (offset 0x3C, printed page 2-110, `hi3518ev200-datasheet.txt` line 7465).";

        enum PADCTRL_REG15_padctrl_reg15_sr_enum {
            FAST_EDGE = 0 { name = "Fast Edge"; desc = "fast edge"; };
            SLOW_EDGE = 1 { name = "Slow Edge"; desc = "slow edge"; };
        };

        field {
            name = "padctrl_reg15_sr";
            desc = "Rising/Falling speed control of the output signal";
            sw = rw;
            hw = r;
            encode = PADCTRL_REG15_padctrl_reg15_sr_enum;
            reset = 0x1;
        } padctrl_reg15_sr[7:7];

        enum PADCTRL_REG15_padctrl_reg15_ds_enum {
            V_4_MA = 0 { name = "V 4 Ma"; desc = "4 mA"; };
            V_3_MA = 1 { name = "V 3 Ma"; desc = "3 mA"; };
            V_2_MA = 2 { name = "V 2 Ma"; desc = "2 mA"; };
            V_1_MA = 3 { name = "V 1 Ma"; desc = "1 mA"; };
        };

        field {
            name = "padctrl_reg15_ds";
            desc = "Drive capability of the MDIO pin";
            sw = rw;
            hw = r;
            encode = PADCTRL_REG15_padctrl_reg15_ds_enum;
            reset = 0x1;
        } padctrl_reg15_ds[5:4];
    } PADCTRL_REG15 @ 0x83C;

    reg {
        name = "Control register for the SPI0_SCLK functional pin";
        desc = "PADCTRL_REG16 is a control register for the SPI0_SCLK functional pin.

Data sheet 2.6.2 PADCTRL_REG16 (offset 0x40, printed page 2-111, `hi3518ev200-datasheet.txt` line 7506).";

        enum PADCTRL_REG16_padctrl_reg16_sr_enum {
            FAST_EDGE = 0 { name = "Fast Edge"; desc = "fast edge"; };
            SLOW_EDGE = 1 { name = "Slow Edge"; desc = "slow edge"; };
        };

        field {
            name = "padctrl_reg16_sr";
            desc = "Rising/Falling speed control of the output signal";
            sw = rw;
            hw = r;
            encode = PADCTRL_REG16_padctrl_reg16_sr_enum;
            reset = 0x0;
        } padctrl_reg16_sr[7:7];

        enum PADCTRL_REG16_padctrl_reg16_ds_enum {
            V_12_MA = 0 { name = "V 12 Ma"; desc = "12 mA"; };
            V_11_MA = 1 { name = "V 11 Ma"; desc = "11 mA"; };
            V_9_MA = 2 { name = "V 9 Ma"; desc = "9 mA"; };
            V_8_MA = 3 { name = "V 8 Ma"; desc = "8 mA"; };
            V_5_MA = 4 { name = "V 5 Ma"; desc = "5 mA"; };
            V_4_MA = 5 { name = "V 4 Ma"; desc = "4 mA"; };
            V_2_MA = 6 { name = "V 2 Ma"; desc = "2 mA"; };
            V_1_MA = 7 { name = "V 1 Ma"; desc = "1 mA"; };
        };

        field {
            name = "padctrl_reg16_ds";
            desc = "Drive capability of the SPI0_SCLK pin";
            sw = rw;
            hw = r;
            encode = PADCTRL_REG16_padctrl_reg16_ds_enum;
            reset = 0x4;
        } padctrl_reg16_ds[6:4];
    } PADCTRL_REG16 @ 0x840;

    reg {
        name = "Control register for the SPI0_SDO functional pin";
        desc = "PADCTRL_REG17 is a control register for the SPI0_SDO functional pin.

Data sheet 2.6.2 PADCTRL_REG17 (offset 0x44, printed page 2-112, `hi3518ev200-datasheet.txt` line 7555).";

        enum PADCTRL_REG17_padctrl_reg17_sr_enum {
            FAST_EDGE = 0 { name = "Fast Edge"; desc = "fast edge"; };
            SLOW_EDGE = 1 { name = "Slow Edge"; desc = "slow edge"; };
        };

        field {
            name = "padctrl_reg17_sr";
            desc = "Rising/Falling speed control of the output signal";
            sw = rw;
            hw = r;
            encode = PADCTRL_REG17_padctrl_reg17_sr_enum;
            reset = 0x1;
        } padctrl_reg17_sr[7:7];

        enum PADCTRL_REG17_padctrl_reg17_ds_enum {
            V_4_MA = 0 { name = "V 4 Ma"; desc = "4 mA"; };
            V_3_MA = 1 { name = "V 3 Ma"; desc = "3 mA"; };
            V_2_MA = 2 { name = "V 2 Ma"; desc = "2 mA"; };
            V_1_MA = 3 { name = "V 1 Ma"; desc = "1 mA"; };
        };

        field {
            name = "padctrl_reg17_ds";
            desc = "Drive capability of the SPI0_SDO pin";
            sw = rw;
            hw = r;
            encode = PADCTRL_REG17_padctrl_reg17_ds_enum;
            reset = 0x1;
        } padctrl_reg17_ds[5:4];
    } PADCTRL_REG17 @ 0x844;

    reg {
        name = "Control register for the SPI0_SDI functional pin";
        desc = "PADCTRL_REG18 is a control register for the SPI0_SDI functional pin.

Data sheet 2.6.2 PADCTRL_REG18 (offset 0x48, printed page 2-113, `hi3518ev200-datasheet.txt` line 7597).";

        enum PADCTRL_REG18_padctrl_reg18_sr_enum {
            FAST_EDGE = 0 { name = "Fast Edge"; desc = "fast edge"; };
            SLOW_EDGE = 1 { name = "Slow Edge"; desc = "slow edge"; };
        };

        field {
            name = "padctrl_reg18_sr";
            desc = "Rising/Falling speed control of the output signal";
            sw = rw;
            hw = r;
            encode = PADCTRL_REG18_padctrl_reg18_sr_enum;
            reset = 0x1;
        } padctrl_reg18_sr[7:7];

        enum PADCTRL_REG18_padctrl_reg18_ds_enum {
            V_4_MA = 0 { name = "V 4 Ma"; desc = "4 mA"; };
            V_3_MA = 1 { name = "V 3 Ma"; desc = "3 mA"; };
            V_2_MA = 2 { name = "V 2 Ma"; desc = "2 mA"; };
            V_1_MA = 3 { name = "V 1 Ma"; desc = "1 mA"; };
        };

        field {
            name = "padctrl_reg18_ds";
            desc = "Drive capability of the SPI0_SDI pin";
            sw = rw;
            hw = r;
            encode = PADCTRL_REG18_padctrl_reg18_ds_enum;
            reset = 0x1;
        } padctrl_reg18_ds[5:4];
    } PADCTRL_REG18 @ 0x848;

    reg {
        name = "Control register for the SPI0_CSN functional pin";
        desc = "PADCTRL_REG19 is a control register for the SPI0_CSN functional pin.

Data sheet 2.6.2 PADCTRL_REG19 (offset 0x4C, printed page 2-113, `hi3518ev200-datasheet.txt` line 7633).";

        enum PADCTRL_REG19_padctrl_reg19_sr_enum {
            FAST_EDGE = 0 { name = "Fast Edge"; desc = "fast edge"; };
            SLOW_EDGE = 1 { name = "Slow Edge"; desc = "slow edge"; };
        };

        field {
            name = "padctrl_reg19_sr";
            desc = "Rising/Falling speed control of the output signal";
            sw = rw;
            hw = r;
            encode = PADCTRL_REG19_padctrl_reg19_sr_enum;
            reset = 0x1;
        } padctrl_reg19_sr[7:7];

        enum PADCTRL_REG19_padctrl_reg19_ds_enum {
            V_4_MA = 0 { name = "V 4 Ma"; desc = "4 mA"; };
            V_3_MA = 1 { name = "V 3 Ma"; desc = "3 mA"; };
            V_2_MA = 2 { name = "V 2 Ma"; desc = "2 mA"; };
            V_1_MA = 3 { name = "V 1 Ma"; desc = "1 mA"; };
        };

        field {
            name = "padctrl_reg19_ds";
            desc = "Drive capability of the SPI0_CSN pin";
            sw = rw;
            hw = r;
            encode = PADCTRL_REG19_padctrl_reg19_ds_enum;
            reset = 0x1;
        } padctrl_reg19_ds[5:4];
    } PADCTRL_REG19 @ 0x84C;

    reg {
        name = "Control register for the SPI1_SCLK functional pin";
        desc = "PADCTRL_REG20 is a control register for the SPI1_SCLK functional pin.

Data sheet 2.6.2 PADCTRL_REG20 (offset 0x50, printed page 2-114, `hi3518ev200-datasheet.txt` line 7674).";

        enum PADCTRL_REG20_padctrl_reg20_sr_enum {
            FAST_EDGE = 0 { name = "Fast Edge"; desc = "fast edge"; };
            SLOW_EDGE = 1 { name = "Slow Edge"; desc = "slow edge"; };
        };

        field {
            name = "padctrl_reg20_sr";
            desc = "Rising/Falling speed control of the output signal";
            sw = rw;
            hw = r;
            encode = PADCTRL_REG20_padctrl_reg20_sr_enum;
            reset = 0x1;
        } padctrl_reg20_sr[7:7];

        enum PADCTRL_REG20_padctrl_reg20_ds_enum {
            V_4_MA = 0 { name = "V 4 Ma"; desc = "4 mA"; };
            V_3_MA = 1 { name = "V 3 Ma"; desc = "3 mA"; };
            V_2_MA = 2 { name = "V 2 Ma"; desc = "2 mA"; };
            V_1_MA = 3 { name = "V 1 Ma"; desc = "1 mA"; };
        };

        field {
            name = "padctrl_reg20_ds";
            desc = "Drive capability of the SPI1_SCLK pin";
            sw = rw;
            hw = r;
            encode = PADCTRL_REG20_padctrl_reg20_ds_enum;
            reset = 0x1;
        } padctrl_reg20_ds[5:4];
    } PADCTRL_REG20 @ 0x850;

    reg {
        name = "Control register for the SPI1_SDO functional pin";
        desc = "PADCTRL_REG21 is a control register for the SPI1_SDO functional pin.

Data sheet 2.6.2 PADCTRL_REG21 (offset 0x54, printed page 2-115, `hi3518ev200-datasheet.txt` line 7720).";

        enum PADCTRL_REG21_padctrl_reg21_sr_enum {
            FAST_EDGE = 0 { name = "Fast Edge"; desc = "fast edge"; };
            SLOW_EDGE = 1 { name = "Slow Edge"; desc = "slow edge"; };
        };

        field {
            name = "padctrl_reg21_sr";
            desc = "Rising/Falling speed control of the output signal";
            sw = rw;
            hw = r;
            encode = PADCTRL_REG21_padctrl_reg21_sr_enum;
            reset = 0x1;
        } padctrl_reg21_sr[7:7];

        enum PADCTRL_REG21_padctrl_reg21_ds_enum {
            V_4_MA = 0 { name = "V 4 Ma"; desc = "4 mA"; };
            V_3_MA = 1 { name = "V 3 Ma"; desc = "3 mA"; };
            V_2_MA = 2 { name = "V 2 Ma"; desc = "2 mA"; };
            V_1_MA = 3 { name = "V 1 Ma"; desc = "1 mA"; };
        };

        field {
            name = "padctrl_reg21_ds";
            desc = "Drive capability of the SPI1_SDO pin";
            sw = rw;
            hw = r;
            encode = PADCTRL_REG21_padctrl_reg21_ds_enum;
            reset = 0x2;
        } padctrl_reg21_ds[5:4];
    } PADCTRL_REG21 @ 0x854;

    reg {
        name = "Control register for the SPI1_SDI functional pin";
        desc = "PADCTRL_REG22 is a control register for the SPI1_SDI functional pin.

Data sheet 2.6.2 PADCTRL_REG22 (offset 0x58, printed page 2-116, `hi3518ev200-datasheet.txt` line 7764).";

        enum PADCTRL_REG22_padctrl_reg22_sr_enum {
            FAST_EDGE = 0 { name = "Fast Edge"; desc = "fast edge"; };
            SLOW_EDGE = 1 { name = "Slow Edge"; desc = "slow edge"; };
        };

        field {
            name = "padctrl_reg22_sr";
            desc = "Rising/Falling speed control of the output signal";
            sw = rw;
            hw = r;
            encode = PADCTRL_REG22_padctrl_reg22_sr_enum;
            reset = 0x1;
        } padctrl_reg22_sr[7:7];

        enum PADCTRL_REG22_padctrl_reg22_ds_enum {
            V_4_MA = 0 { name = "V 4 Ma"; desc = "4 mA"; };
            V_3_MA = 1 { name = "V 3 Ma"; desc = "3 mA"; };
            V_2_MA = 2 { name = "V 2 Ma"; desc = "2 mA"; };
            V_1_MA = 3 { name = "V 1 Ma"; desc = "1 mA"; };
        };

        field {
            name = "padctrl_reg22_ds";
            desc = "Drive capability of the SPI1_SDI pin";
            sw = rw;
            hw = r;
            encode = PADCTRL_REG22_padctrl_reg22_ds_enum;
            reset = 0x2;
        } padctrl_reg22_ds[5:4];
    } PADCTRL_REG22 @ 0x858;

    reg {
        name = "Control register for the SPI1_CSN0 functional pin";
        desc = "PADCTRL_REG23 is a control register for the SPI1_CSN0 functional pin.

Data sheet 2.6.2 PADCTRL_REG23 (offset 0x5C, printed page 2-116, `hi3518ev200-datasheet.txt` line 7800).";

        enum PADCTRL_REG23_padctrl_reg23_sr_enum {
            FAST_EDGE = 0 { name = "Fast Edge"; desc = "fast edge"; };
            SLOW_EDGE = 1 { name = "Slow Edge"; desc = "slow edge"; };
        };

        field {
            name = "padctrl_reg23_sr";
            desc = "Rising/Falling speed control of the output signal";
            sw = rw;
            hw = r;
            encode = PADCTRL_REG23_padctrl_reg23_sr_enum;
            reset = 0x1;
        } padctrl_reg23_sr[7:7];

        enum PADCTRL_REG23_padctrl_reg23_ds_enum {
            V_4_MA = 0 { name = "V 4 Ma"; desc = "4 mA"; };
            V_3_MA = 1 { name = "V 3 Ma"; desc = "3 mA"; };
            V_2_MA = 2 { name = "V 2 Ma"; desc = "2 mA"; };
            V_1_MA = 3 { name = "V 1 Ma"; desc = "1 mA"; };
        };

        field {
            name = "padctrl_reg23_ds";
            desc = "Drive capability of the SPI1_CSN0 pin";
            sw = rw;
            hw = r;
            encode = PADCTRL_REG23_padctrl_reg23_ds_enum;
            reset = 0x2;
        } padctrl_reg23_ds[5:4];
    } PADCTRL_REG23 @ 0x85C;

    reg {
        name = "Control register for the I2C2_SDA functional pin";
        desc = "PADCTRL_REG24 is a control register for the I2C2_SDA functional pin.

Data sheet 2.6.2 PADCTRL_REG24 (offset 0x60, printed page 2-117, `hi3518ev200-datasheet.txt` line 7841).";

        enum PADCTRL_REG24_padctrl_reg24_sl_enum {
            SLOW_EDGE = 0 { name = "Slow Edge"; desc = "slow edge"; };
            FAST_EDGE = 1 { name = "Fast Edge"; desc = "fast edge"; };
        };

        field {
            name = "padctrl_reg24_sl";
            desc = "Rising/Falling speed control of the output signal";
            sw = rw;
            hw = r;
            encode = PADCTRL_REG24_padctrl_reg24_sl_enum;
            reset = 0x0;
        } padctrl_reg24_sl[7:7];

        enum PADCTRL_REG24_padctrl_reg24_ds_enum {
            V_1_MA = 0 { name = "V 1 Ma"; desc = "1 mA"; };
            V_2_MA = 1 { name = "V 2 Ma"; desc = "2 mA"; };
            V_3_MA = 2 { name = "V 3 Ma"; desc = "3 mA"; };
            V_4_MA = 3 { name = "V 4 Ma"; desc = "4 mA"; };
        };

        field {
            name = "padctrl_reg24_ds";
            desc = "Drive capability of the I2C2_SDA pin";
            sw = rw;
            hw = r;
            encode = PADCTRL_REG24_padctrl_reg24_ds_enum;
            reset = 0x1;
        } padctrl_reg24_ds[5:4];
    } PADCTRL_REG24 @ 0x860;

    reg {
        name = "Control register for the I2C2_SCL functional pin";
        desc = "PADCTRL_REG25 is a control register for the I2C2_SCL functional pin.

Data sheet 2.6.2 PADCTRL_REG25 (offset 0x64, printed page 2-118, `hi3518ev200-datasheet.txt` line 7887).";

        enum PADCTRL_REG25_padctrl_reg25_sr_enum {
            SLOW_EDGE = 0 { name = "Slow Edge"; desc = "slow edge"; };
            FAST_EDGE = 1 { name = "Fast Edge"; desc = "fast edge"; };
        };

        field {
            name = "padctrl_reg25_sr";
            desc = "Rising/Falling speed control of the output signal";
            sw = rw;
            hw = r;
            encode = PADCTRL_REG25_padctrl_reg25_sr_enum;
            reset = 0x0;
        } padctrl_reg25_sr[7:7];

        enum PADCTRL_REG25_padctrl_reg25_ds_enum {
            V_1_MA = 0 { name = "V 1 Ma"; desc = "1 mA"; };
            V_2_MA = 1 { name = "V 2 Ma"; desc = "2 mA"; };
            V_3_MA = 2 { name = "V 3 Ma"; desc = "3 mA"; };
            V_4_MA = 3 { name = "V 4 Ma"; desc = "4 mA"; };
        };

        field {
            name = "padctrl_reg25_ds";
            desc = "Drive capability of the I2C2_SCL pin";
            sw = rw;
            hw = r;
            encode = PADCTRL_REG25_padctrl_reg25_ds_enum;
            reset = 0x1;
        } padctrl_reg25_ds[5:4];
    } PADCTRL_REG25 @ 0x864;

    reg {
        name = "Control register for the UART0_RXD functional pin";
        desc = "PADCTRL_REG26 is a control register for the UART0_RXD functional pin.

Data sheet 2.6.2 PADCTRL_REG26 (offset 0x68, printed page 2-119, `hi3518ev200-datasheet.txt` line 7931).";

        enum PADCTRL_REG26_padctrl_reg26_sr_enum {
            FAST_EDGE = 0 { name = "Fast Edge"; desc = "fast edge"; };
            SLOW_EDGE = 1 { name = "Slow Edge"; desc = "slow edge"; };
        };

        field {
            name = "padctrl_reg26_sr";
            desc = "Rising/Falling speed control of the output signal";
            sw = rw;
            hw = r;
            encode = PADCTRL_REG26_padctrl_reg26_sr_enum;
            reset = 0x1;
        } padctrl_reg26_sr[7:7];

        enum PADCTRL_REG26_padctrl_reg26_ds_enum {
            V_4_MA = 0 { name = "V 4 Ma"; desc = "4 mA"; };
            V_3_MA = 1 { name = "V 3 Ma"; desc = "3 mA"; };
            V_2_MA = 2 { name = "V 2 Ma"; desc = "2 mA"; };
            V_1_MA = 3 { name = "V 1 Ma"; desc = "1 mA"; };
        };

        field {
            name = "padctrl_reg26_ds";
            desc = "Drive capability of the UART0_RXD pin";
            sw = rw;
            hw = r;
            encode = PADCTRL_REG26_padctrl_reg26_ds_enum;
            reset = 0x3;
        } padctrl_reg26_ds[5:4];
    } PADCTRL_REG26 @ 0x868;

    reg {
        name = "Control register for the UART0_TXD functional pin";
        desc = "PADCTRL_REG27 is a control register for the UART0_TXD functional pin.

Data sheet 2.6.2 PADCTRL_REG27 (offset 0x6C, printed page 2-119, `hi3518ev200-datasheet.txt` line 7967).";

        enum PADCTRL_REG27_padctrl_reg27_sr_enum {
            FAST_EDGE = 0 { name = "Fast Edge"; desc = "fast edge"; };
            SLOW_EDGE = 1 { name = "Slow Edge"; desc = "slow edge"; };
        };

        field {
            name = "padctrl_reg27_sr";
            desc = "Rising/Falling speed control of the output signal";
            sw = rw;
            hw = r;
            encode = PADCTRL_REG27_padctrl_reg27_sr_enum;
            reset = 0x1;
        } padctrl_reg27_sr[7:7];

        enum PADCTRL_REG27_padctrl_reg27_ds_enum {
            V_4_MA = 0 { name = "V 4 Ma"; desc = "4 mA"; };
            V_3_MA = 1 { name = "V 3 Ma"; desc = "3 mA"; };
            V_2_MA = 2 { name = "V 2 Ma"; desc = "2 mA"; };
            V_1_MA = 3 { name = "V 1 Ma"; desc = "1 mA"; };
        };

        field {
            name = "padctrl_reg27_ds";
            desc = "Drive capability of the UART0_TXD pin";
            sw = rw;
            hw = r;
            encode = PADCTRL_REG27_padctrl_reg27_ds_enum;
            reset = 0x3;
        } padctrl_reg27_ds[5:4];
    } PADCTRL_REG27 @ 0x86C;

    reg {
        name = "Control register for the USB_OVRCUR functional pin";
        desc = "PADCTRL_REG30 is a control register for the USB_OVRCUR functional pin.

Data sheet 2.6.2 PADCTRL_REG30 (offset 0x78, printed page 2-120, `hi3518ev200-datasheet.txt` line 8010).";

        enum PADCTRL_REG30_padctrl_reg30_sr_enum {
            FAST_EDGE = 0 { name = "Fast Edge"; desc = "fast edge"; };
            SLOW_EDGE = 1 { name = "Slow Edge"; desc = "slow edge"; };
        };

        field {
            name = "padctrl_reg30_sr";
            desc = "Rising/Falling speed control of the output signal";
            sw = rw;
            hw = r;
            encode = PADCTRL_REG30_padctrl_reg30_sr_enum;
            reset = 0x1;
        } padctrl_reg30_sr[7:7];

        enum PADCTRL_REG30_padctrl_reg30_ds_enum {
            V_4_MA = 0 { name = "V 4 Ma"; desc = "4 mA"; };
            V_3_MA = 1 { name = "V 3 Ma"; desc = "3 mA"; };
            V_2_MA = 2 { name = "V 2 Ma"; desc = "2 mA"; };
            V_1_MA = 3 { name = "V 1 Ma"; desc = "1 mA"; };
        };

        field {
            name = "padctrl_reg30_ds";
            desc = "Drive capability of the USB_OVRCUR pin";
            sw = rw;
            hw = r;
            encode = PADCTRL_REG30_padctrl_reg30_ds_enum;
            reset = 0x3;
        } padctrl_reg30_ds[5:4];
    } PADCTRL_REG30 @ 0x878;

    reg {
        name = "Control register for the USB_PWREN functional pin";
        desc = "PADCTRL_REG31 is a control register for the USB_PWREN functional pin.

Data sheet 2.6.2 PADCTRL_REG31 (offset 0x7C, printed page 2-121, `hi3518ev200-datasheet.txt` line 8052).";

        enum PADCTRL_REG31_padctrl_reg31_sr_enum {
            FAST_EDGE = 0 { name = "Fast Edge"; desc = "fast edge"; };
            SLOW_EDGE = 1 { name = "Slow Edge"; desc = "slow edge"; };
        };

        field {
            name = "padctrl_reg31_sr";
            desc = "Rising/Falling speed control of the output signal";
            sw = rw;
            hw = r;
            encode = PADCTRL_REG31_padctrl_reg31_sr_enum;
            reset = 0x1;
        } padctrl_reg31_sr[7:7];

        enum PADCTRL_REG31_padctrl_reg31_ds_enum {
            V_4_MA = 0 { name = "V 4 Ma"; desc = "4 mA"; };
            V_3_MA = 1 { name = "V 3 Ma"; desc = "3 mA"; };
            V_2_MA = 2 { name = "V 2 Ma"; desc = "2 mA"; };
            V_1_MA = 3 { name = "V 1 Ma"; desc = "1 mA"; };
        };

        field {
            name = "padctrl_reg31_ds";
            desc = "Drive capability of the USB_PWREN pin";
            sw = rw;
            hw = r;
            encode = PADCTRL_REG31_padctrl_reg31_ds_enum;
            reset = 0x3;
        } padctrl_reg31_ds[5:4];
    } PADCTRL_REG31 @ 0x87C;

    reg {
        name = "Control register for the GPIO0_0 functional pin";
        desc = "PADCTRL_REG32 is a control register for the GPIO0_0 functional pin.

Data sheet 2.6.2 PADCTRL_REG32 (offset 0x80, printed page 2-122, `hi3518ev200-datasheet.txt` line 8096).";

        enum PADCTRL_REG32_padctrl_reg32_sl_enum {
            SLOW_EDGE = 0 { name = "Slow Edge"; desc = "slow edge"; };
            FAST_EDGE = 1 { name = "Fast Edge"; desc = "fast edge"; };
        };

        field {
            name = "padctrl_reg32_sl";
            desc = "Rising/Falling speed control of the output signal";
            sw = rw;
            hw = r;
            encode = PADCTRL_REG32_padctrl_reg32_sl_enum;
            reset = 0x0;
        } padctrl_reg32_sl[7:7];

        enum PADCTRL_REG32_padctrl_reg32_ds_enum {
            V_1_MA = 0 { name = "V 1 Ma"; desc = "1 mA"; };
            V_2_MA = 1 { name = "V 2 Ma"; desc = "2 mA"; };
            V_3_MA = 2 { name = "V 3 Ma"; desc = "3 mA"; };
            V_4_MA = 3 { name = "V 4 Ma"; desc = "4 mA"; };
        };

        field {
            name = "padctrl_reg32_ds";
            desc = "Drive capability of the GPIO0_0 pin";
            sw = rw;
            hw = r;
            encode = PADCTRL_REG32_padctrl_reg32_ds_enum;
            reset = 0x0;
        } padctrl_reg32_ds[5:4];
    } PADCTRL_REG32 @ 0x880;

    reg {
        name = "Control register for the GPIO0_1 functional pin";
        desc = "PADCTRL_REG33 is a control register for the GPIO0_1 functional pin.

Data sheet 2.6.2 PADCTRL_REG33 (offset 0x84, printed page 2-122, `hi3518ev200-datasheet.txt` line 8131).";

        enum PADCTRL_REG33_padctrl_reg33_sl_enum {
            SLOW_EDGE = 0 { name = "Slow Edge"; desc = "slow edge"; };
            FAST_EDGE = 1 { name = "Fast Edge"; desc = "fast edge"; };
        };

        field {
            name = "padctrl_reg33_sl";
            desc = "Rising/Falling speed control of the output signal";
            sw = rw;
            hw = r;
            encode = PADCTRL_REG33_padctrl_reg33_sl_enum;
            reset = 0x0;
        } padctrl_reg33_sl[7:7];

        enum PADCTRL_REG33_padctrl_reg33_ds_enum {
            V_1_MA = 0 { name = "V 1 Ma"; desc = "1 mA"; };
            V_2_MA = 1 { name = "V 2 Ma"; desc = "2 mA"; };
            V_3_MA = 2 { name = "V 3 Ma"; desc = "3 mA"; };
            V_4_MA = 3 { name = "V 4 Ma"; desc = "4 mA"; };
        };

        field {
            name = "padctrl_reg33_ds";
            desc = "Drive capability of the GPIO0_1 pin";
            sw = rw;
            hw = r;
            encode = PADCTRL_REG33_padctrl_reg33_ds_enum;
            reset = 0x0;
        } padctrl_reg33_ds[5:4];
    } PADCTRL_REG33 @ 0x884;

    reg {
        name = "Control register for the GPIO0_2 functional pin";
        desc = "PADCTRL_REG34 is a control register for the GPIO0_2 functional pin.

Data sheet 2.6.2 PADCTRL_REG34 (offset 0x88, printed page 2-123, `hi3518ev200-datasheet.txt` line 8172).";

        enum PADCTRL_REG34_padctrl_reg34_sl_enum {
            SLOW_EDGE = 0 { name = "Slow Edge"; desc = "slow edge"; };
            FAST_EDGE = 1 { name = "Fast Edge"; desc = "fast edge"; };
        };

        field {
            name = "padctrl_reg34_sl";
            desc = "Rising/Falling speed control of the output signal";
            sw = rw;
            hw = r;
            encode = PADCTRL_REG34_padctrl_reg34_sl_enum;
            reset = 0x0;
        } padctrl_reg34_sl[7:7];

        enum PADCTRL_REG34_padctrl_reg34_ds_enum {
            V_1_MA = 0 { name = "V 1 Ma"; desc = "1 mA"; };
            V_2_MA = 1 { name = "V 2 Ma"; desc = "2 mA"; };
            V_3_MA = 2 { name = "V 3 Ma"; desc = "3 mA"; };
            V_4_MA = 3 { name = "V 4 Ma"; desc = "4 mA"; };
        };

        field {
            name = "padctrl_reg34_ds";
            desc = "Drive capability of the GPIO0_2 pin";
            sw = rw;
            hw = r;
            encode = PADCTRL_REG34_padctrl_reg34_ds_enum;
            reset = 0x0;
        } padctrl_reg34_ds[5:4];
    } PADCTRL_REG34 @ 0x888;

    reg {
        name = "Control register for the GPIO1_0 functional pin";
        desc = "PADCTRL_REG35 is a control register for the GPIO1_0 functional pin.

Data sheet 2.6.2 PADCTRL_REG35 (offset 0x8C, printed page 2-124, `hi3518ev200-datasheet.txt` line 8218).";

        enum PADCTRL_REG35_padctrl_reg35_sr_enum {
            FAST_EDGE = 0 { name = "Fast Edge"; desc = "fast edge"; };
            SLOW_EDGE = 1 { name = "Slow Edge"; desc = "slow edge"; };
        };

        field {
            name = "padctrl_reg35_sr";
            desc = "Rising/Falling speed control of the output signal";
            sw = rw;
            hw = r;
            encode = PADCTRL_REG35_padctrl_reg35_sr_enum;
            reset = 0x1;
        } padctrl_reg35_sr[7:7];

        enum PADCTRL_REG35_padctrl_reg35_ds_enum {
            V_4_MA = 0 { name = "V 4 Ma"; desc = "4 mA"; };
            V_3_MA = 1 { name = "V 3 Ma"; desc = "3 mA"; };
            V_2_MA = 2 { name = "V 2 Ma"; desc = "2 mA"; };
            V_1_MA = 3 { name = "V 1 Ma"; desc = "1 mA"; };
        };

        field {
            name = "padctrl_reg35_ds";
            desc = "Drive capability of the GPIO1_0 pin";
            sw = rw;
            hw = r;
            encode = PADCTRL_REG35_padctrl_reg35_ds_enum;
            reset = 0x3;
        } padctrl_reg35_ds[5:4];
    } PADCTRL_REG35 @ 0x88C;

    reg {
        name = "Control register for the GPIO1_1 functional pin";
        desc = "PADCTRL_REG36 is a control register for the GPIO1_1 functional pin.

Data sheet 2.6.2 PADCTRL_REG36 (offset 0x90, printed page 2-125, `hi3518ev200-datasheet.txt` line 8263).";

        enum PADCTRL_REG36_padctrl_reg36_sr_enum {
            FAST_EDGE = 0 { name = "Fast Edge"; desc = "fast edge"; };
            SLOW_EDGE = 1 { name = "Slow Edge"; desc = "slow edge"; };
        };

        field {
            name = "padctrl_reg36_sr";
            desc = "Rising/Falling speed control of the output signal";
            sw = rw;
            hw = r;
            encode = PADCTRL_REG36_padctrl_reg36_sr_enum;
            reset = 0x1;
        } padctrl_reg36_sr[7:7];

        enum PADCTRL_REG36_padctrl_reg36_ds_enum {
            V_4_MA = 0 { name = "V 4 Ma"; desc = "4 mA"; };
            V_3_MA = 1 { name = "V 3 Ma"; desc = "3 mA"; };
            V_2_MA = 2 { name = "V 2 Ma"; desc = "2 mA"; };
            V_1_MA = 3 { name = "V 1 Ma"; desc = "1 mA"; };
        };

        field {
            name = "padctrl_reg36_ds";
            desc = "Drive capability of the GPIO1_1 pin";
            sw = rw;
            hw = r;
            encode = PADCTRL_REG36_padctrl_reg36_ds_enum;
            reset = 0x3;
        } padctrl_reg36_ds[5:4];
    } PADCTRL_REG36 @ 0x890;

    reg {
        name = "Control register for the GPIO1_2 functional pin";
        desc = "PADCTRL_REG37 is a control register for the GPIO1_2 functional pin.

Data sheet 2.6.2 PADCTRL_REG37 (offset 0x94, printed page 2-125, `hi3518ev200-datasheet.txt` line 8299).";

        enum PADCTRL_REG37_padctrl_reg37_sr_enum {
            FAST_EDGE = 0 { name = "Fast Edge"; desc = "fast edge"; };
            SLOW_EDGE = 1 { name = "Slow Edge"; desc = "slow edge"; };
        };

        field {
            name = "padctrl_reg37_sr";
            desc = "Rising/Falling speed control of the output signal";
            sw = rw;
            hw = r;
            encode = PADCTRL_REG37_padctrl_reg37_sr_enum;
            reset = 0x1;
        } padctrl_reg37_sr[7:7];

        enum PADCTRL_REG37_padctrl_reg37_ds_enum {
            V_4_MA = 0 { name = "V 4 Ma"; desc = "4 mA"; };
            V_3_MA = 1 { name = "V 3 Ma"; desc = "3 mA"; };
            V_2_MA = 2 { name = "V 2 Ma"; desc = "2 mA"; };
            V_1_MA = 3 { name = "V 1 Ma"; desc = "1 mA"; };
        };

        field {
            name = "padctrl_reg37_ds";
            desc = "Drive capability of the GPIO1_2 pin";
            sw = rw;
            hw = r;
            encode = PADCTRL_REG37_padctrl_reg37_ds_enum;
            reset = 0x3;
        } padctrl_reg37_ds[5:4];
    } PADCTRL_REG37 @ 0x894;

    reg {
        name = "Control register for the GPIO1_3 functional pin";
        desc = "PADCTRL_REG38 is a control register for the GPIO1_3 functional pin.

Data sheet 2.6.2 PADCTRL_REG38 (offset 0x98, printed page 2-126, `hi3518ev200-datasheet.txt` line 8340).";

        enum PADCTRL_REG38_padctrl_reg38_sr_enum {
            FAST_EDGE = 0 { name = "Fast Edge"; desc = "fast edge"; };
            SLOW_EDGE = 1 { name = "Slow Edge"; desc = "slow edge"; };
        };

        field {
            name = "padctrl_reg38_sr";
            desc = "Rising/Falling speed control of the output signal";
            sw = rw;
            hw = r;
            encode = PADCTRL_REG38_padctrl_reg38_sr_enum;
            reset = 0x1;
        } padctrl_reg38_sr[7:7];

        enum PADCTRL_REG38_padctrl_reg38_ds_enum {
            V_4_MA = 0 { name = "V 4 Ma"; desc = "4 mA"; };
            V_3_MA = 1 { name = "V 3 Ma"; desc = "3 mA"; };
            V_2_MA = 2 { name = "V 2 Ma"; desc = "2 mA"; };
            V_1_MA = 3 { name = "V 1 Ma"; desc = "1 mA"; };
        };

        field {
            name = "padctrl_reg38_ds";
            desc = "Drive capability of the GPIO1_3 pin";
            sw = rw;
            hw = r;
            encode = PADCTRL_REG38_padctrl_reg38_ds_enum;
            reset = 0x3;
        } padctrl_reg38_ds[5:4];
    } PADCTRL_REG38 @ 0x898;

    reg {
        name = "Control register for the GPIO1_4 functional pin";
        desc = "PADCTRL_REG39 is a control register for the GPIO1_4 functional pin.

Data sheet 2.6.2 PADCTRL_REG39 (offset 0x9C, printed page 2-127, `hi3518ev200-datasheet.txt` line 8385).";

        enum PADCTRL_REG39_padctrl_reg39_sr_enum {
            FAST_EDGE = 0 { name = "Fast Edge"; desc = "fast edge"; };
            SLOW_EDGE = 1 { name = "Slow Edge"; desc = "slow edge"; };
        };

        field {
            name = "padctrl_reg39_sr";
            desc = "Rising/Falling speed control of the output signal";
            sw = rw;
            hw = r;
            encode = PADCTRL_REG39_padctrl_reg39_sr_enum;
            reset = 0x1;
        } padctrl_reg39_sr[7:7];

        enum PADCTRL_REG39_padctrl_reg39_ds_enum {
            V_4_MA = 0 { name = "V 4 Ma"; desc = "4 mA"; };
            V_3_MA = 1 { name = "V 3 Ma"; desc = "3 mA"; };
            V_2_MA = 2 { name = "V 2 Ma"; desc = "2 mA"; };
            V_1_MA = 3 { name = "V 1 Ma"; desc = "1 mA"; };
        };

        field {
            name = "padctrl_reg39_ds";
            desc = "Drive capability of the GPIO1_4 pin";
            sw = rw;
            hw = r;
            encode = PADCTRL_REG39_padctrl_reg39_ds_enum;
            reset = 0x3;
        } padctrl_reg39_ds[5:4];
    } PADCTRL_REG39 @ 0x89C;

    reg {
        name = "Control register for the GPIO1_5 functional pin";
        desc = "PADCTRL_REG40 is a control register for the GPIO1_5 functional pin.

Data sheet 2.6.2 PADCTRL_REG40 (offset 0xA0, printed page 2-128, `hi3518ev200-datasheet.txt` line 8430).";

        enum PADCTRL_REG40_padctrl_reg40_sr_enum {
            FAST_EDGE = 0 { name = "Fast Edge"; desc = "fast edge"; };
            SLOW_EDGE = 1 { name = "Slow Edge"; desc = "slow edge"; };
        };

        field {
            name = "padctrl_reg40_sr";
            desc = "Rising/Falling speed control of the output signal";
            sw = rw;
            hw = r;
            encode = PADCTRL_REG40_padctrl_reg40_sr_enum;
            reset = 0x1;
        } padctrl_reg40_sr[7:7];

        enum PADCTRL_REG40_padctrl_reg40_ds_enum {
            V_4_MA = 0 { name = "V 4 Ma"; desc = "4 mA"; };
            V_3_MA = 1 { name = "V 3 Ma"; desc = "3 mA"; };
            V_2_MA = 2 { name = "V 2 Ma"; desc = "2 mA"; };
            V_1_MA = 3 { name = "V 1 Ma"; desc = "1 mA"; };
        };

        field {
            name = "padctrl_reg40_ds";
            desc = "Drive capability of the GPIO1_5 pin";
            sw = rw;
            hw = r;
            encode = PADCTRL_REG40_padctrl_reg40_ds_enum;
            reset = 0x3;
        } padctrl_reg40_ds[5:4];
    } PADCTRL_REG40 @ 0x8A0;

    reg {
        name = "Control register for the GPIO1_6 functional pin";
        desc = "PADCTRL_REG41 is a control register for the GPIO1_6 functional pin.

Data sheet 2.6.2 PADCTRL_REG41 (offset 0xA4, printed page 2-128, `hi3518ev200-datasheet.txt` line 8466).";

        enum PADCTRL_REG41_padctrl_reg41_sr_enum {
            FAST_EDGE = 0 { name = "Fast Edge"; desc = "fast edge"; };
            SLOW_EDGE = 1 { name = "Slow Edge"; desc = "slow edge"; };
        };

        field {
            name = "padctrl_reg41_sr";
            desc = "Rising/Falling speed control of the output signal";
            sw = rw;
            hw = r;
            encode = PADCTRL_REG41_padctrl_reg41_sr_enum;
            reset = 0x1;
        } padctrl_reg41_sr[7:7];

        enum PADCTRL_REG41_padctrl_reg41_ds_enum {
            V_4_MA = 0 { name = "V 4 Ma"; desc = "4 mA"; };
            V_3_MA = 1 { name = "V 3 Ma"; desc = "3 mA"; };
            V_2_MA = 2 { name = "V 2 Ma"; desc = "2 mA"; };
            V_1_MA = 3 { name = "V 1 Ma"; desc = "1 mA"; };
        };

        field {
            name = "padctrl_reg41_ds";
            desc = "Drive capability of the GPIO1_6 pin";
            sw = rw;
            hw = r;
            encode = PADCTRL_REG41_padctrl_reg41_ds_enum;
            reset = 0x3;
        } padctrl_reg41_ds[5:4];
    } PADCTRL_REG41 @ 0x8A4;

    reg {
        name = "Control register for the SDIO0_CARD_POWER_EN functional pin";
        desc = "PADCTRL_REG42 is a control register for the SDIO0_CARD_POWER_EN functional pin.

Data sheet 2.6.2 PADCTRL_REG42 (offset 0xA8, printed page 2-129, `hi3518ev200-datasheet.txt` line 8507).";

        enum PADCTRL_REG42_padctrl_reg42_sr_enum {
            FAST_EDGE = 0 { name = "Fast Edge"; desc = "fast edge"; };
            SLOW_EDGE = 1 { name = "Slow Edge"; desc = "slow edge"; };
        };

        field {
            name = "padctrl_reg42_sr";
            desc = "Rising/Falling speed control of the output signal";
            sw = rw;
            hw = r;
            encode = PADCTRL_REG42_padctrl_reg42_sr_enum;
            reset = 0x1;
        } padctrl_reg42_sr[7:7];

        enum PADCTRL_REG42_padctrl_reg42_ds_enum {
            V_4_MA = 0 { name = "V 4 Ma"; desc = "4 mA"; };
            V_3_MA = 1 { name = "V 3 Ma"; desc = "3 mA"; };
            V_2_MA = 2 { name = "V 2 Ma"; desc = "2 mA"; };
            V_1_MA = 3 { name = "V 1 Ma"; desc = "1 mA"; };
        };

        field {
            name = "padctrl_reg42_ds";
            desc = "Drive capability of the SDIO0_CARD_POWER_EN pin";
            sw = rw;
            hw = r;
            encode = PADCTRL_REG42_padctrl_reg42_ds_enum;
            reset = 0x3;
        } padctrl_reg42_ds[5:4];
    } PADCTRL_REG42 @ 0x8A8;

    reg {
        name = "Control register for the SDIO0_CARD_DETECT functional pin";
        desc = "PADCTRL_REG43 is a control register for the SDIO0_CARD_DETECT functional pin.

Data sheet 2.6.2 PADCTRL_REG43 (offset 0xAC, printed page 2-130, `hi3518ev200-datasheet.txt` line 8553).";

        enum PADCTRL_REG43_padctrl_reg43_sr_enum {
            FAST_EDGE = 0 { name = "Fast Edge"; desc = "fast edge"; };
            SLOW_EDGE = 1 { name = "Slow Edge"; desc = "slow edge"; };
        };

        field {
            name = "padctrl_reg43_sr";
            desc = "Rising/Falling speed control of the output signal";
            sw = rw;
            hw = r;
            encode = PADCTRL_REG43_padctrl_reg43_sr_enum;
            reset = 0x1;
        } padctrl_reg43_sr[7:7];

        enum PADCTRL_REG43_padctrl_reg43_ds_enum {
            V_4_MA = 0 { name = "V 4 Ma"; desc = "4 mA"; };
            V_3_MA = 1 { name = "V 3 Ma"; desc = "3 mA"; };
            V_2_MA = 2 { name = "V 2 Ma"; desc = "2 mA"; };
            V_1_MA = 3 { name = "V 1 Ma"; desc = "1 mA"; };
        };

        field {
            name = "padctrl_reg43_ds";
            desc = "Drive capability of the SDIO0_CARD_DETECT pin";
            sw = rw;
            hw = r;
            encode = PADCTRL_REG43_padctrl_reg43_ds_enum;
            reset = 0x3;
        } padctrl_reg43_ds[5:4];
    } PADCTRL_REG43 @ 0x8AC;

    reg {
        name = "Control register for the SDIO0_CWPR functional pin";
        desc = "PADCTRL_REG44 is a control register for the SDIO0_CWPR functional pin.

Data sheet 2.6.2 PADCTRL_REG44 (offset 0xB0, printed page 2-131, `hi3518ev200-datasheet.txt` line 8597).";

        enum PADCTRL_REG44_padctrl_reg44_sr_enum {
            FAST_EDGE = 0 { name = "Fast Edge"; desc = "fast edge"; };
            SLOW_EDGE = 1 { name = "Slow Edge"; desc = "slow edge"; };
        };

        field {
            name = "padctrl_reg44_sr";
            desc = "Rising/Falling speed control of the output signal";
            sw = rw;
            hw = r;
            encode = PADCTRL_REG44_padctrl_reg44_sr_enum;
            reset = 0x1;
        } padctrl_reg44_sr[7:7];

        enum PADCTRL_REG44_padctrl_reg44_ds_enum {
            V_4_MA = 0 { name = "V 4 Ma"; desc = "4 mA"; };
            V_3_MA = 1 { name = "V 3 Ma"; desc = "3 mA"; };
            V_2_MA = 2 { name = "V 2 Ma"; desc = "2 mA"; };
            V_1_MA = 3 { name = "V 1 Ma"; desc = "1 mA"; };
        };

        field {
            name = "padctrl_reg44_ds";
            desc = "Drive capability of the SDIO0_CWPR pin";
            sw = rw;
            hw = r;
            encode = PADCTRL_REG44_padctrl_reg44_ds_enum;
            reset = 0x3;
        } padctrl_reg44_ds[5:4];
    } PADCTRL_REG44 @ 0x8B0;

    reg {
        name = "Control register for the SDIO0_CCLK_OUT functional pin";
        desc = "PADCTRL_REG45 is a control register for the SDIO0_CCLK_OUT functional pin.

Data sheet 2.6.2 PADCTRL_REG45 (offset 0xB4, printed page 2-131, `hi3518ev200-datasheet.txt` line 8633).";

        enum PADCTRL_REG45_padctrl_reg45_sr_enum {
            FAST_EDGE = 0 { name = "Fast Edge"; desc = "fast edge"; };
            SLOW_EDGE = 1 { name = "Slow Edge"; desc = "slow edge"; };
        };

        field {
            name = "padctrl_reg45_sr";
            desc = "Rising/Falling speed control of the output signal";
            sw = rw;
            hw = r;
            encode = PADCTRL_REG45_padctrl_reg45_sr_enum;
            reset = 0x1;
        } padctrl_reg45_sr[7:7];

        enum PADCTRL_REG45_padctrl_reg45_ds_enum {
            V_18_MA = 0 { name = "V 18 Ma"; desc = "18 mA"; };
            V_16_MA = 1 { name = "V 16 Ma"; desc = "16 mA"; };
            V_14_MA = 2 { name = "V 14 Ma"; desc = "14 mA"; };
            V_12_MA = 3 { name = "V 12 Ma"; desc = "12 mA"; };
            V_5_MA = 4 { name = "V 5 Ma"; desc = "5 mA"; };
            V_4_MA = 5 { name = "V 4 Ma"; desc = "4 mA"; };
            V_2_MA = 6 { name = "V 2 Ma"; desc = "2 mA"; };
            V_1_MA = 7 { name = "V 1 Ma"; desc = "1 mA"; };
        };

        field {
            name = "padctrl_reg45_ds";
            desc = "Drive capability of the SDIO0_CCLK_OUT pin";
            sw = rw;
            hw = r;
            encode = PADCTRL_REG45_padctrl_reg45_ds_enum;
            reset = 0x5;
        } padctrl_reg45_ds[6:4];
    } PADCTRL_REG45 @ 0x8B4;

    reg {
        name = "Control register for the SDIO0_CCMD functional pin";
        desc = "PADCTRL_REG46 is a control register for the SDIO0_CCMD functional pin.

Data sheet 2.6.2 PADCTRL_REG46 (offset 0xB8, printed page 2-132, `hi3518ev200-datasheet.txt` line 8677).";

        enum PADCTRL_REG46_padctrl_reg46_sr_enum {
            FAST_EDGE = 0 { name = "Fast Edge"; desc = "fast edge"; };
            SLOW_EDGE = 1 { name = "Slow Edge"; desc = "slow edge"; };
        };

        field {
            name = "padctrl_reg46_sr";
            desc = "Rising/Falling speed control of the output signal";
            sw = rw;
            hw = r;
            encode = PADCTRL_REG46_padctrl_reg46_sr_enum;
            reset = 0x1;
        } padctrl_reg46_sr[7:7];

        enum PADCTRL_REG46_padctrl_reg46_ds_enum {
            V_12_MA = 0 { name = "V 12 Ma"; desc = "12 mA"; };
            V_11_MA = 1 { name = "V 11 Ma"; desc = "11 mA"; };
            V_9_MA = 2 { name = "V 9 Ma"; desc = "9 mA"; };
            V_8_MA = 3 { name = "V 8 Ma"; desc = "8 mA"; };
            V_5_MA = 4 { name = "V 5 Ma"; desc = "5 mA"; };
            V_4_MA = 5 { name = "V 4 Ma"; desc = "4 mA"; };
            V_2_MA = 6 { name = "V 2 Ma"; desc = "2 mA"; };
            V_1_MA = 7 { name = "V 1 Ma"; desc = "1 mA"; };
        };

        field {
            name = "padctrl_reg46_ds";
            desc = "Drive capability of the SDIO0_CCMD pin";
            sw = rw;
            hw = r;
            encode = PADCTRL_REG46_padctrl_reg46_ds_enum;
            reset = 0x6;
        } padctrl_reg46_ds[6:4];
    } PADCTRL_REG46 @ 0x8B8;

    reg {
        name = "Control register for the SDIO0_CDATA0 functional pin";
        desc = "PADCTRL_REG47 is a control register for the SDIO0_CDATA0 functional pin.

Data sheet 2.6.2 PADCTRL_REG47 (offset 0xBC, printed page 2-133, `hi3518ev200-datasheet.txt` line 8726).";

        enum PADCTRL_REG47_padctrl_reg47_sr_enum {
            FAST_EDGE = 0 { name = "Fast Edge"; desc = "fast edge"; };
            SLOW_EDGE = 1 { name = "Slow Edge"; desc = "slow edge"; };
        };

        field {
            name = "padctrl_reg47_sr";
            desc = "Rising/Falling speed control of the output signal";
            sw = rw;
            hw = r;
            encode = PADCTRL_REG47_padctrl_reg47_sr_enum;
            reset = 0x1;
        } padctrl_reg47_sr[7:7];

        enum PADCTRL_REG47_padctrl_reg47_ds_enum {
            V_12_MA = 0 { name = "V 12 Ma"; desc = "12 mA"; };
            V_11_MA = 1 { name = "V 11 Ma"; desc = "11 mA"; };
            V_9_MA = 2 { name = "V 9 Ma"; desc = "9 mA"; };
            V_8_MA = 3 { name = "V 8 Ma"; desc = "8 mA"; };
            V_5_MA = 4 { name = "V 5 Ma"; desc = "5 mA"; };
            V_4_MA = 5 { name = "V 4 Ma"; desc = "4 mA"; };
            V_2_MA = 6 { name = "V 2 Ma"; desc = "2 mA"; };
            V_1_MA = 7 { name = "V 1 Ma"; desc = "1 mA"; };
        };

        field {
            name = "padctrl_reg47_ds";
            desc = "Drive capability of the SDIO0_CDATA0 pin";
            sw = rw;
            hw = r;
            encode = PADCTRL_REG47_padctrl_reg47_ds_enum;
            reset = 0x6;
        } padctrl_reg47_ds[6:4];
    } PADCTRL_REG47 @ 0x8BC;

    reg {
        name = "Control register for the SDIO0_CDATA1 functional pin";
        desc = "PADCTRL_REG48 is a control register for the SDIO0_CDATA1 functional pin.

Data sheet 2.6.2 PADCTRL_REG48 (offset 0xC0, printed page 2-134, `hi3518ev200-datasheet.txt` line 8774).";

        enum PADCTRL_REG48_padctrl_reg48_sr_enum {
            FAST_EDGE = 0 { name = "Fast Edge"; desc = "fast edge"; };
            SLOW_EDGE = 1 { name = "Slow Edge"; desc = "slow edge"; };
        };

        field {
            name = "padctrl_reg48_sr";
            desc = "Rising/Falling speed control of the output signal";
            sw = rw;
            hw = r;
            encode = PADCTRL_REG48_padctrl_reg48_sr_enum;
            reset = 0x1;
        } padctrl_reg48_sr[7:7];

        enum PADCTRL_REG48_padctrl_reg48_ds_enum {
            V_12_MA = 0 { name = "V 12 Ma"; desc = "12 mA"; };
            V_11_MA = 1 { name = "V 11 Ma"; desc = "11 mA"; };
            V_9_MA = 2 { name = "V 9 Ma"; desc = "9 mA"; };
            V_8_MA = 3 { name = "V 8 Ma"; desc = "8 mA"; };
            V_5_MA = 4 { name = "V 5 Ma"; desc = "5 mA"; };
            V_4_MA = 5 { name = "V 4 Ma"; desc = "4 mA"; };
            V_2_MA = 6 { name = "V 2 Ma"; desc = "2 mA"; };
            V_1_MA = 7 { name = "V 1 Ma"; desc = "1 mA"; };
        };

        field {
            name = "padctrl_reg48_ds";
            desc = "Drive capability of the SDIO0_CDATA1 pin";
            sw = rw;
            hw = r;
            encode = PADCTRL_REG48_padctrl_reg48_ds_enum;
            reset = 0x6;
        } padctrl_reg48_ds[6:4];
    } PADCTRL_REG48 @ 0x8C0;

    reg {
        name = "Control register for the SDIO0_CDATA2 functional pin";
        desc = "PADCTRL_REG49 is a control register for the SDIO0_CDATA2 functional pin.

Data sheet 2.6.2 PADCTRL_REG49 (offset 0xC4, printed page 2-135, `hi3518ev200-datasheet.txt` line 8822).";

        enum PADCTRL_REG49_padctrl_reg49_sr_enum {
            FAST_EDGE = 0 { name = "Fast Edge"; desc = "fast edge"; };
            SLOW_EDGE = 1 { name = "Slow Edge"; desc = "slow edge"; };
        };

        field {
            name = "padctrl_reg49_sr";
            desc = "Rising/Falling speed control of the output signal";
            sw = rw;
            hw = r;
            encode = PADCTRL_REG49_padctrl_reg49_sr_enum;
            reset = 0x1;
        } padctrl_reg49_sr[7:7];

        enum PADCTRL_REG49_padctrl_reg49_ds_enum {
            V_12_MA = 0 { name = "V 12 Ma"; desc = "12 mA"; };
            V_11_MA = 1 { name = "V 11 Ma"; desc = "11 mA"; };
            V_9_MA = 2 { name = "V 9 Ma"; desc = "9 mA"; };
            V_8_MA = 3 { name = "V 8 Ma"; desc = "8 mA"; };
            V_5_MA = 4 { name = "V 5 Ma"; desc = "5 mA"; };
            V_4_MA = 5 { name = "V 4 Ma"; desc = "4 mA"; };
            V_2_MA = 6 { name = "V 2 Ma"; desc = "2 mA"; };
            V_1_MA = 7 { name = "V 1 Ma"; desc = "1 mA"; };
        };

        field {
            name = "padctrl_reg49_ds";
            desc = "Drive capability of the SDIO0_CDATA2 pin";
            sw = rw;
            hw = r;
            encode = PADCTRL_REG49_padctrl_reg49_ds_enum;
            reset = 0x6;
        } padctrl_reg49_ds[6:4];
    } PADCTRL_REG49 @ 0x8C4;

    reg {
        name = "Control register for the SDIO0_CDATA3 functional pin";
        desc = "PADCTRL_REG50 is a control register for the SDIO0_CDATA3 functional pin.

Data sheet 2.6.2 PADCTRL_REG50 (offset 0xC8, printed page 2-136, `hi3518ev200-datasheet.txt` line 8870).";

        enum PADCTRL_REG50_padctrl_reg50_sr_enum {
            FAST_EDGE = 0 { name = "Fast Edge"; desc = "fast edge"; };
            SLOW_EDGE = 1 { name = "Slow Edge"; desc = "slow edge"; };
        };

        field {
            name = "padctrl_reg50_sr";
            desc = "Rising/Falling speed control of the output signal";
            sw = rw;
            hw = r;
            encode = PADCTRL_REG50_padctrl_reg50_sr_enum;
            reset = 0x1;
        } padctrl_reg50_sr[7:7];

        enum PADCTRL_REG50_padctrl_reg50_ds_enum {
            V_12_MA = 0 { name = "V 12 Ma"; desc = "12 mA"; };
            V_11_MA = 1 { name = "V 11 Ma"; desc = "11 mA"; };
            V_9_MA = 2 { name = "V 9 Ma"; desc = "9 mA"; };
            V_8_MA = 3 { name = "V 8 Ma"; desc = "8 mA"; };
            V_5_MA = 4 { name = "V 5 Ma"; desc = "5 mA"; };
            V_4_MA = 5 { name = "V 4 Ma"; desc = "4 mA"; };
            V_2_MA = 6 { name = "V 2 Ma"; desc = "2 mA"; };
            V_1_MA = 7 { name = "V 1 Ma"; desc = "1 mA"; };
        };

        field {
            name = "padctrl_reg50_ds";
            desc = "Drive capability of the SDIO0_CDATA3 pin";
            sw = rw;
            hw = r;
            encode = PADCTRL_REG50_padctrl_reg50_ds_enum;
            reset = 0x6;
        } padctrl_reg50_ds[6:4];
    } PADCTRL_REG50 @ 0x8C8;

    reg {
        name = "Control register for the SFC_CLK functional pin";
        desc = "PADCTRL_REG51 is a control register for the SFC_CLK functional pin.

Data sheet 2.6.2 PADCTRL_REG51 (offset 0xCC, printed page 2-137, `hi3518ev200-datasheet.txt` line 8918).";

        enum PADCTRL_REG51_padctrl_reg51_st_enum {
            NO_SCHMITT_INPUT = 0 { name = "No Schmitt Input"; desc = "no Schmitt input"; };
            SCHMITT_INPUT = 1 { name = "Schmitt Input"; desc = "Schmitt input"; };
        };

        field {
            name = "padctrl_reg51_st";
            desc = "Input Schmitt control";
            sw = rw;
            hw = r;
            encode = PADCTRL_REG51_padctrl_reg51_st_enum;
            reset = 0x0;
        } padctrl_reg51_st[10:10];

        enum PADCTRL_REG51_padctrl_reg51_pd_enum {
            NO_PULL_DOWN = 0 { name = "No Pull Down"; desc = "no pull-down"; };
            PULL_DOWN = 1 { name = "Pull Down"; desc = "pull-down"; };
        };

        field {
            name = "padctrl_reg51_pd";
            desc = "Input pull-down control";
            sw = rw;
            hw = r;
            encode = PADCTRL_REG51_padctrl_reg51_pd_enum;
            reset = 0x0;
        } padctrl_reg51_pd[9:9];

        enum PADCTRL_REG51_padctrl_reg51_pu_enum {
            NO_PULL_UP = 0 { name = "No Pull Up"; desc = "no pull-up"; };
            PULL_UP = 1 { name = "Pull Up"; desc = "pull-up"; };
        };

        field {
            name = "padctrl_reg51_pu";
            desc = "Input pull-up control";
            sw = rw;
            hw = r;
            encode = PADCTRL_REG51_padctrl_reg51_pu_enum;
            reset = 0x0;
        } padctrl_reg51_pu[8:8];

        enum PADCTRL_REG51_padctrl_reg51_ds_enum {
            V_1_MA = 0 { name = "V 1 Ma"; desc = "1 mA"; };
            V_2_MA = 1 { name = "V 2 Ma"; desc = "2 mA"; };
            V_4_MA = 2 { name = "V 4 Ma"; desc = "4 mA"; };
            V_5_MA = 3 { name = "V 5 Ma"; desc = "5 mA"; };
            V_12_MA = 4 { name = "V 12 Ma"; desc = "12 mA"; };
            V_14_MA = 5 { name = "V 14 Ma"; desc = "14 mA"; };
            V_16_MA = 6 { name = "V 16 Ma"; desc = "16 mA"; };
            V_18_MA = 7 { name = "V 18 Ma"; desc = "18 mA"; };
        };

        field {
            name = "padctrl_reg51_ds";
            desc = "Drive capability of the SFC_CLK pin";
            sw = rw;
            hw = r;
            encode = PADCTRL_REG51_padctrl_reg51_ds_enum;
            reset = 0x4;
        } padctrl_reg51_ds[6:4];
    } PADCTRL_REG51 @ 0x8CC;

    reg {
        name = "Control register for the SFC_SIO_IO0 functional pin";
        desc = "PADCTRL_REG52 is a control register for the SFC_SIO_IO0 functional pin.

Data sheet 2.6.2 PADCTRL_REG52 (offset 0xD0, printed page 2-138, `hi3518ev200-datasheet.txt` line 8973).";

        enum PADCTRL_REG52_padctrl_reg52_st_enum {
            NO_SCHMITT_INPUT = 0 { name = "No Schmitt Input"; desc = "no Schmitt input"; };
            SCHMITT_INPUT = 1 { name = "Schmitt Input"; desc = "Schmitt input"; };
        };

        field {
            name = "padctrl_reg52_st";
            desc = "Input Schmitt control";
            sw = rw;
            hw = r;
            encode = PADCTRL_REG52_padctrl_reg52_st_enum;
            reset = 0x0;
        } padctrl_reg52_st[10:10];

        enum PADCTRL_REG52_padctrl_reg52_pd_enum {
            NO_PULL_DOWN = 0 { name = "No Pull Down"; desc = "no pull-down"; };
            PULL_DOWN = 1 { name = "Pull Down"; desc = "pull-down"; };
        };

        field {
            name = "padctrl_reg52_pd";
            desc = "Input pull-down control";
            sw = rw;
            hw = r;
            encode = PADCTRL_REG52_padctrl_reg52_pd_enum;
            reset = 0x0;
        } padctrl_reg52_pd[9:9];

        enum PADCTRL_REG52_padctrl_reg52_pu_enum {
            NO_PULL_UP = 0 { name = "No Pull Up"; desc = "no pull-up"; };
            PULL_UP = 1 { name = "Pull Up"; desc = "pull-up"; };
        };

        field {
            name = "padctrl_reg52_pu";
            desc = "Input pull-up control";
            sw = rw;
            hw = r;
            encode = PADCTRL_REG52_padctrl_reg52_pu_enum;
            reset = 0x0;
        } padctrl_reg52_pu[8:8];

        enum PADCTRL_REG52_padctrl_reg52_ds_enum {
            V_1_MA = 0 { name = "V 1 Ma"; desc = "1 mA"; };
            V_2_MA = 1 { name = "V 2 Ma"; desc = "2 mA"; };
            V_4_MA = 2 { name = "V 4 Ma"; desc = "4 mA"; };
            V_5_MA = 3 { name = "V 5 Ma"; desc = "5 mA"; };
            V_12_MA = 4 { name = "V 12 Ma"; desc = "12 mA"; };
            V_14_MA = 5 { name = "V 14 Ma"; desc = "14 mA"; };
            V_16_MA = 6 { name = "V 16 Ma"; desc = "16 mA"; };
            V_18_MA = 7 { name = "V 18 Ma"; desc = "18 mA"; };
        };

        field {
            name = "padctrl_reg52_ds";
            desc = "Drive capability of the SFC_SIO_IO0 pin";
            sw = rw;
            hw = r;
            encode = PADCTRL_REG52_padctrl_reg52_ds_enum;
            reset = 0x2;
        } padctrl_reg52_ds[6:4];
    } PADCTRL_REG52 @ 0x8D0;

    reg {
        name = "Control register for the SFC_SOI_IO1 functional pin";
        desc = "PADCTRL_REG53 is a control register for the SFC_SOI_IO1 functional pin.

Data sheet 2.6.2 PADCTRL_REG53 (offset 0xD4, printed page 2-139, `hi3518ev200-datasheet.txt` line 9028).";

        enum PADCTRL_REG53_padctrl_reg53_st_enum {
            NO_SCHMITT_INPUT = 0 { name = "No Schmitt Input"; desc = "no Schmitt input"; };
            SCHMITT_INPUT = 1 { name = "Schmitt Input"; desc = "Schmitt input"; };
        };

        field {
            name = "padctrl_reg53_st";
            desc = "Input Schmitt control";
            sw = rw;
            hw = r;
            encode = PADCTRL_REG53_padctrl_reg53_st_enum;
            reset = 0x0;
        } padctrl_reg53_st[10:10];

        enum PADCTRL_REG53_padctrl_reg53_pd_enum {
            NO_PULL_DOWN = 0 { name = "No Pull Down"; desc = "no pull-down"; };
            PULL_DOWN = 1 { name = "Pull Down"; desc = "pull-down"; };
        };

        field {
            name = "padctrl_reg53_pd";
            desc = "Input pull-down control";
            sw = rw;
            hw = r;
            encode = PADCTRL_REG53_padctrl_reg53_pd_enum;
            reset = 0x0;
        } padctrl_reg53_pd[9:9];

        enum PADCTRL_REG53_padctrl_reg53_pu_enum {
            NO_PULL_UP = 0 { name = "No Pull Up"; desc = "no pull-up"; };
            PULL_UP = 1 { name = "Pull Up"; desc = "pull-up"; };
        };

        field {
            name = "padctrl_reg53_pu";
            desc = "Input pull-up control";
            sw = rw;
            hw = r;
            encode = PADCTRL_REG53_padctrl_reg53_pu_enum;
            reset = 0x0;
        } padctrl_reg53_pu[8:8];

        enum PADCTRL_REG53_padctrl_reg53_ds_enum {
            V_1_MA = 0 { name = "V 1 Ma"; desc = "1 mA"; };
            V_2_MA = 1 { name = "V 2 Ma"; desc = "2 mA"; };
            V_4_MA = 2 { name = "V 4 Ma"; desc = "4 mA"; };
            V_5_MA = 3 { name = "V 5 Ma"; desc = "5 mA"; };
            V_12_MA = 4 { name = "V 12 Ma"; desc = "12 mA"; };
            V_14_MA = 5 { name = "V 14 Ma"; desc = "14 mA"; };
            V_16_MA = 6 { name = "V 16 Ma"; desc = "16 mA"; };
            V_18_MA = 7 { name = "V 18 Ma"; desc = "18 mA"; };
        };

        field {
            name = "padctrl_reg53_ds";
            desc = "Drive capability of the SFC_SOI_IO1 pin";
            sw = rw;
            hw = r;
            encode = PADCTRL_REG53_padctrl_reg53_ds_enum;
            reset = 0x2;
        } padctrl_reg53_ds[6:4];
    } PADCTRL_REG53 @ 0x8D4;

    reg {
        name = "Control register for the SFC_WP_IO2 functional pin";
        desc = "PADCTRL_REG54 is a control register for the SFC_WP_IO2 functional pin.

Data sheet 2.6.2 PADCTRL_REG54 (offset 0xD8, printed page 2-140, `hi3518ev200-datasheet.txt` line 9083).";

        enum PADCTRL_REG54_padctrl_reg54_st_enum {
            NO_SCHMITT_INPUT = 0 { name = "No Schmitt Input"; desc = "no Schmitt input"; };
            SCHMITT_INPUT = 1 { name = "Schmitt Input"; desc = "Schmitt input"; };
        };

        field {
            name = "padctrl_reg54_st";
            desc = "Input Schmitt control";
            sw = rw;
            hw = r;
            encode = PADCTRL_REG54_padctrl_reg54_st_enum;
            reset = 0x0;
        } padctrl_reg54_st[10:10];

        enum PADCTRL_REG54_padctrl_reg54_pd_enum {
            NO_PULL_DOWN = 0 { name = "No Pull Down"; desc = "no pull-down"; };
            PULL_DOWN = 1 { name = "Pull Down"; desc = "pull-down"; };
        };

        field {
            name = "padctrl_reg54_pd";
            desc = "Input pull-down control";
            sw = rw;
            hw = r;
            encode = PADCTRL_REG54_padctrl_reg54_pd_enum;
            reset = 0x0;
        } padctrl_reg54_pd[9:9];

        enum PADCTRL_REG54_padctrl_reg54_pu_enum {
            NO_PULL_UP = 0 { name = "No Pull Up"; desc = "no pull-up"; };
            PULL_UP = 1 { name = "Pull Up"; desc = "pull-up"; };
        };

        field {
            name = "padctrl_reg54_pu";
            desc = "Input pull-up control";
            sw = rw;
            hw = r;
            encode = PADCTRL_REG54_padctrl_reg54_pu_enum;
            reset = 0x0;
        } padctrl_reg54_pu[8:8];

        enum PADCTRL_REG54_padctrl_reg54_ds_enum {
            V_1_MA = 0 { name = "V 1 Ma"; desc = "1 mA"; };
            V_2_MA = 1 { name = "V 2 Ma"; desc = "2 mA"; };
            V_4_MA = 2 { name = "V 4 Ma"; desc = "4 mA"; };
            V_5_MA = 3 { name = "V 5 Ma"; desc = "5 mA"; };
            V_12_MA = 4 { name = "V 12 Ma"; desc = "12 mA"; };
            V_14_MA = 5 { name = "V 14 Ma"; desc = "14 mA"; };
            V_16_MA = 6 { name = "V 16 Ma"; desc = "16 mA"; };
            V_18_MA = 7 { name = "V 18 Ma"; desc = "18 mA"; };
        };

        field {
            name = "padctrl_reg54_ds";
            desc = "Drive capability of the SFC_WP_IO2 pin";
            sw = rw;
            hw = r;
            encode = PADCTRL_REG54_padctrl_reg54_ds_enum;
            reset = 0x2;
        } padctrl_reg54_ds[6:4];
    } PADCTRL_REG54 @ 0x8D8;

    reg {
        name = "Control register for the SFC_HOLD_IO3 functional pin";
        desc = "PADCTRL_REG55 is a control register for the SFC_HOLD_IO3 functional pin.

Data sheet 2.6.2 PADCTRL_REG55 (offset 0xDC, printed page 2-141, `hi3518ev200-datasheet.txt` line 9138).";

        enum PADCTRL_REG55_padctrl_reg55_st_enum {
            NO_SCHMITT_INPUT = 0 { name = "No Schmitt Input"; desc = "no Schmitt input"; };
            SCHMITT_INPUT = 1 { name = "Schmitt Input"; desc = "Schmitt input"; };
        };

        field {
            name = "padctrl_reg55_st";
            desc = "Input Schmitt control";
            sw = rw;
            hw = r;
            encode = PADCTRL_REG55_padctrl_reg55_st_enum;
            reset = 0x0;
        } padctrl_reg55_st[10:10];

        enum PADCTRL_REG55_padctrl_reg55_pd_enum {
            NO_PULL_DOWN = 0 { name = "No Pull Down"; desc = "no pull-down"; };
            PULL_DOWN = 1 { name = "Pull Down"; desc = "pull-down"; };
        };

        field {
            name = "padctrl_reg55_pd";
            desc = "Input pull-down control";
            sw = rw;
            hw = r;
            encode = PADCTRL_REG55_padctrl_reg55_pd_enum;
            reset = 0x0;
        } padctrl_reg55_pd[9:9];

        enum PADCTRL_REG55_padctrl_reg55_pu_enum {
            NO_PULL_UP = 0 { name = "No Pull Up"; desc = "no pull-up"; };
            PULL_UP = 1 { name = "Pull Up"; desc = "pull-up"; };
        };

        field {
            name = "padctrl_reg55_pu";
            desc = "Input pull-up control";
            sw = rw;
            hw = r;
            encode = PADCTRL_REG55_padctrl_reg55_pu_enum;
            reset = 0x0;
        } padctrl_reg55_pu[8:8];

        enum PADCTRL_REG55_padctrl_reg55_ds_enum {
            V_1_MA = 0 { name = "V 1 Ma"; desc = "1 mA"; };
            V_2_MA = 1 { name = "V 2 Ma"; desc = "2 mA"; };
            V_4_MA = 2 { name = "V 4 Ma"; desc = "4 mA"; };
            V_5_MA = 3 { name = "V 5 Ma"; desc = "5 mA"; };
            V_12_MA = 4 { name = "V 12 Ma"; desc = "12 mA"; };
            V_14_MA = 5 { name = "V 14 Ma"; desc = "14 mA"; };
            V_16_MA = 6 { name = "V 16 Ma"; desc = "16 mA"; };
            V_18_MA = 7 { name = "V 18 Ma"; desc = "18 mA"; };
        };

        field {
            name = "padctrl_reg55_ds";
            desc = "Drive capability of the SFC_HOLD_IO3 pin";
            sw = rw;
            hw = r;
            encode = PADCTRL_REG55_padctrl_reg55_ds_enum;
            reset = 0x2;
        } padctrl_reg55_ds[6:4];
    } PADCTRL_REG55 @ 0x8DC;

    reg {
        name = "Control register for the SFC_CSN0 functional pin";
        desc = "PADCTRL_REG56 is a control register for the SFC_CSN0 functional pin.

Data sheet 2.6.2 PADCTRL_REG56 (offset 0xE0, printed page 2-142, `hi3518ev200-datasheet.txt` line 9193).";

        enum PADCTRL_REG56_padctrl_reg56_sl_enum {
            SLOW_EDGE = 0 { name = "Slow Edge"; desc = "slow edge"; };
            FAST_EDGE = 1 { name = "Fast Edge"; desc = "fast edge"; };
        };

        field {
            name = "padctrl_reg56_sl";
            desc = "Rising/Falling speed control of the output signal";
            sw = rw;
            hw = r;
            encode = PADCTRL_REG56_padctrl_reg56_sl_enum;
            reset = 0x0;
        } padctrl_reg56_sl[7:7];

        enum PADCTRL_REG56_padctrl_reg56_ds_enum {
            V_1_MA = 0 { name = "V 1 Ma"; desc = "1 mA"; };
            V_2_MA = 1 { name = "V 2 Ma"; desc = "2 mA"; };
            V_3_MA = 2 { name = "V 3 Ma"; desc = "3 mA"; };
            V_4_MA = 3 { name = "V 4 Ma"; desc = "4 mA"; };
        };

        field {
            name = "padctrl_reg56_ds";
            desc = "Drive capability of the SFC_CSN0 pin";
            sw = rw;
            hw = r;
            encode = PADCTRL_REG56_padctrl_reg56_ds_enum;
            reset = 0x0;
        } padctrl_reg56_ds[5:4];
    } PADCTRL_REG56 @ 0x8E0;

    reg {
        name = "Control register for the SFC_CSN1 functional pin";
        desc = "PADCTRL_REG57 is a control register for the SFC_CSN1 functional pin.

Data sheet 2.6.2 PADCTRL_REG57 (offset 0xE4, printed page 2-143, `hi3518ev200-datasheet.txt` line 9234).";

        enum PADCTRL_REG57_padctrl_reg57_sl_enum {
            SLOW_EDGE = 0 { name = "Slow Edge"; desc = "slow edge"; };
            FAST_EDGE = 1 { name = "Fast Edge"; desc = "fast edge"; };
        };

        field {
            name = "padctrl_reg57_sl";
            desc = "Rising/Falling speed control of the output signal";
            sw = rw;
            hw = r;
            encode = PADCTRL_REG57_padctrl_reg57_sl_enum;
            reset = 0x0;
        } padctrl_reg57_sl[7:7];

        enum PADCTRL_REG57_padctrl_reg57_ds_enum {
            V_1_MA = 0 { name = "V 1 Ma"; desc = "1 mA"; };
            V_2_MA = 1 { name = "V 2 Ma"; desc = "2 mA"; };
            V_3_MA = 2 { name = "V 3 Ma"; desc = "3 mA"; };
            V_4_MA = 3 { name = "V 4 Ma"; desc = "4 mA"; };
        };

        field {
            name = "padctrl_reg57_ds";
            desc = "Drive capability of the SFC_CSN1 pin";
            sw = rw;
            hw = r;
            encode = PADCTRL_REG57_padctrl_reg57_ds_enum;
            reset = 0x0;
        } padctrl_reg57_ds[5:4];
    } PADCTRL_REG57 @ 0x8E4;

    reg {
        name = "Control register for the UART1_RTSN functional pin";
        desc = "PADCTRL_REG58 is a control register for the UART1_RTSN functional pin.

Data sheet 2.6.2 PADCTRL_REG58 (offset 0xE8, printed page 2-144, `hi3518ev200-datasheet.txt` line 9278).";

        enum PADCTRL_REG58_padctrl_reg58_st_enum {
            NO_SCHMITT_INPUT = 0 { name = "No Schmitt Input"; desc = "no Schmitt input"; };
            SCHMITT_INPUT = 1 { name = "Schmitt Input"; desc = "Schmitt input"; };
        };

        field {
            name = "padctrl_reg58_st";
            desc = "Input Schmitt control";
            sw = rw;
            hw = r;
            encode = PADCTRL_REG58_padctrl_reg58_st_enum;
            reset = 0x0;
        } padctrl_reg58_st[10:10];

        enum PADCTRL_REG58_padctrl_reg58_pd_enum {
            NO_PULL_DOWN = 0 { name = "No Pull Down"; desc = "no pull-down"; };
            PULL_DOWN = 1 { name = "Pull Down"; desc = "pull-down"; };
        };

        field {
            name = "padctrl_reg58_pd";
            desc = "Input pull-down control";
            sw = rw;
            hw = r;
            encode = PADCTRL_REG58_padctrl_reg58_pd_enum;
            reset = 0x0;
        } padctrl_reg58_pd[9:9];

        enum PADCTRL_REG58_padctrl_reg58_pu_enum {
            NO_PULL_UP = 0 { name = "No Pull Up"; desc = "no pull-up"; };
            PULL_UP = 1 { name = "Pull Up"; desc = "pull-up"; };
        };

        field {
            name = "padctrl_reg58_pu";
            desc = "Input pull-up control";
            sw = rw;
            hw = r;
            encode = PADCTRL_REG58_padctrl_reg58_pu_enum;
            reset = 0x0;
        } padctrl_reg58_pu[8:8];

        enum PADCTRL_REG58_padctrl_reg58_ds_enum {
            V_1_MA = 0 { name = "V 1 Ma"; desc = "1 mA"; };
            V_2_MA = 1 { name = "V 2 Ma"; desc = "2 mA"; };
            V_4_MA = 2 { name = "V 4 Ma"; desc = "4 mA"; };
            V_5_MA = 3 { name = "V 5 Ma"; desc = "5 mA"; };
            V_12_MA = 4 { name = "V 12 Ma"; desc = "12 mA"; };
            V_14_MA = 5 { name = "V 14 Ma"; desc = "14 mA"; };
            V_16_MA = 6 { name = "V 16 Ma"; desc = "16 mA"; };
            V_18_MA = 7 { name = "V 18 Ma"; desc = "18 mA"; };
        };

        field {
            name = "padctrl_reg58_ds";
            desc = "Drive capability of the UART1_RTSN pin";
            sw = rw;
            hw = r;
            encode = PADCTRL_REG58_padctrl_reg58_ds_enum;
            reset = 0x0;
        } padctrl_reg58_ds[6:4];
    } PADCTRL_REG58 @ 0x8E8;

    reg {
        name = "Control register for the UART1_RXD functional pin";
        desc = "PADCTRL_REG59 is a control register for the UART1_RXD functional pin.

Data sheet 2.6.2 PADCTRL_REG59 (offset 0xEC, printed page 2-145, `hi3518ev200-datasheet.txt` line 9332).";

        enum PADCTRL_REG59_padctrl_reg59_st_enum {
            NO_SCHMITT_INPUT = 0 { name = "No Schmitt Input"; desc = "no Schmitt input"; };
            SCHMITT_INPUT = 1 { name = "Schmitt Input"; desc = "Schmitt input"; };
        };

        field {
            name = "padctrl_reg59_st";
            desc = "Input Schmitt control";
            sw = rw;
            hw = r;
            encode = PADCTRL_REG59_padctrl_reg59_st_enum;
            reset = 0x0;
        } padctrl_reg59_st[10:10];

        enum PADCTRL_REG59_padctrl_reg59_pd_enum {
            NO_PULL_DOWN = 0 { name = "No Pull Down"; desc = "no pull-down"; };
            PULL_DOWN = 1 { name = "Pull Down"; desc = "pull-down"; };
        };

        field {
            name = "padctrl_reg59_pd";
            desc = "Input pull-down control";
            sw = rw;
            hw = r;
            encode = PADCTRL_REG59_padctrl_reg59_pd_enum;
            reset = 0x0;
        } padctrl_reg59_pd[9:9];

        enum PADCTRL_REG59_padctrl_reg59_pu_enum {
            NO_PULL_UP = 0 { name = "No Pull Up"; desc = "no pull-up"; };
            PULL_UP = 1 { name = "Pull Up"; desc = "pull-up"; };
        };

        field {
            name = "padctrl_reg59_pu";
            desc = "Input pull-up control";
            sw = rw;
            hw = r;
            encode = PADCTRL_REG59_padctrl_reg59_pu_enum;
            reset = 0x0;
        } padctrl_reg59_pu[8:8];

        enum PADCTRL_REG59_padctrl_reg59_ds_enum {
            V_1_MA = 0 { name = "V 1 Ma"; desc = "1 mA"; };
            V_2_MA = 1 { name = "V 2 Ma"; desc = "2 mA"; };
            V_4_MA = 2 { name = "V 4 Ma"; desc = "4 mA"; };
            V_5_MA = 3 { name = "V 5 Ma"; desc = "5 mA"; };
            V_12_MA = 4 { name = "V 12 Ma"; desc = "12 mA"; };
            V_14_MA = 5 { name = "V 14 Ma"; desc = "14 mA"; };
            V_16_MA = 6 { name = "V 16 Ma"; desc = "16 mA"; };
            V_18_MA = 7 { name = "V 18 Ma"; desc = "18 mA"; };
        };

        field {
            name = "padctrl_reg59_ds";
            desc = "Drive capability of the UART1_RXD pin";
            sw = rw;
            hw = r;
            encode = PADCTRL_REG59_padctrl_reg59_ds_enum;
            reset = 0x0;
        } padctrl_reg59_ds[6:4];
    } PADCTRL_REG59 @ 0x8EC;

    reg {
        name = "Control register for the UART1_CTSN functional pin";
        desc = "PADCTRL_REG60 is a control register for the UART1_CTSN functional pin.

Data sheet 2.6.2 PADCTRL_REG60 (offset 0xF0, printed page 2-146, `hi3518ev200-datasheet.txt` line 9386).";

        enum PADCTRL_REG60_padctrl_reg60_st_enum {
            NO_SCHMITT_INPUT = 0 { name = "No Schmitt Input"; desc = "no Schmitt input"; };
            SCHMITT_INPUT = 1 { name = "Schmitt Input"; desc = "Schmitt input"; };
        };

        field {
            name = "padctrl_reg60_st";
            desc = "Input Schmitt control";
            sw = rw;
            hw = r;
            encode = PADCTRL_REG60_padctrl_reg60_st_enum;
            reset = 0x0;
        } padctrl_reg60_st[10:10];

        enum PADCTRL_REG60_padctrl_reg60_pd_enum {
            NO_PULL_DOWN = 0 { name = "No Pull Down"; desc = "no pull-down"; };
            PULL_DOWN = 1 { name = "Pull Down"; desc = "pull-down"; };
        };

        field {
            name = "padctrl_reg60_pd";
            desc = "Input pull-down control";
            sw = rw;
            hw = r;
            encode = PADCTRL_REG60_padctrl_reg60_pd_enum;
            reset = 0x0;
        } padctrl_reg60_pd[9:9];

        enum PADCTRL_REG60_padctrl_reg60_pu_enum {
            NO_PULL_UP = 0 { name = "No Pull Up"; desc = "no pull-up"; };
            PULL_UP = 1 { name = "Pull Up"; desc = "pull-up"; };
        };

        field {
            name = "padctrl_reg60_pu";
            desc = "Input pull-up control";
            sw = rw;
            hw = r;
            encode = PADCTRL_REG60_padctrl_reg60_pu_enum;
            reset = 0x0;
        } padctrl_reg60_pu[8:8];

        enum PADCTRL_REG60_padctrl_reg60_ds_enum {
            V_1_MA = 0 { name = "V 1 Ma"; desc = "1 mA"; };
            V_2_MA = 1 { name = "V 2 Ma"; desc = "2 mA"; };
            V_4_MA = 2 { name = "V 4 Ma"; desc = "4 mA"; };
            V_5_MA = 3 { name = "V 5 Ma"; desc = "5 mA"; };
            V_12_MA = 4 { name = "V 12 Ma"; desc = "12 mA"; };
            V_14_MA = 5 { name = "V 14 Ma"; desc = "14 mA"; };
            V_16_MA = 6 { name = "V 16 Ma"; desc = "16 mA"; };
            V_18_MA = 7 { name = "V 18 Ma"; desc = "18 mA"; };
        };

        field {
            name = "padctrl_reg60_ds";
            desc = "Drive capability of the UART1_CTSN pin";
            sw = rw;
            hw = r;
            encode = PADCTRL_REG60_padctrl_reg60_ds_enum;
            reset = 0x0;
        } padctrl_reg60_ds[6:4];
    } PADCTRL_REG60 @ 0x8F0;

    reg {
        name = "Control register for the UART1_TXD functional pin";
        desc = "PADCTRL_REG61 is a control register for the UART1_TXD functional pin.

Data sheet 2.6.2 PADCTRL_REG61 (offset 0xF4, printed page 2-147, `hi3518ev200-datasheet.txt` line 9440).";

        enum PADCTRL_REG61_padctrl_reg61_st_enum {
            NO_SCHMITT_INPUT = 0 { name = "No Schmitt Input"; desc = "no Schmitt input"; };
            SCHMITT_INPUT = 1 { name = "Schmitt Input"; desc = "Schmitt input"; };
        };

        field {
            name = "padctrl_reg61_st";
            desc = "Input Schmitt control";
            sw = rw;
            hw = r;
            encode = PADCTRL_REG61_padctrl_reg61_st_enum;
            reset = 0x0;
        } padctrl_reg61_st[10:10];

        enum PADCTRL_REG61_padctrl_reg61_pd_enum {
            NO_PULL_DOWN = 0 { name = "No Pull Down"; desc = "no pull-down"; };
            PULL_DOWN = 1 { name = "Pull Down"; desc = "pull-down"; };
        };

        field {
            name = "padctrl_reg61_pd";
            desc = "Input pull-down control";
            sw = rw;
            hw = r;
            encode = PADCTRL_REG61_padctrl_reg61_pd_enum;
            reset = 0x0;
        } padctrl_reg61_pd[9:9];

        enum PADCTRL_REG61_padctrl_reg61_pu_enum {
            NO_PULL_UP = 0 { name = "No Pull Up"; desc = "no pull-up"; };
            PULL_UP = 1 { name = "Pull Up"; desc = "pull-up"; };
        };

        field {
            name = "padctrl_reg61_pu";
            desc = "Input pull-up control";
            sw = rw;
            hw = r;
            encode = PADCTRL_REG61_padctrl_reg61_pu_enum;
            reset = 0x0;
        } padctrl_reg61_pu[8:8];

        enum PADCTRL_REG61_padctrl_reg61_ds_enum {
            V_1_MA = 0 { name = "V 1 Ma"; desc = "1 mA"; };
            V_2_MA = 1 { name = "V 2 Ma"; desc = "2 mA"; };
            V_4_MA = 2 { name = "V 4 Ma"; desc = "4 mA"; };
            V_5_MA = 3 { name = "V 5 Ma"; desc = "5 mA"; };
            V_12_MA = 4 { name = "V 12 Ma"; desc = "12 mA"; };
            V_14_MA = 5 { name = "V 14 Ma"; desc = "14 mA"; };
            V_16_MA = 6 { name = "V 16 Ma"; desc = "16 mA"; };
            V_18_MA = 7 { name = "V 18 Ma"; desc = "18 mA"; };
        };

        field {
            name = "padctrl_reg61_ds";
            desc = "Drive capability of the UART1_TXD pin";
            sw = rw;
            hw = r;
            encode = PADCTRL_REG61_padctrl_reg61_ds_enum;
            reset = 0x0;
        } padctrl_reg61_ds[6:4];
    } PADCTRL_REG61 @ 0x8F4;

    reg {
        name = "Control register for the UART2_RXD functional pin";
        desc = "PADCTRL_REG62 is a control register for the UART2_RXD functional pin.

Data sheet 2.6.2 PADCTRL_REG62 (offset 0xF8, printed page 2-148, `hi3518ev200-datasheet.txt` line 9494).";

        enum PADCTRL_REG62_padctrl_reg62_st_enum {
            NO_SCHMITT_INPUT = 0 { name = "No Schmitt Input"; desc = "no Schmitt input"; };
            SCHMITT_INPUT = 1 { name = "Schmitt Input"; desc = "Schmitt input"; };
        };

        field {
            name = "padctrl_reg62_st";
            desc = "Input Schmitt control";
            sw = rw;
            hw = r;
            encode = PADCTRL_REG62_padctrl_reg62_st_enum;
            reset = 0x0;
        } padctrl_reg62_st[10:10];

        enum PADCTRL_REG62_padctrl_reg62_pd_enum {
            NO_PULL_DOWN = 0 { name = "No Pull Down"; desc = "no pull-down"; };
            PULL_DOWN = 1 { name = "Pull Down"; desc = "pull-down"; };
        };

        field {
            name = "padctrl_reg62_pd";
            desc = "Input pull-down control";
            sw = rw;
            hw = r;
            encode = PADCTRL_REG62_padctrl_reg62_pd_enum;
            reset = 0x0;
        } padctrl_reg62_pd[9:9];

        enum PADCTRL_REG62_padctrl_reg62_pu_enum {
            NO_PULL_UP = 0 { name = "No Pull Up"; desc = "no pull-up"; };
            PULL_UP = 1 { name = "Pull Up"; desc = "pull-up"; };
        };

        field {
            name = "padctrl_reg62_pu";
            desc = "Input pull-up control";
            sw = rw;
            hw = r;
            encode = PADCTRL_REG62_padctrl_reg62_pu_enum;
            reset = 0x0;
        } padctrl_reg62_pu[8:8];

        enum PADCTRL_REG62_padctrl_reg62_ds_enum {
            V_1_MA = 0 { name = "V 1 Ma"; desc = "1 mA"; };
            V_2_MA = 1 { name = "V 2 Ma"; desc = "2 mA"; };
            V_4_MA = 2 { name = "V 4 Ma"; desc = "4 mA"; };
            V_5_MA = 3 { name = "V 5 Ma"; desc = "5 mA"; };
            V_12_MA = 4 { name = "V 12 Ma"; desc = "12 mA"; };
            V_14_MA = 5 { name = "V 14 Ma"; desc = "14 mA"; };
            V_16_MA = 6 { name = "V 16 Ma"; desc = "16 mA"; };
            V_18_MA = 7 { name = "V 18 Ma"; desc = "18 mA"; };
        };

        field {
            name = "padctrl_reg62_ds";
            desc = "Drive capability of the UART2_RXD pin";
            sw = rw;
            hw = r;
            encode = PADCTRL_REG62_padctrl_reg62_ds_enum;
            reset = 0x0;
        } padctrl_reg62_ds[6:4];
    } PADCTRL_REG62 @ 0x8F8;

    reg {
        name = "Control register for the UART2_TXD functional pin";
        desc = "PADCTRL_REG63 is a control register for the UART2_TXD functional pin.

Data sheet 2.6.2 PADCTRL_REG63 (offset 0xFC, printed page 2-149, `hi3518ev200-datasheet.txt` line 9548).";

        enum PADCTRL_REG63_padctrl_reg63_st_enum {
            NO_SCHMITT_INPUT = 0 { name = "No Schmitt Input"; desc = "no Schmitt input"; };
            SCHMITT_INPUT = 1 { name = "Schmitt Input"; desc = "Schmitt input"; };
        };

        field {
            name = "padctrl_reg63_st";
            desc = "Input Schmitt control";
            sw = rw;
            hw = r;
            encode = PADCTRL_REG63_padctrl_reg63_st_enum;
            reset = 0x0;
        } padctrl_reg63_st[10:10];

        enum PADCTRL_REG63_padctrl_reg63_pd_enum {
            NO_PULL_DOWN = 0 { name = "No Pull Down"; desc = "no pull-down"; };
            PULL_DOWN = 1 { name = "Pull Down"; desc = "pull-down"; };
        };

        field {
            name = "padctrl_reg63_pd";
            desc = "Input pull-down control";
            sw = rw;
            hw = r;
            encode = PADCTRL_REG63_padctrl_reg63_pd_enum;
            reset = 0x0;
        } padctrl_reg63_pd[9:9];

        enum PADCTRL_REG63_padctrl_reg63_pu_enum {
            NO_PULL_UP = 0 { name = "No Pull Up"; desc = "no pull-up"; };
            PULL_UP = 1 { name = "Pull Up"; desc = "pull-up"; };
        };

        field {
            name = "padctrl_reg63_pu";
            desc = "Input pull-up control";
            sw = rw;
            hw = r;
            encode = PADCTRL_REG63_padctrl_reg63_pu_enum;
            reset = 0x0;
        } padctrl_reg63_pu[8:8];

        enum PADCTRL_REG63_padctrl_reg63_ds_enum {
            V_1_MA = 0 { name = "V 1 Ma"; desc = "1 mA"; };
            V_2_MA = 1 { name = "V 2 Ma"; desc = "2 mA"; };
            V_4_MA = 2 { name = "V 4 Ma"; desc = "4 mA"; };
            V_5_MA = 3 { name = "V 5 Ma"; desc = "5 mA"; };
            V_12_MA = 4 { name = "V 12 Ma"; desc = "12 mA"; };
            V_14_MA = 5 { name = "V 14 Ma"; desc = "14 mA"; };
            V_16_MA = 6 { name = "V 16 Ma"; desc = "16 mA"; };
            V_18_MA = 7 { name = "V 18 Ma"; desc = "18 mA"; };
        };

        field {
            name = "padctrl_reg63_ds";
            desc = "Drive capability of the UART2_TXD pin";
            sw = rw;
            hw = r;
            encode = PADCTRL_REG63_padctrl_reg63_ds_enum;
            reset = 0x0;
        } padctrl_reg63_ds[6:4];
    } PADCTRL_REG63 @ 0x8FC;

    reg {
        name = "Control register for the JTAG_TRSTN functional pin";
        desc = "PADCTRL_REG64 is a control register for the JTAG_TRSTN functional pin.

Data sheet 2.6.2 PADCTRL_REG64 (offset 0x100, printed page 2-150, `hi3518ev200-datasheet.txt` line 9602).";

        enum PADCTRL_REG64_padctrl_reg64_sr_enum {
            FAST_EDGE = 0 { name = "Fast Edge"; desc = "fast edge"; };
            SLOW_EDGE = 1 { name = "Slow Edge"; desc = "slow edge"; };
        };

        field {
            name = "padctrl_reg64_sr";
            desc = "Rising/Falling speed control of the output signal";
            sw = rw;
            hw = r;
            encode = PADCTRL_REG64_padctrl_reg64_sr_enum;
            reset = 0x1;
        } padctrl_reg64_sr[7:7];

        enum PADCTRL_REG64_padctrl_reg64_ds_enum {
            V_4_MA = 0 { name = "V 4 Ma"; desc = "4 mA"; };
            V_3_MA = 1 { name = "V 3 Ma"; desc = "3 mA"; };
            V_2_MA = 2 { name = "V 2 Ma"; desc = "2 mA"; };
            V_1_MA = 3 { name = "V 1 Ma"; desc = "1 mA"; };
        };

        field {
            name = "padctrl_reg64_ds";
            desc = "Drive capability of the JTAG_TRSTN pin";
            sw = rw;
            hw = r;
            encode = PADCTRL_REG64_padctrl_reg64_ds_enum;
            reset = 0x3;
        } padctrl_reg64_ds[5:4];
    } PADCTRL_REG64 @ 0x900;

    reg {
        name = "Control register for the JTAG_TCK functional pin";
        desc = "PADCTRL_REG65 is a control register for the JTAG_TCK functional pin.

Data sheet 2.6.2 PADCTRL_REG65 (offset 0x104, printed page 2-150, `hi3518ev200-datasheet.txt` line 9637).";

        enum PADCTRL_REG65_padctrl_reg65_sr_enum {
            FAST_EDGE = 0 { name = "Fast Edge"; desc = "fast edge"; };
            SLOW_EDGE = 1 { name = "Slow Edge"; desc = "slow edge"; };
        };

        field {
            name = "padctrl_reg65_sr";
            desc = "Rising/Falling speed control of the output signal";
            sw = rw;
            hw = r;
            encode = PADCTRL_REG65_padctrl_reg65_sr_enum;
            reset = 0x1;
        } padctrl_reg65_sr[7:7];

        enum PADCTRL_REG65_padctrl_reg65_ds_enum {
            V_4_MA = 0 { name = "V 4 Ma"; desc = "4 mA"; };
            V_3_MA = 1 { name = "V 3 Ma"; desc = "3 mA"; };
            V_2_MA = 2 { name = "V 2 Ma"; desc = "2 mA"; };
            V_1_MA = 3 { name = "V 1 Ma"; desc = "1 mA"; };
        };

        field {
            name = "padctrl_reg65_ds";
            desc = "Drive capability of the JTAG_TCK pin";
            sw = rw;
            hw = r;
            encode = PADCTRL_REG65_padctrl_reg65_ds_enum;
            reset = 0x3;
        } padctrl_reg65_ds[5:4];
    } PADCTRL_REG65 @ 0x904;

    reg {
        name = "Control register for the JTAG_TMS functional pin";
        desc = "PADCTRL_REG66 is a control register for the JTAG_TMS functional pin.

Data sheet 2.6.2 PADCTRL_REG66 (offset 0x108, printed page 2-151, `hi3518ev200-datasheet.txt` line 9678).";

        enum PADCTRL_REG66_padctrl_reg66_sr_enum {
            FAST_EDGE = 0 { name = "Fast Edge"; desc = "fast edge"; };
            SLOW_EDGE = 1 { name = "Slow Edge"; desc = "slow edge"; };
        };

        field {
            name = "padctrl_reg66_sr";
            desc = "Rising/Falling speed control of the output signal";
            sw = rw;
            hw = r;
            encode = PADCTRL_REG66_padctrl_reg66_sr_enum;
            reset = 0x1;
        } padctrl_reg66_sr[7:7];

        enum PADCTRL_REG66_padctrl_reg66_ds_enum {
            V_4_MA = 0 { name = "V 4 Ma"; desc = "4 mA"; };
            V_3_MA = 1 { name = "V 3 Ma"; desc = "3 mA"; };
            V_2_MA = 2 { name = "V 2 Ma"; desc = "2 mA"; };
            V_1_MA = 3 { name = "V 1 Ma"; desc = "1 mA"; };
        };

        field {
            name = "padctrl_reg66_ds";
            desc = "Drive capability of the JTAG_TMS pin";
            sw = rw;
            hw = r;
            encode = PADCTRL_REG66_padctrl_reg66_ds_enum;
            reset = 0x3;
        } padctrl_reg66_ds[5:4];
    } PADCTRL_REG66 @ 0x908;

    reg {
        name = "Control register for the JTAG_TDO functional pin";
        desc = "PADCTRL_REG67 is a control register for the JTAG_TDO functional pin.

Data sheet 2.6.2 PADCTRL_REG67 (offset 0x10C, printed page 2-152, `hi3518ev200-datasheet.txt` line 9723).";

        enum PADCTRL_REG67_padctrl_reg67_sr_enum {
            FAST_EDGE = 0 { name = "Fast Edge"; desc = "fast edge"; };
            SLOW_EDGE = 1 { name = "Slow Edge"; desc = "slow edge"; };
        };

        field {
            name = "padctrl_reg67_sr";
            desc = "Rising/Falling speed control of the output signal";
            sw = rw;
            hw = r;
            encode = PADCTRL_REG67_padctrl_reg67_sr_enum;
            reset = 0x1;
        } padctrl_reg67_sr[7:7];

        enum PADCTRL_REG67_padctrl_reg67_ds_enum {
            V_4_MA = 0 { name = "V 4 Ma"; desc = "4 mA"; };
            V_3_MA = 1 { name = "V 3 Ma"; desc = "3 mA"; };
            V_2_MA = 2 { name = "V 2 Ma"; desc = "2 mA"; };
            V_1_MA = 3 { name = "V 1 Ma"; desc = "1 mA"; };
        };

        field {
            name = "padctrl_reg67_ds";
            desc = "Drive capability of the JTAG_TDO pin";
            sw = rw;
            hw = r;
            encode = PADCTRL_REG67_padctrl_reg67_ds_enum;
            reset = 0x3;
        } padctrl_reg67_ds[5:4];
    } PADCTRL_REG67 @ 0x90C;

    reg {
        name = "Control register for the JTAG_TDI functional pin";
        desc = "PADCTRL_REG68 is a control register for the JTAG_TDI functional pin.

Data sheet 2.6.2 PADCTRL_REG68 (offset 0x110, printed page 2-153, `hi3518ev200-datasheet.txt` line 9767).";

        enum PADCTRL_REG68_padctrl_reg68_sr_enum {
            FAST_EDGE = 0 { name = "Fast Edge"; desc = "fast edge"; };
            SLOW_EDGE = 1 { name = "Slow Edge"; desc = "slow edge"; };
        };

        field {
            name = "padctrl_reg68_sr";
            desc = "Rising/Falling speed control of the output signal";
            sw = rw;
            hw = r;
            encode = PADCTRL_REG68_padctrl_reg68_sr_enum;
            reset = 0x1;
        } padctrl_reg68_sr[7:7];

        enum PADCTRL_REG68_padctrl_reg68_ds_enum {
            V_4_MA = 0 { name = "V 4 Ma"; desc = "4 mA"; };
            V_3_MA = 1 { name = "V 3 Ma"; desc = "3 mA"; };
            V_2_MA = 2 { name = "V 2 Ma"; desc = "2 mA"; };
            V_1_MA = 3 { name = "V 1 Ma"; desc = "1 mA"; };
        };

        field {
            name = "padctrl_reg68_ds";
            desc = "Drive capability of the JTAG_TDI pin";
            sw = rw;
            hw = r;
            encode = PADCTRL_REG68_padctrl_reg68_ds_enum;
            reset = 0x3;
        } padctrl_reg68_ds[5:4];
    } PADCTRL_REG68 @ 0x910;

    reg {
        name = "Control register for the PWM0 functional pin";
        desc = "PADCTRL_REG70 is a control register for the PWM0 functional pin.

Data sheet 2.6.2 PADCTRL_REG70 (offset 0x118, printed page 2-153, `hi3518ev200-datasheet.txt` line 9802).";

        enum PADCTRL_REG70_padctrl_reg70_sl_enum {
            SLOW_EDGE = 0 { name = "Slow Edge"; desc = "slow edge"; };
            FAST_EDGE = 1 { name = "Fast Edge"; desc = "fast edge"; };
        };

        field {
            name = "padctrl_reg70_sl";
            desc = "Rising/Falling speed control of the output signal";
            sw = rw;
            hw = r;
            encode = PADCTRL_REG70_padctrl_reg70_sl_enum;
            reset = 0x0;
        } padctrl_reg70_sl[7:7];

        enum PADCTRL_REG70_padctrl_reg70_ds_enum {
            V_1_MA = 0 { name = "V 1 Ma"; desc = "1 mA"; };
            V_2_MA = 1 { name = "V 2 Ma"; desc = "2 mA"; };
            V_3_MA = 2 { name = "V 3 Ma"; desc = "3 mA"; };
            V_4_MA = 3 { name = "V 4 Ma"; desc = "4 mA"; };
        };

        field {
            name = "padctrl_reg70_ds";
            desc = "Drive capability of the PWM0 pin";
            sw = rw;
            hw = r;
            encode = PADCTRL_REG70_padctrl_reg70_ds_enum;
            reset = 0x0;
        } padctrl_reg70_ds[5:4];
    } PADCTRL_REG70 @ 0x918;

    reg {
        name = "Control register for the PWM1 functional pin";
        desc = "PADCTRL_REG71 is a control register for the PWM1 functional pin.

Data sheet 2.6.2 PADCTRL_REG71 (offset 0x11C, printed page 2-154, `hi3518ev200-datasheet.txt` line 9843).";

        enum PADCTRL_REG71_padctrl_reg71_sl_enum {
            SLOW_EDGE = 0 { name = "Slow Edge"; desc = "slow edge"; };
            FAST_EDGE = 1 { name = "Fast Edge"; desc = "fast edge"; };
        };

        field {
            name = "padctrl_reg71_sl";
            desc = "Rising/Falling speed control of the output signal";
            sw = rw;
            hw = r;
            encode = PADCTRL_REG71_padctrl_reg71_sl_enum;
            reset = 0x0;
        } padctrl_reg71_sl[7:7];

        enum PADCTRL_REG71_padctrl_reg71_ds_enum {
            V_1_MA = 0 { name = "V 1 Ma"; desc = "1 mA"; };
            V_2_MA = 1 { name = "V 2 Ma"; desc = "2 mA"; };
            V_3_MA = 2 { name = "V 3 Ma"; desc = "3 mA"; };
            V_4_MA = 3 { name = "V 4 Ma"; desc = "4 mA"; };
        };

        field {
            name = "padctrl_reg71_ds";
            desc = "Drive capability of the PWM1 pin";
            sw = rw;
            hw = r;
            encode = PADCTRL_REG71_padctrl_reg71_ds_enum;
            reset = 0x0;
        } padctrl_reg71_ds[5:4];
    } PADCTRL_REG71 @ 0x91C;

    reg {
        name = "Control register for the PWM2 functional pin";
        desc = "PADCTRL_REG72 is a control register for the PWM2 functional pin.

Data sheet 2.6.2 PADCTRL_REG72 (offset 0x120, printed page 2-155, `hi3518ev200-datasheet.txt` line 9888).";

        enum PADCTRL_REG72_padctrl_reg72_sl_enum {
            SLOW_EDGE = 0 { name = "Slow Edge"; desc = "slow edge"; };
            FAST_EDGE = 1 { name = "Fast Edge"; desc = "fast edge"; };
        };

        field {
            name = "padctrl_reg72_sl";
            desc = "Rising/Falling speed control of the output signal";
            sw = rw;
            hw = r;
            encode = PADCTRL_REG72_padctrl_reg72_sl_enum;
            reset = 0x0;
        } padctrl_reg72_sl[7:7];

        enum PADCTRL_REG72_padctrl_reg72_ds_enum {
            V_1_MA = 0 { name = "V 1 Ma"; desc = "1 mA"; };
            V_2_MA = 1 { name = "V 2 Ma"; desc = "2 mA"; };
            V_3_MA = 2 { name = "V 3 Ma"; desc = "3 mA"; };
            V_4_MA = 3 { name = "V 4 Ma"; desc = "4 mA"; };
        };

        field {
            name = "padctrl_reg72_ds";
            desc = "Drive capability of the PWM2 pin";
            sw = rw;
            hw = r;
            encode = PADCTRL_REG72_padctrl_reg72_ds_enum;
            reset = 0x0;
        } padctrl_reg72_ds[5:4];
    } PADCTRL_REG72 @ 0x920;

    reg {
        name = "Control register for the PWM3 functional pin";
        desc = "PADCTRL_REG73 is a control register for the PWM3 functional pin.

Data sheet 2.6.2 PADCTRL_REG73 (offset 0x124, printed page 2-156, `hi3518ev200-datasheet.txt` line 9932).";

        enum PADCTRL_REG73_padctrl_reg73_sl_enum {
            SLOW_EDGE = 0 { name = "Slow Edge"; desc = "slow edge"; };
            FAST_EDGE = 1 { name = "Fast Edge"; desc = "fast edge"; };
        };

        field {
            name = "padctrl_reg73_sl";
            desc = "Rising/Falling speed control of the output signal";
            sw = rw;
            hw = r;
            encode = PADCTRL_REG73_padctrl_reg73_sl_enum;
            reset = 0x0;
        } padctrl_reg73_sl[7:7];

        enum PADCTRL_REG73_padctrl_reg73_ds_enum {
            V_1_MA = 0 { name = "V 1 Ma"; desc = "1 mA"; };
            V_2_MA = 1 { name = "V 2 Ma"; desc = "2 mA"; };
            V_3_MA = 2 { name = "V 3 Ma"; desc = "3 mA"; };
            V_4_MA = 3 { name = "V 4 Ma"; desc = "4 mA"; };
        };

        field {
            name = "padctrl_reg73_ds";
            desc = "Drive capability of the PWM3 pin";
            sw = rw;
            hw = r;
            encode = PADCTRL_REG73_padctrl_reg73_ds_enum;
            reset = 0x0;
        } padctrl_reg73_ds[5:4];
    } PADCTRL_REG73 @ 0x924;

    reg {
        name = "Control register for the SAR_ADC_CH0 functional pin";
        desc = "PADCTRL_REG74 is a control register for the SAR_ADC_CH0 functional pin.

Data sheet 2.6.2 PADCTRL_REG74 (offset 0x128, printed page 2-156, `hi3518ev200-datasheet.txt` line 9967).";

        enum PADCTRL_REG74_padctrl_reg74_st_enum {
            NO_SCHMITT_INPUT = 0 { name = "No Schmitt Input"; desc = "no Schmitt input"; };
            SCHMITT_INPUT = 1 { name = "Schmitt Input"; desc = "Schmitt input"; };
        };

        field {
            name = "padctrl_reg74_st";
            desc = "Input Schmitt control";
            sw = rw;
            hw = r;
            encode = PADCTRL_REG74_padctrl_reg74_st_enum;
            reset = 0x1;
        } padctrl_reg74_st[10:10];

        enum PADCTRL_REG74_padctrl_reg74_pd_enum {
            NO_PULL_DOWN = 0 { name = "No Pull Down"; desc = "no pull-down"; };
            PULL_DOWN = 1 { name = "Pull Down"; desc = "pull-down"; };
        };

        field {
            name = "padctrl_reg74_pd";
            desc = "Input pull-down control";
            sw = rw;
            hw = r;
            encode = PADCTRL_REG74_padctrl_reg74_pd_enum;
            reset = 0x0;
        } padctrl_reg74_pd[9:9];

        enum PADCTRL_REG74_padctrl_reg74_pu_enum {
            NO_PULL_UP = 0 { name = "No Pull Up"; desc = "no pull-up"; };
            PULL_UP = 1 { name = "Pull Up"; desc = "pull-up"; };
        };

        field {
            name = "padctrl_reg74_pu";
            desc = "Input pull-up control";
            sw = rw;
            hw = r;
            encode = PADCTRL_REG74_padctrl_reg74_pu_enum;
            reset = 0x0;
        } padctrl_reg74_pu[8:8];

        enum PADCTRL_REG74_padctrl_reg74_sl_enum {
            SLOW_EDGE = 0 { name = "Slow Edge"; desc = "slow edge"; };
            FAST_EDGE = 1 { name = "Fast Edge"; desc = "fast edge"; };
        };

        field {
            name = "padctrl_reg74_sl";
            desc = "Rising/Falling speed control of the output signal";
            sw = rw;
            hw = r;
            encode = PADCTRL_REG74_padctrl_reg74_sl_enum;
            reset = 0x0;
        } padctrl_reg74_sl[7:7];

        enum PADCTRL_REG74_padctrl_reg74_ds_enum {
            V_1_MA = 0 { name = "V 1 Ma"; desc = "1 mA"; };
            V_2_MA = 1 { name = "V 2 Ma"; desc = "2 mA"; };
            V_3_MA = 2 { name = "V 3 Ma"; desc = "3 mA"; };
            V_4_MA = 3 { name = "V 4 Ma"; desc = "4 mA"; };
        };

        field {
            name = "padctrl_reg74_ds";
            desc = "Drive capability of the SAR_ADC_CH0 pin";
            sw = rw;
            hw = r;
            encode = PADCTRL_REG74_padctrl_reg74_ds_enum;
            reset = 0x0;
        } padctrl_reg74_ds[5:4];
    } PADCTRL_REG74 @ 0x928;

    reg {
        name = "Control register for the SAR_ADC_CH1 functional pin";
        desc = "PADCTRL_REG75 is a control register for the SAR_ADC_CH1 functional pin.

Data sheet 2.6.2 PADCTRL_REG75 (offset 0x12C, printed page 2-157, `hi3518ev200-datasheet.txt` line 10017).";

        enum PADCTRL_REG75_padctrl_reg75_st_enum {
            NO_SCHMITT_INPUT = 0 { name = "No Schmitt Input"; desc = "no Schmitt input"; };
            SCHMITT_INPUT = 1 { name = "Schmitt Input"; desc = "Schmitt input"; };
        };

        field {
            name = "padctrl_reg75_st";
            desc = "Input Schmitt control";
            sw = rw;
            hw = r;
            encode = PADCTRL_REG75_padctrl_reg75_st_enum;
            reset = 0x1;
        } padctrl_reg75_st[10:10];

        enum PADCTRL_REG75_padctrl_reg75_pd_enum {
            NO_PULL_DOWN = 0 { name = "No Pull Down"; desc = "no pull-down"; };
            PULL_DOWN = 1 { name = "Pull Down"; desc = "pull-down"; };
        };

        field {
            name = "padctrl_reg75_pd";
            desc = "Input pull-down control";
            sw = rw;
            hw = r;
            encode = PADCTRL_REG75_padctrl_reg75_pd_enum;
            reset = 0x0;
        } padctrl_reg75_pd[9:9];

        enum PADCTRL_REG75_padctrl_reg75_pu_enum {
            NO_PULL_UP = 0 { name = "No Pull Up"; desc = "no pull-up"; };
            PULL_UP = 1 { name = "Pull Up"; desc = "pull-up"; };
        };

        field {
            name = "padctrl_reg75_pu";
            desc = "Input pull-up control";
            sw = rw;
            hw = r;
            encode = PADCTRL_REG75_padctrl_reg75_pu_enum;
            reset = 0x0;
        } padctrl_reg75_pu[8:8];

        enum PADCTRL_REG75_padctrl_reg75_sl_enum {
            SLOW_EDGE = 0 { name = "Slow Edge"; desc = "slow edge"; };
            FAST_EDGE = 1 { name = "Fast Edge"; desc = "fast edge"; };
        };

        field {
            name = "padctrl_reg75_sl";
            desc = "Rising/Falling speed control of the output signal";
            sw = rw;
            hw = r;
            encode = PADCTRL_REG75_padctrl_reg75_sl_enum;
            reset = 0x0;
        } padctrl_reg75_sl[7:7];

        enum PADCTRL_REG75_padctrl_reg75_ds_enum {
            V_1_MA = 0 { name = "V 1 Ma"; desc = "1 mA"; };
            V_2_MA = 1 { name = "V 2 Ma"; desc = "2 mA"; };
            V_3_MA = 2 { name = "V 3 Ma"; desc = "3 mA"; };
            V_4_MA = 3 { name = "V 4 Ma"; desc = "4 mA"; };
        };

        field {
            name = "padctrl_reg75_ds";
            desc = "Drive capability of the SAR_ADC_CH1 pin";
            sw = rw;
            hw = r;
            encode = PADCTRL_REG75_padctrl_reg75_ds_enum;
            reset = 0x0;
        } padctrl_reg75_ds[5:4];
    } PADCTRL_REG75 @ 0x92C;

    reg {
        name = "Control register for the SAR_ADC_CH2 functional pin";
        desc = "PADCTRL_REG76 is a control register for the SAR_ADC_CH2 functional pin.

Data sheet 2.6.2 PADCTRL_REG76 (offset 0x130, printed page 2-158, `hi3518ev200-datasheet.txt` line 10067).";

        enum PADCTRL_REG76_padctrl_reg76_st_enum {
            NO_SCHMITT_INPUT = 0 { name = "No Schmitt Input"; desc = "no Schmitt input"; };
            SCHMITT_INPUT = 1 { name = "Schmitt Input"; desc = "Schmitt input"; };
        };

        field {
            name = "padctrl_reg76_st";
            desc = "Input Schmitt control";
            sw = rw;
            hw = r;
            encode = PADCTRL_REG76_padctrl_reg76_st_enum;
            reset = 0x1;
        } padctrl_reg76_st[10:10];

        enum PADCTRL_REG76_padctrl_reg76_pd_enum {
            NO_PULL_DOWN = 0 { name = "No Pull Down"; desc = "no pull-down"; };
            PULL_DOWN = 1 { name = "Pull Down"; desc = "pull-down"; };
        };

        field {
            name = "padctrl_reg76_pd";
            desc = "Input pull-down control";
            sw = rw;
            hw = r;
            encode = PADCTRL_REG76_padctrl_reg76_pd_enum;
            reset = 0x0;
        } padctrl_reg76_pd[9:9];

        enum PADCTRL_REG76_padctrl_reg76_pu_enum {
            NO_PULL_UP = 0 { name = "No Pull Up"; desc = "no pull-up"; };
            PULL_UP = 1 { name = "Pull Up"; desc = "pull-up"; };
        };

        field {
            name = "padctrl_reg76_pu";
            desc = "Input pull-up control";
            sw = rw;
            hw = r;
            encode = PADCTRL_REG76_padctrl_reg76_pu_enum;
            reset = 0x0;
        } padctrl_reg76_pu[8:8];

        enum PADCTRL_REG76_padctrl_reg76_sl_enum {
            SLOW_EDGE = 0 { name = "Slow Edge"; desc = "slow edge"; };
            FAST_EDGE = 1 { name = "Fast Edge"; desc = "fast edge"; };
        };

        field {
            name = "padctrl_reg76_sl";
            desc = "Rising/Falling speed control of the output signal";
            sw = rw;
            hw = r;
            encode = PADCTRL_REG76_padctrl_reg76_sl_enum;
            reset = 0x0;
        } padctrl_reg76_sl[7:7];

        enum PADCTRL_REG76_padctrl_reg76_ds_enum {
            V_1_MA = 0 { name = "V 1 Ma"; desc = "1 mA"; };
            V_2_MA = 1 { name = "V 2 Ma"; desc = "2 mA"; };
            V_3_MA = 2 { name = "V 3 Ma"; desc = "3 mA"; };
            V_4_MA = 3 { name = "V 4 Ma"; desc = "4 mA"; };
        };

        field {
            name = "padctrl_reg76_ds";
            desc = "Drive capability of the SAR_ADC_CH2 pin";
            sw = rw;
            hw = r;
            encode = PADCTRL_REG76_padctrl_reg76_ds_enum;
            reset = 0x0;
        } padctrl_reg76_ds[5:4];
    } PADCTRL_REG76 @ 0x930;

    reg {
        name = "Control register for the SAR_ADC_CH3 functional pin";
        desc = "PADCTRL_REG77 is a control register for the SAR_ADC_CH3 functional pin.

Data sheet 2.6.2 PADCTRL_REG77 (offset 0x134, printed page 2-159, `hi3518ev200-datasheet.txt` line 10117).";

        enum PADCTRL_REG77_padctrl_reg77_st_enum {
            NO_SCHMITT_INPUT = 0 { name = "No Schmitt Input"; desc = "no Schmitt input"; };
            SCHMITT_INPUT = 1 { name = "Schmitt Input"; desc = "Schmitt input"; };
        };

        field {
            name = "padctrl_reg77_st";
            desc = "Input Schmitt control";
            sw = rw;
            hw = r;
            encode = PADCTRL_REG77_padctrl_reg77_st_enum;
            reset = 0x1;
        } padctrl_reg77_st[10:10];

        enum PADCTRL_REG77_padctrl_reg77_pd_enum {
            NO_PULL_DOWN = 0 { name = "No Pull Down"; desc = "no pull-down"; };
            PULL_DOWN = 1 { name = "Pull Down"; desc = "pull-down"; };
        };

        field {
            name = "padctrl_reg77_pd";
            desc = "Input pull-down control";
            sw = rw;
            hw = r;
            encode = PADCTRL_REG77_padctrl_reg77_pd_enum;
            reset = 0x0;
        } padctrl_reg77_pd[9:9];

        enum PADCTRL_REG77_padctrl_reg77_pu_enum {
            NO_PULL_UP = 0 { name = "No Pull Up"; desc = "no pull-up"; };
            PULL_UP = 1 { name = "Pull Up"; desc = "pull-up"; };
        };

        field {
            name = "padctrl_reg77_pu";
            desc = "Input pull-up control";
            sw = rw;
            hw = r;
            encode = PADCTRL_REG77_padctrl_reg77_pu_enum;
            reset = 0x0;
        } padctrl_reg77_pu[8:8];

        enum PADCTRL_REG77_padctrl_reg77_sl_enum {
            SLOW_EDGE = 0 { name = "Slow Edge"; desc = "slow edge"; };
            FAST_EDGE = 1 { name = "Fast Edge"; desc = "fast edge"; };
        };

        field {
            name = "padctrl_reg77_sl";
            desc = "Rising/Falling speed control of the output signal";
            sw = rw;
            hw = r;
            encode = PADCTRL_REG77_padctrl_reg77_sl_enum;
            reset = 0x0;
        } padctrl_reg77_sl[7:7];

        enum PADCTRL_REG77_padctrl_reg77_ds_enum {
            V_1_MA = 0 { name = "V 1 Ma"; desc = "1 mA"; };
            V_2_MA = 1 { name = "V 2 Ma"; desc = "2 mA"; };
            V_3_MA = 2 { name = "V 3 Ma"; desc = "3 mA"; };
            V_4_MA = 3 { name = "V 4 Ma"; desc = "4 mA"; };
        };

        field {
            name = "padctrl_reg77_ds";
            desc = "Drive capability of the SAR_ADC_CH3 pin";
            sw = rw;
            hw = r;
            encode = PADCTRL_REG77_padctrl_reg77_ds_enum;
            reset = 0x0;
        } padctrl_reg77_ds[5:4];
    } PADCTRL_REG77 @ 0x934;

};

`endif
