`ifndef HISI_TIMER_SP804_RDL
`define HISI_TIMER_SP804_RDL

regfile eHISI_TIMER_SP804 {
    name = "Timer Registers";
    desc = "
    The timer is based on the [`ARM SP804`](https://developer.arm.com/documentation/ddi0271/latest/) device. Each SP804 is a dual timer: the two timers of a pair
    share one 4 KB window and one interrupt line, timer 0 of the pair at +0x000 and timer 1 at +0x020 (this file is instantiated once per timer, so an SP804 pair is two
    instances 0x20 apart). Timer control: the clock is a TIMCLK enabled by TIMCLKENx (the bus clock or the 3 MHz / 24 MHz reference selected by the system controller
    SC_CTRL `timeren0sel ..` / CRG bits, see the chip's SYS_CTRL / CRG), optionally prescaled by 16 or 256; 16- or 32-bit, free-running / periodic / one-shot.

    The register map (TIMERx_LOAD .. TIMERx_BGLOAD) is identical in every data sheet checked; only the documented reset values differ, selected by macros in each chip's
    `defines.rdl`: `TIMER_SP804_RESET_G1` (TIMERx_CONTROL `intenable` resets to 0: Hi3515, Hi3516 V100, Hi3516A/D V100, Hi3520/Hi3520D V100, Hi3518E V20X, Hi3516A V200,
    Hi3519 V101, Hi3516C V300, Hi3516A V300), `TIMER_SP804_RESET_G2` (`intenable` resets to 1, total 0x20: Hi3511/Hi3512, Hi3516C V100, Hi3518 V100) and
    `TIMER_SP804_RESET_G3` (TIMERx_INTCLR has a documented reset 0: Hi3516A V300 only; the other data sheets give it none). The SP804 TRM reset of TimerXControl is 0x20
    (interrupt enabled), so the G1 value is what the HiSilicon data sheets print, not necessarily what the hardware does. The SP804 TRM also has the ITCR/ITOP integration
    test registers and the PeriphID/PCellID registers (0xF00.., 0xFE0..); no data sheet lists them and they are not modelled.

    ## Instances per SoC

    | SoC | Timers | Base addresses | Interrupt |
    |-----|--------|----------------|-----------|
    | Hi3511 / Hi3512 | Timer0-3 | 0x101E2000 (Timer0/1), 0x101E3000 (Timer2/3) | VIC 4 (Timer0/1), 5 (Timer2/3) |
    | Hi3515 | Timer0-3 | 0x20000000 (Timer0/1), 0x20010000 (Timer2/3) | VIC 4, 5 |
    | Hi3520 V100 | Timer0-7 | 0x20000000, 0x20010000, 0x20020000, 0x20030000 (one pair each) | ARM11 VIC 4 (Timer0/1), 5 (Timer2/3); the second VIC 4 (Timer4/5), 5 (Timer6/7) |
    | Hi3516C V100 / Hi3518 V100 / Hi3518E V20X / Hi3516C V200 | Timer0-3 | 0x20000000, 0x20010000 | VIC 3, 4 |
    | Hi3516 V100 | Timer0-3 | 0x20000000, 0x20010000 | GIC 35, 36 |
    | Hi3516A / Hi3516D V100 | Timer0-3 | 0x20000000, 0x20010000 | GIC 35, 36 |
    | Hi3520D V100 | Timer0-7 | 0x20000000, 0x20010000, 0x20130000, 0x20140000 | GIC 35-38 (the table names them Timer0-3 and has no entries for Timer4-7; each pair shares one line, see the chip's interrupt notes) |
    | Hi3516A V200 / Hi3519 V101 | Timer0-5 | 0x12000000, 0x12001000, 0x12002000 | GIC 96-101 (one line per timer) |
    | Hi3516C V300 / Hi3516E V100 | Timer0-3 | 0x12000000, 0x12001000 | VIC 3, 4 |
    | Hi3516A V300 | Timer0-7 | 0x12000000, 0x12001000, 0x12002000, 0x12003000 | GIC 33-36 (one line per pair) |

    The address maps of the Hi3515, Hi3520 and Hi3520D data sheets call the windows `Timer0 register`, `Timer1 register` .. (one name per SP804 pair); the timer chapters
    number the timers Timer0..Timer7 as in the table above.
    ";

    /* Fields */

    reg {
        name = "Initial Count Value Register";

        field {
            name = "timerx_load";
            desc = "
            Used to set the initial count value of each timer. Each timer has one such register.

            !!! NOTE
                * The minimum valid value written to TIMERx_LOAD is 1.
                * When the value 0 is written to TIMERx_LOAD, the dual-timer module generates an interrupt immediately.

                If values are written to TIMERx_BGLOAD and TIMERx_LOAD before the rising edge of TIMCLK enabled by TIMCLKENx reaches, the count value of the next rising edge of TIMCLK is changed to the value written to TIMERx_LOAD. As the value of TIMERx_BGLOAD changes when data is written to TIMERx_LOAD, the value returned after TIMERx_BGLOAD is read is the latest value that is written to TIMERx_LOAD and TIMERx_BGLOAD. When the timer works in periodic mode and the count value decreases to 0, the initial value is loaded from TIMERx_BGLOAD to continue counting.
            ";
            reset = 0x0;
        } timerx_load[31:0];

    } TIMERx_LOAD @ 0x000;

    reg {
        name = "Current Count Value Register";
        desc = "
        Shows the current value of the counter that is decremented. After a value is written to TIMERx_LOAD, TIMERx_VALUE immediately shows the newly loaded value of the counter in the PCLK domain without waiting for the clock edge of TIMCLK enabled by TIMCLKENx.

        !!! NOTE
            When a timer is in 16-bit mode, the 16 upper bits of the 32-bit TIMERx_VALUE are not set to 0 automatically. If the timer is switched from 32-bit mode to 16-bit mode and no data is written to TIMERx_LOAD, the upper 16 bits of TIMERx_VALUE may be non-zero.
        ";

        field {
            name = "timerx_value";
            desc = "Current count value of the timer.";
            counter;
            decrvalue = 1;
            sw = r;
            hw = w;
            reset = 0xFFFFFFFF;
        } timerx_value[31:0];

    } TIMERx_VALUE @ 0x04;

    reg {
        name = "Timer Control Register";
        desc = "
        !!! NOTE
            When the periodic mode is selected, TIMERx_CONTROL[timermode] must be set to 1 and TIMERx_CONTROL[oneshot] must be set to 0.
        ";

        enum oneshot_enum {
            PERIODIC = 0x0 { desc = "Periodic Mode or Free Running Mode"; };
            ONE_SHOT = 0x1 { desc = "One Shot Mode"; };
        };

        field {
            name = "oneshot";
            desc = "Count mode select.";
            encode = oneshot_enum;
            reset = 0x0;
        } oneshot[0:0];

        enum timersize_enum {
            BIT_16 = 0x0 { desc = "16 Bit Counter"; };
            BIT_32 = 0x1 { desc = "32 Bit Counter"; };
        };

        field {
            name = "timersize";
            desc = "Counter select.";
            encode = timersize_enum;
            reset = 0x0;
        } timersize[1:1];

        enum timerpre_enum {
            PRESCALE_NONE      = 0x0 { desc = "The clock frequency of the timer isn't divided."; };
            PRESCALE_16        = 0x1 { desc = "The clock frequency of the timer is divided by 16 (4 bits of prescale)."; };
            PRESCALE_256       = 0x2 { desc = "The clock frequency of the timer is divided by 256 (8 bits of prescale)."; };
            PRESCALE_UNDEFINED = 0x3 { desc = "Undefined; the data sheets say it behaves like divide by 256."; };
        };

        field {
            name = "timerpre";
            desc = "Prescaling factor configuration.";
            encode = timerpre_enum;
            reset = 0x0;
        } timerpre[3:2];

        enum intenable_enum {
            MASKED     = 0x0 { desc = "Masked"; };
            NOT_MASKED = 0x1 { desc = "Not Masked"; };
        };

        field {
            name = "intenable";
            desc = "Raw interrupt mask.";
            encode = intenable_enum;
`ifdef TIMER_SP804_RESET_G1
            reset = 0x0;
`endif
`ifdef TIMER_SP804_RESET_G2
            reset = 0x1;
`endif
        } intenable[5:5];

        enum timermode_enum {
            FREE_RUNNING = 0x0 { desc = "Free Running Mode"; };
            PERIODIC     = 0x1 { desc = "Periodic Mode"; };
        };

        field {
            name = "timermode";
            desc = "Timer count mode.";
            encode = timermode_enum;
            reset = 0x0;
        } timermode[6:6];

        enum timeren_enum {
            DISABLED = 0x0 { desc = "Disabled"; };
            ENABLED  = 0x1 { desc = "Enabled"; };
        };

        field {
            name = "timeren";
            desc = "Timer enable.";
            encode = timeren_enum;
            reset = 0x0;
        } timeren[7:7];

    } TIMERx_CONTROL @ 0x08;

    reg {
        name = "Interrupt Clear Register";
        desc = "The interrupt status of a counter is cleared after any operation is performed on this register.";

        field {
            name = "timerx_intclr";
            desc = "Writing this register clears the output interrupt.";
            sw = w;
            hw = r;
`ifdef TIMER_SP804_RESET_G3
            reset = 0x0;
`endif
        } timerx_intclr[31:0];

    } TIMERx_INTCLR @ 0x0C;

    reg {
        name = "Raw Interrupt Status Register";
        desc = "The Hi3520D data sheet summary table (Table 3-21) puts TIMERx_RIS at offset 0x010 (0x030 for Timer1/3/5/7) but the TIMER0_RIS register description prints the offset 0x030; the summary table is consistent with the SP804 layout and is used here.";

        enum timerx_ris_enum {
            NO_INTERRUPT = 0x0 { desc = "No Interrupt"; };
            INTERRUPT    = 0x1 { desc = "Interrupt"; };
        };

        field {
            name = "timerx_ris";
            desc = "Raw interrupt status.";
            encode = timerx_ris_enum;
            sw = r;
            hw = w;
            reset = 0x0;
        } timerx_ris[0:0];

    } TIMERx_RIS @ 0x10;

    reg {
        name = "Masked Interrupt Status Register";

        enum timerx_mis_enum {
            NO_INTERRUPT = 0x0 { desc = "No Interrupt; Or Interrupt is Masked"; };
            INTERRUPT    = 0x1 { desc = "Interrupt"; };
        };

        field {
            name = "timerx_mis";
            desc = "Masked interrupt status.";
            encode = timerx_mis_enum;
            sw = r;
            hw = w;
            reset = 0x0;
        } timerx_mis[0:0];

    } TIMERx_MIS @ 0x14;

    reg {
        name = "Periodic Initial Count Value Register";
        desc = "
        The TIMERx_BGLOAD register contains the initial count value of the timer. This register is used to reload an initial count value when the count value of the timer reaches 0 in periodic mode.

        In addition, this register provides another method of accessing TIMERx_LOAD. The difference is that after a value is written to TIMERx_BGLOAD, the timer does not count starting from the input value immediately.
        ";

        field {
            name = "timerx_bgload";
            desc = "
            Initial count value

            !!! NOTE
                Note: This register differs from TIMERx_LOAD. For details, see the descriptions of TIMERx_LOAD.
            ";
            reset = 0x0;
        } timerx_bgload[31:0];

    } TIMERx_BGLOAD @ 0x18;

};
`endif
