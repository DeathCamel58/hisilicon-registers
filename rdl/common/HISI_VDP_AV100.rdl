`ifndef HISI_VDP_AV100_RDL
`define HISI_VDP_AV100_RDL


regfile eHISI_VDP_AV100 {
    name = "HiSilicon video display processor (Hi3516A/D V100)";
    desc = "
    HiSilicon video display processor (VDP) of the Hi3516A V100 / Hi3516D V100 at 0x205C0000 (interrupt 65 on the GIC-400). Video layer V1 (the data sheet documents V1 at 0x1000; the vendor header lists the V0 layer at 0x0800 with the same layout plus 16 regions and DCMP state), graphics layers G0 (header, 0x6000) and G2 (data sheet, 0x7000), display channels DHD0 (header, 0xC000) and DHD1 (data sheet, 0xC400), BT.1120/BT.656 interface registers (BT_* 0xD200, INTF_* 0xD000) and the DATE TV encoder (0xF2xx). Global VOCTRL/VOINTSTA/VOMSKINTSTA/VOINTMSK/VDPVERSION/VO_MUX at 0x0 and the VO DAC control at 0x130. Non-instant registers take effect after the layer/channel `*_UPD` bit, as on the Hi3520D VDP (`eHISI_VDP`). Generation: same register family as the Hi3518E V20X `eHISI_VDP_V2` (79 of its 81 registers appear here) and the Hi3516C V300 / Hi3516A V200 / Hi3519 VDPs.

    Generated 2026-11-10 by build/rdl-audit/video-rdl-scratch/gen_blocks.py: mechanical transcription of the data sheet register tables (ds_extract2 + description extraction from the PDF) merged with the vendor header; not hardware verified.

    Register sources: 153 registers from the data sheet (hi3516av100--Hi3516A-Hi3516D-Datasheet.txt, section 10.2.6); 104 registers and 72 fields from vendor U-Boot 2010.06 `product/hiosd/vo/hi3516a/vou_reg.h` (GPL-2.0 U-Boot tree, HiSilicon copyright, created 2013-04-27; mirror github.com/OpenIPC/u-boot-hi3516cv200) (GPL-2.0, same-chip vendor header), each marked `[inferred]` in its desc (names from the header, meanings inferred from the names, reset/access unknown). Name differences, data sheet kept: 0x4 VOINTSTA [19:19] DS v1_dc_err_int / header v3rr_int; 0x8 VOMSKINTSTA [19:19] DS v1_dc_err_int / header v3rr_clr; 0xC VOINTMSK [19:19] DS v1_dc_err_int / header v3rr_intmsk; 0x100 VO_MUX [27:27] DS yc_sel / header ye_sel; 0xF318 name DS DATE_COEFF70 / header DATE_COEFF71; 0xF31C name DS DATE_COEFF71 / header DATE_COEFF72; 0xF31C DATE_COEFF71 header field phase_shift_coeff [31:0] overlaps DS fields differently; 0xF320 name DS DATE_COEFF72 / header DATE_COEFF73; 0xF320 DATE_COEFF72 header field coef_notch_ovrd [0:0] overlaps DS fields differently; 0xF324 name DS DATE_COEFF73 / header DATE_COEFF74; 0xF324 DATE_COEFF73 header field coef_notch_1 [9:0] overlaps DS fields differently; 0xF328 name DS DATE_COEFF74 / header DATE_COEFF75; 0xF328 DATE_COEFF74 [9:0] DS coef_notch_1 / header coef_notch_3; 0xF328 DATE_COEFF74 [25:16] DS coef_notch_2 / header coef_notch_4; 0xF32C name DS DATE_COEFF75 / header DATE_COEFF76; 0xF32C DATE_COEFF75 [9:0] DS coef_notch_3 / header coef_notch_5; 0xF32C DATE_COEFF75 [25:16] DS coef_notch_4 / header coef_notch_6; 0xF330 name DS DATE_COEFF76 / header DATE_COEFF77; 0xF330 DATE_COEFF76 [9:0] DS coef_notch_5 / header coef_notch_7; 0xF330 DATE_COEFF76 [25:16] DS coef_notch_6 / header coef_notch_8; 0xF334 name DS DATE_COEFF77 / header DATE_COEFF78; 0xF334 DATE_COEFF77 [9:0] DS coef_notch_7 / header coef_notch_9; 0xF334 DATE_COEFF77 [25:16] DS coef_notch_8 / header coef_notch_10; 0xF338 name DS DATE_COEFF78 / header DATE_COEFF79; 0xF338 DATE_COEFF78 [9:0] DS coef_notch_9 / header coef_notch_11; 0xF338 DATE_COEFF78 [25:16] DS coef_notch_10 / header coef_notch_12; 0xF33C name DS DATE_COEFF79 / header DATE_COEFF80; 0xF33C DATE_COEFF79 header field coef_chra_lpf_ovrd [0:0] overlaps DS fields differently; 0xF340 name DS DATE_COEFF80 / header DATE_COEFF81; 0xF340 DATE_COEFF80 header field coef_chra_lpf_1 [8:0] overlaps DS fields differently; 0xF344 name DS DATE_COEFF81 / header DATE_COEFF82; 0xF344 DATE_COEFF81 [8:0] DS coef_chra_lpf_1 / header coef_chra_lpf_3; 0xF344 DATE_COEFF81 [24:16] DS coef_chra_lpf_2 / header coef_chra_lpf_4; 0xF348 name DS DATE_COEFF82 / header DATE_COEFF83; 0xF348 DATE_COEFF82 [8:0] DS coef_chra_lpf_3 / header coef_chra_lpf_5; 0xF348 DATE_COEFF82 [24:16] DS coef_chra_lpf_4 / header coef_chra_lpf_6; 0xF34C name DS DATE_COEFF83 / header DATE_COEFF84; 0xF34C DATE_COEFF83 [8:0] DS coef_chra_lpf_5 / header coef_chra_lpf_7; header register BT_CTRL at 0xD000 renamed BT_CTRL_D000 (name used by the data sheet elsewhere).";

    reg {
        name = "VO control register";
        desc = "VOCTRL is a VO control register. It is used to configure the arbitration mode of surface bus requests.

Data sheet 10.2.6 VOCTRL (offset 0x0, printed page 10-176, `hi3516av100--Hi3516A-Hi3516D-Datasheet.txt` line 68889).";

        enum VOCTRL_vo_ck_gt_en_enum {
            DISABLED = 0 { name = "Disabled"; desc = "disabled"; };
            ENABLED = 1 { name = "Enabled"; desc = "enabled"; };
        };

        field {
            name = "vo_ck_gt_en";
            desc = "VDP clock gating enable.";
            sw = rw;
            hw = r;
            encode = VOCTRL_vo_ck_gt_en_enum;
            reset = 0x0;
        } vo_ck_gt_en[31:31];

        enum VOCTRL_m0_arb_mode_enum {
            POLLING = 0 { name = "Polling"; desc = "polling"; };
            GRAPHICS_LAYER_FIRST = 1 { name = "Graphics Layer First"; desc = "graphics layer first Other values: reserved"; };
        };

        field {
            name = "m0_arb_mode";
            desc = "Arbitration mode of data requests of internal surface buses of VO MAC0.";
            sw = rw;
            hw = r;
            encode = VOCTRL_m0_arb_mode_enum;
            reset = 0x0;
        } m0_arb_mode[3:0];
    } VOCTRL @ 0x0;

    reg {
        name = "VO interrupt status register (read-only)";
        desc = "VOINTSTA is a VO interrupt status register (read-only).

Data sheet 10.2.6 VOINTSTA (offset 0x4, printed page 10-177, `hi3516av100--Hi3516A-Hi3516D-Datasheet.txt` line 68933).";

        field {
            name = "m0_be_int";
            desc = "[inferred] M0 be interrupt. (bits reserved in the data sheet; vendor header `product/hiosd/vo/hi3516a/vou_reg.h` field `m0_be_int`; access and reset unknown, modelled RW)";
            sw = rw;
            hw = r;
        } m0_be_int[30:30];

        field {
            name = "g4rr_int";
            desc = "[inferred] G4rr interrupt. (bits reserved in the data sheet; vendor header `product/hiosd/vo/hi3516a/vou_reg.h` field `g4rr_int`; access and reset unknown, modelled RW)";
            sw = rw;
            hw = r;
        } g4rr_int[26:26];

        field {
            name = "g2rr_int";
            desc = "[inferred] G2rr interrupt. (bits reserved in the data sheet; vendor header `product/hiosd/vo/hi3516a/vou_reg.h` field `g2rr_int`; access and reset unknown, modelled RW)";
            sw = rw;
            hw = r;
        } g2rr_int[24:24];

        field {
            name = "g1rr_int";
            desc = "[inferred] G1rr interrupt. (bits reserved in the data sheet; vendor header `product/hiosd/vo/hi3516a/vou_reg.h` field `g1rr_int`; access and reset unknown, modelled RW)";
            sw = rw;
            hw = r;
        } g1rr_int[23:23];

        field {
            name = "g0rr_int";
            desc = "[inferred] G0rr interrupt. (bits reserved in the data sheet; vendor header `product/hiosd/vo/hi3516a/vou_reg.h` field `g0rr_int`; access and reset unknown, modelled RW)";
            sw = rw;
            hw = r;
        } g0rr_int[22:22];

        field {
            name = "v4rr_int";
            desc = "[inferred] V4rr interrupt. (bits reserved in the data sheet; vendor header `product/hiosd/vo/hi3516a/vou_reg.h` field `v4rr_int`; access and reset unknown, modelled RW)";
            sw = rw;
            hw = r;
        } v4rr_int[20:20];

        enum VOINTSTA_v1_dc_err_int_enum {
            INTERRUPT_REPORTED = 0 { name = "Interrupt Reported"; desc = "An interrupt is reported."; };
            NO_INTERRUPT_REPORTED = 1 { name = "No Interrupt Reported"; desc = "No interrupt is reported."; };
        };

        field {
            name = "v1_dc_err_int";
            desc = "V1 chrominance decompression error interrupt.";
            sw = r;
            hw = w;
            encode = VOINTSTA_v1_dc_err_int_enum;
            reset = 0x0;
        } v1_dc_err_int[19:19];

        enum VOINTSTA_v1_dl_err_int_enum {
            INTERRUPT_REPORTED = 0 { name = "Interrupt Reported"; desc = "An interrupt is reported."; };
            NO_INTERRUPT_REPORTED = 1 { name = "No Interrupt Reported"; desc = "No interrupt is reported."; };
        };

        field {
            name = "v1_dl_err_int";
            desc = "V1 luminance decompression error interrupt.";
            sw = r;
            hw = w;
            encode = VOINTSTA_v1_dl_err_int_enum;
            reset = 0x0;
        } v1_dl_err_int[18:18];

        field {
            name = "dsd0uf_int";
            desc = "[inferred] Dsd0uf interrupt. (bits reserved in the data sheet; vendor header `product/hiosd/vo/hi3516a/vou_reg.h` field `dsd0uf_int`; access and reset unknown, modelled RW)";
            sw = rw;
            hw = r;
        } dsd0uf_int[17:17];

        field {
            name = "dsd0vtthd1_int";
            desc = "[inferred] Dsd0vtthd1 interrupt. (bits reserved in the data sheet; vendor header `product/hiosd/vo/hi3516a/vou_reg.h` field `dsd0vtthd1_int`; access and reset unknown, modelled RW)";
            sw = rw;
            hw = r;
        } dsd0vtthd1_int[16:16];

        field {
            name = "vdac3_unload_int";
            desc = "[inferred] Vdac3 unload interrupt. (bits reserved in the data sheet; vendor header `product/hiosd/vo/hi3516a/vou_reg.h` field `vdac3_unload_int`; access and reset unknown, modelled RW)";
            sw = rw;
            hw = r;
        } vdac3_unload_int[15:15];

        field {
            name = "vdac2_unload_int";
            desc = "[inferred] Vdac2 unload interrupt. (bits reserved in the data sheet; vendor header `product/hiosd/vo/hi3516a/vou_reg.h` field `vdac2_unload_int`; access and reset unknown, modelled RW)";
            sw = rw;
            hw = r;
        } vdac2_unload_int[14:14];

        field {
            name = "vdac1_unload_int";
            desc = "[inferred] Vdac1 unload interrupt. (bits reserved in the data sheet; vendor header `product/hiosd/vo/hi3516a/vou_reg.h` field `vdac1_unload_int`; access and reset unknown, modelled RW)";
            sw = rw;
            hw = r;
        } vdac1_unload_int[13:13];

        enum VOINTSTA_vdac0_unload_int_enum {
            INTERRUPT_REPORTED = 0 { name = "Interrupt Reported"; desc = "An interrupt is reported."; };
            NO_INTERRUPT_REPORTED = 1 { name = "No Interrupt Reported"; desc = "No interrupt is reported."; };
        };

        field {
            name = "vdac0_unload_int";
            desc = "DAC0 offload interrupt.";
            sw = r;
            hw = w;
            encode = VOINTSTA_vdac0_unload_int_enum;
            reset = 0x0;
        } vdac0_unload_int[12:12];

        field {
            name = "g4wbc_vte_int";
            desc = "[inferred] G4wbc vertical timing end interrupt. (bits reserved in the data sheet; vendor header `product/hiosd/vo/hi3516a/vou_reg.h` field `g4wbc_vte_int`; access and reset unknown, modelled RW)";
            sw = rw;
            hw = r;
        } g4wbc_vte_int[11:11];

        field {
            name = "g0wbc_vte_int";
            desc = "[inferred] G0wbc vertical timing end interrupt. (bits reserved in the data sheet; vendor header `product/hiosd/vo/hi3516a/vou_reg.h` field `g0wbc_vte_int`; access and reset unknown, modelled RW)";
            sw = rw;
            hw = r;
        } g0wbc_vte_int[10:10];

        field {
            name = "dwbc0_vte_int";
            desc = "[inferred] Dwbc0 vertical timing end interrupt. (bits reserved in the data sheet; vendor header `product/hiosd/vo/hi3516a/vou_reg.h` field `dwbc0_vte_int`; access and reset unknown, modelled RW)";
            sw = rw;
            hw = r;
        } dwbc0_vte_int[9:9];

        enum VOINTSTA_dhd1uf_int_enum {
            INTERRUPT_REPORTED = 0 { name = "Interrupt Reported"; desc = "An interrupt is reported."; };
            NO_INTERRUPT_REPORTED = 1 { name = "No Interrupt Reported"; desc = "No interrupt is reported."; };
        };

        field {
            name = "dhd1uf_int";
            desc = "DHD1 low-bandwidth alarm interrupt.";
            sw = r;
            hw = w;
            encode = VOINTSTA_dhd1uf_int_enum;
            reset = 0x0;
        } dhd1uf_int[7:7];

        field {
            name = "dhd1vtthd3_int";
            desc = "[inferred] Dhd1vtthd3 interrupt. (bits reserved in the data sheet; vendor header `product/hiosd/vo/hi3516a/vou_reg.h` field `dhd1vtthd3_int`; access and reset unknown, modelled RW)";
            sw = rw;
            hw = r;
        } dhd1vtthd3_int[6:6];

        field {
            name = "dhd1vtthd2_int";
            desc = "[inferred] Dhd1vtthd2 interrupt. (bits reserved in the data sheet; vendor header `product/hiosd/vo/hi3516a/vou_reg.h` field `dhd1vtthd2_int`; access and reset unknown, modelled RW)";
            sw = rw;
            hw = r;
        } dhd1vtthd2_int[5:5];

        enum VOINTSTA_dhd1vtthd1_int_enum {
            INTERRUPT_REPORTED = 0 { name = "Interrupt Reported"; desc = "An interrupt is reported."; };
            NO_INTERRUPT_REPORTED = 1 { name = "No Interrupt Reported"; desc = "No interrupt is reported."; };
        };

        field {
            name = "dhd1vtthd1_int";
            desc = "DHD1 vertical timing interrupt 1.";
            sw = r;
            hw = w;
            encode = VOINTSTA_dhd1vtthd1_int_enum;
            reset = 0x0;
        } dhd1vtthd1_int[4:4];

        field {
            name = "dhd0uf_int";
            desc = "[inferred] Dhd0uf interrupt. (bits reserved in the data sheet; vendor header `product/hiosd/vo/hi3516a/vou_reg.h` field `dhd0uf_int`; access and reset unknown, modelled RW)";
            sw = rw;
            hw = r;
        } dhd0uf_int[3:3];

        field {
            name = "dhd0vtthd3_int";
            desc = "[inferred] Dhd0vtthd3 interrupt. (bits reserved in the data sheet; vendor header `product/hiosd/vo/hi3516a/vou_reg.h` field `dhd0vtthd3_int`; access and reset unknown, modelled RW)";
            sw = rw;
            hw = r;
        } dhd0vtthd3_int[2:2];

        field {
            name = "dhd0vtthd2_int";
            desc = "[inferred] Dhd0vtthd2 interrupt. (bits reserved in the data sheet; vendor header `product/hiosd/vo/hi3516a/vou_reg.h` field `dhd0vtthd2_int`; access and reset unknown, modelled RW)";
            sw = rw;
            hw = r;
        } dhd0vtthd2_int[1:1];

        field {
            name = "dhd0vtthd1_int";
            desc = "[inferred] Dhd0vtthd1 interrupt. (bits reserved in the data sheet; vendor header `product/hiosd/vo/hi3516a/vou_reg.h` field `dhd0vtthd1_int`; access and reset unknown, modelled RW)";
            sw = rw;
            hw = r;
        } dhd0vtthd1_int[0:0];
    } VOINTSTA @ 0x4;

    reg {
        name = "VO masked interrupt status register";
        desc = "VOMSKINTSTA is a VO masked interrupt status register.

Data sheet 10.2.6 VOMSKINTSTA (offset 0x8, printed page 10-178, `hi3516av100--Hi3516A-Hi3516D-Datasheet.txt` line 68996).";

        field {
            name = "m0_be_clr";
            desc = "[inferred] M0 be clear. (bits reserved in the data sheet; vendor header `product/hiosd/vo/hi3516a/vou_reg.h` field `m0_be_clr`; access and reset unknown, modelled RW)";
            sw = rw;
            hw = r;
        } m0_be_clr[30:30];

        field {
            name = "g4rr_clr";
            desc = "[inferred] G4rr clear. (bits reserved in the data sheet; vendor header `product/hiosd/vo/hi3516a/vou_reg.h` field `g4rr_clr`; access and reset unknown, modelled RW)";
            sw = rw;
            hw = r;
        } g4rr_clr[26:26];

        field {
            name = "g2rr_clr";
            desc = "[inferred] G2rr clear. (bits reserved in the data sheet; vendor header `product/hiosd/vo/hi3516a/vou_reg.h` field `g2rr_clr`; access and reset unknown, modelled RW)";
            sw = rw;
            hw = r;
        } g2rr_clr[24:24];

        field {
            name = "g1rr_clr";
            desc = "[inferred] G1rr clear. (bits reserved in the data sheet; vendor header `product/hiosd/vo/hi3516a/vou_reg.h` field `g1rr_clr`; access and reset unknown, modelled RW)";
            sw = rw;
            hw = r;
        } g1rr_clr[23:23];

        field {
            name = "g0rr_clr";
            desc = "[inferred] G0rr clear. (bits reserved in the data sheet; vendor header `product/hiosd/vo/hi3516a/vou_reg.h` field `g0rr_clr`; access and reset unknown, modelled RW)";
            sw = rw;
            hw = r;
        } g0rr_clr[22:22];

        field {
            name = "v4rr_clr";
            desc = "[inferred] V4rr clear. (bits reserved in the data sheet; vendor header `product/hiosd/vo/hi3516a/vou_reg.h` field `v4rr_clr`; access and reset unknown, modelled RW)";
            sw = rw;
            hw = r;
        } v4rr_clr[20:20];

        enum VOMSKINTSTA_v1_dc_err_int_enum {
            INTERRUPT_REPORTED = 0 { name = "Interrupt Reported"; desc = "An interrupt is reported."; };
            NO_INTERRUPT_REPORTED = 1 { name = "No Interrupt Reported"; desc = "No interrupt is reported."; };
        };

        field {
            name = "v1_dc_err_int";
            desc = "V1 chrominance decompression error interrupt.";
            sw = rw;
            hw = w;
            onwrite = woclr;
            encode = VOMSKINTSTA_v1_dc_err_int_enum;
            reset = 0x0;
        } v1_dc_err_int[19:19];

        enum VOMSKINTSTA_v1_dl_err_int_enum {
            INTERRUPT_REPORTED = 0 { name = "Interrupt Reported"; desc = "An interrupt is reported."; };
            NO_INTERRUPT_REPORTED = 1 { name = "No Interrupt Reported"; desc = "No interrupt is reported."; };
        };

        field {
            name = "v1_dl_err_int";
            desc = "V1 luminance decompression error interrupt.";
            sw = rw;
            hw = w;
            onwrite = woclr;
            encode = VOMSKINTSTA_v1_dl_err_int_enum;
            reset = 0x0;
        } v1_dl_err_int[18:18];

        field {
            name = "dsd0uf_clr";
            desc = "[inferred] Dsd0uf clear. (bits reserved in the data sheet; vendor header `product/hiosd/vo/hi3516a/vou_reg.h` field `dsd0uf_clr`; access and reset unknown, modelled RW)";
            sw = rw;
            hw = r;
        } dsd0uf_clr[17:17];

        field {
            name = "dsd0vtthd1_clr";
            desc = "[inferred] Dsd0vtthd1 clear. (bits reserved in the data sheet; vendor header `product/hiosd/vo/hi3516a/vou_reg.h` field `dsd0vtthd1_clr`; access and reset unknown, modelled RW)";
            sw = rw;
            hw = r;
        } dsd0vtthd1_clr[16:16];

        field {
            name = "vdac3_unload_int";
            desc = "[inferred] Vdac3 unload interrupt. (bits reserved in the data sheet; vendor header `product/hiosd/vo/hi3516a/vou_reg.h` field `vdac3_unload_int`; access and reset unknown, modelled RW)";
            sw = rw;
            hw = r;
        } vdac3_unload_int[15:15];

        field {
            name = "vdac2_unload_int";
            desc = "[inferred] Vdac2 unload interrupt. (bits reserved in the data sheet; vendor header `product/hiosd/vo/hi3516a/vou_reg.h` field `vdac2_unload_int`; access and reset unknown, modelled RW)";
            sw = rw;
            hw = r;
        } vdac2_unload_int[14:14];

        field {
            name = "vdac1_unload_int";
            desc = "[inferred] Vdac1 unload interrupt. (bits reserved in the data sheet; vendor header `product/hiosd/vo/hi3516a/vou_reg.h` field `vdac1_unload_int`; access and reset unknown, modelled RW)";
            sw = rw;
            hw = r;
        } vdac1_unload_int[13:13];

        enum VOMSKINTSTA_vdac0_unload_int_enum {
            INTERRUPT_REPORTED = 0 { name = "Interrupt Reported"; desc = "An interrupt is reported."; };
            NO_INTERRUPT_REPORTED = 1 { name = "No Interrupt Reported"; desc = "No interrupt is reported."; };
        };

        field {
            name = "vdac0_unload_int";
            desc = "DAC0 offload interrupt.";
            sw = rw;
            hw = w;
            onwrite = woclr;
            encode = VOMSKINTSTA_vdac0_unload_int_enum;
            reset = 0x0;
        } vdac0_unload_int[12:12];

        field {
            name = "g4wbc_vte_clr";
            desc = "[inferred] G4wbc vertical timing end clear. (bits reserved in the data sheet; vendor header `product/hiosd/vo/hi3516a/vou_reg.h` field `g4wbc_vte_clr`; access and reset unknown, modelled RW)";
            sw = rw;
            hw = r;
        } g4wbc_vte_clr[11:11];

        field {
            name = "g0wbc_vte_clr";
            desc = "[inferred] G0wbc vertical timing end clear. (bits reserved in the data sheet; vendor header `product/hiosd/vo/hi3516a/vou_reg.h` field `g0wbc_vte_clr`; access and reset unknown, modelled RW)";
            sw = rw;
            hw = r;
        } g0wbc_vte_clr[10:10];

        field {
            name = "dwbc0_vte_clr";
            desc = "[inferred] Dwbc0 vertical timing end clear. (bits reserved in the data sheet; vendor header `product/hiosd/vo/hi3516a/vou_reg.h` field `dwbc0_vte_clr`; access and reset unknown, modelled RW)";
            sw = rw;
            hw = r;
        } dwbc0_vte_clr[9:9];

        enum VOMSKINTSTA_dhd1uf_clr_enum {
            INTERRUPT_REPORTED = 0 { name = "Interrupt Reported"; desc = "An interrupt is reported."; };
            NO_INTERRUPT_REPORTED = 1 { name = "No Interrupt Reported"; desc = "No interrupt is reported."; };
        };

        field {
            name = "dhd1uf_clr";
            desc = "DHD1 low-bandwidth alarm interrupt.";
            sw = rw;
            hw = w;
            onwrite = woclr;
            encode = VOMSKINTSTA_dhd1uf_clr_enum;
            reset = 0x0;
        } dhd1uf_clr[7:7];

        field {
            name = "dhd1vtthd3_clr";
            desc = "[inferred] Dhd1vtthd3 clear. (bits reserved in the data sheet; vendor header `product/hiosd/vo/hi3516a/vou_reg.h` field `dhd1vtthd3_clr`; access and reset unknown, modelled RW)";
            sw = rw;
            hw = r;
        } dhd1vtthd3_clr[6:6];

        field {
            name = "dhd1vtthd2_clr";
            desc = "[inferred] Dhd1vtthd2 clear. (bits reserved in the data sheet; vendor header `product/hiosd/vo/hi3516a/vou_reg.h` field `dhd1vtthd2_clr`; access and reset unknown, modelled RW)";
            sw = rw;
            hw = r;
        } dhd1vtthd2_clr[5:5];

        enum VOMSKINTSTA_dhd1vtthd1_clr_enum {
            INTERRUPT_REPORTED = 0 { name = "Interrupt Reported"; desc = "An interrupt is reported."; };
            NO_INTERRUPT_REPORTED = 1 { name = "No Interrupt Reported"; desc = "No interrupt is reported."; };
        };

        field {
            name = "dhd1vtthd1_clr";
            desc = "DHD1 vertical timing interrupt 1.";
            sw = rw;
            hw = w;
            onwrite = woclr;
            encode = VOMSKINTSTA_dhd1vtthd1_clr_enum;
            reset = 0x0;
        } dhd1vtthd1_clr[4:4];

        field {
            name = "dhd0uf_clr";
            desc = "[inferred] Dhd0uf clear. (bits reserved in the data sheet; vendor header `product/hiosd/vo/hi3516a/vou_reg.h` field `dhd0uf_clr`; access and reset unknown, modelled RW)";
            sw = rw;
            hw = r;
        } dhd0uf_clr[3:3];

        field {
            name = "dhd0vtthd3_clr";
            desc = "[inferred] Dhd0vtthd3 clear. (bits reserved in the data sheet; vendor header `product/hiosd/vo/hi3516a/vou_reg.h` field `dhd0vtthd3_clr`; access and reset unknown, modelled RW)";
            sw = rw;
            hw = r;
        } dhd0vtthd3_clr[2:2];

        field {
            name = "dhd0vtthd2_clr";
            desc = "[inferred] Dhd0vtthd2 clear. (bits reserved in the data sheet; vendor header `product/hiosd/vo/hi3516a/vou_reg.h` field `dhd0vtthd2_clr`; access and reset unknown, modelled RW)";
            sw = rw;
            hw = r;
        } dhd0vtthd2_clr[1:1];

        field {
            name = "dhd0vtthd1_clr";
            desc = "[inferred] Dhd0vtthd1 clear. (bits reserved in the data sheet; vendor header `product/hiosd/vo/hi3516a/vou_reg.h` field `dhd0vtthd1_clr`; access and reset unknown, modelled RW)";
            sw = rw;
            hw = r;
        } dhd0vtthd1_clr[0:0];
    } VOMSKINTSTA @ 0x8;

    reg {
        name = "VDP interrupt mask register";
        desc = "VOINTMSK is a VDP interrupt mask register. Huawei Proprietary and Confidential Hi3516A/Hi3516D Professional HD IP Camera SoC

Data sheet 10.2.6 VOINTMSK (offset 0xC, printed page 10-180, `hi3516av100--Hi3516A-Hi3516D-Datasheet.txt` line 69069).";

        field {
            name = "m0_be_intmsk";
            desc = "[inferred] M0 be interrupt mask. (bits reserved in the data sheet; vendor header `product/hiosd/vo/hi3516a/vou_reg.h` field `m0_be_intmsk`; access and reset unknown, modelled RW)";
            sw = rw;
            hw = r;
        } m0_be_intmsk[30:30];

        field {
            name = "g4rr_intmsk";
            desc = "[inferred] G4rr interrupt mask. (bits reserved in the data sheet; vendor header `product/hiosd/vo/hi3516a/vou_reg.h` field `g4rr_intmsk`; access and reset unknown, modelled RW)";
            sw = rw;
            hw = r;
        } g4rr_intmsk[26:26];

        field {
            name = "g2rr_intmsk";
            desc = "[inferred] G2rr interrupt mask. (bits reserved in the data sheet; vendor header `product/hiosd/vo/hi3516a/vou_reg.h` field `g2rr_intmsk`; access and reset unknown, modelled RW)";
            sw = rw;
            hw = r;
        } g2rr_intmsk[24:24];

        field {
            name = "g1rr_intmsk";
            desc = "[inferred] G1rr interrupt mask. (bits reserved in the data sheet; vendor header `product/hiosd/vo/hi3516a/vou_reg.h` field `g1rr_intmsk`; access and reset unknown, modelled RW)";
            sw = rw;
            hw = r;
        } g1rr_intmsk[23:23];

        field {
            name = "g0rr_intmsk";
            desc = "[inferred] G0rr interrupt mask. (bits reserved in the data sheet; vendor header `product/hiosd/vo/hi3516a/vou_reg.h` field `g0rr_intmsk`; access and reset unknown, modelled RW)";
            sw = rw;
            hw = r;
        } g0rr_intmsk[22:22];

        field {
            name = "v4rr_intmsk";
            desc = "[inferred] V4rr interrupt mask. (bits reserved in the data sheet; vendor header `product/hiosd/vo/hi3516a/vou_reg.h` field `v4rr_intmsk`; access and reset unknown, modelled RW)";
            sw = rw;
            hw = r;
        } v4rr_intmsk[20:20];

        enum VOINTMSK_v1_dc_err_int_enum {
            MASKED = 0 { name = "Masked"; desc = "masked"; };
            ENABLED = 1 { name = "Enabled"; desc = "enabled"; };
        };

        field {
            name = "v1_dc_err_int";
            desc = "Mask for the V1 chrominance decompression error interrupt.";
            sw = rw;
            hw = r;
            encode = VOINTMSK_v1_dc_err_int_enum;
            reset = 0x0;
        } v1_dc_err_int[19:19];

        enum VOINTMSK_v1_dl_err_int_enum {
            MASKED = 0 { name = "Masked"; desc = "masked"; };
            ENABLED = 1 { name = "Enabled"; desc = "enabled"; };
        };

        field {
            name = "v1_dl_err_int";
            desc = "Mask for the V1 luminance decompression error interrupt.";
            sw = rw;
            hw = r;
            encode = VOINTMSK_v1_dl_err_int_enum;
            reset = 0x0;
        } v1_dl_err_int[18:18];

        field {
            name = "dsd0uf_intmsk";
            desc = "[inferred] Dsd0uf interrupt mask. (bits reserved in the data sheet; vendor header `product/hiosd/vo/hi3516a/vou_reg.h` field `dsd0uf_intmsk`; access and reset unknown, modelled RW)";
            sw = rw;
            hw = r;
        } dsd0uf_intmsk[17:17];

        field {
            name = "dsd0vtthd1_intmsk";
            desc = "[inferred] Dsd0vtthd1 interrupt mask. (bits reserved in the data sheet; vendor header `product/hiosd/vo/hi3516a/vou_reg.h` field `dsd0vtthd1_intmsk`; access and reset unknown, modelled RW)";
            sw = rw;
            hw = r;
        } dsd0vtthd1_intmsk[16:16];

        field {
            name = "vdac3_unload_intmsk";
            desc = "[inferred] Vdac3 unload interrupt mask. (bits reserved in the data sheet; vendor header `product/hiosd/vo/hi3516a/vou_reg.h` field `vdac3_unload_intmsk`; access and reset unknown, modelled RW)";
            sw = rw;
            hw = r;
        } vdac3_unload_intmsk[15:15];

        field {
            name = "vdac2_unload_intmsk";
            desc = "[inferred] Vdac2 unload interrupt mask. (bits reserved in the data sheet; vendor header `product/hiosd/vo/hi3516a/vou_reg.h` field `vdac2_unload_intmsk`; access and reset unknown, modelled RW)";
            sw = rw;
            hw = r;
        } vdac2_unload_intmsk[14:14];

        field {
            name = "vdac1_unload_intmsk";
            desc = "[inferred] Vdac1 unload interrupt mask. (bits reserved in the data sheet; vendor header `product/hiosd/vo/hi3516a/vou_reg.h` field `vdac1_unload_intmsk`; access and reset unknown, modelled RW)";
            sw = rw;
            hw = r;
        } vdac1_unload_intmsk[13:13];

        enum VOINTMSK_vdac0_unload_intmsk_enum {
            MASKED = 0 { name = "Masked"; desc = "masked"; };
            ENABLED = 1 { name = "Enabled"; desc = "enabled"; };
        };

        field {
            name = "vdac0_unload_intmsk";
            desc = "Mask for the DAC0 offload interrupt.";
            sw = rw;
            hw = r;
            encode = VOINTMSK_vdac0_unload_intmsk_enum;
            reset = 0x0;
        } vdac0_unload_intmsk[12:12];

        field {
            name = "g4wbc_vte_intmsk";
            desc = "[inferred] G4wbc vertical timing end interrupt mask. (bits reserved in the data sheet; vendor header `product/hiosd/vo/hi3516a/vou_reg.h` field `g4wbc_vte_intmsk`; access and reset unknown, modelled RW)";
            sw = rw;
            hw = r;
        } g4wbc_vte_intmsk[11:11];

        field {
            name = "g0wbc_vte_intmsk";
            desc = "[inferred] G0wbc vertical timing end interrupt mask. (bits reserved in the data sheet; vendor header `product/hiosd/vo/hi3516a/vou_reg.h` field `g0wbc_vte_intmsk`; access and reset unknown, modelled RW)";
            sw = rw;
            hw = r;
        } g0wbc_vte_intmsk[10:10];

        field {
            name = "dwbc0_vte_intmsk";
            desc = "[inferred] Dwbc0 vertical timing end interrupt mask. (bits reserved in the data sheet; vendor header `product/hiosd/vo/hi3516a/vou_reg.h` field `dwbc0_vte_intmsk`; access and reset unknown, modelled RW)";
            sw = rw;
            hw = r;
        } dwbc0_vte_intmsk[9:9];

        enum VOINTMSK_dhd1uf_intmsk_enum {
            MASKED = 0 { name = "Masked"; desc = "masked"; };
            ENABLED = 1 { name = "Enabled"; desc = "enabled"; };
        };

        field {
            name = "dhd1uf_intmsk";
            desc = "Mask for the DHD1 low-bandwidth alarm interrupt.";
            sw = rw;
            hw = r;
            encode = VOINTMSK_dhd1uf_intmsk_enum;
            reset = 0x0;
        } dhd1uf_intmsk[7:7];

        field {
            name = "dhd1vtthd3_intmsk";
            desc = "[inferred] Dhd1vtthd3 interrupt mask. (bits reserved in the data sheet; vendor header `product/hiosd/vo/hi3516a/vou_reg.h` field `dhd1vtthd3_intmsk`; access and reset unknown, modelled RW)";
            sw = rw;
            hw = r;
        } dhd1vtthd3_intmsk[6:6];

        field {
            name = "dhd1vtthd2_intmsk";
            desc = "[inferred] Dhd1vtthd2 interrupt mask. (bits reserved in the data sheet; vendor header `product/hiosd/vo/hi3516a/vou_reg.h` field `dhd1vtthd2_intmsk`; access and reset unknown, modelled RW)";
            sw = rw;
            hw = r;
        } dhd1vtthd2_intmsk[5:5];

        enum VOINTMSK_dhd1vtthd1_intmsk_enum {
            MASKED = 0 { name = "Masked"; desc = "masked"; };
            ENABLED = 1 { name = "Enabled"; desc = "enabled"; };
        };

        field {
            name = "dhd1vtthd1_intmsk";
            desc = "Mask for DHD1 vertical timing interrupt 1.";
            sw = rw;
            hw = r;
            encode = VOINTMSK_dhd1vtthd1_intmsk_enum;
            reset = 0x0;
        } dhd1vtthd1_intmsk[4:4];

        field {
            name = "dhd0uf_intmsk";
            desc = "[inferred] Dhd0uf interrupt mask. (bits reserved in the data sheet; vendor header `product/hiosd/vo/hi3516a/vou_reg.h` field `dhd0uf_intmsk`; access and reset unknown, modelled RW)";
            sw = rw;
            hw = r;
        } dhd0uf_intmsk[3:3];

        field {
            name = "dhd0vtthd3_intmsk";
            desc = "[inferred] Dhd0vtthd3 interrupt mask. (bits reserved in the data sheet; vendor header `product/hiosd/vo/hi3516a/vou_reg.h` field `dhd0vtthd3_intmsk`; access and reset unknown, modelled RW)";
            sw = rw;
            hw = r;
        } dhd0vtthd3_intmsk[2:2];

        field {
            name = "dhd0vtthd2_intmsk";
            desc = "[inferred] Dhd0vtthd2 interrupt mask. (bits reserved in the data sheet; vendor header `product/hiosd/vo/hi3516a/vou_reg.h` field `dhd0vtthd2_intmsk`; access and reset unknown, modelled RW)";
            sw = rw;
            hw = r;
        } dhd0vtthd2_intmsk[1:1];

        field {
            name = "dhd0vtthd1_intmsk";
            desc = "[inferred] Dhd0vtthd1 interrupt mask. (bits reserved in the data sheet; vendor header `product/hiosd/vo/hi3516a/vou_reg.h` field `dhd0vtthd1_intmsk`; access and reset unknown, modelled RW)";
            sw = rw;
            hw = r;
        } dhd0vtthd1_intmsk[0:0];
    } VOINTMSK @ 0xC;

    reg {
        name = "VDP version register 1";
        desc = "VDPVERSION1 is VDP version register 1.

Data sheet 10.2.6 VDPVERSION1 (offset 0x10, printed page 10-181, `hi3516av100--Hi3516A-Hi3516D-Datasheet.txt` line 69132).";

        field {
            name = "vdpversion1";
            desc = "VDP version 1.";
            sw = r;
            hw = w;
            reset = 0x76756F76;
        } vdpversion1[31:0];
    } VDPVERSION1 @ 0x10;

    reg {
        name = "VDP version register 2";
        desc = "VDPVERSION2 is VDP version register 2.

Data sheet 10.2.6 VDPVERSION2 (offset 0x14, printed page 10-181, `hi3516av100--Hi3516A-Hi3516D-Datasheet.txt` line 69150).";

        field {
            name = "vdpversion2";
            desc = "VDP version 2.";
            sw = r;
            hw = w;
            reset = 0x30313134;
        } vdpversion2[31:0];
    } VDPVERSION2 @ 0x14;

    reg {
        name = "VO AXI bus configuration register";
        desc = "VOAXICTRL is a VO AXI bus configuration register. Huawei Proprietary and Confidential Hi3516A/Hi3516D Professional HD IP Camera SoC

Data sheet 10.2.6 VOAXICTRL (offset 0x34, printed page 10-182, `hi3516av100--Hi3516A-Hi3516D-Datasheet.txt` line 69178).";

        field {
            name = "m0_wr_ostd";
            desc = "[inferred] M0 write outstanding. (bits reserved in the data sheet; vendor header `product/hiosd/vo/hi3516a/vou_reg.h` field `m0_wr_ostd`; access and reset unknown, modelled RW)";
            sw = rw;
            hw = r;
        } m0_wr_ostd[11:8];

        field {
            name = "m0_outstd_rid0";
            desc = "Read ID0 outstanding of AXI master 0. The value ranges from 0 to 7.";
            sw = rw;
            hw = r;
            reset = 0x1;
        } m0_outstd_rid0[3:0];
    } VOAXICTRL @ 0x34;

    reg {
        name = "VOUFSTA";
        desc = "[inferred] VOUFSTA. Not in the data sheet. Source: vendor U-Boot 2010.06 `product/hiosd/vo/hi3516a/vou_reg.h` (GPL-2.0 U-Boot tree, HiSilicon copyright, created 2013-04-27; mirror github.com/OpenIPC/u-boot-hi3516cv200), union `U_VOUFSTA`, struct offset 0x40 (GPL-2.0, same-chip vendor header). Reset value and access type unknown (modelled RW, no reset). Confidence: medium (vendor header for this chip family, not hardware verified).";

        field {
            name = "g4_uf_sta";
            desc = "[inferred] G4 underflow status. (vendor header `product/hiosd/vo/hi3516a/vou_reg.h` field `g4_uf_sta`; access and reset unknown, modelled RW)";
            sw = rw;
            hw = r;
        } g4_uf_sta[12:12];

        field {
            name = "g2_uf_sta";
            desc = "[inferred] G2 underflow status. (vendor header `product/hiosd/vo/hi3516a/vou_reg.h` field `g2_uf_sta`; access and reset unknown, modelled RW)";
            sw = rw;
            hw = r;
        } g2_uf_sta[10:10];

        field {
            name = "g1_uf_sta";
            desc = "[inferred] G1 underflow status. (vendor header `product/hiosd/vo/hi3516a/vou_reg.h` field `g1_uf_sta`; access and reset unknown, modelled RW)";
            sw = rw;
            hw = r;
        } g1_uf_sta[9:9];

        field {
            name = "g0_uf_sta";
            desc = "[inferred] G0 underflow status. (vendor header `product/hiosd/vo/hi3516a/vou_reg.h` field `g0_uf_sta`; access and reset unknown, modelled RW)";
            sw = rw;
            hw = r;
        } g0_uf_sta[8:8];

        field {
            name = "v3_uf_sta";
            desc = "[inferred] V3 underflow status. (vendor header `product/hiosd/vo/hi3516a/vou_reg.h` field `v3_uf_sta`; access and reset unknown, modelled RW)";
            sw = rw;
            hw = r;
        } v3_uf_sta[3:3];

        field {
            name = "v1_uf_sta";
            desc = "[inferred] V1 underflow status. (vendor header `product/hiosd/vo/hi3516a/vou_reg.h` field `v1_uf_sta`; access and reset unknown, modelled RW)";
            sw = rw;
            hw = r;
        } v1_uf_sta[1:1];

        field {
            name = "v0_uf_sta";
            desc = "[inferred] V0 underflow status. (vendor header `product/hiosd/vo/hi3516a/vou_reg.h` field `v0_uf_sta`; access and reset unknown, modelled RW)";
            sw = rw;
            hw = r;
        } v0_uf_sta[0:0];
    } VOUFSTA @ 0x40;

    reg {
        name = "VOUFCLR";
        desc = "[inferred] VOUFCLR. Not in the data sheet. Source: vendor U-Boot 2010.06 `product/hiosd/vo/hi3516a/vou_reg.h` (GPL-2.0 U-Boot tree, HiSilicon copyright, created 2013-04-27; mirror github.com/OpenIPC/u-boot-hi3516cv200), union `U_VOUFCLR`, struct offset 0x44 (GPL-2.0, same-chip vendor header). Reset value and access type unknown (modelled RW, no reset). Confidence: medium (vendor header for this chip family, not hardware verified).";

        field {
            name = "g4_uf_clr";
            desc = "[inferred] G4 underflow clear. (vendor header `product/hiosd/vo/hi3516a/vou_reg.h` field `g4_uf_clr`; access and reset unknown, modelled RW)";
            sw = rw;
            hw = r;
        } g4_uf_clr[12:12];

        field {
            name = "g2_uf_clr";
            desc = "[inferred] G2 underflow clear. (vendor header `product/hiosd/vo/hi3516a/vou_reg.h` field `g2_uf_clr`; access and reset unknown, modelled RW)";
            sw = rw;
            hw = r;
        } g2_uf_clr[10:10];

        field {
            name = "g1_uf_clr";
            desc = "[inferred] G1 underflow clear. (vendor header `product/hiosd/vo/hi3516a/vou_reg.h` field `g1_uf_clr`; access and reset unknown, modelled RW)";
            sw = rw;
            hw = r;
        } g1_uf_clr[9:9];

        field {
            name = "g0_uf_clr";
            desc = "[inferred] G0 underflow clear. (vendor header `product/hiosd/vo/hi3516a/vou_reg.h` field `g0_uf_clr`; access and reset unknown, modelled RW)";
            sw = rw;
            hw = r;
        } g0_uf_clr[8:8];

        field {
            name = "v3_uf_clr";
            desc = "[inferred] V3 underflow clear. (vendor header `product/hiosd/vo/hi3516a/vou_reg.h` field `v3_uf_clr`; access and reset unknown, modelled RW)";
            sw = rw;
            hw = r;
        } v3_uf_clr[3:3];

        field {
            name = "v1_uf_clr";
            desc = "[inferred] V1 underflow clear. (vendor header `product/hiosd/vo/hi3516a/vou_reg.h` field `v1_uf_clr`; access and reset unknown, modelled RW)";
            sw = rw;
            hw = r;
        } v1_uf_clr[1:1];

        field {
            name = "v0_uf_clr";
            desc = "[inferred] V0 underflow clear. (vendor header `product/hiosd/vo/hi3516a/vou_reg.h` field `v0_uf_clr`; access and reset unknown, modelled RW)";
            sw = rw;
            hw = r;
        } v0_uf_clr[0:0];
    } VOUFCLR @ 0x44;

    reg {
        name = "VO interface multiplexing register";
        desc = "VO_MUX is a VO interface multiplexing register.

Data sheet 10.2.6 VO_MUX (offset 0x100, printed page 10-182, `hi3516av100--Hi3516A-Hi3516D-Datasheet.txt` line 69201).";

        enum VO_MUX_digital_sel_enum {
            BT_1120 = 0 { name = "Bt 1120"; desc = "BT.1120 (default)"; };
            BT_656 = 1 { name = "Bt 656"; desc = "BT.656"; };
        };

        field {
            name = "digital_sel";
            desc = "Digital interface data select.";
            sw = rw;
            hw = r;
            encode = VO_MUX_digital_sel_enum;
            reset = 0x0;
        } digital_sel[31:28];

        enum VO_MUX_yc_sel_enum {
            UPPER_EIGHT_BITS = 0 { name = "Upper Eight Bits"; desc = "The upper eight bits are used to transmit the Y component, and the lower eight bits are used to transmit the C component."; };
            UPPER_EIGHT_BITS_2 = 1 { name = "Upper Eight Bits 2"; desc = "The upper eight bits are used to transmit the C component, and the lower eight bits are used to transmit the Y component."; };
        };

        field {
            name = "yc_sel";
            desc = "BT.1120 Y/C position select.";
            sw = rw;
            hw = r;
            encode = VO_MUX_yc_sel_enum;
            reset = 0x0;
        } yc_sel[27:27];

        field {
            name = "bt1120_sel";
            desc = "[inferred] Bt1120 select. (bits reserved in the data sheet; vendor header `product/hiosd/vo/hi3516a/vou_reg.h` field `bt1120_sel`; access and reset unknown, modelled RW)";
            sw = rw;
            hw = r;
        } bt1120_sel[23:20];
    } VO_MUX @ 0x100;

    reg {
        name = "VO DAC interface multiplexing register";
        desc = "VO_MUX_DAC is a VO DAC interface multiplexing register. Huawei Proprietary and Confidential Hi3516A/Hi3516D Professional HD IP Camera SoC

Data sheet 10.2.6 VO_MUX_DAC (offset 0x104, printed page 10-183, `hi3516av100--Hi3516A-Hi3516D-Datasheet.txt` line 69241).";

        field {
            name = "dac3_sel";
            desc = "[inferred] Dac3 select. (bits reserved in the data sheet; vendor header `product/hiosd/vo/hi3516a/vou_reg.h` field `dac3_sel`; access and reset unknown, modelled RW)";
            sw = rw;
            hw = r;
        } dac3_sel[15:12];

        field {
            name = "dac2_sel";
            desc = "[inferred] Dac2 select. (bits reserved in the data sheet; vendor header `product/hiosd/vo/hi3516a/vou_reg.h` field `dac2_sel`; access and reset unknown, modelled RW)";
            sw = rw;
            hw = r;
        } dac2_sel[11:8];

        field {
            name = "dac1_sel";
            desc = "[inferred] Dac1 select. (bits reserved in the data sheet; vendor header `product/hiosd/vo/hi3516a/vou_reg.h` field `dac1_sel`; access and reset unknown, modelled RW)";
            sw = rw;
            hw = r;
        } dac1_sel[7:4];

        enum VO_MUX_DAC_dac0_sel_enum {
            CVBS_VIDEO = 0 { name = "Cvbs Video"; desc = "CVBS video (SDATE)"; };
            SD_ANALOG_VIDEO = 1 { name = "Sd Analog Video"; desc = "SD analog video Y/R component (SDATE)"; };
            SD_ANALOG_VIDEO_2 = 2 { name = "Sd Analog Video 2"; desc = "SD analog video Cb/G component (SDATE)"; };
            SD_ANALOG_VIDEO_3 = 3 { name = "Sd Analog Video 3"; desc = "SD analog video Cr/B component (SDATE)"; };
            HD_ANALOG_VIDEO = 4 { name = "Hd Analog Video"; desc = "HD analog video Y/R component (HDATE)"; };
            HD_ANALOG_VIDEO_2 = 5 { name = "Hd Analog Video 2"; desc = "HD analog video Cb/G component (HDATE)"; };
            HD_ANALOG_VIDEO_3 = 6 { name = "Hd Analog Video 3"; desc = "HD analog video Cr/B component (HDATE)"; };
            VGA_VIDEO_R = 7 { name = "Vga Video R"; desc = "VGA video R component"; };
            VGA_VIDEO_G = 8 { name = "Vga Video G"; desc = "VGA video G component"; };
            VGA_VIDEO_B = 9 { name = "Vga Video B"; desc = "VGA video B component Other values: reserved"; };
        };

        field {
            name = "dac0_sel";
            desc = "DAC0 output select. The default value is 0x0.";
            sw = rw;
            hw = r;
            encode = VO_MUX_DAC_dac0_sel_enum;
            reset = 0x0;
        } dac0_sel[3:0];
    } VO_MUX_DAC @ 0x104;

    reg {
        name = "VO interface test register NC";
        desc = "VO_MUX_TESTSYNC is a VO interface test register.

Data sheet 10.2.6 VO_MUX_TESTSYNC (offset 0x108, printed page 10-183, `hi3516av100--Hi3516A-Hi3516D-Datasheet.txt` line 69272).";

        enum VO_MUX_TESTSYNC_vo_test_en_enum {
            DISABLED = 0 { name = "Disabled"; desc = "disabled"; };
            ENABLED = 1 { name = "Enabled"; desc = "enabled"; };
        };

        field {
            name = "vo_test_en";
            desc = "VDP output interface test enable.";
            sw = rw;
            hw = r;
            encode = VO_MUX_TESTSYNC_vo_test_en_enum;
            reset = 0x0;
        } vo_test_en[31:31];

        field {
            name = "test_field";
            desc = "Test value of the field signal.";
            sw = rw;
            hw = r;
            reset = 0x0;
        } test_field[3:3];

        field {
            name = "test_vsync";
            desc = "Test value of the vsync signal.";
            sw = rw;
            hw = r;
            reset = 0x1;
        } test_vsync[2:2];

        field {
            name = "test_hsync";
            desc = "Test value of the hsync signal.";
            sw = rw;
            hw = r;
            reset = 0x0;
        } test_hsync[1:1];

        field {
            name = "test_dv";
            desc = "Test value of the dv signal.";
            sw = rw;
            hw = r;
            reset = 0x0;
        } test_dv[0:0];
    } VO_MUX_TESTSYNC @ 0x108;

    reg {
        name = "VO interface test data register TA";
        desc = "VO_MUX_TESTDATA is a VO interface test data register.

Data sheet 10.2.6 VO_MUX_TESTDATA (offset 0x10C, printed page 10-184, `hi3516av100--Hi3516A-Hi3516D-Datasheet.txt` line 69314).";

        field {
            name = "test_data";
            desc = "Output data in test mode. The output of DAC0-3 channels is the lower 10 bits of the register value, the output of the BT.1120 channel is the lower 16 bits of the register value, the output of the LCD channel is bits 29-22, 19-12, and 9-2, and the output of other channels is the register value. The output is from upper bits to lower bits in RGB or YUV format.";
            sw = rw;
            hw = r;
            reset = 0x0;
        } test_data[29:0];
    } VO_MUX_TESTDATA @ 0x10C;

    reg {
        name = "VO DAC control register";
        desc = "VO_DAC_CTRL is a VO DAC control register. Huawei Proprietary and Confidential Hi3516A/Hi3516D Professional HD IP Camera SoC

Data sheet 10.2.6 VO_DAC_CTRL (offset 0x120, printed page 10-185, `hi3516av100--Hi3516A-Hi3516D-Datasheet.txt` line 69352).";

        enum VO_DAC_CTRL_envbg_enum {
            DISABLED = 0 { name = "Disabled"; desc = "disabled"; };
            ENABLED = 1 { name = "Enabled"; desc = "enabled"; };
        };

        field {
            name = "envbg";
            desc = "Power up enable for the internal band gap of the DAC.";
            sw = rw;
            hw = r;
            encode = VO_DAC_CTRL_envbg_enum;
            reset = 0x0;
        } envbg[31:31];

        enum VO_DAC_CTRL_enextref_enum {
            INTERNAL_SIGNAL_USED = 0 { name = "Internal Signal Used"; desc = "The internal signal is used, and the VBG pin does not output a signal to the test pin."; };
            VBG_PIN_OUTPUTS = 1 { name = "Vbg Pin Outputs"; desc = "The VBG pin outputs a signal externally for tests."; };
        };

        field {
            name = "enextref";
            desc = "VBG output test enable.";
            sw = rw;
            hw = r;
            encode = VO_DAC_CTRL_enextref_enum;
            reset = 0x0;
        } enextref[30:30];

        field {
            name = "enctr";
            desc = "DAC0 analog biasing enable. The value 3'b000 indicates the normal working mode.";
            sw = rw;
            hw = r;
            reset = 0x0;
        } enctr[18:16];
    } VO_DAC_CTRL @ 0x120;

    reg {
        name = "VO DAC C control";
        desc = "[inferred] VO DAC C control. Not in the data sheet. Source: vendor U-Boot 2010.06 `product/hiosd/vo/hi3516a/vou_reg.h` (GPL-2.0 U-Boot tree, HiSilicon copyright, created 2013-04-27; mirror github.com/OpenIPC/u-boot-hi3516cv200), union `U_VO_DAC_C_CTRL`, struct offset 0x130 (GPL-2.0, same-chip vendor header). Reset value and access type unknown (modelled RW, no reset). Confidence: medium (vendor header for this chip family, not hardware verified).";

        field {
            name = "endac";
            desc = "[inferred] Endac. (vendor header `product/hiosd/vo/hi3516a/vou_reg.h` field `endac`; access and reset unknown, modelled RW)";
            sw = rw;
            hw = r;
        } endac[31:31];

        field {
            name = "dacgc";
            desc = "[inferred] Dacgc. (vendor header `product/hiosd/vo/hi3516a/vou_reg.h` field `dacgc`; access and reset unknown, modelled RW)";
            sw = rw;
            hw = r;
        } dacgc[20:15];
    } VO_DAC_C_CTRL @ 0x130;

    reg {
        name = "VO DAC R channel control register";
        desc = "VO_DAC_R_CTRL is a VO DAC R channel control register.

Data sheet 10.2.6 VO_DAC_R_CTRL (offset 0x134, printed page 10-185, `hi3516av100--Hi3516A-Hi3516D-Datasheet.txt` line 69386).";

        enum VO_DAC_R_CTRL_endac_enum {
            DISABLED = 0 { name = "Disabled"; desc = "disabled"; };
            ENABLED = 1 { name = "Enabled"; desc = "enabled"; };
        };

        field {
            name = "endac";
            desc = "DAC enable.";
            sw = rw;
            hw = r;
            encode = VO_DAC_R_CTRL_endac_enum;
            reset = 0x0;
        } endac[31:31];

        field {
            name = "dacgc";
            desc = "DAC gain.";
            sw = rw;
            hw = r;
            reset = 0x0;
        } dacgc[20:15];
    } VO_DAC_R_CTRL @ 0x134;

    reg {
        name = "VO DAC G control";
        desc = "[inferred] VO DAC G control. Not in the data sheet. Source: vendor U-Boot 2010.06 `product/hiosd/vo/hi3516a/vou_reg.h` (GPL-2.0 U-Boot tree, HiSilicon copyright, created 2013-04-27; mirror github.com/OpenIPC/u-boot-hi3516cv200), union `U_VO_DAC_G_CTRL`, struct offset 0x138 (GPL-2.0, same-chip vendor header). Reset value and access type unknown (modelled RW, no reset). Confidence: medium (vendor header for this chip family, not hardware verified).";

        field {
            name = "endac";
            desc = "[inferred] Endac. (vendor header `product/hiosd/vo/hi3516a/vou_reg.h` field `endac`; access and reset unknown, modelled RW)";
            sw = rw;
            hw = r;
        } endac[31:31];

        field {
            name = "dacgc";
            desc = "[inferred] Dacgc. (vendor header `product/hiosd/vo/hi3516a/vou_reg.h` field `dacgc`; access and reset unknown, modelled RW)";
            sw = rw;
            hw = r;
        } dacgc[20:15];
    } VO_DAC_G_CTRL @ 0x138;

    reg {
        name = "VO DAC B control";
        desc = "[inferred] VO DAC B control. Not in the data sheet. Source: vendor U-Boot 2010.06 `product/hiosd/vo/hi3516a/vou_reg.h` (GPL-2.0 U-Boot tree, HiSilicon copyright, created 2013-04-27; mirror github.com/OpenIPC/u-boot-hi3516cv200), union `U_VO_DAC_B_CTRL`, struct offset 0x13C (GPL-2.0, same-chip vendor header). Reset value and access type unknown (modelled RW, no reset). Confidence: medium (vendor header for this chip family, not hardware verified).";

        field {
            name = "endac";
            desc = "[inferred] Endac. (vendor header `product/hiosd/vo/hi3516a/vou_reg.h` field `endac`; access and reset unknown, modelled RW)";
            sw = rw;
            hw = r;
        } endac[31:31];

        field {
            name = "dacgc";
            desc = "[inferred] Dacgc. (vendor header `product/hiosd/vo/hi3516a/vou_reg.h` field `dacgc`; access and reset unknown, modelled RW)";
            sw = rw;
            hw = r;
        } dacgc[20:15];
    } VO_DAC_B_CTRL @ 0x13C;

    reg {
        name = "VO DAC status 0 register";
        desc = "VO_DAC_STAT0 is a VO DAC status 0 register.

Data sheet 10.2.6 VO_DAC_STAT0 (offset 0x140, printed page 10-186, `hi3516av100--Hi3516A-Hi3516D-Datasheet.txt` line 69420).";

        field {
            name = "cableout3";
            desc = "[inferred] Cableout3. (bits reserved in the data sheet; vendor header `product/hiosd/vo/hi3516a/vou_reg.h` field `cableout3`; access and reset unknown, modelled RW)";
            sw = rw;
            hw = r;
        } cableout3[19:19];

        field {
            name = "cableout2";
            desc = "[inferred] Cableout2. (bits reserved in the data sheet; vendor header `product/hiosd/vo/hi3516a/vou_reg.h` field `cableout2`; access and reset unknown, modelled RW)";
            sw = rw;
            hw = r;
        } cableout2[18:18];

        field {
            name = "cableout1";
            desc = "[inferred] Cableout1. (bits reserved in the data sheet; vendor header `product/hiosd/vo/hi3516a/vou_reg.h` field `cableout1`; access and reset unknown, modelled RW)";
            sw = rw;
            hw = r;
        } cableout1[17:17];

        field {
            name = "cableout0";
            desc = "Cableout3 feedback signal.";
            sw = r;
            hw = w;
            reset = 0x0;
        } cableout0[16:16];
    } VO_DAC_STAT0 @ 0x140;

    reg {
        name = "Virtual coefficient register";
        desc = "COEF_DATA is a virtual coefficient register. All VDP coefficients are read from this register. The coefficients are distinguished from each other by using the PARARD read enable register.

Data sheet 10.2.6 COEF_DATA (offset 0x400, printed page 10-186, `hi3516av100--Hi3516A-Hi3516D-Datasheet.txt` line 69450).";

        field {
            name = "coef_data";
            desc = "Coefficient.";
            sw = r;
            hw = w;
            reset = 0x0;
        } coef_data[31:0];
    } COEF_DATA @ 0x400;

    reg {
        name = "V0 control";
        desc = "[inferred] V0 control. Not in the data sheet. Source: vendor U-Boot 2010.06 `product/hiosd/vo/hi3516a/vou_reg.h` (GPL-2.0 U-Boot tree, HiSilicon copyright, created 2013-04-27; mirror github.com/OpenIPC/u-boot-hi3516cv200), union `U_V0_CTRL`, struct offset 0x800 (GPL-2.0, same-chip vendor header). Reset value and access type unknown (modelled RW, no reset). Confidence: medium (vendor header for this chip family, not hardware verified).";

        field {
            name = "surface_en";
            desc = "[inferred] Surface enable. (vendor header `product/hiosd/vo/hi3516a/vou_reg.h` field `surface_en`; access and reset unknown, modelled RW)";
            sw = rw;
            hw = r;
        } surface_en[31:31];

        field {
            name = "mute_en";
            desc = "[inferred] Mute enable. (vendor header `product/hiosd/vo/hi3516a/vou_reg.h` field `mute_en`; access and reset unknown, modelled RW)";
            sw = rw;
            hw = r;
        } mute_en[27:27];

        field {
            name = "crop_en";
            desc = "[inferred] Crop enable. (vendor header `product/hiosd/vo/hi3516a/vou_reg.h` field `crop_en`; access and reset unknown, modelled RW)";
            sw = rw;
            hw = r;
        } crop_en[23:23];

        field {
            name = "precharge_en";
            desc = "[inferred] Precharge enable. (vendor header `product/hiosd/vo/hi3516a/vou_reg.h` field `precharge_en`; access and reset unknown, modelled RW)";
            sw = rw;
            hw = r;
        } precharge_en[21:21];

        field {
            name = "precharge_mode";
            desc = "[inferred] Precharge mode. (vendor header `product/hiosd/vo/hi3516a/vou_reg.h` field `precharge_mode`; access and reset unknown, modelled RW)";
            sw = rw;
            hw = r;
        } precharge_mode[20:20];

        field {
            name = "ifir_mode";
            desc = "[inferred] Input FIR filter mode. (vendor header `product/hiosd/vo/hi3516a/vou_reg.h` field `ifir_mode`; access and reset unknown, modelled RW)";
            sw = rw;
            hw = r;
        } ifir_mode[19:18];

        field {
            name = "vup_mode";
            desc = "[inferred] Vup mode. (vendor header `product/hiosd/vo/hi3516a/vou_reg.h` field `vup_mode`; access and reset unknown, modelled RW)";
            sw = rw;
            hw = r;
        } vup_mode[17:17];

        field {
            name = "lm_rmode";
            desc = "[inferred] Lm rmode. (vendor header `product/hiosd/vo/hi3516a/vou_reg.h` field `lm_rmode`; access and reset unknown, modelled RW)";
            sw = rw;
            hw = r;
        } lm_rmode[15:14];

        field {
            name = "chm_rmode";
            desc = "[inferred] Chm rmode. (vendor header `product/hiosd/vo/hi3516a/vou_reg.h` field `chm_rmode`; access and reset unknown, modelled RW)";
            sw = rw;
            hw = r;
        } chm_rmode[13:12];

        field {
            name = "dcmp_en";
            desc = "[inferred] Decompression enable. (vendor header `product/hiosd/vo/hi3516a/vou_reg.h` field `dcmp_en`; access and reset unknown, modelled RW)";
            sw = rw;
            hw = r;
        } dcmp_en[8:8];

        field {
            name = "time_out";
            desc = "[inferred] Time out. (vendor header `product/hiosd/vo/hi3516a/vou_reg.h` field `time_out`; access and reset unknown, modelled RW)";
            sw = rw;
            hw = r;
        } time_out[7:5];

        field {
            name = "ifmt";
            desc = "[inferred] Input format. (vendor header `product/hiosd/vo/hi3516a/vou_reg.h` field `ifmt`; access and reset unknown, modelled RW)";
            sw = rw;
            hw = r;
        } ifmt[3:0];
    } V0_CTRL @ 0x800;

    reg {
        name = "V0 update";
        desc = "[inferred] V0 update. Not in the data sheet. Source: vendor U-Boot 2010.06 `product/hiosd/vo/hi3516a/vou_reg.h` (GPL-2.0 U-Boot tree, HiSilicon copyright, created 2013-04-27; mirror github.com/OpenIPC/u-boot-hi3516cv200), union `U_V0_UPD`, struct offset 0x804 (GPL-2.0, same-chip vendor header). Reset value and access type unknown (modelled RW, no reset). Confidence: medium (vendor header for this chip family, not hardware verified).";

        field {
            name = "regup";
            desc = "[inferred] Regup. (vendor header `product/hiosd/vo/hi3516a/vou_reg.h` field `regup`; access and reset unknown, modelled RW)";
            sw = rw;
            hw = r;
        } regup[0:0];
    } V0_UPD @ 0x804;

    reg {
        name = "V0 IRESO";
        desc = "[inferred] V0 IRESO. Not in the data sheet. Source: vendor U-Boot 2010.06 `product/hiosd/vo/hi3516a/vou_reg.h` (GPL-2.0 U-Boot tree, HiSilicon copyright, created 2013-04-27; mirror github.com/OpenIPC/u-boot-hi3516cv200), union `U_V0_IRESO`, struct offset 0x828 (GPL-2.0, same-chip vendor header). Reset value and access type unknown (modelled RW, no reset). Confidence: medium (vendor header for this chip family, not hardware verified).";

        field {
            name = "ih";
            desc = "[inferred] Ih. (vendor header `product/hiosd/vo/hi3516a/vou_reg.h` field `ih`; access and reset unknown, modelled RW)";
            sw = rw;
            hw = r;
        } ih[23:12];

        field {
            name = "iw";
            desc = "[inferred] Iw. (vendor header `product/hiosd/vo/hi3516a/vou_reg.h` field `iw`; access and reset unknown, modelled RW)";
            sw = rw;
            hw = r;
        } iw[11:0];
    } V0_IRESO @ 0x828;

    reg {
        name = "V0 ORESO";
        desc = "[inferred] V0 ORESO. Not in the data sheet. Source: vendor U-Boot 2010.06 `product/hiosd/vo/hi3516a/vou_reg.h` (GPL-2.0 U-Boot tree, HiSilicon copyright, created 2013-04-27; mirror github.com/OpenIPC/u-boot-hi3516cv200), union `U_V0_ORESO`, struct offset 0x82C (GPL-2.0, same-chip vendor header). Reset value and access type unknown (modelled RW, no reset). Confidence: medium (vendor header for this chip family, not hardware verified).";

        field {
            name = "oh";
            desc = "[inferred] Oh. (vendor header `product/hiosd/vo/hi3516a/vou_reg.h` field `oh`; access and reset unknown, modelled RW)";
            sw = rw;
            hw = r;
        } oh[23:12];

        field {
            name = "ow";
            desc = "[inferred] Ow. (vendor header `product/hiosd/vo/hi3516a/vou_reg.h` field `ow`; access and reset unknown, modelled RW)";
            sw = rw;
            hw = r;
        } ow[11:0];
    } V0_ORESO @ 0x82C;

    reg {
        name = "V0 CBMPARA";
        desc = "[inferred] V0 CBMPARA. Not in the data sheet. Source: vendor U-Boot 2010.06 `product/hiosd/vo/hi3516a/vou_reg.h` (GPL-2.0 U-Boot tree, HiSilicon copyright, created 2013-04-27; mirror github.com/OpenIPC/u-boot-hi3516cv200), union `U_V0_CBMPARA`, struct offset 0x838 (GPL-2.0, same-chip vendor header). Reset value and access type unknown (modelled RW, no reset). Confidence: medium (vendor header for this chip family, not hardware verified).";

        field {
            name = "galpha";
            desc = "[inferred] Galpha. (vendor header `product/hiosd/vo/hi3516a/vou_reg.h` field `galpha`; access and reset unknown, modelled RW)";
            sw = rw;
            hw = r;
        } galpha[7:0];
    } V0_CBMPARA @ 0x838;

    reg {
        name = "V0 CPOS";
        desc = "[inferred] V0 CPOS. Not in the data sheet. Source: vendor U-Boot 2010.06 `product/hiosd/vo/hi3516a/vou_reg.h` (GPL-2.0 U-Boot tree, HiSilicon copyright, created 2013-04-27; mirror github.com/OpenIPC/u-boot-hi3516cv200), union `U_V0_CPOS`, struct offset 0x844 (GPL-2.0, same-chip vendor header). Reset value and access type unknown (modelled RW, no reset). Confidence: medium (vendor header for this chip family, not hardware verified).";

        field {
            name = "src_xlpos";
            desc = "[inferred] Source xlpos. (vendor header `product/hiosd/vo/hi3516a/vou_reg.h` field `src_xlpos`; access and reset unknown, modelled RW)";
            sw = rw;
            hw = r;
        } src_xlpos[23:12];

        field {
            name = "src_xfpos";
            desc = "[inferred] Source xfpos. (vendor header `product/hiosd/vo/hi3516a/vou_reg.h` field `src_xfpos`; access and reset unknown, modelled RW)";
            sw = rw;
            hw = r;
        } src_xfpos[11:0];
    } V0_CPOS @ 0x844;

    reg {
        name = "V0 DFPOS";
        desc = "[inferred] V0 DFPOS. Not in the data sheet. Source: vendor U-Boot 2010.06 `product/hiosd/vo/hi3516a/vou_reg.h` (GPL-2.0 U-Boot tree, HiSilicon copyright, created 2013-04-27; mirror github.com/OpenIPC/u-boot-hi3516cv200), union `U_V0_DFPOS`, struct offset 0x860 (GPL-2.0, same-chip vendor header). Reset value and access type unknown (modelled RW, no reset). Confidence: medium (vendor header for this chip family, not hardware verified).";

        field {
            name = "disp_yfpos";
            desc = "[inferred] Disp yfpos. (vendor header `product/hiosd/vo/hi3516a/vou_reg.h` field `disp_yfpos`; access and reset unknown, modelled RW)";
            sw = rw;
            hw = r;
        } disp_yfpos[23:12];

        field {
            name = "disp_xfpos";
            desc = "[inferred] Disp xfpos. (vendor header `product/hiosd/vo/hi3516a/vou_reg.h` field `disp_xfpos`; access and reset unknown, modelled RW)";
            sw = rw;
            hw = r;
        } disp_xfpos[11:0];
    } V0_DFPOS @ 0x860;

    reg {
        name = "V0 DLPOS";
        desc = "[inferred] V0 DLPOS. Not in the data sheet. Source: vendor U-Boot 2010.06 `product/hiosd/vo/hi3516a/vou_reg.h` (GPL-2.0 U-Boot tree, HiSilicon copyright, created 2013-04-27; mirror github.com/OpenIPC/u-boot-hi3516cv200), union `U_V0_DLPOS`, struct offset 0x864 (GPL-2.0, same-chip vendor header). Reset value and access type unknown (modelled RW, no reset). Confidence: medium (vendor header for this chip family, not hardware verified).";

        field {
            name = "disp_ylpos";
            desc = "[inferred] Disp ylpos. (vendor header `product/hiosd/vo/hi3516a/vou_reg.h` field `disp_ylpos`; access and reset unknown, modelled RW)";
            sw = rw;
            hw = r;
        } disp_ylpos[23:12];

        field {
            name = "disp_xlpos";
            desc = "[inferred] Disp xlpos. (vendor header `product/hiosd/vo/hi3516a/vou_reg.h` field `disp_xlpos`; access and reset unknown, modelled RW)";
            sw = rw;
            hw = r;
        } disp_xlpos[11:0];
    } V0_DLPOS @ 0x864;

    reg {
        name = "V0 VFPOS";
        desc = "[inferred] V0 VFPOS. Not in the data sheet. Source: vendor U-Boot 2010.06 `product/hiosd/vo/hi3516a/vou_reg.h` (GPL-2.0 U-Boot tree, HiSilicon copyright, created 2013-04-27; mirror github.com/OpenIPC/u-boot-hi3516cv200), union `U_V0_VFPOS`, struct offset 0x868 (GPL-2.0, same-chip vendor header). Reset value and access type unknown (modelled RW, no reset). Confidence: medium (vendor header for this chip family, not hardware verified).";

        field {
            name = "video_yfpos";
            desc = "[inferred] Video yfpos. (vendor header `product/hiosd/vo/hi3516a/vou_reg.h` field `video_yfpos`; access and reset unknown, modelled RW)";
            sw = rw;
            hw = r;
        } video_yfpos[23:12];

        field {
            name = "video_xfpos";
            desc = "[inferred] Video xfpos. (vendor header `product/hiosd/vo/hi3516a/vou_reg.h` field `video_xfpos`; access and reset unknown, modelled RW)";
            sw = rw;
            hw = r;
        } video_xfpos[11:0];
    } V0_VFPOS @ 0x868;

    reg {
        name = "V0 VLPOS";
        desc = "[inferred] V0 VLPOS. Not in the data sheet. Source: vendor U-Boot 2010.06 `product/hiosd/vo/hi3516a/vou_reg.h` (GPL-2.0 U-Boot tree, HiSilicon copyright, created 2013-04-27; mirror github.com/OpenIPC/u-boot-hi3516cv200), union `U_V0_VLPOS`, struct offset 0x86C (GPL-2.0, same-chip vendor header). Reset value and access type unknown (modelled RW, no reset). Confidence: medium (vendor header for this chip family, not hardware verified).";

        field {
            name = "video_ylpos";
            desc = "[inferred] Video ylpos. (vendor header `product/hiosd/vo/hi3516a/vou_reg.h` field `video_ylpos`; access and reset unknown, modelled RW)";
            sw = rw;
            hw = r;
        } video_ylpos[23:12];

        field {
            name = "video_xlpos";
            desc = "[inferred] Video xlpos. (vendor header `product/hiosd/vo/hi3516a/vou_reg.h` field `video_xlpos`; access and reset unknown, modelled RW)";
            sw = rw;
            hw = r;
        } video_xlpos[11:0];
    } V0_VLPOS @ 0x86C;

    reg {
        name = "V0 background";
        desc = "[inferred] V0 background. Not in the data sheet. Source: vendor U-Boot 2010.06 `product/hiosd/vo/hi3516a/vou_reg.h` (GPL-2.0 U-Boot tree, HiSilicon copyright, created 2013-04-27; mirror github.com/OpenIPC/u-boot-hi3516cv200), union `U_V0_BK`, struct offset 0x870 (GPL-2.0, same-chip vendor header). Reset value and access type unknown (modelled RW, no reset). Confidence: medium (vendor header for this chip family, not hardware verified).";

        field {
            name = "vbk_y";
            desc = "[inferred] Vbk y. (vendor header `product/hiosd/vo/hi3516a/vou_reg.h` field `vbk_y`; access and reset unknown, modelled RW)";
            sw = rw;
            hw = r;
        } vbk_y[29:20];

        field {
            name = "vbk_cb";
            desc = "[inferred] Vbk cb. (vendor header `product/hiosd/vo/hi3516a/vou_reg.h` field `vbk_cb`; access and reset unknown, modelled RW)";
            sw = rw;
            hw = r;
        } vbk_cb[19:10];

        field {
            name = "vbk_cr";
            desc = "[inferred] Vbk cr. (vendor header `product/hiosd/vo/hi3516a/vou_reg.h` field `vbk_cr`; access and reset unknown, modelled RW)";
            sw = rw;
            hw = r;
        } vbk_cr[9:0];
    } V0_BK @ 0x870;

    reg {
        name = "V0 alpha";
        desc = "[inferred] V0 alpha. Not in the data sheet. Source: vendor U-Boot 2010.06 `product/hiosd/vo/hi3516a/vou_reg.h` (GPL-2.0 U-Boot tree, HiSilicon copyright, created 2013-04-27; mirror github.com/OpenIPC/u-boot-hi3516cv200), union `U_V0_ALPHA`, struct offset 0x874 (GPL-2.0, same-chip vendor header). Reset value and access type unknown (modelled RW, no reset). Confidence: medium (vendor header for this chip family, not hardware verified).";

        field {
            name = "vbk_alpha";
            desc = "[inferred] Vbk alpha. (vendor header `product/hiosd/vo/hi3516a/vou_reg.h` field `vbk_alpha`; access and reset unknown, modelled RW)";
            sw = rw;
            hw = r;
        } vbk_alpha[7:0];
    } V0_ALPHA @ 0x874;

    reg {
        name = "V0 colour-space conversion IDC";
        desc = "[inferred] V0 colour-space conversion IDC. Not in the data sheet. Source: vendor U-Boot 2010.06 `product/hiosd/vo/hi3516a/vou_reg.h` (GPL-2.0 U-Boot tree, HiSilicon copyright, created 2013-04-27; mirror github.com/OpenIPC/u-boot-hi3516cv200), union `U_V0_CSC_IDC`, struct offset 0x880 (GPL-2.0, same-chip vendor header). Reset value and access type unknown (modelled RW, no reset). Confidence: medium (vendor header for this chip family, not hardware verified).";

        field {
            name = "csc_en";
            desc = "[inferred] Colour-space conversion enable. (vendor header `product/hiosd/vo/hi3516a/vou_reg.h` field `csc_en`; access and reset unknown, modelled RW)";
            sw = rw;
            hw = r;
        } csc_en[22:22];

        field {
            name = "cscidc1";
            desc = "[inferred] Cscidc1. (vendor header `product/hiosd/vo/hi3516a/vou_reg.h` field `cscidc1`; access and reset unknown, modelled RW)";
            sw = rw;
            hw = r;
        } cscidc1[21:11];

        field {
            name = "cscidc0";
            desc = "[inferred] Cscidc0. (vendor header `product/hiosd/vo/hi3516a/vou_reg.h` field `cscidc0`; access and reset unknown, modelled RW)";
            sw = rw;
            hw = r;
        } cscidc0[10:0];
    } V0_CSC_IDC @ 0x880;

    reg {
        name = "V0 colour-space conversion ODC";
        desc = "[inferred] V0 colour-space conversion ODC. Not in the data sheet. Source: vendor U-Boot 2010.06 `product/hiosd/vo/hi3516a/vou_reg.h` (GPL-2.0 U-Boot tree, HiSilicon copyright, created 2013-04-27; mirror github.com/OpenIPC/u-boot-hi3516cv200), union `U_V0_CSC_ODC`, struct offset 0x884 (GPL-2.0, same-chip vendor header). Reset value and access type unknown (modelled RW, no reset). Confidence: medium (vendor header for this chip family, not hardware verified).";

        field {
            name = "csc_sign_mode";
            desc = "[inferred] Colour-space conversion sign mode. (vendor header `product/hiosd/vo/hi3516a/vou_reg.h` field `csc_sign_mode`; access and reset unknown, modelled RW)";
            sw = rw;
            hw = r;
        } csc_sign_mode[22:22];

        field {
            name = "cscodc1";
            desc = "[inferred] Cscodc1. (vendor header `product/hiosd/vo/hi3516a/vou_reg.h` field `cscodc1`; access and reset unknown, modelled RW)";
            sw = rw;
            hw = r;
        } cscodc1[21:11];

        field {
            name = "cscodc0";
            desc = "[inferred] Cscodc0. (vendor header `product/hiosd/vo/hi3516a/vou_reg.h` field `cscodc0`; access and reset unknown, modelled RW)";
            sw = rw;
            hw = r;
        } cscodc0[10:0];
    } V0_CSC_ODC @ 0x884;

    reg {
        name = "V0 colour-space conversion IODC";
        desc = "[inferred] V0 colour-space conversion IODC. Not in the data sheet. Source: vendor U-Boot 2010.06 `product/hiosd/vo/hi3516a/vou_reg.h` (GPL-2.0 U-Boot tree, HiSilicon copyright, created 2013-04-27; mirror github.com/OpenIPC/u-boot-hi3516cv200), union `U_V0_CSC_IODC`, struct offset 0x888 (GPL-2.0, same-chip vendor header). Reset value and access type unknown (modelled RW, no reset). Confidence: medium (vendor header for this chip family, not hardware verified).";

        field {
            name = "cscodc2";
            desc = "[inferred] Cscodc2. (vendor header `product/hiosd/vo/hi3516a/vou_reg.h` field `cscodc2`; access and reset unknown, modelled RW)";
            sw = rw;
            hw = r;
        } cscodc2[21:11];

        field {
            name = "cscidc2";
            desc = "[inferred] Cscidc2. (vendor header `product/hiosd/vo/hi3516a/vou_reg.h` field `cscidc2`; access and reset unknown, modelled RW)";
            sw = rw;
            hw = r;
        } cscidc2[10:0];
    } V0_CSC_IODC @ 0x888;

    reg {
        name = "V0 colour-space conversion P0";
        desc = "[inferred] V0 colour-space conversion P0. Not in the data sheet. Source: vendor U-Boot 2010.06 `product/hiosd/vo/hi3516a/vou_reg.h` (GPL-2.0 U-Boot tree, HiSilicon copyright, created 2013-04-27; mirror github.com/OpenIPC/u-boot-hi3516cv200), union `U_V0_CSC_P0`, struct offset 0x88C (GPL-2.0, same-chip vendor header). Reset value and access type unknown (modelled RW, no reset). Confidence: medium (vendor header for this chip family, not hardware verified).";

        field {
            name = "cscp01";
            desc = "[inferred] Cscp01. (vendor header `product/hiosd/vo/hi3516a/vou_reg.h` field `cscp01`; access and reset unknown, modelled RW)";
            sw = rw;
            hw = r;
        } cscp01[30:16];

        field {
            name = "cscp00";
            desc = "[inferred] Cscp00. (vendor header `product/hiosd/vo/hi3516a/vou_reg.h` field `cscp00`; access and reset unknown, modelled RW)";
            sw = rw;
            hw = r;
        } cscp00[14:0];
    } V0_CSC_P0 @ 0x88C;

    reg {
        name = "V0 colour-space conversion P1";
        desc = "[inferred] V0 colour-space conversion P1. Not in the data sheet. Source: vendor U-Boot 2010.06 `product/hiosd/vo/hi3516a/vou_reg.h` (GPL-2.0 U-Boot tree, HiSilicon copyright, created 2013-04-27; mirror github.com/OpenIPC/u-boot-hi3516cv200), union `U_V0_CSC_P1`, struct offset 0x890 (GPL-2.0, same-chip vendor header). Reset value and access type unknown (modelled RW, no reset). Confidence: medium (vendor header for this chip family, not hardware verified).";

        field {
            name = "cscp10";
            desc = "[inferred] Cscp10. (vendor header `product/hiosd/vo/hi3516a/vou_reg.h` field `cscp10`; access and reset unknown, modelled RW)";
            sw = rw;
            hw = r;
        } cscp10[30:16];

        field {
            name = "cscp02";
            desc = "[inferred] Cscp02. (vendor header `product/hiosd/vo/hi3516a/vou_reg.h` field `cscp02`; access and reset unknown, modelled RW)";
            sw = rw;
            hw = r;
        } cscp02[14:0];
    } V0_CSC_P1 @ 0x890;

    reg {
        name = "V0 colour-space conversion P2";
        desc = "[inferred] V0 colour-space conversion P2. Not in the data sheet. Source: vendor U-Boot 2010.06 `product/hiosd/vo/hi3516a/vou_reg.h` (GPL-2.0 U-Boot tree, HiSilicon copyright, created 2013-04-27; mirror github.com/OpenIPC/u-boot-hi3516cv200), union `U_V0_CSC_P2`, struct offset 0x894 (GPL-2.0, same-chip vendor header). Reset value and access type unknown (modelled RW, no reset). Confidence: medium (vendor header for this chip family, not hardware verified).";

        field {
            name = "cscp12";
            desc = "[inferred] Cscp12. (vendor header `product/hiosd/vo/hi3516a/vou_reg.h` field `cscp12`; access and reset unknown, modelled RW)";
            sw = rw;
            hw = r;
        } cscp12[30:16];

        field {
            name = "cscp11";
            desc = "[inferred] Cscp11. (vendor header `product/hiosd/vo/hi3516a/vou_reg.h` field `cscp11`; access and reset unknown, modelled RW)";
            sw = rw;
            hw = r;
        } cscp11[14:0];
    } V0_CSC_P2 @ 0x894;

    reg {
        name = "V0 colour-space conversion P3";
        desc = "[inferred] V0 colour-space conversion P3. Not in the data sheet. Source: vendor U-Boot 2010.06 `product/hiosd/vo/hi3516a/vou_reg.h` (GPL-2.0 U-Boot tree, HiSilicon copyright, created 2013-04-27; mirror github.com/OpenIPC/u-boot-hi3516cv200), union `U_V0_CSC_P3`, struct offset 0x898 (GPL-2.0, same-chip vendor header). Reset value and access type unknown (modelled RW, no reset). Confidence: medium (vendor header for this chip family, not hardware verified).";

        field {
            name = "cscp21";
            desc = "[inferred] Cscp21. (vendor header `product/hiosd/vo/hi3516a/vou_reg.h` field `cscp21`; access and reset unknown, modelled RW)";
            sw = rw;
            hw = r;
        } cscp21[30:16];

        field {
            name = "cscp20";
            desc = "[inferred] Cscp20. (vendor header `product/hiosd/vo/hi3516a/vou_reg.h` field `cscp20`; access and reset unknown, modelled RW)";
            sw = rw;
            hw = r;
        } cscp20[14:0];
    } V0_CSC_P3 @ 0x898;

    reg {
        name = "V0 colour-space conversion P4";
        desc = "[inferred] V0 colour-space conversion P4. Not in the data sheet. Source: vendor U-Boot 2010.06 `product/hiosd/vo/hi3516a/vou_reg.h` (GPL-2.0 U-Boot tree, HiSilicon copyright, created 2013-04-27; mirror github.com/OpenIPC/u-boot-hi3516cv200), union `U_V0_CSC_P4`, struct offset 0x89C (GPL-2.0, same-chip vendor header). Reset value and access type unknown (modelled RW, no reset). Confidence: medium (vendor header for this chip family, not hardware verified).";

        field {
            name = "cscp22";
            desc = "[inferred] Cscp22. (vendor header `product/hiosd/vo/hi3516a/vou_reg.h` field `cscp22`; access and reset unknown, modelled RW)";
            sw = rw;
            hw = r;
        } cscp22[14:0];
    } V0_CSC_P4 @ 0x89C;

    reg {
        name = "V0 IFIRCOEF01";
        desc = "[inferred] V0 IFIRCOEF01. Not in the data sheet. Source: vendor U-Boot 2010.06 `product/hiosd/vo/hi3516a/vou_reg.h` (GPL-2.0 U-Boot tree, HiSilicon copyright, created 2013-04-27; mirror github.com/OpenIPC/u-boot-hi3516cv200), union `U_V0_IFIRCOEF01`, struct offset 0x980 (GPL-2.0, same-chip vendor header). Reset value and access type unknown (modelled RW, no reset). Confidence: medium (vendor header for this chip family, not hardware verified).";

        field {
            name = "coef1";
            desc = "[inferred] Coef1. (vendor header `product/hiosd/vo/hi3516a/vou_reg.h` field `coef1`; access and reset unknown, modelled RW)";
            sw = rw;
            hw = r;
        } coef1[25:16];

        field {
            name = "coef0";
            desc = "[inferred] Coef0. (vendor header `product/hiosd/vo/hi3516a/vou_reg.h` field `coef0`; access and reset unknown, modelled RW)";
            sw = rw;
            hw = r;
        } coef0[9:0];
    } V0_IFIRCOEF01 @ 0x980;

    reg {
        name = "V0 IFIRCOEF23";
        desc = "[inferred] V0 IFIRCOEF23. Not in the data sheet. Source: vendor U-Boot 2010.06 `product/hiosd/vo/hi3516a/vou_reg.h` (GPL-2.0 U-Boot tree, HiSilicon copyright, created 2013-04-27; mirror github.com/OpenIPC/u-boot-hi3516cv200), union `U_V0_IFIRCOEF23`, struct offset 0x984 (GPL-2.0, same-chip vendor header). Reset value and access type unknown (modelled RW, no reset). Confidence: medium (vendor header for this chip family, not hardware verified).";

        field {
            name = "coef3";
            desc = "[inferred] Coef3. (vendor header `product/hiosd/vo/hi3516a/vou_reg.h` field `coef3`; access and reset unknown, modelled RW)";
            sw = rw;
            hw = r;
        } coef3[25:16];

        field {
            name = "coef2";
            desc = "[inferred] Coef2. (vendor header `product/hiosd/vo/hi3516a/vou_reg.h` field `coef2`; access and reset unknown, modelled RW)";
            sw = rw;
            hw = r;
        } coef2[9:0];
    } V0_IFIRCOEF23 @ 0x984;

    reg {
        name = "V0 IFIRCOEF45";
        desc = "[inferred] V0 IFIRCOEF45. Not in the data sheet. Source: vendor U-Boot 2010.06 `product/hiosd/vo/hi3516a/vou_reg.h` (GPL-2.0 U-Boot tree, HiSilicon copyright, created 2013-04-27; mirror github.com/OpenIPC/u-boot-hi3516cv200), union `U_V0_IFIRCOEF45`, struct offset 0x988 (GPL-2.0, same-chip vendor header). Reset value and access type unknown (modelled RW, no reset). Confidence: medium (vendor header for this chip family, not hardware verified).";

        field {
            name = "coef5";
            desc = "[inferred] Coef5. (vendor header `product/hiosd/vo/hi3516a/vou_reg.h` field `coef5`; access and reset unknown, modelled RW)";
            sw = rw;
            hw = r;
        } coef5[25:16];

        field {
            name = "coef4";
            desc = "[inferred] Coef4. (vendor header `product/hiosd/vo/hi3516a/vou_reg.h` field `coef4`; access and reset unknown, modelled RW)";
            sw = rw;
            hw = r;
        } coef4[9:0];
    } V0_IFIRCOEF45 @ 0x988;

    reg {
        name = "V0 IFIRCOEF67";
        desc = "[inferred] V0 IFIRCOEF67. Not in the data sheet. Source: vendor U-Boot 2010.06 `product/hiosd/vo/hi3516a/vou_reg.h` (GPL-2.0 U-Boot tree, HiSilicon copyright, created 2013-04-27; mirror github.com/OpenIPC/u-boot-hi3516cv200), union `U_V0_IFIRCOEF67`, struct offset 0x98C (GPL-2.0, same-chip vendor header). Reset value and access type unknown (modelled RW, no reset). Confidence: medium (vendor header for this chip family, not hardware verified).";

        field {
            name = "coef7";
            desc = "[inferred] Coef7. (vendor header `product/hiosd/vo/hi3516a/vou_reg.h` field `coef7`; access and reset unknown, modelled RW)";
            sw = rw;
            hw = r;
        } coef7[25:16];

        field {
            name = "coef6";
            desc = "[inferred] Coef6. (vendor header `product/hiosd/vo/hi3516a/vou_reg.h` field `coef6`; access and reset unknown, modelled RW)";
            sw = rw;
            hw = r;
        } coef6[9:0];
    } V0_IFIRCOEF67 @ 0x98C;

    reg {
        name = "V0 P0LADDR";
        desc = "[inferred] V0 P0LADDR. Not in the data sheet. Source: vendor U-Boot 2010.06 `product/hiosd/vo/hi3516a/vou_reg.h` (GPL-2.0 U-Boot tree, HiSilicon copyright, created 2013-04-27; mirror github.com/OpenIPC/u-boot-hi3516cv200), union `U_V0_P0LADDR`, struct offset 0xA04 (GPL-2.0, same-chip vendor header). Reset value and access type unknown (modelled RW, no reset). Confidence: medium (vendor header for this chip family, not hardware verified).";

        field {
            name = "surface_addr";
            desc = "[inferred] Surface address. (vendor header `product/hiosd/vo/hi3516a/vou_reg.h` field `surface_addr`; access and reset unknown, modelled RW)";
            sw = rw;
            hw = r;
        } surface_addr[31:0];
    } V0_P0LADDR @ 0xA04;

    reg {
        name = "V0 P0CADDR";
        desc = "[inferred] V0 P0CADDR. Not in the data sheet. Source: vendor U-Boot 2010.06 `product/hiosd/vo/hi3516a/vou_reg.h` (GPL-2.0 U-Boot tree, HiSilicon copyright, created 2013-04-27; mirror github.com/OpenIPC/u-boot-hi3516cv200), union `U_V0_P0CADDR`, struct offset 0xA08 (GPL-2.0, same-chip vendor header). Reset value and access type unknown (modelled RW, no reset). Confidence: medium (vendor header for this chip family, not hardware verified).";

        field {
            name = "surface_addr";
            desc = "[inferred] Surface address. (vendor header `product/hiosd/vo/hi3516a/vou_reg.h` field `surface_addr`; access and reset unknown, modelled RW)";
            sw = rw;
            hw = r;
        } surface_addr[31:0];
    } V0_P0CADDR @ 0xA08;

    reg {
        name = "V0 P0STRIDE";
        desc = "[inferred] V0 P0STRIDE. Not in the data sheet. Source: vendor U-Boot 2010.06 `product/hiosd/vo/hi3516a/vou_reg.h` (GPL-2.0 U-Boot tree, HiSilicon copyright, created 2013-04-27; mirror github.com/OpenIPC/u-boot-hi3516cv200), union `U_V0_P0STRIDE`, struct offset 0xA0C (GPL-2.0, same-chip vendor header). Reset value and access type unknown (modelled RW, no reset). Confidence: medium (vendor header for this chip family, not hardware verified).";

        field {
            name = "surface_cstride";
            desc = "[inferred] Surface cstride. (vendor header `product/hiosd/vo/hi3516a/vou_reg.h` field `surface_cstride`; access and reset unknown, modelled RW)";
            sw = rw;
            hw = r;
        } surface_cstride[31:16];

        field {
            name = "surface_stride";
            desc = "[inferred] Surface stride. (vendor header `product/hiosd/vo/hi3516a/vou_reg.h` field `surface_stride`; access and reset unknown, modelled RW)";
            sw = rw;
            hw = r;
        } surface_stride[15:0];
    } V0_P0STRIDE @ 0xA0C;

    reg {
        name = "V0 LADDROFFSET";
        desc = "[inferred] V0 LADDROFFSET. Not in the data sheet. Source: vendor U-Boot 2010.06 `product/hiosd/vo/hi3516a/vou_reg.h` (GPL-2.0 U-Boot tree, HiSilicon copyright, created 2013-04-27; mirror github.com/OpenIPC/u-boot-hi3516cv200), union `U_V0_LADDROFFSET`, struct offset 0xE40 (GPL-2.0, same-chip vendor header). Reset value and access type unknown (modelled RW, no reset). Confidence: medium (vendor header for this chip family, not hardware verified).";

        field {
            name = "laddr_offset";
            desc = "[inferred] Laddr offset. (vendor header `product/hiosd/vo/hi3516a/vou_reg.h` field `laddr_offset`; access and reset unknown, modelled RW)";
            sw = rw;
            hw = r;
        } laddr_offset[31:0];
    } V0_LADDROFFSET @ 0xE40;

    reg {
        name = "V0 CADDROFFSET";
        desc = "[inferred] V0 CADDROFFSET. Not in the data sheet. Source: vendor U-Boot 2010.06 `product/hiosd/vo/hi3516a/vou_reg.h` (GPL-2.0 U-Boot tree, HiSilicon copyright, created 2013-04-27; mirror github.com/OpenIPC/u-boot-hi3516cv200), union `U_V0_CADDROFFSET`, struct offset 0xE44 (GPL-2.0, same-chip vendor header). Reset value and access type unknown (modelled RW, no reset). Confidence: medium (vendor header for this chip family, not hardware verified).";

        field {
            name = "caddr_offset";
            desc = "[inferred] Caddr offset. (vendor header `product/hiosd/vo/hi3516a/vou_reg.h` field `caddr_offset`; access and reset unknown, modelled RW)";
            sw = rw;
            hw = r;
        } caddr_offset[31:0];
    } V0_CADDROFFSET @ 0xE44;

    reg {
        name = "V0 decompression LSTATE0";
        desc = "[inferred] V0 decompression LSTATE0. Not in the data sheet. Source: vendor U-Boot 2010.06 `product/hiosd/vo/hi3516a/vou_reg.h` (GPL-2.0 U-Boot tree, HiSilicon copyright, created 2013-04-27; mirror github.com/OpenIPC/u-boot-hi3516cv200), union `U_V0_DCMP_LSTATE0`, struct offset 0xF20 (GPL-2.0, same-chip vendor header). Reset value and access type unknown (modelled RW, no reset). Confidence: medium (vendor header for this chip family, not hardware verified).";

        field {
            name = "dcmp_l_state0";
            desc = "[inferred] Decompression l state0. (vendor header `product/hiosd/vo/hi3516a/vou_reg.h` field `dcmp_l_state0`; access and reset unknown, modelled RW)";
            sw = rw;
            hw = r;
        } dcmp_l_state0[31:0];
    } V0_DCMP_LSTATE0 @ 0xF20;

    reg {
        name = "V0 decompression LSTATE1";
        desc = "[inferred] V0 decompression LSTATE1. Not in the data sheet. Source: vendor U-Boot 2010.06 `product/hiosd/vo/hi3516a/vou_reg.h` (GPL-2.0 U-Boot tree, HiSilicon copyright, created 2013-04-27; mirror github.com/OpenIPC/u-boot-hi3516cv200), union `U_V0_DCMP_LSTATE1`, struct offset 0xF24 (GPL-2.0, same-chip vendor header). Reset value and access type unknown (modelled RW, no reset). Confidence: medium (vendor header for this chip family, not hardware verified).";

        field {
            name = "dcmp_l_state1";
            desc = "[inferred] Decompression l state1. (vendor header `product/hiosd/vo/hi3516a/vou_reg.h` field `dcmp_l_state1`; access and reset unknown, modelled RW)";
            sw = rw;
            hw = r;
        } dcmp_l_state1[31:0];
    } V0_DCMP_LSTATE1 @ 0xF24;

    reg {
        name = "V0 decompression CSTATE0";
        desc = "[inferred] V0 decompression CSTATE0. Not in the data sheet. Source: vendor U-Boot 2010.06 `product/hiosd/vo/hi3516a/vou_reg.h` (GPL-2.0 U-Boot tree, HiSilicon copyright, created 2013-04-27; mirror github.com/OpenIPC/u-boot-hi3516cv200), union `U_V0_DCMP_CSTATE0`, struct offset 0xF28 (GPL-2.0, same-chip vendor header). Reset value and access type unknown (modelled RW, no reset). Confidence: medium (vendor header for this chip family, not hardware verified).";

        field {
            name = "dcmp_c_state0";
            desc = "[inferred] Decompression c state0. (vendor header `product/hiosd/vo/hi3516a/vou_reg.h` field `dcmp_c_state0`; access and reset unknown, modelled RW)";
            sw = rw;
            hw = r;
        } dcmp_c_state0[31:0];
    } V0_DCMP_CSTATE0 @ 0xF28;

    reg {
        name = "V0 decompression CSTATE1";
        desc = "[inferred] V0 decompression CSTATE1. Not in the data sheet. Source: vendor U-Boot 2010.06 `product/hiosd/vo/hi3516a/vou_reg.h` (GPL-2.0 U-Boot tree, HiSilicon copyright, created 2013-04-27; mirror github.com/OpenIPC/u-boot-hi3516cv200), union `U_V0_DCMP_CSTATE1`, struct offset 0xF2C (GPL-2.0, same-chip vendor header). Reset value and access type unknown (modelled RW, no reset). Confidence: medium (vendor header for this chip family, not hardware verified).";

        field {
            name = "dcmp_c_state1";
            desc = "[inferred] Decompression c state1. (vendor header `product/hiosd/vo/hi3516a/vou_reg.h` field `dcmp_c_state1`; access and reset unknown, modelled RW)";
            sw = rw;
            hw = r;
        } dcmp_c_state1[31:0];
    } V0_DCMP_CSTATE1 @ 0xF2C;

    reg {
        name = "VO DCMPERRCLR";
        desc = "[inferred] VO DCMPERRCLR. Not in the data sheet. Source: vendor U-Boot 2010.06 `product/hiosd/vo/hi3516a/vou_reg.h` (GPL-2.0 U-Boot tree, HiSilicon copyright, created 2013-04-27; mirror github.com/OpenIPC/u-boot-hi3516cv200), union `U_VO_DCMPERRCLR`, struct offset 0xF30 (GPL-2.0, same-chip vendor header). Reset value and access type unknown (modelled RW, no reset). Confidence: medium (vendor header for this chip family, not hardware verified).";

        field {
            name = "dcmp_c_errclr";
            desc = "[inferred] Decompression c errclr. (vendor header `product/hiosd/vo/hi3516a/vou_reg.h` field `dcmp_c_errclr`; access and reset unknown, modelled RW)";
            sw = rw;
            hw = r;
        } dcmp_c_errclr[1:1];

        field {
            name = "dcmp_l_errclr";
            desc = "[inferred] Decompression l errclr. (vendor header `product/hiosd/vo/hi3516a/vou_reg.h` field `dcmp_l_errclr`; access and reset unknown, modelled RW)";
            sw = rw;
            hw = r;
        } dcmp_l_errclr[0:0];
    } VO_DCMPERRCLR @ 0xF30;

    reg {
        name = "V0 decompression error";
        desc = "[inferred] V0 decompression error. Not in the data sheet. Source: vendor U-Boot 2010.06 `product/hiosd/vo/hi3516a/vou_reg.h` (GPL-2.0 U-Boot tree, HiSilicon copyright, created 2013-04-27; mirror github.com/OpenIPC/u-boot-hi3516cv200), union `U_V0_DCMP_ERR`, struct offset 0xF34 (GPL-2.0, same-chip vendor header). Reset value and access type unknown (modelled RW, no reset). Confidence: medium (vendor header for this chip family, not hardware verified).";

        field {
            name = "dcmp_c_wrong";
            desc = "[inferred] Decompression c wrong. (vendor header `product/hiosd/vo/hi3516a/vou_reg.h` field `dcmp_c_wrong`; access and reset unknown, modelled RW)";
            sw = rw;
            hw = r;
        } dcmp_c_wrong[1:1];

        field {
            name = "dcmp_l_wrong";
            desc = "[inferred] Decompression l wrong. (vendor header `product/hiosd/vo/hi3516a/vou_reg.h` field `dcmp_l_wrong`; access and reset unknown, modelled RW)";
            sw = rw;
            hw = r;
        } dcmp_l_wrong[0:0];
    } V0_DCMP_ERR @ 0xF34;

    reg {
        name = "V1 configuration register (non-instant register)";
        desc = "V1_CTRL is a V1 configuration register (non-instant register).

Data sheet 10.2.6 V1_CTRL (offset 0x1000, printed page 10-187, `hi3516av100--Hi3516A-Hi3516D-Datasheet.txt` line 69474).";

        enum V1_CTRL_surface_en_enum {
            DISABLED = 0 { name = "Disabled"; desc = "disabled"; };
            ENABLED = 1 { name = "Enabled"; desc = "enabled"; };
        };

        field {
            name = "surface_en";
            desc = "Surface enable (non-instant).";
            sw = rw;
            hw = r;
            encode = V1_CTRL_surface_en_enum;
            reset = 0x0;
        } surface_en[31:31];

        enum V1_CTRL_crop_en_enum {
            DISABLED = 0 { name = "Disabled"; desc = "disabled"; };
            ENABLED = 1 { name = "Enabled"; desc = "enabled"; };
        };

        field {
            name = "crop_en";
            desc = "Crop enable (non-instant).";
            sw = rw;
            hw = r;
            encode = V1_CTRL_crop_en_enum;
            reset = 0x0;
        } crop_en[23:23];

        enum V1_CTRL_precharge_en_enum {
            DISABLED = 0 { name = "Disabled"; desc = "disabled"; };
            ENABLED = 1 { name = "Enabled"; desc = "enabled"; };
        };

        field {
            name = "precharge_en";
            desc = "Pre-charge enable. This field is valid when the precharge_mode field is 1 (software mode).";
            sw = rw;
            hw = r;
            encode = V1_CTRL_precharge_en_enum;
            reset = 0x0;
        } precharge_en[21:21];

        enum V1_CTRL_precharge_mode_enum {
            HARDWARE_MODE_HARDWARE = 0 { name = "Hardware Mode Hardware"; desc = "hardware mode. Hardware automatically enters the pre-charge status on the frame trailer."; };
            SOFTWARE_MODE_SOFTWARE = 1 { name = "Software Mode Software"; desc = "software mode. Software controls whether to enter or exit the pre-charge status."; };
        };

        field {
            name = "precharge_mode";
            desc = "Pre-charge mode of the FDR FIFO.";
            sw = rw;
            hw = r;
            encode = V1_CTRL_precharge_mode_enum;
            reset = 0x0;
        } precharge_mode[20:20];

        enum V1_CTRL_ifir_mode_enum {
            RESERVED = 0 { name = "Reserved"; desc = "reserved"; };
            CHROMINANCE_IFIR_REPLICATION = 1 { name = "Chrominance Ifir Replication"; desc = "chrominance IFIR replication mode"; };
            BILINEAR_INTERPOLATION = 2 { name = "Bilinear Interpolation"; desc = "bilinear interpolation"; };
            V_16_ORDER_HALF = 3 { name = "V 16 Order Half"; desc = "16-order half-band filtering"; };
        };

        field {
            name = "ifir_mode";
            desc = "Horizontal chrominance IFIR mode.";
            sw = rw;
            hw = r;
            encode = V1_CTRL_ifir_mode_enum;
            reset = 0x0;
        } ifir_mode[19:18];

        enum V1_CTRL_vup_mode_enum {
            UPDATE_FRAME = 0 { name = "Update Frame"; desc = "update by frame"; };
            UPDATE_FIELD = 1 { name = "Update Field"; desc = "update by field"; };
        };

        field {
            name = "vup_mode";
            desc = "Surface coefficient update mode.";
            sw = rw;
            hw = r;
            encode = V1_CTRL_vup_mode_enum;
            reset = 0x0;
        } vup_mode[17:17];

        enum V1_CTRL_lm_rmode_enum {
            READ_MODE_BOUND = 0 { name = "Read Mode Bound"; desc = "The read mode is bound to the interface."; };
            FRAME_BUFFER_DATA = 1 { name = "Frame Buffer Data"; desc = "The frame buffer data is read in progressive mode."; };
            TOP_FIELD_READ = 2 { name = "Top Field Read"; desc = "The top field is read in interlaced mode."; };
            BOTTOM_FIELD_READ = 3 { name = "Bottom Field Read"; desc = "The bottom field is read in interlaced mode."; };
        };

        field {
            name = "lm_rmode";
            desc = "Luminance read mode.";
            sw = rw;
            hw = r;
            encode = V1_CTRL_lm_rmode_enum;
            reset = 0x0;
        } lm_rmode[15:14];

        enum V1_CTRL_chm_rmode_enum {
            READ_MODE_BOUND = 0 { name = "Read Mode Bound"; desc = "The read mode is bound to the interface."; };
            FRAME_BUFFER_DATA = 1 { name = "Frame Buffer Data"; desc = "The frame buffer data is read in progressive mode."; };
            TOP_FIELD_READ = 2 { name = "Top Field Read"; desc = "The top field is read in interlaced mode."; };
            BOTTOM_FIELD_READ = 3 { name = "Bottom Field Read"; desc = "The bottom field is read in interlaced mode."; };
        };

        field {
            name = "chm_rmode";
            desc = "Chrominance read mode.";
            sw = rw;
            hw = r;
            encode = V1_CTRL_chm_rmode_enum;
            reset = 0x0;
        } chm_rmode[13:12];

        field {
            name = "dcmp_en";
            desc = "Decompression enable.";
            sw = rw;
            hw = r;
            reset = 0x0;
        } dcmp_en[8:8];

        field {
            name = "time_out";
            desc = "Timeout period.";
            sw = rw;
            hw = r;
            reset = 0x0;
        } time_out[7:5];

        enum V1_CTRL_ifmt_enum {
            SPYCBCR400 = 1 { name = "Spycbcr400"; desc = "SPYCbCr400"; };
            SPYCBCR420 = 3 { name = "Spycbcr420"; desc = "SPYCbCr420"; };
            SPYCBCR422_OTHER_VALUES = 4 { name = "Spycbcr422 Other Values"; desc = "SPYCbCr422 Other values: reserved"; };
        };

        field {
            name = "ifmt";
            desc = "Format of the input data.";
            sw = rw;
            hw = r;
            encode = V1_CTRL_ifmt_enum;
            reset = 0x0;
        } ifmt[3:0];
    } V1_CTRL @ 0x1000;

    reg {
        name = "V1 channel update enable register";
        desc = "V1_UPD is a V1 channel update enable register.

Data sheet 10.2.6 V1_UPD (offset 0x1004, printed page 10-188, `hi3516av100--Hi3516A-Hi3516D-Datasheet.txt` line 69558).";

        field {
            name = "regup";
            desc = "Surface register update. After the registers at this layer are configured, the registers are updated when the value 1 is written to this bit. After the registers are updated, this bit is automatically cleared by the hardware.";
            sw = rw;
            hw = w;
            onwrite = woclr;
            reset = 0x0;
        } regup[0:0];
    } V1_UPD @ 0x1004;

    reg {
        name = "V1 input resolution register (non-instant register)";
        desc = "V1_IRESO is a V1 input resolution register (non-instant register).

Data sheet 10.2.6 V1_IRESO (offset 0x1028, printed page 10-189, `hi3516av100--Hi3516A-Hi3516D-Datasheet.txt` line 69593).";

        field {
            name = "ih";
            desc = "Height (in line). The configured value is the actual height minus 1. The frame height is referenced and its unit is line.";
            sw = rw;
            hw = r;
            reset = 0x0;
        } ih[23:12];

        field {
            name = "iw";
            desc = "Width (in pixel). The configured value is the actual width minus 1.";
            sw = rw;
            hw = r;
            reset = 0x0;
        } iw[11:0];
    } V1_IRESO @ 0x1028;

    reg {
        name = "V1 output resolution register (non-instant register)";
        desc = "V1_ORESO is a V1 output resolution register (non-instant register).

Data sheet 10.2.6 V1_ORESO (offset 0x102C, printed page 10-189, `hi3516av100--Hi3516A-Hi3516D-Datasheet.txt` line 69615).";

        field {
            name = "oh";
            desc = "Height (in line). The configured value is the actual height minus 1. The frame height is referenced and its unit is line.";
            sw = rw;
            hw = r;
            reset = 0x0;
        } oh[23:12];

        field {
            name = "ow";
            desc = "Width (in pixel). The configured value is the actual width minus 1.";
            sw = rw;
            hw = r;
            reset = 0x0;
        } ow[11:0];
    } V1_ORESO @ 0x102C;

    reg {
        name = "V1 overlay parameter register (non-instant register)";
        desc = "V1_CBMPARA is a V1 overlay parameter register (non-instant register).

Data sheet 10.2.6 V1_CBMPARA (offset 0x1038, printed page 10-190, `hi3516av100--Hi3516A-Hi3516D-Datasheet.txt` line 69643).";

        field {
            name = "galpha";
            desc = "Overlay global alpha value. The value ranges from 0 to 255. The value 255 indicates opaque, and the value 0 indicates completely transparent.";
            sw = rw;
            hw = r;
            reset = 0x0;
        } galpha[7:0];
    } V1_CBMPARA @ 0x1038;

    reg {
        name = "Horizontal crop coordinate register for the source picture";
        desc = "V1_CPOS is a horizontal crop coordinate register for the source picture.

Data sheet 10.2.6 V1_CPOS (offset 0x1044, printed page 10-190, `hi3516av100--Hi3516A-Hi3516D-Datasheet.txt` line 69664).";

        field {
            name = "src_xlpos";
            desc = "End coordinates for horizontally cropping the source picture.";
            sw = rw;
            hw = r;
            reset = 0x0;
        } src_xlpos[23:12];

        field {
            name = "src_xfpos";
            desc = "Start coordinates for horizontally cropping the source picture.";
            sw = rw;
            hw = r;
            reset = 0x0;
        } src_xfpos[11:0];
    } V1_CPOS @ 0x1044;

    reg {
        name = "V1 surface start position (in the display window) register (non-instant register)";
        desc = "V1_DFPOS is a V1 surface start position (in the display window) register (non-instant register). Huawei Proprietary and Confidential Hi3516A/Hi3516D Professional HD IP Camera SoC

Data sheet 10.2.6 V1_DFPOS (offset 0x1060, printed page 10-191, `hi3516av100--Hi3516A-Hi3516D-Datasheet.txt` line 69695).";

        field {
            name = "disp_yfpos";
            desc = "Start coordinates of the display column. The frame height is referenced and its unit is line.";
            sw = rw;
            hw = r;
            reset = 0x0;
        } disp_yfpos[23:12];

        field {
            name = "disp_xfpos";
            desc = "Start coordinates of the display row.";
            sw = rw;
            hw = r;
            reset = 0x0;
        } disp_xfpos[11:0];
    } V1_DFPOS @ 0x1060;

    reg {
        name = "V1 surface end position (in the display window) register (non-instant register)";
        desc = "V1_DLPOS is a V1 surface end position (in the display window) register (non-instant register).

Data sheet 10.2.6 V1_DLPOS (offset 0x1064, printed page 10-191, `hi3516av100--Hi3516A-Hi3516D-Datasheet.txt` line 69718).";

        field {
            name = "disp_ylpos";
            desc = "End coordinates of the display column. The frame height is referenced and its unit is line.";
            sw = rw;
            hw = r;
            reset = 0x0;
        } disp_ylpos[23:12];

        field {
            name = "disp_xlpos";
            desc = "End coordinates of the display row.";
            sw = rw;
            hw = r;
            reset = 0x0;
        } disp_xlpos[11:0];
    } V1_DLPOS @ 0x1064;

    reg {
        name = "V1 surface content start position (in the display window) register (non-instant register)";
        desc = "V1_VFPOS is a V1 surface content start position (in the display window) register (non-instant register). Huawei Proprietary and Confidential Hi3516A/Hi3516D Professional HD IP Camera SoC

Data sheet 10.2.6 V1_VFPOS (offset 0x1068, printed page 10-192, `hi3516av100--Hi3516A-Hi3516D-Datasheet.txt` line 69751).";

        field {
            name = "video_yfpos";
            desc = "Start coordinates of the video column. The frame height is referenced and its unit is line.";
            sw = rw;
            hw = r;
            reset = 0x0;
        } video_yfpos[23:12];

        field {
            name = "video_xfpos";
            desc = "Start coordinates of the video row.";
            sw = rw;
            hw = r;
            reset = 0x0;
        } video_xfpos[11:0];
    } V1_VFPOS @ 0x1068;

    reg {
        name = "V1 surface content end position (in the display window) register (non-instant register)";
        desc = "V1_VLPOS is a V1 surface content end position (in the display window) register (non-instant register).

Data sheet 10.2.6 V1_VLPOS (offset 0x106C, printed page 10-192, `hi3516av100--Hi3516A-Hi3516D-Datasheet.txt` line 69774).";

        field {
            name = "video_ylpos";
            desc = "End coordinates of the video column. The frame height is referenced and its unit is line.";
            sw = rw;
            hw = r;
            reset = 0x0;
        } video_ylpos[23:12];

        field {
            name = "video_xlpos";
            desc = "End coordinates of the video row.";
            sw = rw;
            hw = r;
            reset = 0x0;
        } video_xlpos[11:0];
    } V1_VLPOS @ 0x106C;

    reg {
        name = "V1 background color register";
        desc = "V1_BK is a V1 background color register. Huawei Proprietary and Confidential Hi3516A/Hi3516D Professional HD IP Camera SoC

Data sheet 10.2.6 V1_BK (offset 0x1070, printed page 10-193, `hi3516av100--Hi3516A-Hi3516D-Datasheet.txt` line 69806).";

        field {
            name = "vbk_y";
            desc = "Y component.";
            sw = rw;
            hw = r;
            reset = 0x0;
        } vbk_y[29:20];

        field {
            name = "vbk_cb";
            desc = "Cb component.";
            sw = rw;
            hw = r;
            reset = 0x0;
        } vbk_cb[19:10];

        field {
            name = "vbk_cr";
            desc = "Cr component.";
            sw = rw;
            hw = r;
            reset = 0x0;
        } vbk_cr[9:0];
    } V1_BK @ 0x1070;

    reg {
        name = "V1 background filling color alpha register";
        desc = "V1_ALPHA is a V1 background filling color alpha register.

Data sheet 10.2.6 V1_ALPHA (offset 0x1074, printed page 10-193, `hi3516av100--Hi3516A-Hi3516D-Datasheet.txt` line 69829).";

        field {
            name = "vbk_alpha";
            desc = "Level 0-255 of the background filling color of the video layer.";
            sw = rw;
            hw = r;
            reset = 0x0;
        } vbk_alpha[7:0];
    } V1_ALPHA @ 0x1074;

    reg {
        name = "V1 CSC input DC component register (instant register)";
        desc = "V1_CSC_IDC is a V1 CSC input DC component register (instant register). Huawei Proprietary and Confidential Hi3516A/Hi3516D Professional HD IP Camera SoC

Data sheet 10.2.6 V1_CSC_IDC (offset 0x1080, printed page 10-194, `hi3516av100--Hi3516A-Hi3516D-Datasheet.txt` line 69858).";

        enum V1_CSC_IDC_csc_en_enum {
            DISABLED = 0 { name = "Disabled"; desc = "disabled"; };
            ENABLED = 1 { name = "Enabled"; desc = "enabled"; };
        };

        field {
            name = "csc_en";
            desc = "CSC enable.";
            sw = rw;
            hw = r;
            encode = V1_CSC_IDC_csc_en_enum;
            reset = 0x0;
        } csc_en[22:22];

        field {
            name = "cscidc1";
            desc = "DC parameter of the input U/G component. The MSB is the signed bit. The value is expressed as a two's complement.";
            sw = rw;
            hw = r;
            reset = 0x0;
        } cscidc1[21:11];

        field {
            name = "cscidc0";
            desc = "DC parameter of the input V/B component. The MSB is the signed bit. The value is expressed as a two's complement.";
            sw = rw;
            hw = r;
            reset = 0x0;
        } cscidc0[10:0];
    } V1_CSC_IDC @ 0x1080;

    reg {
        name = "V1 CSC output DC component register (instant register)";
        desc = "V1_CSC_ODC is a V1 CSC output DC component register (instant register).

Data sheet 10.2.6 V1_CSC_ODC (offset 0x1084, printed page 10-194, `hi3516av100--Hi3516A-Hi3516D-Datasheet.txt` line 69887).";

        enum V1_CSC_ODC_csc_sign_mode_enum {
            CSC_OUTPUT_10 = 0 { name = "Csc Output 10"; desc = "The CSC output is a 10-bit unsigned number."; };
            CSC_OUTPUT_12 = 1 { name = "Csc Output 12"; desc = "The CSC output is a 12-bit signed number."; };
        };

        field {
            name = "csc_sign_mode";
            desc = "CSC output mode.";
            sw = rw;
            hw = r;
            encode = V1_CSC_ODC_csc_sign_mode_enum;
            reset = 0x0;
        } csc_sign_mode[22:22];

        field {
            name = "cscodc1";
            desc = "DC parameter of the output U/G component. The MSB is the signed bit. The value is expressed as a two's complement.";
            sw = rw;
            hw = r;
            reset = 0x0;
        } cscodc1[21:11];

        field {
            name = "cscodc0";
            desc = "DC parameter of the output Y/R component. The MSB is the signed bit. The value is expressed as a two's complement.";
            sw = rw;
            hw = r;
            reset = 0x0;
        } cscodc0[10:0];
    } V1_CSC_ODC @ 0x1084;

    reg {
        name = "V1 CSC input/output DC component register (instant register)";
        desc = "V1_CSC_IODC is a V1 CSC input/output DC component register (instant register).

Data sheet 10.2.6 V1_CSC_IODC (offset 0x1088, printed page 10-195, `hi3516av100--Hi3516A-Hi3516D-Datasheet.txt` line 69932).";

        field {
            name = "cscodc2";
            desc = "DC parameter of the output V/B component. The MSB is the signed bit. The value is expressed as a two's complement.";
            sw = rw;
            hw = r;
            reset = 0x0;
        } cscodc2[21:11];

        field {
            name = "cscidc2";
            desc = "DC parameter of the input Y/R component. The MSB is the signed bit. The value is expressed as a two's complement.";
            sw = rw;
            hw = r;
            reset = 0x0;
        } cscidc2[10:0];
    } V1_CSC_IODC @ 0x1088;

    reg {
        name = "V1 CSC parameter 0 register (instant register)";
        desc = "V1_CSC_P0 is a V1 CSC parameter 0 register (instant register).

Data sheet 10.2.6 V1_CSC_P0 (offset 0x108C, printed page 10-195, `hi3516av100--Hi3516A-Hi3516D-Datasheet.txt` line 69956).";

        field {
            name = "cscp01";
            desc = "5.10 data format that consists of a 1-bit sign part, a 4-bit integer part, and an 8-bit decimal part. The value is expressed as a two's complement.";
            sw = rw;
            hw = r;
            reset = 0x0;
        } cscp01[30:16];

        field {
            name = "cscp00";
            desc = "5.10 data format that consists of a 1-bit sign part, a 4-bit integer part, and an 8-bit decimal part. The value is expressed as a two's complement.";
            sw = rw;
            hw = r;
            reset = 0x0;
        } cscp00[14:0];
    } V1_CSC_P0 @ 0x108C;

    reg {
        name = "V1 CSC parameter 1 register (instant register)";
        desc = "V1_CSC_P1 is a V1 CSC parameter 1 register (instant register).

Data sheet 10.2.6 V1_CSC_P1 (offset 0x1090, printed page 10-196, `hi3516av100--Hi3516A-Hi3516D-Datasheet.txt` line 69996).";

        field {
            name = "cscp10";
            desc = "5.10 data format that consists of a 1-bit sign part, a 4-bit integer part, and an 8-bit decimal part. The value is expressed as a two's complement.";
            sw = rw;
            hw = r;
            reset = 0x0;
        } cscp10[30:16];

        field {
            name = "cscp02";
            desc = "5.10 data format that consists of a 1-bit sign part, a 4-bit integer part, and an 8-bit decimal part. The value is expressed as a two's complement.";
            sw = rw;
            hw = r;
            reset = 0x0;
        } cscp02[14:0];
    } V1_CSC_P1 @ 0x1090;

    reg {
        name = "V1 CSC parameter 2 register (instant register)";
        desc = "V1_CSC_P2 is a V1 CSC parameter 2 register (instant register).

Data sheet 10.2.6 V1_CSC_P2 (offset 0x1094, printed page 10-196, `hi3516av100--Hi3516A-Hi3516D-Datasheet.txt` line 70024).";

        field {
            name = "cscp12";
            desc = "5.10 data format that consists of a 1-bit sign part, a 4-bit integer part, and an 8-bit decimal part. The value is expressed as a two's complement.";
            sw = rw;
            hw = r;
            reset = 0x0;
        } cscp12[30:16];

        field {
            name = "cscp11";
            desc = "5.10 data format that consists of a 1-bit sign part, a 4-bit integer part, and an 8-bit decimal part. The value is expressed as a two's complement.";
            sw = rw;
            hw = r;
            reset = 0x0;
        } cscp11[14:0];
    } V1_CSC_P2 @ 0x1094;

    reg {
        name = "V1 CSC parameter 3 register (instant register)";
        desc = "V1_CSC_P3 is a V1 CSC parameter 3 register (instant register).

Data sheet 10.2.6 V1_CSC_P3 (offset 0x1098, printed page 10-197, `hi3516av100--Hi3516A-Hi3516D-Datasheet.txt` line 70063).";

        field {
            name = "cscp21";
            desc = "5.10 data format that consists of a 1-bit sign part, a 4-bit integer part, and an 8-bit decimal part. The value is expressed as a two's complement.";
            sw = rw;
            hw = r;
            reset = 0x0;
        } cscp21[30:16];

        field {
            name = "cscp20";
            desc = "5.10 data format that consists of a 1-bit sign part, a 4-bit integer part, and an 8-bit decimal part. The value is expressed as a two's complement.";
            sw = rw;
            hw = r;
            reset = 0x0;
        } cscp20[14:0];
    } V1_CSC_P3 @ 0x1098;

    reg {
        name = "V1 CSC parameter 4 register (instant register)";
        desc = "V1_CSC_P4 is a V1 CSC parameter 4 register (instant register). Huawei Proprietary and Confidential Hi3516A/Hi3516D Professional HD IP Camera SoC

Data sheet 10.2.6 V1_CSC_P4 (offset 0x109C, printed page 10-198, `hi3516av100--Hi3516A-Hi3516D-Datasheet.txt` line 70102).";

        field {
            name = "cscp22";
            desc = "5.10 data format that consists of a 1-bit sign part, a 4-bit integer part, and an 8-bit decimal part. The value is expressed as a two's complement.";
            sw = rw;
            hw = r;
            reset = 0x0;
        } cscp22[14:0];
    } V1_CSC_P4 @ 0x109C;

    reg {
        name = "IFIR filtering coefficient 0/1 register";
        desc = "V1_IFIRCOEF01 is an IFIR filtering coefficient 0/1 register.

Data sheet 10.2.6 V1_IFIRCOEF01 (offset 0x1180, printed page 10-198, `hi3516av100--Hi3516A-Hi3516D-Datasheet.txt` line 70123).";

        field {
            name = "coef1";
            desc = "IFIR filtering coefficient 1.";
            sw = rw;
            hw = r;
            reset = 0xF;
        } coef1[25:16];

        field {
            name = "coef0";
            desc = "IFIR filtering coefficient 0.";
            sw = rw;
            hw = r;
            reset = 0x3F5;
        } coef0[9:0];
    } V1_IFIRCOEF01 @ 0x1180;

    reg {
        name = "IFIR filtering coefficient 2/3 register";
        desc = "V1_IFIRCOEF23 is an IFIR filtering coefficient 2/3 register. Huawei Proprietary and Confidential Hi3516A/Hi3516D Professional HD IP Camera SoC

Data sheet 10.2.6 V1_IFIRCOEF23 (offset 0x1184, printed page 10-199, `hi3516av100--Hi3516A-Hi3516D-Datasheet.txt` line 70154).";

        field {
            name = "coef3";
            desc = "IFIR filtering coefficient 3.";
            sw = rw;
            hw = r;
            reset = 0x1C;
        } coef3[25:16];

        field {
            name = "coef2";
            desc = "IFIR filtering coefficient 2.";
            sw = rw;
            hw = r;
            reset = 0x3EC;
        } coef2[9:0];
    } V1_IFIRCOEF23 @ 0x1184;

    reg {
        name = "IFIR filtering coefficient 4/5 register";
        desc = "V1_IFIRCOEF45 is an IFIR filtering coefficient 4/5 register.

Data sheet 10.2.6 V1_IFIRCOEF45 (offset 0x1188, printed page 10-199, `hi3516av100--Hi3516A-Hi3516D-Datasheet.txt` line 70175).";

        field {
            name = "coef5";
            desc = "IFIR filtering coefficient 5.";
            sw = rw;
            hw = r;
            reset = 0x3D;
        } coef5[25:16];

        field {
            name = "coef4";
            desc = "IFIR filtering coefficient 4.";
            sw = rw;
            hw = r;
            reset = 0x3D8;
        } coef4[9:0];
    } V1_IFIRCOEF45 @ 0x1188;

    reg {
        name = "IFIR filtering coefficient 6/7 register";
        desc = "V1_IFIRCOEF67 is an IFIR filtering coefficient 6/7 register. Huawei Proprietary and Confidential Hi3516A/Hi3516D Professional HD IP Camera SoC

Data sheet 10.2.6 V1_IFIRCOEF67 (offset 0x118C, printed page 10-200, `hi3516av100--Hi3516A-Hi3516D-Datasheet.txt` line 70206).";

        field {
            name = "coef7";
            desc = "IFIR filtering coefficient 7.";
            sw = rw;
            hw = r;
            reset = 0x14A;
        } coef7[25:16];

        field {
            name = "coef6";
            desc = "IFIR filtering coefficient 6.";
            sw = rw;
            hw = r;
            reset = 0x395;
        } coef6[9:0];
    } V1_IFIRCOEF67 @ 0x118C;

    reg {
        name = "V1 luminance address register";
        desc = "V1_P0LADDR is a V1 luminance address register.

Data sheet 10.2.6 V1_P0LADDR (offset 0x1204, printed page 10-200, `hi3516av100--Hi3516A-Hi3516D-Datasheet.txt` line 70227).";

        field {
            name = "surface_addr";
            desc = "Luminance start address for the video layer.";
            sw = rw;
            hw = r;
            reset = 0x0;
        } surface_addr[31:0];
    } V1_P0LADDR @ 0x1204;

    reg {
        name = "V1 chrominance address register";
        desc = "V1_P0CADDR is a V1 chrominance address register.

Data sheet 10.2.6 V1_P0CADDR (offset 0x1208, printed page 10-200, `hi3516av100--Hi3516A-Hi3516D-Datasheet.txt` line 70245).";

        field {
            name = "surface_addr";
            desc = "Chrominance start address for the video layer.";
            sw = rw;
            hw = r;
            reset = 0x0;
        } surface_addr[31:0];
    } V1_P0CADDR @ 0x1208;

    reg {
        name = "V1 stride register";
        desc = "V1_P0STRIDE is a V1 stride register.

Data sheet 10.2.6 V1_P0STRIDE (offset 0x120C, printed page 10-201, `hi3516av100--Hi3516A-Hi3516D-Datasheet.txt` line 70269).";

        field {
            name = "surface_cstride";
            desc = "Stride of the chrominance buffer of the video layer (valid in semi- planar format), 128-bit alignment.";
            sw = rw;
            hw = r;
            reset = 0x0;
        } surface_cstride[31:16];

        field {
            name = "surface_stride";
            desc = "Stride of the video layer buffer (luminance stride in semi-planar format), 128-bit alignment.";
            sw = rw;
            hw = r;
            reset = 0x0;
        } surface_stride[15:0];
    } V1_P0STRIDE @ 0x120C;

    reg {
        name = "G0 control";
        desc = "[inferred] G0 control. Not in the data sheet. Source: vendor U-Boot 2010.06 `product/hiosd/vo/hi3516a/vou_reg.h` (GPL-2.0 U-Boot tree, HiSilicon copyright, created 2013-04-27; mirror github.com/OpenIPC/u-boot-hi3516cv200), union `U_G0_CTRL`, struct offset 0x6000 (GPL-2.0, same-chip vendor header). Reset value and access type unknown (modelled RW, no reset). Confidence: medium (vendor header for this chip family, not hardware verified).";

        field {
            name = "surface_en";
            desc = "[inferred] Surface enable. (vendor header `product/hiosd/vo/hi3516a/vou_reg.h` field `surface_en`; access and reset unknown, modelled RW)";
            sw = rw;
            hw = r;
        } surface_en[31:31];

        field {
            name = "upd_mode";
            desc = "[inferred] Update mode. (vendor header `product/hiosd/vo/hi3516a/vou_reg.h` field `upd_mode`; access and reset unknown, modelled RW)";
            sw = rw;
            hw = r;
        } upd_mode[27:27];

        field {
            name = "read_mode";
            desc = "[inferred] Read mode. (vendor header `product/hiosd/vo/hi3516a/vou_reg.h` field `read_mode`; access and reset unknown, modelled RW)";
            sw = rw;
            hw = r;
        } read_mode[26:26];

        field {
            name = "precharge_en";
            desc = "[inferred] Precharge enable. (vendor header `product/hiosd/vo/hi3516a/vou_reg.h` field `precharge_en`; access and reset unknown, modelled RW)";
            sw = rw;
            hw = r;
        } precharge_en[21:21];

        field {
            name = "precharge_mode";
            desc = "[inferred] Precharge mode. (vendor header `product/hiosd/vo/hi3516a/vou_reg.h` field `precharge_mode`; access and reset unknown, modelled RW)";
            sw = rw;
            hw = r;
        } precharge_mode[20:20];

        field {
            name = "bitext";
            desc = "[inferred] Bitext. (vendor header `product/hiosd/vo/hi3516a/vou_reg.h` field `bitext`; access and reset unknown, modelled RW)";
            sw = rw;
            hw = r;
        } bitext[9:8];

        field {
            name = "ifmt";
            desc = "[inferred] Input format. (vendor header `product/hiosd/vo/hi3516a/vou_reg.h` field `ifmt`; access and reset unknown, modelled RW)";
            sw = rw;
            hw = r;
        } ifmt[7:0];
    } G0_CTRL @ 0x6000;

    reg {
        name = "G0 update";
        desc = "[inferred] G0 update. Not in the data sheet. Source: vendor U-Boot 2010.06 `product/hiosd/vo/hi3516a/vou_reg.h` (GPL-2.0 U-Boot tree, HiSilicon copyright, created 2013-04-27; mirror github.com/OpenIPC/u-boot-hi3516cv200), union `U_G0_UPD`, struct offset 0x6004 (GPL-2.0, same-chip vendor header). Reset value and access type unknown (modelled RW, no reset). Confidence: medium (vendor header for this chip family, not hardware verified).";

        field {
            name = "regup";
            desc = "[inferred] Regup. (vendor header `product/hiosd/vo/hi3516a/vou_reg.h` field `regup`; access and reset unknown, modelled RW)";
            sw = rw;
            hw = r;
        } regup[0:0];
    } G0_UPD @ 0x6004;

    reg {
        name = "G0 address";
        desc = "[inferred] G0 address. Not in the data sheet. Source: vendor U-Boot 2010.06 `product/hiosd/vo/hi3516a/vou_reg.h` (GPL-2.0 U-Boot tree, HiSilicon copyright, created 2013-04-27; mirror github.com/OpenIPC/u-boot-hi3516cv200), union `U_G0_ADDR`, struct offset 0x6010 (GPL-2.0, same-chip vendor header). Reset value and access type unknown (modelled RW, no reset). Confidence: medium (vendor header for this chip family, not hardware verified).";

        field {
            name = "surface_addr";
            desc = "[inferred] Surface address. (vendor header `product/hiosd/vo/hi3516a/vou_reg.h` field `surface_addr`; access and reset unknown, modelled RW)";
            sw = rw;
            hw = r;
        } surface_addr[31:0];
    } G0_ADDR @ 0x6010;

    reg {
        name = "G0 stride";
        desc = "[inferred] G0 stride. Not in the data sheet. Source: vendor U-Boot 2010.06 `product/hiosd/vo/hi3516a/vou_reg.h` (GPL-2.0 U-Boot tree, HiSilicon copyright, created 2013-04-27; mirror github.com/OpenIPC/u-boot-hi3516cv200), union `U_G0_STRIDE`, struct offset 0x601C (GPL-2.0, same-chip vendor header). Reset value and access type unknown (modelled RW, no reset). Confidence: medium (vendor header for this chip family, not hardware verified).";

        field {
            name = "surface_stride";
            desc = "[inferred] Surface stride. (vendor header `product/hiosd/vo/hi3516a/vou_reg.h` field `surface_stride`; access and reset unknown, modelled RW)";
            sw = rw;
            hw = r;
        } surface_stride[15:0];
    } G0_STRIDE @ 0x601C;

    reg {
        name = "G0 IRESO";
        desc = "[inferred] G0 IRESO. Not in the data sheet. Source: vendor U-Boot 2010.06 `product/hiosd/vo/hi3516a/vou_reg.h` (GPL-2.0 U-Boot tree, HiSilicon copyright, created 2013-04-27; mirror github.com/OpenIPC/u-boot-hi3516cv200), union `U_G0_IRESO`, struct offset 0x6020 (GPL-2.0, same-chip vendor header). Reset value and access type unknown (modelled RW, no reset). Confidence: medium (vendor header for this chip family, not hardware verified).";

        field {
            name = "ih";
            desc = "[inferred] Ih. (vendor header `product/hiosd/vo/hi3516a/vou_reg.h` field `ih`; access and reset unknown, modelled RW)";
            sw = rw;
            hw = r;
        } ih[23:12];

        field {
            name = "iw";
            desc = "[inferred] Iw. (vendor header `product/hiosd/vo/hi3516a/vou_reg.h` field `iw`; access and reset unknown, modelled RW)";
            sw = rw;
            hw = r;
        } iw[11:0];
    } G0_IRESO @ 0x6020;

    reg {
        name = "G0 SFPOS";
        desc = "[inferred] G0 SFPOS. Not in the data sheet. Source: vendor U-Boot 2010.06 `product/hiosd/vo/hi3516a/vou_reg.h` (GPL-2.0 U-Boot tree, HiSilicon copyright, created 2013-04-27; mirror github.com/OpenIPC/u-boot-hi3516cv200), union `U_G0_SFPOS`, struct offset 0x6024 (GPL-2.0, same-chip vendor header). Reset value and access type unknown (modelled RW, no reset). Confidence: medium (vendor header for this chip family, not hardware verified).";

        field {
            name = "src_xfpos";
            desc = "[inferred] Source xfpos. (vendor header `product/hiosd/vo/hi3516a/vou_reg.h` field `src_xfpos`; access and reset unknown, modelled RW)";
            sw = rw;
            hw = r;
        } src_xfpos[6:0];
    } G0_SFPOS @ 0x6024;

    reg {
        name = "G0 CBMPARA";
        desc = "[inferred] G0 CBMPARA. Not in the data sheet. Source: vendor U-Boot 2010.06 `product/hiosd/vo/hi3516a/vou_reg.h` (GPL-2.0 U-Boot tree, HiSilicon copyright, created 2013-04-27; mirror github.com/OpenIPC/u-boot-hi3516cv200), union `U_G0_CBMPARA`, struct offset 0x6030 (GPL-2.0, same-chip vendor header). Reset value and access type unknown (modelled RW, no reset). Confidence: medium (vendor header for this chip family, not hardware verified).";

        field {
            name = "key_mode";
            desc = "[inferred] Key mode. (vendor header `product/hiosd/vo/hi3516a/vou_reg.h` field `key_mode`; access and reset unknown, modelled RW)";
            sw = rw;
            hw = r;
        } key_mode[15:15];

        field {
            name = "key_en";
            desc = "[inferred] Key enable. (vendor header `product/hiosd/vo/hi3516a/vou_reg.h` field `key_en`; access and reset unknown, modelled RW)";
            sw = rw;
            hw = r;
        } key_en[14:14];

        field {
            name = "premult_en";
            desc = "[inferred] Premult enable. (vendor header `product/hiosd/vo/hi3516a/vou_reg.h` field `premult_en`; access and reset unknown, modelled RW)";
            sw = rw;
            hw = r;
        } premult_en[13:13];

        field {
            name = "palpha_en";
            desc = "[inferred] Palpha enable. (vendor header `product/hiosd/vo/hi3516a/vou_reg.h` field `palpha_en`; access and reset unknown, modelled RW)";
            sw = rw;
            hw = r;
        } palpha_en[12:12];

        field {
            name = "hedge_p";
            desc = "[inferred] Hedge p. (vendor header `product/hiosd/vo/hi3516a/vou_reg.h` field `hedge_p`; access and reset unknown, modelled RW)";
            sw = rw;
            hw = r;
        } hedge_p[11:11];

        field {
            name = "vedge_p";
            desc = "[inferred] Vedge p. (vendor header `product/hiosd/vo/hi3516a/vou_reg.h` field `vedge_p`; access and reset unknown, modelled RW)";
            sw = rw;
            hw = r;
        } vedge_p[10:10];

        field {
            name = "palpha_range";
            desc = "[inferred] Palpha range. (vendor header `product/hiosd/vo/hi3516a/vou_reg.h` field `palpha_range`; access and reset unknown, modelled RW)";
            sw = rw;
            hw = r;
        } palpha_range[8:8];

        field {
            name = "galpha";
            desc = "[inferred] Galpha. (vendor header `product/hiosd/vo/hi3516a/vou_reg.h` field `galpha`; access and reset unknown, modelled RW)";
            sw = rw;
            hw = r;
        } galpha[7:0];
    } G0_CBMPARA @ 0x6030;

    reg {
        name = "G0 CKEYMAX";
        desc = "[inferred] G0 CKEYMAX. Not in the data sheet. Source: vendor U-Boot 2010.06 `product/hiosd/vo/hi3516a/vou_reg.h` (GPL-2.0 U-Boot tree, HiSilicon copyright, created 2013-04-27; mirror github.com/OpenIPC/u-boot-hi3516cv200), union `U_G0_CKEYMAX`, struct offset 0x6034 (GPL-2.0, same-chip vendor header). Reset value and access type unknown (modelled RW, no reset). Confidence: medium (vendor header for this chip family, not hardware verified).";

        field {
            name = "va0";
            desc = "[inferred] Va0. (vendor header `product/hiosd/vo/hi3516a/vou_reg.h` field `va0`; access and reset unknown, modelled RW)";
            sw = rw;
            hw = r;
        } va0[31:24];

        field {
            name = "keyr_max";
            desc = "[inferred] Keyr max. (vendor header `product/hiosd/vo/hi3516a/vou_reg.h` field `keyr_max`; access and reset unknown, modelled RW)";
            sw = rw;
            hw = r;
        } keyr_max[23:16];

        field {
            name = "keyg_max";
            desc = "[inferred] Keyg max. (vendor header `product/hiosd/vo/hi3516a/vou_reg.h` field `keyg_max`; access and reset unknown, modelled RW)";
            sw = rw;
            hw = r;
        } keyg_max[15:8];

        field {
            name = "keyb_max";
            desc = "[inferred] Keyb max. (vendor header `product/hiosd/vo/hi3516a/vou_reg.h` field `keyb_max`; access and reset unknown, modelled RW)";
            sw = rw;
            hw = r;
        } keyb_max[7:0];
    } G0_CKEYMAX @ 0x6034;

    reg {
        name = "G0 CKEYMIN";
        desc = "[inferred] G0 CKEYMIN. Not in the data sheet. Source: vendor U-Boot 2010.06 `product/hiosd/vo/hi3516a/vou_reg.h` (GPL-2.0 U-Boot tree, HiSilicon copyright, created 2013-04-27; mirror github.com/OpenIPC/u-boot-hi3516cv200), union `U_G0_CKEYMIN`, struct offset 0x6038 (GPL-2.0, same-chip vendor header). Reset value and access type unknown (modelled RW, no reset). Confidence: medium (vendor header for this chip family, not hardware verified).";

        field {
            name = "va1";
            desc = "[inferred] Va1. (vendor header `product/hiosd/vo/hi3516a/vou_reg.h` field `va1`; access and reset unknown, modelled RW)";
            sw = rw;
            hw = r;
        } va1[31:24];

        field {
            name = "keyr_min";
            desc = "[inferred] Keyr min. (vendor header `product/hiosd/vo/hi3516a/vou_reg.h` field `keyr_min`; access and reset unknown, modelled RW)";
            sw = rw;
            hw = r;
        } keyr_min[23:16];

        field {
            name = "keyg_min";
            desc = "[inferred] Keyg min. (vendor header `product/hiosd/vo/hi3516a/vou_reg.h` field `keyg_min`; access and reset unknown, modelled RW)";
            sw = rw;
            hw = r;
        } keyg_min[15:8];

        field {
            name = "keyb_min";
            desc = "[inferred] Keyb min. (vendor header `product/hiosd/vo/hi3516a/vou_reg.h` field `keyb_min`; access and reset unknown, modelled RW)";
            sw = rw;
            hw = r;
        } keyb_min[7:0];
    } G0_CKEYMIN @ 0x6038;

    reg {
        name = "G0 CMASK";
        desc = "[inferred] G0 CMASK. Not in the data sheet. Source: vendor U-Boot 2010.06 `product/hiosd/vo/hi3516a/vou_reg.h` (GPL-2.0 U-Boot tree, HiSilicon copyright, created 2013-04-27; mirror github.com/OpenIPC/u-boot-hi3516cv200), union `U_G0_CMASK`, struct offset 0x603C (GPL-2.0, same-chip vendor header). Reset value and access type unknown (modelled RW, no reset). Confidence: medium (vendor header for this chip family, not hardware verified).";

        field {
            name = "kmsk_r";
            desc = "[inferred] Kmsk r. (vendor header `product/hiosd/vo/hi3516a/vou_reg.h` field `kmsk_r`; access and reset unknown, modelled RW)";
            sw = rw;
            hw = r;
        } kmsk_r[23:16];

        field {
            name = "kmsk_g";
            desc = "[inferred] Kmsk g. (vendor header `product/hiosd/vo/hi3516a/vou_reg.h` field `kmsk_g`; access and reset unknown, modelled RW)";
            sw = rw;
            hw = r;
        } kmsk_g[15:8];

        field {
            name = "kmsk_b";
            desc = "[inferred] Kmsk b. (vendor header `product/hiosd/vo/hi3516a/vou_reg.h` field `kmsk_b`; access and reset unknown, modelled RW)";
            sw = rw;
            hw = r;
        } kmsk_b[7:0];
    } G0_CMASK @ 0x603C;

    reg {
        name = "G0 PARAADDR";
        desc = "[inferred] G0 PARAADDR. Not in the data sheet. Source: vendor U-Boot 2010.06 `product/hiosd/vo/hi3516a/vou_reg.h` (GPL-2.0 U-Boot tree, HiSilicon copyright, created 2013-04-27; mirror github.com/OpenIPC/u-boot-hi3516cv200), union `U_G0_PARAADDR`, struct offset 0x6040 (GPL-2.0, same-chip vendor header). Reset value and access type unknown (modelled RW, no reset). Confidence: medium (vendor header for this chip family, not hardware verified).";

        field {
            name = "surface_addr";
            desc = "[inferred] Surface address. (vendor header `product/hiosd/vo/hi3516a/vou_reg.h` field `surface_addr`; access and reset unknown, modelled RW)";
            sw = rw;
            hw = r;
        } surface_addr[31:0];
    } G0_PARAADDR @ 0x6040;

    reg {
        name = "G0 PARAUP";
        desc = "[inferred] G0 PARAUP. Not in the data sheet. Source: vendor U-Boot 2010.06 `product/hiosd/vo/hi3516a/vou_reg.h` (GPL-2.0 U-Boot tree, HiSilicon copyright, created 2013-04-27; mirror github.com/OpenIPC/u-boot-hi3516cv200), union `U_G0_PARAUP`, struct offset 0x6044 (GPL-2.0, same-chip vendor header). Reset value and access type unknown (modelled RW, no reset). Confidence: medium (vendor header for this chip family, not hardware verified).";

        field {
            name = "gdc_paraup";
            desc = "[inferred] Gdc paraup. (vendor header `product/hiosd/vo/hi3516a/vou_reg.h` field `gdc_paraup`; access and reset unknown, modelled RW)";
            sw = rw;
            hw = r;
        } gdc_paraup[0:0];
    } G0_PARAUP @ 0x6044;

    reg {
        name = "G0 DFPOS";
        desc = "[inferred] G0 DFPOS. Not in the data sheet. Source: vendor U-Boot 2010.06 `product/hiosd/vo/hi3516a/vou_reg.h` (GPL-2.0 U-Boot tree, HiSilicon copyright, created 2013-04-27; mirror github.com/OpenIPC/u-boot-hi3516cv200), union `U_G0_DFPOS`, struct offset 0x6080 (GPL-2.0, same-chip vendor header). Reset value and access type unknown (modelled RW, no reset). Confidence: medium (vendor header for this chip family, not hardware verified).";

        field {
            name = "disp_yfpos";
            desc = "[inferred] Disp yfpos. (vendor header `product/hiosd/vo/hi3516a/vou_reg.h` field `disp_yfpos`; access and reset unknown, modelled RW)";
            sw = rw;
            hw = r;
        } disp_yfpos[23:12];

        field {
            name = "disp_xfpos";
            desc = "[inferred] Disp xfpos. (vendor header `product/hiosd/vo/hi3516a/vou_reg.h` field `disp_xfpos`; access and reset unknown, modelled RW)";
            sw = rw;
            hw = r;
        } disp_xfpos[11:0];
    } G0_DFPOS @ 0x6080;

    reg {
        name = "G0 DLPOS";
        desc = "[inferred] G0 DLPOS. Not in the data sheet. Source: vendor U-Boot 2010.06 `product/hiosd/vo/hi3516a/vou_reg.h` (GPL-2.0 U-Boot tree, HiSilicon copyright, created 2013-04-27; mirror github.com/OpenIPC/u-boot-hi3516cv200), union `U_G0_DLPOS`, struct offset 0x6084 (GPL-2.0, same-chip vendor header). Reset value and access type unknown (modelled RW, no reset). Confidence: medium (vendor header for this chip family, not hardware verified).";

        field {
            name = "disp_ylpos";
            desc = "[inferred] Disp ylpos. (vendor header `product/hiosd/vo/hi3516a/vou_reg.h` field `disp_ylpos`; access and reset unknown, modelled RW)";
            sw = rw;
            hw = r;
        } disp_ylpos[23:12];

        field {
            name = "disp_xlpos";
            desc = "[inferred] Disp xlpos. (vendor header `product/hiosd/vo/hi3516a/vou_reg.h` field `disp_xlpos`; access and reset unknown, modelled RW)";
            sw = rw;
            hw = r;
        } disp_xlpos[11:0];
    } G0_DLPOS @ 0x6084;

    reg {
        name = "G0 VFPOS";
        desc = "[inferred] G0 VFPOS. Not in the data sheet. Source: vendor U-Boot 2010.06 `product/hiosd/vo/hi3516a/vou_reg.h` (GPL-2.0 U-Boot tree, HiSilicon copyright, created 2013-04-27; mirror github.com/OpenIPC/u-boot-hi3516cv200), union `U_G0_VFPOS`, struct offset 0x6088 (GPL-2.0, same-chip vendor header). Reset value and access type unknown (modelled RW, no reset). Confidence: medium (vendor header for this chip family, not hardware verified).";

        field {
            name = "video_yfpos";
            desc = "[inferred] Video yfpos. (vendor header `product/hiosd/vo/hi3516a/vou_reg.h` field `video_yfpos`; access and reset unknown, modelled RW)";
            sw = rw;
            hw = r;
        } video_yfpos[23:12];

        field {
            name = "video_xfpos";
            desc = "[inferred] Video xfpos. (vendor header `product/hiosd/vo/hi3516a/vou_reg.h` field `video_xfpos`; access and reset unknown, modelled RW)";
            sw = rw;
            hw = r;
        } video_xfpos[11:0];
    } G0_VFPOS @ 0x6088;

    reg {
        name = "G0 VLPOS";
        desc = "[inferred] G0 VLPOS. Not in the data sheet. Source: vendor U-Boot 2010.06 `product/hiosd/vo/hi3516a/vou_reg.h` (GPL-2.0 U-Boot tree, HiSilicon copyright, created 2013-04-27; mirror github.com/OpenIPC/u-boot-hi3516cv200), union `U_G0_VLPOS`, struct offset 0x608C (GPL-2.0, same-chip vendor header). Reset value and access type unknown (modelled RW, no reset). Confidence: medium (vendor header for this chip family, not hardware verified).";

        field {
            name = "video_ylpos";
            desc = "[inferred] Video ylpos. (vendor header `product/hiosd/vo/hi3516a/vou_reg.h` field `video_ylpos`; access and reset unknown, modelled RW)";
            sw = rw;
            hw = r;
        } video_ylpos[23:12];

        field {
            name = "video_xlpos";
            desc = "[inferred] Video xlpos. (vendor header `product/hiosd/vo/hi3516a/vou_reg.h` field `video_xlpos`; access and reset unknown, modelled RW)";
            sw = rw;
            hw = r;
        } video_xlpos[11:0];
    } G0_VLPOS @ 0x608C;

    reg {
        name = "G0 background";
        desc = "[inferred] G0 background. Not in the data sheet. Source: vendor U-Boot 2010.06 `product/hiosd/vo/hi3516a/vou_reg.h` (GPL-2.0 U-Boot tree, HiSilicon copyright, created 2013-04-27; mirror github.com/OpenIPC/u-boot-hi3516cv200), union `U_G0_BK`, struct offset 0x6090 (GPL-2.0, same-chip vendor header). Reset value and access type unknown (modelled RW, no reset). Confidence: medium (vendor header for this chip family, not hardware verified).";

        field {
            name = "vbk_y";
            desc = "[inferred] Vbk y. (vendor header `product/hiosd/vo/hi3516a/vou_reg.h` field `vbk_y`; access and reset unknown, modelled RW)";
            sw = rw;
            hw = r;
        } vbk_y[29:20];

        field {
            name = "vbk_cb";
            desc = "[inferred] Vbk cb. (vendor header `product/hiosd/vo/hi3516a/vou_reg.h` field `vbk_cb`; access and reset unknown, modelled RW)";
            sw = rw;
            hw = r;
        } vbk_cb[19:10];

        field {
            name = "vbk_cr";
            desc = "[inferred] Vbk cr. (vendor header `product/hiosd/vo/hi3516a/vou_reg.h` field `vbk_cr`; access and reset unknown, modelled RW)";
            sw = rw;
            hw = r;
        } vbk_cr[9:0];
    } G0_BK @ 0x6090;

    reg {
        name = "G0 alpha";
        desc = "[inferred] G0 alpha. Not in the data sheet. Source: vendor U-Boot 2010.06 `product/hiosd/vo/hi3516a/vou_reg.h` (GPL-2.0 U-Boot tree, HiSilicon copyright, created 2013-04-27; mirror github.com/OpenIPC/u-boot-hi3516cv200), union `U_G0_ALPHA`, struct offset 0x6094 (GPL-2.0, same-chip vendor header). Reset value and access type unknown (modelled RW, no reset). Confidence: medium (vendor header for this chip family, not hardware verified).";

        field {
            name = "vbk_alpha";
            desc = "[inferred] Vbk alpha. (vendor header `product/hiosd/vo/hi3516a/vou_reg.h` field `vbk_alpha`; access and reset unknown, modelled RW)";
            sw = rw;
            hw = r;
        } vbk_alpha[7:0];
    } G0_ALPHA @ 0x6094;

    reg {
        name = "G0 colour-space conversion IDC";
        desc = "[inferred] G0 colour-space conversion IDC. Not in the data sheet. Source: vendor U-Boot 2010.06 `product/hiosd/vo/hi3516a/vou_reg.h` (GPL-2.0 U-Boot tree, HiSilicon copyright, created 2013-04-27; mirror github.com/OpenIPC/u-boot-hi3516cv200), union `U_G0_CSC_IDC`, struct offset 0x60C0 (GPL-2.0, same-chip vendor header). Reset value and access type unknown (modelled RW, no reset). Confidence: medium (vendor header for this chip family, not hardware verified).";

        field {
            name = "csc_mode";
            desc = "[inferred] Colour-space conversion mode. (vendor header `product/hiosd/vo/hi3516a/vou_reg.h` field `csc_mode`; access and reset unknown, modelled RW)";
            sw = rw;
            hw = r;
        } csc_mode[25:23];

        field {
            name = "csc_en";
            desc = "[inferred] Colour-space conversion enable. (vendor header `product/hiosd/vo/hi3516a/vou_reg.h` field `csc_en`; access and reset unknown, modelled RW)";
            sw = rw;
            hw = r;
        } csc_en[22:22];

        field {
            name = "cscidc1";
            desc = "[inferred] Cscidc1. (vendor header `product/hiosd/vo/hi3516a/vou_reg.h` field `cscidc1`; access and reset unknown, modelled RW)";
            sw = rw;
            hw = r;
        } cscidc1[21:11];

        field {
            name = "cscidc0";
            desc = "[inferred] Cscidc0. (vendor header `product/hiosd/vo/hi3516a/vou_reg.h` field `cscidc0`; access and reset unknown, modelled RW)";
            sw = rw;
            hw = r;
        } cscidc0[10:0];
    } G0_CSC_IDC @ 0x60C0;

    reg {
        name = "G0 colour-space conversion ODC";
        desc = "[inferred] G0 colour-space conversion ODC. Not in the data sheet. Source: vendor U-Boot 2010.06 `product/hiosd/vo/hi3516a/vou_reg.h` (GPL-2.0 U-Boot tree, HiSilicon copyright, created 2013-04-27; mirror github.com/OpenIPC/u-boot-hi3516cv200), union `U_G0_CSC_ODC`, struct offset 0x60C4 (GPL-2.0, same-chip vendor header). Reset value and access type unknown (modelled RW, no reset). Confidence: medium (vendor header for this chip family, not hardware verified).";

        field {
            name = "csc_sign_mode";
            desc = "[inferred] Colour-space conversion sign mode. (vendor header `product/hiosd/vo/hi3516a/vou_reg.h` field `csc_sign_mode`; access and reset unknown, modelled RW)";
            sw = rw;
            hw = r;
        } csc_sign_mode[22:22];

        field {
            name = "cscodc1";
            desc = "[inferred] Cscodc1. (vendor header `product/hiosd/vo/hi3516a/vou_reg.h` field `cscodc1`; access and reset unknown, modelled RW)";
            sw = rw;
            hw = r;
        } cscodc1[21:11];

        field {
            name = "cscodc0";
            desc = "[inferred] Cscodc0. (vendor header `product/hiosd/vo/hi3516a/vou_reg.h` field `cscodc0`; access and reset unknown, modelled RW)";
            sw = rw;
            hw = r;
        } cscodc0[10:0];
    } G0_CSC_ODC @ 0x60C4;

    reg {
        name = "G0 colour-space conversion IODC";
        desc = "[inferred] G0 colour-space conversion IODC. Not in the data sheet. Source: vendor U-Boot 2010.06 `product/hiosd/vo/hi3516a/vou_reg.h` (GPL-2.0 U-Boot tree, HiSilicon copyright, created 2013-04-27; mirror github.com/OpenIPC/u-boot-hi3516cv200), union `U_G0_CSC_IODC`, struct offset 0x60C8 (GPL-2.0, same-chip vendor header). Reset value and access type unknown (modelled RW, no reset). Confidence: medium (vendor header for this chip family, not hardware verified).";

        field {
            name = "cscodc2";
            desc = "[inferred] Cscodc2. (vendor header `product/hiosd/vo/hi3516a/vou_reg.h` field `cscodc2`; access and reset unknown, modelled RW)";
            sw = rw;
            hw = r;
        } cscodc2[21:11];

        field {
            name = "cscidc2";
            desc = "[inferred] Cscidc2. (vendor header `product/hiosd/vo/hi3516a/vou_reg.h` field `cscidc2`; access and reset unknown, modelled RW)";
            sw = rw;
            hw = r;
        } cscidc2[10:0];
    } G0_CSC_IODC @ 0x60C8;

    reg {
        name = "G0 colour-space conversion P0";
        desc = "[inferred] G0 colour-space conversion P0. Not in the data sheet. Source: vendor U-Boot 2010.06 `product/hiosd/vo/hi3516a/vou_reg.h` (GPL-2.0 U-Boot tree, HiSilicon copyright, created 2013-04-27; mirror github.com/OpenIPC/u-boot-hi3516cv200), union `U_G0_CSC_P0`, struct offset 0x60CC (GPL-2.0, same-chip vendor header). Reset value and access type unknown (modelled RW, no reset). Confidence: medium (vendor header for this chip family, not hardware verified).";

        field {
            name = "cscp01";
            desc = "[inferred] Cscp01. (vendor header `product/hiosd/vo/hi3516a/vou_reg.h` field `cscp01`; access and reset unknown, modelled RW)";
            sw = rw;
            hw = r;
        } cscp01[30:16];

        field {
            name = "cscp00";
            desc = "[inferred] Cscp00. (vendor header `product/hiosd/vo/hi3516a/vou_reg.h` field `cscp00`; access and reset unknown, modelled RW)";
            sw = rw;
            hw = r;
        } cscp00[14:0];
    } G0_CSC_P0 @ 0x60CC;

    reg {
        name = "G0 colour-space conversion P1";
        desc = "[inferred] G0 colour-space conversion P1. Not in the data sheet. Source: vendor U-Boot 2010.06 `product/hiosd/vo/hi3516a/vou_reg.h` (GPL-2.0 U-Boot tree, HiSilicon copyright, created 2013-04-27; mirror github.com/OpenIPC/u-boot-hi3516cv200), union `U_G0_CSC_P1`, struct offset 0x60D0 (GPL-2.0, same-chip vendor header). Reset value and access type unknown (modelled RW, no reset). Confidence: medium (vendor header for this chip family, not hardware verified).";

        field {
            name = "cscp10";
            desc = "[inferred] Cscp10. (vendor header `product/hiosd/vo/hi3516a/vou_reg.h` field `cscp10`; access and reset unknown, modelled RW)";
            sw = rw;
            hw = r;
        } cscp10[30:16];

        field {
            name = "cscp02";
            desc = "[inferred] Cscp02. (vendor header `product/hiosd/vo/hi3516a/vou_reg.h` field `cscp02`; access and reset unknown, modelled RW)";
            sw = rw;
            hw = r;
        } cscp02[14:0];
    } G0_CSC_P1 @ 0x60D0;

    reg {
        name = "G0 colour-space conversion P2";
        desc = "[inferred] G0 colour-space conversion P2. Not in the data sheet. Source: vendor U-Boot 2010.06 `product/hiosd/vo/hi3516a/vou_reg.h` (GPL-2.0 U-Boot tree, HiSilicon copyright, created 2013-04-27; mirror github.com/OpenIPC/u-boot-hi3516cv200), union `U_G0_CSC_P2`, struct offset 0x60D4 (GPL-2.0, same-chip vendor header). Reset value and access type unknown (modelled RW, no reset). Confidence: medium (vendor header for this chip family, not hardware verified).";

        field {
            name = "cscp12";
            desc = "[inferred] Cscp12. (vendor header `product/hiosd/vo/hi3516a/vou_reg.h` field `cscp12`; access and reset unknown, modelled RW)";
            sw = rw;
            hw = r;
        } cscp12[30:16];

        field {
            name = "cscp11";
            desc = "[inferred] Cscp11. (vendor header `product/hiosd/vo/hi3516a/vou_reg.h` field `cscp11`; access and reset unknown, modelled RW)";
            sw = rw;
            hw = r;
        } cscp11[14:0];
    } G0_CSC_P2 @ 0x60D4;

    reg {
        name = "G0 colour-space conversion P3";
        desc = "[inferred] G0 colour-space conversion P3. Not in the data sheet. Source: vendor U-Boot 2010.06 `product/hiosd/vo/hi3516a/vou_reg.h` (GPL-2.0 U-Boot tree, HiSilicon copyright, created 2013-04-27; mirror github.com/OpenIPC/u-boot-hi3516cv200), union `U_G0_CSC_P3`, struct offset 0x60D8 (GPL-2.0, same-chip vendor header). Reset value and access type unknown (modelled RW, no reset). Confidence: medium (vendor header for this chip family, not hardware verified).";

        field {
            name = "cscp21";
            desc = "[inferred] Cscp21. (vendor header `product/hiosd/vo/hi3516a/vou_reg.h` field `cscp21`; access and reset unknown, modelled RW)";
            sw = rw;
            hw = r;
        } cscp21[30:16];

        field {
            name = "cscp20";
            desc = "[inferred] Cscp20. (vendor header `product/hiosd/vo/hi3516a/vou_reg.h` field `cscp20`; access and reset unknown, modelled RW)";
            sw = rw;
            hw = r;
        } cscp20[14:0];
    } G0_CSC_P3 @ 0x60D8;

    reg {
        name = "G0 colour-space conversion P4";
        desc = "[inferred] G0 colour-space conversion P4. Not in the data sheet. Source: vendor U-Boot 2010.06 `product/hiosd/vo/hi3516a/vou_reg.h` (GPL-2.0 U-Boot tree, HiSilicon copyright, created 2013-04-27; mirror github.com/OpenIPC/u-boot-hi3516cv200), union `U_G0_CSC_P4`, struct offset 0x60DC (GPL-2.0, same-chip vendor header). Reset value and access type unknown (modelled RW, no reset). Confidence: medium (vendor header for this chip family, not hardware verified).";

        field {
            name = "cscp22";
            desc = "[inferred] Cscp22. (vendor header `product/hiosd/vo/hi3516a/vou_reg.h` field `cscp22`; access and reset unknown, modelled RW)";
            sw = rw;
            hw = r;
        } cscp22[14:0];
    } G0_CSC_P4 @ 0x60DC;

    reg {
        name = "G2 configuration register";
        desc = "G2_CTR is a G2 configuration register (non-instant register).

Data sheet 10.2.6 G2_CTRL (offset 0x7000, printed page 10-201, `hi3516av100--Hi3516A-Hi3516D-Datasheet.txt` line 70292).";

        enum G2_CTRL_surface_en_enum {
            DISABLED = 0 { name = "Disabled"; desc = "disabled"; };
            ENABLED = 1 { name = "Enabled"; desc = "enabled"; };
        };

        field {
            name = "surface_en";
            desc = "Surface enable (non-instant).";
            sw = rw;
            hw = r;
            encode = G2_CTRL_surface_en_enum;
            reset = 0x0;
        } surface_en[31:31];

        enum G2_CTRL_upd_mode_enum {
            UPDATE_FAME = 0 { name = "Update Fame"; desc = "update by fame"; };
            UPDATE_FIELD = 1 { name = "Update Field"; desc = "update by field"; };
        };

        field {
            name = "upd_mode";
            desc = "Update mode.";
            sw = rw;
            hw = r;
            encode = G2_CTRL_upd_mode_enum;
            reset = 0x0;
        } upd_mode[27:27];

        enum G2_CTRL_read_mode_enum {
            READ_MODE_AUTOMATICALLY = 0 { name = "Read Mode Automatically"; desc = "The read mode is automatically selected based on the interface read mode. That is, the progressive read mode is selected in progressive display mode, and the interlaced read mode is selected in interlaced display mode."; };
            PROGRESSIVE_READ_MODE = 1 { name = "Progressive Read Mode"; desc = "The progressive read mode is selected forcibly."; };
        };

        field {
            name = "read_mode";
            desc = "Data read mode.";
            sw = rw;
            hw = r;
            encode = G2_CTRL_read_mode_enum;
            reset = 0x0;
        } read_mode[26:26];

        enum G2_CTRL_precharge_en_enum {
            DISABLED = 0 { name = "Disabled"; desc = "disabled"; };
            ENABLED = 1 { name = "Enabled"; desc = "enabled"; };
        };

        field {
            name = "precharge_en";
            desc = "Pre-charge enable. This field is valid when the precharge_mode field is 1 (software mode).";
            sw = rw;
            hw = r;
            encode = G2_CTRL_precharge_en_enum;
            reset = 0x0;
        } precharge_en[21:21];

        enum G2_CTRL_precharge_mode_enum {
            HARDWARE_MODE_HARDWARE = 0 { name = "Hardware Mode Hardware"; desc = "hardware mode. Hardware automatically enters the pre-charge status on the frame trailer."; };
            SOFTWARE_MODE_SOFTWARE = 1 { name = "Software Mode Software"; desc = "software mode. Software controls whether to enter or exit the pre-charge status."; };
        };

        field {
            name = "precharge_mode";
            desc = "Pre-charge mode of the FDR FIFO.";
            sw = rw;
            hw = r;
            encode = G2_CTRL_precharge_mode_enum;
            reset = 0x0;
        } precharge_mode[20:20];

        enum G2_CTRL_bitext_enum {
            EXTEND_0S_LOWER = 0 { name = "Extend 0S Lower"; desc = "extend 0s to lower bits"; };
            EXTEND_VALUE_MSB = 2 { name = "Extend Value Msb"; desc = "extend the value of the MSB to a lower bit"; };
            EXTEND_VALUES_UPPER = 3 { name = "Extend Values Upper"; desc = "extend the values of upper bits to lower bits Other values: reserved"; };
        };

        field {
            name = "bitext";
            desc = "Bit extend mode of the input bitmap.";
            sw = rw;
            hw = r;
            encode = G2_CTRL_bitext_enum;
            reset = 0x0;
        } bitext[9:8];

        enum G2_CTRL_ifmt_enum {
            ARGB4444 = 0x48 { name = "Argb4444"; desc = "ARGB4444"; };
            ARGB1555 = 0x49 { name = "Argb1555"; desc = "ARGB1555"; };
            AYCBCR8888_OTHER_VALUES = 0x69 { name = "Aycbcr8888 Other Values"; desc = "AYCbCr8888 Other values: reserved"; };
        };

        field {
            name = "ifmt";
            desc = "Format of the input data.";
            sw = rw;
            hw = r;
            encode = G2_CTRL_ifmt_enum;
            reset = 0x0;
        } ifmt[7:0];
    } G2_CTRL @ 0x7000;

    reg {
        name = "G2 update enable register";
        desc = "G2_UPD is a G2 update enable register. Huawei Proprietary and Confidential Hi3516A/Hi3516D Professional HD IP Camera SoC

Data sheet 10.2.6 G2_UPD (offset 0x7004, printed page 10-203, `hi3516av100--Hi3516A-Hi3516D-Datasheet.txt` line 70374).";

        field {
            name = "regup";
            desc = "Surface register update. After the registers at this layer are configured, the registers are updated when the value 1 is written to this bit. After updates, this bit is automatically cleared by the hardware.";
            sw = rw;
            hw = r;
            reset = 0x0;
        } regup[0:0];
    } G2_UPD @ 0x7004;

    reg {
        name = "G2 address register";
        desc = "G2_ADDR is a G2 address register. When the horizontal pixel offsets, the address is calculated by following the description of G2_SFPOS.

Data sheet 10.2.6 G2_ADDR (offset 0x7010, printed page 10-203, `hi3516av100--Hi3516A-Hi3516D-Datasheet.txt` line 70400).";

        field {
            name = "surface_addr";
            desc = "Address for the surface frame buffer.";
            sw = rw;
            hw = r;
            reset = 0x0;
        } surface_addr[31:0];
    } G2_ADDR @ 0x7010;

    reg {
        name = "G2 stride register";
        desc = "G2_STRIDE is a G2 stride register. Huawei Proprietary and Confidential Hi3516A/Hi3516D Professional HD IP Camera SoC

Data sheet 10.2.6 G2_STRIDE (offset 0x701C, printed page 10-204, `hi3516av100--Hi3516A-Hi3516D-Datasheet.txt` line 70428).";

        field {
            name = "surface_stride";
            desc = "Frame buffer stride.";
            sw = rw;
            hw = r;
            reset = 0x0;
        } surface_stride[15:0];
    } G2_STRIDE @ 0x701C;

    reg {
        name = "G2 input resolution register (non-instant register)";
        desc = "G2_IRESO is a G2 input resolution register (non-instant register).

Data sheet 10.2.6 G2_IRESO (offset 0x7020, printed page 10-204, `hi3516av100--Hi3516A-Hi3516D-Datasheet.txt` line 70447).";

        field {
            name = "ih";
            desc = "Height (in line). The configured value is the actual height minus 1. Note: In interlaced output mode, the actual layer height must be an even number. There is no such limitation in progressive output mode.";
            sw = rw;
            hw = r;
            reset = 0x0;
        } ih[23:12];

        field {
            name = "iw";
            desc = "Width (in pixel). The configured value is the actual width minus 1. Note: The actual layer width must be an even number.";
            sw = rw;
            hw = r;
            reset = 0x0;
        } iw[11:0];
    } G2_IRESO @ 0x7020;

    reg {
        name = "G2 surface read data start position (in the source bitmap) register (non-instant register)";
        desc = "G2 surface read data start position (in the source bitmap) register (non-instant register).

Data sheet 10.2.6 G2_SFPOS (offset 0x7024, printed page 10-205, `hi3516av100--Hi3516A-Hi3516D-Datasheet.txt` line 70493).";

        field {
            name = "src_xfpos";
            desc = "Start horizontal coordinate of the source picture. The value 0 indicates the first pixel of a line.";
            sw = rw;
            hw = r;
            reset = 0x0;
        } src_xfpos[6:0];
    } G2_SFPOS @ 0x7024;

    reg {
        name = "Overlaying parameter register (non-instant register)";
        desc = "G2_CBMPARA is a G2 overlay parameter register (non-instant register).

Data sheet 10.2.6 G2_CBMPARA (offset 0x7030, printed page 10-205, `hi3516av100--Hi3516A-Hi3516D-Datasheet.txt` line 70514).";

        enum G2_CBMPARA_key_mode_enum {
            COLOR_REGARDED_AS = 0 { name = "Color Regarded As"; desc = "The color is regarded as the colorkey when the following condition is met: Keymin <= Pixel <= Keymax"; };
            COLOR_REGARDED_AS_2 = 1 { name = "Color Regarded As 2"; desc = "The color is regarded as the colorkey when either of the following conditions is met: Pixel <= Keymin or Pixel >= Keymax"; };
        };

        field {
            name = "key_mode";
            desc = "Colorkey mode.";
            sw = rw;
            hw = r;
            encode = G2_CBMPARA_key_mode_enum;
            reset = 0x0;
        } key_mode[15:15];

        enum G2_CBMPARA_key_en_enum {
            DISABLED = 0 { name = "Disabled"; desc = "disabled"; };
            ENABLED = 1 { name = "Enabled"; desc = "enabled"; };
        };

        field {
            name = "key_en";
            desc = "Colorkey enable.";
            sw = rw;
            hw = r;
            encode = G2_CBMPARA_key_en_enum;
            reset = 0x0;
        } key_en[14:14];

        enum G2_CBMPARA_premult_en_enum {
            NON_PREMULTIPLIED_BITMAP = 0 { name = "Non Premultiplied Bitmap"; desc = "non-premultiplied bitmap"; };
            PREMULTIPLIED_BITMAP = 1 { name = "Premultiplied Bitmap"; desc = "premultiplied bitmap"; };
        };

        field {
            name = "premult_en";
            desc = "Whether the input bitmap is a premultiplied bitmap.";
            sw = rw;
            hw = r;
            encode = G2_CBMPARA_premult_en_enum;
            reset = 0x0;
        } premult_en[13:13];

        enum G2_CBMPARA_palpha_en_enum {
            DISABLED = 0 { name = "Disabled"; desc = "disabled"; };
            ENABLED = 1 { name = "Enabled"; desc = "enabled"; };
        };

        field {
            name = "palpha_en";
            desc = "Pixel alpha enable.";
            sw = rw;
            hw = r;
            encode = G2_CBMPARA_palpha_en_enum;
            reset = 0x0;
        } palpha_en[12:12];

        field {
            name = "galpha";
            desc = "Overlay global alpha value. The value ranges from 0 to 255. The value 255 indicates opaque, and the value 0 indicates completely transparent.";
            sw = rw;
            hw = r;
            reset = 0x0;
        } galpha[7:0];
    } G2_CBMPARA @ 0x7030;

    reg {
        name = "Maximum colorkey value register (non- instant register)";
        desc = "G2_CKEYMAX is a maximum colorkey value register (non-instant register).

Data sheet 10.2.6 G2_CKEYMAX (offset 0x7034, printed page 10-206, `hi3516av100--Hi3516A-Hi3516D-Datasheet.txt` line 70566).";

        field {
            name = "va0";
            desc = "Alpha0 value. When the data format is alphaRGB1555 and the alpha value is 0, the alpha0 value is used.";
            sw = rw;
            hw = r;
            reset = 0x0;
        } va0[31:24];

        field {
            name = "keyr_max";
            desc = "Maximum value of the colorkey R component.";
            sw = rw;
            hw = r;
            reset = 0x0;
        } keyr_max[23:16];

        field {
            name = "keyg_max";
            desc = "Maximum value of the colorkey G component.";
            sw = rw;
            hw = r;
            reset = 0x0;
        } keyg_max[15:8];

        field {
            name = "keyb_max";
            desc = "Maximum value of the colorkey B component.";
            sw = rw;
            hw = r;
            reset = 0x0;
        } keyb_max[7:0];
    } G2_CKEYMAX @ 0x7034;

    reg {
        name = "Minimum colorkey value register (non- instant register)";
        desc = "G2_CKEYMIN is a minimum colorkey value register (non-instant register). Huawei Proprietary and Confidential Hi3516A/Hi3516D Professional HD IP Camera SoC

Data sheet 10.2.6 G2_CKEYMIN (offset 0x7038, printed page 10-207, `hi3516av100--Hi3516A-Hi3516D-Datasheet.txt` line 70599).";

        field {
            name = "va1";
            desc = "Alpha1 value. When the data format is alphaRGB1555 and the alpha value is 1, the alpha1 value is used.";
            sw = rw;
            hw = r;
            reset = 0x0;
        } va1[31:24];

        field {
            name = "keyr_min";
            desc = "Minimum value of the colorkey R component.";
            sw = rw;
            hw = r;
            reset = 0x0;
        } keyr_min[23:16];

        field {
            name = "keyg_min";
            desc = "Minimum value of the colorkey G component.";
            sw = rw;
            hw = r;
            reset = 0x0;
        } keyg_min[15:8];

        field {
            name = "keyb_min";
            desc = "Minimum value of the colorkey B component.";
            sw = rw;
            hw = r;
            reset = 0x0;
        } keyb_min[7:0];
    } G2_CKEYMIN @ 0x7038;

    reg {
        name = "Colorkey mask value register (non-instant register)";
        desc = "G2_CMASK is a colorkey mask register (non-instant register). The value 1 indicates that a pixel bit is retained during colorkey comparison; the value 0 indicates that a pixel bit is forcibly set to 0 during color comparison no matter whether the bit is 0 or 1.

Data sheet 10.2.6 G2_CMASK (offset 0x703C, printed page 10-207, `hi3516av100--Hi3516A-Hi3516D-Datasheet.txt` line 70625).";

        field {
            name = "kmsk_r";
            desc = "R component of the masked colorkey.";
            sw = rw;
            hw = r;
            reset = 0xFF;
        } kmsk_r[23:16];

        field {
            name = "kmsk_g";
            desc = "G component of the masked colorkey.";
            sw = rw;
            hw = r;
            reset = 0xFF;
        } kmsk_g[15:8];

        field {
            name = "kmsk_b";
            desc = "B component of the masked colorkey.";
            sw = rw;
            hw = r;
            reset = 0xFF;
        } kmsk_b[7:0];
    } G2_CMASK @ 0x703C;

    reg {
        name = "G2 LUT coefficient address register";
        desc = "G2_PARAADDR is a G2 LUT coefficient address register. Huawei Proprietary and Confidential Hi3516A/Hi3516D Professional HD IP Camera SoC

Data sheet 10.2.6 G2_PARAADDR (offset 0x7040, printed page 10-208, `hi3516av100--Hi3516A-Hi3516D-Datasheet.txt` line 70656).";

        field {
            name = "surface_addr";
            desc = "Surface LUT coefficient address.";
            sw = rw;
            hw = r;
            reset = 0x0;
        } surface_addr[31:0];
    } G2_PARAADDR @ 0x7040;

    reg {
        name = "G2 LUT coefficient update register";
        desc = "G2_PARAUP is a G2 LUT coefficient update register.

Data sheet 10.2.6 G2_PARAUP (offset 0x7044, printed page 10-208, `hi3516av100--Hi3516A-Hi3516D-Datasheet.txt` line 70674).";

        enum G2_PARAUP_gdc_paraup_enum {
            NOT_UPDATED = 0 { name = "Not Updated"; desc = "not updated"; };
            UPDATED = 1 { name = "Updated"; desc = "updated"; };
        };

        field {
            name = "gdc_paraup";
            desc = "LUT coefficient update.";
            sw = rw;
            hw = r;
            encode = G2_PARAUP_gdc_paraup_enum;
            reset = 0x0;
        } gdc_paraup[0:0];
    } G2_PARAUP @ 0x7044;

    reg {
        name = "G2 surface start position (in the display window) register (non-instant register)";
        desc = "G2_DFPOS is a G2 surface start position (in the display window) register (non-instant register). The position unit is pixel. Huawei Proprietary and Confidential Hi3516A/Hi3516D Professional HD IP Camera SoC

Data sheet 10.2.6 G2_DFPOS (offset 0x7080, printed page 10-209, `hi3516av100--Hi3516A-Hi3516D-Datasheet.txt` line 70713).";

        field {
            name = "disp_yfpos";
            desc = "Column start coordinates.";
            sw = rw;
            hw = r;
            reset = 0x0;
        } disp_yfpos[23:12];

        field {
            name = "disp_xfpos";
            desc = "Row start coordinates.";
            sw = rw;
            hw = r;
            reset = 0x0;
        } disp_xfpos[11:0];
    } G2_DFPOS @ 0x7080;

    reg {
        name = "G2 surface end position (in the display window) register (non-instant register)";
        desc = "G2_DLPOS is a G2 surface end position (in the display window) register (non-instant register). The position unit is pixel.

Data sheet 10.2.6 G2_DLPOS (offset 0x7084, printed page 10-209, `hi3516av100--Hi3516A-Hi3516D-Datasheet.txt` line 70734).";

        field {
            name = "disp_ylpos";
            desc = "Column end coordinates.";
            sw = rw;
            hw = r;
            reset = 0x0;
        } disp_ylpos[23:12];

        field {
            name = "disp_xlpos";
            desc = "Row end coordinates.";
            sw = rw;
            hw = r;
            reset = 0x0;
        } disp_xlpos[11:0];
    } G2_DLPOS @ 0x7084;

    reg {
        name = "G2 surface content start position (in the display window) register (non-instant register)";
        desc = "G2_VFPOS is a G2 surface content start position (in the display window) register (non-instant register). The position unit is pixel. Huawei Proprietary and Confidential Hi3516A/Hi3516D Professional HD IP Camera SoC

Data sheet 10.2.6 G2_VFPOS (offset 0x7088, printed page 10-210, `hi3516av100--Hi3516A-Hi3516D-Datasheet.txt` line 70765).";

        field {
            name = "video_yfpos";
            desc = "Start coordinates of the graphics column. The frame height is referenced and its unit is line.";
            sw = rw;
            hw = r;
            reset = 0x0;
        } video_yfpos[23:12];

        field {
            name = "video_xfpos";
            desc = "Start coordinates of the graphics row.";
            sw = rw;
            hw = r;
            reset = 0x0;
        } video_xfpos[11:0];
    } G2_VFPOS @ 0x7088;

    reg {
        name = "G2 surface content end position (in the display window) register (non-instant register)";
        desc = "G2_VLPOS is a G2 surface content end position (in the display window) register (non-instant register). The position unit is pixel.

Data sheet 10.2.6 G2_VLPOS (offset 0x708C, printed page 10-210, `hi3516av100--Hi3516A-Hi3516D-Datasheet.txt` line 70788).";

        field {
            name = "video_ylpos";
            desc = "End coordinates of the graphics column. The frame height is referenced and its unit is line.";
            sw = rw;
            hw = r;
            reset = 0x0;
        } video_ylpos[23:12];

        field {
            name = "video_xlpos";
            desc = "End coordinates of the graphics row.";
            sw = rw;
            hw = r;
            reset = 0x0;
        } video_xlpos[11:0];
    } G2_VLPOS @ 0x708C;

    reg {
        name = "G2 background color register";
        desc = "G2_BK is a G2 background color register. Huawei Proprietary and Confidential Hi3516A/Hi3516D Professional HD IP Camera SoC

Data sheet 10.2.6 G2_BK (offset 0x7090, printed page 10-211, `hi3516av100--Hi3516A-Hi3516D-Datasheet.txt` line 70820).";

        field {
            name = "vbk_y";
            desc = "Y component.";
            sw = rw;
            hw = r;
            reset = 0x0;
        } vbk_y[29:20];

        field {
            name = "vbk_cb";
            desc = "Cb component.";
            sw = rw;
            hw = r;
            reset = 0x0;
        } vbk_cb[19:10];

        field {
            name = "vbk_cr";
            desc = "Cr component.";
            sw = rw;
            hw = r;
            reset = 0x0;
        } vbk_cr[9:0];
    } G2_BK @ 0x7090;

    reg {
        name = "G2 background filling color alpha register";
        desc = "G2_ALPHA is a G2 background filling color alpha register.

Data sheet 10.2.6 G2_ALPHA (offset 0x7094, printed page 10-211, `hi3516av100--Hi3516A-Hi3516D-Datasheet.txt` line 70845).";

        field {
            name = "vbk_alpha";
            desc = "Level 0-128 of the background filling color of the graphics layer.";
            sw = rw;
            hw = r;
            reset = 0x0;
        } vbk_alpha[7:0];
    } G2_ALPHA @ 0x7094;

    reg {
        name = "G2 CSC input DC component register (instant register)";
        desc = "G2_CSC_IDC is a G2 CSC input DC register (instant register). Huawei Proprietary and Confidential Hi3516A/Hi3516D Professional HD IP Camera SoC

Data sheet 10.2.6 G2_CSC_IDC (offset 0x70C0, printed page 10-212, `hi3516av100--Hi3516A-Hi3516D-Datasheet.txt` line 70874).";

        enum G2_CSC_IDC_csc_mode_enum {
            RESERVED = 0 { name = "Reserved"; desc = "reserved"; };
            YUV2YUV = 1 { name = "Yuv2Yuv"; desc = "YUV2YUV"; };
            YUV601_RGB = 2 { name = "Yuv601 Rgb"; desc = "YUV601_RGB"; };
            YUV709_RGB = 3 { name = "Yuv709 Rgb"; desc = "YUV709_RGB"; };
            YUV2YUV_709_601 = 4 { name = "Yuv2Yuv 709 601"; desc = "YUV2YUV_709_601"; };
            YUV2YUV_601_709 = 5 { name = "Yuv2Yuv 601 709"; desc = "YUV2YUV_601_709"; };
            RGB2YUV_601 = 6 { name = "Rgb2Yuv 601"; desc = "RGB2YUV_601"; };
            RGB2YUV_709 = 7 { name = "Rgb2Yuv 709"; desc = "RGB2YUV_709"; };
        };

        field {
            name = "csc_mode";
            desc = "This field is valid only when the G2 CSC coefficients are fixed.";
            sw = rw;
            hw = r;
            encode = G2_CSC_IDC_csc_mode_enum;
            reset = 0x0;
        } csc_mode[25:23];

        enum G2_CSC_IDC_csc_en_enum {
            DISABLED = 0 { name = "Disabled"; desc = "disabled"; };
            ENABLED = 1 { name = "Enabled"; desc = "enabled"; };
        };

        field {
            name = "csc_en";
            desc = "CSC enable.";
            sw = rw;
            hw = r;
            encode = G2_CSC_IDC_csc_en_enum;
            reset = 0x0;
        } csc_en[22:22];

        field {
            name = "cscidc1";
            desc = "DC parameter of the input U/G component. The MSB is the signed bit. The value is expressed as a two's complement.";
            sw = rw;
            hw = r;
            reset = 0x0;
        } cscidc1[21:11];

        field {
            name = "cscidc0";
            desc = "DC parameter of the input V/B component. The MSB is the signed bit. The value is expressed as a two's complement.";
            sw = rw;
            hw = r;
            reset = 0x0;
        } cscidc0[10:0];
    } G2_CSC_IDC @ 0x70C0;

    reg {
        name = "G2 CSC output DC component register (instant register)";
        desc = "G2_CSC_ODC is a G2 CSC output DC component register (instant register). Huawei Proprietary and Confidential Hi3516A/Hi3516D Professional HD IP Camera SoC

Data sheet 10.2.6 G2_CSC_ODC (offset 0x70C4, printed page 10-213, `hi3516av100--Hi3516A-Hi3516D-Datasheet.txt` line 70924).";

        enum G2_CSC_ODC_csc_sign_mode_enum {
            CSC_OUTPUT_10 = 0 { name = "Csc Output 10"; desc = "The CSC output is a 10-bit unsigned number."; };
            CSC_OUTPUT_12 = 1 { name = "Csc Output 12"; desc = "The CSC output is a 12-bit signed number."; };
        };

        field {
            name = "csc_sign_mode";
            desc = "CSC output mode.";
            sw = rw;
            hw = r;
            encode = G2_CSC_ODC_csc_sign_mode_enum;
            reset = 0x0;
        } csc_sign_mode[22:22];

        field {
            name = "cscodc1";
            desc = "DC parameter of the output U/G component. The MSB is the signed bit. The value is expressed as a two's complement.";
            sw = rw;
            hw = r;
            reset = 0x0;
        } cscodc1[21:11];

        field {
            name = "cscodc0";
            desc = "DC parameter of the output Y/R component. The MSB is the signed bit. The value is expressed as a two's complement.";
            sw = rw;
            hw = r;
            reset = 0x0;
        } cscodc0[10:0];
    } G2_CSC_ODC @ 0x70C4;

    reg {
        name = "G2 CSC input/output DC component register (instant register)";
        desc = "G2_CSC_IODC is a G2 CSC input/output DC component register (instant register).

Data sheet 10.2.6 G2_CSC_IODC (offset 0x70C8, printed page 10-213, `hi3516av100--Hi3516A-Hi3516D-Datasheet.txt` line 70958).";

        field {
            name = "cscodc2";
            desc = "DC parameter of the output V/B component. The MSB is the signed bit. The value is expressed as a two's complement.";
            sw = rw;
            hw = r;
            reset = 0x0;
        } cscodc2[21:11];

        field {
            name = "cscidc2";
            desc = "DC parameter of the input Y/R component. The MSB is the signed bit. The value is expressed as a two's complement.";
            sw = rw;
            hw = r;
            reset = 0x0;
        } cscidc2[10:0];
    } G2_CSC_IODC @ 0x70C8;

    reg {
        name = "G2 CSC parameter 0 register (instant register)";
        desc = "G2_CSC_P0 is a G2 CSC parameter 0 register (instant register).

Data sheet 10.2.6 G2_CSC_P0 (offset 0x70CC, printed page 10-214, `hi3516av100--Hi3516A-Hi3516D-Datasheet.txt` line 70988).";

        field {
            name = "cscp01";
            desc = "5.10 data format that consists of a 1-bit sign part, a 4-bit integer part, and an 8-bit decimal part. The value is expressed as a two's complement.";
            sw = rw;
            hw = r;
            reset = 0x0;
        } cscp01[30:16];

        field {
            name = "cscp00";
            desc = "5.10 data format that consists of a 1-bit sign part, a 4-bit integer part, and an 8-bit decimal part. The value is expressed as a two's complement.";
            sw = rw;
            hw = r;
            reset = 0x0;
        } cscp00[14:0];
    } G2_CSC_P0 @ 0x70CC;

    reg {
        name = "G2 CSC parameter 1 register (instant register)";
        desc = "G2_CSC_P1 is a G2 CSC parameter 1 register (instant register).

Data sheet 10.2.6 G2_CSC_P1 (offset 0x70D0, printed page 10-214, `hi3516av100--Hi3516A-Hi3516D-Datasheet.txt` line 71017).";

        field {
            name = "cscp10";
            desc = "5.10 data format that consists of a 1-bit sign part, a 4-bit integer part, and an 8-bit decimal part. The value is expressed as a two's complement.";
            sw = rw;
            hw = r;
            reset = 0x0;
        } cscp10[30:16];

        field {
            name = "cscp02";
            desc = "5.10 data format that consists of a 1-bit sign part, a 4-bit integer part, and an 8-bit decimal part. The value is expressed as a two's complement.";
            sw = rw;
            hw = r;
            reset = 0x0;
        } cscp02[14:0];
    } G2_CSC_P1 @ 0x70D0;

    reg {
        name = "G2 CSC parameter 2 register (instant register)";
        desc = "G2_CSC_P2 is a G2 CSC parameter 2 register (instant register).

Data sheet 10.2.6 G2_CSC_P2 (offset 0x70D4, printed page 10-215, `hi3516av100--Hi3516A-Hi3516D-Datasheet.txt` line 71056).";

        field {
            name = "cscp12";
            desc = "5.10 data format that consists of a 1-bit sign part, a 4-bit integer part, and an 8-bit decimal part. The value is expressed as a two's complement.";
            sw = rw;
            hw = r;
            reset = 0x0;
        } cscp12[30:16];

        field {
            name = "cscp11";
            desc = "5.10 data format that consists of a 1-bit sign part, a 4-bit integer part, and an 8-bit decimal part. The value is expressed as a two's complement.";
            sw = rw;
            hw = r;
            reset = 0x0;
        } cscp11[14:0];
    } G2_CSC_P2 @ 0x70D4;

    reg {
        name = "G2 CSC parameter 3 register (instant register)";
        desc = "G2_CSC_P3 is a G2 CSC parameter 3 register (instant register).

Data sheet 10.2.6 G2_CSC_P3 (offset 0x70D8, printed page 10-215, `hi3516av100--Hi3516A-Hi3516D-Datasheet.txt` line 71083).";

        field {
            name = "cscp21";
            desc = "5.10 data format that consists of a 1-bit sign part, a 4-bit integer part, and an 8-bit decimal part. The value is expressed as a two's complement.";
            sw = rw;
            hw = r;
            reset = 0x0;
        } cscp21[30:16];

        field {
            name = "cscp20";
            desc = "5.10 data format that consists of a 1-bit sign part, a 4-bit integer part, and an 8-bit decimal part. The value is expressed as a two's complement.";
            sw = rw;
            hw = r;
            reset = 0x0;
        } cscp20[14:0];
    } G2_CSC_P3 @ 0x70D8;

    reg {
        name = "G2 CSC parameter 4 register (instant register)";
        desc = "G2_CSC_P4 is a G2 CSC parameter 4 register (instant register).

Data sheet 10.2.6 G2_CSC_P4 (offset 0x70DC, printed page 10-216, `hi3516av100--Hi3516A-Hi3516D-Datasheet.txt` line 71122).";

        field {
            name = "cscp22";
            desc = "5.10 data format that consists of a 1-bit sign part, a 4-bit integer part, and an 8-bit decimal part. The value is expressed as a two's complement.";
            sw = rw;
            hw = r;
            reset = 0x0;
        } cscp22[14:0];
    } G2_CSC_P4 @ 0x70DC;

    reg {
        name = "CBM mixer 2 overlay background color register";
        desc = "CBM_BKG2 is a CBM mixer 2 overlay background color register.

Data sheet 10.2.6 CBM_BKG2 (offset 0xB420, printed page 10-216, `hi3516av100--Hi3516A-Hi3516D-Datasheet.txt` line 71143).";

        field {
            name = "cbm_bkgy2";
            desc = "Overlay background color of CBM mixer 2, Y component.";
            sw = rw;
            hw = r;
            reset = 0x0;
        } cbm_bkgy2[29:20];

        field {
            name = "cbm_bkgcb2";
            desc = "Overlay background color of CBM mixer 2, Cb component.";
            sw = rw;
            hw = r;
            reset = 0x0;
        } cbm_bkgcb2[19:10];

        field {
            name = "cbm_bkgcr2";
            desc = "Overlay background color of CBM mixer 2, Cr component.";
            sw = rw;
            hw = r;
            reset = 0x0;
        } cbm_bkgcr2[9:0];
    } CBM_BKG2 @ 0xB420;

    reg {
        name = "CBM mixer 2 priority configuration register";
        desc = "CBM_MIX2 is a CBM mixer 2 priority configuration register (instant register). The register configuration takes effect only when the vsync signal is valid. mixer_prio_x is overly layer priority x.

Data sheet 10.2.6 CBM_MIX2 (offset 0xB428, printed page 10-217, `hi3516av100--Hi3516A-Hi3516D-Datasheet.txt` line 71181).";

        field {
            name = "mixer_prio3";
            desc = "[inferred] Mixer prio3. (bits reserved in the data sheet; vendor header `product/hiosd/vo/hi3516a/vou_reg.h` field `mixer_prio3`; access and reset unknown, modelled RW)";
            sw = rw;
            hw = r;
        } mixer_prio3[15:12];

        field {
            name = "mixer_prio2";
            desc = "[inferred] Mixer prio2. (bits reserved in the data sheet; vendor header `product/hiosd/vo/hi3516a/vou_reg.h` field `mixer_prio2`; access and reset unknown, modelled RW)";
            sw = rw;
            hw = r;
        } mixer_prio2[11:8];

        enum CBM_MIX2_mixer_prio1_enum {
            NO_DRIVE_LAYER = 0 { name = "No Drive Layer"; desc = "no drive layer"; };
            V1 = 9 { name = "V1"; desc = "V1"; };
            G2_OTHER_VALUES = 10 { name = "G2 Other Values"; desc = "G2 Other values: reserved"; };
        };

        field {
            name = "mixer_prio1";
            desc = "Drive layer of CBM mixer 2 with priority 1.";
            sw = rw;
            hw = r;
            encode = CBM_MIX2_mixer_prio1_enum;
            reset = 0x0;
        } mixer_prio1[7:4];

        enum CBM_MIX2_mixer_prio0_enum {
            NO_DRIVE_LAYER = 0 { name = "No Drive Layer"; desc = "no drive layer"; };
            V1 = 9 { name = "V1"; desc = "V1"; };
            G2_OTHER_VALUES = 10 { name = "G2 Other Values"; desc = "G2 Other values: reserved"; };
        };

        field {
            name = "mixer_prio0";
            desc = "Drive layer of CBM mixer 2 with priority 0.";
            sw = rw;
            hw = r;
            encode = CBM_MIX2_mixer_prio0_enum;
            reset = 0x0;
        } mixer_prio0[3:0];
    } CBM_MIX2 @ 0xB428;

    reg {
        name = "DHD0 control";
        desc = "[inferred] DHD0 control. Not in the data sheet. Source: vendor U-Boot 2010.06 `product/hiosd/vo/hi3516a/vou_reg.h` (GPL-2.0 U-Boot tree, HiSilicon copyright, created 2013-04-27; mirror github.com/OpenIPC/u-boot-hi3516cv200), union `U_DHD0_CTRL`, struct offset 0xC000 (GPL-2.0, same-chip vendor header). Reset value and access type unknown (modelled RW, no reset). Confidence: medium (vendor header for this chip family, not hardware verified).";

        field {
            name = "intf_en";
            desc = "[inferred] Intf enable. (vendor header `product/hiosd/vo/hi3516a/vou_reg.h` field `intf_en`; access and reset unknown, modelled RW)";
            sw = rw;
            hw = r;
        } intf_en[31:31];

        field {
            name = "cbar_en";
            desc = "[inferred] Cbar enable. (vendor header `product/hiosd/vo/hi3516a/vou_reg.h` field `cbar_en`; access and reset unknown, modelled RW)";
            sw = rw;
            hw = r;
        } cbar_en[30:30];

        field {
            name = "cbar_sel";
            desc = "[inferred] Cbar select. (vendor header `product/hiosd/vo/hi3516a/vou_reg.h` field `cbar_sel`; access and reset unknown, modelled RW)";
            sw = rw;
            hw = r;
        } cbar_sel[29:29];

        field {
            name = "fpga_lmt_en";
            desc = "[inferred] Fpga lmt enable. (vendor header `product/hiosd/vo/hi3516a/vou_reg.h` field `fpga_lmt_en`; access and reset unknown, modelled RW)";
            sw = rw;
            hw = r;
        } fpga_lmt_en[27:27];

        field {
            name = "fpga_lmt_width";
            desc = "[inferred] Fpga lmt width. (vendor header `product/hiosd/vo/hi3516a/vou_reg.h` field `fpga_lmt_width`; access and reset unknown, modelled RW)";
            sw = rw;
            hw = r;
        } fpga_lmt_width[26:20];

        field {
            name = "precharge_en";
            desc = "[inferred] Precharge enable. (vendor header `product/hiosd/vo/hi3516a/vou_reg.h` field `precharge_en`; access and reset unknown, modelled RW)";
            sw = rw;
            hw = r;
        } precharge_en[10:10];

        field {
            name = "precharge_mode";
            desc = "[inferred] Precharge mode. (vendor header `product/hiosd/vo/hi3516a/vou_reg.h` field `precharge_mode`; access and reset unknown, modelled RW)";
            sw = rw;
            hw = r;
        } precharge_mode[9:9];

        field {
            name = "iop";
            desc = "[inferred] Iop. (vendor header `product/hiosd/vo/hi3516a/vou_reg.h` field `iop`; access and reset unknown, modelled RW)";
            sw = rw;
            hw = r;
        } iop[4:4];

        field {
            name = "regup";
            desc = "[inferred] Regup. (vendor header `product/hiosd/vo/hi3516a/vou_reg.h` field `regup`; access and reset unknown, modelled RW)";
            sw = rw;
            hw = r;
        } regup[0:0];
    } DHD0_CTRL @ 0xC000;

    reg {
        name = "DHD0 vertical sync";
        desc = "[inferred] DHD0 vertical sync. Not in the data sheet. Source: vendor U-Boot 2010.06 `product/hiosd/vo/hi3516a/vou_reg.h` (GPL-2.0 U-Boot tree, HiSilicon copyright, created 2013-04-27; mirror github.com/OpenIPC/u-boot-hi3516cv200), union `U_DHD0_VSYNC`, struct offset 0xC004 (GPL-2.0, same-chip vendor header). Reset value and access type unknown (modelled RW, no reset). Confidence: medium (vendor header for this chip family, not hardware verified).";

        field {
            name = "vfb";
            desc = "[inferred] Vfb. (vendor header `product/hiosd/vo/hi3516a/vou_reg.h` field `vfb`; access and reset unknown, modelled RW)";
            sw = rw;
            hw = r;
        } vfb[27:20];

        field {
            name = "vbb";
            desc = "[inferred] Vbb. (vendor header `product/hiosd/vo/hi3516a/vou_reg.h` field `vbb`; access and reset unknown, modelled RW)";
            sw = rw;
            hw = r;
        } vbb[19:12];

        field {
            name = "vact";
            desc = "[inferred] Vact. (vendor header `product/hiosd/vo/hi3516a/vou_reg.h` field `vact`; access and reset unknown, modelled RW)";
            sw = rw;
            hw = r;
        } vact[11:0];
    } DHD0_VSYNC @ 0xC004;

    reg {
        name = "DHD0 HSYNC1";
        desc = "[inferred] DHD0 HSYNC1. Not in the data sheet. Source: vendor U-Boot 2010.06 `product/hiosd/vo/hi3516a/vou_reg.h` (GPL-2.0 U-Boot tree, HiSilicon copyright, created 2013-04-27; mirror github.com/OpenIPC/u-boot-hi3516cv200), union `U_DHD0_HSYNC1`, struct offset 0xC008 (GPL-2.0, same-chip vendor header). Reset value and access type unknown (modelled RW, no reset). Confidence: medium (vendor header for this chip family, not hardware verified).";

        field {
            name = "hbb";
            desc = "[inferred] Hbb. (vendor header `product/hiosd/vo/hi3516a/vou_reg.h` field `hbb`; access and reset unknown, modelled RW)";
            sw = rw;
            hw = r;
        } hbb[31:16];

        field {
            name = "hact";
            desc = "[inferred] Hact. (vendor header `product/hiosd/vo/hi3516a/vou_reg.h` field `hact`; access and reset unknown, modelled RW)";
            sw = rw;
            hw = r;
        } hact[15:0];
    } DHD0_HSYNC1 @ 0xC008;

    reg {
        name = "DHD0 HSYNC2";
        desc = "[inferred] DHD0 HSYNC2. Not in the data sheet. Source: vendor U-Boot 2010.06 `product/hiosd/vo/hi3516a/vou_reg.h` (GPL-2.0 U-Boot tree, HiSilicon copyright, created 2013-04-27; mirror github.com/OpenIPC/u-boot-hi3516cv200), union `U_DHD0_HSYNC2`, struct offset 0xC00C (GPL-2.0, same-chip vendor header). Reset value and access type unknown (modelled RW, no reset). Confidence: medium (vendor header for this chip family, not hardware verified).";

        field {
            name = "hmid";
            desc = "[inferred] Hmid. (vendor header `product/hiosd/vo/hi3516a/vou_reg.h` field `hmid`; access and reset unknown, modelled RW)";
            sw = rw;
            hw = r;
        } hmid[31:16];

        field {
            name = "hfb";
            desc = "[inferred] Hfb. (vendor header `product/hiosd/vo/hi3516a/vou_reg.h` field `hfb`; access and reset unknown, modelled RW)";
            sw = rw;
            hw = r;
        } hfb[15:0];
    } DHD0_HSYNC2 @ 0xC00C;

    reg {
        name = "DHD0 VPLUS";
        desc = "[inferred] DHD0 VPLUS. Not in the data sheet. Source: vendor U-Boot 2010.06 `product/hiosd/vo/hi3516a/vou_reg.h` (GPL-2.0 U-Boot tree, HiSilicon copyright, created 2013-04-27; mirror github.com/OpenIPC/u-boot-hi3516cv200), union `U_DHD0_VPLUS`, struct offset 0xC010 (GPL-2.0, same-chip vendor header). Reset value and access type unknown (modelled RW, no reset). Confidence: medium (vendor header for this chip family, not hardware verified).";

        field {
            name = "bvfb";
            desc = "[inferred] Bvfb. (vendor header `product/hiosd/vo/hi3516a/vou_reg.h` field `bvfb`; access and reset unknown, modelled RW)";
            sw = rw;
            hw = r;
        } bvfb[27:20];

        field {
            name = "bvbb";
            desc = "[inferred] Bvbb. (vendor header `product/hiosd/vo/hi3516a/vou_reg.h` field `bvbb`; access and reset unknown, modelled RW)";
            sw = rw;
            hw = r;
        } bvbb[19:12];

        field {
            name = "bvact";
            desc = "[inferred] Bvact. (vendor header `product/hiosd/vo/hi3516a/vou_reg.h` field `bvact`; access and reset unknown, modelled RW)";
            sw = rw;
            hw = r;
        } bvact[11:0];
    } DHD0_VPLUS @ 0xC010;

    reg {
        name = "DHD0 PWR";
        desc = "[inferred] DHD0 PWR. Not in the data sheet. Source: vendor U-Boot 2010.06 `product/hiosd/vo/hi3516a/vou_reg.h` (GPL-2.0 U-Boot tree, HiSilicon copyright, created 2013-04-27; mirror github.com/OpenIPC/u-boot-hi3516cv200), union `U_DHD0_PWR`, struct offset 0xC014 (GPL-2.0, same-chip vendor header). Reset value and access type unknown (modelled RW, no reset). Confidence: medium (vendor header for this chip family, not hardware verified).";

        field {
            name = "vpw";
            desc = "[inferred] Vpw. (vendor header `product/hiosd/vo/hi3516a/vou_reg.h` field `vpw`; access and reset unknown, modelled RW)";
            sw = rw;
            hw = r;
        } vpw[23:16];

        field {
            name = "hpw";
            desc = "[inferred] Hpw. (vendor header `product/hiosd/vo/hi3516a/vou_reg.h` field `hpw`; access and reset unknown, modelled RW)";
            sw = rw;
            hw = r;
        } hpw[15:0];
    } DHD0_PWR @ 0xC014;

    reg {
        name = "DHD0 VTTHD3";
        desc = "[inferred] DHD0 VTTHD3. Not in the data sheet. Source: vendor U-Boot 2010.06 `product/hiosd/vo/hi3516a/vou_reg.h` (GPL-2.0 U-Boot tree, HiSilicon copyright, created 2013-04-27; mirror github.com/OpenIPC/u-boot-hi3516cv200), union `U_DHD0_VTTHD3`, struct offset 0xC018 (GPL-2.0, same-chip vendor header). Reset value and access type unknown (modelled RW, no reset). Confidence: medium (vendor header for this chip family, not hardware verified).";

        field {
            name = "thd4_mode";
            desc = "[inferred] Thd4 mode. (vendor header `product/hiosd/vo/hi3516a/vou_reg.h` field `thd4_mode`; access and reset unknown, modelled RW)";
            sw = rw;
            hw = r;
        } thd4_mode[31:31];

        field {
            name = "vtmgthd4";
            desc = "[inferred] Vtmgthd4. (vendor header `product/hiosd/vo/hi3516a/vou_reg.h` field `vtmgthd4`; access and reset unknown, modelled RW)";
            sw = rw;
            hw = r;
        } vtmgthd4[28:16];

        field {
            name = "thd3_mode";
            desc = "[inferred] Thd3 mode. (vendor header `product/hiosd/vo/hi3516a/vou_reg.h` field `thd3_mode`; access and reset unknown, modelled RW)";
            sw = rw;
            hw = r;
        } thd3_mode[15:15];

        field {
            name = "vtmgthd3";
            desc = "[inferred] Vtmgthd3. (vendor header `product/hiosd/vo/hi3516a/vou_reg.h` field `vtmgthd3`; access and reset unknown, modelled RW)";
            sw = rw;
            hw = r;
        } vtmgthd3[12:0];
    } DHD0_VTTHD3 @ 0xC018;

    reg {
        name = "DHD0 VTTHD";
        desc = "[inferred] DHD0 VTTHD. Not in the data sheet. Source: vendor U-Boot 2010.06 `product/hiosd/vo/hi3516a/vou_reg.h` (GPL-2.0 U-Boot tree, HiSilicon copyright, created 2013-04-27; mirror github.com/OpenIPC/u-boot-hi3516cv200), union `U_DHD0_VTTHD`, struct offset 0xC01C (GPL-2.0, same-chip vendor header). Reset value and access type unknown (modelled RW, no reset). Confidence: medium (vendor header for this chip family, not hardware verified).";

        field {
            name = "thd2_mode";
            desc = "[inferred] Thd2 mode. (vendor header `product/hiosd/vo/hi3516a/vou_reg.h` field `thd2_mode`; access and reset unknown, modelled RW)";
            sw = rw;
            hw = r;
        } thd2_mode[31:31];

        field {
            name = "vtmgthd2";
            desc = "[inferred] Vtmgthd2. (vendor header `product/hiosd/vo/hi3516a/vou_reg.h` field `vtmgthd2`; access and reset unknown, modelled RW)";
            sw = rw;
            hw = r;
        } vtmgthd2[28:16];

        field {
            name = "thd1_mode";
            desc = "[inferred] Thd1 mode. (vendor header `product/hiosd/vo/hi3516a/vou_reg.h` field `thd1_mode`; access and reset unknown, modelled RW)";
            sw = rw;
            hw = r;
        } thd1_mode[15:15];

        field {
            name = "vtmgthd1";
            desc = "[inferred] Vtmgthd1. (vendor header `product/hiosd/vo/hi3516a/vou_reg.h` field `vtmgthd1`; access and reset unknown, modelled RW)";
            sw = rw;
            hw = r;
        } vtmgthd1[12:0];
    } DHD0_VTTHD @ 0xC01C;

    reg {
        name = "DHD0 AFFTHD";
        desc = "[inferred] DHD0 AFFTHD. Not in the data sheet. Source: vendor U-Boot 2010.06 `product/hiosd/vo/hi3516a/vou_reg.h` (GPL-2.0 U-Boot tree, HiSilicon copyright, created 2013-04-27; mirror github.com/OpenIPC/u-boot-hi3516cv200), union `U_DHD0_AFFTHD`, struct offset 0xC030 (GPL-2.0, same-chip vendor header). Reset value and access type unknown (modelled RW, no reset). Confidence: medium (vendor header for this chip family, not hardware verified).";

        field {
            name = "dhd_aff_thd";
            desc = "[inferred] Dhd aff threshold. (vendor header `product/hiosd/vo/hi3516a/vou_reg.h` field `dhd_aff_thd`; access and reset unknown, modelled RW)";
            sw = rw;
            hw = r;
        } dhd_aff_thd[5:0];
    } DHD0_AFFTHD @ 0xC030;

    reg {
        name = "DHD0 VGA DACDET1";
        desc = "[inferred] DHD0 VGA DACDET1. Not in the data sheet. Source: vendor U-Boot 2010.06 `product/hiosd/vo/hi3516a/vou_reg.h` (GPL-2.0 U-Boot tree, HiSilicon copyright, created 2013-04-27; mirror github.com/OpenIPC/u-boot-hi3516cv200), union `U_DHD0_VGA_DACDET1`, struct offset 0xC038 (GPL-2.0, same-chip vendor header). Reset value and access type unknown (modelled RW, no reset). Confidence: medium (vendor header for this chip family, not hardware verified).";

        field {
            name = "det_line";
            desc = "[inferred] Det line. (vendor header `product/hiosd/vo/hi3516a/vou_reg.h` field `det_line`; access and reset unknown, modelled RW)";
            sw = rw;
            hw = r;
        } det_line[25:16];

        field {
            name = "vdac_det_high";
            desc = "[inferred] Vdac det high. (vendor header `product/hiosd/vo/hi3516a/vou_reg.h` field `vdac_det_high`; access and reset unknown, modelled RW)";
            sw = rw;
            hw = r;
        } vdac_det_high[9:0];
    } DHD0_VGA_DACDET1 @ 0xC038;

    reg {
        name = "DHD0 VGA DACDET2";
        desc = "[inferred] DHD0 VGA DACDET2. Not in the data sheet. Source: vendor U-Boot 2010.06 `product/hiosd/vo/hi3516a/vou_reg.h` (GPL-2.0 U-Boot tree, HiSilicon copyright, created 2013-04-27; mirror github.com/OpenIPC/u-boot-hi3516cv200), union `U_DHD0_VGA_DACDET2`, struct offset 0xC03C (GPL-2.0, same-chip vendor header). Reset value and access type unknown (modelled RW, no reset). Confidence: medium (vendor header for this chip family, not hardware verified).";

        field {
            name = "vdac_det_en";
            desc = "[inferred] Vdac det enable. (vendor header `product/hiosd/vo/hi3516a/vou_reg.h` field `vdac_det_en`; access and reset unknown, modelled RW)";
            sw = rw;
            hw = r;
        } vdac_det_en[31:31];

        field {
            name = "det_pixel_wid";
            desc = "[inferred] Det pixel width. (vendor header `product/hiosd/vo/hi3516a/vou_reg.h` field `det_pixel_wid`; access and reset unknown, modelled RW)";
            sw = rw;
            hw = r;
        } det_pixel_wid[26:16];

        field {
            name = "det_pixel_sta";
            desc = "[inferred] Det pixel status. (vendor header `product/hiosd/vo/hi3516a/vou_reg.h` field `det_pixel_sta`; access and reset unknown, modelled RW)";
            sw = rw;
            hw = r;
        } det_pixel_sta[10:0];
    } DHD0_VGA_DACDET2 @ 0xC03C;

    reg {
        name = "DHD0 PARATHD";
        desc = "[inferred] DHD0 PARATHD. Not in the data sheet. Source: vendor U-Boot 2010.06 `product/hiosd/vo/hi3516a/vou_reg.h` (GPL-2.0 U-Boot tree, HiSilicon copyright, created 2013-04-27; mirror github.com/OpenIPC/u-boot-hi3516cv200), union `U_DHD0_PARATHD`, struct offset 0xC0B0 (GPL-2.0, same-chip vendor header). Reset value and access type unknown (modelled RW, no reset). Confidence: medium (vendor header for this chip family, not hardware verified).";

        field {
            name = "dfs_en";
            desc = "[inferred] Dfs enable. (vendor header `product/hiosd/vo/hi3516a/vou_reg.h` field `dfs_en`; access and reset unknown, modelled RW)";
            sw = rw;
            hw = r;
        } dfs_en[31:31];

        field {
            name = "para_thd";
            desc = "[inferred] Para threshold. (vendor header `product/hiosd/vo/hi3516a/vou_reg.h` field `para_thd`; access and reset unknown, modelled RW)";
            sw = rw;
            hw = r;
        } para_thd[5:0];
    } DHD0_PARATHD @ 0xC0B0;

    reg {
        name = "DHD0 START position";
        desc = "[inferred] DHD0 START position. Not in the data sheet. Source: vendor U-Boot 2010.06 `product/hiosd/vo/hi3516a/vou_reg.h` (GPL-2.0 U-Boot tree, HiSilicon copyright, created 2013-04-27; mirror github.com/OpenIPC/u-boot-hi3516cv200), union `U_DHD0_START_POS`, struct offset 0xC0C0 (GPL-2.0, same-chip vendor header). Reset value and access type unknown (modelled RW, no reset). Confidence: medium (vendor header for this chip family, not hardware verified).";

        field {
            name = "timing_start_pos";
            desc = "[inferred] Timing start position. (vendor header `product/hiosd/vo/hi3516a/vou_reg.h` field `timing_start_pos`; access and reset unknown, modelled RW)";
            sw = rw;
            hw = r;
        } timing_start_pos[15:8];

        field {
            name = "start_pos";
            desc = "[inferred] Start position. (vendor header `product/hiosd/vo/hi3516a/vou_reg.h` field `start_pos`; access and reset unknown, modelled RW)";
            sw = rw;
            hw = r;
        } start_pos[7:0];
    } DHD0_START_POS @ 0xC0C0;

    reg {
        name = "DHD0 STATE";
        desc = "[inferred] DHD0 STATE. Not in the data sheet. Source: vendor U-Boot 2010.06 `product/hiosd/vo/hi3516a/vou_reg.h` (GPL-2.0 U-Boot tree, HiSilicon copyright, created 2013-04-27; mirror github.com/OpenIPC/u-boot-hi3516cv200), union `U_DHD0_STATE`, struct offset 0xC0F0 (GPL-2.0, same-chip vendor header). Reset value and access type unknown (modelled RW, no reset). Confidence: medium (vendor header for this chip family, not hardware verified).";

        field {
            name = "count_int";
            desc = "[inferred] Count interrupt. (vendor header `product/hiosd/vo/hi3516a/vou_reg.h` field `count_int`; access and reset unknown, modelled RW)";
            sw = rw;
            hw = r;
        } count_int[23:16];

        field {
            name = "vcnt";
            desc = "[inferred] Vcnt. (vendor header `product/hiosd/vo/hi3516a/vou_reg.h` field `vcnt`; access and reset unknown, modelled RW)";
            sw = rw;
            hw = r;
        } vcnt[15:3];

        field {
            name = "bottom_field";
            desc = "[inferred] Bottom field. (vendor header `product/hiosd/vo/hi3516a/vou_reg.h` field `bottom_field`; access and reset unknown, modelled RW)";
            sw = rw;
            hw = r;
        } bottom_field[2:2];

        field {
            name = "vblank";
            desc = "[inferred] Vblank. (vendor header `product/hiosd/vo/hi3516a/vou_reg.h` field `vblank`; access and reset unknown, modelled RW)";
            sw = rw;
            hw = r;
        } vblank[1:1];

        field {
            name = "vback_blank";
            desc = "[inferred] Vback blank. (vendor header `product/hiosd/vo/hi3516a/vou_reg.h` field `vback_blank`; access and reset unknown, modelled RW)";
            sw = rw;
            hw = r;
        } vback_blank[0:0];
    } DHD0_STATE @ 0xC0F0;

    reg {
        name = "DHD0 DEBUG";
        desc = "[inferred] DHD0 DEBUG. Not in the data sheet. Source: vendor U-Boot 2010.06 `product/hiosd/vo/hi3516a/vou_reg.h` (GPL-2.0 U-Boot tree, HiSilicon copyright, created 2013-04-27; mirror github.com/OpenIPC/u-boot-hi3516cv200), union `U_DHD0_DEBUG`, struct offset 0xC0F8 (GPL-2.0, same-chip vendor header). Reset value and access type unknown (modelled RW, no reset). Confidence: medium (vendor header for this chip family, not hardware verified).";

        field {
            name = "pix_src";
            desc = "[inferred] Pix source. (vendor header `product/hiosd/vo/hi3516a/vou_reg.h` field `pix_src`; access and reset unknown, modelled RW)";
            sw = rw;
            hw = r;
        } pix_src[30:28];

        field {
            name = "pix_v";
            desc = "[inferred] Pix v. (vendor header `product/hiosd/vo/hi3516a/vou_reg.h` field `pix_v`; access and reset unknown, modelled RW)";
            sw = rw;
            hw = r;
        } pix_v[27:16];

        field {
            name = "pix_h";
            desc = "[inferred] Pix h. (vendor header `product/hiosd/vo/hi3516a/vou_reg.h` field `pix_h`; access and reset unknown, modelled RW)";
            sw = rw;
            hw = r;
        } pix_h[15:0];
    } DHD0_DEBUG @ 0xC0F8;

    reg {
        name = "DHD0 DEBUG STATE";
        desc = "[inferred] DHD0 DEBUG STATE. Not in the data sheet. Source: vendor U-Boot 2010.06 `product/hiosd/vo/hi3516a/vou_reg.h` (GPL-2.0 U-Boot tree, HiSilicon copyright, created 2013-04-27; mirror github.com/OpenIPC/u-boot-hi3516cv200), union `U_DHD0_DEBUG_STATE`, struct offset 0xC0FC (GPL-2.0, same-chip vendor header). Reset value and access type unknown (modelled RW, no reset). Confidence: medium (vendor header for this chip family, not hardware verified).";

        field {
            name = "pixel_value";
            desc = "[inferred] Pixel value. (vendor header `product/hiosd/vo/hi3516a/vou_reg.h` field `pixel_value`; access and reset unknown, modelled RW)";
            sw = rw;
            hw = r;
        } pixel_value[29:0];
    } DHD0_DEBUG_STATE @ 0xC0FC;

    reg {
        name = "DSD1 global control register";
        desc = "DHD1_CTRL is a DHD1 global control register. Huawei Proprietary and Confidential Hi3516A/Hi3516D Professional HD IP Camera SoC

Data sheet 10.2.6 DHD1_CTRL (offset 0xC400, printed page 10-218, `hi3516av100--Hi3516A-Hi3516D-Datasheet.txt` line 71219).";

        enum DHD1_CTRL_intf_en_enum {
            DISABLED = 0 { name = "Disabled"; desc = "disabled"; };
            ENABLED = 1 { name = "Enabled"; desc = "enabled"; };
        };

        field {
            name = "intf_en";
            desc = "Display interface enable (instant). Data is output over the interface only when this field is enabled.";
            sw = rw;
            hw = r;
            encode = DHD1_CTRL_intf_en_enum;
            reset = 0x0;
        } intf_en[31:31];

        enum DHD1_CTRL_cbar_en_enum {
            DISABLED = 0 { name = "Disabled"; desc = "disabled"; };
            ENABLED = 1 { name = "Enabled"; desc = "enabled"; };
        };

        field {
            name = "cbar_en";
            desc = "Color bar enable. The color bar is output over the interface when this field is enabled.";
            sw = rw;
            hw = r;
            encode = DHD1_CTRL_cbar_en_enum;
            reset = 0x0;
        } cbar_en[30:30];

        enum DHD1_CTRL_cbar_sel_enum {
            VGA = 0 { name = "Vga"; desc = "VGA"; };
            YPBPR = 1 { name = "Ypbpr"; desc = "YPbPr"; };
        };

        field {
            name = "cbar_sel";
            desc = "Color space select for the output color bar (instant).";
            sw = rw;
            hw = r;
            encode = DHD1_CTRL_cbar_sel_enum;
            reset = 0x0;
        } cbar_sel[29:29];

        enum DHD1_CTRL_fpga_lmt_en_enum {
            DISABLED = 0 { name = "Disabled"; desc = "disabled"; };
            ENABLED = 1 { name = "Enabled"; desc = "enabled"; };
        };

        field {
            name = "fpga_lmt_en";
            desc = "Debug field. As the frequency of the FPGA clock bus is limited, the 1080i picture cannot be displayed. After this bit is enabled, the picture with 1280-pixel width can be displayed over the 1080i interface.";
            sw = rw;
            hw = r;
            encode = DHD1_CTRL_fpga_lmt_en_enum;
            reset = 0x0;
        } fpga_lmt_en[27:27];

        field {
            name = "fpga_lmt_width";
            desc = "Debug field. When fpga_lmt_en is enabled, the active region width of the VDP interface depends on this field. The actual width of the active region is calculated as follows: Actual width of the active region = fpga_lmt_width x 16";
            sw = rw;
            hw = r;
            reset = 0x0;
        } fpga_lmt_width[26:20];

        enum DHD1_CTRL_precharge_en_enum {
            DISABLED = 0 { name = "Disabled"; desc = "disabled"; };
            ENABLED = 1 { name = "Enabled"; desc = "enabled"; };
        };

        field {
            name = "precharge_en";
            desc = "Pre-charge enable. This field is valid when the precharge_mode field is 1 (software mode).";
            sw = rw;
            hw = r;
            encode = DHD1_CTRL_precharge_en_enum;
            reset = 0x0;
        } precharge_en[10:10];

        enum DHD1_CTRL_precharge_mode_enum {
            HARDWARE_MODE_HARDWARE = 0 { name = "Hardware Mode Hardware"; desc = "hardware mode. Hardware automatically enters the pre-charge status in the vertical blanking region."; };
            SOFTWARE_MODE_SOFTWARE = 1 { name = "Software Mode Software"; desc = "software mode. Software controls whether to enter or exit the pre-charge status."; };
        };

        field {
            name = "precharge_mode";
            desc = "Pre-charge mode of AFIFO.";
            sw = rw;
            hw = r;
            encode = DHD1_CTRL_precharge_mode_enum;
            reset = 0x0;
        } precharge_mode[9:9];

        enum DHD1_CTRL_iop_enum {
            INTERLACED_DISPLAY = 0 { name = "Interlaced Display"; desc = "interlaced display"; };
            PROGRESSIVE_DISPLAY = 1 { name = "Progressive Display"; desc = "progressive display"; };
        };

        field {
            name = "iop";
            desc = "Display mode (non-instant).";
            sw = rw;
            hw = r;
            encode = DHD1_CTRL_iop_enum;
            reset = 0x0;
        } iop[4:4];

        field {
            name = "regup";
            desc = "Surface register update. After the registers at this layer are configured, the registers are updated when the value 1 is written to this bit. After the registers are updated, this bit is automatically cleared by the hardware.";
            sw = rw;
            hw = w;
            onwrite = woclr;
            reset = 0x0;
        } regup[0:0];
    } DHD1_CTRL @ 0xC400;

    reg {
        name = "Top field vertical sync timing register in interlaced output mode or frame vertical sync timing register in progressive output mode";
        desc = "DHD1_VSYNC is a top field vertical sync timing register in interlaced output mode or frame vertical sync timing register in progressive output mode. This register is a non-instant register.

Data sheet 10.2.6 DHD1_VSYNC (offset 0xC404, printed page 10-219, `hi3516av100--Hi3516A-Hi3516D-Datasheet.txt` line 71300).";

        field {
            name = "vfb";
            desc = "In interlaced output mode: top vertical front blanking (TVFB) In progressive output mode: vertical front blanking (VFB)";
            sw = rw;
            hw = r;
            reset = 0x1;
        } vfb[27:20];

        field {
            name = "vbb";
            desc = "In interlaced output mode: top vertical back blanking (TVBB) In progressive output mode: vertical back blanking (VBB)+vertical pulse width (VPW)";
            sw = rw;
            hw = r;
            reset = 0x13;
        } vbb[19:12];

        field {
            name = "vact";
            desc = "In interlaced output mode: height of an active picture on the top field In progressive output mode: height of an active picture in a frame. The configured value is the actual value minus 1.";
            sw = rw;
            hw = r;
            reset = 0x21B;
        } vact[11:0];
    } DHD1_VSYNC @ 0xC404;

    reg {
        name = "Horizontal sync configuration register in interlaced or progressive output mode";
        desc = "DHD1_HSYNC1 is a horizontal sync configuration register in interlaced or progressive output mode (non-instant register).

Data sheet 10.2.6 DHD1_HSYNC1 (offset 0xC408, printed page 10-220, `hi3516av100--Hi3516A-Hi3516D-Datasheet.txt` line 71336).";

        field {
            name = "hbb";
            desc = "Horizontal back blanking (HBB), in pixel.";
            sw = rw;
            hw = r;
            reset = 0xBF;
        } hbb[31:16];

        field {
            name = "hact";
            desc = "Number of horizontal pixels in an active region.";
            sw = rw;
            hw = r;
            reset = 0x77F;
        } hact[15:0];
    } DHD1_HSYNC1 @ 0xC408;

    reg {
        name = "Horizontal sync configuration register in interlaced or progressive output mode (non-instant register)";
        desc = "DHD1_HSYNC2 is a horizontal sync configuration register in interlaced or progressive output mode (non-instant register).

Data sheet 10.2.6 DHD1_HSYNC2 (offset 0xC40C, printed page 10-220, `hi3516av100--Hi3516A-Hi3516D-Datasheet.txt` line 71356).";

        field {
            name = "hmid";
            desc = "Bottom vertical sync active pixel (active region).";
            sw = rw;
            hw = r;
            reset = 0x0;
        } hmid[31:16];

        field {
            name = "hfb";
            desc = "HFB, in pixel.";
            sw = rw;
            hw = r;
            reset = 0x20F;
        } hfb[15:0];
    } DHD1_HSYNC2 @ 0xC40C;

    reg {
        name = "Bottom field vertical sync timing register in interlaced output mode (non-instant register)";
        desc = "DHD1_VPLUS is a bottom field vertical sync timing in interlaced output mode (non-instant register). Huawei Proprietary and Confidential Hi3516A/Hi3516D Professional HD IP Camera SoC

Data sheet 10.2.6 DHD1_VPLUS (offset 0xC410, printed page 10-221, `hi3516av100--Hi3516A-Hi3516D-Datasheet.txt` line 71386).";

        field {
            name = "bvfb";
            desc = "Bottom vertical front blanking (BVFB) in interlaced output mode.";
            sw = rw;
            hw = r;
            reset = 0x2;
        } bvfb[27:20];

        field {
            name = "bvbb";
            desc = "Bottom vertical back blanking (BVBB)+VPW in interlaced output mode.";
            sw = rw;
            hw = r;
            reset = 0x13;
        } bvbb[19:12];

        field {
            name = "bvact";
            desc = "Height of an active picture in the bottom field in interlaced output mode. The configured value is the actual value minus 1.";
            sw = rw;
            hw = r;
            reset = 0x21B;
        } bvact[11:0];
    } DHD1_VPLUS @ 0xC410;

    reg {
        name = "Sync signal pulse width register (non- instant register)";
        desc = "DHD1_PWR is a sync signal pulse width register (non-instant register).

Data sheet 10.2.6 DHD1_PWR (offset 0xC414, printed page 10-221, `hi3516av100--Hi3516A-Hi3516D-Datasheet.txt` line 71411).";

        field {
            name = "vpw";
            desc = "VPW. The configured value is the actual value minus 1.";
            sw = rw;
            hw = r;
            reset = 0x0;
        } vpw[23:16];

        field {
            name = "hpw";
            desc = "Horizontal pulse width (HPW). The configured value is the actual value minus 1.";
            sw = rw;
            hw = r;
            reset = 0x0;
        } hpw[15:0];
    } DHD1_PWR @ 0xC414;

    reg {
        name = "Vertical timing threshold register (instant register)";
        desc = "DHD1_VTTHD3 is a vertical timing threshold register (instant register). It can be used to set two thresholds for generating two interrupts separately. Huawei Proprietary and Confidential Hi3516A/Hi3516D Professional HD IP Camera SoC

Data sheet 10.2.6 DHD1_VTTHD3 (offset 0xC418, printed page 10-222, `hi3516av100--Hi3516A-Hi3516D-Datasheet.txt` line 71444).";

        enum DHD1_VTTHD3_thd4_mode_enum {
            FRAME_MODE_THRESHOLD = 0 { name = "Frame Mode Threshold"; desc = "frame mode. The threshold count is by frame."; };
            FIELD_MODE_THRESHOLD = 1 { name = "Field Mode Threshold"; desc = "field mode. The threshold count is by field during interlaced displaying."; };
        };

        field {
            name = "thd4_mode";
            desc = "Mode of generating threshold 4.";
            sw = rw;
            hw = r;
            encode = DHD1_VTTHD3_thd4_mode_enum;
            reset = 0x0;
        } thd4_mode[31:31];

        field {
            name = "vtmgthd4";
            desc = "Vertical timing threshold 4 for simultaneously triggering DHD and DSD. The start time of the DSD interface timing is later than that of the DHD interface timing and is equal to the number of lines configured in vtmgthd4.";
            sw = rw;
            hw = r;
            reset = 0x0;
        } vtmgthd4[28:16];

        enum DHD1_VTTHD3_thd3_mode_enum {
            FRAME_MODE_THRESHOLD = 0 { name = "Frame Mode Threshold"; desc = "frame mode. The threshold count is by frame."; };
            FIELD_MODE_THRESHOLD = 1 { name = "Field Mode Threshold"; desc = "field mode. The threshold count is by field during interlaced displaying."; };
        };

        field {
            name = "thd3_mode";
            desc = "Mode of generating threshold 3.";
            sw = rw;
            hw = r;
            encode = DHD1_VTTHD3_thd3_mode_enum;
            reset = 0x0;
        } thd3_mode[15:15];

        field {
            name = "vtmgthd3";
            desc = "Vertical timing threshold 3. When the vertical timing counter reaches this threshold, the VOINTSTA[dhdvtthd3_int] interrupt is triggered.";
            sw = rw;
            hw = r;
            reset = 0x0;
        } vtmgthd3[12:0];
    } DHD1_VTTHD3 @ 0xC418;

    reg {
        name = "Vertical timing threshold register (instant register)";
        desc = "DHD1_VTTHD is a vertical timing threshold register (instant register). It can be used to set two thresholds for generating two interrupts separately. Huawei Proprietary and Confidential Hi3516A/Hi3516D Professional HD IP Camera SoC

Data sheet 10.2.6 DHD1_VTTHD (offset 0xC41C, printed page 10-223, `hi3516av100--Hi3516A-Hi3516D-Datasheet.txt` line 71498).";

        enum DHD1_VTTHD_thd2_mode_enum {
            FRAME_MODE_THRESHOLD = 0 { name = "Frame Mode Threshold"; desc = "frame mode. The threshold count is by frame."; };
            FIELD_MODE_THRESHOLD = 1 { name = "Field Mode Threshold"; desc = "field mode. The threshold count is by field during interlaced displaying."; };
        };

        field {
            name = "thd2_mode";
            desc = "Mode of generating threshold 2.";
            sw = rw;
            hw = r;
            encode = DHD1_VTTHD_thd2_mode_enum;
            reset = 0x0;
        } thd2_mode[31:31];

        field {
            name = "vtmgthd2";
            desc = "Vertical timing threshold 2. When the vertical timing counter reaches this threshold, the VOINTSTA[dhdvtthd2_int] interrupt is triggered.";
            sw = rw;
            hw = r;
            reset = 0x1;
        } vtmgthd2[28:16];

        enum DHD1_VTTHD_thd1_mode_enum {
            FRAME_MODE_THRESHOLD = 0 { name = "Frame Mode Threshold"; desc = "frame mode. The threshold count is by frame."; };
            FIELD_MODE_THRESHOLD = 1 { name = "Field Mode Threshold"; desc = "field mode. The threshold count is by field during interlaced displaying."; };
        };

        field {
            name = "thd1_mode";
            desc = "Mode of generating threshold 1.";
            sw = rw;
            hw = r;
            encode = DHD1_VTTHD_thd1_mode_enum;
            reset = 0x0;
        } thd1_mode[15:15];

        field {
            name = "vtmgthd1";
            desc = "Vertical timing threshold 1. When the vertical timing counter reaches this threshold, the VOINTSTA[dhdvtthd_int1] interrupt is triggered.";
            sw = rw;
            hw = r;
            reset = 0x1;
        } vtmgthd1[12:0];
    } DHD1_VTTHD @ 0xC41C;

    reg {
        name = "PARA coefficient update pointer threshold register";
        desc = "DHD1_PARATHDis a PARA coefficient update point threshold register. Huawei Proprietary and Confidential Hi3516A/Hi3516D Professional HD IP Camera SoC

Data sheet 10.2.6 DHD1_PARATHD (offset 0xC4B0, printed page 10-224, `hi3516av100--Hi3516A-Hi3516D-Datasheet.txt` line 71549).";

        enum DHD1_PARATHD_dfs_en_enum {
            DISABLED = 0 { name = "Disabled"; desc = "disabled"; };
            ENABLED = 1 { name = "Enabled"; desc = "enabled"; };
        };

        field {
            name = "dfs_en";
            desc = "DFS enable.";
            sw = rw;
            hw = r;
            encode = DHD1_PARATHD_dfs_en_enum;
            reset = 0x0;
        } dfs_en[31:31];

        field {
            name = "para_thd";
            desc = "PARA coefficient update point threshold. It indicates the line after the vertical back blanking where the update point occurs. This field is valid only after DFS is enabled.";
            sw = rw;
            hw = r;
            reset = 0x0;
        } para_thd[5:0];
    } DHD1_PARATHD @ 0xC4B0;

    reg {
        name = "DHD1 start signal start position register";
        desc = "DHD1_START_POS is a DHD1 start signal start position register.

Data sheet 10.2.6 DHD1_START_POS (offset 0xC4C0, printed page 10-224, `hi3516av100--Hi3516A-Hi3516D-Datasheet.txt` line 71575).";

        field {
            name = "timing_start_pos";
            desc = "Number of lines before the active region where the timing_gen state machine starts to work.";
            sw = rw;
            hw = r;
            reset = 0x8;
        } timing_start_pos[15:8];

        field {
            name = "start_pos";
            desc = "Number of lines before the active region where the start signal is generated in online mode.";
            sw = rw;
            hw = r;
            reset = 0x5;
        } start_pos[7:0];
    } DHD1_START_POS @ 0xC4C0;

    reg {
        name = "DHD1 status register";
        desc = "DHD1_STATE is a DHD1 status register. Huawei Proprietary and Confidential Hi3516A/Hi3516D Professional HD IP Camera SoC

Data sheet 10.2.6 DHD1_STATE (offset 0xC4F0, printed page 10-225, `hi3516av100--Hi3516A-Hi3516D-Datasheet.txt` line 71609).";

        field {
            name = "count_int";
            desc = "DHD1 interrupt count. The count value is increased by 1 each time a vertical timing interrupt is reported.";
            sw = r;
            hw = w;
            reset = 0x0;
        } count_int[23:16];

        field {
            name = "vcnt";
            desc = "Active display line count of DHD1.";
            sw = r;
            hw = w;
            reset = 0x0;
        } vcnt[15:3];

        enum DHD1_STATE_bottom_field_enum {
            TOP_FIELD = 0 { name = "Top Field"; desc = "top field"; };
            BOTTOM_FIELD = 1 { name = "Bottom Field"; desc = "bottom field"; };
        };

        field {
            name = "bottom_field";
            desc = "DHD1 top/bottom field indicator";
            sw = r;
            hw = w;
            encode = DHD1_STATE_bottom_field_enum;
            reset = 0x1;
        } bottom_field[2:2];

        enum DHD1_STATE_vblank_enum {
            ACTIVE_REGION = 0 { name = "Active Region"; desc = "active region"; };
            BLANKING_REGION = 1 { name = "Blanking Region"; desc = "blanking region"; };
        };

        field {
            name = "vblank";
            desc = "DHD1 blanking region indicator.";
            sw = r;
            hw = w;
            encode = DHD1_STATE_vblank_enum;
            reset = 0x1;
        } vblank[1:1];

        enum DHD1_STATE_vback_blank_enum {
            NON_BACK_BLANKING = 0 { name = "Non Back Blanking"; desc = "non-back blanking region"; };
            BLANKING_REGION = 1 { name = "Blanking Region"; desc = "blanking region"; };
        };

        field {
            name = "vback_blank";
            desc = "DHD1 back blanking region indicator.";
            sw = r;
            hw = w;
            encode = DHD1_STATE_vback_blank_enum;
            reset = 0x0;
        } vback_blank[0:0];
    } DHD1_STATE @ 0xC4F0;

    reg {
        name = "BT control D000";
        desc = "[inferred] BT control D000. Not in the data sheet. Source: vendor U-Boot 2010.06 `product/hiosd/vo/hi3516a/vou_reg.h` (GPL-2.0 U-Boot tree, HiSilicon copyright, created 2013-04-27; mirror github.com/OpenIPC/u-boot-hi3516cv200), union `U_BT_CTRL`, struct offset 0xD000 (GPL-2.0, same-chip vendor header). Reset value and access type unknown (modelled RW, no reset). Confidence: medium (vendor header for this chip family, not hardware verified).";

        field {
            name = "bt1120_bypass";
            desc = "[inferred] Bt1120 bypass. (vendor header `product/hiosd/vo/hi3516a/vou_reg.h` field `bt1120_bypass`; access and reset unknown, modelled RW)";
            sw = rw;
            hw = r;
        } bt1120_bypass[30:30];
    } BT_CTRL_D000 @ 0xD000;

    reg {
        name = "INTF SYNC invert";
        desc = "[inferred] INTF SYNC invert. Not in the data sheet. Source: vendor U-Boot 2010.06 `product/hiosd/vo/hi3516a/vou_reg.h` (GPL-2.0 U-Boot tree, HiSilicon copyright, created 2013-04-27; mirror github.com/OpenIPC/u-boot-hi3516cv200), union `U_INTF_SYNC_INV`, struct offset 0xD008 (GPL-2.0, same-chip vendor header). Reset value and access type unknown (modelled RW, no reset). Confidence: medium (vendor header for this chip family, not hardware verified).";

        field {
            name = "f_inv";
            desc = "[inferred] F invert. (vendor header `product/hiosd/vo/hi3516a/vou_reg.h` field `f_inv`; access and reset unknown, modelled RW)";
            sw = rw;
            hw = r;
        } f_inv[3:3];

        field {
            name = "vs_inv";
            desc = "[inferred] Vertical sync invert. (vendor header `product/hiosd/vo/hi3516a/vou_reg.h` field `vs_inv`; access and reset unknown, modelled RW)";
            sw = rw;
            hw = r;
        } vs_inv[2:2];

        field {
            name = "hs_inv";
            desc = "[inferred] Horizontal sync invert. (vendor header `product/hiosd/vo/hi3516a/vou_reg.h` field `hs_inv`; access and reset unknown, modelled RW)";
            sw = rw;
            hw = r;
        } hs_inv[1:1];

        field {
            name = "dv_inv";
            desc = "[inferred] Dv invert. (vendor header `product/hiosd/vo/hi3516a/vou_reg.h` field `dv_inv`; access and reset unknown, modelled RW)";
            sw = rw;
            hw = r;
        } dv_inv[0:0];
    } INTF_SYNC_INV @ 0xD008;

    reg {
        name = "INTF CLIP0 L";
        desc = "[inferred] INTF CLIP0 L. Not in the data sheet. Source: vendor U-Boot 2010.06 `product/hiosd/vo/hi3516a/vou_reg.h` (GPL-2.0 U-Boot tree, HiSilicon copyright, created 2013-04-27; mirror github.com/OpenIPC/u-boot-hi3516cv200), union `U_INTF_CLIP0_L`, struct offset 0xD010 (GPL-2.0, same-chip vendor header). Reset value and access type unknown (modelled RW, no reset). Confidence: medium (vendor header for this chip family, not hardware verified).";

        field {
            name = "clip_cl2";
            desc = "[inferred] Clip cl2. (vendor header `product/hiosd/vo/hi3516a/vou_reg.h` field `clip_cl2`; access and reset unknown, modelled RW)";
            sw = rw;
            hw = r;
        } clip_cl2[29:20];

        field {
            name = "clip_cl1";
            desc = "[inferred] Clip cl1. (vendor header `product/hiosd/vo/hi3516a/vou_reg.h` field `clip_cl1`; access and reset unknown, modelled RW)";
            sw = rw;
            hw = r;
        } clip_cl1[19:10];

        field {
            name = "clip_cl0";
            desc = "[inferred] Clip cl0. (vendor header `product/hiosd/vo/hi3516a/vou_reg.h` field `clip_cl0`; access and reset unknown, modelled RW)";
            sw = rw;
            hw = r;
        } clip_cl0[9:0];
    } INTF_CLIP0_L @ 0xD010;

    reg {
        name = "INTF CLIP0 H";
        desc = "[inferred] INTF CLIP0 H. Not in the data sheet. Source: vendor U-Boot 2010.06 `product/hiosd/vo/hi3516a/vou_reg.h` (GPL-2.0 U-Boot tree, HiSilicon copyright, created 2013-04-27; mirror github.com/OpenIPC/u-boot-hi3516cv200), union `U_INTF_CLIP0_H`, struct offset 0xD014 (GPL-2.0, same-chip vendor header). Reset value and access type unknown (modelled RW, no reset). Confidence: medium (vendor header for this chip family, not hardware verified).";

        field {
            name = "clip_ch2";
            desc = "[inferred] Clip ch2. (vendor header `product/hiosd/vo/hi3516a/vou_reg.h` field `clip_ch2`; access and reset unknown, modelled RW)";
            sw = rw;
            hw = r;
        } clip_ch2[29:20];

        field {
            name = "clip_ch1";
            desc = "[inferred] Clip ch1. (vendor header `product/hiosd/vo/hi3516a/vou_reg.h` field `clip_ch1`; access and reset unknown, modelled RW)";
            sw = rw;
            hw = r;
        } clip_ch1[19:10];

        field {
            name = "clip_ch0";
            desc = "[inferred] Clip ch0. (vendor header `product/hiosd/vo/hi3516a/vou_reg.h` field `clip_ch0`; access and reset unknown, modelled RW)";
            sw = rw;
            hw = r;
        } clip_ch0[9:0];
    } INTF_CLIP0_H @ 0xD014;

    reg {
        name = "INTF DITHER0 control";
        desc = "[inferred] INTF DITHER0 control. Not in the data sheet. Source: vendor U-Boot 2010.06 `product/hiosd/vo/hi3516a/vou_reg.h` (GPL-2.0 U-Boot tree, HiSilicon copyright, created 2013-04-27; mirror github.com/OpenIPC/u-boot-hi3516cv200), union `U_INTF_DITHER0_CTRL`, struct offset 0xD080 (GPL-2.0, same-chip vendor header). Reset value and access type unknown (modelled RW, no reset). Confidence: medium (vendor header for this chip family, not hardware verified).";

        field {
            name = "dither_md";
            desc = "[inferred] Dither md. (vendor header `product/hiosd/vo/hi3516a/vou_reg.h` field `dither_md`; access and reset unknown, modelled RW)";
            sw = rw;
            hw = r;
        } dither_md[31:29];
    } INTF_DITHER0_CTRL @ 0xD080;

    reg {
        name = "INTF DITHER0 COEF0";
        desc = "[inferred] INTF DITHER0 COEF0. Not in the data sheet. Source: vendor U-Boot 2010.06 `product/hiosd/vo/hi3516a/vou_reg.h` (GPL-2.0 U-Boot tree, HiSilicon copyright, created 2013-04-27; mirror github.com/OpenIPC/u-boot-hi3516cv200), union `U_INTF_DITHER0_COEF0`, struct offset 0xD084 (GPL-2.0, same-chip vendor header). Reset value and access type unknown (modelled RW, no reset). Confidence: medium (vendor header for this chip family, not hardware verified).";

        field {
            name = "dither_coef3";
            desc = "[inferred] Dither coef3. (vendor header `product/hiosd/vo/hi3516a/vou_reg.h` field `dither_coef3`; access and reset unknown, modelled RW)";
            sw = rw;
            hw = r;
        } dither_coef3[31:24];

        field {
            name = "dither_coef2";
            desc = "[inferred] Dither coef2. (vendor header `product/hiosd/vo/hi3516a/vou_reg.h` field `dither_coef2`; access and reset unknown, modelled RW)";
            sw = rw;
            hw = r;
        } dither_coef2[23:16];

        field {
            name = "dither_coef1";
            desc = "[inferred] Dither coef1. (vendor header `product/hiosd/vo/hi3516a/vou_reg.h` field `dither_coef1`; access and reset unknown, modelled RW)";
            sw = rw;
            hw = r;
        } dither_coef1[15:8];

        field {
            name = "dither_coef0";
            desc = "[inferred] Dither coef0. (vendor header `product/hiosd/vo/hi3516a/vou_reg.h` field `dither_coef0`; access and reset unknown, modelled RW)";
            sw = rw;
            hw = r;
        } dither_coef0[7:0];
    } INTF_DITHER0_COEF0 @ 0xD084;

    reg {
        name = "INTF DITHER0 COEF1";
        desc = "[inferred] INTF DITHER0 COEF1. Not in the data sheet. Source: vendor U-Boot 2010.06 `product/hiosd/vo/hi3516a/vou_reg.h` (GPL-2.0 U-Boot tree, HiSilicon copyright, created 2013-04-27; mirror github.com/OpenIPC/u-boot-hi3516cv200), union `U_INTF_DITHER0_COEF1`, struct offset 0xD088 (GPL-2.0, same-chip vendor header). Reset value and access type unknown (modelled RW, no reset). Confidence: medium (vendor header for this chip family, not hardware verified).";

        field {
            name = "dither_coef7";
            desc = "[inferred] Dither coef7. (vendor header `product/hiosd/vo/hi3516a/vou_reg.h` field `dither_coef7`; access and reset unknown, modelled RW)";
            sw = rw;
            hw = r;
        } dither_coef7[31:24];

        field {
            name = "dither_coef6";
            desc = "[inferred] Dither coef6. (vendor header `product/hiosd/vo/hi3516a/vou_reg.h` field `dither_coef6`; access and reset unknown, modelled RW)";
            sw = rw;
            hw = r;
        } dither_coef6[23:16];

        field {
            name = "dither_coef5";
            desc = "[inferred] Dither coef5. (vendor header `product/hiosd/vo/hi3516a/vou_reg.h` field `dither_coef5`; access and reset unknown, modelled RW)";
            sw = rw;
            hw = r;
        } dither_coef5[15:8];

        field {
            name = "dither_coef4";
            desc = "[inferred] Dither coef4. (vendor header `product/hiosd/vo/hi3516a/vou_reg.h` field `dither_coef4`; access and reset unknown, modelled RW)";
            sw = rw;
            hw = r;
        } dither_coef4[7:0];
    } INTF_DITHER0_COEF1 @ 0xD088;

    reg {
        name = "BT.656/BT.1120 control register";
        desc = "BT_CTRL is a BT.656/BT.1120 control register. Huawei Proprietary and Confidential Hi3516A/Hi3516D Professional HD IP Camera SoC

Data sheet 10.2.6 BT_CTRL (offset 0xD200, printed page 10-226, `hi3516av100--Hi3516A-Hi3516D-Datasheet.txt` line 71656).";

        enum BT_CTRL_bt1120_bypass_enum {
            DISABLED = 0 { name = "Disabled"; desc = "disabled"; };
            ENABLED = 1 { name = "Enabled"; desc = "enabled"; };
        };

        field {
            name = "bt1120_bypass";
            desc = "BT.1120 bypass enable (valid only for the BT.1120 interface).";
            sw = rw;
            hw = r;
            encode = BT_CTRL_bt1120_bypass_enum;
            reset = 0x0;
        } bt1120_bypass[30:30];
    } BT_CTRL @ 0xD200;

    reg {
        name = "BT.656/BT.1120 clip lowest threshold register (instant register)";
        desc = "BT_CLIP0_L is a BT.656/BT.1120 clip lowest threshold register (instant register).

Data sheet 10.2.6 BT_CLIP0_L (offset 0xD210, printed page 10-226, `hi3516av100--Hi3516A-Hi3516D-Datasheet.txt` line 71685).";

        field {
            name = "clip_cl2";
            desc = "Lowest threshold Y/R of component 2, unsigned integer.";
            sw = rw;
            hw = r;
            reset = 0x10;
        } clip_cl2[29:20];

        field {
            name = "clip_cl1";
            desc = "Lowest threshold Cb/G of component 1, unsigned integer.";
            sw = rw;
            hw = r;
            reset = 0x10;
        } clip_cl1[19:10];

        field {
            name = "clip_cl0";
            desc = "Lowest threshold Cr/B of component 0, unsigned integer.";
            sw = rw;
            hw = r;
            reset = 0x10;
        } clip_cl0[9:0];
    } BT_CLIP0_L @ 0xD210;

    reg {
        name = "BT.656/BT.1120 clip highest threshold register (instant register)";
        desc = "BT_CLIP0_H is a BT.656/BT.1120 clip highest threshold register (instant register). For example, the output data needs to be clipped in BT.656 output mode.

Data sheet 10.2.6 BT_CLIP0_H (offset 0xD214, printed page 10-227, `hi3516av100--Hi3516A-Hi3516D-Datasheet.txt` line 71717).";

        field {
            name = "clip_ch2";
            desc = "Highest threshold Y/R of component 2, unsigned integer.";
            sw = rw;
            hw = r;
            reset = 0xEB;
        } clip_ch2[29:20];

        field {
            name = "clip_ch1";
            desc = "Highest threshold Cb/G of component 1, unsigned integer.";
            sw = rw;
            hw = r;
            reset = 0xF0;
        } clip_ch1[19:10];

        field {
            name = "clip_ch0";
            desc = "Highest threshold Cr/B of component 0, unsigned integer.";
            sw = rw;
            hw = r;
            reset = 0xF0;
        } clip_ch0[9:0];
    } BT_CLIP0_H @ 0xD214;

    reg {
        name = "BT.656/BT.1120 dither control register L";
        desc = "BT_DITHER0_CTRL is a BT.656/BT.1120 dither control register. Huawei Proprietary and Confidential Hi3516A/Hi3516D Professional HD IP Camera SoC

Data sheet 10.2.6 BT_DITHER0_CTRL (offset 0xD280, printed page 10-228, `hi3516av100--Hi3516A-Hi3516D-Datasheet.txt` line 71750).";

        enum BT_DITHER0_CTRL_dither_md_enum {
            V_12_BIT_INPUTS = 0 { name = "V 12 Bit Inputs"; desc = "12-bit inputs, 10-bit outputs, no dithering, and direct bit truncation"; };
            V_12_BIT_INPUTS_2 = 1 { name = "V 12 Bit Inputs 2"; desc = "12-bit inputs, 10-bit outputs, and time-domain dithering"; };
            V_12_BIT_INPUTS_3 = 2 { name = "V 12 Bit Inputs 3"; desc = "12-bit inputs, 10-bit outputs, and spatial-domain dithering"; };
            V_12_BIT_INPUTS_4 = 3 { name = "V 12 Bit Inputs 4"; desc = "12-bit inputs, 8-bit outputs, and time-domain and spatial- domain dithering"; };
            V_12_BIT_INPUTS_5 = 4 { name = "V 12 Bit Inputs 5"; desc = "12-bit inputs, 10-bit outputs, and round off"; };
            V_12_BIT_INPUTS_6 = 5 { name = "V 12 Bit Inputs 6"; desc = "12-bit inputs, 8-bit outputs, and round off Other values: reserved"; };
        };

        field {
            name = "dither_md";
            desc = "Dither mode select.";
            sw = rw;
            hw = r;
            encode = BT_DITHER0_CTRL_dither_md_enum;
            reset = 0x1;
        } dither_md[31:29];
    } BT_DITHER0_CTRL @ 0xD280;

    reg {
        name = "BT.656/BT.1120 dither coefficient 0 F0 register";
        desc = "BT_DITHER0_COEF0 is BT.656/BT.1120 dither coefficient register 0.

Data sheet 10.2.6 BT_DITHER0_COEF0 (offset 0xD284, printed page 10-228, `hi3516av100--Hi3516A-Hi3516D-Datasheet.txt` line 71785).";

        field {
            name = "dither_coef3";
            desc = "Coefficient 3 for time-domain dithering.";
            sw = rw;
            hw = r;
            reset = 0xDD;
        } dither_coef3[31:24];

        field {
            name = "dither_coef2";
            desc = "Coefficient 2 for time-domain dithering.";
            sw = rw;
            hw = r;
            reset = 0x66;
        } dither_coef2[23:16];

        field {
            name = "dither_coef1";
            desc = "Coefficient 1 for time-domain dithering.";
            sw = rw;
            hw = r;
            reset = 0x44;
        } dither_coef1[15:8];

        field {
            name = "dither_coef0";
            desc = "Coefficient 0 for time-domain dithering.";
            sw = rw;
            hw = r;
            reset = 0x0;
        } dither_coef0[7:0];
    } BT_DITHER0_COEF0 @ 0xD284;

    reg {
        name = "BT.656/BT.1120 dither coefficient 1 F1 register";
        desc = "BT_DITHER0_COEF1 is BT.656/BT.1120 dither coefficient register 1.

Data sheet 10.2.6 BT_DITHER0_COEF1 (offset 0xD288, printed page 10-229, `hi3516av100--Hi3516A-Hi3516D-Datasheet.txt` line 71812).";

        field {
            name = "dither_coef7";
            desc = "Coefficient 7 for time-domain dithering.";
            sw = rw;
            hw = r;
            reset = 0xDD;
        } dither_coef7[31:24];

        field {
            name = "dither_coef6";
            desc = "Coefficient 6 for time-domain dithering.";
            sw = rw;
            hw = r;
            reset = 0x66;
        } dither_coef6[23:16];

        field {
            name = "dither_coef5";
            desc = "Coefficient 5 for time-domain dithering.";
            sw = rw;
            hw = r;
            reset = 0x44;
        } dither_coef5[15:8];

        field {
            name = "dither_coef4";
            desc = "Coefficient 4 for time-domain dithering.";
            sw = rw;
            hw = r;
            reset = 0x0;
        } dither_coef4[7:0];
    } BT_DITHER0_COEF1 @ 0xD288;

    reg {
        name = "Sync signal polarity configuration register in DATE external sync timing input mode";
        desc = "DATE_SYNC_INV is a sync signal polarity configuration register in DATE external sync timing input mode. The setting of this register takes effect immediately after configuration, that is, the polarity of the corresponding sync signal is immediately affected.

Data sheet 10.2.6 DATE_SYNC_INV (offset 0xD308, printed page 10-229, `hi3516av100--Hi3516A-Hi3516D-Datasheet.txt` line 71835).";

        enum DATE_SYNC_INV_f_inv_enum {
            DISABLED = 0 { name = "Disabled"; desc = "disabled"; };
            ENABLED = 1 { name = "Enabled"; desc = "enabled"; };
        };

        field {
            name = "f_inv";
            desc = "Output phase inversion enable for the odd/even field indicator signal (instant).";
            sw = rw;
            hw = r;
            encode = DATE_SYNC_INV_f_inv_enum;
            reset = 0x0;
        } f_inv[3:3];

        enum DATE_SYNC_INV_vs_inv_enum {
            DISABLED = 0 { name = "Disabled"; desc = "disabled"; };
            ENABLED = 1 { name = "Enabled"; desc = "enabled"; };
        };

        field {
            name = "vs_inv";
            desc = "Output phase inversion enable for the vertical sync pulse (instant).";
            sw = rw;
            hw = r;
            encode = DATE_SYNC_INV_vs_inv_enum;
            reset = 0x0;
        } vs_inv[2:2];

        enum DATE_SYNC_INV_hs_inv_enum {
            DISABLED = 0 { name = "Disabled"; desc = "disabled"; };
            ENABLED = 1 { name = "Enabled"; desc = "enabled"; };
        };

        field {
            name = "hs_inv";
            desc = "Output phase inversion enable for the horizontal sync pulse (instant).";
            sw = rw;
            hw = r;
            encode = DATE_SYNC_INV_hs_inv_enum;
            reset = 0x0;
        } hs_inv[1:1];

        enum DATE_SYNC_INV_dv_inv_enum {
            DISABLED = 0 { name = "Disabled"; desc = "disabled"; };
            ENABLED = 1 { name = "Enabled"; desc = "enabled"; };
        };

        field {
            name = "dv_inv";
            desc = "Output phase inversion enable for the data valid signal (instant).";
            sw = rw;
            hw = r;
            encode = DATE_SYNC_INV_dv_inv_enum;
            reset = 0x0;
        } dv_inv[0:0];
    } DATE_SYNC_INV @ 0xD308;

    reg {
        name = "DATE clip lowest threshold register (instant register)";
        desc = "DATE_CLIP0_L is a DATE clip lowest threshold register (instant register).

Data sheet 10.2.6 DATE_CLIP0_L (offset 0xD310, printed page 10-230, `hi3516av100--Hi3516A-Hi3516D-Datasheet.txt` line 71882).";

        field {
            name = "clip_cl2";
            desc = "Lowest threshold Y/R of component 2, unsigned integer.";
            sw = rw;
            hw = r;
            reset = 0x10;
        } clip_cl2[29:20];

        field {
            name = "clip_cl1";
            desc = "Lowest threshold Cb/G of component 1, unsigned integer.";
            sw = rw;
            hw = r;
            reset = 0x10;
        } clip_cl1[19:10];

        field {
            name = "clip_cl0";
            desc = "Lowest threshold Cr/B of component 0, unsigned integer.";
            sw = rw;
            hw = r;
            reset = 0x10;
        } clip_cl0[9:0];
    } DATE_CLIP0_L @ 0xD310;

    reg {
        name = "DATE clip highest threshold register (instant register)";
        desc = "DATE_CLIP0_H is a DATE clip highest threshold register (instant register). For example, the output data needs to be clipped in BT.656 output mode. Huawei Proprietary and Confidential Hi3516A/Hi3516D Professional HD IP Camera SoC

Data sheet 10.2.6 DATE_CLIP0_H (offset 0xD314, printed page 10-231, `hi3516av100--Hi3516A-Hi3516D-Datasheet.txt` line 71918).";

        field {
            name = "clip_ch2";
            desc = "Highest threshold Y/R of component 2, unsigned integer.";
            sw = rw;
            hw = r;
            reset = 0xEB;
        } clip_ch2[29:20];

        field {
            name = "clip_ch1";
            desc = "Highest threshold Cb/G of component 1, unsigned integer.";
            sw = rw;
            hw = r;
            reset = 0xF0;
        } clip_ch1[19:10];

        field {
            name = "clip_ch0";
            desc = "Highest threshold Cr/B of component 0, unsigned integer.";
            sw = rw;
            hw = r;
            reset = 0xF0;
        } clip_ch0[9:0];
    } DATE_CLIP0_H @ 0xD314;

    reg {
        name = "Standard parameter configuration register";
        desc = "DATE_COEFF0 is a standard parameter configuration register.

Data sheet 10.2.6 DATE_COEFF0 (offset 0xF200, printed page 10-231, `hi3516av100--Hi3516A-Hi3516D-Datasheet.txt` line 71941).";

        enum DATE_COEFF0_clpf_sel_enum {
            V_1_1_MHZ = 0 { name = "V 1 1 Mhz"; desc = "1.1 MHz (NTSC)"; };
            V_1_3_MHZ = 1 { name = "V 1 3 Mhz"; desc = "1.3 MHz (PAL)"; };
            V_1_6_MHZ = 2 { name = "V 1 6 Mhz"; desc = "1.6 MHz (for test)"; };
            RESERVED = 3 { name = "Reserved"; desc = "reserved"; };
        };

        field {
            name = "clpf_sel";
            desc = "Bandwidth of the chrominance low-pass filter.";
            sw = rw;
            hw = r;
            encode = DATE_COEFF0_clpf_sel_enum;
            reset = 0x1;
        } clpf_sel[31:30];

        enum DATE_COEFF0_dis_ire_enum {
            BLACK_LEVEL_7 = 0 { name = "Black Level 7"; desc = "The black level is 7.5 IRE higher than the blanking level."; };
            BLACK_LEVEL_EQUAL = 1 { name = "Black Level Equal"; desc = "The black level is equal to the blanking level."; };
        };

        field {
            name = "dis_ire";
            desc = "For the (M) NTSC and (M, N) PAL standards, the black level is 7.5 IRE higher than the blanking level; for other standards, the black level is equal to the blanking level. This bit controls whether the black level is 7.5 IRE higher than the blanking level.";
            sw = rw;
            hw = r;
            encode = DATE_COEFF0_dis_ire_enum;
            reset = 0x0;
        } dis_ire[29:29];

        enum DATE_COEFF0_pal_half_en_enum {
            DISABLED = 0 { name = "Disabled"; desc = "disabled"; };
            ENABLED = 1 { name = "Enabled"; desc = "enabled"; };
        };

        field {
            name = "pal_half_en";
            desc = "PAL half line reduction enable.";
            sw = rw;
            hw = r;
            encode = DATE_COEFF0_pal_half_en_enum;
            reset = 0x0;
        } pal_half_en[27:27];

        enum DATE_COEFF0_pbpr_lpf_en_enum {
            DISABLED = 0 { name = "Disabled"; desc = "disabled"; };
            ENABLED = 1 { name = "Enabled"; desc = "enabled"; };
        };

        field {
            name = "pbpr_lpf_en";
            desc = "Component chrominance low-pass filtering enable.";
            sw = rw;
            hw = r;
            encode = DATE_COEFF0_pbpr_lpf_en_enum;
            reset = 0x0;
        } pbpr_lpf_en[26:26];

        enum DATE_COEFF0_scanline_enum {
            V_525_LINES_FRAME = 0 { name = "V 525 Lines Frame"; desc = "525 lines in a frame"; };
            V_625_LINES_FRAME = 1 { name = "V 625 Lines Frame"; desc = "625 lines in a frame"; };
        };

        field {
            name = "scanline";
            desc = "Number of scanned lines in each frame based on standards. For the (M) NTSC, NTSC-J, and (M) PAL standards, each line contains 525 lines; for the (B, D, J, H, I) PAL, (N) PAL, and (Nc) PAL standards, each frame contains 625 lines.";
            sw = rw;
            hw = r;
            encode = DATE_COEFF0_scanline_enum;
            reset = 0x1;
        } scanline[25:25];

        enum DATE_COEFF0_rgb_en_enum {
            YPBPR = 0 { name = "Ypbpr"; desc = "YPbPr"; };
            RGB = 1 { name = "Rgb"; desc = "RGB"; };
        };

        field {
            name = "rgb_en";
            desc = "Whether the component signal is RGB or YPbPr.";
            sw = rw;
            hw = r;
            encode = DATE_COEFF0_rgb_en_enum;
            reset = 0x0;
        } rgb_en[24:24];

        enum DATE_COEFF0_vbi_lpf_en_enum {
            DISABLED = 0 { name = "Disabled"; desc = "disabled"; };
            ENABLED = 1 { name = "Enabled"; desc = "enabled"; };
        };

        field {
            name = "vbi_lpf_en";
            desc = "VBI data low-pass filtering enable.";
            sw = rw;
            hw = r;
            encode = DATE_COEFF0_vbi_lpf_en_enum;
            reset = 0x1;
        } vbi_lpf_en[23:23];

        enum DATE_COEFF0_fm_sel_enum {
            SIN_MODE = 0 { name = "Sin Mode"; desc = "SIN mode"; };
            COS_MODE = 1 { name = "Cos Mode"; desc = "COS mode"; };
        };

        field {
            name = "fm_sel";
            desc = "FMSECAM frequency modulation select.";
            sw = rw;
            hw = r;
            encode = DATE_COEFF0_fm_sel_enum;
            reset = 0x0;
        } fm_sel[22:22];

        field {
            name = "style_sel";
            desc = "CVBS/S-Video output signal standard when this bit works with the scanline bit. When the scanline bit is 0 (525 scanned lines in a frame), the definition of the style_sel bit is as follows: 0001: (M) NTSC standard 0010: NTSC-J standard 0100: (M) PAL standard Other values: reserved When the scanline bit is 1 (625 scanned lines in a frame), the definition of the style_sel bit is as follows: 0001: (B, D, G, H, I) PAL standard 0010: (N) PAL standard 0100: (Nc) PAL standard 1000: SECAM standard Other values: reserved";
            sw = rw;
            hw = r;
            reset = 0x1;
        } style_sel[21:18];

        field {
            name = "sync_mode_sel";
            desc = "bit[17]: Whether there are sync signals in three channels during component output. This bit takes effect only when the sync_mode_scart bit is set to 0. 0: Only one channel contains sync signals during component output. 1: Three channels contain sync signals during component output. When bit 17 is set to 0, the sync channel must be the Y channel for YPbPr output or G channel for RGB output. bit[16]: Whether there are blanking radixes during RGB output. 0: There are no blanking radixes during RGB output. 1: There are blanking radixes during RGB output.";
            sw = rw;
            hw = r;
            reset = 0x0;
        } sync_mode_sel[17:16];

        enum DATE_COEFF0_sync_mode_scart_enum {
            COMPONENT_SYNC_OUTPUT = 0 { name = "Component Sync Output"; desc = "Component sync output is configured based on sync_mode_sel bit[1]. sync_mode_sel bit[1] is bit 17 of sync_mode_sel"; };
            COMPONENTS_THREE_CHANNELS = 1 { name = "Components Three Channels"; desc = "The components of the three channels are not overlaid and synchronized. In this case, sync_mode_sel bit[1] must be set to 0."; };
        };

        field {
            name = "sync_mode_scart";
            desc = "Overlay sync control for the components of three channels.";
            sw = rw;
            hw = r;
            encode = DATE_COEFF0_sync_mode_scart_enum;
            reset = 0x0;
        } sync_mode_scart[15:15];

        enum DATE_COEFF0_length_sel_enum {
            OUTPUT_ACCORDING_LINE = 0 { name = "Output According Line"; desc = "output according to the line active pixel width in BT.601 mode"; };
            OUTPUT_ACCORDING_LINE_2 = 1 { name = "Output According Line 2"; desc = "output according to the line active pixel width in BT.470 mode When this bit is set to 0, the active line width is 720 pixels. When this bit is set to 1, the active line width is 704 pixels for the 625- line standard or 712 pixels for the 525-line standard. Currently, the BT.601 mode and BT.470 mode cannot be dynamically switched. You can change the mode only after reset. The BT.601 mode is recommended, and this mode is the default mode after power-on reset."; };
        };

        field {
            name = "length_sel";
            desc = "Active width of each video line (in pixel).";
            sw = rw;
            hw = r;
            encode = DATE_COEFF0_length_sel_enum;
            reset = 0x0;
        } length_sel[14:14];

        enum DATE_COEFF0_agc_amp_sel_enum {
            AGC_PULSE_GENERATED = 0 { name = "Agc Pulse Generated"; desc = "The AGC pulse is generated based on the on-chip default value (recommended)."; };
            AGC_PULSE_GENERATED_2 = 1 { name = "Agc Pulse Generated 2"; desc = "The AGC pulse is generated based on DATE_COEFF1[amp_outside]."; };
        };

        field {
            name = "agc_amp_sel";
            desc = "agc_amp_sel";
            sw = rw;
            hw = r;
            encode = DATE_COEFF0_agc_amp_sel_enum;
            reset = 0x0;
        } agc_amp_sel[13:13];

        field {
            name = "luma_dl";
            desc = "Lead or lag-behind offset of the chrominance signal relative to the luminance signal, in the unit of half a pixel width. bit[12]: offset direction of the chrominance signal relative to the luminance signal. 0: The chrominance signal lags behind the luminance signal. 1: The chrominance signal leads the luminance signal. bit[11:9]: absolute offset of the chrominance signal relative to the luminance signal. The value is in binary format and ranges from 0 to 7. 000: The chrominance signal is aligned with the luminance signal. No adjustment is required. 001-111: The chrominance signal leads or lags behind the luminance signal by one to seven units.";
            sw = rw;
            hw = r;
            reset = 0xA;
        } luma_dl[12:9];

        field {
            name = "oversam_en";
            desc = "Level-1 over-sampling enable. Both luminance over-sampling and chrominance over-sampling are controlled. bit[7]: luminance over-sampling enable. 0: disabled 1: enabled bit[6]: chrominance over-sampling enable. 0: disabled 1: enabled";
            sw = rw;
            hw = r;
            reset = 0x3;
        } oversam_en[7:6];

        enum DATE_COEFF0_lunt_en_enum {
            DISABLED = 0 { name = "Disabled"; desc = "disabled"; };
            ENABLED = 1 { name = "Enabled"; desc = "enabled"; };
        };

        field {
            name = "lunt_en";
            desc = "Luminance notch enable.";
            sw = rw;
            hw = r;
            encode = DATE_COEFF0_lunt_en_enum;
            reset = 0x1;
        } lunt_en[5:5];

        enum DATE_COEFF0_oversam2_en_enum {
            DISABLED = 0 { name = "Disabled"; desc = "disabled"; };
            ENABLED = 1 { name = "Enabled"; desc = "enabled"; };
        };

        field {
            name = "oversam2_en";
            desc = "Level-2 over-sampling enable. Both the luminance channel and chrominance channel are controlled.";
            sw = rw;
            hw = r;
            encode = DATE_COEFF0_oversam2_en_enum;
            reset = 0x1;
        } oversam2_en[4:4];

        enum DATE_COEFF0_chlp_en_enum {
            DISABLED = 0 { name = "Disabled"; desc = "disabled"; };
            ENABLED = 1 { name = "Enabled"; desc = "enabled"; };
        };

        field {
            name = "chlp_en";
            desc = "Chrominance low-pass filtering enable.";
            sw = rw;
            hw = r;
            encode = DATE_COEFF0_chlp_en_enum;
            reset = 0x1;
        } chlp_en[3:3];

        enum DATE_COEFF0_sylp_en_enum {
            DISABLED = 0 { name = "Disabled"; desc = "disabled"; };
            ENABLED = 1 { name = "Enabled"; desc = "enabled"; };
        };

        field {
            name = "sylp_en";
            desc = "Sync low-pass filtering enable.";
            sw = rw;
            hw = r;
            encode = DATE_COEFF0_sylp_en_enum;
            reset = 0x1;
        } sylp_en[2:2];

        field {
            name = "chgain_en";
            desc = "chgain_en";
            sw = rw;
            hw = r;
            reset = 0x0;
        } chgain_en[1:1];

        field {
            name = "tt_seq";
            desc = "tt_seq";
            sw = rw;
            hw = r;
            reset = 0x0;
        } tt_seq[0:0];
    } DATE_COEFF0 @ 0xF200;

    reg {
        name = "Amplitude configuration register";
        desc = "DATE_COEFF1 is an amplitude configuration register.

Data sheet 10.2.6 DATE_COEFF1 (offset 0xF204, printed page 10-235, `hi3516av100--Hi3516A-Hi3516D-Datasheet.txt` line 72133).";

        field {
            name = "c_gain";
            desc = "Adjustment of the chrominance sync gain amplitude.";
            sw = rw;
            hw = r;
            reset = 0x0;
        } c_gain[31:29];

        enum DATE_COEFF1_cvbs_limit_en_enum {
            NOT_LIMITED = 0 { name = "Not Limited"; desc = "not limited"; };
            LIMITED = 1 { name = "Limited"; desc = "limited"; };
        };

        field {
            name = "cvbs_limit_en";
            desc = "CVBS amplitude limit.";
            sw = rw;
            hw = r;
            encode = DATE_COEFF1_cvbs_limit_en_enum;
            reset = 0x0;
        } cvbs_limit_en[28:28];

        enum DATE_COEFF1_wss_seq_enum {
            FROM_UPPER_BITS = 0 { name = "From Upper Bits"; desc = "from upper bits to lower bits"; };
            FROM_LOWER_BITS = 1 { name = "From Lower Bits"; desc = "from lower bits to upper bits"; };
        };

        field {
            name = "wss_seq";
            desc = "Sequence of transmitting the bits of the WSS data.";
            sw = rw;
            hw = r;
            encode = DATE_COEFF1_wss_seq_enum;
            reset = 0x0;
        } wss_seq[27:27];

        enum DATE_COEFF1_vps_seq_enum {
            FROM_UPPER_BITS = 0 { name = "From Upper Bits"; desc = "from upper bits to lower bits"; };
            FROM_LOWER_BITS = 1 { name = "From Lower Bits"; desc = "from lower bits to upper bits"; };
        };

        field {
            name = "vps_seq";
            desc = "Sequence of transmitting the bits of the video programming system (VPS) data.";
            sw = rw;
            hw = r;
            encode = DATE_COEFF1_vps_seq_enum;
            reset = 0x0;
        } vps_seq[26:26];

        enum DATE_COEFF1_cgms_seq_enum {
            FROM_UPPER_BITS = 0 { name = "From Upper Bits"; desc = "from upper bits to lower bits"; };
            FROM_LOWER_BITS = 1 { name = "From Lower Bits"; desc = "from lower bits to upper bits"; };
        };

        field {
            name = "cgms_seq";
            desc = "Sequence of transmitting the bits of the copy generation management system (CGMS) data.";
            sw = rw;
            hw = r;
            encode = DATE_COEFF1_cgms_seq_enum;
            reset = 0x0;
        } cgms_seq[25:25];

        enum DATE_COEFF1_cc_seq_enum {
            FROM_UPPER_BITS = 0 { name = "From Upper Bits"; desc = "from upper bits to lower bits"; };
            FROM_LOWER_BITS = 1 { name = "From Lower Bits"; desc = "from lower bits to upper bits"; };
        };

        field {
            name = "cc_seq";
            desc = "Sequence of transmitting the bits of the closed caption data.";
            sw = rw;
            hw = r;
            encode = DATE_COEFF1_cc_seq_enum;
            reset = 0x0;
        } cc_seq[24:24];

        enum DATE_COEFF1_c_limit_en_enum {
            NOT_LIMITED = 0 { name = "Not Limited"; desc = "not limited"; };
            LIMITED = 1 { name = "Limited"; desc = "limited"; };
        };

        field {
            name = "c_limit_en";
            desc = "Chrominance amplitude limit.";
            sw = rw;
            hw = r;
            encode = DATE_COEFF1_c_limit_en_enum;
            reset = 0x0;
        } c_limit_en[23:23];

        field {
            name = "amp_outside";
            desc = "Pulse amplitude input of the external AGC.";
            sw = rw;
            hw = r;
            reset = 0x0;
        } amp_outside[22:13];

        field {
            name = "date_test_en";
            desc = "Test valid signal.";
            sw = rw;
            hw = r;
            reset = 0x0;
        } date_test_en[12:12];

        field {
            name = "date_test_mode";
            desc = "Test mode signal.";
            sw = rw;
            hw = r;
            reset = 0x0;
        } date_test_mode[11:10];

        field {
            name = "dac_test";
            desc = "DAC test value input.";
            sw = rw;
            hw = r;
            reset = 0x0;
        } dac_test[9:0];
    } DATE_COEFF1 @ 0xF204;

    reg {
        name = "DATE coefficient 2 register";
        desc = "DATE_COEFF2 is a DATE coefficient 2 register.

Data sheet 10.2.6 DATE_COEFF2 (offset 0xF208, printed page 10-236, `hi3516av100--Hi3516A-Hi3516D-Datasheet.txt` line 72194).";

        field {
            name = "coef02";
            desc = "DATE coefficient 2.";
            sw = rw;
            hw = r;
            reset = 0x0;
        } coef02[31:0];
    } DATE_COEFF2 @ 0xF208;

    reg {
        name = "DATE coefficient 3 register";
        desc = "DATE_COEFF3 is a DATE coefficient 3 register.

Data sheet 10.2.6 DATE_COEFF3 (offset 0xF20C, printed page 10-236, `hi3516av100--Hi3516A-Hi3516D-Datasheet.txt` line 72212).";

        field {
            name = "coef03";
            desc = "DATE coefficient 3.";
            sw = rw;
            hw = r;
            reset = 0x0;
        } coef03[25:0];
    } DATE_COEFF3 @ 0xF20C;

    reg {
        name = "DATE coefficient 4 register";
        desc = "DATE_COEFF4 is a DATE coefficient 4 register. Huawei Proprietary and Confidential Hi3516A/Hi3516D Professional HD IP Camera SoC

Data sheet 10.2.6 DATE_COEFF4 (offset 0xF210, printed page 10-237, `hi3516av100--Hi3516A-Hi3516D-Datasheet.txt` line 72239).";

        field {
            name = "coef04";
            desc = "DATE coefficient 4.";
            sw = rw;
            hw = r;
            reset = 0x0;
        } coef04[29:0];
    } DATE_COEFF4 @ 0xF210;

    reg {
        name = "DATE coefficient 5 register";
        desc = "DATE_COEFF5 is a DATE coefficient 5 register.

Data sheet 10.2.6 DATE_COEFF5 (offset 0xF214, printed page 10-237, `hi3516av100--Hi3516A-Hi3516D-Datasheet.txt` line 72262).";

        field {
            name = "coef05";
            desc = "DATE coefficient 5.";
            sw = rw;
            hw = r;
            reset = 0x0;
        } coef05[28:0];
    } DATE_COEFF5 @ 0xF214;

    reg {
        name = "DATE coefficient 6 register";
        desc = "DATE_COEFF6 is a DATE coefficient 6 register. Huawei Proprietary and Confidential Hi3516A/Hi3516D Professional HD IP Camera SoC

Data sheet 10.2.6 DATE_COEFF6 (offset 0xF218, printed page 10-238, `hi3516av100--Hi3516A-Hi3516D-Datasheet.txt` line 72295).";

        field {
            name = "coef06_0";
            desc = "DATE coefficient 6 register 0.";
            sw = rw;
            hw = r;
            reset = 0x1;
        } coef06_0[31:31];

        field {
            name = "coef06_1";
            desc = "DATE coefficient 6 register 1.";
            sw = rw;
            hw = r;
            reset = 0x0;
        } coef06_1[22:0];
    } DATE_COEFF6 @ 0xF218;

    reg {
        name = "DATE COEFF7";
        desc = "[inferred] DATE COEFF7. Not in the data sheet. Source: vendor U-Boot 2010.06 `product/hiosd/vo/hi3516a/vou_reg.h` (GPL-2.0 U-Boot tree, HiSilicon copyright, created 2013-04-27; mirror github.com/OpenIPC/u-boot-hi3516cv200), union `U_DATE_COEFF7`, struct offset 0xF21C (GPL-2.0, same-chip vendor header). Reset value and access type unknown (modelled RW, no reset). Confidence: medium (vendor header for this chip family, not hardware verified).";

        field {
            name = "tt22_enf1";
            desc = "[inferred] Tt22 enf1. (vendor header `product/hiosd/vo/hi3516a/vou_reg.h` field `tt22_enf1`; access and reset unknown, modelled RW)";
            sw = rw;
            hw = r;
        } tt22_enf1[31:31];

        field {
            name = "tt21_enf1";
            desc = "[inferred] Tt21 enf1. (vendor header `product/hiosd/vo/hi3516a/vou_reg.h` field `tt21_enf1`; access and reset unknown, modelled RW)";
            sw = rw;
            hw = r;
        } tt21_enf1[30:30];

        field {
            name = "tt20_enf1";
            desc = "[inferred] Tt20 enf1. (vendor header `product/hiosd/vo/hi3516a/vou_reg.h` field `tt20_enf1`; access and reset unknown, modelled RW)";
            sw = rw;
            hw = r;
        } tt20_enf1[29:29];

        field {
            name = "tt19_enf1";
            desc = "[inferred] Tt19 enf1. (vendor header `product/hiosd/vo/hi3516a/vou_reg.h` field `tt19_enf1`; access and reset unknown, modelled RW)";
            sw = rw;
            hw = r;
        } tt19_enf1[28:28];

        field {
            name = "tt18_enf1";
            desc = "[inferred] Tt18 enf1. (vendor header `product/hiosd/vo/hi3516a/vou_reg.h` field `tt18_enf1`; access and reset unknown, modelled RW)";
            sw = rw;
            hw = r;
        } tt18_enf1[27:27];

        field {
            name = "tt17_enf1";
            desc = "[inferred] Tt17 enf1. (vendor header `product/hiosd/vo/hi3516a/vou_reg.h` field `tt17_enf1`; access and reset unknown, modelled RW)";
            sw = rw;
            hw = r;
        } tt17_enf1[26:26];

        field {
            name = "tt16_enf1";
            desc = "[inferred] Tt16 enf1. (vendor header `product/hiosd/vo/hi3516a/vou_reg.h` field `tt16_enf1`; access and reset unknown, modelled RW)";
            sw = rw;
            hw = r;
        } tt16_enf1[25:25];

        field {
            name = "tt15_enf1";
            desc = "[inferred] Tt15 enf1. (vendor header `product/hiosd/vo/hi3516a/vou_reg.h` field `tt15_enf1`; access and reset unknown, modelled RW)";
            sw = rw;
            hw = r;
        } tt15_enf1[24:24];

        field {
            name = "tt14_enf1";
            desc = "[inferred] Tt14 enf1. (vendor header `product/hiosd/vo/hi3516a/vou_reg.h` field `tt14_enf1`; access and reset unknown, modelled RW)";
            sw = rw;
            hw = r;
        } tt14_enf1[23:23];

        field {
            name = "tt13_enf1";
            desc = "[inferred] Tt13 enf1. (vendor header `product/hiosd/vo/hi3516a/vou_reg.h` field `tt13_enf1`; access and reset unknown, modelled RW)";
            sw = rw;
            hw = r;
        } tt13_enf1[22:22];

        field {
            name = "tt12_enf1";
            desc = "[inferred] Tt12 enf1. (vendor header `product/hiosd/vo/hi3516a/vou_reg.h` field `tt12_enf1`; access and reset unknown, modelled RW)";
            sw = rw;
            hw = r;
        } tt12_enf1[21:21];

        field {
            name = "tt11_enf1";
            desc = "[inferred] Tt11 enf1. (vendor header `product/hiosd/vo/hi3516a/vou_reg.h` field `tt11_enf1`; access and reset unknown, modelled RW)";
            sw = rw;
            hw = r;
        } tt11_enf1[20:20];

        field {
            name = "tt10_enf1";
            desc = "[inferred] Tt10 enf1. (vendor header `product/hiosd/vo/hi3516a/vou_reg.h` field `tt10_enf1`; access and reset unknown, modelled RW)";
            sw = rw;
            hw = r;
        } tt10_enf1[19:19];

        field {
            name = "tt09_enf1";
            desc = "[inferred] Tt09 enf1. (vendor header `product/hiosd/vo/hi3516a/vou_reg.h` field `tt09_enf1`; access and reset unknown, modelled RW)";
            sw = rw;
            hw = r;
        } tt09_enf1[18:18];

        field {
            name = "tt08_enf1";
            desc = "[inferred] Tt08 enf1. (vendor header `product/hiosd/vo/hi3516a/vou_reg.h` field `tt08_enf1`; access and reset unknown, modelled RW)";
            sw = rw;
            hw = r;
        } tt08_enf1[17:17];

        field {
            name = "tt07_enf1";
            desc = "[inferred] Tt07 enf1. (vendor header `product/hiosd/vo/hi3516a/vou_reg.h` field `tt07_enf1`; access and reset unknown, modelled RW)";
            sw = rw;
            hw = r;
        } tt07_enf1[16:16];

        field {
            name = "tt22_enf2";
            desc = "[inferred] Tt22 enf2. (vendor header `product/hiosd/vo/hi3516a/vou_reg.h` field `tt22_enf2`; access and reset unknown, modelled RW)";
            sw = rw;
            hw = r;
        } tt22_enf2[15:15];

        field {
            name = "tt21_enf2";
            desc = "[inferred] Tt21 enf2. (vendor header `product/hiosd/vo/hi3516a/vou_reg.h` field `tt21_enf2`; access and reset unknown, modelled RW)";
            sw = rw;
            hw = r;
        } tt21_enf2[14:14];

        field {
            name = "tt20_enf2";
            desc = "[inferred] Tt20 enf2. (vendor header `product/hiosd/vo/hi3516a/vou_reg.h` field `tt20_enf2`; access and reset unknown, modelled RW)";
            sw = rw;
            hw = r;
        } tt20_enf2[13:13];

        field {
            name = "tt19_enf2";
            desc = "[inferred] Tt19 enf2. (vendor header `product/hiosd/vo/hi3516a/vou_reg.h` field `tt19_enf2`; access and reset unknown, modelled RW)";
            sw = rw;
            hw = r;
        } tt19_enf2[12:12];

        field {
            name = "tt18_enf2";
            desc = "[inferred] Tt18 enf2. (vendor header `product/hiosd/vo/hi3516a/vou_reg.h` field `tt18_enf2`; access and reset unknown, modelled RW)";
            sw = rw;
            hw = r;
        } tt18_enf2[11:11];

        field {
            name = "tt17_enf2";
            desc = "[inferred] Tt17 enf2. (vendor header `product/hiosd/vo/hi3516a/vou_reg.h` field `tt17_enf2`; access and reset unknown, modelled RW)";
            sw = rw;
            hw = r;
        } tt17_enf2[10:10];

        field {
            name = "tt16_enf2";
            desc = "[inferred] Tt16 enf2. (vendor header `product/hiosd/vo/hi3516a/vou_reg.h` field `tt16_enf2`; access and reset unknown, modelled RW)";
            sw = rw;
            hw = r;
        } tt16_enf2[9:9];

        field {
            name = "tt15_enf2";
            desc = "[inferred] Tt15 enf2. (vendor header `product/hiosd/vo/hi3516a/vou_reg.h` field `tt15_enf2`; access and reset unknown, modelled RW)";
            sw = rw;
            hw = r;
        } tt15_enf2[8:8];

        field {
            name = "tt14_enf2";
            desc = "[inferred] Tt14 enf2. (vendor header `product/hiosd/vo/hi3516a/vou_reg.h` field `tt14_enf2`; access and reset unknown, modelled RW)";
            sw = rw;
            hw = r;
        } tt14_enf2[7:7];

        field {
            name = "tt13_enf2";
            desc = "[inferred] Tt13 enf2. (vendor header `product/hiosd/vo/hi3516a/vou_reg.h` field `tt13_enf2`; access and reset unknown, modelled RW)";
            sw = rw;
            hw = r;
        } tt13_enf2[6:6];

        field {
            name = "tt12_enf2";
            desc = "[inferred] Tt12 enf2. (vendor header `product/hiosd/vo/hi3516a/vou_reg.h` field `tt12_enf2`; access and reset unknown, modelled RW)";
            sw = rw;
            hw = r;
        } tt12_enf2[5:5];

        field {
            name = "tt11_enf2";
            desc = "[inferred] Tt11 enf2. (vendor header `product/hiosd/vo/hi3516a/vou_reg.h` field `tt11_enf2`; access and reset unknown, modelled RW)";
            sw = rw;
            hw = r;
        } tt11_enf2[4:4];

        field {
            name = "tt10_enf2";
            desc = "[inferred] Tt10 enf2. (vendor header `product/hiosd/vo/hi3516a/vou_reg.h` field `tt10_enf2`; access and reset unknown, modelled RW)";
            sw = rw;
            hw = r;
        } tt10_enf2[3:3];

        field {
            name = "tt09_enf2";
            desc = "[inferred] Tt09 enf2. (vendor header `product/hiosd/vo/hi3516a/vou_reg.h` field `tt09_enf2`; access and reset unknown, modelled RW)";
            sw = rw;
            hw = r;
        } tt09_enf2[2:2];

        field {
            name = "tt08_enf2";
            desc = "[inferred] Tt08 enf2. (vendor header `product/hiosd/vo/hi3516a/vou_reg.h` field `tt08_enf2`; access and reset unknown, modelled RW)";
            sw = rw;
            hw = r;
        } tt08_enf2[1:1];

        field {
            name = "tt07_enf2";
            desc = "[inferred] Tt07 enf2. (vendor header `product/hiosd/vo/hi3516a/vou_reg.h` field `tt07_enf2`; access and reset unknown, modelled RW)";
            sw = rw;
            hw = r;
        } tt07_enf2[0:0];
    } DATE_COEFF7 @ 0xF21C;

    reg {
        name = "DATE COEFF8";
        desc = "[inferred] DATE COEFF8. Not in the data sheet. Source: vendor U-Boot 2010.06 `product/hiosd/vo/hi3516a/vou_reg.h` (GPL-2.0 U-Boot tree, HiSilicon copyright, created 2013-04-27; mirror github.com/OpenIPC/u-boot-hi3516cv200), union `U_DATE_COEFF8`, struct offset 0xF220 (GPL-2.0, same-chip vendor header). Reset value and access type unknown (modelled RW, no reset). Confidence: medium (vendor header for this chip family, not hardware verified).";

        field {
            name = "tt_staddr";
            desc = "[inferred] Tt staddr. (vendor header `product/hiosd/vo/hi3516a/vou_reg.h` field `tt_staddr`; access and reset unknown, modelled RW)";
            sw = rw;
            hw = r;
        } tt_staddr[31:0];
    } DATE_COEFF8 @ 0xF220;

    reg {
        name = "DATE COEFF9";
        desc = "[inferred] DATE COEFF9. Not in the data sheet. Source: vendor U-Boot 2010.06 `product/hiosd/vo/hi3516a/vou_reg.h` (GPL-2.0 U-Boot tree, HiSilicon copyright, created 2013-04-27; mirror github.com/OpenIPC/u-boot-hi3516cv200), union `U_DATE_COEFF9`, struct offset 0xF224 (GPL-2.0, same-chip vendor header). Reset value and access type unknown (modelled RW, no reset). Confidence: medium (vendor header for this chip family, not hardware verified).";

        field {
            name = "tt_edaddr";
            desc = "[inferred] Tt edaddr. (vendor header `product/hiosd/vo/hi3516a/vou_reg.h` field `tt_edaddr`; access and reset unknown, modelled RW)";
            sw = rw;
            hw = r;
        } tt_edaddr[31:0];
    } DATE_COEFF9 @ 0xF224;

    reg {
        name = "DATE COEFF10";
        desc = "[inferred] DATE COEFF10. Not in the data sheet. Source: vendor U-Boot 2010.06 `product/hiosd/vo/hi3516a/vou_reg.h` (GPL-2.0 U-Boot tree, HiSilicon copyright, created 2013-04-27; mirror github.com/OpenIPC/u-boot-hi3516cv200), union `U_DATE_COEFF10`, struct offset 0xF228 (GPL-2.0, same-chip vendor header). Reset value and access type unknown (modelled RW, no reset). Confidence: medium (vendor header for this chip family, not hardware verified).";

        field {
            name = "tt_ready";
            desc = "[inferred] Tt ready. (vendor header `product/hiosd/vo/hi3516a/vou_reg.h` field `tt_ready`; access and reset unknown, modelled RW)";
            sw = rw;
            hw = r;
        } tt_ready[31:31];

        field {
            name = "nabts_100ire";
            desc = "[inferred] Nabts 100ire. (vendor header `product/hiosd/vo/hi3516a/vou_reg.h` field `nabts_100ire`; access and reset unknown, modelled RW)";
            sw = rw;
            hw = r;
        } nabts_100ire[12:12];

        field {
            name = "full_page";
            desc = "[inferred] Full page. (vendor header `product/hiosd/vo/hi3516a/vou_reg.h` field `full_page`; access and reset unknown, modelled RW)";
            sw = rw;
            hw = r;
        } full_page[11:11];

        field {
            name = "tt_highest";
            desc = "[inferred] Tt highest. (vendor header `product/hiosd/vo/hi3516a/vou_reg.h` field `tt_highest`; access and reset unknown, modelled RW)";
            sw = rw;
            hw = r;
        } tt_highest[10:10];

        field {
            name = "tt_mode";
            desc = "[inferred] Tt mode. (vendor header `product/hiosd/vo/hi3516a/vou_reg.h` field `tt_mode`; access and reset unknown, modelled RW)";
            sw = rw;
            hw = r;
        } tt_mode[9:8];

        field {
            name = "tt_pktoff";
            desc = "[inferred] Tt pktoff. (vendor header `product/hiosd/vo/hi3516a/vou_reg.h` field `tt_pktoff`; access and reset unknown, modelled RW)";
            sw = rw;
            hw = r;
        } tt_pktoff[7:0];
    } DATE_COEFF10 @ 0xF228;

    reg {
        name = "DATE COEFF11";
        desc = "[inferred] DATE COEFF11. Not in the data sheet. Source: vendor U-Boot 2010.06 `product/hiosd/vo/hi3516a/vou_reg.h` (GPL-2.0 U-Boot tree, HiSilicon copyright, created 2013-04-27; mirror github.com/OpenIPC/u-boot-hi3516cv200), union `U_DATE_COEFF11`, struct offset 0xF22C (GPL-2.0, same-chip vendor header). Reset value and access type unknown (modelled RW, no reset). Confidence: medium (vendor header for this chip family, not hardware verified).";

        field {
            name = "cc_enf1";
            desc = "[inferred] Cc enf1. (vendor header `product/hiosd/vo/hi3516a/vou_reg.h` field `cc_enf1`; access and reset unknown, modelled RW)";
            sw = rw;
            hw = r;
        } cc_enf1[21:21];

        field {
            name = "cc_enf2";
            desc = "[inferred] Cc enf2. (vendor header `product/hiosd/vo/hi3516a/vou_reg.h` field `cc_enf2`; access and reset unknown, modelled RW)";
            sw = rw;
            hw = r;
        } cc_enf2[20:20];

        field {
            name = "date_clf1";
            desc = "[inferred] Date clf1. (vendor header `product/hiosd/vo/hi3516a/vou_reg.h` field `date_clf1`; access and reset unknown, modelled RW)";
            sw = rw;
            hw = r;
        } date_clf1[19:10];

        field {
            name = "date_clf2";
            desc = "[inferred] Date clf2. (vendor header `product/hiosd/vo/hi3516a/vou_reg.h` field `date_clf2`; access and reset unknown, modelled RW)";
            sw = rw;
            hw = r;
        } date_clf2[9:0];
    } DATE_COEFF11 @ 0xF22C;

    reg {
        name = "DATE COEFF12";
        desc = "[inferred] DATE COEFF12. Not in the data sheet. Source: vendor U-Boot 2010.06 `product/hiosd/vo/hi3516a/vou_reg.h` (GPL-2.0 U-Boot tree, HiSilicon copyright, created 2013-04-27; mirror github.com/OpenIPC/u-boot-hi3516cv200), union `U_DATE_COEFF12`, struct offset 0xF230 (GPL-2.0, same-chip vendor header). Reset value and access type unknown (modelled RW, no reset). Confidence: medium (vendor header for this chip family, not hardware verified).";

        field {
            name = "cc_f1data";
            desc = "[inferred] Cc f1data. (vendor header `product/hiosd/vo/hi3516a/vou_reg.h` field `cc_f1data`; access and reset unknown, modelled RW)";
            sw = rw;
            hw = r;
        } cc_f1data[31:16];

        field {
            name = "cc_f2data";
            desc = "[inferred] Cc f2data. (vendor header `product/hiosd/vo/hi3516a/vou_reg.h` field `cc_f2data`; access and reset unknown, modelled RW)";
            sw = rw;
            hw = r;
        } cc_f2data[15:0];
    } DATE_COEFF12 @ 0xF230;

    reg {
        name = "DATE COEFF13";
        desc = "[inferred] DATE COEFF13. Not in the data sheet. Source: vendor U-Boot 2010.06 `product/hiosd/vo/hi3516a/vou_reg.h` (GPL-2.0 U-Boot tree, HiSilicon copyright, created 2013-04-27; mirror github.com/OpenIPC/u-boot-hi3516cv200), union `U_DATE_COEFF13`, struct offset 0xF234 (GPL-2.0, same-chip vendor header). Reset value and access type unknown (modelled RW, no reset). Confidence: medium (vendor header for this chip family, not hardware verified).";

        field {
            name = "cg_enf1";
            desc = "[inferred] Cg enf1. (vendor header `product/hiosd/vo/hi3516a/vou_reg.h` field `cg_enf1`; access and reset unknown, modelled RW)";
            sw = rw;
            hw = r;
        } cg_enf1[21:21];

        field {
            name = "cg_enf2";
            desc = "[inferred] Cg enf2. (vendor header `product/hiosd/vo/hi3516a/vou_reg.h` field `cg_enf2`; access and reset unknown, modelled RW)";
            sw = rw;
            hw = r;
        } cg_enf2[20:20];

        field {
            name = "cg_f1data";
            desc = "[inferred] Cg f1data. (vendor header `product/hiosd/vo/hi3516a/vou_reg.h` field `cg_f1data`; access and reset unknown, modelled RW)";
            sw = rw;
            hw = r;
        } cg_f1data[19:0];
    } DATE_COEFF13 @ 0xF234;

    reg {
        name = "DATE COEFF14";
        desc = "[inferred] DATE COEFF14. Not in the data sheet. Source: vendor U-Boot 2010.06 `product/hiosd/vo/hi3516a/vou_reg.h` (GPL-2.0 U-Boot tree, HiSilicon copyright, created 2013-04-27; mirror github.com/OpenIPC/u-boot-hi3516cv200), union `U_DATE_COEFF14`, struct offset 0xF238 (GPL-2.0, same-chip vendor header). Reset value and access type unknown (modelled RW, no reset). Confidence: medium (vendor header for this chip family, not hardware verified).";

        field {
            name = "cg_f2data";
            desc = "[inferred] Cg f2data. (vendor header `product/hiosd/vo/hi3516a/vou_reg.h` field `cg_f2data`; access and reset unknown, modelled RW)";
            sw = rw;
            hw = r;
        } cg_f2data[19:0];
    } DATE_COEFF14 @ 0xF238;

    reg {
        name = "DATE COEFF15";
        desc = "[inferred] DATE COEFF15. Not in the data sheet. Source: vendor U-Boot 2010.06 `product/hiosd/vo/hi3516a/vou_reg.h` (GPL-2.0 U-Boot tree, HiSilicon copyright, created 2013-04-27; mirror github.com/OpenIPC/u-boot-hi3516cv200), union `U_DATE_COEFF15`, struct offset 0xF23C (GPL-2.0, same-chip vendor header). Reset value and access type unknown (modelled RW, no reset). Confidence: medium (vendor header for this chip family, not hardware verified).";

        field {
            name = "wss_en";
            desc = "[inferred] Wss enable. (vendor header `product/hiosd/vo/hi3516a/vou_reg.h` field `wss_en`; access and reset unknown, modelled RW)";
            sw = rw;
            hw = r;
        } wss_en[14:14];

        field {
            name = "wss_data";
            desc = "[inferred] Wss data. (vendor header `product/hiosd/vo/hi3516a/vou_reg.h` field `wss_data`; access and reset unknown, modelled RW)";
            sw = rw;
            hw = r;
        } wss_data[13:0];
    } DATE_COEFF15 @ 0xF23C;

    reg {
        name = "DATE COEFF16";
        desc = "[inferred] DATE COEFF16. Not in the data sheet. Source: vendor U-Boot 2010.06 `product/hiosd/vo/hi3516a/vou_reg.h` (GPL-2.0 U-Boot tree, HiSilicon copyright, created 2013-04-27; mirror github.com/OpenIPC/u-boot-hi3516cv200), union `U_DATE_COEFF16`, struct offset 0xF240 (GPL-2.0, same-chip vendor header). Reset value and access type unknown (modelled RW, no reset). Confidence: medium (vendor header for this chip family, not hardware verified).";

        field {
            name = "vps_en";
            desc = "[inferred] Vps enable. (vendor header `product/hiosd/vo/hi3516a/vou_reg.h` field `vps_en`; access and reset unknown, modelled RW)";
            sw = rw;
            hw = r;
        } vps_en[24:24];

        field {
            name = "vps_data";
            desc = "[inferred] Vps data. (vendor header `product/hiosd/vo/hi3516a/vou_reg.h` field `vps_data`; access and reset unknown, modelled RW)";
            sw = rw;
            hw = r;
        } vps_data[23:0];
    } DATE_COEFF16 @ 0xF240;

    reg {
        name = "DATE COEFF17";
        desc = "[inferred] DATE COEFF17. Not in the data sheet. Source: vendor U-Boot 2010.06 `product/hiosd/vo/hi3516a/vou_reg.h` (GPL-2.0 U-Boot tree, HiSilicon copyright, created 2013-04-27; mirror github.com/OpenIPC/u-boot-hi3516cv200), union `U_DATE_COEFF17`, struct offset 0xF244 (GPL-2.0, same-chip vendor header). Reset value and access type unknown (modelled RW, no reset). Confidence: medium (vendor header for this chip family, not hardware verified).";

        field {
            name = "vps_data";
            desc = "[inferred] Vps data. (vendor header `product/hiosd/vo/hi3516a/vou_reg.h` field `vps_data`; access and reset unknown, modelled RW)";
            sw = rw;
            hw = r;
        } vps_data[31:0];
    } DATE_COEFF17 @ 0xF244;

    reg {
        name = "DATE COEFF18";
        desc = "[inferred] DATE COEFF18. Not in the data sheet. Source: vendor U-Boot 2010.06 `product/hiosd/vo/hi3516a/vou_reg.h` (GPL-2.0 U-Boot tree, HiSilicon copyright, created 2013-04-27; mirror github.com/OpenIPC/u-boot-hi3516cv200), union `U_DATE_COEFF18`, struct offset 0xF248 (GPL-2.0, same-chip vendor header). Reset value and access type unknown (modelled RW, no reset). Confidence: medium (vendor header for this chip family, not hardware verified).";

        field {
            name = "vps_data";
            desc = "[inferred] Vps data. (vendor header `product/hiosd/vo/hi3516a/vou_reg.h` field `vps_data`; access and reset unknown, modelled RW)";
            sw = rw;
            hw = r;
        } vps_data[31:0];
    } DATE_COEFF18 @ 0xF248;

    reg {
        name = "DATE COEFF19";
        desc = "[inferred] DATE COEFF19. Not in the data sheet. Source: vendor U-Boot 2010.06 `product/hiosd/vo/hi3516a/vou_reg.h` (GPL-2.0 U-Boot tree, HiSilicon copyright, created 2013-04-27; mirror github.com/OpenIPC/u-boot-hi3516cv200), union `U_DATE_COEFF19`, struct offset 0xF24C (GPL-2.0, same-chip vendor header). Reset value and access type unknown (modelled RW, no reset). Confidence: medium (vendor header for this chip family, not hardware verified).";

        field {
            name = "vps_data";
            desc = "[inferred] Vps data. (vendor header `product/hiosd/vo/hi3516a/vou_reg.h` field `vps_data`; access and reset unknown, modelled RW)";
            sw = rw;
            hw = r;
        } vps_data[15:0];
    } DATE_COEFF19 @ 0xF24C;

    reg {
        name = "DATE COEFF20";
        desc = "[inferred] DATE COEFF20. Not in the data sheet. Source: vendor U-Boot 2010.06 `product/hiosd/vo/hi3516a/vou_reg.h` (GPL-2.0 U-Boot tree, HiSilicon copyright, created 2013-04-27; mirror github.com/OpenIPC/u-boot-hi3516cv200), union `U_DATE_COEFF20`, struct offset 0xF250 (GPL-2.0, same-chip vendor header). Reset value and access type unknown (modelled RW, no reset). Confidence: medium (vendor header for this chip family, not hardware verified).";

        field {
            name = "tt06_enf1";
            desc = "[inferred] Tt06 enf1. (vendor header `product/hiosd/vo/hi3516a/vou_reg.h` field `tt06_enf1`; access and reset unknown, modelled RW)";
            sw = rw;
            hw = r;
        } tt06_enf1[2:2];

        field {
            name = "tt06_enf2";
            desc = "[inferred] Tt06 enf2. (vendor header `product/hiosd/vo/hi3516a/vou_reg.h` field `tt06_enf2`; access and reset unknown, modelled RW)";
            sw = rw;
            hw = r;
        } tt06_enf2[1:1];

        field {
            name = "tt05_enf2";
            desc = "[inferred] Tt05 enf2. (vendor header `product/hiosd/vo/hi3516a/vou_reg.h` field `tt05_enf2`; access and reset unknown, modelled RW)";
            sw = rw;
            hw = r;
        } tt05_enf2[0:0];
    } DATE_COEFF20 @ 0xF250;

    reg {
        name = "Output matrix control register";
        desc = "DATE_COEFF21 is an output matrix control register.

Data sheet 10.2.6 DATE_COEFF21 (offset 0xF254, printed page 10-238, `hi3516av100--Hi3516A-Hi3516D-Datasheet.txt` line 72321).";

        enum DATE_COEFF21_dac5_in_sel_enum {
            V_0 = 0 { name = "V 0"; desc = "0"; };
            CVBS = 1 { name = "Cvbs"; desc = "CVBS"; };
            G_Y = 2 { name = "G Y"; desc = "G/Y"; };
            B_PB = 3 { name = "B Pb"; desc = "B/Pb"; };
            R_PR = 4 { name = "R Pr"; desc = "R/Pr"; };
            SVIDEO_Y = 5 { name = "Svideo Y"; desc = "svideo_y"; };
            SVIDEO_C = 6 { name = "Svideo C"; desc = "svideo_c"; };
            V_0_2 = 7 { name = "V 0 2"; desc = "0"; };
        };

        field {
            name = "dac5_in_sel";
            desc = "DAC5 output mode.";
            sw = rw;
            hw = r;
            encode = DATE_COEFF21_dac5_in_sel_enum;
            reset = 0x6;
        } dac5_in_sel[22:20];

        enum DATE_COEFF21_dac4_in_sel_enum {
            V_0 = 0 { name = "V 0"; desc = "0"; };
            CVBS = 1 { name = "Cvbs"; desc = "cvbs"; };
            G_Y = 2 { name = "G Y"; desc = "G/Y"; };
            B_PB = 3 { name = "B Pb"; desc = "B/Pb"; };
            R_PR = 4 { name = "R Pr"; desc = "R/Pr"; };
            SVIDEO_Y = 5 { name = "Svideo Y"; desc = "svideo_y"; };
            SVIDEO_C = 6 { name = "Svideo C"; desc = "svideo_c"; };
            V_0_2 = 7 { name = "V 0 2"; desc = "0"; };
        };

        field {
            name = "dac4_in_sel";
            desc = "DAC4 output mode.";
            sw = rw;
            hw = r;
            encode = DATE_COEFF21_dac4_in_sel_enum;
            reset = 0x5;
        } dac4_in_sel[18:16];

        enum DATE_COEFF21_dac3_in_sel_enum {
            V_0 = 0 { name = "V 0"; desc = "0"; };
            CVBS = 1 { name = "Cvbs"; desc = "CVBS"; };
            G_Y = 2 { name = "G Y"; desc = "G/Y"; };
            B_PB = 3 { name = "B Pb"; desc = "B/Pb"; };
            R_PR = 4 { name = "R Pr"; desc = "R/Pr"; };
            SVIDEO_Y = 5 { name = "Svideo Y"; desc = "svideo_y"; };
            SVIDEO_C = 6 { name = "Svideo C"; desc = "svideo_c"; };
            V_0_2 = 7 { name = "V 0 2"; desc = "0"; };
        };

        field {
            name = "dac3_in_sel";
            desc = "DAC3 output mode.";
            sw = rw;
            hw = r;
            encode = DATE_COEFF21_dac3_in_sel_enum;
            reset = 0x1;
        } dac3_in_sel[14:12];

        enum DATE_COEFF21_dac2_in_sel_enum {
            V_0 = 0 { name = "V 0"; desc = "0"; };
            CVBS = 1 { name = "Cvbs"; desc = "CVBS"; };
            G_Y = 2 { name = "G Y"; desc = "G/Y"; };
            B_PB = 3 { name = "B Pb"; desc = "B/Pb"; };
            R_PR = 4 { name = "R Pr"; desc = "R/Pr"; };
            SVIDEO_Y = 5 { name = "Svideo Y"; desc = "svideo_y"; };
            SVIDEO_C = 6 { name = "Svideo C"; desc = "svideo_c"; };
            V_0_2 = 7 { name = "V 0 2"; desc = "0"; };
        };

        field {
            name = "dac2_in_sel";
            desc = "DAC2 output mode.";
            sw = rw;
            hw = r;
            encode = DATE_COEFF21_dac2_in_sel_enum;
            reset = 0x4;
        } dac2_in_sel[10:8];

        enum DATE_COEFF21_dac1_in_sel_enum {
            V_0 = 0 { name = "V 0"; desc = "0"; };
            CVBS = 1 { name = "Cvbs"; desc = "CVBS"; };
            G_Y = 2 { name = "G Y"; desc = "G/Y"; };
            B_PB = 3 { name = "B Pb"; desc = "B/Pb"; };
            R_PR = 4 { name = "R Pr"; desc = "R/Pr"; };
            SVIDEO_Y = 5 { name = "Svideo Y"; desc = "svideo_y"; };
            SVIDEO_C = 6 { name = "Svideo C"; desc = "svideo_c"; };
            V_0_2 = 7 { name = "V 0 2"; desc = "0"; };
        };

        field {
            name = "dac1_in_sel";
            desc = "DAC1 output mode.";
            sw = rw;
            hw = r;
            encode = DATE_COEFF21_dac1_in_sel_enum;
            reset = 0x3;
        } dac1_in_sel[6:4];

        enum DATE_COEFF21_dac0_in_sel_enum {
            V_0 = 0 { name = "V 0"; desc = "0"; };
            CVBS = 1 { name = "Cvbs"; desc = "CVBS"; };
            G_Y = 2 { name = "G Y"; desc = "G/Y"; };
            B_PB_100 = 3 { name = "B Pb 100"; desc = "B/Pb 100 R/Pr"; };
            SVIDEO_Y = 5 { name = "Svideo Y"; desc = "svideo_y"; };
            SVIDEO_C = 6 { name = "Svideo C"; desc = "svideo_c"; };
            V_0_2 = 7 { name = "V 0 2"; desc = "0"; };
        };

        field {
            name = "dac0_in_sel";
            desc = "DAC0 output mode.";
            sw = rw;
            hw = r;
            encode = DATE_COEFF21_dac0_in_sel_enum;
            reset = 0x2;
        } dac0_in_sel[2:0];
    } DATE_COEFF21 @ 0xF254;

    reg {
        name = "Discrete time oscillator (DTO) initial phase configuration register";
        desc = "DATE_COEFF22 is a DTO initial phase configuration register.

Data sheet 10.2.6 DATE_COEFF22 (offset 0xF258, printed page 10-240, `hi3516av100--Hi3516A-Hi3516D-Datasheet.txt` line 72424).";

        field {
            name = "video_phase_delta";
            desc = "DTO initial phase.";
            sw = rw;
            hw = r;
            reset = 0x0;
        } video_phase_delta[10:0];
    } DATE_COEFF22 @ 0xF258;

    reg {
        name = "Video output delay configuration register";
        desc = "DATE_COEFF23 is a video output delay configuration register. Huawei Proprietary and Confidential Hi3516A/Hi3516D Professional HD IP Camera SoC

Data sheet 10.2.6 DATE_COEFF23 (offset 0xF25C, printed page 10-241, `hi3516av100--Hi3516A-Hi3516D-Datasheet.txt` line 72453).";

        field {
            name = "dac5_out_dly";
            desc = "DAC5 output delay cycle. The unit is 54 MHz clock cycle, and the value n indicates n delay cycles.";
            sw = rw;
            hw = r;
            reset = 0x0;
        } dac5_out_dly[22:20];

        field {
            name = "dac4_out_dly";
            desc = "DAC4 output delay cycle. The unit is 54 MHz clock cycle, and the value n indicates n delay cycles.";
            sw = rw;
            hw = r;
            reset = 0x0;
        } dac4_out_dly[18:16];

        field {
            name = "dac3_out_dly";
            desc = "DAC3 output delay cycle. The unit is 54 MHz clock cycle, and the value n indicates n delay cycles.";
            sw = rw;
            hw = r;
            reset = 0x0;
        } dac3_out_dly[14:12];

        field {
            name = "dac2_out_dly";
            desc = "DAC2 output delay cycle. The unit is 54 MHz clock cycle, and the value n indicates n delay cycles.";
            sw = rw;
            hw = r;
            reset = 0x0;
        } dac2_out_dly[10:8];

        field {
            name = "dac1_out_dly";
            desc = "DAC1 output delay cycle. The unit is 54 MHz clock cycle, and the value n indicates n delay cycles.";
            sw = rw;
            hw = r;
            reset = 0x0;
        } dac1_out_dly[6:4];

        field {
            name = "dac0_out_dly";
            desc = "DAC0 output delay cycle. The unit is 54 MHz clock cycle, and the value n indicates n delay cycles.";
            sw = rw;
            hw = r;
            reset = 0x0;
        } dac0_out_dly[2:0];
    } DATE_COEFF23 @ 0xF25C;

    reg {
        name = "ColorBurst start position register";
        desc = "DATE_COEFF24 is a ColorBurst start position register.

Data sheet 10.2.6 DATE_COEFF24 (offset 0xF260, printed page 10-242, `hi3516av100--Hi3516A-Hi3516D-Datasheet.txt` line 72507).";

        field {
            name = "burst_start";
            desc = "ColorBurst start position.";
            sw = rw;
            hw = r;
            reset = 0x00012C99;
        } burst_start[31:0];
    } DATE_COEFF24 @ 0xF260;

    reg {
        name = "SECAM preemphasis curve input coefficient register";
        desc = "DATE_COEFF25 is a SECAM preemphasis curve input coefficient register.

Data sheet 10.2.6 DATE_COEFF25 (offset 0xF264, printed page 10-242, `hi3516av100--Hi3516A-Hi3516D-Datasheet.txt` line 72525).";

        field {
            name = "x_n_1_coef";
            desc = "Input coefficient 2 of the SECAM preemphasis curve.";
            sw = rw;
            hw = r;
            reset = 0x15B5;
        } x_n_1_coef[28:16];

        field {
            name = "x_n_coef";
            desc = "Input coefficient 1 of the SECAM preemphasis curve.";
            sw = rw;
            hw = r;
            reset = 0x9C5;
        } x_n_coef[12:0];
    } DATE_COEFF25 @ 0xF264;

    reg {
        name = "Preemphasis curve input coefficient register";
        desc = "DATE_COEFF26 is a preemphasis curve input coefficient register. Huawei Proprietary and Confidential Hi3516A/Hi3516D Professional HD IP Camera SoC

Data sheet 10.2.6 DATE_COEFF26 (offset 0xF268, printed page 10-243, `hi3516av100--Hi3516A-Hi3516D-Datasheet.txt` line 72560).";

        field {
            name = "x_n_1_coef";
            desc = "Input coefficient 3 of the SECAM preemphasis curve.";
            sw = rw;
            hw = r;
            reset = 0x945;
        } x_n_1_coef[12:0];
    } DATE_COEFF26 @ 0xF268;

    reg {
        name = "SECAM preemphasis curve output coefficient register";
        desc = "DATE_COEFF27 is a SECAM preemphasis curve output coefficient register.

Data sheet 10.2.6 DATE_COEFF27 (offset 0xF26C, printed page 10-243, `hi3516av100--Hi3516A-Hi3516D-Datasheet.txt` line 72579).";

        field {
            name = "y_n_1_coef";
            desc = "Output coefficient 2 of the SECAM preemphasis curve.";
            sw = rw;
            hw = r;
            reset = 0x780;
        } y_n_1_coef[26:16];

        field {
            name = "y_n_coef";
            desc = "Output coefficient 1 of the SECAM preemphasis curve.";
            sw = rw;
            hw = r;
            reset = 0xD0;
        } y_n_coef[10:0];
    } DATE_COEFF27 @ 0xF26C;

    reg {
        name = "SECAM color sync start coordinate register";
        desc = "DATE_COEFF28 is a SECAM color sync start coordinate register.

Data sheet 10.2.6 DATE_COEFF28 (offset 0xF270, printed page 10-243, `hi3516av100--Hi3516A-Hi3516D-Datasheet.txt` line 72600).";

        field {
            name = "pixel_begin2";
            desc = "Start position 2 for SECAM color sync.";
            sw = rw;
            hw = r;
            reset = 0x6B0;
        } pixel_begin2[26:16];

        field {
            name = "pixel_begin1";
            desc = "Start position 1 for SECAM color sync.";
            sw = rw;
            hw = r;
            reset = 0x0;
        } pixel_begin1[10:0];
    } DATE_COEFF28 @ 0xF270;

    reg {
        name = "SECAM color sync end coordinate register";
        desc = "DATE_COEFF29 is a SECAM color sync end coordinate register.

Data sheet 10.2.6 DATE_COEFF29 (offset 0xF274, printed page 10-244, `hi3516av100--Hi3516A-Hi3516D-Datasheet.txt` line 72631).";

        field {
            name = "pixel_end";
            desc = "End position for SECAM color sync.";
            sw = rw;
            hw = r;
            reset = 0xA2;
        } pixel_end[10:0];
    } DATE_COEFF29 @ 0xF274;

    reg {
        name = "SECAM peak video signal level width coefficient register";
        desc = "DATE_COEFF30 is a SECAM peak video signal level width coefficient register.

Data sheet 10.2.6 DATE_COEFF30 (offset 0xF278, printed page 10-244, `hi3516av100--Hi3516A-Hi3516D-Datasheet.txt` line 72650).";

        field {
            name = "g_secam";
            desc = "Level width coefficient of the SECAM peak video signal.";
            sw = rw;
            hw = r;
            reset = 0x3F;
        } g_secam[6:0];
    } DATE_COEFF30 @ 0xF278;

    reg {
        name = "Interrupt mask register";
        desc = "DATE_ISRMASK is an interrupt mask register. Huawei Proprietary and Confidential Hi3516A/Hi3516D Professional HD IP Camera SoC

Data sheet 10.2.6 DATE_ISRMASK (offset 0xF280, printed page 10-245, `hi3516av100--Hi3516A-Hi3516D-Datasheet.txt` line 72679).";

        enum DATE_ISRMASK_tt_mask_enum {
            ENABLED = 0 { name = "Enabled"; desc = "enabled"; };
            MASKED = 1 { name = "Masked"; desc = "masked"; };
        };

        field {
            name = "tt_mask";
            desc = "Teletext interrupt mask.";
            sw = rw;
            hw = r;
            encode = DATE_ISRMASK_tt_mask_enum;
            reset = 0x0;
        } tt_mask[0:0];
    } DATE_ISRMASK @ 0xF280;

    reg {
        name = "Interrupt status register";
        desc = "DATE_ISRSTATE is an interrupt status register.

Data sheet 10.2.6 DATE_ISRSTATE (offset 0xF284, printed page 10-245, `hi3516av100--Hi3516A-Hi3516D-Datasheet.txt` line 72703).";

        field {
            name = "tt_status";
            desc = "Teletext interrupt status. After the DATE module reads all the teletext data, the bit is set to 1. Writing 1 to this bit clears the interrupt.";
            sw = rw;
            hw = w;
            onwrite = woclr;
            reset = 0x0;
        } tt_status[0:0];
    } DATE_ISRSTATE @ 0xF284;

    reg {
        name = "Interrupt register";
        desc = "DATE_ISR is an interrupt register. Huawei Proprietary and Confidential Hi3516A/Hi3516D Professional HD IP Camera SoC

Data sheet 10.2.6 DATE_ISR (offset 0xF288, printed page 10-246, `hi3516av100--Hi3516A-Hi3516D-Datasheet.txt` line 72738).";

        field {
            name = "tt_int";
            desc = "Teletext interrupt. It shows the interrupt status after tt_status is masked by tt_mask.";
            sw = r;
            hw = w;
            reset = 0x0;
        } tt_int[0:0];
    } DATE_ISR @ 0xF288;

    reg {
        name = "Version register";
        desc = "DATE_VERSION is a version register. The data sheet lists no bit fields for it.

Data sheet 10.2.6 DATE_VERSION (offset 0xF290, printed page 10-246, `hi3516av100--Hi3516A-Hi3516D-Datasheet.txt` line 72761).";

        field {
            name = "value";
            desc = "Register value (the data sheet gives no bit table for this register).";
            sw = rw;
            hw = r;
            reset = 0x24;
        } value[31:0];
    } DATE_VERSION @ 0xF290;

    reg {
        name = "Up-sampling filtering coefficient register 1";
        desc = "DATE_COEFF37 is up-sampling filtering coefficient register 1.

Data sheet 10.2.6 DATE_COEFF37 (offset 0xF294, printed page 10-246, `hi3516av100--Hi3516A-Hi3516D-Datasheet.txt` line 72779).";

        field {
            name = "fir_y1_coeff3";
            desc = "Coefficient 13 for luminance up-sampling filtering.";
            sw = rw;
            hw = r;
            reset = 0x19;
        } fir_y1_coeff3[31:24];

        field {
            name = "fir_y1_coeff2";
            desc = "Coefficient 12 for luminance up-sampling filtering.";
            sw = rw;
            hw = r;
            reset = 0xEF;
        } fir_y1_coeff2[23:16];

        field {
            name = "fir_y1_coeff1";
            desc = "Coefficient 11 for luminance up-sampling filtering.";
            sw = rw;
            hw = r;
            reset = 0xC;
        } fir_y1_coeff1[15:8];

        field {
            name = "fir_y1_coeff0";
            desc = "Coefficient 10 for luminance up-sampling filtering.";
            sw = rw;
            hw = r;
            reset = 0xF9;
        } fir_y1_coeff0[7:0];
    } DATE_COEFF37 @ 0xF294;

    reg {
        name = "Up-sampling filtering coefficient register 2";
        desc = "DATE_COEFF38 is up-sampling filtering coefficient register 2.

Data sheet 10.2.6 DATE_COEFF38 (offset 0xF298, printed page 10-247, `hi3516av100--Hi3516A-Hi3516D-Datasheet.txt` line 72811).";

        field {
            name = "fir_y2_coeff1";
            desc = "Coefficient 21 for luminance up-sampling filtering.";
            sw = rw;
            hw = r;
            reset = 0x3A;
        } fir_y2_coeff1[31:16];

        field {
            name = "fir_y2_coeff0";
            desc = "Coefficient 20 for luminance up-sampling filtering.";
            sw = rw;
            hw = r;
            reset = 0xFFDA;
        } fir_y2_coeff0[15:0];
    } DATE_COEFF38 @ 0xF298;

    reg {
        name = "Up-sampling filtering coefficient register 3";
        desc = "DATE_COEFF39 is up-sampling filtering coefficient register 3.

Data sheet 10.2.6 DATE_COEFF39 (offset 0xF29C, printed page 10-247, `hi3516av100--Hi3516A-Hi3516D-Datasheet.txt` line 72830).";

        field {
            name = "fir_y2_coeff3";
            desc = "Coefficient 23 for luminance up-sampling filtering.";
            sw = rw;
            hw = r;
            reset = 0x148;
        } fir_y2_coeff3[31:16];

        field {
            name = "fir_y2_coeff2";
            desc = "Coefficient 22 for luminance up-sampling filtering.";
            sw = rw;
            hw = r;
            reset = 0xFF97;
        } fir_y2_coeff2[15:0];
    } DATE_COEFF39 @ 0xF29C;

    reg {
        name = "Up-sampling filtering coefficient register 4";
        desc = "DATE_COEFF40 is up-sampling filtering coefficient register 4. Huawei Proprietary and Confidential Hi3516A/Hi3516D Professional HD IP Camera SoC

Data sheet 10.2.6 DATE_COEFF40 (offset 0xF2A0, printed page 10-248, `hi3516av100--Hi3516A-Hi3516D-Datasheet.txt` line 72859).";

        field {
            name = "fir_c1_coeff3";
            desc = "Coefficient 13 for chrominance up-sampling filtering.";
            sw = rw;
            hw = r;
            reset = 0x19;
        } fir_c1_coeff3[31:24];

        field {
            name = "fir_c1_coeff2";
            desc = "Coefficient 12 for chrominance up-sampling filtering.";
            sw = rw;
            hw = r;
            reset = 0xEF;
        } fir_c1_coeff2[23:16];

        field {
            name = "fir_c1_coeff1";
            desc = "Coefficient 11 for chrominance up-sampling filtering.";
            sw = rw;
            hw = r;
            reset = 0xC;
        } fir_c1_coeff1[15:8];

        field {
            name = "fir_c1_coeff0";
            desc = "Coefficient 10 for chrominance up-sampling filtering.";
            sw = rw;
            hw = r;
            reset = 0xF9;
        } fir_c1_coeff0[7:0];
    } DATE_COEFF40 @ 0xF2A0;

    reg {
        name = "Up-sampling filtering coefficient register 5";
        desc = "DATE_COEFF41 is up-sampling filtering coefficient register 5.

Data sheet 10.2.6 DATE_COEFF41 (offset 0xF2A4, printed page 10-248, `hi3516av100--Hi3516A-Hi3516D-Datasheet.txt` line 72880).";

        field {
            name = "fir_c2_coeff1";
            desc = "Coefficient 21 for chrominance up-sampling filtering.";
            sw = rw;
            hw = r;
            reset = 0x3A;
        } fir_c2_coeff1[31:16];

        field {
            name = "fir_c2_coeff0";
            desc = "Coefficient 20 for chrominance up-sampling filtering.";
            sw = rw;
            hw = r;
            reset = 0xFFDA;
        } fir_c2_coeff0[15:0];
    } DATE_COEFF41 @ 0xF2A4;

    reg {
        name = "Up-sampling filtering coefficient register 6";
        desc = "DATE_COEFF42 is up-sampling filtering coefficient register 6.

Data sheet 10.2.6 DATE_COEFF42 (offset 0xF2A8, printed page 10-248, `hi3516av100--Hi3516A-Hi3516D-Datasheet.txt` line 72899).";

        field {
            name = "fir_c2_coeff3";
            desc = "Coefficient 23 for chrominance up-sampling filtering.";
            sw = rw;
            hw = r;
            reset = 0x148;
        } fir_c2_coeff3[31:16];

        field {
            name = "fir_c2_coeff2";
            desc = "Coefficient 22 for chrominance up-sampling filtering.";
            sw = rw;
            hw = r;
            reset = 0xFF97;
        } fir_c2_coeff2[15:0];
    } DATE_COEFF42 @ 0xF2A8;

    reg {
        name = "DAC automatic detection register 1";
        desc = "DATE_DACDET1 is DAC automatic detection register 1.

Data sheet 10.2.6 DATE_DACDET1 (offset 0xF2C0, printed page 10-249, `hi3516av100--Hi3516A-Hi3516D-Datasheet.txt` line 72928).";

        field {
            name = "det_line";
            desc = "Line of the detected level.";
            sw = rw;
            hw = r;
            reset = 0xD;
        } det_line[25:16];

        field {
            name = "vdac_det_high";
            desc = "Detected level.";
            sw = rw;
            hw = r;
            reset = 0x303;
        } vdac_det_high[9:0];
    } DATE_DACDET1 @ 0xF2C0;

    reg {
        name = "DAC automatic detection register 2";
        desc = "DATE_DACDET2 is DAC automatic detection register 2.

Data sheet 10.2.6 DATE_DACDET2 (offset 0xF2C4, printed page 10-249, `hi3516av100--Hi3516A-Hi3516D-Datasheet.txt` line 72949).";

        enum DATE_DACDET2_vdac_det_en_enum {
            DISABLED = 0 { name = "Disabled"; desc = "disabled"; };
            ENABLED = 1 { name = "Enabled"; desc = "enabled"; };
        };

        field {
            name = "vdac_det_en";
            desc = "DAC automatic detection enable.";
            sw = rw;
            hw = r;
            encode = DATE_DACDET2_vdac_det_en_enum;
            reset = 0x0;
        } vdac_det_en[31:31];

        field {
            name = "det_pixel_wid";
            desc = "Level width.";
            sw = rw;
            hw = r;
            reset = 0x30;
        } det_pixel_wid[26:16];

        field {
            name = "det_pixel_sta";
            desc = "Start position of a line.";
            sw = rw;
            hw = r;
            reset = 0x118;
        } det_pixel_sta[10:0];
    } DATE_DACDET2 @ 0xF2C4;

    reg {
        name = "Over-sampling filtering coefficient register 1";
        desc = "DATE_COEFF50 is over-sampling filtering coefficient register 1.

Data sheet 10.2.6 DATE_COEFF50 (offset 0xF2C8, printed page 10-250, `hi3516av100--Hi3516A-Hi3516D-Datasheet.txt` line 72989).";

        field {
            name = "ovs_coeff1";
            desc = "Coefficient 11 for luminance over-sampling filtering.";
            sw = rw;
            hw = r;
            reset = 0x7FF;
        } ovs_coeff1[26:16];

        field {
            name = "ovs_coeff0";
            desc = "Coefficient 10 for luminance over-sampling filtering.";
            sw = rw;
            hw = r;
            reset = 0x7FF;
        } ovs_coeff0[10:0];
    } DATE_COEFF50 @ 0xF2C8;

    reg {
        name = "Over-sampling filtering coefficient register 2";
        desc = "DATE_COEFF51 is over-sampling filtering coefficient register 2.

Data sheet 10.2.6 DATE_COEFF51 (offset 0xF2CC, printed page 10-250, `hi3516av100--Hi3516A-Hi3516D-Datasheet.txt` line 73010).";

        field {
            name = "ovs_coeff1";
            desc = "Coefficient 21 for luminance over-sampling filtering.";
            sw = rw;
            hw = r;
            reset = 0x7FF;
        } ovs_coeff1[26:16];

        field {
            name = "ovs_coeff0";
            desc = "Coefficient 20 for luminance over-sampling filtering.";
            sw = rw;
            hw = r;
            reset = 0x204;
        } ovs_coeff0[10:0];
    } DATE_COEFF51 @ 0xF2CC;

    reg {
        name = "Over-sampling filtering coefficient register 3";
        desc = "DATE_COEFF52 is over-sampling filtering coefficient register 3. Huawei Proprietary and Confidential Hi3516A/Hi3516D Professional HD IP Camera SoC

Data sheet 10.2.6 DATE_COEFF52 (offset 0xF2D0, printed page 10-251, `hi3516av100--Hi3516A-Hi3516D-Datasheet.txt` line 73040).";

        field {
            name = "ovs_coeff1";
            desc = "Coefficient 31 for luminance over-sampling filtering.";
            sw = rw;
            hw = r;
            reset = 0x0;
        } ovs_coeff1[26:16];

        field {
            name = "ovs_coeff0";
            desc = "Coefficient 30 for luminance over-sampling filtering.";
            sw = rw;
            hw = r;
            reset = 0x7FF;
        } ovs_coeff0[10:0];
    } DATE_COEFF52 @ 0xF2D0;

    reg {
        name = "Over-sampling filtering coefficient register 4";
        desc = "DATE_COEFF53 is over-sampling filtering coefficient register 4.

Data sheet 10.2.6 DATE_COEFF53 (offset 0xF2D4, printed page 10-251, `hi3516av100--Hi3516A-Hi3516D-Datasheet.txt` line 73061).";

        field {
            name = "ovs_coeff1";
            desc = "Coefficient 41 for luminance over-sampling filtering.";
            sw = rw;
            hw = r;
            reset = 0x7BF;
        } ovs_coeff1[26:16];

        field {
            name = "ovs_coeff0";
            desc = "Coefficient 40 for luminance over-sampling filtering.";
            sw = rw;
            hw = r;
            reset = 0xC;
        } ovs_coeff0[10:0];
    } DATE_COEFF53 @ 0xF2D4;

    reg {
        name = "Over-sampling filtering coefficient register 5";
        desc = "DATE_COEFF54 is over-sampling filtering coefficient register 5. Huawei Proprietary and Confidential Hi3516A/Hi3516D Professional HD IP Camera SoC

Data sheet 10.2.6 DATE_COEFF54 (offset 0xF2D8, printed page 10-252, `hi3516av100--Hi3516A-Hi3516D-Datasheet.txt` line 73092).";

        field {
            name = "ovs_coeff1";
            desc = "Coefficient 51 for luminance over-sampling filtering.";
            sw = rw;
            hw = r;
            reset = 0x135;
        } ovs_coeff1[26:16];

        field {
            name = "ovs_coeff0";
            desc = "Coefficient 50 for luminance over-sampling filtering.";
            sw = rw;
            hw = r;
            reset = 0x135;
        } ovs_coeff0[10:0];
    } DATE_COEFF54 @ 0xF2D8;

    reg {
        name = "Over-sampling filtering coefficient register 6";
        desc = "DATE_COEFF55 is over-sampling filtering coefficient register 6.

Data sheet 10.2.6 DATE_COEFF55 (offset 0xF2DC, printed page 10-252, `hi3516av100--Hi3516A-Hi3516D-Datasheet.txt` line 73113).";

        field {
            name = "ovs_coeff1";
            desc = "Coefficient 61 for luminance over-sampling filtering.";
            sw = rw;
            hw = r;
            reset = 0xC;
        } ovs_coeff1[26:16];

        field {
            name = "ovs_coeff0";
            desc = "Coefficient 60 for luminance over-sampling filtering.";
            sw = rw;
            hw = r;
            reset = 0x7BF;
        } ovs_coeff0[10:0];
    } DATE_COEFF55 @ 0xF2DC;

    reg {
        name = "Over-sampling round-off register";
        desc = "DATE_COEFF56 is an over-sampling round-off register. Huawei Proprietary and Confidential Hi3516A/Hi3516D Professional HD IP Camera SoC

Data sheet 10.2.6 DATE_COEFF56 (offset 0xF2E0, printed page 10-253, `hi3516av100--Hi3516A-Hi3516D-Datasheet.txt` line 73144).";

        enum DATE_COEFF56_oversam2_round_en_enum {
            DISABLED = 0 { name = "Disabled"; desc = "disabled"; };
            ENABLED = 1 { name = "Enabled"; desc = "enabled"; };
        };

        field {
            name = "oversam2_round_en";
            desc = "Round-off enable during 2x over-sampling.";
            sw = rw;
            hw = r;
            encode = DATE_COEFF56_oversam2_round_en_enum;
            reset = 0x0;
        } oversam2_round_en[0:0];
    } DATE_COEFF56 @ 0xF2E0;

    reg {
        name = "CVBS gain control register";
        desc = "DATE_COEFF57 is a CVBS gain control register.

Data sheet 10.2.6 DATE_COEFF57 (offset 0xF2E4, printed page 10-253, `hi3516av100--Hi3516A-Hi3516D-Datasheet.txt` line 73174).";

        enum DATE_COEFF57_cvbs_gain_en_enum {
            DISABLED = 0 { name = "Disabled"; desc = "disabled"; };
            ENABLED = 1 { name = "Enabled"; desc = "enabled"; };
        };

        field {
            name = "cvbs_gain_en";
            desc = "CVBS gain enable.";
            sw = rw;
            hw = r;
            encode = DATE_COEFF57_cvbs_gain_en_enum;
            reset = 0x0;
        } cvbs_gain_en[31:31];

        field {
            name = "ycvbs_gain";
            desc = "Gain of the luminance component Y.";
            sw = rw;
            hw = r;
            reset = 0x0;
        } ycvbs_gain[23:16];

        field {
            name = "u_gain";
            desc = "Gain of the chrominance component U.";
            sw = rw;
            hw = r;
            reset = 0x0;
        } u_gain[15:8];

        field {
            name = "v_gain";
            desc = "Gain of the chrominance component V.";
            sw = rw;
            hw = r;
            reset = 0x0;
        } v_gain[7:0];
    } DATE_COEFF57 @ 0xF2E4;

    reg {
        name = "Component gain control register";
        desc = "DATE_COEFF58 is a component gain control register.

Data sheet 10.2.6 DATE_COEFF58 (offset 0xF2E8, printed page 10-254, `hi3516av100--Hi3516A-Hi3516D-Datasheet.txt` line 73213).";

        enum DATE_COEFF58_comp_gain_en_enum {
            DISABLED = 0 { name = "Disabled"; desc = "disabled"; };
            ENABLED = 1 { name = "Enabled"; desc = "enabled"; };
        };

        field {
            name = "comp_gain_en";
            desc = "Component gain enable.";
            sw = rw;
            hw = r;
            encode = DATE_COEFF58_comp_gain_en_enum;
            reset = 0x0;
        } comp_gain_en[31:31];

        field {
            name = "ycomp_gain";
            desc = "Gain of the luminance component Y.";
            sw = rw;
            hw = r;
            reset = 0x0;
        } ycomp_gain[23:16];

        field {
            name = "pb_gain";
            desc = "Gain of the chrominance component U.";
            sw = rw;
            hw = r;
            reset = 0x0;
        } pb_gain[15:8];

        field {
            name = "pr_gain";
            desc = "Gain of the chrominance component V.";
            sw = rw;
            hw = r;
            reset = 0x0;
        } pr_gain[7:0];
    } DATE_COEFF58 @ 0xF2E8;

    reg {
        name = "Clip control register";
        desc = "DATE_COEFF59 is a clip control register. Huawei Proprietary and Confidential Hi3516A/Hi3516D Professional HD IP Camera SoC

Data sheet 10.2.6 DATE_COEFF59 (offset 0xF2EC, printed page 10-255, `hi3516av100--Hi3516A-Hi3516D-Datasheet.txt` line 73254).";

        field {
            name = "cb_gain_polar";
            desc = "Chrominance subcarrier polarity.";
            sw = rw;
            hw = r;
            reset = 0x0;
        } cb_gain_polar[16:16];

        enum DATE_COEFF59_cr_os_clip_fullrange_enum {
            DISABLED = 0 { name = "Disabled"; desc = "disabled"; };
            ENABLED = 1 { name = "Enabled"; desc = "enabled"; };
        };

        field {
            name = "cr_os_clip_fullrange";
            desc = "Cr component clip enable on the up-sampling module.";
            sw = rw;
            hw = r;
            encode = DATE_COEFF59_cr_os_clip_fullrange_enum;
            reset = 0x0;
        } cr_os_clip_fullrange[13:13];

        enum DATE_COEFF59_cb_os_clip_fullrange_enum {
            DISABLED = 0 { name = "Disabled"; desc = "disabled"; };
            ENABLED = 1 { name = "Enabled"; desc = "enabled"; };
        };

        field {
            name = "cb_os_clip_fullrange";
            desc = "Cb component clip enable on the up-sampling module.";
            sw = rw;
            hw = r;
            encode = DATE_COEFF59_cb_os_clip_fullrange_enum;
            reset = 0x0;
        } cb_os_clip_fullrange[12:12];

        enum DATE_COEFF59_v_os_clip_fullrange_enum {
            DISABLED = 0 { name = "Disabled"; desc = "disabled"; };
            ENABLED = 1 { name = "Enabled"; desc = "enabled"; };
        };

        field {
            name = "v_os_clip_fullrange";
            desc = "V component clip enable on the up-sampling module.";
            sw = rw;
            hw = r;
            encode = DATE_COEFF59_v_os_clip_fullrange_enum;
            reset = 0x0;
        } v_os_clip_fullrange[9:9];

        enum DATE_COEFF59_u_os_clip_fullrange_enum {
            DISABLED = 0 { name = "Disabled"; desc = "disabled"; };
            ENABLED = 1 { name = "Enabled"; desc = "enabled"; };
        };

        field {
            name = "u_os_clip_fullrange";
            desc = "U component clip enable on the up-sampling module.";
            sw = rw;
            hw = r;
            encode = DATE_COEFF59_u_os_clip_fullrange_enum;
            reset = 0x0;
        } u_os_clip_fullrange[8:8];

        enum DATE_COEFF59_y_os_clip_fullrange_enum {
            DISABLED = 0 { name = "Disabled"; desc = "disabled"; };
            ENABLED = 1 { name = "Enabled"; desc = "enabled"; };
        };

        field {
            name = "y_os_clip_fullrange";
            desc = "Y component clip enable on the up-sampling module.";
            sw = rw;
            hw = r;
            encode = DATE_COEFF59_y_os_clip_fullrange_enum;
            reset = 0x0;
        } y_os_clip_fullrange[4:4];

        enum DATE_COEFF59_clpf_clip_fullrange_enum {
            DISABLED = 0 { name = "Disabled"; desc = "disabled"; };
            ENABLED = 1 { name = "Enabled"; desc = "enabled"; };
        };

        field {
            name = "clpf_clip_fullrange";
            desc = "Chrominance low-pass module clip enable.";
            sw = rw;
            hw = r;
            encode = DATE_COEFF59_clpf_clip_fullrange_enum;
            reset = 0x0;
        } clpf_clip_fullrange[1:1];

        enum DATE_COEFF59_ynotch_clip_fullrange_enum {
            DISABLED = 0 { name = "Disabled"; desc = "disabled"; };
            ENABLED = 1 { name = "Enabled"; desc = "enabled"; };
        };

        field {
            name = "ynotch_clip_fullrange";
            desc = "Luminance notch module clip enable.";
            sw = rw;
            hw = r;
            encode = DATE_COEFF59_ynotch_clip_fullrange_enum;
            reset = 0x0;
        } ynotch_clip_fullrange[0:0];
    } DATE_COEFF59 @ 0xF2EC;

    reg {
        name = "DATE COEFF60";
        desc = "[inferred] DATE COEFF60. Not in the data sheet. Source: vendor U-Boot 2010.06 `product/hiosd/vo/hi3516a/vou_reg.h` (GPL-2.0 U-Boot tree, HiSilicon copyright, created 2013-04-27; mirror github.com/OpenIPC/u-boot-hi3516cv200), union `U_DATE_COEFF60`, struct offset 0xF2F0 (GPL-2.0, same-chip vendor header). Reset value and access type unknown (modelled RW, no reset). Confidence: medium (vendor header for this chip family, not hardware verified).";

        field {
            name = "line_960h_en";
            desc = "[inferred] Line 960h enable. (vendor header `product/hiosd/vo/hi3516a/vou_reg.h` field `line_960h_en`; access and reset unknown, modelled RW)";
            sw = rw;
            hw = r;
        } line_960h_en[0:0];
    } DATE_COEFF60 @ 0xF2F0;

    reg {
        name = "Timing global control register";
        desc = "DATE_COEFF61 is a timing global control register.

Data sheet 10.2.6 DATE_COEFF61 (offset 0xF2F4, printed page 10-256, `hi3516av100--Hi3516A-Hi3516D-Datasheet.txt` line 73323).";

        enum DATE_COEFF61_rgb_acrive_ovrd_enum {
            CONFIGURED_RGB_ACTIVE = 0 { name = "Configured Rgb Active"; desc = "The configured RGB active region does not take effect."; };
            CONFIGURED_RGB_ACTIVE_2 = 1 { name = "Configured Rgb Active 2"; desc = "The configured RGB active region takes effect."; };
        };

        field {
            name = "rgb_acrive_ovrd";
            desc = "Global control for the RGB active region coefficient configuration register.";
            sw = rw;
            hw = r;
            encode = DATE_COEFF61_rgb_acrive_ovrd_enum;
            reset = 0x0;
        } rgb_acrive_ovrd[4:4];

        enum DATE_COEFF61_pal_half_ovrd_enum {
            CONFIGURED_PAL_HALF = 0 { name = "Configured Pal Half"; desc = "The configured PAL half line does not take effect."; };
            CONFIGURED_PAL_HALF_2 = 1 { name = "Configured Pal Half 2"; desc = "The configured PAL half line takes effect."; };
        };

        field {
            name = "pal_half_ovrd";
            desc = "Global control for the PAL half-line coefficient configuration register.";
            sw = rw;
            hw = r;
            encode = DATE_COEFF61_pal_half_ovrd_enum;
            reset = 0x0;
        } pal_half_ovrd[3:3];

        enum DATE_COEFF61_cb_bound_ovrd_enum {
            CONFIGURED_CHROMINANCE_SUBCARR = 0 { name = "Configured Chrominance Subcarr"; desc = "The configured chrominance subcarrier boundary does not take effect."; };
            CONFIGURED_CHROMINANCE_SUBCARR_2 = 1 { name = "Configured Chrominance Subcarr 2"; desc = "The configured chrominance subcarrier boundary takes effect."; };
        };

        field {
            name = "cb_bound_ovrd";
            desc = "Global control for the chrominance subcarrier boundary coefficient configuration register.";
            sw = rw;
            hw = r;
            encode = DATE_COEFF61_cb_bound_ovrd_enum;
            reset = 0x0;
        } cb_bound_ovrd[2:2];

        enum DATE_COEFF61_burst_dura_ovrd_enum {
            CONFIGURED_CHROMINANCE_CARRIER = 0 { name = "Configured Chrominance Carrier"; desc = "The configured chrominance carrier duration does not take effect."; };
            CONFIGURED_CHROMINANCE_CARRIER_2 = 1 { name = "Configured Chrominance Carrier 2"; desc = "The configured chrominance carrier duration takes effect."; };
        };

        field {
            name = "burst_dura_ovrd";
            desc = "Global control for the chrominance carrier duration coefficient configuration register.";
            sw = rw;
            hw = r;
            encode = DATE_COEFF61_burst_dura_ovrd_enum;
            reset = 0x0;
        } burst_dura_ovrd[1:1];

        enum DATE_COEFF61_burst_start_ovrd_enum {
            CONFIGURED_CHROMINANCE_CARRIER = 0 { name = "Configured Chrominance Carrier"; desc = "The configured chrominance carrier start position does not take effect."; };
            CONFIGURED_CHROMINANCE_CARRIER_2 = 1 { name = "Configured Chrominance Carrier 2"; desc = "The configured chrominance carrier start position takes effect."; };
        };

        field {
            name = "burst_start_ovrd";
            desc = "Global control for the chrominance carrier start position coefficient configuration register.";
            sw = rw;
            hw = r;
            encode = DATE_COEFF61_burst_start_ovrd_enum;
            reset = 0x0;
        } burst_start_ovrd[0:0];
    } DATE_COEFF61 @ 0xF2F4;

    reg {
        name = "Chrominance subcarrier duration control register";
        desc = "DATE_COEFF62 is a chrominance subcarrier duration control register.

Data sheet 10.2.6 DATE_COEFF62 (offset 0xF2F8, printed page 10-257, `hi3516av100--Hi3516A-Hi3516D-Datasheet.txt` line 73384).";

        field {
            name = "burst_dura_coeff";
            desc = "Chrominance carrier duration.";
            sw = rw;
            hw = r;
            reset = 0x0;
        } burst_dura_coeff[31:0];
    } DATE_COEFF62 @ 0xF2F8;

    reg {
        name = "Chrominance subcarrier boundary control register";
        desc = "DATE_COEFF63 is a chrominance subcarrier boundary control register.

Data sheet 10.2.6 DATE_COEFF63 (offset 0xF2FC, printed page 10-257, `hi3516av100--Hi3516A-Hi3516D-Datasheet.txt` line 73402).";

        field {
            name = "cb_bound_coeff";
            desc = "Chrominance subcarrier boundary.";
            sw = rw;
            hw = r;
            reset = 0x0;
        } cb_bound_coeff[31:0];
    } DATE_COEFF63 @ 0xF2FC;

    reg {
        name = "PAL half-line control register";
        desc = "DATE_COEFF64 is a PAL half-line control register. Huawei Proprietary and Confidential Hi3516A/Hi3516D Professional HD IP Camera SoC

Data sheet 10.2.6 DATE_COEFF64 (offset 0xF300, printed page 10-258, `hi3516av100--Hi3516A-Hi3516D-Datasheet.txt` line 73430).";

        field {
            name = "pal_half_coeff";
            desc = "PAL half line.";
            sw = rw;
            hw = r;
            reset = 0x0;
        } pal_half_coeff[31:0];
    } DATE_COEFF64 @ 0xF300;

    reg {
        name = "RGB active region control register";
        desc = "DATE_COEFF65 is an RGB active region control register.

Data sheet 10.2.6 DATE_COEFF65 (offset 0xF304, printed page 10-258, `hi3516av100--Hi3516A-Hi3516D-Datasheet.txt` line 73448).";

        field {
            name = "rgb_active_coeff";
            desc = "RGB active region.";
            sw = rw;
            hw = r;
            reset = 0x0;
        } rgb_active_coeff[31:0];
    } DATE_COEFF65 @ 0xF304;

    reg {
        name = "Sync timing global control register";
        desc = "DATE_COEFF66 is a sync timing global control register.

Data sheet 10.2.6 DATE_COEFF66 (offset 0xF308, printed page 10-258, `hi3516av100--Hi3516A-Hi3516D-Datasheet.txt` line 73466).";

        enum DATE_COEFF66_wid_act_ovrd_enum {
            CONFIGURED_TIMING_ACTIVE = 0 { name = "Configured Timing Active"; desc = "The configured timing active region does not take effect."; };
            CONFIGURED_TIMING_ACTIVE_2 = 1 { name = "Configured Timing Active 2"; desc = "The configured timing active region takes effect."; };
        };

        field {
            name = "wid_act_ovrd";
            desc = "Timing global control.";
            sw = rw;
            hw = r;
            encode = DATE_COEFF66_wid_act_ovrd_enum;
            reset = 0x0;
        } wid_act_ovrd[3:3];

        enum DATE_COEFF66_wid_hfb_ovrd_enum {
            HFB_CONFIGURATION_DOES = 0 { name = "Hfb Configuration Does"; desc = "The HFB configuration does not take effect."; };
            HFB_CONFIGURATION_TAKES = 1 { name = "Hfb Configuration Takes"; desc = "The HFB configuration takes effect."; };
        };

        field {
            name = "wid_hfb_ovrd";
            desc = "Timing global control.";
            sw = rw;
            hw = r;
            encode = DATE_COEFF66_wid_hfb_ovrd_enum;
            reset = 0x0;
        } wid_hfb_ovrd[2:2];

        enum DATE_COEFF66_wid_sync_ovrd_enum {
            CONFIGURED_SYNC_HEADER = 0 { name = "Configured Sync Header"; desc = "The configured sync header width does not take effect."; };
            CONFIGURED_SYNC_HEADER_2 = 1 { name = "Configured Sync Header 2"; desc = "The configured sync header width takes effect."; };
        };

        field {
            name = "wid_sync_ovrd";
            desc = "Timing global control.";
            sw = rw;
            hw = r;
            encode = DATE_COEFF66_wid_sync_ovrd_enum;
            reset = 0x0;
        } wid_sync_ovrd[1:1];

        enum DATE_COEFF66_htotal_ovrd_enum {
            CONFIGURED_TOTAL_LINE = 0 { name = "Configured Total Line"; desc = "The configured total line point number does not take effect."; };
            CONFIGURED_TOTAL_LINE_2 = 1 { name = "Configured Total Line 2"; desc = "The configured total line point number takes effect."; };
        };

        field {
            name = "htotal_ovrd";
            desc = "Timing global control.";
            sw = rw;
            hw = r;
            encode = DATE_COEFF66_htotal_ovrd_enum;
            reset = 0x0;
        } htotal_ovrd[0:0];
    } DATE_COEFF66 @ 0xF308;

    reg {
        name = "Line point quantity configuration register";
        desc = "DATE_COEFF67 is a line point quantity configuration register.

Data sheet 10.2.6 DATE_COEFF67 (offset 0xF30C, printed page 10-259, `hi3516av100--Hi3516A-Hi3516D-Datasheet.txt` line 73514).";

        field {
            name = "htotal_sw";
            desc = "Total number of line points.";
            sw = rw;
            hw = r;
            reset = 0x0;
        } htotal_sw[11:0];
    } DATE_COEFF67 @ 0xF30C;

    reg {
        name = "Sync width configuration register";
        desc = "DATE_COEFF68 is a sync width configuration register.

Data sheet 10.2.6 DATE_COEFF68 (offset 0xF310, printed page 10-259, `hi3516av100--Hi3516A-Hi3516D-Datasheet.txt` line 73533).";

        field {
            name = "wid_sync_sw";
            desc = "Sync width.";
            sw = rw;
            hw = r;
            reset = 0x0;
        } wid_sync_sw[11:0];
    } DATE_COEFF68 @ 0xF310;

    reg {
        name = "Horizontal front blanking (HFB) configuration register";
        desc = "DATE_COEFF69 is an HFB configuration register.

Data sheet 10.2.6 DATE_COEFF69 (offset 0xF314, printed page 10-260, `hi3516av100--Hi3516A-Hi3516D-Datasheet.txt` line 73561).";

        field {
            name = "wid_hfb_sw";
            desc = "HFB.";
            sw = rw;
            hw = r;
            reset = 0x0;
        } wid_hfb_sw[11:0];
    } DATE_COEFF69 @ 0xF314;

    reg {
        name = "Line active configuration register";
        desc = "DATE_COEFF70 is a line active configuration register.

Data sheet 10.2.6 DATE_COEFF70 (offset 0xF318, printed page 10-260, `hi3516av100--Hi3516A-Hi3516D-Datasheet.txt` line 73580).";

        field {
            name = "wid_act_sw";
            desc = "Line active region.";
            sw = rw;
            hw = r;
            reset = 0x0;
        } wid_act_sw[11:0];
    } DATE_COEFF70 @ 0xF318;

    reg {
        name = "Phase shift global control register";
        desc = "DATE_COEFF71 is a phase shift global control register. Huawei Proprietary and Confidential Hi3516A/Hi3516D Professional HD IP Camera SoC

Data sheet 10.2.6 DATE_COEFF71 (offset 0xF31C, printed page 10-261, `hi3516av100--Hi3516A-Hi3516D-Datasheet.txt` line 73609).";

        enum DATE_COEFF71_phase_shift_ovrd_enum {
            PHASE_SHIFT_REGISTER = 0 { name = "Phase Shift Register"; desc = "The phase shift register does not take effect."; };
            PHASE_SHIFT_REGISTER_2 = 1 { name = "Phase Shift Register 2"; desc = "The phase shift register takes effect."; };
        };

        field {
            name = "phase_shift_ovrd";
            desc = "Phase shift global control.";
            sw = rw;
            hw = r;
            encode = DATE_COEFF71_phase_shift_ovrd_enum;
            reset = 0x0;
        } phase_shift_ovrd[0:0];
    } DATE_COEFF71 @ 0xF31C;

    reg {
        name = "Phase shift register";
        desc = "DATE_COEFF72 is a phase shift register.

Data sheet 10.2.6 DATE_COEFF72 (offset 0xF320, printed page 10-261, `hi3516av100--Hi3516A-Hi3516D-Datasheet.txt` line 73637).";

        field {
            name = "phase_shift_coeff";
            desc = "Phase shift.";
            sw = rw;
            hw = r;
            reset = 0x0;
        } phase_shift_coeff[31:0];
    } DATE_COEFF72 @ 0xF320;

    reg {
        name = "Luminance notch coefficient global control register";
        desc = "DATE_COEFF73 is a luminance notch coefficient global control register. Huawei Proprietary and Confidential Hi3516A/Hi3516D Professional HD IP Camera SoC

Data sheet 10.2.6 DATE_COEFF73 (offset 0xF324, printed page 10-262, `hi3516av100--Hi3516A-Hi3516D-Datasheet.txt` line 73665).";

        field {
            name = "coef_notch_2";
            desc = "[inferred] Coefficient notch 2. (bits reserved in the data sheet; vendor header `product/hiosd/vo/hi3516a/vou_reg.h` field `coef_notch_2`; access and reset unknown, modelled RW)";
            sw = rw;
            hw = r;
        } coef_notch_2[25:16];

        field {
            name = "coef_notch_ovrd";
            desc = "Luminance notch coefficient validate.";
            sw = rw;
            hw = r;
            reset = 0x0;
        } coef_notch_ovrd[0:0];
    } DATE_COEFF73 @ 0xF324;

    reg {
        name = "Luminance notch coefficient register 1";
        desc = "DATE_COEFF74 is luminance notch coefficient register 1.

Data sheet 10.2.6 DATE_COEFF74 (offset 0xF328, printed page 10-262, `hi3516av100--Hi3516A-Hi3516D-Datasheet.txt` line 73691).";

        field {
            name = "coef_notch_2";
            desc = "Luminance notch coefficient 2.";
            sw = rw;
            hw = r;
            reset = 0x0;
        } coef_notch_2[25:16];

        field {
            name = "coef_notch_1";
            desc = "Luminance notch coefficient 1.";
            sw = rw;
            hw = r;
            reset = 0x0;
        } coef_notch_1[9:0];
    } DATE_COEFF74 @ 0xF328;

    reg {
        name = "Luminance notch coefficient register 2";
        desc = "DATE_COEFF75 is luminance notch coefficient register 2. Huawei Proprietary and Confidential Hi3516A/Hi3516D Professional HD IP Camera SoC

Data sheet 10.2.6 DATE_COEFF75 (offset 0xF32C, printed page 10-263, `hi3516av100--Hi3516A-Hi3516D-Datasheet.txt` line 73722).";

        field {
            name = "coef_notch_4";
            desc = "Luminance notch coefficient 4.";
            sw = rw;
            hw = r;
            reset = 0x0;
        } coef_notch_4[25:16];

        field {
            name = "coef_notch_3";
            desc = "Luminance notch coefficient 3.";
            sw = rw;
            hw = r;
            reset = 0x0;
        } coef_notch_3[9:0];
    } DATE_COEFF75 @ 0xF32C;

    reg {
        name = "Luminance notch coefficient register 3";
        desc = "DATE_COEFF76 is luminance notch coefficient register 3.

Data sheet 10.2.6 DATE_COEFF76 (offset 0xF330, printed page 10-263, `hi3516av100--Hi3516A-Hi3516D-Datasheet.txt` line 73743).";

        field {
            name = "coef_notch_6";
            desc = "Luminance notch coefficient 6.";
            sw = rw;
            hw = r;
            reset = 0x0;
        } coef_notch_6[25:16];

        field {
            name = "coef_notch_5";
            desc = "Luminance notch coefficient 5.";
            sw = rw;
            hw = r;
            reset = 0x0;
        } coef_notch_5[9:0];
    } DATE_COEFF76 @ 0xF330;

    reg {
        name = "Luminance notch coefficient register 4";
        desc = "DATE_COEFF77 is luminance notch coefficient register 4. Huawei Proprietary and Confidential Hi3516A/Hi3516D Professional HD IP Camera SoC

Data sheet 10.2.6 DATE_COEFF77 (offset 0xF334, printed page 10-264, `hi3516av100--Hi3516A-Hi3516D-Datasheet.txt` line 73774).";

        field {
            name = "coef_notch_8";
            desc = "Luminance notch coefficient 8.";
            sw = rw;
            hw = r;
            reset = 0x0;
        } coef_notch_8[25:16];

        field {
            name = "coef_notch_7";
            desc = "Luminance notch coefficient 7.";
            sw = rw;
            hw = r;
            reset = 0x0;
        } coef_notch_7[9:0];
    } DATE_COEFF77 @ 0xF334;

    reg {
        name = "Luminance notch coefficient register 5";
        desc = "DATE_COEFF78 is luminance notch coefficient register 5.

Data sheet 10.2.6 DATE_COEFF78 (offset 0xF338, printed page 10-264, `hi3516av100--Hi3516A-Hi3516D-Datasheet.txt` line 73795).";

        field {
            name = "coef_notch_10";
            desc = "Luminance notch coefficient 10.";
            sw = rw;
            hw = r;
            reset = 0x0;
        } coef_notch_10[25:16];

        field {
            name = "coef_notch_9";
            desc = "Luminance notch coefficient 9.";
            sw = rw;
            hw = r;
            reset = 0x0;
        } coef_notch_9[9:0];
    } DATE_COEFF78 @ 0xF338;

    reg {
        name = "Luminance notch coefficient register 6";
        desc = "DATE_COEFF79 is luminance notch coefficient register 6. Huawei Proprietary and Confidential Hi3516A/Hi3516D Professional HD IP Camera SoC

Data sheet 10.2.6 DATE_COEFF79 (offset 0xF33C, printed page 10-265, `hi3516av100--Hi3516A-Hi3516D-Datasheet.txt` line 73826).";

        field {
            name = "coef_notch_12";
            desc = "Luminance notch coefficient 12.";
            sw = rw;
            hw = r;
            reset = 0x0;
        } coef_notch_12[25:16];

        field {
            name = "coef_notch_11";
            desc = "Luminance notch coefficient 11.";
            sw = rw;
            hw = r;
            reset = 0x0;
        } coef_notch_11[9:0];
    } DATE_COEFF79 @ 0xF33C;

    reg {
        name = "Chrominance low-pass coefficient global control register";
        desc = "DATE_COEFF80 is a chrominance low-pass coefficient global control register.

Data sheet 10.2.6 DATE_COEFF80 (offset 0xF340, printed page 10-265, `hi3516av100--Hi3516A-Hi3516D-Datasheet.txt` line 73847).";

        field {
            name = "coef_chra_lpf_2";
            desc = "[inferred] Coefficient chra lpf 2. (bits reserved in the data sheet; vendor header `product/hiosd/vo/hi3516a/vou_reg.h` field `coef_chra_lpf_2`; access and reset unknown, modelled RW)";
            sw = rw;
            hw = r;
        } coef_chra_lpf_2[24:16];

        enum DATE_COEFF80_coef_chra_lpf_ovrd_enum {
            CHROMINANCE_LOW_PASS = 0 { name = "Chrominance Low Pass"; desc = "The chrominance low-pass coefficient does not take effect."; };
            CHROMINANCE_LOW_PASS_2 = 1 { name = "Chrominance Low Pass 2"; desc = "The chrominance low-pass coefficient takes effect."; };
        };

        field {
            name = "coef_chra_lpf_ovrd";
            desc = "Chrominance low-pass coefficient global control.";
            sw = rw;
            hw = r;
            encode = DATE_COEFF80_coef_chra_lpf_ovrd_enum;
            reset = 0x0;
        } coef_chra_lpf_ovrd[0:0];
    } DATE_COEFF80 @ 0xF340;

    reg {
        name = "Chrominance low-pass coefficient register 1";
        desc = "DATE_COEFF81 is chrominance low-pass coefficient register 1. Huawei Proprietary and Confidential Hi3516A/Hi3516D Professional HD IP Camera SoC

Data sheet 10.2.6 DATE_COEFF81 (offset 0xF344, printed page 10-266, `hi3516av100--Hi3516A-Hi3516D-Datasheet.txt` line 73885).";

        field {
            name = "coef_chra_lpf_2";
            desc = "Chrominance low-pass coefficient 2.";
            sw = rw;
            hw = r;
            reset = 0x0;
        } coef_chra_lpf_2[24:16];

        field {
            name = "coef_chra_lpf_1";
            desc = "Chrominance low-pass coefficient 1.";
            sw = rw;
            hw = r;
            reset = 0x0;
        } coef_chra_lpf_1[8:0];
    } DATE_COEFF81 @ 0xF344;

    reg {
        name = "Chrominance low-pass coefficient register 2";
        desc = "DATE_COEFF82 is chrominance low-pass coefficient register 2.

Data sheet 10.2.6 DATE_COEFF82 (offset 0xF348, printed page 10-266, `hi3516av100--Hi3516A-Hi3516D-Datasheet.txt` line 73906).";

        field {
            name = "coef_chra_lpf_4";
            desc = "Chrominance low-pass coefficient 4.";
            sw = rw;
            hw = r;
            reset = 0x0;
        } coef_chra_lpf_4[24:16];

        field {
            name = "coef_chra_lpf_3";
            desc = "Chrominance low-pass coefficient 3.";
            sw = rw;
            hw = r;
            reset = 0x0;
        } coef_chra_lpf_3[8:0];
    } DATE_COEFF82 @ 0xF348;

    reg {
        name = "Chrominance low-pass coefficient register 3";
        desc = "DATE_COEFF83 is chrominance low-pass coefficient register 3. Huawei Proprietary and Confidential Hi3516A/Hi3516D Professional HD IP Camera SoC

Data sheet 10.2.6 DATE_COEFF83 (offset 0xF34C, printed page 10-267, `hi3516av100--Hi3516A-Hi3516D-Datasheet.txt` line 73937).";

        field {
            name = "coef_chra_lpf_6";
            desc = "Chrominance low-pass coefficient 6.";
            sw = rw;
            hw = r;
            reset = 0x0;
        } coef_chra_lpf_6[24:16];

        field {
            name = "coef_chra_lpf_5";
            desc = "Chrominance low-pass coefficient 5.";
            sw = rw;
            hw = r;
            reset = 0x0;
        } coef_chra_lpf_5[8:0];
    } DATE_COEFF83 @ 0xF34C;

    reg {
        name = "Chrominance low-pass coefficient register 4";
        desc = "DATE_COEFF84 is chrominance low-pass coefficient register 4.

Data sheet 10.2.6 DATE_COEFF84 (offset 0xF350, printed page 10-267, `hi3516av100--Hi3516A-Hi3516D-Datasheet.txt` line 73958).";

        field {
            name = "coef_chra_lpf_7";
            desc = "Chrominance low-pass coefficient 7.";
            sw = rw;
            hw = r;
            reset = 0x0;
        } coef_chra_lpf_7[8:0];
    } DATE_COEFF84 @ 0xF350;
};

`endif
