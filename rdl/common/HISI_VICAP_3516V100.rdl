`ifndef HISI_VICAP_3516V100_RDL
`define HISI_VICAP_3516V100_RDL


regfile eHISI_VICAP_3516V100 {
    name = "VICAP (video capture, Hi3516 V100)";
    desc = "Video capture unit (VICAP) of the Hi3516 V100 at 0x20650000 (256 KB window, data sheet chapter 8.1; VICAP interrupt 50 in the data sheet interrupt table), including the sensor port and multi-channel sub-blocks. The data sheet of this chip is Chinese-only: this block transcribes register offsets, names, bit ranges, access types and reset values from the data sheet register tables; the Chinese description text and value encodings were NOT translated, so every description here is generated from the register or field name. Generated 2026-11-15 by scripts/rdl-extract/gen_m_cells.py from the data sheet register tables (ds_extract2 + description extraction from the PDF); PROVENANCE: PROVEN = offsets, names, bit fields, access and reset values from the data sheet tables; nothing here is hardware verified.

    Register sources: 226 registers from the data sheet (hi3516v100--Hi3516-Datasheet.txt, section 8.1.6). ";

    reg {
        name = "HD_INTF_MOD";
        desc = "Data sheet 8.1.6 HD_INTF_MOD (offset 0x0, printed page 8-32, `hi3516v100--Hi3516-Datasheet.txt` line 36898).";

        field {
            name = "samp_mod";
            desc = "Samp mod. Chinese-only data sheet: description and value encoding not translated.";
            sw = rw;
            hw = r;
            reset = 0x0;
        } samp_mod[7:7];

        field {
            name = "port_mod";
            desc = "Port mod. Chinese-only data sheet: description and value encoding not translated.";
            sw = rw;
            hw = r;
            reset = 0x0;
        } port_mod[4:3];

        field {
            name = "raw_mod";
            desc = "Raw mod. Chinese-only data sheet: description and value encoding not translated.";
            sw = rw;
            hw = r;
            reset = 0x0;
        } raw_mod[2:2];

        field {
            name = "clk_mode";
            desc = "Clk mode. Chinese-only data sheet: description and value encoding not translated.";
            sw = rw;
            hw = r;
            reset = 0x0;
        } clk_mode[1:1];

        field {
            name = "port_en";
            desc = "Port enable. Chinese-only data sheet: description and value encoding not translated.";
            sw = rw;
            hw = r;
            reset = 0x0;
        } port_en[0:0];
    } HD_INTF_MOD @ 0x0;

    reg {
        name = "HD_R_MASK_L";
        desc = "Data sheet 8.1.6 HD_R_MASK_L (offset 0x4, printed page 8-33, `hi3516v100--Hi3516-Datasheet.txt` line 36962).";

        field {
            name = "r_mask";
            desc = "R mask. Chinese-only data sheet: description and value encoding not translated.";
            sw = rw;
            hw = r;
            reset = 0x0;
        } r_mask[15:0];
    } HD_R_MASK_L @ 0x4;

    reg {
        name = "HD_R_MASK_H";
        desc = "Data sheet 8.1.6 HD_R_MASK_H (offset 0x8, printed page 8-34, `hi3516v100--Hi3516-Datasheet.txt` line 36992).";

        field {
            name = "r_mask";
            desc = "R mask. Chinese-only data sheet: description and value encoding not translated.";
            sw = rw;
            hw = r;
            reset = 0x0;
        } r_mask[15:0];
    } HD_R_MASK_H @ 0x8;

    reg {
        name = "HD_G_MASK_L";
        desc = "Data sheet 8.1.6 HD_G_MASK_L (offset 0xC, printed page 8-34, `hi3516v100--Hi3516-Datasheet.txt` line 37013).";

        field {
            name = "g_mask";
            desc = "G mask. Chinese-only data sheet: description and value encoding not translated.";
            sw = rw;
            hw = r;
            reset = 0x0;
        } g_mask[15:0];
    } HD_G_MASK_L @ 0xC;

    reg {
        name = "HD_G_MASK_H";
        desc = "Data sheet 8.1.6 HD_G_MASK_H (offset 0x10, printed page 8-35, `hi3516v100--Hi3516-Datasheet.txt` line 37049).";

        field {
            name = "g_mask";
            desc = "G mask. Chinese-only data sheet: description and value encoding not translated.";
            sw = rw;
            hw = r;
            reset = 0x0;
        } g_mask[15:0];
    } HD_G_MASK_H @ 0x10;

    reg {
        name = "HD_B_MASK_L";
        desc = "Data sheet 8.1.6 HD_B_MASK_L (offset 0x14, printed page 8-35, `hi3516v100--Hi3516-Datasheet.txt` line 37070).";

        field {
            name = "b_mask";
            desc = "B mask. Chinese-only data sheet: description and value encoding not translated.";
            sw = rw;
            hw = r;
            reset = 0x0;
        } b_mask[15:0];
    } HD_B_MASK_L @ 0x14;

    reg {
        name = "HD_B_MASK_H";
        desc = "Data sheet 8.1.6 HD_B_MASK_H (offset 0x18, printed page 8-36, `hi3516v100--Hi3516-Datasheet.txt` line 37103).";

        field {
            name = "b_mask";
            desc = "B mask. Chinese-only data sheet: description and value encoding not translated.";
            sw = rw;
            hw = r;
            reset = 0x0;
        } b_mask[15:0];
    } HD_B_MASK_H @ 0x18;

    reg {
        name = "HD_R_OFFSET_L";
        desc = "Data sheet 8.1.6 HD_R_OFFSET_L (offset 0x1C, printed page 8-36, `hi3516v100--Hi3516-Datasheet.txt` line 37124).";

        field {
            name = "r_offset";
            desc = "R offset. Chinese-only data sheet: description and value encoding not translated.";
            sw = rw;
            hw = r;
            reset = 0x0;
        } r_offset[15:0];
    } HD_R_OFFSET_L @ 0x1C;

    reg {
        name = "HD_R_OFFSET_H";
        desc = "Data sheet 8.1.6 HD_R_OFFSET_H (offset 0x20, printed page 8-36, `hi3516v100--Hi3516-Datasheet.txt` line 37145).";

        field {
            name = "r_offset";
            desc = "R offset. Chinese-only data sheet: description and value encoding not translated.";
            sw = rw;
            hw = r;
            reset = 0x0;
        } r_offset[15:0];
    } HD_R_OFFSET_H @ 0x20;

    reg {
        name = "HD_G_OFFSET_L";
        desc = "Data sheet 8.1.6 HD_G_OFFSET_L (offset 0x24, printed page 8-37, `hi3516v100--Hi3516-Datasheet.txt` line 37177).";

        field {
            name = "g_offset";
            desc = "G offset. Chinese-only data sheet: description and value encoding not translated.";
            sw = rw;
            hw = r;
            reset = 0x0;
        } g_offset[15:0];
    } HD_G_OFFSET_L @ 0x24;

    reg {
        name = "HD_G_OFFSET_H";
        desc = "Data sheet 8.1.6 HD_G_OFFSET_H (offset 0x28, printed page 8-37, `hi3516v100--Hi3516-Datasheet.txt` line 37198).";

        field {
            name = "g_offset";
            desc = "G offset. Chinese-only data sheet: description and value encoding not translated.";
            sw = rw;
            hw = r;
            reset = 0x0;
        } g_offset[15:0];
    } HD_G_OFFSET_H @ 0x28;

    reg {
        name = "HD_B_OFFSET_L";
        desc = "Data sheet 8.1.6 HD_B_OFFSET_L (offset 0x2C, printed page 8-38, `hi3516v100--Hi3516-Datasheet.txt` line 37229).";

        field {
            name = "b_offset";
            desc = "B offset. Chinese-only data sheet: description and value encoding not translated.";
            sw = rw;
            hw = r;
            reset = 0x0;
        } b_offset[15:0];
    } HD_B_OFFSET_L @ 0x2C;

    reg {
        name = "HD_B_OFFSET_H";
        desc = "Data sheet 8.1.6 HD_B_OFFSET_H (offset 0x30, printed page 8-38, `hi3516v100--Hi3516-Datasheet.txt` line 37250).";

        field {
            name = "b_offset";
            desc = "B offset. Chinese-only data sheet: description and value encoding not translated.";
            sw = rw;
            hw = r;
            reset = 0x0;
        } b_offset[15:0];
    } HD_B_OFFSET_H @ 0x30;

    reg {
        name = "HD_PORTA_CFG1";
        desc = "Data sheet 8.1.6 HD_PORTA_CFG1 (offset 0x34, printed page 8-39, `hi3516v100--Hi3516-Datasheet.txt` line 37286).";

        field {
            name = "vsync_bypass";
            desc = "Vertical sync bypass. Chinese-only data sheet: description and value encoding not translated.";
            sw = rw;
            hw = r;
            reset = 0x0;
        } vsync_bypass[11:11];

        field {
            name = "vsync_valid_neg";
            desc = "Vertical sync valid neg. Chinese-only data sheet: description and value encoding not translated.";
            sw = rw;
            hw = r;
            reset = 0x0;
        } vsync_valid_neg[10:10];

        field {
            name = "vsync_valid";
            desc = "Vertical sync valid. Chinese-only data sheet: description and value encoding not translated.";
            sw = rw;
            hw = r;
            reset = 0x0;
        } vsync_valid[9:9];

        field {
            name = "port_scan_mode";
            desc = "Port scan mode. Chinese-only data sheet: description and value encoding not translated.";
            sw = rw;
            hw = r;
            reset = 0x0;
        } port_scan_mode[8:7];

        field {
            name = "port_cap_mode";
            desc = "Port cap mode. Chinese-only data sheet: description and value encoding not translated.";
            sw = rw;
            hw = r;
            reset = 0x0;
        } port_cap_mode[6:5];

        field {
            name = "port_vsync";
            desc = "Port vertical sync. Chinese-only data sheet: description and value encoding not translated.";
            sw = rw;
            hw = r;
            reset = 0x0;
        } port_vsync[4:4];

        field {
            name = "port_vsync_neg";
            desc = "Port vertical sync neg. Chinese-only data sheet: description and value encoding not translated.";
            sw = rw;
            hw = r;
            reset = 0x0;
        } port_vsync_neg[3:3];

        field {
            name = "port_hsync";
            desc = "Port horizontal sync. Chinese-only data sheet: description and value encoding not translated.";
            sw = rw;
            hw = r;
            reset = 0x0;
        } port_hsync[2:2];

        field {
            name = "port_hsync_neg";
            desc = "Port horizontal sync neg. Chinese-only data sheet: description and value encoding not translated.";
            sw = rw;
            hw = r;
            reset = 0x0;
        } port_hsync_neg[1:1];
    } HD_PORTA_CFG1 @ 0x34;

    reg {
        name = "HD_PORTA_CFG2";
        desc = "Data sheet 8.1.6 HD_PORTA_CFG2 (offset 0x38, printed page 8-41, `hi3516v100--Hi3516-Datasheet.txt` line 37398).";

        field {
            name = "data_type";
            desc = "Data type. Chinese-only data sheet: description and value encoding not translated.";
            sw = rw;
            hw = r;
            reset = 0x0;
        } data_type[9:9];

        field {
            name = "debug_en";
            desc = "Debug enable. Chinese-only data sheet: description and value encoding not translated.";
            sw = rw;
            hw = r;
            reset = 0x0;
        } debug_en[8:8];

        field {
            name = "rgb_seq";
            desc = "Rgb seq. Chinese-only data sheet: description and value encoding not translated.";
            sw = rw;
            hw = r;
            reset = 0x0;
        } rgb_seq[7:6];

        field {
            name = "yuv_seq";
            desc = "Yuv seq. Chinese-only data sheet: description and value encoding not translated.";
            sw = rw;
            hw = r;
            reset = 0x0;
        } yuv_seq[5:4];

        field {
            name = "fix_code";
            desc = "Fix code. Chinese-only data sheet: description and value encoding not translated.";
            sw = rw;
            hw = r;
            reset = 0x0;
        } fix_code[3:3];

        field {
            name = "seav_f_neg";
            desc = "Seav f neg. Chinese-only data sheet: description and value encoding not translated.";
            sw = rw;
            hw = r;
            reset = 0x0;
        } seav_f_neg[2:2];

        field {
            name = "correct_en";
            desc = "Correct enable. Chinese-only data sheet: description and value encoding not translated.";
            sw = rw;
            hw = r;
            reset = 0x0;
        } correct_en[0:0];
    } HD_PORTA_CFG2 @ 0x38;

    reg {
        name = "HD_HSYNC_HFB";
        desc = "Data sheet 8.1.6 HD_HSYNC_HFB (offset 0x3C, printed page 8-42, `hi3516v100--Hi3516-Datasheet.txt` line 37472).";

        field {
            name = "hsync_hfb";
            desc = "Horizontal sync hfb. Chinese-only data sheet: description and value encoding not translated.";
            sw = rw;
            hw = r;
            reset = 0x0;
        } hsync_hfb[15:0];
    } HD_HSYNC_HFB @ 0x3C;

    reg {
        name = "HD_HSYNC_HACT";
        desc = "Data sheet 8.1.6 HD_HSYNC_HACT (offset 0x40, printed page 8-42, `hi3516v100--Hi3516-Datasheet.txt` line 37493).";

        field {
            name = "hsync_hact";
            desc = "Horizontal sync hact. Chinese-only data sheet: description and value encoding not translated.";
            sw = rw;
            hw = r;
            reset = 0x0;
        } hsync_hact[15:0];
    } HD_HSYNC_HACT @ 0x40;

    reg {
        name = "HD_HSYNC_HBB";
        desc = "Data sheet 8.1.6 HD_HSYNC_HBB (offset 0x44, printed page 8-43, `hi3516v100--Hi3516-Datasheet.txt` line 37526).";

        field {
            name = "hsync_hbb";
            desc = "Horizontal sync hbb. Chinese-only data sheet: description and value encoding not translated.";
            sw = rw;
            hw = r;
            reset = 0x0;
        } hsync_hbb[15:0];
    } HD_HSYNC_HBB @ 0x44;

    reg {
        name = "HD_VSYNC0_VFB";
        desc = "Data sheet 8.1.6 HD_VSYNC0_VFB (offset 0x48, printed page 8-43, `hi3516v100--Hi3516-Datasheet.txt` line 37547).";

        field {
            name = "hsync_hfb";
            desc = "Horizontal sync hfb. Chinese-only data sheet: description and value encoding not translated.";
            sw = rw;
            hw = r;
            reset = 0x0;
        } hsync_hfb[15:0];
    } HD_VSYNC0_VFB @ 0x48;

    reg {
        name = "HD_VSYNC0_VACT";
        desc = "Data sheet 8.1.6 HD_VSYNC0_VACT (offset 0x4C, printed page 8-44, `hi3516v100--Hi3516-Datasheet.txt` line 37578).";

        field {
            name = "hsync_hact";
            desc = "Horizontal sync hact. Chinese-only data sheet: description and value encoding not translated.";
            sw = rw;
            hw = r;
            reset = 0x0;
        } hsync_hact[15:0];
    } HD_VSYNC0_VACT @ 0x4C;

    reg {
        name = "HD_VSYNC0_VBB";
        desc = "Data sheet 8.1.6 HD_VSYNC0_VBB (offset 0x50, printed page 8-44, `hi3516v100--Hi3516-Datasheet.txt` line 37599).";

        field {
            name = "hsync_hbb";
            desc = "Horizontal sync hbb. Chinese-only data sheet: description and value encoding not translated.";
            sw = rw;
            hw = r;
            reset = 0x0;
        } hsync_hbb[15:0];
    } HD_VSYNC0_VBB @ 0x50;

    reg {
        name = "HD_VSYNC1_VFB";
        desc = "Data sheet 8.1.6 HD_VSYNC1_VFB (offset 0x54, printed page 8-44, `hi3516v100--Hi3516-Datasheet.txt` line 37620).";

        field {
            name = "hsync_hfb";
            desc = "Horizontal sync hfb. Chinese-only data sheet: description and value encoding not translated.";
            sw = rw;
            hw = r;
            reset = 0x0;
        } hsync_hfb[15:0];
    } HD_VSYNC1_VFB @ 0x54;

    reg {
        name = "HD_VSYNC1_VACT";
        desc = "Data sheet 8.1.6 HD_VSYNC1_VACT (offset 0x58, printed page 8-45, `hi3516v100--Hi3516-Datasheet.txt` line 37652).";

        field {
            name = "hsync_hact";
            desc = "Horizontal sync hact. Chinese-only data sheet: description and value encoding not translated.";
            sw = rw;
            hw = r;
            reset = 0x0;
        } hsync_hact[15:0];
    } HD_VSYNC1_VACT @ 0x58;

    reg {
        name = "HD_VSYNC1_VBB";
        desc = "Data sheet 8.1.6 HD_VSYNC1_VBB (offset 0x5C, printed page 8-45, `hi3516v100--Hi3516-Datasheet.txt` line 37673).";

        field {
            name = "hsync_hbb";
            desc = "Horizontal sync hbb. Chinese-only data sheet: description and value encoding not translated.";
            sw = rw;
            hw = r;
            reset = 0x0;
        } hsync_hbb[15:0];
    } HD_VSYNC1_VBB @ 0x5C;

    reg {
        name = "HD_DSAC_CFG0";
        desc = "Data sheet 8.1.6 HD_DSAC_CFG0 (offset 0x64, printed page 8-46, `hi3516v100--Hi3516-Datasheet.txt` line 37704).";

        field {
            name = "isp_vsync_sel";
            desc = "Isp vertical sync select. Chinese-only data sheet: description and value encoding not translated.";
            sw = rw;
            hw = r;
            reset = 0x0;
        } isp_vsync_sel[2:2];

        field {
            name = "isp_byte_en";
            desc = "Isp byte enable. Chinese-only data sheet: description and value encoding not translated.";
            sw = rw;
            hw = r;
            reset = 0x0;
        } isp_byte_en[1:0];
    } HD_DSAC_CFG0 @ 0x64;

    reg {
        name = "HD_DSAC_CFG1";
        desc = "Data sheet 8.1.6 HD_DSAC_CFG1 (offset 0x68, printed page 8-46, `hi3516v100--Hi3516-Datasheet.txt` line 37738).";

        field {
            name = "isp_mod";
            desc = "Isp mod. Chinese-only data sheet: description and value encoding not translated.";
            sw = rw;
            hw = r;
            reset = 0x0;
        } isp_mod[15:15];

        field {
            name = "test";
            desc = "Test. Chinese-only data sheet: description and value encoding not translated.";
            sw = rw;
            hw = r;
            reset = 0x0;
        } test[14:6];

        field {
            name = "dsac2_mod";
            desc = "Dsac2 mod. Chinese-only data sheet: description and value encoding not translated.";
            sw = rw;
            hw = r;
            reset = 0x0;
        } dsac2_mod[5:4];

        field {
            name = "reserve";
            desc = "Reserve. Chinese-only data sheet: description and value encoding not translated.";
            sw = rw;
            hw = r;
            reset = 0x0;
        } reserve[3:2];

        field {
            name = "debug_en";
            desc = "Debug enable. Chinese-only data sheet: description and value encoding not translated.";
            sw = rw;
            hw = r;
            reset = 0x0;
        } debug_en[1:1];

        field {
            name = "dsac2_sel";
            desc = "Dsac2 select. Chinese-only data sheet: description and value encoding not translated.";
            sw = rw;
            hw = r;
            reset = 0x0;
        } dsac2_sel[0:0];
    } HD_DSAC_CFG1 @ 0x68;

    reg {
        name = "HD_CSC_CFG";
        desc = "Data sheet 8.1.6 HD_CSC_CFG (offset 0x6C, printed page 8-47, `hi3516v100--Hi3516-Datasheet.txt` line 37797).";

        field {
            name = "csc_load";
            desc = "Colour-space conversion load. Chinese-only data sheet: description and value encoding not translated.";
            sw = rw;
            hw = r;
            reset = 0x0;
        } csc_load[1:1];

        field {
            name = "csc_en";
            desc = "Colour-space conversion enable. Chinese-only data sheet: description and value encoding not translated.";
            sw = rw;
            hw = r;
            reset = 0x0;
        } csc_en[0:0];
    } HD_CSC_CFG @ 0x6C;

    reg {
        name = "HD_CSC_IDCn";
        desc = "Data sheet 8.1.6 HD_CSC_IDCn (offset 0x70, printed page 8-48, `hi3516v100--Hi3516-Datasheet.txt` line 37836).";

        field {
            name = "csc_idcn";
            desc = "Colour-space conversion idcn. Chinese-only data sheet: description and value encoding not translated.";
            sw = rw;
            hw = r;
            reset = 0x0;
        } csc_idcn[8:0];
    } HD_CSC_IDCn[3] @ 0x70 += 0x4;

    reg {
        name = "HD_CSC_ODCn";
        desc = "Data sheet 8.1.6 HD_CSC_ODCn (offset 0x80, printed page 8-48, `hi3516v100--Hi3516-Datasheet.txt` line 37857).";

        field {
            name = "csc_odcn";
            desc = "Colour-space conversion odcn. Chinese-only data sheet: description and value encoding not translated.";
            sw = rw;
            hw = r;
            reset = 0x0;
        } csc_odcn[8:0];
    } HD_CSC_ODCn[3] @ 0x80 += 0x4;

    reg {
        name = "HD_CSC_COEFn";
        desc = "Data sheet 8.1.6 HD_CSC_COEFn (offset 0x8C, printed page 8-49, `hi3516v100--Hi3516-Datasheet.txt` line 37894).";

        field {
            name = "csc_coefn";
            desc = "Colour-space conversion coefn. Chinese-only data sheet: description and value encoding not translated.";
            sw = rw;
            hw = r;
            reset = 0x0;
        } csc_coefn[12:0];
    } HD_CSC_COEFn[9] @ 0x8C += 0x4;

    reg {
        name = "HD_CDS_CFG";
        desc = "Data sheet 8.1.6 HD_CDS_CFG (offset 0xB0, printed page 8-49, `hi3516v100--Hi3516-Datasheet.txt` line 37915).";

        field {
            name = "cds_bypass";
            desc = "Cds bypass. Chinese-only data sheet: description and value encoding not translated.";
            sw = rw;
            hw = r;
            reset = 0x0;
        } cds_bypass[4:4];

        field {
            name = "cds_clip";
            desc = "Cds clip. Chinese-only data sheet: description and value encoding not translated.";
            sw = rw;
            hw = r;
            reset = 0x0;
        } cds_clip[3:3];

        field {
            name = "cds_mod";
            desc = "Cds mod. Chinese-only data sheet: description and value encoding not translated.";
            sw = rw;
            hw = r;
            reset = 0x0;
        } cds_mod[2:2];

        field {
            name = "cds_load";
            desc = "Cds load. Chinese-only data sheet: description and value encoding not translated.";
            sw = rw;
            hw = r;
            reset = 0x0;
        } cds_load[1:1];

        field {
            name = "cds_en";
            desc = "Cds enable. Chinese-only data sheet: description and value encoding not translated.";
            sw = rw;
            hw = r;
            reset = 0x0;
        } cds_en[0:0];
    } HD_CDS_CFG @ 0xB0;

    reg {
        name = "HD_CDS_COEFn";
        desc = "Data sheet 8.1.6 HD_CDS_COEFn (offset 0xB4, printed page 8-50, `hi3516v100--Hi3516-Datasheet.txt` line 37967).";

        field {
            name = "csc_coefn";
            desc = "Colour-space conversion coefn. Chinese-only data sheet: description and value encoding not translated.";
            sw = rw;
            hw = r;
            reset = 0x0;
        } csc_coefn[9:0];
    } HD_CDS_COEFn[4] @ 0xB4 += 0x4;

    reg {
        name = "HD_ACC_CFG";
        desc = "Data sheet 8.1.6 HD_ACC_CFG (offset 0x100, printed page 8-50, `hi3516v100--Hi3516-Datasheet.txt` line 37988).";

        field {
            name = "acc_load";
            desc = "ACC load. Chinese-only data sheet: description and value encoding not translated.";
            sw = rw;
            hw = r;
            reset = 0x0;
        } acc_load[0:0];
    } HD_ACC_CFG @ 0x100;

    reg {
        name = "HD_ACC_COEF register";
        desc = "HD_ACC_COEF register. The data sheet lists no bit fields for it.

Data sheet 8.1.6 HD_ACC_COEF (offset 0x104, printed page 8-51, `hi3516v100--Hi3516-Datasheet.txt` line 38025).";

        field {
            name = "value";
            desc = "Register value (the data sheet gives no bit table for this register).";
            sw = rw;
            hw = r;
            reset = 0x0;
        } value[31:0];
    } HD_ACC_COEF @ 0x104;

    reg {
        name = "HD_DOP_CFG register";
        desc = "HD_DOP_CFG register. The data sheet lists no bit fields for it.

Data sheet 8.1.6 HD_DOP_CFG (offset 0x108, printed page 8-51, `hi3516v100--Hi3516-Datasheet.txt` line 38044).";

        field {
            name = "value";
            desc = "Register value (the data sheet gives no bit table for this register).";
            sw = rw;
            hw = r;
            reset = 0x0;
        } value[31:0];
    } HD_DOP_CFG @ 0x108;

    reg {
        name = "HD_INT_MASK";
        desc = "Data sheet 8.1.6 HD_INT_MASK (offset 0xF00, printed page 8-52, `hi3516v100--Hi3516-Datasheet.txt` line 38075).";

        field {
            name = "hd_mask_intf";
            desc = "Hd mask intf. Chinese-only data sheet: description and value encoding not translated.";
            sw = rw;
            hw = r;
            reset = 0x0;
        } hd_mask_intf[8:8];

        field {
            name = "hd_mask_isp7";
            desc = "Hd mask isp7. Chinese-only data sheet: description and value encoding not translated.";
            sw = rw;
            hw = r;
            reset = 0x0;
        } hd_mask_isp7[7:7];

        field {
            name = "hd_mask_isp6";
            desc = "Hd mask isp6. Chinese-only data sheet: description and value encoding not translated.";
            sw = rw;
            hw = r;
            reset = 0x0;
        } hd_mask_isp6[6:6];

        field {
            name = "hd_mask_isp5";
            desc = "Hd mask isp5. Chinese-only data sheet: description and value encoding not translated.";
            sw = rw;
            hw = r;
            reset = 0x0;
        } hd_mask_isp5[5:5];

        field {
            name = "hd_mask_isp4";
            desc = "Hd mask isp4. Chinese-only data sheet: description and value encoding not translated.";
            sw = rw;
            hw = r;
            reset = 0x0;
        } hd_mask_isp4[4:4];

        field {
            name = "hd_mask_isp3";
            desc = "Hd mask isp3. Chinese-only data sheet: description and value encoding not translated.";
            sw = rw;
            hw = r;
            reset = 0x0;
        } hd_mask_isp3[3:3];

        field {
            name = "hd_mask_isp2";
            desc = "Hd mask isp2. Chinese-only data sheet: description and value encoding not translated.";
            sw = rw;
            hw = r;
            reset = 0x0;
        } hd_mask_isp2[2:2];

        field {
            name = "hd_mask_isp1";
            desc = "Hd mask isp1. Chinese-only data sheet: description and value encoding not translated.";
            sw = rw;
            hw = r;
            reset = 0x0;
        } hd_mask_isp1[1:1];

        field {
            name = "hd_mask_isp0";
            desc = "Hd mask isp0. Chinese-only data sheet: description and value encoding not translated.";
            sw = rw;
            hw = r;
            reset = 0x0;
        } hd_mask_isp0[0:0];
    } HD_INT_MASK @ 0xF00;

    reg {
        name = "HD_INT";
        desc = "Data sheet 8.1.6 HD_INT (offset 0xF04, printed page 8-53, `hi3516v100--Hi3516-Datasheet.txt` line 38134).";

        field {
            name = "hd_int_intf";
            desc = "Hd interrupt intf. Chinese-only data sheet: description and value encoding not translated.";
            sw = rw;
            hw = w;
            onwrite = woclr;
            reset = 0x0;
        } hd_int_intf[8:8];

        field {
            name = "hd_int_isp7";
            desc = "Hd interrupt isp7. Chinese-only data sheet: description and value encoding not translated.";
            sw = rw;
            hw = w;
            onwrite = woclr;
            reset = 0x0;
        } hd_int_isp7[7:7];

        field {
            name = "hd_int_isp6";
            desc = "Hd interrupt isp6. Chinese-only data sheet: description and value encoding not translated.";
            sw = rw;
            hw = w;
            onwrite = woclr;
            reset = 0x0;
        } hd_int_isp6[6:6];

        field {
            name = "hd_int_isp5";
            desc = "Hd interrupt isp5. Chinese-only data sheet: description and value encoding not translated.";
            sw = rw;
            hw = w;
            onwrite = woclr;
            reset = 0x0;
        } hd_int_isp5[5:5];

        field {
            name = "hd_int_isp4";
            desc = "Hd interrupt isp4. Chinese-only data sheet: description and value encoding not translated.";
            sw = rw;
            hw = w;
            onwrite = woclr;
            reset = 0x0;
        } hd_int_isp4[4:4];

        field {
            name = "hd_int_isp3";
            desc = "Hd interrupt isp3. Chinese-only data sheet: description and value encoding not translated.";
            sw = rw;
            hw = w;
            onwrite = woclr;
            reset = 0x0;
        } hd_int_isp3[3:3];

        field {
            name = "hd_int_isp2";
            desc = "Hd interrupt isp2. Chinese-only data sheet: description and value encoding not translated.";
            sw = rw;
            hw = w;
            onwrite = woclr;
            reset = 0x0;
        } hd_int_isp2[2:2];

        field {
            name = "hd_int_isp1";
            desc = "Hd interrupt isp1. Chinese-only data sheet: description and value encoding not translated.";
            sw = rw;
            hw = w;
            onwrite = woclr;
            reset = 0x0;
        } hd_int_isp1[1:1];

        field {
            name = "hd_int_isp0";
            desc = "Hd interrupt isp0. Chinese-only data sheet: description and value encoding not translated.";
            sw = rw;
            hw = w;
            onwrite = woclr;
            reset = 0x0;
        } hd_int_isp0[0:0];
    } HD_INT @ 0xF04;

    reg {
        name = "HD_INT_RAW";
        desc = "Data sheet 8.1.6 HD_INT_RAW (offset 0xF08, printed page 8-54, `hi3516v100--Hi3516-Datasheet.txt` line 38190).";

        field {
            name = "hd_int_raw_intf";
            desc = "Hd interrupt raw intf. Chinese-only data sheet: description and value encoding not translated.";
            sw = r;
            hw = w;
            reset = 0x0;
        } hd_int_raw_intf[8:8];

        field {
            name = "hd_int_raw_isp7";
            desc = "Hd interrupt raw isp7. Chinese-only data sheet: description and value encoding not translated.";
            sw = r;
            hw = w;
            reset = 0x0;
        } hd_int_raw_isp7[7:7];

        field {
            name = "hd_int_raw_isp6";
            desc = "Hd interrupt raw isp6. Chinese-only data sheet: description and value encoding not translated.";
            sw = r;
            hw = w;
            reset = 0x0;
        } hd_int_raw_isp6[6:6];

        field {
            name = "hd_int_raw_isp5";
            desc = "Hd interrupt raw isp5. Chinese-only data sheet: description and value encoding not translated.";
            sw = r;
            hw = w;
            reset = 0x0;
        } hd_int_raw_isp5[5:5];

        field {
            name = "hd_int_raw_isp4";
            desc = "Hd interrupt raw isp4. Chinese-only data sheet: description and value encoding not translated.";
            sw = r;
            hw = w;
            reset = 0x0;
        } hd_int_raw_isp4[4:4];

        field {
            name = "hd_int_raw_isp3";
            desc = "Hd interrupt raw isp3. Chinese-only data sheet: description and value encoding not translated.";
            sw = r;
            hw = w;
            reset = 0x0;
        } hd_int_raw_isp3[3:3];

        field {
            name = "hd_int_raw_isp2";
            desc = "Hd interrupt raw isp2. Chinese-only data sheet: description and value encoding not translated.";
            sw = r;
            hw = w;
            reset = 0x0;
        } hd_int_raw_isp2[2:2];

        field {
            name = "hd_int_raw_isp1";
            desc = "Hd interrupt raw isp1. Chinese-only data sheet: description and value encoding not translated.";
            sw = r;
            hw = w;
            reset = 0x0;
        } hd_int_raw_isp1[1:1];

        field {
            name = "hd_int_raw_isp0";
            desc = "Hd interrupt raw isp0. Chinese-only data sheet: description and value encoding not translated.";
            sw = r;
            hw = w;
            reset = 0x0;
        } hd_int_raw_isp0[0:0];
    } HD_INT_RAW @ 0xF08;

    reg {
        name = "HD_STATUS";
        desc = "Data sheet 8.1.6 HD_STATUS (offset 0xF0C, printed page 8-55, `hi3516v100--Hi3516-Datasheet.txt` line 38249).";

        field {
            name = "hd_status";
            desc = "Hd status. Chinese-only data sheet: description and value encoding not translated.";
            sw = rw;
            hw = r;
            reset = 0x0;
        } hd_status[8:0];
    } HD_STATUS @ 0xF0C;

    reg {
        name = "SD_INTF_MOD";
        desc = "Data sheet 8.1.6 SD_INTF_MOD (offset 0x1000, printed page 8-55, `hi3516v100--Hi3516-Datasheet.txt` line 38270).";

        field {
            name = "samp_mod";
            desc = "Samp mod. Chinese-only data sheet: description and value encoding not translated.";
            sw = rw;
            hw = r;
            reset = 0x0;
        } samp_mod[7:7];

        field {
            name = "port_mod";
            desc = "Port mod. Chinese-only data sheet: description and value encoding not translated.";
            sw = rw;
            hw = r;
            reset = 0x0;
        } port_mod[4:3];

        field {
            name = "raw_mod";
            desc = "Raw mod. Chinese-only data sheet: description and value encoding not translated.";
            sw = rw;
            hw = r;
            reset = 0x0;
        } raw_mod[2:2];

        field {
            name = "clk_mode";
            desc = "Clk mode. Chinese-only data sheet: description and value encoding not translated.";
            sw = rw;
            hw = r;
            reset = 0x0;
        } clk_mode[1:1];

        field {
            name = "port_en";
            desc = "Port enable. Chinese-only data sheet: description and value encoding not translated.";
            sw = rw;
            hw = r;
            reset = 0x0;
        } port_en[0:0];
    } SD_INTF_MOD @ 0x1000;

    reg {
        name = "SD_R_MASK_L";
        desc = "Data sheet 8.1.6 SD_R_MASK_L (offset 0x1004, printed page 8-56, `hi3516v100--Hi3516-Datasheet.txt` line 38329).";

        field {
            name = "r_mask";
            desc = "R mask. Chinese-only data sheet: description and value encoding not translated.";
            sw = rw;
            hw = r;
            reset = 0x0;
        } r_mask[15:0];
    } SD_R_MASK_L @ 0x1004;

    reg {
        name = "SD_R_MASK_H";
        desc = "Data sheet 8.1.6 SD_R_MASK_H (offset 0x1008, printed page 8-57, `hi3516v100--Hi3516-Datasheet.txt` line 38365).";

        field {
            name = "r_mask";
            desc = "R mask. Chinese-only data sheet: description and value encoding not translated.";
            sw = rw;
            hw = r;
            reset = 0x0;
        } r_mask[15:0];
    } SD_R_MASK_H @ 0x1008;

    reg {
        name = "SD_G_MASK_L";
        desc = "Data sheet 8.1.6 SD_G_MASK_L (offset 0x100C, printed page 8-57, `hi3516v100--Hi3516-Datasheet.txt` line 38386).";

        field {
            name = "g_mask";
            desc = "G mask. Chinese-only data sheet: description and value encoding not translated.";
            sw = rw;
            hw = r;
            reset = 0x0;
        } g_mask[15:0];
    } SD_G_MASK_L @ 0x100C;

    reg {
        name = "SD_G_MASK_H";
        desc = "Data sheet 8.1.6 SD_G_MASK_H (offset 0x1010, printed page 8-58, `hi3516v100--Hi3516-Datasheet.txt` line 38419).";

        field {
            name = "g_mask";
            desc = "G mask. Chinese-only data sheet: description and value encoding not translated.";
            sw = rw;
            hw = r;
            reset = 0x0;
        } g_mask[15:0];
    } SD_G_MASK_H @ 0x1010;

    reg {
        name = "SD_R_OFFSET_L";
        desc = "Data sheet 8.1.6 SD_R_OFFSET_L (offset 0x101C, printed page 8-58, `hi3516v100--Hi3516-Datasheet.txt` line 38440).";

        field {
            name = "r_offset";
            desc = "R offset. Chinese-only data sheet: description and value encoding not translated.";
            sw = rw;
            hw = r;
            reset = 0x0;
        } r_offset[15:0];
    } SD_R_OFFSET_L @ 0x101C;

    reg {
        name = "SD_R_OFFSET_H";
        desc = "Data sheet 8.1.6 SD_R_OFFSET_H (offset 0x1020, printed page 8-58, `hi3516v100--Hi3516-Datasheet.txt` line 38461).";

        field {
            name = "r_offset";
            desc = "R offset. Chinese-only data sheet: description and value encoding not translated.";
            sw = rw;
            hw = r;
            reset = 0x0;
        } r_offset[15:0];
    } SD_R_OFFSET_H @ 0x1020;

    reg {
        name = "SD_G_OFFSET_L";
        desc = "Data sheet 8.1.6 SD_G_OFFSET_L (offset 0x1024, printed page 8-59, `hi3516v100--Hi3516-Datasheet.txt` line 38493).";

        field {
            name = "g_offset";
            desc = "G offset. Chinese-only data sheet: description and value encoding not translated.";
            sw = rw;
            hw = r;
            reset = 0x0;
        } g_offset[15:0];
    } SD_G_OFFSET_L @ 0x1024;

    reg {
        name = "SD_G_OFFSET_H";
        desc = "Data sheet 8.1.6 SD_G_OFFSET_H (offset 0x1028, printed page 8-59, `hi3516v100--Hi3516-Datasheet.txt` line 38514).";

        field {
            name = "g_offset";
            desc = "G offset. Chinese-only data sheet: description and value encoding not translated.";
            sw = rw;
            hw = r;
            reset = 0x0;
        } g_offset[15:0];
    } SD_G_OFFSET_H @ 0x1028;

    reg {
        name = "SD_PORTB_CFG1";
        desc = "Data sheet 8.1.6 SD_PORTB_CFG1 (offset 0x1034, printed page 8-60, `hi3516v100--Hi3516-Datasheet.txt` line 38545).";

        field {
            name = "vsync_valid_neg";
            desc = "Vertical sync valid neg. Chinese-only data sheet: description and value encoding not translated.";
            sw = rw;
            hw = r;
            reset = 0x0;
        } vsync_valid_neg[10:10];

        field {
            name = "vsync_valid";
            desc = "Vertical sync valid. Chinese-only data sheet: description and value encoding not translated.";
            sw = rw;
            hw = r;
            reset = 0x0;
        } vsync_valid[9:9];

        field {
            name = "port_scan_mode";
            desc = "Port scan mode. Chinese-only data sheet: description and value encoding not translated.";
            sw = rw;
            hw = r;
            reset = 0x0;
        } port_scan_mode[8:7];

        field {
            name = "port_cap_mode";
            desc = "Port cap mode. Chinese-only data sheet: description and value encoding not translated.";
            sw = rw;
            hw = r;
            reset = 0x0;
        } port_cap_mode[6:5];

        field {
            name = "port_vsync";
            desc = "Port vertical sync. Chinese-only data sheet: description and value encoding not translated.";
            sw = rw;
            hw = r;
            reset = 0x0;
        } port_vsync[4:4];

        field {
            name = "port_vsync_neg";
            desc = "Port vertical sync neg. Chinese-only data sheet: description and value encoding not translated.";
            sw = rw;
            hw = r;
            reset = 0x0;
        } port_vsync_neg[3:3];

        field {
            name = "port_hsync";
            desc = "VI_P_HSYNC_VD pin function. 0: VI_P_HSYNC_VD is a data-valid signal. 1: VI_P_HSYNC_VD is a horizontal sync pulse (the 16-bit sync interface sets this bit to 1). Description translated from the Chinese data sheet; the bit row had no access cell in the extraction (RW inferred from the neighbouring port_hsync_neg field, reset 0 from the total reset 0x4000).";
            sw = rw;
            hw = r;
            reset = 0x0;
        } port_hsync[2:2];

        field {
            name = "port_hsync_neg";
            desc = "Port horizontal sync neg. Chinese-only data sheet: description and value encoding not translated.";
            sw = rw;
            hw = r;
            reset = 0x0;
        } port_hsync_neg[1:1];
    } SD_PORTB_CFG1 @ 0x1034;

    reg {
        name = "SD_PORTB_CFG2";
        desc = "Data sheet 8.1.6 SD_PORTB_CFG2 (offset 0x1038, printed page 8-62, `hi3516v100--Hi3516-Datasheet.txt` line 38653).";

        field {
            name = "data_type";
            desc = "Data type. Chinese-only data sheet: description and value encoding not translated.";
            sw = rw;
            hw = r;
            reset = 0x0;
        } data_type[9:9];

        field {
            name = "debug_en";
            desc = "Debug enable. Chinese-only data sheet: description and value encoding not translated.";
            sw = rw;
            hw = r;
            reset = 0x0;
        } debug_en[8:8];

        field {
            name = "rgb_seq";
            desc = "Rgb seq. Chinese-only data sheet: description and value encoding not translated.";
            sw = rw;
            hw = r;
            reset = 0x0;
        } rgb_seq[7:6];

        field {
            name = "yuv_seq";
            desc = "Yuv seq. Chinese-only data sheet: description and value encoding not translated.";
            sw = rw;
            hw = r;
            reset = 0x0;
        } yuv_seq[5:4];

        field {
            name = "fix_code";
            desc = "Fix code. Chinese-only data sheet: description and value encoding not translated.";
            sw = rw;
            hw = r;
            reset = 0x0;
        } fix_code[3:3];

        field {
            name = "seav_f_neg";
            desc = "Seav f neg. Chinese-only data sheet: description and value encoding not translated.";
            sw = rw;
            hw = r;
            reset = 0x0;
        } seav_f_neg[2:2];

        field {
            name = "correct_en";
            desc = "Correct enable. Chinese-only data sheet: description and value encoding not translated.";
            sw = rw;
            hw = r;
            reset = 0x0;
        } correct_en[0:0];
    } SD_PORTB_CFG2 @ 0x1038;

    reg {
        name = "SD_HSYNC_HFB";
        desc = "Data sheet 8.1.6 SD_HSYNC_HFB (offset 0x103C, printed page 8-63, `hi3516v100--Hi3516-Datasheet.txt` line 38726).";

        field {
            name = "hsync_hfb";
            desc = "Horizontal sync hfb. Chinese-only data sheet: description and value encoding not translated.";
            sw = rw;
            hw = r;
            reset = 0x0;
        } hsync_hfb[15:0];
    } SD_HSYNC_HFB @ 0x103C;

    reg {
        name = "SD_HSYNC_HACT";
        desc = "Data sheet 8.1.6 SD_HSYNC_HACT (offset 0x1040, printed page 8-63, `hi3516v100--Hi3516-Datasheet.txt` line 38747).";

        field {
            name = "hsync_hact";
            desc = "Horizontal sync hact. Chinese-only data sheet: description and value encoding not translated.";
            sw = rw;
            hw = r;
            reset = 0x0;
        } hsync_hact[15:0];
    } SD_HSYNC_HACT @ 0x1040;

    reg {
        name = "SD_HSYNC_HBB";
        desc = "Data sheet 8.1.6 SD_HSYNC_HBB (offset 0x1044, printed page 8-64, `hi3516v100--Hi3516-Datasheet.txt` line 38777).";

        field {
            name = "hsync_hbb";
            desc = "Horizontal sync hbb. Chinese-only data sheet: description and value encoding not translated.";
            sw = rw;
            hw = r;
            reset = 0x0;
        } hsync_hbb[15:0];
    } SD_HSYNC_HBB @ 0x1044;

    reg {
        name = "SD_VSYNC0_VFB";
        desc = "Data sheet 8.1.6 SD_VSYNC0_VFB (offset 0x1048, printed page 8-64, `hi3516v100--Hi3516-Datasheet.txt` line 38798).";

        field {
            name = "hsync_hfb";
            desc = "Horizontal sync hfb. Chinese-only data sheet: description and value encoding not translated.";
            sw = rw;
            hw = r;
            reset = 0x0;
        } hsync_hfb[15:0];
    } SD_VSYNC0_VFB @ 0x1048;

    reg {
        name = "SD_VSYNC0_VACT";
        desc = "Data sheet 8.1.6 SD_VSYNC0_VACT (offset 0x104C, printed page 8-65, `hi3516v100--Hi3516-Datasheet.txt` line 38834).";

        field {
            name = "hsync_hact";
            desc = "Horizontal sync hact. Chinese-only data sheet: description and value encoding not translated.";
            sw = rw;
            hw = r;
            reset = 0x0;
        } hsync_hact[15:0];
    } SD_VSYNC0_VACT @ 0x104C;

    reg {
        name = "SD_VSYNC0_VBB";
        desc = "Data sheet 8.1.6 SD_VSYNC0_VBB (offset 0x1050, printed page 8-65, `hi3516v100--Hi3516-Datasheet.txt` line 38855).";

        field {
            name = "hsync_hbb";
            desc = "Horizontal sync hbb. Chinese-only data sheet: description and value encoding not translated.";
            sw = rw;
            hw = r;
            reset = 0x0;
        } hsync_hbb[15:0];
    } SD_VSYNC0_VBB @ 0x1050;

    reg {
        name = "SD_VSYNC1_VFB";
        desc = "Data sheet 8.1.6 SD_VSYNC1_VFB (offset 0x1054, printed page 8-66, `hi3516v100--Hi3516-Datasheet.txt` line 38888).";

        field {
            name = "hsync_hfb";
            desc = "Horizontal sync hfb. Chinese-only data sheet: description and value encoding not translated.";
            sw = rw;
            hw = r;
            reset = 0x0;
        } hsync_hfb[15:0];
    } SD_VSYNC1_VFB @ 0x1054;

    reg {
        name = "SD_VSYNC1_VACT";
        desc = "Data sheet 8.1.6 SD_VSYNC1_VACT (offset 0x1058, printed page 8-66, `hi3516v100--Hi3516-Datasheet.txt` line 38909).";

        field {
            name = "hsync_hact";
            desc = "Horizontal sync hact. Chinese-only data sheet: description and value encoding not translated.";
            sw = rw;
            hw = r;
            reset = 0x0;
        } hsync_hact[15:0];
    } SD_VSYNC1_VACT @ 0x1058;

    reg {
        name = "SD_VSYNC1_VBB";
        desc = "Data sheet 8.1.6 SD_VSYNC1_VBB (offset 0x105C, printed page 8-66, `hi3516v100--Hi3516-Datasheet.txt` line 38930).";

        field {
            name = "hsync_hbb";
            desc = "Horizontal sync hbb. Chinese-only data sheet: description and value encoding not translated.";
            sw = rw;
            hw = r;
            reset = 0x0;
        } hsync_hbb[15:0];
    } SD_VSYNC1_VBB @ 0x105C;

    reg {
        name = "SD_DSAC_CFG0 register";
        desc = "SD_DSAC_CFG0 register. The data sheet lists no bit fields for it.

Data sheet 8.1.6 SD_DSAC_CFG0 (offset 0x1064, printed page 8-67, `hi3516v100--Hi3516-Datasheet.txt` line 38962).";

        field {
            name = "value";
            desc = "Register value (the data sheet gives no bit table for this register).";
            sw = rw;
            hw = r;
            reset = 0x8;
        } value[31:0];
    } SD_DSAC_CFG0 @ 0x1064;

    reg {
        name = "SD_DSAC_CFG1";
        desc = "Data sheet 8.1.6 SD_DSAC_CFG1 (offset 0x1068, printed page 8-67, `hi3516v100--Hi3516-Datasheet.txt` line 38981).";

        field {
            name = "dsac2_mod";
            desc = "Dsac2 mod. Chinese-only data sheet: description and value encoding not translated.";
            sw = rw;
            hw = r;
            reset = 0x0;
        } dsac2_mod[5:4];

        field {
            name = "reserve";
            desc = "Reserve. Chinese-only data sheet: description and value encoding not translated.";
            sw = rw;
            hw = r;
            reset = 0x0;
        } reserve[3:2];

        field {
            name = "debug_en";
            desc = "Debug enable. Chinese-only data sheet: description and value encoding not translated.";
            sw = rw;
            hw = r;
            reset = 0x0;
        } debug_en[1:1];

        field {
            name = "dsac2_sel";
            desc = "Dsac2 select. Chinese-only data sheet: description and value encoding not translated.";
            sw = rw;
            hw = r;
            reset = 0x0;
        } dsac2_sel[0:0];
    } SD_DSAC_CFG1 @ 0x1068;

    reg {
        name = "SD_CSC_CFG";
        desc = "Data sheet 8.1.6 SD_CSC_CFG (offset 0x106C, printed page 8-68, `hi3516v100--Hi3516-Datasheet.txt` line 39031).";

        field {
            name = "csc_load";
            desc = "Colour-space conversion load. Chinese-only data sheet: description and value encoding not translated.";
            sw = rw;
            hw = r;
            reset = 0x0;
        } csc_load[1:1];

        field {
            name = "csc_en";
            desc = "Colour-space conversion enable. Chinese-only data sheet: description and value encoding not translated.";
            sw = rw;
            hw = r;
            reset = 0x0;
        } csc_en[0:0];
    } SD_CSC_CFG @ 0x106C;

    reg {
        name = "SD_CSC_IDCn";
        desc = "Data sheet 8.1.6 SD_CSC_IDCn (offset 0x1070, printed page 8-69, `hi3516v100--Hi3516-Datasheet.txt` line 39078).";

        field {
            name = "csc_idcn";
            desc = "Colour-space conversion idcn. Chinese-only data sheet: description and value encoding not translated.";
            sw = rw;
            hw = r;
            reset = 0x0;
        } csc_idcn[8:0];
    } SD_CSC_IDCn[3] @ 0x1070 += 0x4;

    reg {
        name = "SD_CSC_ODCn";
        desc = "Data sheet 8.1.6 SD_CSC_ODCn (offset 0x1080, printed page 8-69, `hi3516v100--Hi3516-Datasheet.txt` line 39099).";

        field {
            name = "csc_odcn";
            desc = "Colour-space conversion odcn. Chinese-only data sheet: description and value encoding not translated.";
            sw = rw;
            hw = r;
            reset = 0x0;
        } csc_odcn[8:0];
    } SD_CSC_ODCn[3] @ 0x1080 += 0x4;

    reg {
        name = "SD_CSC_COEFn";
        desc = "Data sheet 8.1.6 SD_CSC_COEFn (offset 0x108C, printed page 8-70, `hi3516v100--Hi3516-Datasheet.txt` line 39132).";

        field {
            name = "csc_coefn";
            desc = "Colour-space conversion coefn. Chinese-only data sheet: description and value encoding not translated.";
            sw = rw;
            hw = r;
            reset = 0x0;
        } csc_coefn[12:0];
    } SD_CSC_COEFn[9] @ 0x108C += 0x4;

    reg {
        name = "SD_CDS_CFG";
        desc = "Data sheet 8.1.6 SD_CDS_CFG (offset 0x10B0, printed page 8-70, `hi3516v100--Hi3516-Datasheet.txt` line 39153).";

        field {
            name = "cds_bypass";
            desc = "Cds bypass. Chinese-only data sheet: description and value encoding not translated.";
            sw = rw;
            hw = r;
            reset = 0x0;
        } cds_bypass[4:4];

        field {
            name = "cds_clip";
            desc = "Cds clip. Chinese-only data sheet: description and value encoding not translated.";
            sw = rw;
            hw = r;
            reset = 0x0;
        } cds_clip[3:3];

        field {
            name = "cds_mod";
            desc = "Cds mod. Chinese-only data sheet: description and value encoding not translated.";
            sw = rw;
            hw = r;
            reset = 0x0;
        } cds_mod[2:2];

        field {
            name = "cds_load";
            desc = "Cds load. Chinese-only data sheet: description and value encoding not translated.";
            sw = rw;
            hw = r;
            reset = 0x0;
        } cds_load[1:1];

        field {
            name = "cds_en";
            desc = "Cds enable. Chinese-only data sheet: description and value encoding not translated.";
            sw = rw;
            hw = r;
            reset = 0x0;
        } cds_en[0:0];
    } SD_CDS_CFG @ 0x10B0;

    reg {
        name = "SD_CDS_COEFn";
        desc = "Data sheet 8.1.6 SD_CDS_COEFn (offset 0x10B4, printed page 8-71, `hi3516v100--Hi3516-Datasheet.txt` line 39212).";

        field {
            name = "csc_coefn";
            desc = "Colour-space conversion coefn. Chinese-only data sheet: description and value encoding not translated.";
            sw = rw;
            hw = r;
            reset = 0x0;
        } csc_coefn[9:0];
    } SD_CDS_COEFn[4] @ 0x10B4 += 0x4;

    reg {
        name = "SD_INT_MASK";
        desc = "Data sheet 8.1.6 SD_INT_MASK (offset 0x1F00, printed page 8-72, `hi3516v100--Hi3516-Datasheet.txt` line 39245).";

        field {
            name = "sd_mask_intf";
            desc = "Sd mask intf. Chinese-only data sheet: description and value encoding not translated.";
            sw = rw;
            hw = r;
            reset = 0x0;
        } sd_mask_intf[8:8];
    } SD_INT_MASK @ 0x1F00;

    reg {
        name = "SD_INT";
        desc = "Data sheet 8.1.6 SD_INT (offset 0x1F04, printed page 8-72, `hi3516v100--Hi3516-Datasheet.txt` line 39277).";

        field {
            name = "sd_int_intf";
            desc = "Sd interrupt intf. Chinese-only data sheet: description and value encoding not translated.";
            sw = rw;
            hw = r;
            reset = 0x0;
        } sd_int_intf[8:8];
    } SD_INT @ 0x1F04;

    reg {
        name = "SD_INT_RAW";
        desc = "Data sheet 8.1.6 SD_INT_RAW (offset 0x1F08, printed page 8-73, `hi3516v100--Hi3516-Datasheet.txt` line 39322).";

        field {
            name = "sd_int_intf_raw";
            desc = "Sd interrupt intf raw. Chinese-only data sheet: description and value encoding not translated.";
            sw = rw;
            hw = r;
            reset = 0x0;
        } sd_int_intf_raw[8:8];
    } SD_INT_RAW @ 0x1F08;

    reg {
        name = "SCH_CTRL";
        desc = "Data sheet 8.1.6 SCH_CTRL (offset 0x4000, printed page 8-74, `hi3516v100--Hi3516-Datasheet.txt` line 39364).";

        field {
            name = "sch_en";
            desc = "Sch enable. Chinese-only data sheet: description and value encoding not translated.";
            sw = rw;
            hw = r;
            reset = 0x0;
        } sch_en[31:31];

        field {
            name = "hist_en";
            desc = "Histogram enable. Chinese-only data sheet: description and value encoding not translated.";
            sw = rw;
            hw = r;
            reset = 0x0;
        } hist_en[23:23];

        field {
            name = "flip_en";
            desc = "Flip enable. Chinese-only data sheet: description and value encoding not translated.";
            sw = rw;
            hw = r;
            reset = 0x0;
        } flip_en[22:22];

        field {
            name = "mir_en";
            desc = "Mir enable. Chinese-only data sheet: description and value encoding not translated.";
            sw = rw;
            hw = r;
            reset = 0x0;
        } mir_en[21:21];

        field {
            name = "store_method";
            desc = "Store method. Chinese-only data sheet: description and value encoding not translated.";
            sw = rw;
            hw = r;
            reset = 0x0;
        } store_method[1:0];
    } SCH_CTRL @ 0x4000;

    reg {
        name = "SCH_REG_NEWER";
        desc = "Data sheet 8.1.6 SCH_REG_NEWER (offset 0x4004, printed page 8-75, `hi3516v100--Hi3516-Datasheet.txt` line 39426).";

        field {
            name = "reg_newer";
            desc = "Reg newer. Chinese-only data sheet: description and value encoding not translated.";
            sw = rw;
            hw = r;
            reset = 0x0;
        } reg_newer[0:0];
    } SCH_REG_NEWER @ 0x4004;

    reg {
        name = "SCH_LINK";
        desc = "Data sheet 8.1.6 SCH_LINK (offset 0x4008, printed page 8-75, `hi3516v100--Hi3516-Datasheet.txt` line 39461).";

        field {
            name = "ch_link_sel";
            desc = "Ch link select. Chinese-only data sheet: description and value encoding not translated.";
            sw = rw;
            hw = r;
            reset = 0x0;
        } ch_link_sel[0:0];
    } SCH_LINK @ 0x4008;

    reg {
        name = "SCH_STORE";
        desc = "Data sheet 8.1.6 SCH_STORE (offset 0x400C, printed page 8-76, `hi3516v100--Hi3516-Datasheet.txt` line 39501).";

        field {
            name = "scan_mode";
            desc = "Scan mode. Chinese-only data sheet: description and value encoding not translated.";
            sw = rw;
            hw = r;
            reset = 0x0;
        } scan_mode[1:1];

        field {
            name = "store_mode";
            desc = "Store mode. Chinese-only data sheet: description and value encoding not translated.";
            sw = rw;
            hw = r;
            reset = 0x0;
        } store_mode[0:0];
    } SCH_STORE @ 0x400C;

    reg {
        name = "SCH_CROP_START";
        desc = "Data sheet 8.1.6 SCH_CROP_START (offset 0x4010, printed page 8-77, `hi3516v100--Hi3516-Datasheet.txt` line 39549).";

        field {
            name = "start_y";
            desc = "Start y. Chinese-only data sheet: description and value encoding not translated.";
            sw = rw;
            hw = r;
            reset = 0x0;
        } start_y[28:16];

        field {
            name = "start_x";
            desc = "Start x. Chinese-only data sheet: description and value encoding not translated.";
            sw = rw;
            hw = r;
            reset = 0x0;
        } start_x[12:0];
    } SCH_CROP_START @ 0x4010;

    reg {
        name = "SCH_CROP_SIZE";
        desc = "Data sheet 8.1.6 SCH_CROP_SIZE (offset 0x4014, printed page 8-77, `hi3516v100--Hi3516-Datasheet.txt` line 39579).";

        field {
            name = "crop_height";
            desc = "Crop height. Chinese-only data sheet: description and value encoding not translated.";
            sw = rw;
            hw = r;
            reset = 0x0;
        } crop_height[28:16];

        field {
            name = "crop_width";
            desc = "Crop width. Chinese-only data sheet: description and value encoding not translated.";
            sw = rw;
            hw = r;
            reset = 0x0;
        } crop_width[12:0];
    } SCH_CROP_SIZE @ 0x4014;

    reg {
        name = "SCH_FSTART_DLY";
        desc = "Data sheet 8.1.6 SCH_FSTART_DLY (offset 0x401C, printed page 8-78, `hi3516v100--Hi3516-Datasheet.txt` line 39618).";

        field {
            name = "fstart_dly";
            desc = "Fstart delay. Chinese-only data sheet: description and value encoding not translated.";
            sw = rw;
            hw = r;
            reset = 0x0;
        } fstart_dly[31:0];
    } SCH_FSTART_DLY @ 0x401C;

    reg {
        name = "SCH_YBASE_ADDR";
        desc = "Data sheet 8.1.6 SCH_YBASE_ADDR (offset 0x4020, printed page 8-78, `hi3516v100--Hi3516-Datasheet.txt` line 39637).";

        field {
            name = "ybase_addr";
            desc = "Ybase address. Chinese-only data sheet: description and value encoding not translated.";
            sw = rw;
            hw = r;
            reset = 0x0;
        } ybase_addr[31:0];
    } SCH_YBASE_ADDR @ 0x4020;

    reg {
        name = "SCH_CBASE_ADDR";
        desc = "Data sheet 8.1.6 SCH_CBASE_ADDR (offset 0x4024, printed page 8-78, `hi3516v100--Hi3516-Datasheet.txt` line 39656).";

        field {
            name = "cbase_addr";
            desc = "Cbase address. Chinese-only data sheet: description and value encoding not translated.";
            sw = rw;
            hw = r;
            reset = 0x0;
        } cbase_addr[31:0];
    } SCH_CBASE_ADDR @ 0x4024;

    reg {
        name = "SCH_Y_STRIDE";
        desc = "Data sheet 8.1.6 SCH_Y_STRIDE (offset 0x4028, printed page 8-79, `hi3516v100--Hi3516-Datasheet.txt` line 39686).";

        field {
            name = "y_stride";
            desc = "Y stride. Chinese-only data sheet: description and value encoding not translated.";
            sw = rw;
            hw = r;
            reset = 0x0;
        } y_stride[15:0];
    } SCH_Y_STRIDE @ 0x4028;

    reg {
        name = "SCH_C_STRIDE";
        desc = "Data sheet 8.1.6 SCH_C_STRIDE (offset 0x402C, printed page 8-79, `hi3516v100--Hi3516-Datasheet.txt` line 39707).";

        field {
            name = "c_stride";
            desc = "C stride. Chinese-only data sheet: description and value encoding not translated.";
            sw = rw;
            hw = r;
            reset = 0x0;
        } c_stride[15:0];
    } SCH_C_STRIDE @ 0x402C;

    reg {
        name = "SCH_HBASE_ADDR";
        desc = "Data sheet 8.1.6 SCH_HBASE_ADDR (offset 0x4030, printed page 8-80, `hi3516v100--Hi3516-Datasheet.txt` line 39740).";

        field {
            name = "hbase_addr";
            desc = "Hbase address. Chinese-only data sheet: description and value encoding not translated.";
            sw = rw;
            hw = r;
            reset = 0x0;
        } hbase_addr[31:0];
    } SCH_HBASE_ADDR @ 0x4030;

    reg {
        name = "SCH_H_STRIDE";
        desc = "Data sheet 8.1.6 SCH_H_STRIDE (offset 0x4034, printed page 8-80, `hi3516v100--Hi3516-Datasheet.txt` line 39759).";

        field {
            name = "h_stride";
            desc = "H stride. Chinese-only data sheet: description and value encoding not translated.";
            sw = rw;
            hw = r;
            reset = 0x0;
        } h_stride[15:0];
    } SCH_H_STRIDE @ 0x4034;

    reg {
        name = "SCH_HIST_SIZE";
        desc = "Data sheet 8.1.6 SCH_HIST_SIZE (offset 0x4038, printed page 8-81, `hi3516v100--Hi3516-Datasheet.txt` line 39795).";

        field {
            name = "h_win_height";
            desc = "H win height. Chinese-only data sheet: description and value encoding not translated.";
            sw = rw;
            hw = r;
            reset = 0x0;
        } h_win_height[3:2];

        field {
            name = "h_win_width";
            desc = "H win width. Chinese-only data sheet: description and value encoding not translated.";
            sw = rw;
            hw = r;
            reset = 0x0;
        } h_win_width[1:0];
    } SCH_HIST_SIZE @ 0x4038;

    reg {
        name = "SCH_HIST_MODE";
        desc = "Data sheet 8.1.6 SCH_HIST_MODE (offset 0x403C, printed page 8-81, `hi3516v100--Hi3516-Datasheet.txt` line 39825).";

        field {
            name = "hist_mode";
            desc = "Histogram mode. Chinese-only data sheet: description and value encoding not translated.";
            sw = rw;
            hw = r;
            reset = 0x0;
        } hist_mode[2:0];
    } SCH_HIST_MODE @ 0x403C;

    reg {
        name = "SCH_INT_EN";
        desc = "Data sheet 8.1.6 SCH_INT_EN (offset 0x4040, printed page 8-82, `hi3516v100--Hi3516-Datasheet.txt` line 39870).";

        field {
            name = "frame_pulse_int_en";
            desc = "Frame pulse interrupt enable. Chinese-only data sheet: description and value encoding not translated.";
            sw = rw;
            hw = r;
            reset = 0x0;
        } frame_pulse_int_en[5:5];

        field {
            name = "reg_update_int_en";
            desc = "Reg update interrupt enable. Chinese-only data sheet: description and value encoding not translated.";
            sw = rw;
            hw = r;
            reset = 0x0;
        } reg_update_int_en[4:4];

        field {
            name = "err_int_en";
            desc = "Error interrupt enable. Chinese-only data sheet: description and value encoding not translated.";
            sw = rw;
            hw = r;
            reset = 0x0;
        } err_int_en[3:3];

        field {
            name = "field_throw_int_en";
            desc = "Field throw interrupt enable. Chinese-only data sheet: description and value encoding not translated.";
            sw = rw;
            hw = r;
            reset = 0x0;
        } field_throw_int_en[2:2];

        field {
            name = "buf_ovf_int_en";
            desc = "Buf overflow interrupt enable. Chinese-only data sheet: description and value encoding not translated.";
            sw = rw;
            hw = r;
            reset = 0x0;
        } buf_ovf_int_en[1:1];

        field {
            name = "cc_int_en";
            desc = "Cc interrupt enable. Chinese-only data sheet: description and value encoding not translated.";
            sw = rw;
            hw = r;
            reset = 0x0;
        } cc_int_en[0:0];
    } SCH_INT_EN @ 0x4040;

    reg {
        name = "SCH_INT_STATUS";
        desc = "Data sheet 8.1.6 SCH_INT_STATUS (offset 0x4044, printed page 8-83, `hi3516v100--Hi3516-Datasheet.txt` line 39933).";

        field {
            name = "frame_pulse_int";
            desc = "Frame pulse interrupt. Chinese-only data sheet: description and value encoding not translated.";
            sw = rw;
            hw = w;
            onwrite = woclr;
            reset = 0x0;
        } frame_pulse_int[5:5];

        field {
            name = "reg_update_int";
            desc = "Reg update interrupt. Chinese-only data sheet: description and value encoding not translated.";
            sw = rw;
            hw = w;
            onwrite = woclr;
            reset = 0x0;
        } reg_update_int[4:4];

        field {
            name = "err_int";
            desc = "Error interrupt. Chinese-only data sheet: description and value encoding not translated.";
            sw = rw;
            hw = w;
            onwrite = woclr;
            reset = 0x0;
        } err_int[3:3];

        field {
            name = "field_throw_int";
            desc = "Field throw interrupt. Chinese-only data sheet: description and value encoding not translated.";
            sw = rw;
            hw = w;
            onwrite = woclr;
            reset = 0x0;
        } field_throw_int[2:2];

        field {
            name = "buf_ovf_int";
            desc = "Buf overflow interrupt. Chinese-only data sheet: description and value encoding not translated.";
            sw = rw;
            hw = w;
            onwrite = woclr;
            reset = 0x0;
        } buf_ovf_int[1:1];

        field {
            name = "cc_int";
            desc = "Cc interrupt. Chinese-only data sheet: description and value encoding not translated.";
            sw = rw;
            hw = w;
            onwrite = woclr;
            reset = 0x0;
        } cc_int[0:0];
    } SCH_INT_STATUS @ 0x4044;

    reg {
        name = "SCH_RAW_INT";
        desc = "Data sheet 8.1.6 SCH_RAW_INT (offset 0x4048, printed page 8-84, `hi3516v100--Hi3516-Datasheet.txt` line 39994).";

        field {
            name = "frame_pulse_raw_int";
            desc = "Frame pulse raw interrupt. Chinese-only data sheet: description and value encoding not translated.";
            sw = r;
            hw = w;
            reset = 0x0;
        } frame_pulse_raw_int[5:5];

        field {
            name = "reg_update_raw_int";
            desc = "Reg update raw interrupt. Chinese-only data sheet: description and value encoding not translated.";
            sw = r;
            hw = w;
            reset = 0x0;
        } reg_update_raw_int[4:4];

        field {
            name = "err_raw_int";
            desc = "Error raw interrupt. Chinese-only data sheet: description and value encoding not translated.";
            sw = r;
            hw = w;
            reset = 0x0;
        } err_raw_int[3:3];

        field {
            name = "field_throw_raw_int";
            desc = "Field throw raw interrupt. Chinese-only data sheet: description and value encoding not translated.";
            sw = r;
            hw = w;
            reset = 0x0;
        } field_throw_raw_int[2:2];

        field {
            name = "buf_ovf_raw_int";
            desc = "Buf overflow raw interrupt. Chinese-only data sheet: description and value encoding not translated.";
            sw = r;
            hw = w;
            reset = 0x0;
        } buf_ovf_raw_int[1:1];

        field {
            name = "cc_raw_int";
            desc = "Cc raw interrupt. Chinese-only data sheet: description and value encoding not translated.";
            sw = r;
            hw = w;
            reset = 0x0;
        } cc_raw_int[0:0];
    } SCH_RAW_INT @ 0x4048;

    reg {
        name = "SCH_STATUS";
        desc = "Data sheet 8.1.6 SCH_STATUS (offset 0x404C, printed page 8-85, `hi3516v100--Hi3516-Datasheet.txt` line 40064).";

        field {
            name = "field_height";
            desc = "Field height. Chinese-only data sheet: description and value encoding not translated.";
            sw = r;
            hw = w;
            reset = 0x0;
        } field_height[18:6];

        field {
            name = "ch_busy";
            desc = "Ch busy. Chinese-only data sheet: description and value encoding not translated.";
            sw = r;
            hw = w;
            reset = 0x0;
        } ch_busy[5:5];

        field {
            name = "field2";
            desc = "Field2. Chinese-only data sheet: description and value encoding not translated.";
            sw = r;
            hw = w;
            reset = 0x0;
        } field2[4:4];

        field {
            name = "bus_err";
            desc = "Bus error. Chinese-only data sheet: description and value encoding not translated.";
            sw = r;
            hw = w;
            reset = 0x0;
        } bus_err[3:3];

        field {
            name = "frame_loss";
            desc = "Frame loss. Chinese-only data sheet: description and value encoding not translated.";
            sw = r;
            hw = w;
            reset = 0x0;
        } frame_loss[2:2];

        field {
            name = "buf_ovf";
            desc = "Buf overflow. Chinese-only data sheet: description and value encoding not translated.";
            sw = r;
            hw = w;
            reset = 0x0;
        } buf_ovf[1:1];

        field {
            name = "image_done";
            desc = "Image done. Chinese-only data sheet: description and value encoding not translated.";
            sw = r;
            hw = w;
            reset = 0x0;
        } image_done[0:0];
    } SCH_STATUS @ 0x404C;

    reg {
        name = "MCH_CTRL";
        desc = "Data sheet 8.1.6 MCH_CTRL (offset 0x5000, printed page 8-86, `hi3516v100--Hi3516-Datasheet.txt` line 40127).";

        field {
            name = "ch_en";
            desc = "Ch enable. Chinese-only data sheet: description and value encoding not translated.";
            sw = rw;
            hw = r;
            reset = 0x0;
        } ch_en[31:31];

        field {
            name = "hist_en";
            desc = "Histogram enable. Chinese-only data sheet: description and value encoding not translated.";
            sw = rw;
            hw = r;
            reset = 0x0;
        } hist_en[23:23];

        field {
            name = "flip_en";
            desc = "Flip enable. Chinese-only data sheet: description and value encoding not translated.";
            sw = rw;
            hw = r;
            reset = 0x0;
        } flip_en[22:22];

        field {
            name = "mir_en";
            desc = "Mir enable. Chinese-only data sheet: description and value encoding not translated.";
            sw = rw;
            hw = r;
            reset = 0x0;
        } mir_en[21:21];

        field {
            name = "store_method";
            desc = "Store method. Chinese-only data sheet: description and value encoding not translated.";
            sw = rw;
            hw = r;
            reset = 0x0;
        } store_method[1:0];
    } MCH_CTRL @ 0x5000;

    reg {
        name = "MCH_REG_NEWER";
        desc = "Data sheet 8.1.6 MCH_REG_NEWER (offset 0x5004, printed page 8-87, `hi3516v100--Hi3516-Datasheet.txt` line 40189).";

        field {
            name = "reg_newer";
            desc = "Reg newer. Chinese-only data sheet: description and value encoding not translated.";
            sw = rw;
            hw = r;
            reset = 0x0;
        } reg_newer[0:0];
    } MCH_REG_NEWER @ 0x5004;

    reg {
        name = "MCH_LINK";
        desc = "Data sheet 8.1.6 MCH_LINK (offset 0x5008, printed page 8-88, `hi3516v100--Hi3516-Datasheet.txt` line 40236).";

        field {
            name = "ch_link_sel";
            desc = "Ch link select. Chinese-only data sheet: description and value encoding not translated.";
            sw = rw;
            hw = r;
            reset = 0x0;
        } ch_link_sel[0:0];
    } MCH_LINK @ 0x5008;

    reg {
        name = "MCH_STORE";
        desc = "Data sheet 8.1.6 MCH_STORE (offset 0x500C, printed page 8-89, `hi3516v100--Hi3516-Datasheet.txt` line 40281).";

        field {
            name = "scan_mode";
            desc = "Scan mode. Chinese-only data sheet: description and value encoding not translated.";
            sw = rw;
            hw = r;
            reset = 0x0;
        } scan_mode[1:1];

        field {
            name = "store_mode";
            desc = "Store mode. Chinese-only data sheet: description and value encoding not translated.";
            sw = rw;
            hw = r;
            reset = 0x0;
        } store_mode[0:0];
    } MCH_STORE @ 0x500C;

    reg {
        name = "MCH_CROP_START";
        desc = "Data sheet 8.1.6 MCH_CROP_START (offset 0x5010, printed page 8-89, `hi3516v100--Hi3516-Datasheet.txt` line 40314).";

        field {
            name = "start_y";
            desc = "Start y. Chinese-only data sheet: description and value encoding not translated.";
            sw = rw;
            hw = r;
            reset = 0x0;
        } start_y[28:16];

        field {
            name = "start_x";
            desc = "Start x. Chinese-only data sheet: description and value encoding not translated.";
            sw = rw;
            hw = r;
            reset = 0x0;
        } start_x[12:0];
    } MCH_CROP_START @ 0x5010;

    reg {
        name = "MCH_CROP_SIZE";
        desc = "Data sheet 8.1.6 MCH_CROP_SIZE (offset 0x5014, printed page 8-90, `hi3516v100--Hi3516-Datasheet.txt` line 40353).";

        field {
            name = "crop_height";
            desc = "Crop height. Chinese-only data sheet: description and value encoding not translated.";
            sw = rw;
            hw = r;
            reset = 0x0;
        } crop_height[28:16];

        field {
            name = "crop_width";
            desc = "Crop width. Chinese-only data sheet: description and value encoding not translated.";
            sw = rw;
            hw = r;
            reset = 0x0;
        } crop_width[12:0];
    } MCH_CROP_SIZE @ 0x5014;

    reg {
        name = "MCH_DES_SIZE";
        desc = "Data sheet 8.1.6 MCH_DES_SIZE (offset 0x5018, printed page 8-90, `hi3516v100--Hi3516-Datasheet.txt` line 40383).";

        field {
            name = "des_height";
            desc = "Des height. Chinese-only data sheet: description and value encoding not translated.";
            sw = rw;
            hw = r;
            reset = 0x0;
        } des_height[28:16];

        field {
            name = "des_width";
            desc = "Des width. Chinese-only data sheet: description and value encoding not translated.";
            sw = rw;
            hw = r;
            reset = 0x0;
        } des_width[12:0];
    } MCH_DES_SIZE @ 0x5018;

    reg {
        name = "MCH_FSTART_DLY";
        desc = "Data sheet 8.1.6 MCH_FSTART_DLY (offset 0x501C, printed page 8-91, `hi3516v100--Hi3516-Datasheet.txt` line 40425).";

        field {
            name = "fstart_dly";
            desc = "Fstart delay. Chinese-only data sheet: description and value encoding not translated.";
            sw = rw;
            hw = r;
            reset = 0x0;
        } fstart_dly[31:0];
    } MCH_FSTART_DLY @ 0x501C;

    reg {
        name = "MCH_YBASE_ADDR";
        desc = "Data sheet 8.1.6 MCH_YBASE_ADDR (offset 0x5020, printed page 8-91, `hi3516v100--Hi3516-Datasheet.txt` line 40444).";

        field {
            name = "ybase_addr";
            desc = "Ybase address. Chinese-only data sheet: description and value encoding not translated.";
            sw = rw;
            hw = r;
            reset = 0x0;
        } ybase_addr[31:0];
    } MCH_YBASE_ADDR @ 0x5020;

    reg {
        name = "MCH_CBASE_ADDR";
        desc = "Data sheet 8.1.6 MCH_CBASE_ADDR (offset 0x5024, printed page 8-92, `hi3516v100--Hi3516-Datasheet.txt` line 40475).";

        field {
            name = "cbase_addr";
            desc = "Cbase address. Chinese-only data sheet: description and value encoding not translated.";
            sw = rw;
            hw = r;
            reset = 0x0;
        } cbase_addr[31:0];
    } MCH_CBASE_ADDR @ 0x5024;

    reg {
        name = "MCH_Y_STRIDE";
        desc = "Data sheet 8.1.6 MCH_Y_STRIDE (offset 0x5028, printed page 8-92, `hi3516v100--Hi3516-Datasheet.txt` line 40494).";

        field {
            name = "y_stride";
            desc = "Y stride. Chinese-only data sheet: description and value encoding not translated.";
            sw = rw;
            hw = r;
            reset = 0x0;
        } y_stride[15:0];
    } MCH_Y_STRIDE @ 0x5028;

    reg {
        name = "MCH_C_STRIDE";
        desc = "Data sheet 8.1.6 MCH_C_STRIDE (offset 0x502C, printed page 8-92, `hi3516v100--Hi3516-Datasheet.txt` line 40515).";

        field {
            name = "c_stride";
            desc = "C stride. Chinese-only data sheet: description and value encoding not translated.";
            sw = rw;
            hw = r;
            reset = 0x0;
        } c_stride[15:0];
    } MCH_C_STRIDE @ 0x502C;

    reg {
        name = "MCH_HBASE_ADDR";
        desc = "Data sheet 8.1.6 MCH_HBASE_ADDR (offset 0x5030, printed page 8-93, `hi3516v100--Hi3516-Datasheet.txt` line 40547).";

        field {
            name = "hbase_addr";
            desc = "Hbase address. Chinese-only data sheet: description and value encoding not translated.";
            sw = rw;
            hw = r;
            reset = 0x0;
        } hbase_addr[31:0];
    } MCH_HBASE_ADDR @ 0x5030;

    reg {
        name = "MCH_H_STRIDE";
        desc = "Data sheet 8.1.6 MCH_H_STRIDE (offset 0x5034, printed page 8-93, `hi3516v100--Hi3516-Datasheet.txt` line 40566).";

        field {
            name = "h_stride";
            desc = "H stride. Chinese-only data sheet: description and value encoding not translated.";
            sw = rw;
            hw = r;
            reset = 0x0;
        } h_stride[15:0];
    } MCH_H_STRIDE @ 0x5034;

    reg {
        name = "MCH_HIST_SIZE";
        desc = "Data sheet 8.1.6 MCH_HIST_SIZE (offset 0x5038, printed page 8-94, `hi3516v100--Hi3516-Datasheet.txt` line 40599).";

        field {
            name = "h_win_height";
            desc = "H win height. Chinese-only data sheet: description and value encoding not translated.";
            sw = rw;
            hw = r;
            reset = 0x0;
        } h_win_height[3:2];

        field {
            name = "h_win_width";
            desc = "H win width. Chinese-only data sheet: description and value encoding not translated.";
            sw = rw;
            hw = r;
            reset = 0x0;
        } h_win_width[1:0];
    } MCH_HIST_SIZE @ 0x5038;

    reg {
        name = "MCH_HIST_MODE";
        desc = "Data sheet 8.1.6 MCH_HIST_MODE (offset 0x503C, printed page 8-94, `hi3516v100--Hi3516-Datasheet.txt` line 40629).";

        field {
            name = "hist_mode";
            desc = "Histogram mode. Chinese-only data sheet: description and value encoding not translated.";
            sw = rw;
            hw = r;
            reset = 0x0;
        } hist_mode[2:0];
    } MCH_HIST_MODE @ 0x503C;

    reg {
        name = "MCH_INT_EN";
        desc = "Data sheet 8.1.6 MCH_INT_EN (offset 0x5040, printed page 8-95, `hi3516v100--Hi3516-Datasheet.txt` line 40672).";

        field {
            name = "frame_pulse_int_en";
            desc = "Frame pulse interrupt enable. Chinese-only data sheet: description and value encoding not translated.";
            sw = rw;
            hw = r;
            reset = 0x0;
        } frame_pulse_int_en[5:5];

        field {
            name = "reg_update_int_en";
            desc = "Reg update interrupt enable. Chinese-only data sheet: description and value encoding not translated.";
            sw = rw;
            hw = r;
            reset = 0x0;
        } reg_update_int_en[4:4];

        field {
            name = "err_int_en";
            desc = "Error interrupt enable. Chinese-only data sheet: description and value encoding not translated.";
            sw = rw;
            hw = r;
            reset = 0x0;
        } err_int_en[3:3];

        field {
            name = "field_throw_int_en";
            desc = "Field throw interrupt enable. Chinese-only data sheet: description and value encoding not translated.";
            sw = rw;
            hw = r;
            reset = 0x0;
        } field_throw_int_en[2:2];

        field {
            name = "buf_ovf_int_en";
            desc = "Buf overflow interrupt enable. Chinese-only data sheet: description and value encoding not translated.";
            sw = rw;
            hw = r;
            reset = 0x0;
        } buf_ovf_int_en[1:1];

        field {
            name = "cc_int_en";
            desc = "Cc interrupt enable. Chinese-only data sheet: description and value encoding not translated.";
            sw = rw;
            hw = r;
            reset = 0x0;
        } cc_int_en[0:0];
    } MCH_INT_EN @ 0x5040;

    reg {
        name = "MCH_INT_STATUS";
        desc = "Data sheet 8.1.6 MCH_INT_STATUS (offset 0x5044, printed page 8-96, `hi3516v100--Hi3516-Datasheet.txt` line 40729).";

        field {
            name = "frame_pulse_int";
            desc = "Frame pulse interrupt. Chinese-only data sheet: description and value encoding not translated.";
            sw = rw;
            hw = w;
            onwrite = woclr;
            reset = 0x0;
        } frame_pulse_int[5:5];

        field {
            name = "reg_update_int";
            desc = "Reg update interrupt. Chinese-only data sheet: description and value encoding not translated.";
            sw = rw;
            hw = w;
            onwrite = woclr;
            reset = 0x0;
        } reg_update_int[4:4];

        field {
            name = "err_int";
            desc = "Error interrupt. Chinese-only data sheet: description and value encoding not translated.";
            sw = rw;
            hw = w;
            onwrite = woclr;
            reset = 0x0;
        } err_int[3:3];

        field {
            name = "field_throw_int";
            desc = "Field throw interrupt. Chinese-only data sheet: description and value encoding not translated.";
            sw = rw;
            hw = w;
            onwrite = woclr;
            reset = 0x0;
        } field_throw_int[2:2];

        field {
            name = "buf_ovf_int";
            desc = "Buf overflow interrupt. Chinese-only data sheet: description and value encoding not translated.";
            sw = rw;
            hw = w;
            onwrite = woclr;
            reset = 0x0;
        } buf_ovf_int[1:1];

        field {
            name = "cc_int";
            desc = "Cc interrupt. Chinese-only data sheet: description and value encoding not translated.";
            sw = rw;
            hw = w;
            onwrite = woclr;
            reset = 0x0;
        } cc_int[0:0];
    } MCH_INT_STATUS @ 0x5044;

    reg {
        name = "MCH_RAW_INT";
        desc = "Data sheet 8.1.6 MCH_RAW_INT (offset 0x5048, printed page 8-97, `hi3516v100--Hi3516-Datasheet.txt` line 40791).";

        field {
            name = "frame_pulse_raw_int";
            desc = "Frame pulse raw interrupt. Chinese-only data sheet: description and value encoding not translated.";
            sw = r;
            hw = w;
            reset = 0x0;
        } frame_pulse_raw_int[5:5];

        field {
            name = "reg_update_raw_int";
            desc = "Reg update raw interrupt. Chinese-only data sheet: description and value encoding not translated.";
            sw = r;
            hw = w;
            reset = 0x0;
        } reg_update_raw_int[4:4];

        field {
            name = "err_raw_int";
            desc = "Error raw interrupt. Chinese-only data sheet: description and value encoding not translated.";
            sw = r;
            hw = w;
            reset = 0x0;
        } err_raw_int[3:3];

        field {
            name = "field_throw_raw_int";
            desc = "Field throw raw interrupt. Chinese-only data sheet: description and value encoding not translated.";
            sw = r;
            hw = w;
            reset = 0x0;
        } field_throw_raw_int[2:2];

        field {
            name = "buf_ovf_raw_int";
            desc = "Buf overflow raw interrupt. Chinese-only data sheet: description and value encoding not translated.";
            sw = r;
            hw = w;
            reset = 0x0;
        } buf_ovf_raw_int[1:1];

        field {
            name = "cc_raw_int";
            desc = "Cc raw interrupt. Chinese-only data sheet: description and value encoding not translated.";
            sw = r;
            hw = w;
            reset = 0x0;
        } cc_raw_int[0:0];
    } MCH_RAW_INT @ 0x5048;

    reg {
        name = "MCH_STATUS";
        desc = "Data sheet 8.1.6 MCH_STATUS (offset 0x504C, printed page 8-98, `hi3516v100--Hi3516-Datasheet.txt` line 40858).";

        field {
            name = "field_height";
            desc = "Field height. Chinese-only data sheet: description and value encoding not translated.";
            sw = r;
            hw = w;
            reset = 0x0;
        } field_height[18:6];

        field {
            name = "ch_busy";
            desc = "Ch busy. Chinese-only data sheet: description and value encoding not translated.";
            sw = r;
            hw = w;
            reset = 0x0;
        } ch_busy[5:5];

        field {
            name = "field2";
            desc = "Field2. Chinese-only data sheet: description and value encoding not translated.";
            sw = r;
            hw = w;
            reset = 0x0;
        } field2[4:4];

        field {
            name = "bus_err";
            desc = "Bus error. Chinese-only data sheet: description and value encoding not translated.";
            sw = r;
            hw = w;
            reset = 0x0;
        } bus_err[3:3];

        field {
            name = "frame_loss";
            desc = "Frame loss. Chinese-only data sheet: description and value encoding not translated.";
            sw = r;
            hw = w;
            reset = 0x0;
        } frame_loss[2:2];

        field {
            name = "buf_ovf";
            desc = "Buf overflow. Chinese-only data sheet: description and value encoding not translated.";
            sw = r;
            hw = w;
            reset = 0x0;
        } buf_ovf[1:1];

        field {
            name = "image_done";
            desc = "Image done. Chinese-only data sheet: description and value encoding not translated.";
            sw = r;
            hw = w;
            reset = 0x0;
        } image_done[0:0];
    } MCH_STATUS @ 0x504C;

    reg {
        name = "MCH_HLFIR_PAR";
        desc = "Data sheet 8.1.6 MCH_HLFIR_PAR (offset 0x5100, printed page 8-99, `hi3516v100--Hi3516-Datasheet.txt` line 40925).";

        field {
            name = "hlmsc_en";
            desc = "Hlmsc enable. Chinese-only data sheet: description and value encoding not translated.";
            sw = rw;
            hw = r;
            reset = 0x0;
        } hlmsc_en[31:31];

        field {
            name = "hlmid_en";
            desc = "Hlmid enable. Chinese-only data sheet: description and value encoding not translated.";
            sw = rw;
            hw = r;
            reset = 0x0;
        } hlmid_en[30:30];

        field {
            name = "hlfir_en";
            desc = "Hlfir enable. Chinese-only data sheet: description and value encoding not translated.";
            sw = rw;
            hw = r;
            reset = 0x0;
        } hlfir_en[29:29];

        field {
            name = "hlfir_clip_en";
            desc = "Hlfir clip enable. Chinese-only data sheet: description and value encoding not translated.";
            sw = rw;
            hw = r;
            reset = 0x0;
        } hlfir_clip_en[28:28];

        field {
            name = "hlratio";
            desc = "Hlratio. Chinese-only data sheet: description and value encoding not translated.";
            sw = rw;
            hw = r;
            reset = 0x0;
        } hlratio[15:0];
    } MCH_HLFIR_PAR @ 0x5100;

    reg {
        name = "MCH_HCFIR_PAR";
        desc = "Data sheet 8.1.6 MCH_HCFIR_PAR (offset 0x5104, printed page 8-100, `hi3516v100--Hi3516-Datasheet.txt` line 40988).";

        field {
            name = "hchmsc_en";
            desc = "Hchmsc enable. Chinese-only data sheet: description and value encoding not translated.";
            sw = rw;
            hw = r;
            reset = 0x0;
        } hchmsc_en[31:31];

        field {
            name = "hchmid_en";
            desc = "Hchmid enable. Chinese-only data sheet: description and value encoding not translated.";
            sw = rw;
            hw = r;
            reset = 0x0;
        } hchmid_en[30:30];

        field {
            name = "hchfir_en";
            desc = "Hchfir enable. Chinese-only data sheet: description and value encoding not translated.";
            sw = rw;
            hw = r;
            reset = 0x0;
        } hchfir_en[29:29];

        field {
            name = "hchfir_clip_en";
            desc = "Hchfir clip enable. Chinese-only data sheet: description and value encoding not translated.";
            sw = rw;
            hw = r;
            reset = 0x0;
        } hchfir_clip_en[28:28];

        field {
            name = "hchratio";
            desc = "Hchratio. Chinese-only data sheet: description and value encoding not translated.";
            sw = rw;
            hw = r;
            reset = 0x0;
        } hchratio[15:0];
    } MCH_HCFIR_PAR @ 0x5104;

    reg {
        name = "MCH_HLFIR_OFFSET";
        desc = "Data sheet 8.1.6 MCH_HLFIR_OFFSET (offset 0x5108, printed page 8-101, `hi3516v100--Hi3516-Datasheet.txt` line 41054).";

        field {
            name = "hluma_offset";
            desc = "Hluma offset. Chinese-only data sheet: description and value encoding not translated.";
            sw = rw;
            hw = r;
            reset = 0x0;
        } hluma_offset[16:0];
    } MCH_HLFIR_OFFSET @ 0x5108;

    reg {
        name = "MCH_HCFIR_OFFSET";
        desc = "Data sheet 8.1.6 MCH_HCFIR_OFFSET (offset 0x510C, printed page 8-102, `hi3516v100--Hi3516-Datasheet.txt` line 41089).";

        field {
            name = "hchroma_offset";
            desc = "Hchroma offset. Chinese-only data sheet: description and value encoding not translated.";
            sw = rw;
            hw = r;
            reset = 0x0;
        } hchroma_offset[16:0];
    } MCH_HCFIR_OFFSET @ 0x510C;

    reg {
        name = "MCH_VLFIR_PAR";
        desc = "Data sheet 8.1.6 MCH_VLFIR_PAR (offset 0x5110, printed page 8-102, `hi3516v100--Hi3516-Datasheet.txt` line 41112).";

        field {
            name = "vlmsc_en";
            desc = "Vlmsc enable. Chinese-only data sheet: description and value encoding not translated.";
            sw = rw;
            hw = r;
            reset = 0x0;
        } vlmsc_en[31:31];

        field {
            name = "vlmid_en";
            desc = "Vlmid enable. Chinese-only data sheet: description and value encoding not translated.";
            sw = rw;
            hw = r;
            reset = 0x0;
        } vlmid_en[30:30];

        field {
            name = "vlfir_en";
            desc = "Vlfir enable. Chinese-only data sheet: description and value encoding not translated.";
            sw = rw;
            hw = r;
            reset = 0x0;
        } vlfir_en[29:29];

        field {
            name = "vlfir_clip_en";
            desc = "Vlfir clip enable. Chinese-only data sheet: description and value encoding not translated.";
            sw = rw;
            hw = r;
            reset = 0x0;
        } vlfir_clip_en[28:28];

        field {
            name = "vlratio";
            desc = "Vlratio. Chinese-only data sheet: description and value encoding not translated.";
            sw = rw;
            hw = r;
            reset = 0x0;
        } vlratio[15:0];
    } MCH_VLFIR_PAR @ 0x5110;

    reg {
        name = "MCH_VCFIR_PAR";
        desc = "Data sheet 8.1.6 MCH_VCFIR_PAR (offset 0x5114, printed page 8-103, `hi3516v100--Hi3516-Datasheet.txt` line 41178).";

        field {
            name = "vchmsc_en";
            desc = "Vchmsc enable. Chinese-only data sheet: description and value encoding not translated.";
            sw = rw;
            hw = r;
            reset = 0x0;
        } vchmsc_en[31:31];

        field {
            name = "vchmid_en";
            desc = "Vchmid enable. Chinese-only data sheet: description and value encoding not translated.";
            sw = rw;
            hw = r;
            reset = 0x0;
        } vchmid_en[30:30];

        field {
            name = "vchfir_en";
            desc = "Vchfir enable. Chinese-only data sheet: description and value encoding not translated.";
            sw = rw;
            hw = r;
            reset = 0x0;
        } vchfir_en[29:29];

        field {
            name = "vchfir_clip_en";
            desc = "Vchfir clip enable. Chinese-only data sheet: description and value encoding not translated.";
            sw = rw;
            hw = r;
            reset = 0x0;
        } vchfir_clip_en[28:28];

        field {
            name = "vchratio";
            desc = "Vchratio. Chinese-only data sheet: description and value encoding not translated.";
            sw = rw;
            hw = r;
            reset = 0x0;
        } vchratio[15:0];
    } MCH_VCFIR_PAR @ 0x5114;

    reg {
        name = "MCH_VLFIR_OFFSET";
        desc = "Data sheet 8.1.6 MCH_VLFIR_OFFSET (offset 0x5118, printed page 8-104, `hi3516v100--Hi3516-Datasheet.txt` line 41238).";

        field {
            name = "vluma_offset";
            desc = "Vluma offset. Chinese-only data sheet: description and value encoding not translated.";
            sw = rw;
            hw = r;
            reset = 0x0;
        } vluma_offset[16:0];
    } MCH_VLFIR_OFFSET @ 0x5118;

    reg {
        name = "MCH_VCFIR_OFFSET";
        desc = "Data sheet 8.1.6 MCH_VCFIR_OFFSET (offset 0x511C, printed page 8-105, `hi3516v100--Hi3516-Datasheet.txt` line 41276).";

        field {
            name = "vchroma_offset";
            desc = "Vchroma offset. Chinese-only data sheet: description and value encoding not translated.";
            sw = rw;
            hw = r;
            reset = 0x0;
        } vchroma_offset[16:0];
    } MCH_VCFIR_OFFSET @ 0x511C;

    reg {
        name = "MCH_COEF_UPDATE";
        desc = "Data sheet 8.1.6 MCH_COEF_UPDATE (offset 0x5120, printed page 8-105, `hi3516v100--Hi3516-Datasheet.txt` line 41299).";

        field {
            name = "cvcoef_update";
            desc = "Cvcoef update. Chinese-only data sheet: description and value encoding not translated.";
            sw = rw;
            hw = r;
            reset = 0x0;
        } cvcoef_update[3:3];

        field {
            name = "lvcoef_update";
            desc = "Lvcoef update. Chinese-only data sheet: description and value encoding not translated.";
            sw = rw;
            hw = r;
            reset = 0x0;
        } lvcoef_update[2:2];

        field {
            name = "chcoef_update";
            desc = "Chcoef update. Chinese-only data sheet: description and value encoding not translated.";
            sw = rw;
            hw = r;
            reset = 0x0;
        } chcoef_update[1:1];

        field {
            name = "lhcoef_update";
            desc = "Lhcoef update. Chinese-only data sheet: description and value encoding not translated.";
            sw = rw;
            hw = r;
            reset = 0x0;
        } lhcoef_update[0:0];
    } MCH_COEF_UPDATE @ 0x5120;

    reg {
        name = "MCH_HBLANK_WIDTH";
        desc = "Data sheet 8.1.6 MCH_HBLANK_WIDTH (offset 0x5124, printed page 8-106, `hi3516v100--Hi3516-Datasheet.txt` line 41352).";

        field {
            name = "hblank_width";
            desc = "Hblank width. Chinese-only data sheet: description and value encoding not translated.";
            sw = rw;
            hw = r;
            reset = 0x80;
        } hblank_width[15:0];
    } MCH_HBLANK_WIDTH @ 0x5124;

    reg {
        name = "MCH_COEF_RSEL";
        desc = "Data sheet 8.1.6 MCH_COEF_RSEL (offset 0x5128, printed page 8-107, `hi3516v100--Hi3516-Datasheet.txt` line 41392).";

        field {
            name = "cvcoef_read_sel";
            desc = "Cvcoef read select. Chinese-only data sheet: description and value encoding not translated.";
            sw = rw;
            hw = r;
            reset = 0x0;
        } cvcoef_read_sel[3:3];

        field {
            name = "lvcoef_read_sel";
            desc = "Lvcoef read select. Chinese-only data sheet: description and value encoding not translated.";
            sw = rw;
            hw = r;
            reset = 0x0;
        } lvcoef_read_sel[2:2];

        field {
            name = "chcoef_read_sel";
            desc = "Chcoef read select. Chinese-only data sheet: description and value encoding not translated.";
            sw = rw;
            hw = r;
            reset = 0x0;
        } chcoef_read_sel[1:1];

        field {
            name = "lhcoef_read_sel";
            desc = "Lhcoef read select. Chinese-only data sheet: description and value encoding not translated.";
            sw = rw;
            hw = r;
            reset = 0x0;
        } lhcoef_read_sel[0:0];
    } MCH_COEF_RSEL @ 0x5128;

    reg {
        name = "PCH1_CTRL";
        desc = "Data sheet 8.1.6 PCH1_CTRL (offset 0x6000, printed page 8-108, `hi3516v100--Hi3516-Datasheet.txt` line 41446).";

        field {
            name = "ch_en";
            desc = "Ch enable. Chinese-only data sheet: description and value encoding not translated.";
            sw = rw;
            hw = r;
            reset = 0x0;
        } ch_en[31:31];

        field {
            name = "hist_en";
            desc = "Histogram enable. Chinese-only data sheet: description and value encoding not translated.";
            sw = rw;
            hw = r;
            reset = 0x0;
        } hist_en[23:23];

        field {
            name = "flip_en";
            desc = "Flip enable. Chinese-only data sheet: description and value encoding not translated.";
            sw = rw;
            hw = r;
            reset = 0x0;
        } flip_en[22:22];

        field {
            name = "mir_en";
            desc = "Mir enable. Chinese-only data sheet: description and value encoding not translated.";
            sw = rw;
            hw = r;
            reset = 0x0;
        } mir_en[21:21];

        field {
            name = "store_method";
            desc = "Store method. Chinese-only data sheet: description and value encoding not translated.";
            sw = rw;
            hw = r;
            reset = 0x0;
        } store_method[1:0];
    } PCH1_CTRL @ 0x6000;

    reg {
        name = "PCH1_REG_NEWER";
        desc = "Data sheet 8.1.6 PCH1_REG_NEWER (offset 0x6004, printed page 8-109, `hi3516v100--Hi3516-Datasheet.txt` line 41510).";

        field {
            name = "reg_newer";
            desc = "Reg newer. Chinese-only data sheet: description and value encoding not translated.";
            sw = rw;
            hw = r;
            reset = 0x0;
        } reg_newer[0:0];
    } PCH1_REG_NEWER @ 0x6004;

    reg {
        name = "PCH1_LINK";
        desc = "Data sheet 8.1.6 PCH1_LINK (offset 0x6008, printed page 8-109, `hi3516v100--Hi3516-Datasheet.txt` line 41545).";

        field {
            name = "ch_link_sel";
            desc = "Ch link select. Chinese-only data sheet: description and value encoding not translated.";
            sw = rw;
            hw = r;
            reset = 0x0;
        } ch_link_sel[0:0];
    } PCH1_LINK @ 0x6008;

    reg {
        name = "PCH1_STORE";
        desc = "Data sheet 8.1.6 PCH1_STORE (offset 0x600C, printed page 8-110, `hi3516v100--Hi3516-Datasheet.txt` line 41585).";

        field {
            name = "scan_mode";
            desc = "Scan mode. Chinese-only data sheet: description and value encoding not translated.";
            sw = rw;
            hw = r;
            reset = 0x0;
        } scan_mode[1:1];

        field {
            name = "store_mode";
            desc = "Store mode. Chinese-only data sheet: description and value encoding not translated.";
            sw = rw;
            hw = r;
            reset = 0x0;
        } store_mode[0:0];
    } PCH1_STORE @ 0x600C;

    reg {
        name = "PCH1_CROP_START";
        desc = "Data sheet 8.1.6 PCH1_CROP_START (offset 0x6010, printed page 8-111, `hi3516v100--Hi3516-Datasheet.txt` line 41633).";

        field {
            name = "start_y";
            desc = "Start y. Chinese-only data sheet: description and value encoding not translated.";
            sw = rw;
            hw = r;
            reset = 0x0;
        } start_y[28:16];

        field {
            name = "start_x";
            desc = "Start x. Chinese-only data sheet: description and value encoding not translated.";
            sw = rw;
            hw = r;
            reset = 0x0;
        } start_x[12:0];
    } PCH1_CROP_START @ 0x6010;

    reg {
        name = "PCH1_CROP_SIZE";
        desc = "Data sheet 8.1.6 PCH1_CROP_SIZE (offset 0x6014, printed page 8-111, `hi3516v100--Hi3516-Datasheet.txt` line 41663).";

        field {
            name = "crop_height";
            desc = "Crop height. Chinese-only data sheet: description and value encoding not translated.";
            sw = rw;
            hw = r;
            reset = 0x0;
        } crop_height[28:16];

        field {
            name = "crop_width";
            desc = "Crop width. Chinese-only data sheet: description and value encoding not translated.";
            sw = rw;
            hw = r;
            reset = 0x0;
        } crop_width[12:0];
    } PCH1_CROP_SIZE @ 0x6014;

    reg {
        name = "PCH1_DES_SIZE";
        desc = "Data sheet 8.1.6 PCH1_DES_SIZE (offset 0x6018, printed page 8-112, `hi3516v100--Hi3516-Datasheet.txt` line 41702).";

        field {
            name = "des_height";
            desc = "Des height. Chinese-only data sheet: description and value encoding not translated.";
            sw = rw;
            hw = r;
            reset = 0x0;
        } des_height[28:16];

        field {
            name = "des_width";
            desc = "Des width. Chinese-only data sheet: description and value encoding not translated.";
            sw = rw;
            hw = r;
            reset = 0x0;
        } des_width[12:0];
    } PCH1_DES_SIZE @ 0x6018;

    reg {
        name = "PCH1_FSTART_DLY";
        desc = "Data sheet 8.1.6 PCH1_FSTART_DLY (offset 0x601C, printed page 8-112, `hi3516v100--Hi3516-Datasheet.txt` line 41732).";

        field {
            name = "fstart_dly";
            desc = "Fstart delay. Chinese-only data sheet: description and value encoding not translated.";
            sw = rw;
            hw = r;
            reset = 0x0;
        } fstart_dly[31:0];
    } PCH1_FSTART_DLY @ 0x601C;

    reg {
        name = "PCH1_YBASE_ADDR";
        desc = "Data sheet 8.1.6 PCH1_YBASE_ADDR (offset 0x6020, printed page 8-113, `hi3516v100--Hi3516-Datasheet.txt` line 41766).";

        field {
            name = "ybase_addr";
            desc = "Ybase address. Chinese-only data sheet: description and value encoding not translated.";
            sw = rw;
            hw = r;
            reset = 0x0;
        } ybase_addr[31:0];
    } PCH1_YBASE_ADDR @ 0x6020;

    reg {
        name = "PCH1_CBASE_ADDR";
        desc = "Data sheet 8.1.6 PCH1_CBASE_ADDR (offset 0x6024, printed page 8-113, `hi3516v100--Hi3516-Datasheet.txt` line 41785).";

        field {
            name = "cbase_addr";
            desc = "Cbase address. Chinese-only data sheet: description and value encoding not translated.";
            sw = rw;
            hw = r;
            reset = 0x0;
        } cbase_addr[31:0];
    } PCH1_CBASE_ADDR @ 0x6024;

    reg {
        name = "PCH1_Y_STRIDE";
        desc = "Data sheet 8.1.6 PCH1_Y_STRIDE (offset 0x6028, printed page 8-113, `hi3516v100--Hi3516-Datasheet.txt` line 41804).";

        field {
            name = "y_stride";
            desc = "Y stride. Chinese-only data sheet: description and value encoding not translated.";
            sw = rw;
            hw = r;
            reset = 0x0;
        } y_stride[15:0];
    } PCH1_Y_STRIDE @ 0x6028;

    reg {
        name = "PCH1_C_STRIDE";
        desc = "Data sheet 8.1.6 PCH1_C_STRIDE (offset 0x602C, printed page 8-114, `hi3516v100--Hi3516-Datasheet.txt` line 41835).";

        field {
            name = "c_stride";
            desc = "C stride. Chinese-only data sheet: description and value encoding not translated.";
            sw = rw;
            hw = r;
            reset = 0x0;
        } c_stride[15:0];
    } PCH1_C_STRIDE @ 0x602C;

    reg {
        name = "PCH1_HBASE_ADDR";
        desc = "Data sheet 8.1.6 PCH1_HBASE_ADDR (offset 0x6030, printed page 8-114, `hi3516v100--Hi3516-Datasheet.txt` line 41856).";

        field {
            name = "hbase_addr";
            desc = "Hbase address. Chinese-only data sheet: description and value encoding not translated.";
            sw = rw;
            hw = r;
            reset = 0x0;
        } hbase_addr[31:0];
    } PCH1_HBASE_ADDR @ 0x6030;

    reg {
        name = "PCH1_H_STRIDE";
        desc = "Data sheet 8.1.6 PCH1_H_STRIDE (offset 0x6034, printed page 8-115, `hi3516v100--Hi3516-Datasheet.txt` line 41890).";

        field {
            name = "h_stride";
            desc = "H stride. Chinese-only data sheet: description and value encoding not translated.";
            sw = rw;
            hw = r;
            reset = 0x0;
        } h_stride[15:0];
    } PCH1_H_STRIDE @ 0x6034;

    reg {
        name = "PCH1_HIST_SIZE";
        desc = "Data sheet 8.1.6 PCH1_HIST_SIZE (offset 0x6038, printed page 8-115, `hi3516v100--Hi3516-Datasheet.txt` line 41911).";

        field {
            name = "h_win_height";
            desc = "H win height. Chinese-only data sheet: description and value encoding not translated.";
            sw = rw;
            hw = r;
            reset = 0x0;
        } h_win_height[3:2];

        field {
            name = "h_win_width";
            desc = "H win width. Chinese-only data sheet: description and value encoding not translated.";
            sw = rw;
            hw = r;
            reset = 0x0;
        } h_win_width[1:0];
    } PCH1_HIST_SIZE @ 0x6038;

    reg {
        name = "PCH1_HIST_MODE";
        desc = "Data sheet 8.1.6 PCH1_HIST_MODE (offset 0x603C, printed page 8-116, `hi3516v100--Hi3516-Datasheet.txt` line 41953).";

        field {
            name = "hist_mode";
            desc = "Histogram mode. Chinese-only data sheet: description and value encoding not translated.";
            sw = rw;
            hw = r;
            reset = 0x0;
        } hist_mode[2:0];
    } PCH1_HIST_MODE @ 0x603C;

    reg {
        name = "PCH1_INT_EN";
        desc = "Data sheet 8.1.6 PCH1_INT_EN (offset 0x6040, printed page 8-116, `hi3516v100--Hi3516-Datasheet.txt` line 41986).";

        field {
            name = "frame_pulse_int_en";
            desc = "Frame pulse interrupt enable. Chinese-only data sheet: description and value encoding not translated.";
            sw = rw;
            hw = r;
            reset = 0x0;
        } frame_pulse_int_en[5:5];

        field {
            name = "reg_update_int_en";
            desc = "Reg update interrupt enable. Chinese-only data sheet: description and value encoding not translated.";
            sw = rw;
            hw = r;
            reset = 0x0;
        } reg_update_int_en[4:4];

        field {
            name = "err_int_en";
            desc = "Error interrupt enable. Chinese-only data sheet: description and value encoding not translated.";
            sw = rw;
            hw = r;
            reset = 0x0;
        } err_int_en[3:3];

        field {
            name = "field_throw_int_en";
            desc = "Field throw interrupt enable. Chinese-only data sheet: description and value encoding not translated.";
            sw = rw;
            hw = r;
            reset = 0x0;
        } field_throw_int_en[2:2];

        field {
            name = "buf_ovf_int_en";
            desc = "Buf overflow interrupt enable. Chinese-only data sheet: description and value encoding not translated.";
            sw = rw;
            hw = r;
            reset = 0x0;
        } buf_ovf_int_en[1:1];

        field {
            name = "cc_int_en";
            desc = "Cc interrupt enable. Chinese-only data sheet: description and value encoding not translated.";
            sw = rw;
            hw = r;
            reset = 0x0;
        } cc_int_en[0:0];
    } PCH1_INT_EN @ 0x6040;

    reg {
        name = "PCH1_INT_STATUS";
        desc = "Data sheet 8.1.6 PCH1_INT_STATUS (offset 0x6044, printed page 8-118, `hi3516v100--Hi3516-Datasheet.txt` line 42064).";

        field {
            name = "frame_pulse_int";
            desc = "Frame pulse interrupt. Chinese-only data sheet: description and value encoding not translated.";
            sw = rw;
            hw = w;
            onwrite = woclr;
            reset = 0x0;
        } frame_pulse_int[5:5];

        field {
            name = "reg_update_int";
            desc = "Reg update interrupt. Chinese-only data sheet: description and value encoding not translated.";
            sw = rw;
            hw = w;
            onwrite = woclr;
            reset = 0x0;
        } reg_update_int[4:4];

        field {
            name = "err_int";
            desc = "Error interrupt. Chinese-only data sheet: description and value encoding not translated.";
            sw = rw;
            hw = w;
            onwrite = woclr;
            reset = 0x0;
        } err_int[3:3];

        field {
            name = "field_throw_int";
            desc = "Field throw interrupt. Chinese-only data sheet: description and value encoding not translated.";
            sw = rw;
            hw = w;
            onwrite = woclr;
            reset = 0x0;
        } field_throw_int[2:2];

        field {
            name = "buf_ovf_int";
            desc = "Buf overflow interrupt. Chinese-only data sheet: description and value encoding not translated.";
            sw = rw;
            hw = w;
            onwrite = woclr;
            reset = 0x0;
        } buf_ovf_int[1:1];

        field {
            name = "cc_int";
            desc = "Cc interrupt. Chinese-only data sheet: description and value encoding not translated.";
            sw = rw;
            hw = w;
            onwrite = woclr;
            reset = 0x0;
        } cc_int[0:0];
    } PCH1_INT_STATUS @ 0x6044;

    reg {
        name = "PCH1_RAW_INT";
        desc = "Data sheet 8.1.6 PCH1_RAW_INT (offset 0x6048, printed page 8-119, `hi3516v100--Hi3516-Datasheet.txt` line 42125).";

        field {
            name = "frame_pulse_raw_int";
            desc = "Frame pulse raw interrupt. Chinese-only data sheet: description and value encoding not translated.";
            sw = r;
            hw = w;
            reset = 0x0;
        } frame_pulse_raw_int[5:5];

        field {
            name = "reg_update_raw_int";
            desc = "Reg update raw interrupt. Chinese-only data sheet: description and value encoding not translated.";
            sw = r;
            hw = w;
            reset = 0x0;
        } reg_update_raw_int[4:4];

        field {
            name = "err_raw_int";
            desc = "Error raw interrupt. Chinese-only data sheet: description and value encoding not translated.";
            sw = r;
            hw = w;
            reset = 0x0;
        } err_raw_int[3:3];

        field {
            name = "field_throw_raw_int";
            desc = "Field throw raw interrupt. Chinese-only data sheet: description and value encoding not translated.";
            sw = r;
            hw = w;
            reset = 0x0;
        } field_throw_raw_int[2:2];

        field {
            name = "buf_ovf_raw_int";
            desc = "Buf overflow raw interrupt. Chinese-only data sheet: description and value encoding not translated.";
            sw = r;
            hw = w;
            reset = 0x0;
        } buf_ovf_raw_int[1:1];

        field {
            name = "cc_raw_int";
            desc = "Cc raw interrupt. Chinese-only data sheet: description and value encoding not translated.";
            sw = r;
            hw = w;
            reset = 0x0;
        } cc_raw_int[0:0];
    } PCH1_RAW_INT @ 0x6048;

    reg {
        name = "PCH1_STATUS";
        desc = "Data sheet 8.1.6 PCH1_STATUS (offset 0x604C, printed page 8-120, `hi3516v100--Hi3516-Datasheet.txt` line 42189).";

        field {
            name = "act_height";
            desc = "Act height. Chinese-only data sheet: description and value encoding not translated.";
            sw = r;
            hw = w;
            reset = 0x0;
        } act_height[18:6];

        field {
            name = "ch_busy";
            desc = "Ch busy. Chinese-only data sheet: description and value encoding not translated.";
            sw = r;
            hw = w;
            reset = 0x0;
        } ch_busy[5:5];

        field {
            name = "field2";
            desc = "Field2. Chinese-only data sheet: description and value encoding not translated.";
            sw = r;
            hw = w;
            reset = 0x0;
        } field2[4:4];

        field {
            name = "bus_err";
            desc = "Bus error. Chinese-only data sheet: description and value encoding not translated.";
            sw = r;
            hw = w;
            reset = 0x0;
        } bus_err[3:3];

        field {
            name = "frame_loss";
            desc = "Frame loss. Chinese-only data sheet: description and value encoding not translated.";
            sw = r;
            hw = w;
            reset = 0x0;
        } frame_loss[2:2];

        field {
            name = "buf_ovf";
            desc = "Buf overflow. Chinese-only data sheet: description and value encoding not translated.";
            sw = r;
            hw = w;
            reset = 0x0;
        } buf_ovf[1:1];

        field {
            name = "image_done";
            desc = "Image done. Chinese-only data sheet: description and value encoding not translated.";
            sw = r;
            hw = w;
            reset = 0x0;
        } image_done[0:0];
    } PCH1_STATUS @ 0x604C;

    reg {
        name = "PCH1_HLFIR_PAR";
        desc = "Data sheet 8.1.6 PCH1_HLFIR_PAR (offset 0x6100, printed page 8-121, `hi3516v100--Hi3516-Datasheet.txt` line 42252).";

        field {
            name = "hlmsc_en";
            desc = "Hlmsc enable. Chinese-only data sheet: description and value encoding not translated.";
            sw = rw;
            hw = r;
            reset = 0x0;
        } hlmsc_en[31:31];

        field {
            name = "hlmid_en";
            desc = "Hlmid enable. Chinese-only data sheet: description and value encoding not translated.";
            sw = rw;
            hw = r;
            reset = 0x0;
        } hlmid_en[30:30];

        field {
            name = "hlfir_en";
            desc = "Hlfir enable. Chinese-only data sheet: description and value encoding not translated.";
            sw = rw;
            hw = r;
            reset = 0x0;
        } hlfir_en[29:29];

        field {
            name = "hlfir_clip_en";
            desc = "Hlfir clip enable. Chinese-only data sheet: description and value encoding not translated.";
            sw = rw;
            hw = r;
            reset = 0x0;
        } hlfir_clip_en[28:28];

        field {
            name = "hlratio";
            desc = "Hlratio. Chinese-only data sheet: description and value encoding not translated.";
            sw = rw;
            hw = r;
            reset = 0x0;
        } hlratio[15:0];
    } PCH1_HLFIR_PAR @ 0x6100;

    reg {
        name = "PCH1_HCFIR_PAR";
        desc = "Data sheet 8.1.6 PCH1_HCFIR_PAR (offset 0x6104, printed page 8-122, `hi3516v100--Hi3516-Datasheet.txt` line 42312).";

        field {
            name = "hchmsc_en";
            desc = "Hchmsc enable. Chinese-only data sheet: description and value encoding not translated.";
            sw = rw;
            hw = r;
            reset = 0x0;
        } hchmsc_en[31:31];

        field {
            name = "hchmid_en";
            desc = "Hchmid enable. Chinese-only data sheet: description and value encoding not translated.";
            sw = rw;
            hw = r;
            reset = 0x0;
        } hchmid_en[30:30];

        field {
            name = "hchfir_en";
            desc = "Hchfir enable. Chinese-only data sheet: description and value encoding not translated.";
            sw = rw;
            hw = r;
            reset = 0x0;
        } hchfir_en[29:29];

        field {
            name = "hchfir_clip_en";
            desc = "Hchfir clip enable. Chinese-only data sheet: description and value encoding not translated.";
            sw = rw;
            hw = r;
            reset = 0x0;
        } hchfir_clip_en[28:28];

        field {
            name = "hchratio";
            desc = "Hchratio. Chinese-only data sheet: description and value encoding not translated.";
            sw = rw;
            hw = r;
            reset = 0x0;
        } hchratio[15:0];
    } PCH1_HCFIR_PAR @ 0x6104;

    reg {
        name = "PCH1_HLFIR_OFFSET";
        desc = "Data sheet 8.1.6 PCH1_HLFIR_OFFSET (offset 0x6108, printed page 8-123, `hi3516v100--Hi3516-Datasheet.txt` line 42375).";

        field {
            name = "hluma_offset";
            desc = "Hluma offset. Chinese-only data sheet: description and value encoding not translated.";
            sw = rw;
            hw = r;
            reset = 0x0;
        } hluma_offset[16:0];
    } PCH1_HLFIR_OFFSET @ 0x6108;

    reg {
        name = "PCH1_HCFIR_OFFSET";
        desc = "Data sheet 8.1.6 PCH1_HCFIR_OFFSET (offset 0x610C, printed page 8-123, `hi3516v100--Hi3516-Datasheet.txt` line 42398).";

        field {
            name = "hchroma_offset";
            desc = "Hchroma offset. Chinese-only data sheet: description and value encoding not translated.";
            sw = rw;
            hw = r;
            reset = 0x0;
        } hchroma_offset[16:0];
    } PCH1_HCFIR_OFFSET @ 0x610C;

    reg {
        name = "PCH1_VLFIR_PAR";
        desc = "Data sheet 8.1.6 PCH1_VLFIR_PAR (offset 0x6110, printed page 8-124, `hi3516v100--Hi3516-Datasheet.txt` line 42433).";

        field {
            name = "vlmsc_en";
            desc = "Vlmsc enable. Chinese-only data sheet: description and value encoding not translated.";
            sw = rw;
            hw = r;
            reset = 0x0;
        } vlmsc_en[31:31];

        field {
            name = "vlmid_en";
            desc = "Vlmid enable. Chinese-only data sheet: description and value encoding not translated.";
            sw = rw;
            hw = r;
            reset = 0x0;
        } vlmid_en[30:30];

        field {
            name = "vlfir_en";
            desc = "Vlfir enable. Chinese-only data sheet: description and value encoding not translated.";
            sw = rw;
            hw = r;
            reset = 0x0;
        } vlfir_en[29:29];

        field {
            name = "vlfir_clip_en";
            desc = "Vlfir clip enable. Chinese-only data sheet: description and value encoding not translated.";
            sw = rw;
            hw = r;
            reset = 0x0;
        } vlfir_clip_en[28:28];

        field {
            name = "vlratio";
            desc = "Vlratio. Chinese-only data sheet: description and value encoding not translated.";
            sw = rw;
            hw = r;
            reset = 0x0;
        } vlratio[15:0];
    } PCH1_VLFIR_PAR @ 0x6110;

    reg {
        name = "PCH1_VCFIR_PAR";
        desc = "Data sheet 8.1.6 PCH1_VCFIR_PAR (offset 0x6114, printed page 8-125, `hi3516v100--Hi3516-Datasheet.txt` line 42499).";

        field {
            name = "vchmsc_en";
            desc = "Vchmsc enable. Chinese-only data sheet: description and value encoding not translated.";
            sw = rw;
            hw = r;
            reset = 0x0;
        } vchmsc_en[31:31];

        field {
            name = "vchmid_en";
            desc = "Vchmid enable. Chinese-only data sheet: description and value encoding not translated.";
            sw = rw;
            hw = r;
            reset = 0x0;
        } vchmid_en[30:30];

        field {
            name = "vchfir_en";
            desc = "Vchfir enable. Chinese-only data sheet: description and value encoding not translated.";
            sw = rw;
            hw = r;
            reset = 0x0;
        } vchfir_en[29:29];

        field {
            name = "vchfir_clip_en";
            desc = "Vchfir clip enable. Chinese-only data sheet: description and value encoding not translated.";
            sw = rw;
            hw = r;
            reset = 0x0;
        } vchfir_clip_en[28:28];

        field {
            name = "vchratio";
            desc = "Vchratio. Chinese-only data sheet: description and value encoding not translated.";
            sw = rw;
            hw = r;
            reset = 0x0;
        } vchratio[15:0];
    } PCH1_VCFIR_PAR @ 0x6114;

    reg {
        name = "PCH1_VLFIR_OFFSET";
        desc = "Data sheet 8.1.6 PCH1_VLFIR_OFFSET (offset 0x6118, printed page 8-126, `hi3516v100--Hi3516-Datasheet.txt` line 42560).";

        field {
            name = "vluma_offset";
            desc = "Vluma offset. Chinese-only data sheet: description and value encoding not translated.";
            sw = rw;
            hw = r;
            reset = 0x0;
        } vluma_offset[16:0];
    } PCH1_VLFIR_OFFSET @ 0x6118;

    reg {
        name = "PCH1_VCFIR_OFFSET";
        desc = "Data sheet 8.1.6 PCH1_VCFIR_OFFSET (offset 0x611C, printed page 8-126, `hi3516v100--Hi3516-Datasheet.txt` line 42583).";

        field {
            name = "vchroma_offset";
            desc = "Vchroma offset. Chinese-only data sheet: description and value encoding not translated.";
            sw = rw;
            hw = r;
            reset = 0x0;
        } vchroma_offset[16:0];
    } PCH1_VCFIR_OFFSET @ 0x611C;

    reg {
        name = "PCH1_COEF_UPDATE";
        desc = "Data sheet 8.1.6 PCH1_COEF_UPDATE (offset 0x6120, printed page 8-127, `hi3516v100--Hi3516-Datasheet.txt` line 42621).";

        field {
            name = "cvcoef_update";
            desc = "Cvcoef update. Chinese-only data sheet: description and value encoding not translated.";
            sw = rw;
            hw = r;
            reset = 0x0;
        } cvcoef_update[3:3];

        field {
            name = "lvcoef_update";
            desc = "Lvcoef update. Chinese-only data sheet: description and value encoding not translated.";
            sw = rw;
            hw = r;
            reset = 0x0;
        } lvcoef_update[2:2];

        field {
            name = "chcoef_update";
            desc = "Chcoef update. Chinese-only data sheet: description and value encoding not translated.";
            sw = rw;
            hw = r;
            reset = 0x0;
        } chcoef_update[1:1];

        field {
            name = "lhcoef_update";
            desc = "Lhcoef update. Chinese-only data sheet: description and value encoding not translated.";
            sw = rw;
            hw = r;
            reset = 0x0;
        } lhcoef_update[0:0];
    } PCH1_COEF_UPDATE @ 0x6120;

    reg {
        name = "PCH1_HBLANK_WIDTH";
        desc = "Data sheet 8.1.6 PCH1_HBLANK_WIDTH (offset 0x6124, printed page 8-128, `hi3516v100--Hi3516-Datasheet.txt` line 42675).";

        field {
            name = "hblank_width";
            desc = "Hblank width. Chinese-only data sheet: description and value encoding not translated.";
            sw = rw;
            hw = r;
            reset = 0x0;
        } hblank_width[15:0];
    } PCH1_HBLANK_WIDTH @ 0x6124;

    reg {
        name = "PCH1_COEF_RSEL";
        desc = "Data sheet 8.1.6 PCH1_COEF_RSEL (offset 0x6128, printed page 8-128, `hi3516v100--Hi3516-Datasheet.txt` line 42700).";

        field {
            name = "cvcoef_read_sel";
            desc = "Cvcoef read select. Chinese-only data sheet: description and value encoding not translated.";
            sw = rw;
            hw = r;
            reset = 0x0;
        } cvcoef_read_sel[3:3];

        field {
            name = "lvcoef_read_sel";
            desc = "Lvcoef read select. Chinese-only data sheet: description and value encoding not translated.";
            sw = rw;
            hw = r;
            reset = 0x0;
        } lvcoef_read_sel[2:2];

        field {
            name = "chcoef_read_sel";
            desc = "Chcoef read select. Chinese-only data sheet: description and value encoding not translated.";
            sw = rw;
            hw = r;
            reset = 0x0;
        } chcoef_read_sel[1:1];

        field {
            name = "lhcoef_read_sel";
            desc = "Lhcoef read select. Chinese-only data sheet: description and value encoding not translated.";
            sw = rw;
            hw = r;
            reset = 0x0;
        } lhcoef_read_sel[0:0];
    } PCH1_COEF_RSEL @ 0x6128;

    reg {
        name = "PCH2_CTRL";
        desc = "Data sheet 8.1.6 PCH2_CTRL (offset 0x7000, printed page 8-129, `hi3516v100--Hi3516-Datasheet.txt` line 42754).";

        field {
            name = "ch_en";
            desc = "Ch enable. Chinese-only data sheet: description and value encoding not translated.";
            sw = rw;
            hw = r;
            reset = 0x0;
        } ch_en[31:31];

        field {
            name = "hist_en";
            desc = "Histogram enable. Chinese-only data sheet: description and value encoding not translated.";
            sw = rw;
            hw = r;
            reset = 0x0;
        } hist_en[23:23];

        field {
            name = "flip_en";
            desc = "Flip enable. Chinese-only data sheet: description and value encoding not translated.";
            sw = rw;
            hw = r;
            reset = 0x0;
        } flip_en[22:22];

        field {
            name = "mir_en";
            desc = "Mir enable. Chinese-only data sheet: description and value encoding not translated.";
            sw = rw;
            hw = r;
            reset = 0x0;
        } mir_en[21:21];

        field {
            name = "store_method";
            desc = "Store method. Chinese-only data sheet: description and value encoding not translated.";
            sw = rw;
            hw = r;
            reset = 0x0;
        } store_method[1:0];
    } PCH2_CTRL @ 0x7000;

    reg {
        name = "PCH2_REG_NEWER";
        desc = "Data sheet 8.1.6 PCH2_REG_NEWER (offset 0x7004, printed page 8-130, `hi3516v100--Hi3516-Datasheet.txt` line 42816).";

        field {
            name = "reg_newer";
            desc = "Reg newer. Chinese-only data sheet: description and value encoding not translated.";
            sw = rw;
            hw = r;
            reset = 0x0;
        } reg_newer[0:0];
    } PCH2_REG_NEWER @ 0x7004;

    reg {
        name = "PCH2_LINK";
        desc = "Data sheet 8.1.6 PCH2_LINK (offset 0x7008, printed page 8-131, `hi3516v100--Hi3516-Datasheet.txt` line 42863).";

        field {
            name = "ch_link_sel";
            desc = "Ch link select. Chinese-only data sheet: description and value encoding not translated.";
            sw = rw;
            hw = r;
            reset = 0x0;
        } ch_link_sel[0:0];
    } PCH2_LINK @ 0x7008;

    reg {
        name = "PCH2_STORE";
        desc = "Data sheet 8.1.6 PCH2_STORE (offset 0x700C, printed page 8-131, `hi3516v100--Hi3516-Datasheet.txt` line 42893).";

        field {
            name = "scan_mode";
            desc = "Scan mode. Chinese-only data sheet: description and value encoding not translated.";
            sw = rw;
            hw = r;
            reset = 0x0;
        } scan_mode[1:1];

        field {
            name = "store_mode";
            desc = "Store mode. Chinese-only data sheet: description and value encoding not translated.";
            sw = rw;
            hw = r;
            reset = 0x0;
        } store_mode[0:0];
    } PCH2_STORE @ 0x700C;

    reg {
        name = "PCH2_CROP_START";
        desc = "Data sheet 8.1.6 PCH2_CROP_START (offset 0x7010, printed page 8-132, `hi3516v100--Hi3516-Datasheet.txt` line 42937).";

        field {
            name = "start_y";
            desc = "Start y. Chinese-only data sheet: description and value encoding not translated.";
            sw = rw;
            hw = r;
            reset = 0x0;
        } start_y[28:16];

        field {
            name = "start_x";
            desc = "Start x. Chinese-only data sheet: description and value encoding not translated.";
            sw = rw;
            hw = r;
            reset = 0x0;
        } start_x[12:0];
    } PCH2_CROP_START @ 0x7010;

    reg {
        name = "PCH2_CROP_SIZE";
        desc = "Data sheet 8.1.6 PCH2_CROP_SIZE (offset 0x7014, printed page 8-133, `hi3516v100--Hi3516-Datasheet.txt` line 42982).";

        field {
            name = "crop_height";
            desc = "Crop height. Chinese-only data sheet: description and value encoding not translated.";
            sw = rw;
            hw = r;
            reset = 0x0;
        } crop_height[28:16];

        field {
            name = "crop_width";
            desc = "Crop width. Chinese-only data sheet: description and value encoding not translated.";
            sw = rw;
            hw = r;
            reset = 0x0;
        } crop_width[12:0];
    } PCH2_CROP_SIZE @ 0x7014;

    reg {
        name = "PCH2_DES_SIZE";
        desc = "Data sheet 8.1.6 PCH2_DES_SIZE (offset 0x7018, printed page 8-133, `hi3516v100--Hi3516-Datasheet.txt` line 43012).";

        field {
            name = "des_height";
            desc = "Des height. Chinese-only data sheet: description and value encoding not translated.";
            sw = rw;
            hw = r;
            reset = 0x0;
        } des_height[28:16];

        field {
            name = "des_width";
            desc = "Des width. Chinese-only data sheet: description and value encoding not translated.";
            sw = rw;
            hw = r;
            reset = 0x0;
        } des_width[12:0];
    } PCH2_DES_SIZE @ 0x7018;

    reg {
        name = "PCH2_FSTART_DLY";
        desc = "Data sheet 8.1.6 PCH2_FSTART_DLY (offset 0x701C, printed page 8-134, `hi3516v100--Hi3516-Datasheet.txt` line 43051).";

        field {
            name = "fstart_dly";
            desc = "Fstart delay. Chinese-only data sheet: description and value encoding not translated.";
            sw = rw;
            hw = r;
            reset = 0x0;
        } fstart_dly[31:0];
    } PCH2_FSTART_DLY @ 0x701C;

    reg {
        name = "PCH2_YBASE_ADDR";
        desc = "Data sheet 8.1.6 PCH2_YBASE_ADDR (offset 0x7020, printed page 8-134, `hi3516v100--Hi3516-Datasheet.txt` line 43070).";

        field {
            name = "ybase_addr";
            desc = "Ybase address. Chinese-only data sheet: description and value encoding not translated.";
            sw = rw;
            hw = r;
            reset = 0x0;
        } ybase_addr[31:0];
    } PCH2_YBASE_ADDR @ 0x7020;

    reg {
        name = "PCH2_CBASE_ADDR";
        desc = "Data sheet 8.1.6 PCH2_CBASE_ADDR (offset 0x7024, printed page 8-134, `hi3516v100--Hi3516-Datasheet.txt` line 43089).";

        field {
            name = "cbase_addr";
            desc = "Cbase address. Chinese-only data sheet: description and value encoding not translated.";
            sw = rw;
            hw = r;
            reset = 0x0;
        } cbase_addr[31:0];
    } PCH2_CBASE_ADDR @ 0x7024;

    reg {
        name = "PCH2_Y_STRIDE";
        desc = "Data sheet 8.1.6 PCH2_Y_STRIDE (offset 0x7028, printed page 8-135, `hi3516v100--Hi3516-Datasheet.txt` line 43119).";

        field {
            name = "y_stride";
            desc = "Y stride. Chinese-only data sheet: description and value encoding not translated.";
            sw = rw;
            hw = r;
            reset = 0x0;
        } y_stride[15:0];
    } PCH2_Y_STRIDE @ 0x7028;

    reg {
        name = "PCH2_C_STRIDE";
        desc = "Data sheet 8.1.6 PCH2_C_STRIDE (offset 0x702C, printed page 8-135, `hi3516v100--Hi3516-Datasheet.txt` line 43140).";

        field {
            name = "c_stride";
            desc = "C stride. Chinese-only data sheet: description and value encoding not translated.";
            sw = rw;
            hw = r;
            reset = 0x0;
        } c_stride[15:0];
    } PCH2_C_STRIDE @ 0x702C;

    reg {
        name = "PCH2_HBASE_ADDR";
        desc = "Data sheet 8.1.6 PCH2_HBASE_ADDR (offset 0x7030, printed page 8-136, `hi3516v100--Hi3516-Datasheet.txt` line 43173).";

        field {
            name = "hbase_addr";
            desc = "Hbase address. Chinese-only data sheet: description and value encoding not translated.";
            sw = rw;
            hw = r;
            reset = 0x0;
        } hbase_addr[31:0];
    } PCH2_HBASE_ADDR @ 0x7030;

    reg {
        name = "PCH2_H_STRIDE";
        desc = "Data sheet 8.1.6 PCH2_H_STRIDE (offset 0x7034, printed page 8-136, `hi3516v100--Hi3516-Datasheet.txt` line 43192).";

        field {
            name = "h_stride";
            desc = "H stride. Chinese-only data sheet: description and value encoding not translated.";
            sw = rw;
            hw = r;
            reset = 0x0;
        } h_stride[15:0];
    } PCH2_H_STRIDE @ 0x7034;

    reg {
        name = "PCH2_HIST_SIZE";
        desc = "Data sheet 8.1.6 PCH2_HIST_SIZE (offset 0x7038, printed page 8-137, `hi3516v100--Hi3516-Datasheet.txt` line 43228).";

        field {
            name = "h_win_height";
            desc = "H win height. Chinese-only data sheet: description and value encoding not translated.";
            sw = rw;
            hw = r;
            reset = 0x0;
        } h_win_height[3:2];

        field {
            name = "h_win_width";
            desc = "H win width. Chinese-only data sheet: description and value encoding not translated.";
            sw = rw;
            hw = r;
            reset = 0x0;
        } h_win_width[1:0];
    } PCH2_HIST_SIZE @ 0x7038;

    reg {
        name = "PCH2_HIST_MODE";
        desc = "Data sheet 8.1.6 PCH2_HIST_MODE (offset 0x703C, printed page 8-137, `hi3516v100--Hi3516-Datasheet.txt` line 43258).";

        field {
            name = "hist_mode";
            desc = "Histogram mode. Chinese-only data sheet: description and value encoding not translated.";
            sw = rw;
            hw = r;
            reset = 0x0;
        } hist_mode[2:0];
    } PCH2_HIST_MODE @ 0x703C;

    reg {
        name = "PCH2_INT_EN";
        desc = "Data sheet 8.1.6 PCH2_INT_EN (offset 0x7040, printed page 8-138, `hi3516v100--Hi3516-Datasheet.txt` line 43303).";

        field {
            name = "frame_pulse_int_en";
            desc = "Frame pulse interrupt enable. Chinese-only data sheet: description and value encoding not translated.";
            sw = rw;
            hw = r;
            reset = 0x0;
        } frame_pulse_int_en[5:5];

        field {
            name = "reg_update_int_en";
            desc = "Reg update interrupt enable. Chinese-only data sheet: description and value encoding not translated.";
            sw = rw;
            hw = r;
            reset = 0x0;
        } reg_update_int_en[4:4];

        field {
            name = "err_int_en";
            desc = "Error interrupt enable. Chinese-only data sheet: description and value encoding not translated.";
            sw = rw;
            hw = r;
            reset = 0x0;
        } err_int_en[3:3];

        field {
            name = "field_throw_int_en";
            desc = "Field throw interrupt enable. Chinese-only data sheet: description and value encoding not translated.";
            sw = rw;
            hw = r;
            reset = 0x0;
        } field_throw_int_en[2:2];

        field {
            name = "buf_ovf_int_en";
            desc = "Buf overflow interrupt enable. Chinese-only data sheet: description and value encoding not translated.";
            sw = rw;
            hw = r;
            reset = 0x0;
        } buf_ovf_int_en[1:1];

        field {
            name = "cc_int_en";
            desc = "Cc interrupt enable. Chinese-only data sheet: description and value encoding not translated.";
            sw = rw;
            hw = r;
            reset = 0x0;
        } cc_int_en[0:0];
    } PCH2_INT_EN @ 0x7040;

    reg {
        name = "PCH2_INT_STATUS";
        desc = "Data sheet 8.1.6 PCH2_INT_STATUS (offset 0x7044, printed page 8-139, `hi3516v100--Hi3516-Datasheet.txt` line 43369).";

        field {
            name = "frame_pulse_int";
            desc = "Frame pulse interrupt. Chinese-only data sheet: description and value encoding not translated.";
            sw = rw;
            hw = w;
            onwrite = woclr;
            reset = 0x0;
        } frame_pulse_int[5:5];

        field {
            name = "reg_update_int";
            desc = "Reg update interrupt. Chinese-only data sheet: description and value encoding not translated.";
            sw = rw;
            hw = w;
            onwrite = woclr;
            reset = 0x0;
        } reg_update_int[4:4];

        field {
            name = "err_int";
            desc = "Error interrupt. Chinese-only data sheet: description and value encoding not translated.";
            sw = rw;
            hw = w;
            onwrite = woclr;
            reset = 0x0;
        } err_int[3:3];

        field {
            name = "field_throw_int";
            desc = "Field throw interrupt. Chinese-only data sheet: description and value encoding not translated.";
            sw = rw;
            hw = w;
            onwrite = woclr;
            reset = 0x0;
        } field_throw_int[2:2];

        field {
            name = "buf_ovf_int";
            desc = "Buf overflow interrupt. Chinese-only data sheet: description and value encoding not translated.";
            sw = rw;
            hw = w;
            onwrite = woclr;
            reset = 0x0;
        } buf_ovf_int[1:1];

        field {
            name = "cc_int";
            desc = "Cc interrupt. Chinese-only data sheet: description and value encoding not translated.";
            sw = rw;
            hw = w;
            onwrite = woclr;
            reset = 0x0;
        } cc_int[0:0];
    } PCH2_INT_STATUS @ 0x7044;

    reg {
        name = "PCH2_RAW_INT";
        desc = "Data sheet 8.1.6 PCH2_RAW_INT (offset 0x7048, printed page 8-140, `hi3516v100--Hi3516-Datasheet.txt` line 43431).";

        field {
            name = "frame_pulse_raw_int";
            desc = "Frame pulse raw interrupt. Chinese-only data sheet: description and value encoding not translated.";
            sw = r;
            hw = w;
            reset = 0x0;
        } frame_pulse_raw_int[5:5];

        field {
            name = "reg_update_raw_int";
            desc = "Reg update raw interrupt. Chinese-only data sheet: description and value encoding not translated.";
            sw = r;
            hw = w;
            reset = 0x0;
        } reg_update_raw_int[4:4];

        field {
            name = "err_raw_int";
            desc = "Error raw interrupt. Chinese-only data sheet: description and value encoding not translated.";
            sw = r;
            hw = w;
            reset = 0x0;
        } err_raw_int[3:3];

        field {
            name = "field_throw_raw_int";
            desc = "Field throw raw interrupt. Chinese-only data sheet: description and value encoding not translated.";
            sw = r;
            hw = w;
            reset = 0x0;
        } field_throw_raw_int[2:2];

        field {
            name = "buf_ovf_raw_int";
            desc = "Buf overflow raw interrupt. Chinese-only data sheet: description and value encoding not translated.";
            sw = r;
            hw = w;
            reset = 0x0;
        } buf_ovf_raw_int[1:1];

        field {
            name = "cc_raw_int";
            desc = "Cc raw interrupt. Chinese-only data sheet: description and value encoding not translated.";
            sw = r;
            hw = w;
            reset = 0x0;
        } cc_raw_int[0:0];
    } PCH2_RAW_INT @ 0x7048;

    reg {
        name = "PCH2_STATUS";
        desc = "Data sheet 8.1.6 PCH2_STATUS (offset 0x704C, printed page 8-141, `hi3516v100--Hi3516-Datasheet.txt` line 43501).";

        field {
            name = "act_height";
            desc = "Act height. Chinese-only data sheet: description and value encoding not translated.";
            sw = r;
            hw = w;
            reset = 0x0;
        } act_height[18:6];

        field {
            name = "ch_busy";
            desc = "Ch busy. Chinese-only data sheet: description and value encoding not translated.";
            sw = r;
            hw = w;
            reset = 0x0;
        } ch_busy[5:5];

        field {
            name = "field2";
            desc = "Field2. Chinese-only data sheet: description and value encoding not translated.";
            sw = r;
            hw = w;
            reset = 0x0;
        } field2[4:4];

        field {
            name = "bus_err";
            desc = "Bus error. Chinese-only data sheet: description and value encoding not translated.";
            sw = r;
            hw = w;
            reset = 0x0;
        } bus_err[3:3];

        field {
            name = "frame_loss";
            desc = "Frame loss. Chinese-only data sheet: description and value encoding not translated.";
            sw = r;
            hw = w;
            reset = 0x0;
        } frame_loss[2:2];

        field {
            name = "buf_ovf";
            desc = "Buf overflow. Chinese-only data sheet: description and value encoding not translated.";
            sw = r;
            hw = w;
            reset = 0x0;
        } buf_ovf[1:1];

        field {
            name = "image_done";
            desc = "Image done. Chinese-only data sheet: description and value encoding not translated.";
            sw = r;
            hw = w;
            reset = 0x0;
        } image_done[0:0];
    } PCH2_STATUS @ 0x704C;

    reg {
        name = "PCH2_HLFIR_PRE";
        desc = "Data sheet 8.1.6 PCH2_HLFIR_PRE (offset 0x7060, printed page 8-143, `hi3516v100--Hi3516-Datasheet.txt` line 43579).";

        field {
            name = "hlfir_pre_coef1";
            desc = "Hlfir pre coef1. Chinese-only data sheet: description and value encoding not translated.";
            sw = rw;
            hw = r;
            reset = 0x0;
        } hlfir_pre_coef1[12:8];

        field {
            name = "hlfir_pre_coef0";
            desc = "Hlfir pre coef0. Chinese-only data sheet: description and value encoding not translated.";
            sw = rw;
            hw = r;
            reset = 0x0;
        } hlfir_pre_coef0[6:2];

        field {
            name = "hlfir_pre_mode";
            desc = "Hlfir pre mode. Chinese-only data sheet: description and value encoding not translated.";
            sw = rw;
            hw = r;
            reset = 0x0;
        } hlfir_pre_mode[0:0];
    } PCH2_HLFIR_PRE @ 0x7060;

    reg {
        name = "PCH2_HCFIR_PRE";
        desc = "Data sheet 8.1.6 PCH2_HCFIR_PRE (offset 0x7064, printed page 8-144, `hi3516v100--Hi3516-Datasheet.txt` line 43632).";

        field {
            name = "hchfir_pre_coef1";
            desc = "Hchfir pre coef1. Chinese-only data sheet: description and value encoding not translated.";
            sw = rw;
            hw = r;
            reset = 0x0;
        } hchfir_pre_coef1[12:8];

        field {
            name = "hchfir_pre_coef0";
            desc = "Hchfir pre coef0. Chinese-only data sheet: description and value encoding not translated.";
            sw = rw;
            hw = r;
            reset = 0x0;
        } hchfir_pre_coef0[6:2];

        field {
            name = "hchfir_pre_mode";
            desc = "Hchfir pre mode. Chinese-only data sheet: description and value encoding not translated.";
            sw = rw;
            hw = r;
            reset = 0x0;
        } hchfir_pre_mode[0:0];
    } PCH2_HCFIR_PRE @ 0x7064;

    reg {
        name = "PCH2_VLFIR_PRE";
        desc = "Data sheet 8.1.6 PCH2_VLFIR_PRE (offset 0x7068, printed page 8-145, `hi3516v100--Hi3516-Datasheet.txt` line 43688).";

        field {
            name = "vlfir_pre_coef1";
            desc = "Vlfir pre coef1. Chinese-only data sheet: description and value encoding not translated.";
            sw = rw;
            hw = r;
            reset = 0x0;
        } vlfir_pre_coef1[12:8];

        field {
            name = "vlfir_pre_coef0";
            desc = "Vlfir pre coef0. Chinese-only data sheet: description and value encoding not translated.";
            sw = rw;
            hw = r;
            reset = 0x0;
        } vlfir_pre_coef0[6:2];

        field {
            name = "vlfir_pre_mode";
            desc = "Vlfir pre mode. Chinese-only data sheet: description and value encoding not translated.";
            sw = rw;
            hw = r;
            reset = 0x0;
        } vlfir_pre_mode[0:0];
    } PCH2_VLFIR_PRE @ 0x7068;

    reg {
        name = "PCH2_VCFIR_PRE";
        desc = "Data sheet 8.1.6 PCH2_VCFIR_PRE (offset 0x706C, printed page 8-146, `hi3516v100--Hi3516-Datasheet.txt` line 43741).";

        field {
            name = "vchfir_pre_coef3";
            desc = "Vchfir pre coef3. Chinese-only data sheet: description and value encoding not translated.";
            sw = rw;
            hw = r;
            reset = 0x0;
        } vchfir_pre_coef3[24:20];

        field {
            name = "vchfir_pre_coef2";
            desc = "Vchfir pre coef2. Chinese-only data sheet: description and value encoding not translated.";
            sw = rw;
            hw = r;
            reset = 0x0;
        } vchfir_pre_coef2[18:14];

        field {
            name = "vchfir_pre_coef1";
            desc = "Vchfir pre coef1. Chinese-only data sheet: description and value encoding not translated.";
            sw = rw;
            hw = r;
            reset = 0x0;
        } vchfir_pre_coef1[12:8];

        field {
            name = "vchfir_pre_coef0";
            desc = "Vchfir pre coef0. Chinese-only data sheet: description and value encoding not translated.";
            sw = rw;
            hw = r;
            reset = 0x0;
        } vchfir_pre_coef0[6:2];

        field {
            name = "vchfir_pre_mode";
            desc = "Vchfir pre mode. Chinese-only data sheet: description and value encoding not translated.";
            sw = rw;
            hw = r;
            reset = 0x0;
        } vchfir_pre_mode[1:0];
    } PCH2_VCFIR_PRE @ 0x706C;

    reg {
        name = "PCH2_HLFIR_PAR";
        desc = "Data sheet 8.1.6 PCH2_HLFIR_PAR (offset 0x7100, printed page 8-147, `hi3516v100--Hi3516-Datasheet.txt` line 43807).";

        field {
            name = "hlmsc_en";
            desc = "Hlmsc enable. Chinese-only data sheet: description and value encoding not translated.";
            sw = rw;
            hw = r;
            reset = 0x0;
        } hlmsc_en[31:31];

        field {
            name = "hlmid_en";
            desc = "Hlmid enable. Chinese-only data sheet: description and value encoding not translated.";
            sw = rw;
            hw = r;
            reset = 0x0;
        } hlmid_en[30:30];

        field {
            name = "hlfir_en";
            desc = "Hlfir enable. Chinese-only data sheet: description and value encoding not translated.";
            sw = rw;
            hw = r;
            reset = 0x0;
        } hlfir_en[29:29];

        field {
            name = "hlfir_clip_en";
            desc = "Hlfir clip enable. Chinese-only data sheet: description and value encoding not translated.";
            sw = rw;
            hw = r;
            reset = 0x0;
        } hlfir_clip_en[28:28];

        field {
            name = "hlratio";
            desc = "Hlratio. Chinese-only data sheet: description and value encoding not translated.";
            sw = rw;
            hw = r;
            reset = 0x0;
        } hlratio[15:0];
    } PCH2_HLFIR_PAR @ 0x7100;

    reg {
        name = "PCH2_HCFIR_PAR";
        desc = "Data sheet 8.1.6 PCH2_HCFIR_PAR (offset 0x7104, printed page 8-148, `hi3516v100--Hi3516-Datasheet.txt` line 43867).";

        field {
            name = "hchmsc_en";
            desc = "Hchmsc enable. Chinese-only data sheet: description and value encoding not translated.";
            sw = rw;
            hw = r;
            reset = 0x0;
        } hchmsc_en[31:31];

        field {
            name = "hchmid_en";
            desc = "Hchmid enable. Chinese-only data sheet: description and value encoding not translated.";
            sw = rw;
            hw = r;
            reset = 0x0;
        } hchmid_en[30:30];

        field {
            name = "hchfir_en";
            desc = "Hchfir enable. Chinese-only data sheet: description and value encoding not translated.";
            sw = rw;
            hw = r;
            reset = 0x0;
        } hchfir_en[29:29];

        field {
            name = "hchfir_clip_en";
            desc = "Hchfir clip enable. Chinese-only data sheet: description and value encoding not translated.";
            sw = rw;
            hw = r;
            reset = 0x0;
        } hchfir_clip_en[28:28];

        field {
            name = "hchratio";
            desc = "Hchratio. Chinese-only data sheet: description and value encoding not translated.";
            sw = rw;
            hw = r;
            reset = 0x0;
        } hchratio[15:0];
    } PCH2_HCFIR_PAR @ 0x7104;

    reg {
        name = "PCH2_HLFIR_OFFSET";
        desc = "Data sheet 8.1.6 PCH2_HLFIR_OFFSET (offset 0x7108, printed page 8-149, `hi3516v100--Hi3516-Datasheet.txt` line 43932).";

        field {
            name = "hluma_offset";
            desc = "Hluma offset. Chinese-only data sheet: description and value encoding not translated.";
            sw = rw;
            hw = r;
            reset = 0x0;
        } hluma_offset[16:0];
    } PCH2_HLFIR_OFFSET @ 0x7108;

    reg {
        name = "PCH2_HCFIR_OFFSET";
        desc = "Data sheet 8.1.6 PCH2_HCFIR_OFFSET (offset 0x710C, printed page 8-149, `hi3516v100--Hi3516-Datasheet.txt` line 43955).";

        field {
            name = "hchroma_offset";
            desc = "Hchroma offset. Chinese-only data sheet: description and value encoding not translated.";
            sw = rw;
            hw = r;
            reset = 0x0;
        } hchroma_offset[16:0];
    } PCH2_HCFIR_OFFSET @ 0x710C;

    reg {
        name = "PCH2_VLFIR_PAR";
        desc = "Data sheet 8.1.6 PCH2_VLFIR_PAR (offset 0x7110, printed page 8-150, `hi3516v100--Hi3516-Datasheet.txt` line 43990).";

        field {
            name = "vlmsc_en";
            desc = "Vlmsc enable. Chinese-only data sheet: description and value encoding not translated.";
            sw = rw;
            hw = r;
            reset = 0x0;
        } vlmsc_en[31:31];

        field {
            name = "vlmid_en";
            desc = "Vlmid enable. Chinese-only data sheet: description and value encoding not translated.";
            sw = rw;
            hw = r;
            reset = 0x0;
        } vlmid_en[30:30];

        field {
            name = "vlfir_en";
            desc = "Vlfir enable. Chinese-only data sheet: description and value encoding not translated.";
            sw = rw;
            hw = r;
            reset = 0x0;
        } vlfir_en[29:29];

        field {
            name = "vlfir_clip_en";
            desc = "Vlfir clip enable. Chinese-only data sheet: description and value encoding not translated.";
            sw = rw;
            hw = r;
            reset = 0x0;
        } vlfir_clip_en[28:28];

        field {
            name = "vlratio";
            desc = "Vlratio. Chinese-only data sheet: description and value encoding not translated.";
            sw = rw;
            hw = r;
            reset = 0x0;
        } vlratio[15:0];
    } PCH2_VLFIR_PAR @ 0x7110;

    reg {
        name = "PCH2_VCFIR_PAR";
        desc = "Data sheet 8.1.6 PCH2_VCFIR_PAR (offset 0x7114, printed page 8-151, `hi3516v100--Hi3516-Datasheet.txt` line 44055).";

        field {
            name = "vchmsc_en";
            desc = "Vchmsc enable. Chinese-only data sheet: description and value encoding not translated.";
            sw = rw;
            hw = r;
            reset = 0x0;
        } vchmsc_en[31:31];

        field {
            name = "vchmid_en";
            desc = "Vchmid enable. Chinese-only data sheet: description and value encoding not translated.";
            sw = rw;
            hw = r;
            reset = 0x0;
        } vchmid_en[30:30];

        field {
            name = "vchfir_en";
            desc = "Vchfir enable. Chinese-only data sheet: description and value encoding not translated.";
            sw = rw;
            hw = r;
            reset = 0x0;
        } vchfir_en[29:29];

        field {
            name = "vchfir_clip_en";
            desc = "Vchfir clip enable. Chinese-only data sheet: description and value encoding not translated.";
            sw = rw;
            hw = r;
            reset = 0x0;
        } vchfir_clip_en[28:28];

        field {
            name = "vchratio";
            desc = "Vchratio. Chinese-only data sheet: description and value encoding not translated.";
            sw = rw;
            hw = r;
            reset = 0x0;
        } vchratio[15:0];
    } PCH2_VCFIR_PAR @ 0x7114;

    reg {
        name = "PCH2_VLFIR_OFFSET";
        desc = "Data sheet 8.1.6 PCH2_VLFIR_OFFSET (offset 0x7118, printed page 8-152, `hi3516v100--Hi3516-Datasheet.txt` line 44114).";

        field {
            name = "vluma_offset";
            desc = "Vluma offset. Chinese-only data sheet: description and value encoding not translated.";
            sw = rw;
            hw = r;
            reset = 0x0;
        } vluma_offset[16:0];
    } PCH2_VLFIR_OFFSET @ 0x7118;

    reg {
        name = "PCH2_VCFIR_OFFSET";
        desc = "Data sheet 8.1.6 PCH2_VCFIR_OFFSET (offset 0x711C, printed page 8-152, `hi3516v100--Hi3516-Datasheet.txt` line 44137).";

        field {
            name = "vchroma_offset";
            desc = "Vchroma offset. Chinese-only data sheet: description and value encoding not translated.";
            sw = rw;
            hw = r;
            reset = 0x0;
        } vchroma_offset[16:0];
    } PCH2_VCFIR_OFFSET @ 0x711C;

    reg {
        name = "PCH2_COEF_UPDATE";
        desc = "Data sheet 8.1.6 PCH2_COEF_UPDATE (offset 0x7120, printed page 8-153, `hi3516v100--Hi3516-Datasheet.txt` line 44175).";

        field {
            name = "cvcoef_update";
            desc = "Cvcoef update. Chinese-only data sheet: description and value encoding not translated.";
            sw = rw;
            hw = r;
            reset = 0x0;
        } cvcoef_update[3:3];

        field {
            name = "lvcoef_update";
            desc = "Lvcoef update. Chinese-only data sheet: description and value encoding not translated.";
            sw = rw;
            hw = r;
            reset = 0x0;
        } lvcoef_update[2:2];

        field {
            name = "chcoef_update";
            desc = "Chcoef update. Chinese-only data sheet: description and value encoding not translated.";
            sw = rw;
            hw = r;
            reset = 0x0;
        } chcoef_update[1:1];

        field {
            name = "lhcoef_update";
            desc = "Lhcoef update. Chinese-only data sheet: description and value encoding not translated.";
            sw = rw;
            hw = r;
            reset = 0x0;
        } lhcoef_update[0:0];
    } PCH2_COEF_UPDATE @ 0x7120;

    reg {
        name = "PCH2_HBLANK_WIDTH";
        desc = "Data sheet 8.1.6 PCH2_HBLANK_WIDTH (offset 0x7124, printed page 8-154, `hi3516v100--Hi3516-Datasheet.txt` line 44229).";

        field {
            name = "hblank_width";
            desc = "Hblank width. Chinese-only data sheet: description and value encoding not translated.";
            sw = rw;
            hw = r;
            reset = 0x0;
        } hblank_width[15:0];
    } PCH2_HBLANK_WIDTH @ 0x7124;

    reg {
        name = "PCH2_COEF_RSEL";
        desc = "Data sheet 8.1.6 PCH2_COEF_RSEL (offset 0x7128, printed page 8-154, `hi3516v100--Hi3516-Datasheet.txt` line 44254).";

        field {
            name = "cvcoef_read_sel";
            desc = "Cvcoef read select. Chinese-only data sheet: description and value encoding not translated.";
            sw = rw;
            hw = r;
            reset = 0x0;
        } cvcoef_read_sel[3:3];

        field {
            name = "lvcoef_read_sel";
            desc = "Lvcoef read select. Chinese-only data sheet: description and value encoding not translated.";
            sw = rw;
            hw = r;
            reset = 0x0;
        } lvcoef_read_sel[2:2];

        field {
            name = "chcoef_read_sel";
            desc = "Chcoef read select. Chinese-only data sheet: description and value encoding not translated.";
            sw = rw;
            hw = r;
            reset = 0x0;
        } chcoef_read_sel[1:1];

        field {
            name = "lhcoef_read_sel";
            desc = "Lhcoef read select. Chinese-only data sheet: description and value encoding not translated.";
            sw = rw;
            hw = r;
            reset = 0x0;
        } lhcoef_read_sel[0:0];
    } PCH2_COEF_RSEL @ 0x7128;

    reg {
        name = "PCH3_CTRL";
        desc = "Data sheet 8.1.6 PCH3_CTRL (offset 0x8000, printed page 8-155, `hi3516v100--Hi3516-Datasheet.txt` line 44308).";

        field {
            name = "ch_en";
            desc = "Ch enable. Chinese-only data sheet: description and value encoding not translated.";
            sw = rw;
            hw = r;
            reset = 0x0;
        } ch_en[31:31];

        field {
            name = "hist_en";
            desc = "Histogram enable. Chinese-only data sheet: description and value encoding not translated.";
            sw = rw;
            hw = r;
            reset = 0x0;
        } hist_en[23:23];

        field {
            name = "flip_en";
            desc = "Flip enable. Chinese-only data sheet: description and value encoding not translated.";
            sw = rw;
            hw = r;
            reset = 0x0;
        } flip_en[22:22];

        field {
            name = "mir_en";
            desc = "Mir enable. Chinese-only data sheet: description and value encoding not translated.";
            sw = rw;
            hw = r;
            reset = 0x0;
        } mir_en[21:21];

        field {
            name = "store_method";
            desc = "Store method. Chinese-only data sheet: description and value encoding not translated.";
            sw = rw;
            hw = r;
            reset = 0x0;
        } store_method[1:0];
    } PCH3_CTRL @ 0x8000;

    reg {
        name = "PCH3_REG_NEWER";
        desc = "Data sheet 8.1.6 PCH3_REG_NEWER (offset 0x8004, printed page 8-156, `hi3516v100--Hi3516-Datasheet.txt` line 44370).";

        field {
            name = "reg_newer";
            desc = "Reg newer. Chinese-only data sheet: description and value encoding not translated.";
            sw = rw;
            hw = r;
            reset = 0x0;
        } reg_newer[0:0];
    } PCH3_REG_NEWER @ 0x8004;

    reg {
        name = "PCH3_LINK";
        desc = "Data sheet 8.1.6 PCH3_LINK (offset 0x8008, printed page 8-157, `hi3516v100--Hi3516-Datasheet.txt` line 44417).";

        field {
            name = "ch_link_sel";
            desc = "Ch link select. Chinese-only data sheet: description and value encoding not translated.";
            sw = rw;
            hw = r;
            reset = 0x0;
        } ch_link_sel[0:0];
    } PCH3_LINK @ 0x8008;

    reg {
        name = "PCH3_STORE";
        desc = "Data sheet 8.1.6 PCH3_STORE (offset 0x800C, printed page 8-157, `hi3516v100--Hi3516-Datasheet.txt` line 44447).";

        field {
            name = "scan_mode";
            desc = "Scan mode. Chinese-only data sheet: description and value encoding not translated.";
            sw = rw;
            hw = r;
            reset = 0x0;
        } scan_mode[1:1];

        field {
            name = "store_mode";
            desc = "Store mode. Chinese-only data sheet: description and value encoding not translated.";
            sw = rw;
            hw = r;
            reset = 0x0;
        } store_mode[0:0];
    } PCH3_STORE @ 0x800C;

    reg {
        name = "PCH3_CROP_START";
        desc = "Data sheet 8.1.6 PCH3_CROP_START (offset 0x8010, printed page 8-158, `hi3516v100--Hi3516-Datasheet.txt` line 44491).";

        field {
            name = "start_y";
            desc = "Start y. Chinese-only data sheet: description and value encoding not translated.";
            sw = rw;
            hw = r;
            reset = 0x0;
        } start_y[28:16];

        field {
            name = "start_x";
            desc = "Start x. Chinese-only data sheet: description and value encoding not translated.";
            sw = rw;
            hw = r;
            reset = 0x0;
        } start_x[12:0];
    } PCH3_CROP_START @ 0x8010;

    reg {
        name = "PCH3_CROP_SIZE";
        desc = "Data sheet 8.1.6 PCH3_CROP_SIZE (offset 0x8014, printed page 8-159, `hi3516v100--Hi3516-Datasheet.txt` line 44536).";

        field {
            name = "crop_height";
            desc = "Crop height. Chinese-only data sheet: description and value encoding not translated.";
            sw = rw;
            hw = r;
            reset = 0x0;
        } crop_height[28:16];

        field {
            name = "crop_width";
            desc = "Crop width. Chinese-only data sheet: description and value encoding not translated.";
            sw = rw;
            hw = r;
            reset = 0x0;
        } crop_width[12:0];
    } PCH3_CROP_SIZE @ 0x8014;

    reg {
        name = "PCH3_DES_SIZE";
        desc = "Data sheet 8.1.6 PCH3_DES_SIZE (offset 0x8018, printed page 8-159, `hi3516v100--Hi3516-Datasheet.txt` line 44566).";

        field {
            name = "des_height";
            desc = "Des height. Chinese-only data sheet: description and value encoding not translated.";
            sw = rw;
            hw = r;
            reset = 0x0;
        } des_height[28:16];

        field {
            name = "des_width";
            desc = "Des width. Chinese-only data sheet: description and value encoding not translated.";
            sw = rw;
            hw = r;
            reset = 0x0;
        } des_width[12:0];
    } PCH3_DES_SIZE @ 0x8018;

    reg {
        name = "PCH3_FSTART_DLY";
        desc = "Data sheet 8.1.6 PCH3_FSTART_DLY (offset 0x801C, printed page 8-160, `hi3516v100--Hi3516-Datasheet.txt` line 44605).";

        field {
            name = "fstart_dly";
            desc = "Fstart delay. Chinese-only data sheet: description and value encoding not translated.";
            sw = rw;
            hw = r;
            reset = 0x0;
        } fstart_dly[31:0];
    } PCH3_FSTART_DLY @ 0x801C;

    reg {
        name = "PCH3_YBASE_ADDR";
        desc = "Data sheet 8.1.6 PCH3_YBASE_ADDR (offset 0x8020, printed page 8-160, `hi3516v100--Hi3516-Datasheet.txt` line 44624).";

        field {
            name = "ybase_addr";
            desc = "Ybase address. Chinese-only data sheet: description and value encoding not translated.";
            sw = rw;
            hw = r;
            reset = 0x0;
        } ybase_addr[31:0];
    } PCH3_YBASE_ADDR @ 0x8020;

    reg {
        name = "PCH3_CBASE_ADDR";
        desc = "Data sheet 8.1.6 PCH3_CBASE_ADDR (offset 0x8024, printed page 8-160, `hi3516v100--Hi3516-Datasheet.txt` line 44643).";

        field {
            name = "cbase_addr";
            desc = "Cbase address. Chinese-only data sheet: description and value encoding not translated.";
            sw = rw;
            hw = r;
            reset = 0x0;
        } cbase_addr[31:0];
    } PCH3_CBASE_ADDR @ 0x8024;

    reg {
        name = "PCH3_Y_STRIDE";
        desc = "Data sheet 8.1.6 PCH3_Y_STRIDE (offset 0x8028, printed page 8-161, `hi3516v100--Hi3516-Datasheet.txt` line 44673).";

        field {
            name = "y_stride";
            desc = "Y stride. Chinese-only data sheet: description and value encoding not translated.";
            sw = rw;
            hw = r;
            reset = 0x0;
        } y_stride[15:0];
    } PCH3_Y_STRIDE @ 0x8028;

    reg {
        name = "PCH3_C_STRIDE";
        desc = "Data sheet 8.1.6 PCH3_C_STRIDE (offset 0x802C, printed page 8-161, `hi3516v100--Hi3516-Datasheet.txt` line 44694).";

        field {
            name = "c_stride";
            desc = "C stride. Chinese-only data sheet: description and value encoding not translated.";
            sw = rw;
            hw = r;
            reset = 0x0;
        } c_stride[15:0];
    } PCH3_C_STRIDE @ 0x802C;

    reg {
        name = "PCH3_HBASE_ADDR";
        desc = "Data sheet 8.1.6 PCH3_HBASE_ADDR (offset 0x8030, printed page 8-162, `hi3516v100--Hi3516-Datasheet.txt` line 44727).";

        field {
            name = "hbase_addr";
            desc = "Hbase address. Chinese-only data sheet: description and value encoding not translated.";
            sw = rw;
            hw = r;
            reset = 0x0;
        } hbase_addr[31:0];
    } PCH3_HBASE_ADDR @ 0x8030;

    reg {
        name = "PCH3_H_STRIDE";
        desc = "Data sheet 8.1.6 PCH3_H_STRIDE (offset 0x8034, printed page 8-162, `hi3516v100--Hi3516-Datasheet.txt` line 44746).";

        field {
            name = "h_stride";
            desc = "H stride. Chinese-only data sheet: description and value encoding not translated.";
            sw = rw;
            hw = r;
            reset = 0x0;
        } h_stride[15:0];
    } PCH3_H_STRIDE @ 0x8034;

    reg {
        name = "PCH3_HIST_MODE";
        desc = "Data sheet 8.1.6 PCH3_HIST_MODE (offset 0x803C, printed page 8-163, `hi3516v100--Hi3516-Datasheet.txt` line 44782).";

        field {
            name = "hist_mode";
            desc = "Histogram mode. Chinese-only data sheet: description and value encoding not translated.";
            sw = rw;
            hw = r;
            reset = 0x0;
        } hist_mode[2:0];
    } PCH3_HIST_MODE @ 0x803C;

    reg {
        name = "PCH3_INT_EN";
        desc = "Data sheet 8.1.6 PCH3_INT_EN (offset 0x8040, printed page 8-163, `hi3516v100--Hi3516-Datasheet.txt` line 44815).";

        field {
            name = "frame_pulse_int_en";
            desc = "Frame pulse interrupt enable. Chinese-only data sheet: description and value encoding not translated.";
            sw = rw;
            hw = r;
            reset = 0x0;
        } frame_pulse_int_en[5:5];

        field {
            name = "reg_update_int_en";
            desc = "Reg update interrupt enable. Chinese-only data sheet: description and value encoding not translated.";
            sw = rw;
            hw = r;
            reset = 0x0;
        } reg_update_int_en[4:4];

        field {
            name = "err_int_en";
            desc = "Error interrupt enable. Chinese-only data sheet: description and value encoding not translated.";
            sw = rw;
            hw = r;
            reset = 0x0;
        } err_int_en[3:3];

        field {
            name = "field_throw_int_en";
            desc = "Field throw interrupt enable. Chinese-only data sheet: description and value encoding not translated.";
            sw = rw;
            hw = r;
            reset = 0x0;
        } field_throw_int_en[2:2];

        field {
            name = "buf_ovf_int_en";
            desc = "Buf overflow interrupt enable. Chinese-only data sheet: description and value encoding not translated.";
            sw = rw;
            hw = r;
            reset = 0x0;
        } buf_ovf_int_en[1:1];

        field {
            name = "cc_int_en";
            desc = "Cc interrupt enable. Chinese-only data sheet: description and value encoding not translated.";
            sw = rw;
            hw = r;
            reset = 0x0;
        } cc_int_en[0:0];
    } PCH3_INT_EN @ 0x8040;

    reg {
        name = "PCH3_INT_STATUS";
        desc = "Data sheet 8.1.6 PCH3_INT_STATUS (offset 0x8044, printed page 8-164, `hi3516v100--Hi3516-Datasheet.txt` line 44876).";

        field {
            name = "frame_pulse_int";
            desc = "Frame pulse interrupt. Chinese-only data sheet: description and value encoding not translated.";
            sw = rw;
            hw = w;
            onwrite = woclr;
            reset = 0x0;
        } frame_pulse_int[5:5];

        field {
            name = "reg_update_int";
            desc = "Reg update interrupt. Chinese-only data sheet: description and value encoding not translated.";
            sw = rw;
            hw = w;
            onwrite = woclr;
            reset = 0x0;
        } reg_update_int[4:4];

        field {
            name = "err_int";
            desc = "Error interrupt. Chinese-only data sheet: description and value encoding not translated.";
            sw = rw;
            hw = w;
            onwrite = woclr;
            reset = 0x0;
        } err_int[3:3];

        field {
            name = "field_throw_int";
            desc = "Field throw interrupt. Chinese-only data sheet: description and value encoding not translated.";
            sw = rw;
            hw = w;
            onwrite = woclr;
            reset = 0x0;
        } field_throw_int[2:2];

        field {
            name = "buf_ovf_int";
            desc = "Buf overflow interrupt. Chinese-only data sheet: description and value encoding not translated.";
            sw = rw;
            hw = w;
            onwrite = woclr;
            reset = 0x0;
        } buf_ovf_int[1:1];

        field {
            name = "cc_int";
            desc = "Cc interrupt. Chinese-only data sheet: description and value encoding not translated.";
            sw = rw;
            hw = w;
            onwrite = woclr;
            reset = 0x0;
        } cc_int[0:0];
    } PCH3_INT_STATUS @ 0x8044;

    reg {
        name = "PCH3_RAW_INT";
        desc = "Data sheet 8.1.6 PCH3_RAW_INT (offset 0x8048, printed page 8-166, `hi3516v100--Hi3516-Datasheet.txt` line 44949).";

        field {
            name = "frame_pulse_raw_int";
            desc = "Frame pulse raw interrupt. Chinese-only data sheet: description and value encoding not translated.";
            sw = r;
            hw = w;
            reset = 0x0;
        } frame_pulse_raw_int[5:5];

        field {
            name = "reg_update_raw_int";
            desc = "Reg update raw interrupt. Chinese-only data sheet: description and value encoding not translated.";
            sw = r;
            hw = w;
            reset = 0x0;
        } reg_update_raw_int[4:4];

        field {
            name = "err_raw_int";
            desc = "Error raw interrupt. Chinese-only data sheet: description and value encoding not translated.";
            sw = r;
            hw = w;
            reset = 0x0;
        } err_raw_int[3:3];

        field {
            name = "field_throw_raw_int";
            desc = "Field throw raw interrupt. Chinese-only data sheet: description and value encoding not translated.";
            sw = r;
            hw = w;
            reset = 0x0;
        } field_throw_raw_int[2:2];

        field {
            name = "buf_ovf_raw_int";
            desc = "Buf overflow raw interrupt. Chinese-only data sheet: description and value encoding not translated.";
            sw = r;
            hw = w;
            reset = 0x0;
        } buf_ovf_raw_int[1:1];

        field {
            name = "cc_raw_int";
            desc = "Cc raw interrupt. Chinese-only data sheet: description and value encoding not translated.";
            sw = r;
            hw = w;
            reset = 0x0;
        } cc_raw_int[0:0];
    } PCH3_RAW_INT @ 0x8048;

    reg {
        name = "PCH3_STATUS";
        desc = "Data sheet 8.1.6 PCH3_STATUS (offset 0x804C, printed page 8-167, `hi3516v100--Hi3516-Datasheet.txt` line 45016).";

        field {
            name = "act_height";
            desc = "Act height. Chinese-only data sheet: description and value encoding not translated.";
            sw = r;
            hw = w;
            reset = 0x0;
        } act_height[18:6];

        field {
            name = "ch_busy";
            desc = "Ch busy. Chinese-only data sheet: description and value encoding not translated.";
            sw = r;
            hw = w;
            reset = 0x0;
        } ch_busy[5:5];

        field {
            name = "field2";
            desc = "Field2. Chinese-only data sheet: description and value encoding not translated.";
            sw = r;
            hw = w;
            reset = 0x0;
        } field2[4:4];

        field {
            name = "bus_err";
            desc = "Bus error. Chinese-only data sheet: description and value encoding not translated.";
            sw = r;
            hw = w;
            reset = 0x0;
        } bus_err[3:3];

        field {
            name = "frame_loss";
            desc = "Frame loss. Chinese-only data sheet: description and value encoding not translated.";
            sw = r;
            hw = w;
            reset = 0x0;
        } frame_loss[2:2];

        field {
            name = "buf_ovf";
            desc = "Buf overflow. Chinese-only data sheet: description and value encoding not translated.";
            sw = r;
            hw = w;
            reset = 0x0;
        } buf_ovf[1:1];

        field {
            name = "image_done";
            desc = "Image done. Chinese-only data sheet: description and value encoding not translated.";
            sw = r;
            hw = w;
            reset = 0x0;
        } image_done[0:0];
    } PCH3_STATUS @ 0x804C;

    reg {
        name = "PCH3_HLFIR_PRE";
        desc = "Data sheet 8.1.6 PCH3_HLFIR_PRE (offset 0x8060, printed page 8-168, `hi3516v100--Hi3516-Datasheet.txt` line 45074).";

        field {
            name = "hlfir_pre_coef1";
            desc = "Hlfir pre coef1. Chinese-only data sheet: description and value encoding not translated.";
            sw = rw;
            hw = r;
            reset = 0x0;
        } hlfir_pre_coef1[12:8];

        field {
            name = "hlfir_pre_coef0";
            desc = "Hlfir pre coef0. Chinese-only data sheet: description and value encoding not translated.";
            sw = rw;
            hw = r;
            reset = 0x0;
        } hlfir_pre_coef0[6:2];

        field {
            name = "hlfir_pre_mode";
            desc = "Hlfir pre mode. Chinese-only data sheet: description and value encoding not translated.";
            sw = rw;
            hw = r;
            reset = 0x0;
        } hlfir_pre_mode[0:0];
    } PCH3_HLFIR_PRE @ 0x8060;

    reg {
        name = "PCH3_HCFIR_PRE";
        desc = "Data sheet 8.1.6 PCH3_HCFIR_PRE (offset 0x8064, printed page 8-169, `hi3516v100--Hi3516-Datasheet.txt` line 45130).";

        field {
            name = "hchfir_pre_coef1";
            desc = "Hchfir pre coef1. Chinese-only data sheet: description and value encoding not translated.";
            sw = rw;
            hw = r;
            reset = 0x0;
        } hchfir_pre_coef1[12:8];

        field {
            name = "hchfir_pre_coef0";
            desc = "Hchfir pre coef0. Chinese-only data sheet: description and value encoding not translated.";
            sw = rw;
            hw = r;
            reset = 0x0;
        } hchfir_pre_coef0[6:2];

        field {
            name = "hchfir_pre_mode";
            desc = "Hchfir pre mode. Chinese-only data sheet: description and value encoding not translated.";
            sw = rw;
            hw = r;
            reset = 0x0;
        } hchfir_pre_mode[0:0];
    } PCH3_HCFIR_PRE @ 0x8064;

    reg {
        name = "PCH3_VLFIR_PRE";
        desc = "Data sheet 8.1.6 PCH3_VLFIR_PRE (offset 0x8068, printed page 8-170, `hi3516v100--Hi3516-Datasheet.txt` line 45183).";

        field {
            name = "vlfir_pre_coef1";
            desc = "Vlfir pre coef1. Chinese-only data sheet: description and value encoding not translated.";
            sw = rw;
            hw = r;
            reset = 0x0;
        } vlfir_pre_coef1[12:8];

        field {
            name = "vlfir_pre_coef0";
            desc = "Vlfir pre coef0. Chinese-only data sheet: description and value encoding not translated.";
            sw = rw;
            hw = r;
            reset = 0x0;
        } vlfir_pre_coef0[6:2];

        field {
            name = "vlfir_pre_mode";
            desc = "Vlfir pre mode. Chinese-only data sheet: description and value encoding not translated.";
            sw = rw;
            hw = r;
            reset = 0x0;
        } vlfir_pre_mode[0:0];
    } PCH3_VLFIR_PRE @ 0x8068;

    reg {
        name = "PCH3_VCFIR_PRE";
        desc = "Data sheet 8.1.6 PCH3_VCFIR_PRE (offset 0x806C, printed page 8-171, `hi3516v100--Hi3516-Datasheet.txt` line 45239).";

        field {
            name = "vchfir_pre_coef3";
            desc = "Vchfir pre coef3. Chinese-only data sheet: description and value encoding not translated.";
            sw = rw;
            hw = r;
            reset = 0x0;
        } vchfir_pre_coef3[24:20];

        field {
            name = "vchfir_pre_coef2";
            desc = "Vchfir pre coef2. Chinese-only data sheet: description and value encoding not translated.";
            sw = rw;
            hw = r;
            reset = 0x0;
        } vchfir_pre_coef2[18:14];

        field {
            name = "vchfir_pre_coef1";
            desc = "Vchfir pre coef1. Chinese-only data sheet: description and value encoding not translated.";
            sw = rw;
            hw = r;
            reset = 0x0;
        } vchfir_pre_coef1[12:8];

        field {
            name = "vchfir_pre_coef0";
            desc = "Vchfir pre coef0. Chinese-only data sheet: description and value encoding not translated.";
            sw = rw;
            hw = r;
            reset = 0x0;
        } vchfir_pre_coef0[6:2];

        field {
            name = "vchfir_pre_mode";
            desc = "Vchfir pre mode. Chinese-only data sheet: description and value encoding not translated.";
            sw = rw;
            hw = r;
            reset = 0x0;
        } vchfir_pre_mode[1:0];
    } PCH3_VCFIR_PRE @ 0x806C;

    reg {
        name = "PCH3_HLFIR_PAR";
        desc = "Data sheet 8.1.6 PCH3_HLFIR_PAR (offset 0x8100, printed page 8-172, `hi3516v100--Hi3516-Datasheet.txt` line 45300).";

        field {
            name = "hlmsc_en";
            desc = "Hlmsc enable. Chinese-only data sheet: description and value encoding not translated.";
            sw = rw;
            hw = r;
            reset = 0x0;
        } hlmsc_en[31:31];

        field {
            name = "hlmid_en";
            desc = "Hlmid enable. Chinese-only data sheet: description and value encoding not translated.";
            sw = rw;
            hw = r;
            reset = 0x0;
        } hlmid_en[30:30];

        field {
            name = "hlfir_en";
            desc = "Hlfir enable. Chinese-only data sheet: description and value encoding not translated.";
            sw = rw;
            hw = r;
            reset = 0x0;
        } hlfir_en[29:29];

        field {
            name = "hlfir_clip_en";
            desc = "Hlfir clip enable. Chinese-only data sheet: description and value encoding not translated.";
            sw = rw;
            hw = r;
            reset = 0x0;
        } hlfir_clip_en[28:28];

        field {
            name = "hlratio";
            desc = "Hlratio. Chinese-only data sheet: description and value encoding not translated.";
            sw = rw;
            hw = r;
            reset = 0x0;
        } hlratio[15:0];
    } PCH3_HLFIR_PAR @ 0x8100;

    reg {
        name = "PCH3_HCFIR_PAR";
        desc = "Data sheet 8.1.6 PCH3_HCFIR_PAR (offset 0x8104, printed page 8-173, `hi3516v100--Hi3516-Datasheet.txt` line 45365).";

        field {
            name = "hchmsc_en";
            desc = "Hchmsc enable. Chinese-only data sheet: description and value encoding not translated.";
            sw = rw;
            hw = r;
            reset = 0x0;
        } hchmsc_en[31:31];

        field {
            name = "hchmid_en";
            desc = "Hchmid enable. Chinese-only data sheet: description and value encoding not translated.";
            sw = rw;
            hw = r;
            reset = 0x0;
        } hchmid_en[30:30];

        field {
            name = "hchfir_en";
            desc = "Hchfir enable. Chinese-only data sheet: description and value encoding not translated.";
            sw = rw;
            hw = r;
            reset = 0x0;
        } hchfir_en[29:29];

        field {
            name = "hchfir_clip_en";
            desc = "Hchfir clip enable. Chinese-only data sheet: description and value encoding not translated.";
            sw = rw;
            hw = r;
            reset = 0x0;
        } hchfir_clip_en[28:28];

        field {
            name = "hchratio";
            desc = "Hchratio. Chinese-only data sheet: description and value encoding not translated.";
            sw = rw;
            hw = r;
            reset = 0x0;
        } hchratio[15:0];
    } PCH3_HCFIR_PAR @ 0x8104;

    reg {
        name = "PCH3_HLFIR_OFFSET";
        desc = "Data sheet 8.1.6 PCH3_HLFIR_OFFSET (offset 0x8108, printed page 8-174, `hi3516v100--Hi3516-Datasheet.txt` line 45424).";

        field {
            name = "hluma_offset";
            desc = "Hluma offset. Chinese-only data sheet: description and value encoding not translated.";
            sw = rw;
            hw = r;
            reset = 0x0;
        } hluma_offset[16:0];
    } PCH3_HLFIR_OFFSET @ 0x8108;

    reg {
        name = "PCH3_HCFIR_OFFSET";
        desc = "Data sheet 8.1.6 PCH3_HCFIR_OFFSET (offset 0x810C, printed page 8-174, `hi3516v100--Hi3516-Datasheet.txt` line 45447).";

        field {
            name = "hchroma_offset";
            desc = "Hchroma offset. Chinese-only data sheet: description and value encoding not translated.";
            sw = rw;
            hw = r;
            reset = 0x0;
        } hchroma_offset[16:0];
    } PCH3_HCFIR_OFFSET @ 0x810C;

    reg {
        name = "PCH3_VLFIR_PAR";
        desc = "Data sheet 8.1.6 PCH3_VLFIR_PAR (offset 0x8110, printed page 8-175, `hi3516v100--Hi3516-Datasheet.txt` line 45485).";

        field {
            name = "vlmsc_en";
            desc = "Vlmsc enable. Chinese-only data sheet: description and value encoding not translated.";
            sw = rw;
            hw = r;
            reset = 0x0;
        } vlmsc_en[31:31];

        field {
            name = "vlmid_en";
            desc = "Vlmid enable. Chinese-only data sheet: description and value encoding not translated.";
            sw = rw;
            hw = r;
            reset = 0x0;
        } vlmid_en[30:30];

        field {
            name = "vlfir_en";
            desc = "Vlfir enable. Chinese-only data sheet: description and value encoding not translated.";
            sw = rw;
            hw = r;
            reset = 0x0;
        } vlfir_en[29:29];

        field {
            name = "vlfir_clip_en";
            desc = "Vlfir clip enable. Chinese-only data sheet: description and value encoding not translated.";
            sw = rw;
            hw = r;
            reset = 0x0;
        } vlfir_clip_en[28:28];

        field {
            name = "vlratio";
            desc = "Vlratio. Chinese-only data sheet: description and value encoding not translated.";
            sw = rw;
            hw = r;
            reset = 0x0;
        } vlratio[15:0];
    } PCH3_VLFIR_PAR @ 0x8110;

    reg {
        name = "PCH3_VCFIR_PAR";
        desc = "Data sheet 8.1.6 PCH3_VCFIR_PAR (offset 0x8114, printed page 8-176, `hi3516v100--Hi3516-Datasheet.txt` line 45545).";

        field {
            name = "vchmsc_en";
            desc = "Vchmsc enable. Chinese-only data sheet: description and value encoding not translated.";
            sw = rw;
            hw = r;
            reset = 0x0;
        } vchmsc_en[31:31];

        field {
            name = "vchmid_en";
            desc = "Vchmid enable. Chinese-only data sheet: description and value encoding not translated.";
            sw = rw;
            hw = r;
            reset = 0x0;
        } vchmid_en[30:30];

        field {
            name = "vchfir_en";
            desc = "Vchfir enable. Chinese-only data sheet: description and value encoding not translated.";
            sw = rw;
            hw = r;
            reset = 0x0;
        } vchfir_en[29:29];

        field {
            name = "vchfir_clip_en";
            desc = "Vchfir clip enable. Chinese-only data sheet: description and value encoding not translated.";
            sw = rw;
            hw = r;
            reset = 0x0;
        } vchfir_clip_en[28:28];

        field {
            name = "vchratio";
            desc = "Vchratio. Chinese-only data sheet: description and value encoding not translated.";
            sw = rw;
            hw = r;
            reset = 0x0;
        } vchratio[15:0];
    } PCH3_VCFIR_PAR @ 0x8114;

    reg {
        name = "PCH3_VLFIR_OFFSET";
        desc = "Data sheet 8.1.6 PCH3_VLFIR_OFFSET (offset 0x8118, printed page 8-177, `hi3516v100--Hi3516-Datasheet.txt` line 45610).";

        field {
            name = "vluma_offset";
            desc = "Vluma offset. Chinese-only data sheet: description and value encoding not translated.";
            sw = rw;
            hw = r;
            reset = 0x0;
        } vluma_offset[16:0];
    } PCH3_VLFIR_OFFSET @ 0x8118;

    reg {
        name = "PCH3_VCFIR_OFFSET";
        desc = "Data sheet 8.1.6 PCH3_VCFIR_OFFSET (offset 0x811C, printed page 8-177, `hi3516v100--Hi3516-Datasheet.txt` line 45633).";

        field {
            name = "vchroma_offset";
            desc = "Vchroma offset. Chinese-only data sheet: description and value encoding not translated.";
            sw = rw;
            hw = r;
            reset = 0x0;
        } vchroma_offset[16:0];
    } PCH3_VCFIR_OFFSET @ 0x811C;

    reg {
        name = "PCH3_COEF_UPDATE";
        desc = "Data sheet 8.1.6 PCH3_COEF_UPDATE (offset 0x8120, printed page 8-178, `hi3516v100--Hi3516-Datasheet.txt` line 45668).";

        field {
            name = "cvcoef_update";
            desc = "Cvcoef update. Chinese-only data sheet: description and value encoding not translated.";
            sw = rw;
            hw = r;
            reset = 0x0;
        } cvcoef_update[3:3];

        field {
            name = "lvcoef_update";
            desc = "Lvcoef update. Chinese-only data sheet: description and value encoding not translated.";
            sw = rw;
            hw = r;
            reset = 0x0;
        } lvcoef_update[2:2];

        field {
            name = "chcoef_update";
            desc = "Chcoef update. Chinese-only data sheet: description and value encoding not translated.";
            sw = rw;
            hw = r;
            reset = 0x0;
        } chcoef_update[1:1];

        field {
            name = "lhcoef_update";
            desc = "Lhcoef update. Chinese-only data sheet: description and value encoding not translated.";
            sw = rw;
            hw = r;
            reset = 0x0;
        } lhcoef_update[0:0];
    } PCH3_COEF_UPDATE @ 0x8120;

    reg {
        name = "PCH3_HBLANK_WIDTH";
        desc = "Data sheet 8.1.6 PCH3_HBLANK_WIDTH (offset 0x8124, printed page 8-179, `hi3516v100--Hi3516-Datasheet.txt` line 45725).";

        field {
            name = "hblank_width";
            desc = "Hblank width. Chinese-only data sheet: description and value encoding not translated.";
            sw = rw;
            hw = r;
            reset = 0x0;
        } hblank_width[15:0];
    } PCH3_HBLANK_WIDTH @ 0x8124;

    reg {
        name = "PCH3_COEF_RSEL";
        desc = "Data sheet 8.1.6 PCH3_COEF_RSEL (offset 0x8128, printed page 8-179, `hi3516v100--Hi3516-Datasheet.txt` line 45750).";

        field {
            name = "cvcoef_read_sel";
            desc = "Cvcoef read select. Chinese-only data sheet: description and value encoding not translated.";
            sw = rw;
            hw = r;
            reset = 0x0;
        } cvcoef_read_sel[3:3];

        field {
            name = "lvcoef_read_sel";
            desc = "Lvcoef read select. Chinese-only data sheet: description and value encoding not translated.";
            sw = rw;
            hw = r;
            reset = 0x0;
        } lvcoef_read_sel[2:2];

        field {
            name = "chcoef_read_sel";
            desc = "Chcoef read select. Chinese-only data sheet: description and value encoding not translated.";
            sw = rw;
            hw = r;
            reset = 0x0;
        } chcoef_read_sel[1:1];

        field {
            name = "lhcoef_read_sel";
            desc = "Lhcoef read select. Chinese-only data sheet: description and value encoding not translated.";
            sw = rw;
            hw = r;
            reset = 0x0;
        } lhcoef_read_sel[0:0];
    } PCH3_COEF_RSEL @ 0x8128;

    reg {
        name = "MAC_PRIO_CFG";
        desc = "Data sheet 8.1.6 MAC_PRIO_CFG (offset 0x9000, printed page 8-180, `hi3516v100--Hi3516-Datasheet.txt` line 45804).";

        field {
            name = "pch3_hprio_ctrl";
            desc = "Pch3 hprio control. Chinese-only data sheet: description and value encoding not translated.";
            sw = rw;
            hw = r;
            reset = 0x0;
        } pch3_hprio_ctrl[29:28];

        field {
            name = "pch3_cprio_ctrl";
            desc = "Pch3 cprio control. Chinese-only data sheet: description and value encoding not translated.";
            sw = rw;
            hw = r;
            reset = 0x0;
        } pch3_cprio_ctrl[27:26];

        field {
            name = "pch3_yprio_ctrl";
            desc = "Pch3 yprio control. Chinese-only data sheet: description and value encoding not translated.";
            sw = rw;
            hw = r;
            reset = 0x0;
        } pch3_yprio_ctrl[25:24];

        field {
            name = "pch2_hprio_ctrl";
            desc = "Pch2 hprio control. Chinese-only data sheet: description and value encoding not translated.";
            sw = rw;
            hw = r;
            reset = 0x0;
        } pch2_hprio_ctrl[23:22];

        field {
            name = "pch2_cprio_ctrl";
            desc = "Pch2 cprio control. Chinese-only data sheet: description and value encoding not translated.";
            sw = rw;
            hw = r;
            reset = 0x0;
        } pch2_cprio_ctrl[21:20];

        field {
            name = "pch2_yprio_ctrl";
            desc = "Pch2 yprio control. Chinese-only data sheet: description and value encoding not translated.";
            sw = rw;
            hw = r;
            reset = 0x0;
        } pch2_yprio_ctrl[19:18];

        field {
            name = "pch1_hprio_ctrl";
            desc = "Pch1 hprio control. Chinese-only data sheet: description and value encoding not translated.";
            sw = rw;
            hw = r;
            reset = 0x0;
        } pch1_hprio_ctrl[17:16];

        field {
            name = "pch1_cprio_ctrl";
            desc = "Pch1 cprio control. Chinese-only data sheet: description and value encoding not translated.";
            sw = rw;
            hw = r;
            reset = 0x0;
        } pch1_cprio_ctrl[15:14];

        field {
            name = "pch1_yprio_ctrl";
            desc = "Pch1 yprio control. Chinese-only data sheet: description and value encoding not translated.";
            sw = rw;
            hw = r;
            reset = 0x0;
        } pch1_yprio_ctrl[13:12];

        field {
            name = "mch_hprio_ctrl";
            desc = "Mch hprio control. Chinese-only data sheet: description and value encoding not translated.";
            sw = rw;
            hw = r;
            reset = 0x0;
        } mch_hprio_ctrl[11:10];

        field {
            name = "mch_cprio_ctrl";
            desc = "Mch cprio control. Chinese-only data sheet: description and value encoding not translated.";
            sw = rw;
            hw = r;
            reset = 0x0;
        } mch_cprio_ctrl[9:8];

        field {
            name = "mch_yprio_ctrl";
            desc = "Mch yprio control. Chinese-only data sheet: description and value encoding not translated.";
            sw = rw;
            hw = r;
            reset = 0x0;
        } mch_yprio_ctrl[7:6];

        field {
            name = "sch_hprio_ctrl";
            desc = "Sch hprio control. Chinese-only data sheet: description and value encoding not translated.";
            sw = rw;
            hw = r;
            reset = 0x0;
        } sch_hprio_ctrl[5:4];

        field {
            name = "sch_cprio_ctrl";
            desc = "Sch cprio control. Chinese-only data sheet: description and value encoding not translated.";
            sw = rw;
            hw = r;
            reset = 0x0;
        } sch_cprio_ctrl[3:2];

        field {
            name = "sch_yprio_ctrl";
            desc = "Sch yprio control. Chinese-only data sheet: description and value encoding not translated.";
            sw = rw;
            hw = r;
            reset = 0x0;
        } sch_yprio_ctrl[1:0];
    } MAC_PRIO_CFG @ 0x9000;

    reg {
        name = "MAC_CTRL";
        desc = "Data sheet 8.1.6 MAC_CTRL (offset 0x9004, printed page 8-183, `hi3516v100--Hi3516-Datasheet.txt` line 45963).";

        field {
            name = "w_ost_max";
            desc = "W ost max. Chinese-only data sheet: description and value encoding not translated.";
            sw = rw;
            hw = r;
            reset = 0x4;
        } w_ost_max[3:0];
    } MAC_CTRL @ 0x9004;

    reg {
        name = "TOP_INT_INDICATOR";
        desc = "Data sheet 8.1.6 TOP_INT_INDICATOR (offset 0x900C, printed page 8-184, `hi3516v100--Hi3516-Datasheet.txt` line 45997).";

        field {
            name = "sd_int_indicator";
            desc = "Sd interrupt indicator. Chinese-only data sheet: description and value encoding not translated.";
            sw = r;
            hw = w;
            reset = 0x0;
        } sd_int_indicator[6:6];

        field {
            name = "hd_int_indicator";
            desc = "Hd interrupt indicator. Chinese-only data sheet: description and value encoding not translated.";
            sw = r;
            hw = w;
            reset = 0x0;
        } hd_int_indicator[5:5];

        field {
            name = "ph3_int_indicator";
            desc = "Ph3 interrupt indicator. Chinese-only data sheet: description and value encoding not translated.";
            sw = r;
            hw = w;
            reset = 0x0;
        } ph3_int_indicator[4:4];

        field {
            name = "ph2_int_indicator";
            desc = "Ph2 interrupt indicator. Chinese-only data sheet: description and value encoding not translated.";
            sw = r;
            hw = w;
            reset = 0x0;
        } ph2_int_indicator[3:3];

        field {
            name = "ph1_int_indicator";
            desc = "Ph1 interrupt indicator. Chinese-only data sheet: description and value encoding not translated.";
            sw = r;
            hw = w;
            reset = 0x0;
        } ph1_int_indicator[2:2];

        field {
            name = "mch_int_indicator";
            desc = "Mch interrupt indicator. Chinese-only data sheet: description and value encoding not translated.";
            sw = r;
            hw = w;
            reset = 0x0;
        } mch_int_indicator[1:1];

        field {
            name = "sch_int_indicator";
            desc = "Sch interrupt indicator. Chinese-only data sheet: description and value encoding not translated.";
            sw = r;
            hw = w;
            reset = 0x0;
        } sch_int_indicator[0:0];
    } TOP_INT_INDICATOR @ 0x900C;

    reg {
        name = "TOP_PDP_CTRL";
        desc = "Data sheet 8.1.6 TOP_PDP_CTRL (offset 0x9010, printed page 8-185, `hi3516v100--Hi3516-Datasheet.txt` line 46066).";

        field {
            name = "pdp_sd_en";
            desc = "Pdp sd enable. Chinese-only data sheet: description and value encoding not translated.";
            sw = rw;
            hw = r;
            reset = 0x0;
        } pdp_sd_en[1:1];

        field {
            name = "pdp_hd_en";
            desc = "Pdp hd enable. Chinese-only data sheet: description and value encoding not translated.";
            sw = rw;
            hw = r;
            reset = 0x0;
        } pdp_hd_en[0:0];
    } TOP_PDP_CTRL @ 0x9010;

    reg {
        name = "TOP_CK_CTRL";
        desc = "Data sheet 8.1.6 TOP_CK_CTRL (offset 0x9014, printed page 8-186, `hi3516v100--Hi3516-Datasheet.txt` line 46111).";

        field {
            name = "ck_gt_en";
            desc = "Ck gt enable. Chinese-only data sheet: description and value encoding not translated.";
            sw = rw;
            hw = r;
            reset = 0x0;
        } ck_gt_en[0:0];
    } TOP_CK_CTRL @ 0x9014;

    reg {
        name = "TOP_APB_DLY";
        desc = "Data sheet 8.1.6 TOP_APB_DLY (offset 0x9018, printed page 8-186, `hi3516v100--Hi3516-Datasheet.txt` line 46139).";

        field {
            name = "pready_dly_num";
            desc = "Pready delay number. Chinese-only data sheet: description and value encoding not translated.";
            sw = rw;
            hw = r;
            reset = 0x30;
        } pready_dly_num[15:0];
    } TOP_APB_DLY @ 0x9018;
};

`endif
