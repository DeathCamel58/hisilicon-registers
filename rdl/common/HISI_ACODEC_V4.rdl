`ifndef HISI_ACODEC_V4_RDL
`define HISI_ACODEC_V4_RDL

regfile eHISI_ACODEC_V4 {
    name = "Internal audio codec (ACODEC), Hi3516E V200 / V300 generation";
    desc = "Window 0x100F0000 (0x10000). Provenance: PROVEN = offset/bit seen in a named function of hi3516ev200_acodec.ko (static disassembly, build/tmp/ev200/dis) or in the open acodec_init.c; INFERRED = only the offset is seen; GUESS = plausible. Registers 0x34/0x38/0x3C of the module image are software device data, not MMIO. Hardware not read.";

    reg {
        name = "Analog register 0 (power/enable bits)";
        desc = "ACODEC_ANAREG0 [INFERRED] hi3516ev200_acodec.ko acodec_reboot / acodec_exit: read-modify-write with orr 0x3C, 0xC000, 0xC0, 0x1000 at +0 (power-down sequence between osal_msleep calls); acodec_open/acodec_close set/clear it; acodec_soft_reset writes it with the reset value. Hardware not read.";
        field { name = "value"; desc = "Whole register."; } value[31:0];
    } ACODEC_ANAREG0 @ 0x0;

    reg {
        name = "Analog register 1";
        desc = "ACODEC_ANAREG1 [PROVEN] hi3516ev200_acodec.ko ACODEC_HAL_ReadReg/WriteReg access [base+0x04+...]; acodec_ioctl sets bit 17 ([base+4]); open acodec_init.c (openhisilicon kernel/acodec) names it ANAREG1 with bit 1 = EN_RCTUNE (ADC RC-tune pulse, ACODEC_SET_I2S1_FS). Hardware not read.";
        field { name = "en_rctune"; desc = "EN_RCTUNE pulse (open acodec_init.c ACODEC_EN_RCTUNE). [PROVEN]"; } en_rctune[1:1];
        field { name = "bit17"; desc = "Set by acodec_ioctl. [INFERRED]"; } bit17[17:17];
    } ACODEC_ANAREG1 @ 0x4;

    reg {
        name = "Analog register 2";
        desc = "ACODEC_ANAREG2 [INFERRED] hi3516ev200_acodec.ko acodec_soft_reset and acodec_reboot access +0x08. Hardware not read.";
        field { name = "value"; desc = "Whole register."; } value[31:0];
    } ACODEC_ANAREG2 @ 0x8;

    reg {
        name = "Analog register 3";
        desc = "ACODEC_ANAREG3 [INFERRED] hi3516ev200_acodec.ko acodec_reboot (bfc bit 10, orr 0x20000), acodec_ioctl (bit 2). Hardware not read.";
        field { name = "bit2"; desc = "Set by acodec_ioctl. [INFERRED]"; } bit2[2:2];
        field { name = "bit10"; desc = "Cleared by acodec_reboot. [INFERRED]"; } bit10[10:10];
        field { name = "bit17"; desc = "Set by acodec_reboot (orr 0x20000). [INFERRED]"; } bit17[17:17];
    } ACODEC_ANAREG3 @ 0xC;

    reg {
        name = "Analog register 4";
        desc = "ACODEC_ANAREG4 [INFERRED] hi3516ev200_acodec.ko acodec_soft_reset and acodec_reboot access +0x10. Hardware not read.";
        field { name = "value"; desc = "Whole register."; } value[31:0];
    } ACODEC_ANAREG4 @ 0x10;

    reg {
        name = "Analog register 5";
        desc = "ACODEC_ANAREG5 [INFERRED] hi3516ev200_acodec.ko acodec_init reads it, acodec_soft_reset resets it. Hardware not read.";
        field { name = "value"; desc = "Whole register."; } value[31:0];
    } ACODEC_ANAREG5 @ 0x14;

    reg {
        name = "RC-tune calibration status";
        desc = "ACODEC_CAL_STATUS [PROVEN] open acodec_init.c ACODEC_CAL_STATUS 0x18: bit 3 stays set while the tuning matches the codec clock (the module re-pulses EN_RCTUNE when it clears). Hardware not read.";
        field { name = "cal_valid"; desc = "1 = RC tuning valid. [PROVEN]"; } cal_valid[3:3];
    } ACODEC_CAL_STATUS @ 0x18;

    reg {
        name = "Digital register 0";
        desc = "ACODEC_DIGREG0 [INFERRED] hi3516ev200_acodec.ko acodec_soft_reset writes +0xCC. Hardware not read.";
        field { name = "value"; desc = "Whole register."; } value[31:0];
    } ACODEC_DIGREG0 @ 0xCC;

    reg {
        name = "Digital register 1 (volume/sample-rate select)";
        desc = "ACODEC_DIGREG1 [INFERRED] hi3516ev200_acodec.ko acodec_ioctl: fields [20:19] and [22:21] and low bits 1:0 handled; acodec_soft_reset resets it. Hardware not read.";
        field { name = "fs_sel_lo"; desc = "Field written by acodec_ioctl (sample-rate related). [INFERRED]"; } fs_sel_lo[20:19];
        field { name = "fs_sel_hi"; desc = "Field written by acodec_ioctl. [INFERRED]"; } fs_sel_hi[22:21];
    } ACODEC_DIGREG1 @ 0xD0;

    reg {
        name = "Digital register 2";
        desc = "ACODEC_DIGREG2 [INFERRED] hi3516ev200_acodec.ko acodec_reboot writes +0xD4 first (reset), AcodecProcShow reads it. Hardware not read.";
        field { name = "value"; desc = "Whole register."; } value[31:0];
    } ACODEC_DIGREG2 @ 0xD4;

    reg {
        name = "ADC gain / mute";
        desc = "ACODEC_GAIN [PROVEN] hi3516ev200_acodec.ko acodec_ioctl: bit 31 and [30:24] (7-bit gain) written; AcodecProcShow decodes [30:24] and [22:16] (ubfx 24,8 and 16,7). Hardware not read.";
        field { name = "gain_r"; desc = "Right/second channel gain field (AcodecProcShow). [INFERRED]"; } gain_r[22:16];
        field { name = "gain_l"; desc = "Gain field written by acodec_ioctl. [PROVEN]"; } gain_l[30:24];
        field { name = "update"; desc = "Set together with the gain write. [PROVEN]"; } update[31:31];
    } ACODEC_GAIN @ 0xD8;

    reg {
        name = "Digital register 4";
        desc = "ACODEC_DIGREG4 [INFERRED] hi3516ev200_acodec.ko acodec_soft_reset writes +0xDC. Hardware not read.";
        field { name = "value"; desc = "Whole register."; } value[31:0];
    } ACODEC_DIGREG4 @ 0xDC;

};
`endif
