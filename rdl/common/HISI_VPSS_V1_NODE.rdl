`ifndef HISI_VPSS_V1_NODE_RDL
`define HISI_VPSS_V1_NODE_RDL

regfile eHISI_VPSS_V1_COVER {
    name = "VPSS node cover-region record (11 words)";
    desc = "One cover/mask region record inside the VPSS node image of the Hi3518E V200, at node offset 0x2604 + idx * 44 (stride 44 bytes). Provenance: hi3518e_vpss.ko VPSS_HAL_SetCover (words 0..4) and VPSS_HAL_SetCover1 (words 5..10); the offsets and the index scaling 44*idx are PROVEN (arm-re path-sensitive static analysis of the index expression, re-run 2026-11-12; the older linear pass listed the 11 words of idx 0 only); the number of records is INFERRED as 8 from VPSS_HAL_SetCoverCtrl (node word 0x2600, bits 0..7 = per-region enable); word meanings INFERRED from the function names; not hardware verified.";

    reg {
        name = "Cover record word 0x0";
        desc = "Word at record offset 0x0 (node 0x2604 + idx*44). SetCover: R/W, clears 0xFFFFFF, three 8-bit values ORed at bit shifts 0/8/16 (cover colour R/G/B, INFERRED). Provenance: offset/stride PROVEN, masks/shifts PROVEN (lower bounds), meaning INFERRED.";
        field {
            name = "word";
            desc = "32-bit word (see the register description).";
            sw = rw;
            hw = r;
        } word[31:0];
    } COVER_W_00 @ 0x0;

    reg {
        name = "Cover record word 0x4";
        desc = "Word at record offset 0x4 (node 0x2608 + idx*44). SetCover: read-modify-write, two 16-bit halves at shifts 0 and 16 (region coordinate pair, INFERRED). Provenance: offset/stride PROVEN, masks/shifts PROVEN (lower bounds), meaning INFERRED.";
        field {
            name = "word";
            desc = "32-bit word (see the register description).";
            sw = rw;
            hw = r;
        } word[31:0];
    } COVER_W_04 @ 0x4;

    reg {
        name = "Cover record word 0x8";
        desc = "Word at record offset 0x8 (node 0x260C + idx*44). SetCover: two 16-bit halves at shifts 0 and 16 (INFERRED coordinates). Provenance: offset/stride PROVEN, masks/shifts PROVEN (lower bounds), meaning INFERRED.";
        field {
            name = "word";
            desc = "32-bit word (see the register description).";
            sw = rw;
            hw = r;
        } word[31:0];
    } COVER_W_08 @ 0x8;

    reg {
        name = "Cover record word 0xC";
        desc = "Word at record offset 0xC (node 0x2610 + idx*44). SetCover: two 16-bit halves at shifts 0 and 16 (INFERRED coordinates). Provenance: offset/stride PROVEN, masks/shifts PROVEN (lower bounds), meaning INFERRED.";
        field {
            name = "word";
            desc = "32-bit word (see the register description).";
            sw = rw;
            hw = r;
        } word[31:0];
    } COVER_W_0C @ 0xC;

    reg {
        name = "Cover record word 0x10";
        desc = "Word at record offset 0x10 (node 0x2614 + idx*44). SetCover: two 16-bit halves at shifts 0 and 16 (INFERRED coordinates). Provenance: offset/stride PROVEN, masks/shifts PROVEN (lower bounds), meaning INFERRED.";
        field {
            name = "word";
            desc = "32-bit word (see the register description).";
            sw = rw;
            hw = r;
        } word[31:0];
    } COVER_W_10 @ 0x10;

    reg {
        name = "Cover record word 0x14";
        desc = "Word at record offset 0x14 (node 0x2618 + idx*44). SetCover1: R/W, clears 0x1FFFFFFF or written whole (0xFFFFFFFF constant path); 29-bit value (INFERRED: quadrilateral cover parameter). Provenance: offset/stride PROVEN, masks/shifts PROVEN (lower bounds), meaning INFERRED.";
        field {
            name = "word";
            desc = "32-bit word (see the register description).";
            sw = rw;
            hw = r;
        } word[31:0];
    } COVER_W_14 @ 0x14;

    reg {
        name = "Cover record word 0x18";
        desc = "Word at record offset 0x18 (node 0x261C + idx*44). SetCover1: R/W, clears 0x1FFFFFFF or written whole (0xFFFFFFFF constant path); 29-bit value (INFERRED: quadrilateral cover parameter). Provenance: offset/stride PROVEN, masks/shifts PROVEN (lower bounds), meaning INFERRED.";
        field {
            name = "word";
            desc = "32-bit word (see the register description).";
            sw = rw;
            hw = r;
        } word[31:0];
    } COVER_W_18 @ 0x18;

    reg {
        name = "Cover record word 0x1C";
        desc = "Word at record offset 0x1C (node 0x2620 + idx*44). SetCover1: R/W, clears 0x1FFFFFFF or written whole (0xFFFFFFFF constant path); 29-bit value (INFERRED: quadrilateral cover parameter). Provenance: offset/stride PROVEN, masks/shifts PROVEN (lower bounds), meaning INFERRED.";
        field {
            name = "word";
            desc = "32-bit word (see the register description).";
            sw = rw;
            hw = r;
        } word[31:0];
    } COVER_W_1C @ 0x1C;

    reg {
        name = "Cover record word 0x20";
        desc = "Word at record offset 0x20 (node 0x2624 + idx*44). SetCover1: R/W, clears 0x1FFFFFFF or written whole (0xFFFFFFFF constant path); 29-bit value (INFERRED: quadrilateral cover parameter). Provenance: offset/stride PROVEN, masks/shifts PROVEN (lower bounds), meaning INFERRED.";
        field {
            name = "word";
            desc = "32-bit word (see the register description).";
            sw = rw;
            hw = r;
        } word[31:0];
    } COVER_W_20 @ 0x20;

    reg {
        name = "Cover record word 0x24";
        desc = "Word at record offset 0x24 (node 0x2628 + idx*44). SetCover1: R/W, clears 0x1FFFFFFF or written whole (0xFFFFFFFF constant path); 29-bit value (INFERRED: quadrilateral cover parameter). Provenance: offset/stride PROVEN, masks/shifts PROVEN (lower bounds), meaning INFERRED.";
        field {
            name = "word";
            desc = "32-bit word (see the register description).";
            sw = rw;
            hw = r;
        } word[31:0];
    } COVER_W_24 @ 0x24;

    reg {
        name = "Cover record word 0x28";
        desc = "Word at record offset 0x28 (node 0x262C + idx*44). SetCover1: R/W, clears 0x1FFFFFFF or written whole (0xFFFFFFFF constant path); 29-bit value (INFERRED: quadrilateral cover parameter). Provenance: offset/stride PROVEN, masks/shifts PROVEN (lower bounds), meaning INFERRED.";
        field {
            name = "word";
            desc = "32-bit word (see the register description).";
            sw = rw;
            hw = r;
        } word[31:0];
    } COVER_W_28 @ 0x28;
};

regfile eHISI_VPSS_V1_NODE {
    name = "VPSS job node image (NOT A REGISTER FILE), Hi3518E V200 / Hi3516C V200";
    desc = "NOT A REGISTER FILE and NOT INSTANTIATED: layout of one VPSS job node (register image in DDR, linked list through NEXT) as written by the VPSS_HAL_Set* functions of hi3518e_vpss.ko (OpenIPC package, Hi3518EV200_MPP_V1.0.5.0; the Dahua Hi3518EV200 build V1.0.0.0 B010 Debug gives the same word set), described as a regfile only to document offsets. Link words: NODE_ID 0x1F4, MASK 0x1FC, NEXT 0x2FC, timeout 0x31C (same convention as eHISI_VPSS_V2_NODE of the Hi3516C V300). REVISION 2026-11-12 (round 6: the cover block 0x2604-0x262C is now an indexed record array COVER[8], stride 0x2C, after the arm-re engine showed its 44*idx index):  regenerated with the CFG-aware emulator scripts/tools/arm-emu (jump tables followed); the first version (linear pass) had wrong per-channel scaler block offsets (0x4040/0x6000/0x80C0) which are corrected here: scaler blocks are at 0x2000 + n*0x40 (n = channel 0..3, 7 words each). PROVENANCE for every word: offset and the clear-mask / shift constants are PROVEN (read from the load/store/bic/orr sequences of the named functions); extents are LOWER BOUNDS (computed shifts and widths are not followed); the function name suggests the role (INFERRED); words written from unfollowed values show no extent. Not hardware verified.";

    reg {
        name = "Node word at offset 0x0";
        desc = "Word 0x0 of the node image. Accessed by: OnLineVideoEn (read); OnLineVideoEn (write, clears 0x80000000, value ORed at bit shift 31); ScaleEn (read); ScaleEn (write, clears 0x43c, value ORed at bit shift 2/3/4/5); SetCoverCtrl (read); SetCoverCtrl (write). Provenance: offset PROVEN, listed masks/shifts PROVEN (lower bounds), role INFERRED from the function name, anything else UNKNOWN/GUESS.";
        field {
            name = "word";
            desc = "32-bit word (extents see the register description).";
            sw = rw;
            hw = r;
        } word[31:0];
    } NODE_W_0000 @ 0x0;

    reg {
        name = "Node word at offset 0x4";
        desc = "Word 0x4 of the node image. Accessed by: SetChnCrop (read); SetChnCrop (write, clears 0x1c, value ORed at bit shift 2/3/4); SetGrpCropAttr (read); SetGrpCropAttr (write, clears 0x3, value ORed at bit shift 0). Provenance: offset PROVEN, listed masks/shifts PROVEN (lower bounds), role INFERRED from the function name, anything else UNKNOWN/GUESS.";
        field {
            name = "word";
            desc = "32-bit word (extents see the register description).";
            sw = rw;
            hw = r;
        } word[31:0];
    } NODE_W_0004 @ 0x4;

    reg {
        name = "Node word at offset 0x8";
        desc = "Word 0x8 of the node image. Accessed by: NrRfrEn (read); NrRfrEn (write, clears 0x10, value ORed at bit shift 4); SetChnCtrl (read); SetChnCtrl (write, clears 0xf0000, value ORed at bit shift 16/17/18/19); SetChnEn (read); SetChnEn (write, clears 0xe, value ORed at bit shift 0/1/2/3); SetChnEn (write, clears 0xf, value ORed at bit shift 0/1/2/3); SetSrcImgType (read); SetSrcImgType (write, clears 0x100000, value ORed at bit shift 20). Provenance: offset PROVEN, listed masks/shifts PROVEN (lower bounds), role INFERRED from the function name, anything else UNKNOWN/GUESS.";
        field {
            name = "word";
            desc = "32-bit word (extents see the register description).";
            sw = rw;
            hw = r;
        } word[31:0];
    } NODE_W_0008 @ 0x8;

    reg {
        name = "Node word at offset 0xC";
        desc = "Word 0xC of the node image. Accessed by: NrRfrEn (read); NrRfrEn (write, clears 0x10, value ORed at bit shift 4); SetImgWorkType (read); SetImgWorkType (write, clears 0x6, value ORed at bit shift 1); SetVadSel (read); SetVadSel (write, clears 0x8, value ORed at bit shift 3). Provenance: offset PROVEN, listed masks/shifts PROVEN (lower bounds), role INFERRED from the function name, anything else UNKNOWN/GUESS.";
        field {
            name = "word";
            desc = "32-bit word (extents see the register description).";
            sw = rw;
            hw = r;
        } word[31:0];
    } NODE_W_000C @ 0xC;

    reg {
        name = "Node word at offset 0x10";
        desc = "Word 0x10 of the node image. Accessed by: ScaleRegup (read); ScaleRegup (write, clears 0x1e, value ORed at bit shift 1/2/3); ScaleRegup (write, clears 0x1e, value ORed at bit shift 1/2/4); ScaleRegup (write, clears 0x1e, value ORed at bit shift 1/3/4); ScaleRegup (write, clears 0x1e, value ORed at bit shift 2/3/4); SetRegup (read); SetRegup (write, clears 0x1, value ORed at bit shift 0). Provenance: offset PROVEN, listed masks/shifts PROVEN (lower bounds), role INFERRED from the function name, anything else UNKNOWN/GUESS.";
        field {
            name = "word";
            desc = "32-bit word (extents see the register description).";
            sw = rw;
            hw = r;
        } word[31:0];
    } NODE_W_0010 @ 0x10;

    reg {
        name = "Node word at offset 0x20";
        desc = "Word 0x20 of the node image. Accessed by: SetSrcImgSize (read); SetSrcImgSize (write, clears 0x1fff, value ORed at bit shift 19/16). Provenance: offset PROVEN, listed masks/shifts PROVEN (lower bounds), role INFERRED from the function name, anything else UNKNOWN/GUESS.";
        field {
            name = "word";
            desc = "32-bit word (extents see the register description).";
            sw = rw;
            hw = r;
        } word[31:0];
    } NODE_W_0020 @ 0x20;

    reg {
        name = "Node word at offset 0x24";
        desc = "Word 0x24 of the node image. Accessed by: SetRefPicSize (read); SetRefPicSize (write, clears 0x1fff, value ORed at bit shift 19/16). Provenance: offset PROVEN, listed masks/shifts PROVEN (lower bounds), role INFERRED from the function name, anything else UNKNOWN/GUESS.";
        field {
            name = "word";
            desc = "32-bit word (extents see the register description).";
            sw = rw;
            hw = r;
        } word[31:0];
    } NODE_W_0024 @ 0x24;

    reg {
        name = "Node word at offset 0x28";
        desc = "Word 0x28 of the node image. Accessed by: SetGrpCropAttr (read); SetGrpCropAttr (write, value ORed at bit shift 16). Provenance: offset PROVEN, listed masks/shifts PROVEN (lower bounds), role INFERRED from the function name, anything else UNKNOWN/GUESS.";
        field {
            name = "word";
            desc = "32-bit word (extents see the register description).";
            sw = rw;
            hw = r;
        } word[31:0];
    } NODE_W_0028 @ 0x28;

    reg {
        name = "Node word at offset 0x2C";
        desc = "Word 0x2C of the node image. Accessed by: SetGrpCropAttr (read); SetGrpCropAttr (write, value ORed at bit shift 16). Provenance: offset PROVEN, listed masks/shifts PROVEN (lower bounds), role INFERRED from the function name, anything else UNKNOWN/GUESS.";
        field {
            name = "word";
            desc = "32-bit word (extents see the register description).";
            sw = rw;
            hw = r;
        } word[31:0];
    } NODE_W_002C @ 0x2C;

    reg {
        name = "Node word at offset 0x30";
        desc = "Word 0x30 of the node image. Accessed by: SetGrpCropAttr (read); SetGrpCropAttr (write, value ORed at bit shift 16). Provenance: offset PROVEN, listed masks/shifts PROVEN (lower bounds), role INFERRED from the function name, anything else UNKNOWN/GUESS.";
        field {
            name = "word";
            desc = "32-bit word (extents see the register description).";
            sw = rw;
            hw = r;
        } word[31:0];
    } NODE_W_0030 @ 0x30;

    reg {
        name = "Node word at offset 0x34";
        desc = "Word 0x34 of the node image. Accessed by: SetGrpCropAttr (read); SetGrpCropAttr (write, value ORed at bit shift 16). Provenance: offset PROVEN, listed masks/shifts PROVEN (lower bounds), role INFERRED from the function name, anything else UNKNOWN/GUESS.";
        field {
            name = "word";
            desc = "32-bit word (extents see the register description).";
            sw = rw;
            hw = r;
        } word[31:0];
    } NODE_W_0034 @ 0x34;

    reg {
        name = "Node word at offset 0x38";
        desc = "Word 0x38 of the node image. Accessed by: SetChnCrop (read); SetChnCrop (write, clears 0xfff0000, value ORed at bit shift 20/16). Provenance: offset PROVEN, listed masks/shifts PROVEN (lower bounds), role INFERRED from the function name, anything else UNKNOWN/GUESS.";
        field {
            name = "word";
            desc = "32-bit word (extents see the register description).";
            sw = rw;
            hw = r;
        } word[31:0];
    } NODE_W_0038 @ 0x38;

    reg {
        name = "Node word at offset 0x3C";
        desc = "Word 0x3C of the node image. Accessed by: SetChnCrop (read); SetChnCrop (write, clears 0xfff0000, value ORed at bit shift 20/16). Provenance: offset PROVEN, listed masks/shifts PROVEN (lower bounds), role INFERRED from the function name, anything else UNKNOWN/GUESS.";
        field {
            name = "word";
            desc = "32-bit word (extents see the register description).";
            sw = rw;
            hw = r;
        } word[31:0];
    } NODE_W_003C @ 0x3C;

    reg {
        name = "Node word at offset 0x40";
        desc = "Word 0x40 of the node image. Accessed by: SetChnCrop (read); SetChnCrop (write, clears 0xfff0000, value ORed at bit shift 20/16). Provenance: offset PROVEN, listed masks/shifts PROVEN (lower bounds), role INFERRED from the function name, anything else UNKNOWN/GUESS.";
        field {
            name = "word";
            desc = "32-bit word (extents see the register description).";
            sw = rw;
            hw = r;
        } word[31:0];
    } NODE_W_0040 @ 0x40;

    reg {
        name = "Node word at offset 0x44";
        desc = "Word 0x44 of the node image. Accessed by: SetChnCrop (read); SetChnCrop (write, clears 0xfff0000, value ORed at bit shift 20/16). Provenance: offset PROVEN, listed masks/shifts PROVEN (lower bounds), role INFERRED from the function name, anything else UNKNOWN/GUESS.";
        field {
            name = "word";
            desc = "32-bit word (extents see the register description).";
            sw = rw;
            hw = r;
        } word[31:0];
    } NODE_W_0044 @ 0x44;

    reg {
        name = "Node word at offset 0x48";
        desc = "Word 0x48 of the node image. Accessed by: SetChnCrop (read); SetChnCrop (write, clears 0xfff0000, value ORed at bit shift 20/16). Provenance: offset PROVEN, listed masks/shifts PROVEN (lower bounds), role INFERRED from the function name, anything else UNKNOWN/GUESS.";
        field {
            name = "word";
            desc = "32-bit word (extents see the register description).";
            sw = rw;
            hw = r;
        } word[31:0];
    } NODE_W_0048 @ 0x48;

    reg {
        name = "Node word at offset 0x4C";
        desc = "Word 0x4C of the node image. Accessed by: SetChnCrop (read); SetChnCrop (write, clears 0xfff0000, value ORed at bit shift 20/16). Provenance: offset PROVEN, listed masks/shifts PROVEN (lower bounds), role INFERRED from the function name, anything else UNKNOWN/GUESS.";
        field {
            name = "word";
            desc = "32-bit word (extents see the register description).";
            sw = rw;
            hw = r;
        } word[31:0];
    } NODE_W_004C @ 0x4C;

    reg {
        name = "Node word at offset 0x64";
        desc = "Word 0x64 of the node image. Accessed by: SetChnImgSize (read); SetChnImgSize (write, clears 0x1fff0000, value ORed at bit shift 19/16). Provenance: offset PROVEN, listed masks/shifts PROVEN (lower bounds), role INFERRED from the function name, anything else UNKNOWN/GUESS.";
        field {
            name = "word";
            desc = "32-bit word (extents see the register description).";
            sw = rw;
            hw = r;
        } word[31:0];
    } NODE_W_0064 @ 0x64;

    reg {
        name = "Node word at offset 0x68";
        desc = "Word 0x68 of the node image. Accessed by: SetChnImgSize (read); SetChnImgSize (write, clears 0x1fff0000, value ORed at bit shift 19/16). Provenance: offset PROVEN, listed masks/shifts PROVEN (lower bounds), role INFERRED from the function name, anything else UNKNOWN/GUESS.";
        field {
            name = "word";
            desc = "32-bit word (extents see the register description).";
            sw = rw;
            hw = r;
        } word[31:0];
    } NODE_W_0068 @ 0x68;

    reg {
        name = "Node word at offset 0x6C";
        desc = "Word 0x6C of the node image. Accessed by: SetChnImgSize (read); SetChnImgSize (write, clears 0x1fff0000, value ORed at bit shift 19/16). Provenance: offset PROVEN, listed masks/shifts PROVEN (lower bounds), role INFERRED from the function name, anything else UNKNOWN/GUESS.";
        field {
            name = "word";
            desc = "32-bit word (extents see the register description).";
            sw = rw;
            hw = r;
        } word[31:0];
    } NODE_W_006C @ 0x6C;

    reg {
        name = "Node word at offset 0x70";
        desc = "Word 0x70 of the node image. Accessed by: SetChnImgSize (read); SetChnImgSize (write, clears 0x1fff0000, value ORed at bit shift 19/16). Provenance: offset PROVEN, listed masks/shifts PROVEN (lower bounds), role INFERRED from the function name, anything else UNKNOWN/GUESS.";
        field {
            name = "word";
            desc = "32-bit word (extents see the register description).";
            sw = rw;
            hw = r;
        } word[31:0];
    } NODE_W_0070 @ 0x70;

    reg {
        name = "Node word at offset 0x74";
        desc = "Word 0x74 of the node image. Accessed by: SetRfrPicSize (read); SetRfrPicSize (write, clears 0x1fff, value ORed at bit shift 19/16). Provenance: offset PROVEN, listed masks/shifts PROVEN (lower bounds), role INFERRED from the function name, anything else UNKNOWN/GUESS.";
        field {
            name = "word";
            desc = "32-bit word (extents see the register description).";
            sw = rw;
            hw = r;
        } word[31:0];
    } NODE_W_0074 @ 0x74;

    reg {
        name = "Node word at offset 0x100";
        desc = "Word 0x100 of the node image. Accessed by: SetCurPicAddr (read); SetCurPicAddr (write, clears 0x1fff, value ORed at bit shift 0/1/2/3/5). Provenance: offset PROVEN, listed masks/shifts PROVEN (lower bounds), role INFERRED from the function name, anything else UNKNOWN/GUESS.";
        field {
            name = "word";
            desc = "32-bit word (extents see the register description).";
            sw = rw;
            hw = r;
        } word[31:0];
    } NODE_W_0100 @ 0x100;

    reg {
        name = "Node word at offset 0x104";
        desc = "Word 0x104 of the node image. Accessed by: SetCurPicAddr (write). Provenance: offset PROVEN, listed masks/shifts PROVEN (lower bounds), role INFERRED from the function name, anything else UNKNOWN/GUESS.";
        field {
            name = "word";
            desc = "32-bit word (extents see the register description).";
            sw = rw;
            hw = r;
        } word[31:0];
    } NODE_W_0104 @ 0x104;

    reg {
        name = "Node word at offset 0x108";
        desc = "Word 0x108 of the node image. Accessed by: SetCurPicAddr (write). Provenance: offset PROVEN, listed masks/shifts PROVEN (lower bounds), role INFERRED from the function name, anything else UNKNOWN/GUESS.";
        field {
            name = "word";
            desc = "32-bit word (extents see the register description).";
            sw = rw;
            hw = r;
        } word[31:0];
    } NODE_W_0108 @ 0x108;

    reg {
        name = "Node word at offset 0x10C";
        desc = "Word 0x10C of the node image. Accessed by: SetCurPicAddr (write). Provenance: offset PROVEN, listed masks/shifts PROVEN (lower bounds), role INFERRED from the function name, anything else UNKNOWN/GUESS.";
        field {
            name = "word";
            desc = "32-bit word (extents see the register description).";
            sw = rw;
            hw = r;
        } word[31:0];
    } NODE_W_010C @ 0x10C;

    reg {
        name = "Node word at offset 0x110";
        desc = "Word 0x110 of the node image. Accessed by: SetCurPicAddr (write). Provenance: offset PROVEN, listed masks/shifts PROVEN (lower bounds), role INFERRED from the function name, anything else UNKNOWN/GUESS.";
        field {
            name = "word";
            desc = "32-bit word (extents see the register description).";
            sw = rw;
            hw = r;
        } word[31:0];
    } NODE_W_0110 @ 0x110;

    reg {
        name = "Node word at offset 0x114";
        desc = "Word 0x114 of the node image. Accessed by: SetCurPicAddr (read); SetCurPicAddr (write). Provenance: offset PROVEN, listed masks/shifts PROVEN (lower bounds), role INFERRED from the function name, anything else UNKNOWN/GUESS.";
        field {
            name = "word";
            desc = "32-bit word (extents see the register description).";
            sw = rw;
            hw = r;
        } word[31:0];
    } NODE_W_0114 @ 0x114;

    reg {
        name = "Node word at offset 0x118";
        desc = "Word 0x118 of the node image. Accessed by: SetLastPicAddr (read); SetLastPicAddr (write, clears 0xffffffef, value ORed at bit shift 0/1/2/3/5/18); SetLastPicAddr (write, clears 0xffffffef, value ORed at bit shift 0/1/2/3/5/18/31). Provenance: offset PROVEN, listed masks/shifts PROVEN (lower bounds), role INFERRED from the function name, anything else UNKNOWN/GUESS.";
        field {
            name = "word";
            desc = "32-bit word (extents see the register description).";
            sw = rw;
            hw = r;
        } word[31:0];
    } NODE_W_0118 @ 0x118;

    reg {
        name = "Node word at offset 0x11C";
        desc = "Word 0x11C of the node image. Accessed by: SetLastPicAddr (write). Provenance: offset PROVEN, listed masks/shifts PROVEN (lower bounds), role INFERRED from the function name, anything else UNKNOWN/GUESS.";
        field {
            name = "word";
            desc = "32-bit word (extents see the register description).";
            sw = rw;
            hw = r;
        } word[31:0];
    } NODE_W_011C @ 0x11C;

    reg {
        name = "Node word at offset 0x120";
        desc = "Word 0x120 of the node image. Accessed by: SetLastPicAddr (write). Provenance: offset PROVEN, listed masks/shifts PROVEN (lower bounds), role INFERRED from the function name, anything else UNKNOWN/GUESS.";
        field {
            name = "word";
            desc = "32-bit word (extents see the register description).";
            sw = rw;
            hw = r;
        } word[31:0];
    } NODE_W_0120 @ 0x120;

    reg {
        name = "Node word at offset 0x124";
        desc = "Word 0x124 of the node image. Accessed by: SetLastPicAddr (write). Provenance: offset PROVEN, listed masks/shifts PROVEN (lower bounds), role INFERRED from the function name, anything else UNKNOWN/GUESS.";
        field {
            name = "word";
            desc = "32-bit word (extents see the register description).";
            sw = rw;
            hw = r;
        } word[31:0];
    } NODE_W_0124 @ 0x124;

    reg {
        name = "Node word at offset 0x128";
        desc = "Word 0x128 of the node image. Accessed by: SetLastPicAddr (write). Provenance: offset PROVEN, listed masks/shifts PROVEN (lower bounds), role INFERRED from the function name, anything else UNKNOWN/GUESS.";
        field {
            name = "word";
            desc = "32-bit word (extents see the register description).";
            sw = rw;
            hw = r;
        } word[31:0];
    } NODE_W_0128 @ 0x128;

    reg {
        name = "Node word at offset 0x12C";
        desc = "Word 0x12C of the node image. Accessed by: SetLastPicAddr (read); SetLastPicAddr (write). Provenance: offset PROVEN, listed masks/shifts PROVEN (lower bounds), role INFERRED from the function name, anything else UNKNOWN/GUESS.";
        field {
            name = "word";
            desc = "32-bit word (extents see the register description).";
            sw = rw;
            hw = r;
        } word[31:0];
    } NODE_W_012C @ 0x12C;

    reg {
        name = "Node word at offset 0x13C";
        desc = "Word 0x13C of the node image. Accessed by: SetMadAddr (write). Provenance: offset PROVEN, listed masks/shifts PROVEN (lower bounds), role INFERRED from the function name, anything else UNKNOWN/GUESS.";
        field {
            name = "word";
            desc = "32-bit word (extents see the register description).";
            sw = rw;
            hw = r;
        } word[31:0];
    } NODE_W_013C @ 0x13C;

    reg {
        name = "Node word at offset 0x140";
        desc = "Word 0x140 of the node image. Accessed by: SetMadAddr (read); SetMadAddr (write, value ORed at bit shift 16). Provenance: offset PROVEN, listed masks/shifts PROVEN (lower bounds), role INFERRED from the function name, anything else UNKNOWN/GUESS.";
        field {
            name = "word";
            desc = "32-bit word (extents see the register description).";
            sw = rw;
            hw = r;
        } word[31:0];
    } NODE_W_0140 @ 0x140;

    reg {
        name = "Node word at offset 0x144";
        desc = "Word 0x144 of the node image. Accessed by: SetChnCtrl (read); SetChnCtrl (write, clears 0x3f, value ORed at bit shift 0/1/2/3/4/5). Provenance: offset PROVEN, listed masks/shifts PROVEN (lower bounds), role INFERRED from the function name, anything else UNKNOWN/GUESS.";
        field {
            name = "word";
            desc = "32-bit word (extents see the register description).";
            sw = rw;
            hw = r;
        } word[31:0];
    } NODE_W_0144 @ 0x144;

    reg {
        name = "Node word at offset 0x148";
        desc = "Word 0x148 of the node image. Accessed by: SetChnPicAddr (write). Provenance: offset PROVEN, listed masks/shifts PROVEN (lower bounds), role INFERRED from the function name, anything else UNKNOWN/GUESS.";
        field {
            name = "word";
            desc = "32-bit word (extents see the register description).";
            sw = rw;
            hw = r;
        } word[31:0];
    } NODE_W_0148 @ 0x148;

    reg {
        name = "Node word at offset 0x14C";
        desc = "Word 0x14C of the node image. Accessed by: SetChnPicAddr (write). Provenance: offset PROVEN, listed masks/shifts PROVEN (lower bounds), role INFERRED from the function name, anything else UNKNOWN/GUESS.";
        field {
            name = "word";
            desc = "32-bit word (extents see the register description).";
            sw = rw;
            hw = r;
        } word[31:0];
    } NODE_W_014C @ 0x14C;

    reg {
        name = "Node word at offset 0x150";
        desc = "Word 0x150 of the node image. Accessed by: SetChnPicAddr (write). Provenance: offset PROVEN, listed masks/shifts PROVEN (lower bounds), role INFERRED from the function name, anything else UNKNOWN/GUESS.";
        field {
            name = "word";
            desc = "32-bit word (extents see the register description).";
            sw = rw;
            hw = r;
        } word[31:0];
    } NODE_W_0150 @ 0x150;

    reg {
        name = "Node word at offset 0x154";
        desc = "Word 0x154 of the node image. Accessed by: SetChnPicAddr (write). Provenance: offset PROVEN, listed masks/shifts PROVEN (lower bounds), role INFERRED from the function name, anything else UNKNOWN/GUESS.";
        field {
            name = "word";
            desc = "32-bit word (extents see the register description).";
            sw = rw;
            hw = r;
        } word[31:0];
    } NODE_W_0154 @ 0x154;

    reg {
        name = "Node word at offset 0x158";
        desc = "Word 0x158 of the node image. Accessed by: SetChnPicAddr (read); SetChnPicAddr (write). Provenance: offset PROVEN, listed masks/shifts PROVEN (lower bounds), role INFERRED from the function name, anything else UNKNOWN/GUESS.";
        field {
            name = "word";
            desc = "32-bit word (extents see the register description).";
            sw = rw;
            hw = r;
        } word[31:0];
    } NODE_W_0158 @ 0x158;

    reg {
        name = "Node word at offset 0x15C";
        desc = "Word 0x15C of the node image. Accessed by: SetChnCtrl (read); SetChnCtrl (write, clears 0x3f, value ORed at bit shift 0/1/2/3/4/5). Provenance: offset PROVEN, listed masks/shifts PROVEN (lower bounds), role INFERRED from the function name, anything else UNKNOWN/GUESS.";
        field {
            name = "word";
            desc = "32-bit word (extents see the register description).";
            sw = rw;
            hw = r;
        } word[31:0];
    } NODE_W_015C @ 0x15C;

    reg {
        name = "Node word at offset 0x160";
        desc = "Word 0x160 of the node image. Accessed by: SetChnPicAddr (write). Provenance: offset PROVEN, listed masks/shifts PROVEN (lower bounds), role INFERRED from the function name, anything else UNKNOWN/GUESS.";
        field {
            name = "word";
            desc = "32-bit word (extents see the register description).";
            sw = rw;
            hw = r;
        } word[31:0];
    } NODE_W_0160 @ 0x160;

    reg {
        name = "Node word at offset 0x164";
        desc = "Word 0x164 of the node image. Accessed by: SetChnPicAddr (write). Provenance: offset PROVEN, listed masks/shifts PROVEN (lower bounds), role INFERRED from the function name, anything else UNKNOWN/GUESS.";
        field {
            name = "word";
            desc = "32-bit word (extents see the register description).";
            sw = rw;
            hw = r;
        } word[31:0];
    } NODE_W_0164 @ 0x164;

    reg {
        name = "Node word at offset 0x168";
        desc = "Word 0x168 of the node image. Accessed by: SetChnPicAddr (write). Provenance: offset PROVEN, listed masks/shifts PROVEN (lower bounds), role INFERRED from the function name, anything else UNKNOWN/GUESS.";
        field {
            name = "word";
            desc = "32-bit word (extents see the register description).";
            sw = rw;
            hw = r;
        } word[31:0];
    } NODE_W_0168 @ 0x168;

    reg {
        name = "Node word at offset 0x16C";
        desc = "Word 0x16C of the node image. Accessed by: SetChnPicAddr (write). Provenance: offset PROVEN, listed masks/shifts PROVEN (lower bounds), role INFERRED from the function name, anything else UNKNOWN/GUESS.";
        field {
            name = "word";
            desc = "32-bit word (extents see the register description).";
            sw = rw;
            hw = r;
        } word[31:0];
    } NODE_W_016C @ 0x16C;

    reg {
        name = "Node word at offset 0x170";
        desc = "Word 0x170 of the node image. Accessed by: SetChnPicAddr (read); SetChnPicAddr (write). Provenance: offset PROVEN, listed masks/shifts PROVEN (lower bounds), role INFERRED from the function name, anything else UNKNOWN/GUESS.";
        field {
            name = "word";
            desc = "32-bit word (extents see the register description).";
            sw = rw;
            hw = r;
        } word[31:0];
    } NODE_W_0170 @ 0x170;

    reg {
        name = "Node word at offset 0x174";
        desc = "Word 0x174 of the node image. Accessed by: SetChnCtrl (read); SetChnCtrl (write, clears 0x30, value ORed at bit shift 4/5). Provenance: offset PROVEN, listed masks/shifts PROVEN (lower bounds), role INFERRED from the function name, anything else UNKNOWN/GUESS.";
        field {
            name = "word";
            desc = "32-bit word (extents see the register description).";
            sw = rw;
            hw = r;
        } word[31:0];
    } NODE_W_0174 @ 0x174;

    reg {
        name = "Node word at offset 0x180";
        desc = "Word 0x180 of the node image. Accessed by: SetChnPicAddr (write). Provenance: offset PROVEN, listed masks/shifts PROVEN (lower bounds), role INFERRED from the function name, anything else UNKNOWN/GUESS.";
        field {
            name = "word";
            desc = "32-bit word (extents see the register description).";
            sw = rw;
            hw = r;
        } word[31:0];
    } NODE_W_0180 @ 0x180;

    reg {
        name = "Node word at offset 0x184";
        desc = "Word 0x184 of the node image. Accessed by: SetChnPicAddr (write). Provenance: offset PROVEN, listed masks/shifts PROVEN (lower bounds), role INFERRED from the function name, anything else UNKNOWN/GUESS.";
        field {
            name = "word";
            desc = "32-bit word (extents see the register description).";
            sw = rw;
            hw = r;
        } word[31:0];
    } NODE_W_0184 @ 0x184;

    reg {
        name = "Node word at offset 0x188";
        desc = "Word 0x188 of the node image. Accessed by: SetChnPicAddr (read); SetChnPicAddr (write). Provenance: offset PROVEN, listed masks/shifts PROVEN (lower bounds), role INFERRED from the function name, anything else UNKNOWN/GUESS.";
        field {
            name = "word";
            desc = "32-bit word (extents see the register description).";
            sw = rw;
            hw = r;
        } word[31:0];
    } NODE_W_0188 @ 0x188;

    reg {
        name = "Node word at offset 0x18C";
        desc = "Word 0x18C of the node image. Accessed by: SetChnCtrl (read); SetChnCtrl (write, clears 0x3f, value ORed at bit shift 0/1/2/3/4/5). Provenance: offset PROVEN, listed masks/shifts PROVEN (lower bounds), role INFERRED from the function name, anything else UNKNOWN/GUESS.";
        field {
            name = "word";
            desc = "32-bit word (extents see the register description).";
            sw = rw;
            hw = r;
        } word[31:0];
    } NODE_W_018C @ 0x18C;

    reg {
        name = "Node word at offset 0x190";
        desc = "Word 0x190 of the node image. Accessed by: SetChnPicAddr (write). Provenance: offset PROVEN, listed masks/shifts PROVEN (lower bounds), role INFERRED from the function name, anything else UNKNOWN/GUESS.";
        field {
            name = "word";
            desc = "32-bit word (extents see the register description).";
            sw = rw;
            hw = r;
        } word[31:0];
    } NODE_W_0190 @ 0x190;

    reg {
        name = "Node word at offset 0x194";
        desc = "Word 0x194 of the node image. Accessed by: SetChnPicAddr (write). Provenance: offset PROVEN, listed masks/shifts PROVEN (lower bounds), role INFERRED from the function name, anything else UNKNOWN/GUESS.";
        field {
            name = "word";
            desc = "32-bit word (extents see the register description).";
            sw = rw;
            hw = r;
        } word[31:0];
    } NODE_W_0194 @ 0x194;

    reg {
        name = "Node word at offset 0x198";
        desc = "Word 0x198 of the node image. Accessed by: SetChnPicAddr (write). Provenance: offset PROVEN, listed masks/shifts PROVEN (lower bounds), role INFERRED from the function name, anything else UNKNOWN/GUESS.";
        field {
            name = "word";
            desc = "32-bit word (extents see the register description).";
            sw = rw;
            hw = r;
        } word[31:0];
    } NODE_W_0198 @ 0x198;

    reg {
        name = "Node word at offset 0x19C";
        desc = "Word 0x19C of the node image. Accessed by: SetChnPicAddr (write). Provenance: offset PROVEN, listed masks/shifts PROVEN (lower bounds), role INFERRED from the function name, anything else UNKNOWN/GUESS.";
        field {
            name = "word";
            desc = "32-bit word (extents see the register description).";
            sw = rw;
            hw = r;
        } word[31:0];
    } NODE_W_019C @ 0x19C;

    reg {
        name = "Node word at offset 0x1A0";
        desc = "Word 0x1A0 of the node image. Accessed by: SetChnPicAddr (read); SetChnPicAddr (write). Provenance: offset PROVEN, listed masks/shifts PROVEN (lower bounds), role INFERRED from the function name, anything else UNKNOWN/GUESS.";
        field {
            name = "word";
            desc = "32-bit word (extents see the register description).";
            sw = rw;
            hw = r;
        } word[31:0];
    } NODE_W_01A0 @ 0x1A0;

    reg {
        name = "Node word at offset 0x1A4";
        desc = "Word 0x1A4 of the node image. Accessed by: SetRfrPicAddr (read); SetRfrPicAddr (write, clears 0x1, value ORed at bit shift 0). Provenance: offset PROVEN, listed masks/shifts PROVEN (lower bounds), role INFERRED from the function name, anything else UNKNOWN/GUESS.";
        field {
            name = "word";
            desc = "32-bit word (extents see the register description).";
            sw = rw;
            hw = r;
        } word[31:0];
    } NODE_W_01A4 @ 0x1A4;

    reg {
        name = "Node word at offset 0x1A8";
        desc = "Word 0x1A8 of the node image. Accessed by: SetRfrPicAddr (write). Provenance: offset PROVEN, listed masks/shifts PROVEN (lower bounds), role INFERRED from the function name, anything else UNKNOWN/GUESS.";
        field {
            name = "word";
            desc = "32-bit word (extents see the register description).";
            sw = rw;
            hw = r;
        } word[31:0];
    } NODE_W_01A8 @ 0x1A8;

    reg {
        name = "Node word at offset 0x1AC";
        desc = "Word 0x1AC of the node image. Accessed by: SetRfrPicAddr (write). Provenance: offset PROVEN, listed masks/shifts PROVEN (lower bounds), role INFERRED from the function name, anything else UNKNOWN/GUESS.";
        field {
            name = "word";
            desc = "32-bit word (extents see the register description).";
            sw = rw;
            hw = r;
        } word[31:0];
    } NODE_W_01AC @ 0x1AC;

    reg {
        name = "Node word at offset 0x1B0";
        desc = "Word 0x1B0 of the node image. Accessed by: SetRfrPicAddr (write). Provenance: offset PROVEN, listed masks/shifts PROVEN (lower bounds), role INFERRED from the function name, anything else UNKNOWN/GUESS.";
        field {
            name = "word";
            desc = "32-bit word (extents see the register description).";
            sw = rw;
            hw = r;
        } word[31:0];
    } NODE_W_01B0 @ 0x1B0;

    reg {
        name = "Node word at offset 0x1B4";
        desc = "Word 0x1B4 of the node image. Accessed by: SetRfrPicAddr (write). Provenance: offset PROVEN, listed masks/shifts PROVEN (lower bounds), role INFERRED from the function name, anything else UNKNOWN/GUESS.";
        field {
            name = "word";
            desc = "32-bit word (extents see the register description).";
            sw = rw;
            hw = r;
        } word[31:0];
    } NODE_W_01B4 @ 0x1B4;

    reg {
        name = "Node word at offset 0x1B8";
        desc = "Word 0x1B8 of the node image. Accessed by: SetRfrPicAddr (read); SetRfrPicAddr (write). Provenance: offset PROVEN, listed masks/shifts PROVEN (lower bounds), role INFERRED from the function name, anything else UNKNOWN/GUESS.";
        field {
            name = "word";
            desc = "32-bit word (extents see the register description).";
            sw = rw;
            hw = r;
        } word[31:0];
    } NODE_W_01B8 @ 0x1B8;

    reg {
        name = "Node word at offset 0x1BC";
        desc = "Word 0x1BC of the node image. Accessed by: SetMadAddr (write). Provenance: offset PROVEN, listed masks/shifts PROVEN (lower bounds), role INFERRED from the function name, anything else UNKNOWN/GUESS.";
        field {
            name = "word";
            desc = "32-bit word (extents see the register description).";
            sw = rw;
            hw = r;
        } word[31:0];
    } NODE_W_01BC @ 0x1BC;

    reg {
        name = "Node word at offset 0x1C8";
        desc = "Word 0x1C8 of the node image. Accessed by: SetLowDelayAddr (write). Provenance: offset PROVEN, listed masks/shifts PROVEN (lower bounds), role INFERRED from the function name, anything else UNKNOWN/GUESS.";
        field {
            name = "word";
            desc = "32-bit word (extents see the register description).";
            sw = rw;
            hw = r;
        } word[31:0];
    } NODE_W_01C8 @ 0x1C8;

    reg {
        name = "Node word at offset 0x1CC";
        desc = "Word 0x1CC of the node image. Accessed by: SetLowDelayAddr (write). Provenance: offset PROVEN, listed masks/shifts PROVEN (lower bounds), role INFERRED from the function name, anything else UNKNOWN/GUESS.";
        field {
            name = "word";
            desc = "32-bit word (extents see the register description).";
            sw = rw;
            hw = r;
        } word[31:0];
    } NODE_W_01CC @ 0x1CC;

    reg {
        name = "Node word at offset 0x1D0";
        desc = "Word 0x1D0 of the node image. Accessed by: SetLowDelayAddr (write). Provenance: offset PROVEN, listed masks/shifts PROVEN (lower bounds), role INFERRED from the function name, anything else UNKNOWN/GUESS.";
        field {
            name = "word";
            desc = "32-bit word (extents see the register description).";
            sw = rw;
            hw = r;
        } word[31:0];
    } NODE_W_01D0 @ 0x1D0;

    reg {
        name = "Node word at offset 0x1F4";
        desc = "Word 0x1F4 of the node image. Accessed by: SetNodeID (write). Provenance: offset PROVEN, listed masks/shifts PROVEN (lower bounds), role INFERRED from the function name, anything else UNKNOWN/GUESS.";
        field {
            name = "word";
            desc = "32-bit word (extents see the register description).";
            sw = rw;
            hw = r;
        } word[31:0];
    } NODE_W_01F4 @ 0x1F4;

    reg {
        name = "Node word at offset 0x1FC";
        desc = "Word 0x1FC of the node image. Accessed by: SetMask (write). Provenance: offset PROVEN, listed masks/shifts PROVEN (lower bounds), role INFERRED from the function name, anything else UNKNOWN/GUESS.";
        field {
            name = "word";
            desc = "32-bit word (extents see the register description).";
            sw = rw;
            hw = r;
        } word[31:0];
    } NODE_W_01FC @ 0x1FC;

    reg {
        name = "Node word at offset 0x200";
        desc = "Word 0x200 of the node image. Accessed by: SetChnSclCoeff (write, constant 0x557). Provenance: offset PROVEN, listed masks/shifts PROVEN (lower bounds), role INFERRED from the function name, anything else UNKNOWN/GUESS.";
        field {
            name = "word";
            desc = "32-bit word (extents see the register description).";
            sw = rw;
            hw = r;
        } word[31:0];
    } NODE_W_0200 @ 0x200;

    reg {
        name = "Node word at offset 0x204";
        desc = "Word 0x204 of the node image. Accessed by: SetChnSclCoeff (write). Provenance: offset PROVEN, listed masks/shifts PROVEN (lower bounds), role INFERRED from the function name, anything else UNKNOWN/GUESS.";
        field {
            name = "word";
            desc = "32-bit word (extents see the register description).";
            sw = rw;
            hw = r;
        } word[31:0];
    } NODE_W_0204 @ 0x204;

    reg {
        name = "Node word at offset 0x208";
        desc = "Word 0x208 of the node image. Accessed by: SetChnSclCoeff (write). Provenance: offset PROVEN, listed masks/shifts PROVEN (lower bounds), role INFERRED from the function name, anything else UNKNOWN/GUESS.";
        field {
            name = "word";
            desc = "32-bit word (extents see the register description).";
            sw = rw;
            hw = r;
        } word[31:0];
    } NODE_W_0208 @ 0x208;

    reg {
        name = "Node word at offset 0x20C";
        desc = "Word 0x20C of the node image. Accessed by: SetChnSclCoeff (write). Provenance: offset PROVEN, listed masks/shifts PROVEN (lower bounds), role INFERRED from the function name, anything else UNKNOWN/GUESS.";
        field {
            name = "word";
            desc = "32-bit word (extents see the register description).";
            sw = rw;
            hw = r;
        } word[31:0];
    } NODE_W_020C @ 0x20C;

    reg {
        name = "Node word at offset 0x210";
        desc = "Word 0x210 of the node image. Accessed by: SetChnSclCoeff (write, constant 0x557). Provenance: offset PROVEN, listed masks/shifts PROVEN (lower bounds), role INFERRED from the function name, anything else UNKNOWN/GUESS.";
        field {
            name = "word";
            desc = "32-bit word (extents see the register description).";
            sw = rw;
            hw = r;
        } word[31:0];
    } NODE_W_0210 @ 0x210;

    reg {
        name = "Node word at offset 0x214";
        desc = "Word 0x214 of the node image. Accessed by: SetChnSclCoeff (write). Provenance: offset PROVEN, listed masks/shifts PROVEN (lower bounds), role INFERRED from the function name, anything else UNKNOWN/GUESS.";
        field {
            name = "word";
            desc = "32-bit word (extents see the register description).";
            sw = rw;
            hw = r;
        } word[31:0];
    } NODE_W_0214 @ 0x214;

    reg {
        name = "Node word at offset 0x218";
        desc = "Word 0x218 of the node image. Accessed by: SetChnSclCoeff (write). Provenance: offset PROVEN, listed masks/shifts PROVEN (lower bounds), role INFERRED from the function name, anything else UNKNOWN/GUESS.";
        field {
            name = "word";
            desc = "32-bit word (extents see the register description).";
            sw = rw;
            hw = r;
        } word[31:0];
    } NODE_W_0218 @ 0x218;

    reg {
        name = "Node word at offset 0x21C";
        desc = "Word 0x21C of the node image. Accessed by: SetChnSclCoeff (write). Provenance: offset PROVEN, listed masks/shifts PROVEN (lower bounds), role INFERRED from the function name, anything else UNKNOWN/GUESS.";
        field {
            name = "word";
            desc = "32-bit word (extents see the register description).";
            sw = rw;
            hw = r;
        } word[31:0];
    } NODE_W_021C @ 0x21C;

    reg {
        name = "Node word at offset 0x220";
        desc = "Word 0x220 of the node image. Accessed by: SetChnSclCoeff (write, constant 0x557). Provenance: offset PROVEN, listed masks/shifts PROVEN (lower bounds), role INFERRED from the function name, anything else UNKNOWN/GUESS.";
        field {
            name = "word";
            desc = "32-bit word (extents see the register description).";
            sw = rw;
            hw = r;
        } word[31:0];
    } NODE_W_0220 @ 0x220;

    reg {
        name = "Node word at offset 0x224";
        desc = "Word 0x224 of the node image. Accessed by: SetChnSclCoeff (write). Provenance: offset PROVEN, listed masks/shifts PROVEN (lower bounds), role INFERRED from the function name, anything else UNKNOWN/GUESS.";
        field {
            name = "word";
            desc = "32-bit word (extents see the register description).";
            sw = rw;
            hw = r;
        } word[31:0];
    } NODE_W_0224 @ 0x224;

    reg {
        name = "Node word at offset 0x228";
        desc = "Word 0x228 of the node image. Accessed by: SetChnSclCoeff (write). Provenance: offset PROVEN, listed masks/shifts PROVEN (lower bounds), role INFERRED from the function name, anything else UNKNOWN/GUESS.";
        field {
            name = "word";
            desc = "32-bit word (extents see the register description).";
            sw = rw;
            hw = r;
        } word[31:0];
    } NODE_W_0228 @ 0x228;

    reg {
        name = "Node word at offset 0x22C";
        desc = "Word 0x22C of the node image. Accessed by: SetChnSclCoeff (write). Provenance: offset PROVEN, listed masks/shifts PROVEN (lower bounds), role INFERRED from the function name, anything else UNKNOWN/GUESS.";
        field {
            name = "word";
            desc = "32-bit word (extents see the register description).";
            sw = rw;
            hw = r;
        } word[31:0];
    } NODE_W_022C @ 0x22C;

    reg {
        name = "Node word at offset 0x230";
        desc = "Word 0x230 of the node image. Accessed by: SetChnSclCoeff (write, constant 0x557). Provenance: offset PROVEN, listed masks/shifts PROVEN (lower bounds), role INFERRED from the function name, anything else UNKNOWN/GUESS.";
        field {
            name = "word";
            desc = "32-bit word (extents see the register description).";
            sw = rw;
            hw = r;
        } word[31:0];
    } NODE_W_0230 @ 0x230;

    reg {
        name = "Node word at offset 0x234";
        desc = "Word 0x234 of the node image. Accessed by: SetChnSclCoeff (write). Provenance: offset PROVEN, listed masks/shifts PROVEN (lower bounds), role INFERRED from the function name, anything else UNKNOWN/GUESS.";
        field {
            name = "word";
            desc = "32-bit word (extents see the register description).";
            sw = rw;
            hw = r;
        } word[31:0];
    } NODE_W_0234 @ 0x234;

    reg {
        name = "Node word at offset 0x238";
        desc = "Word 0x238 of the node image. Accessed by: SetChnSclCoeff (write). Provenance: offset PROVEN, listed masks/shifts PROVEN (lower bounds), role INFERRED from the function name, anything else UNKNOWN/GUESS.";
        field {
            name = "word";
            desc = "32-bit word (extents see the register description).";
            sw = rw;
            hw = r;
        } word[31:0];
    } NODE_W_0238 @ 0x238;

    reg {
        name = "Node word at offset 0x23C";
        desc = "Word 0x23C of the node image. Accessed by: SetChnSclCoeff (write). Provenance: offset PROVEN, listed masks/shifts PROVEN (lower bounds), role INFERRED from the function name, anything else UNKNOWN/GUESS.";
        field {
            name = "word";
            desc = "32-bit word (extents see the register description).";
            sw = rw;
            hw = r;
        } word[31:0];
    } NODE_W_023C @ 0x23C;

    reg {
        name = "Node word at offset 0x240";
        desc = "Word 0x240 of the node image. Accessed by: SetZmeLoadAddr (write). Provenance: offset PROVEN, listed masks/shifts PROVEN (lower bounds), role INFERRED from the function name, anything else UNKNOWN/GUESS.";
        field {
            name = "word";
            desc = "32-bit word (extents see the register description).";
            sw = rw;
            hw = r;
        } word[31:0];
    } NODE_W_0240 @ 0x240;

    reg {
        name = "Node word at offset 0x244";
        desc = "Word 0x244 of the node image. Accessed by: SetShbdLoadAddr (write). Provenance: offset PROVEN, listed masks/shifts PROVEN (lower bounds), role INFERRED from the function name, anything else UNKNOWN/GUESS.";
        field {
            name = "word";
            desc = "32-bit word (extents see the register description).";
            sw = rw;
            hw = r;
        } word[31:0];
    } NODE_W_0244 @ 0x244;

    reg {
        name = "Node word at offset 0x248";
        desc = "Word 0x248 of the node image. Accessed by: SetNrLoadAddr (write). Provenance: offset PROVEN, listed masks/shifts PROVEN (lower bounds), role INFERRED from the function name, anything else UNKNOWN/GUESS.";
        field {
            name = "word";
            desc = "32-bit word (extents see the register description).";
            sw = rw;
            hw = r;
        } word[31:0];
    } NODE_W_0248 @ 0x248;

    reg {
        name = "Node word at offset 0x270";
        desc = "Word 0x270 of the node image. Accessed by: SetChnLowDelayAttr (read); SetChnLowDelayAttr (write, clears 0xfff0000, value ORed at bit shift 20); SetChnLowDelayAttr (write, clears 0xfff0000, value ORed at bit shift 20/16). Provenance: offset PROVEN, listed masks/shifts PROVEN (lower bounds), role INFERRED from the function name, anything else UNKNOWN/GUESS.";
        field {
            name = "word";
            desc = "32-bit word (extents see the register description).";
            sw = rw;
            hw = r;
        } word[31:0];
    } NODE_W_0270 @ 0x270;

    reg {
        name = "Node word at offset 0x274";
        desc = "Word 0x274 of the node image. Accessed by: SetChnLowDelayAttr (read); SetChnLowDelayAttr (write, clears 0x3f000000, value ORed at bit shift 20/24/26); SetChnLowDelayAttr (write, clears 0x3f000000, value ORed at bit shift 20/24/26/28); SetChnLowDelayAttr (write, clears 0x3f000000, value ORed at bit shift 20/26/28). Provenance: offset PROVEN, listed masks/shifts PROVEN (lower bounds), role INFERRED from the function name, anything else UNKNOWN/GUESS.";
        field {
            name = "word";
            desc = "32-bit word (extents see the register description).";
            sw = rw;
            hw = r;
        } word[31:0];
    } NODE_W_0274 @ 0x274;

    reg {
        name = "Node word at offset 0x2FC";
        desc = "Word 0x2FC of the node image. Accessed by: SetNext (write). Provenance: offset PROVEN, listed masks/shifts PROVEN (lower bounds), role INFERRED from the function name, anything else UNKNOWN/GUESS.";
        field {
            name = "word";
            desc = "32-bit word (extents see the register description).";
            sw = rw;
            hw = r;
        } word[31:0];
    } NODE_W_02FC @ 0x2FC;

    reg {
        name = "Node word at offset 0x31C";
        desc = "Word 0x31C of the node image. Accessed by: SetTimeOut (write). Provenance: offset PROVEN, listed masks/shifts PROVEN (lower bounds), role INFERRED from the function name, anything else UNKNOWN/GUESS.";
        field {
            name = "word";
            desc = "32-bit word (extents see the register description).";
            sw = rw;
            hw = r;
        } word[31:0];
    } NODE_W_031C @ 0x31C;

    reg {
        name = "Node word at offset 0x2000";
        desc = "Word 0x2000 of the node image. Accessed by: SetChnSclCfg (write, value ORed at bit shift 0). Provenance: offset PROVEN, listed masks/shifts PROVEN (lower bounds), role INFERRED from the function name, anything else UNKNOWN/GUESS.";
        field {
            name = "word";
            desc = "32-bit word (extents see the register description).";
            sw = rw;
            hw = r;
        } word[31:0];
    } NODE_W_2000 @ 0x2000;

    reg {
        name = "Node word at offset 0x2004";
        desc = "Word 0x2004 of the node image. Accessed by: SetChnSclCfg (write). Provenance: offset PROVEN, listed masks/shifts PROVEN (lower bounds), role INFERRED from the function name, anything else UNKNOWN/GUESS.";
        field {
            name = "word";
            desc = "32-bit word (extents see the register description).";
            sw = rw;
            hw = r;
        } word[31:0];
    } NODE_W_2004 @ 0x2004;

    reg {
        name = "Node word at offset 0x2008";
        desc = "Word 0x2008 of the node image. Accessed by: SetChnSclCfg (write). Provenance: offset PROVEN, listed masks/shifts PROVEN (lower bounds), role INFERRED from the function name, anything else UNKNOWN/GUESS.";
        field {
            name = "word";
            desc = "32-bit word (extents see the register description).";
            sw = rw;
            hw = r;
        } word[31:0];
    } NODE_W_2008 @ 0x2008;

    reg {
        name = "Node word at offset 0x200C";
        desc = "Word 0x200C of the node image. Accessed by: SetChnSclCfg (write, value ORed at bit shift 30). Provenance: offset PROVEN, listed masks/shifts PROVEN (lower bounds), role INFERRED from the function name, anything else UNKNOWN/GUESS.";
        field {
            name = "word";
            desc = "32-bit word (extents see the register description).";
            sw = rw;
            hw = r;
        } word[31:0];
    } NODE_W_200C @ 0x200C;

    reg {
        name = "Node word at offset 0x2010";
        desc = "Word 0x2010 of the node image. Accessed by: SetChnSclCfg (write). Provenance: offset PROVEN, listed masks/shifts PROVEN (lower bounds), role INFERRED from the function name, anything else UNKNOWN/GUESS.";
        field {
            name = "word";
            desc = "32-bit word (extents see the register description).";
            sw = rw;
            hw = r;
        } word[31:0];
    } NODE_W_2010 @ 0x2010;

    reg {
        name = "Node word at offset 0x2014";
        desc = "Word 0x2014 of the node image. Accessed by: SetChnSclCfg (write). Provenance: offset PROVEN, listed masks/shifts PROVEN (lower bounds), role INFERRED from the function name, anything else UNKNOWN/GUESS.";
        field {
            name = "word";
            desc = "32-bit word (extents see the register description).";
            sw = rw;
            hw = r;
        } word[31:0];
    } NODE_W_2014 @ 0x2014;

    reg {
        name = "Node word at offset 0x2018";
        desc = "Word 0x2018 of the node image. Accessed by: SetChnSclCfg (write). Provenance: offset PROVEN, listed masks/shifts PROVEN (lower bounds), role INFERRED from the function name, anything else UNKNOWN/GUESS.";
        field {
            name = "word";
            desc = "32-bit word (extents see the register description).";
            sw = rw;
            hw = r;
        } word[31:0];
    } NODE_W_2018 @ 0x2018;

    reg {
        name = "Node word at offset 0x2040";
        desc = "Word 0x2040 of the node image. Accessed by: SetChnSclCfg (write, value ORed at bit shift 0). Provenance: offset PROVEN, listed masks/shifts PROVEN (lower bounds), role INFERRED from the function name, anything else UNKNOWN/GUESS.";
        field {
            name = "word";
            desc = "32-bit word (extents see the register description).";
            sw = rw;
            hw = r;
        } word[31:0];
    } NODE_W_2040 @ 0x2040;

    reg {
        name = "Node word at offset 0x2044";
        desc = "Word 0x2044 of the node image. Accessed by: SetChnSclCfg (write). Provenance: offset PROVEN, listed masks/shifts PROVEN (lower bounds), role INFERRED from the function name, anything else UNKNOWN/GUESS.";
        field {
            name = "word";
            desc = "32-bit word (extents see the register description).";
            sw = rw;
            hw = r;
        } word[31:0];
    } NODE_W_2044 @ 0x2044;

    reg {
        name = "Node word at offset 0x2048";
        desc = "Word 0x2048 of the node image. Accessed by: SetChnSclCfg (write). Provenance: offset PROVEN, listed masks/shifts PROVEN (lower bounds), role INFERRED from the function name, anything else UNKNOWN/GUESS.";
        field {
            name = "word";
            desc = "32-bit word (extents see the register description).";
            sw = rw;
            hw = r;
        } word[31:0];
    } NODE_W_2048 @ 0x2048;

    reg {
        name = "Node word at offset 0x204C";
        desc = "Word 0x204C of the node image. Accessed by: SetChnSclCfg (write, value ORed at bit shift 30). Provenance: offset PROVEN, listed masks/shifts PROVEN (lower bounds), role INFERRED from the function name, anything else UNKNOWN/GUESS.";
        field {
            name = "word";
            desc = "32-bit word (extents see the register description).";
            sw = rw;
            hw = r;
        } word[31:0];
    } NODE_W_204C @ 0x204C;

    reg {
        name = "Node word at offset 0x2050";
        desc = "Word 0x2050 of the node image. Accessed by: SetChnSclCfg (write). Provenance: offset PROVEN, listed masks/shifts PROVEN (lower bounds), role INFERRED from the function name, anything else UNKNOWN/GUESS.";
        field {
            name = "word";
            desc = "32-bit word (extents see the register description).";
            sw = rw;
            hw = r;
        } word[31:0];
    } NODE_W_2050 @ 0x2050;

    reg {
        name = "Node word at offset 0x2054";
        desc = "Word 0x2054 of the node image. Accessed by: SetChnSclCfg (write). Provenance: offset PROVEN, listed masks/shifts PROVEN (lower bounds), role INFERRED from the function name, anything else UNKNOWN/GUESS.";
        field {
            name = "word";
            desc = "32-bit word (extents see the register description).";
            sw = rw;
            hw = r;
        } word[31:0];
    } NODE_W_2054 @ 0x2054;

    reg {
        name = "Node word at offset 0x2058";
        desc = "Word 0x2058 of the node image. Accessed by: SetChnSclCfg (write). Provenance: offset PROVEN, listed masks/shifts PROVEN (lower bounds), role INFERRED from the function name, anything else UNKNOWN/GUESS.";
        field {
            name = "word";
            desc = "32-bit word (extents see the register description).";
            sw = rw;
            hw = r;
        } word[31:0];
    } NODE_W_2058 @ 0x2058;

    reg {
        name = "Node word at offset 0x2080";
        desc = "Word 0x2080 of the node image. Accessed by: SetChnSclCfg (write, value ORed at bit shift 0). Provenance: offset PROVEN, listed masks/shifts PROVEN (lower bounds), role INFERRED from the function name, anything else UNKNOWN/GUESS.";
        field {
            name = "word";
            desc = "32-bit word (extents see the register description).";
            sw = rw;
            hw = r;
        } word[31:0];
    } NODE_W_2080 @ 0x2080;

    reg {
        name = "Node word at offset 0x2084";
        desc = "Word 0x2084 of the node image. Accessed by: SetChnSclCfg (write). Provenance: offset PROVEN, listed masks/shifts PROVEN (lower bounds), role INFERRED from the function name, anything else UNKNOWN/GUESS.";
        field {
            name = "word";
            desc = "32-bit word (extents see the register description).";
            sw = rw;
            hw = r;
        } word[31:0];
    } NODE_W_2084 @ 0x2084;

    reg {
        name = "Node word at offset 0x2088";
        desc = "Word 0x2088 of the node image. Accessed by: SetChnSclCfg (write). Provenance: offset PROVEN, listed masks/shifts PROVEN (lower bounds), role INFERRED from the function name, anything else UNKNOWN/GUESS.";
        field {
            name = "word";
            desc = "32-bit word (extents see the register description).";
            sw = rw;
            hw = r;
        } word[31:0];
    } NODE_W_2088 @ 0x2088;

    reg {
        name = "Node word at offset 0x208C";
        desc = "Word 0x208C of the node image. Accessed by: SetChnSclCfg (write, value ORed at bit shift 30). Provenance: offset PROVEN, listed masks/shifts PROVEN (lower bounds), role INFERRED from the function name, anything else UNKNOWN/GUESS.";
        field {
            name = "word";
            desc = "32-bit word (extents see the register description).";
            sw = rw;
            hw = r;
        } word[31:0];
    } NODE_W_208C @ 0x208C;

    reg {
        name = "Node word at offset 0x2090";
        desc = "Word 0x2090 of the node image. Accessed by: SetChnSclCfg (write). Provenance: offset PROVEN, listed masks/shifts PROVEN (lower bounds), role INFERRED from the function name, anything else UNKNOWN/GUESS.";
        field {
            name = "word";
            desc = "32-bit word (extents see the register description).";
            sw = rw;
            hw = r;
        } word[31:0];
    } NODE_W_2090 @ 0x2090;

    reg {
        name = "Node word at offset 0x2094";
        desc = "Word 0x2094 of the node image. Accessed by: SetChnSclCfg (write). Provenance: offset PROVEN, listed masks/shifts PROVEN (lower bounds), role INFERRED from the function name, anything else UNKNOWN/GUESS.";
        field {
            name = "word";
            desc = "32-bit word (extents see the register description).";
            sw = rw;
            hw = r;
        } word[31:0];
    } NODE_W_2094 @ 0x2094;

    reg {
        name = "Node word at offset 0x2098";
        desc = "Word 0x2098 of the node image. Accessed by: SetChnSclCfg (write). Provenance: offset PROVEN, listed masks/shifts PROVEN (lower bounds), role INFERRED from the function name, anything else UNKNOWN/GUESS.";
        field {
            name = "word";
            desc = "32-bit word (extents see the register description).";
            sw = rw;
            hw = r;
        } word[31:0];
    } NODE_W_2098 @ 0x2098;

    reg {
        name = "Node word at offset 0x20C0";
        desc = "Word 0x20C0 of the node image. Accessed by: SetChnSclCfg (write, value ORed at bit shift 0). Provenance: offset PROVEN, listed masks/shifts PROVEN (lower bounds), role INFERRED from the function name, anything else UNKNOWN/GUESS.";
        field {
            name = "word";
            desc = "32-bit word (extents see the register description).";
            sw = rw;
            hw = r;
        } word[31:0];
    } NODE_W_20C0 @ 0x20C0;

    reg {
        name = "Node word at offset 0x20C4";
        desc = "Word 0x20C4 of the node image. Accessed by: SetChnSclCfg (write). Provenance: offset PROVEN, listed masks/shifts PROVEN (lower bounds), role INFERRED from the function name, anything else UNKNOWN/GUESS.";
        field {
            name = "word";
            desc = "32-bit word (extents see the register description).";
            sw = rw;
            hw = r;
        } word[31:0];
    } NODE_W_20C4 @ 0x20C4;

    reg {
        name = "Node word at offset 0x20C8";
        desc = "Word 0x20C8 of the node image. Accessed by: SetChnSclCfg (write). Provenance: offset PROVEN, listed masks/shifts PROVEN (lower bounds), role INFERRED from the function name, anything else UNKNOWN/GUESS.";
        field {
            name = "word";
            desc = "32-bit word (extents see the register description).";
            sw = rw;
            hw = r;
        } word[31:0];
    } NODE_W_20C8 @ 0x20C8;

    reg {
        name = "Node word at offset 0x20CC";
        desc = "Word 0x20CC of the node image. Accessed by: SetChnSclCfg (read); SetChnSclCfg (write, clears 0x180000, value ORed at bit shift 19); SetChnSclCfg (write, value ORed at bit shift 30). Provenance: offset PROVEN, listed masks/shifts PROVEN (lower bounds), role INFERRED from the function name, anything else UNKNOWN/GUESS.";
        field {
            name = "word";
            desc = "32-bit word (extents see the register description).";
            sw = rw;
            hw = r;
        } word[31:0];
    } NODE_W_20CC @ 0x20CC;

    reg {
        name = "Node word at offset 0x20D0";
        desc = "Word 0x20D0 of the node image. Accessed by: SetChnSclCfg (write). Provenance: offset PROVEN, listed masks/shifts PROVEN (lower bounds), role INFERRED from the function name, anything else UNKNOWN/GUESS.";
        field {
            name = "word";
            desc = "32-bit word (extents see the register description).";
            sw = rw;
            hw = r;
        } word[31:0];
    } NODE_W_20D0 @ 0x20D0;

    reg {
        name = "Node word at offset 0x20D4";
        desc = "Word 0x20D4 of the node image. Accessed by: SetChnSclCfg (write). Provenance: offset PROVEN, listed masks/shifts PROVEN (lower bounds), role INFERRED from the function name, anything else UNKNOWN/GUESS.";
        field {
            name = "word";
            desc = "32-bit word (extents see the register description).";
            sw = rw;
            hw = r;
        } word[31:0];
    } NODE_W_20D4 @ 0x20D4;

    reg {
        name = "Node word at offset 0x20D8";
        desc = "Word 0x20D8 of the node image. Accessed by: SetChnSclCfg (write). Provenance: offset PROVEN, listed masks/shifts PROVEN (lower bounds), role INFERRED from the function name, anything else UNKNOWN/GUESS.";
        field {
            name = "word";
            desc = "32-bit word (extents see the register description).";
            sw = rw;
            hw = r;
        } word[31:0];
    } NODE_W_20D8 @ 0x20D8;

    reg {
        name = "Node word at offset 0x20DC";
        desc = "Word 0x20DC of the node image. Accessed by: SetChnSclCfg (write, value ORed at bit shift 0). Provenance: offset PROVEN, listed masks/shifts PROVEN (lower bounds), role INFERRED from the function name, anything else UNKNOWN/GUESS.";
        field {
            name = "word";
            desc = "32-bit word (extents see the register description).";
            sw = rw;
            hw = r;
        } word[31:0];
    } NODE_W_20DC @ 0x20DC;

    reg {
        name = "Node word at offset 0x2600";
        desc = "Word 0x2600 of the node image. Accessed by: SetCoverCtrl (read); SetCoverCtrl (write, clears 0xff, value ORed at bit shift 0/1/2/3/4/5/6/7). Provenance: offset PROVEN, listed masks/shifts PROVEN (lower bounds), role INFERRED from the function name, anything else UNKNOWN/GUESS.";
        field {
            name = "word";
            desc = "32-bit word (extents see the register description).";
            sw = rw;
            hw = r;
        } word[31:0];
    } NODE_W_2600 @ 0x2600;

    eHISI_VPSS_V1_COVER COVER[8] @ 0x2604 += 0x2C;
};

`endif
