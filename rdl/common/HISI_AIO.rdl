`ifndef HISI_AIO_RDL
`define HISI_AIO_RDL


regfile eHISI_AIO {
    name = "HiSilicon audio input/output interface";
    desc = "
    HiSilicon audio input/output interface (AIO) at 0x20650000, GIC interrupt ID 47 (SPI 15): one audio input port (AIP: 2/4/8/16-channel PCM or I2S, 8- or 16-bit multi-channel, 8-32 bit single) and two output ports (AOP0: pads AIO_SD_TX/WS_TX/BCLK_TX; AOP1: I2S master wired inside the chip to the HDMI transmitter, no pads). I2S or PCM, master or slave (AOP1 master only), 8-192 kHz.

    Data moves by the block's own DMA between cyclic buffers in DDR and the port: there is no general DMA controller involved. Per port: BUF_SADDR (multiple of 128), BUF_SIZE (multiple of 128, bytes, 24 bits), BUF_WPTR, BUF_RPTR (byte offsets into the buffer, 24 bits), an almost-full/almost-empty threshold, TRANS_SIZE (a transfer-complete interrupt every TRANS_SIZE bytes, the *_TMP registers latch the pointers at that interrupt), INT_ENA/RAW/STATUS/CLR, STOP (enable and stop_done). The producer owns the write pointer (the block for AIP, software for AOP) and the consumer the read pointer; software must keep at least 32 bytes of free space when it advances an AOP write pointer and must queue at least 128 bytes before enabling an AOP (data sheet 13.4). A port must be stopped (enable 0, stop_done 1) before its soft reset. All three ports share the one interrupt line, AIO_INT_STATUS tells which port fired.

    Register layout: global interrupt registers at 0x0, AIP registers at 0x1000.., AOP0 at 0x2000.., AOP1 at 0x2100.. (data sheet Table 13-1). Registers are from the Hi3520D/Hi3515A/Hi3515C data sheet chapter 13.5/13.6.

    Clocks and resets are NOT in this block, they are in the CRG (offsets from the CRG base 0x20030000, data sheet 3.2.3/3.2.4 and 13.4): PERI_CRG32/33/34 (0x80/0x84/0x88) = AIP/AOP0/AOP1 MCLK fractional divider, 24-bit ckcfg = MCLK / 675 MHz * 2^27 (MCLK at most 62.5 MHz; example: 12.288 MHz = 0x25485F); PERI_CRG32 bit 24 aip_clk_sel (0 = AIP shares the AOP0 BCLK/FS, i.e. 4-wire codec; 1 = own); PERI_CRG35 (0x8C) = AIO bus clock gate (bit 1) and bus soft reset (bit 0): the AIO registers must not be accessed while the bus clock is off; PERI_CRG36/37/38 (0x90/0x94/0x98) = AIP/AOP0/AOP1 fsclk_div [14:12], bclk_div [11:8], bclk_sel [4] (1 = internal master clock), bclkout/bclk polarity [3:2], cken [1] (AIP cken also gates the AIO_MCLK pad) and srst_req [0] (the data sheet says: no separate soft reset is needed after a normal system reset). AOP1 always needs PERI_CRG34/38 programmed as master because the HDMI transmitter takes its clocks from it. The AIO pads are muxed through muxctrl_reg5-11 (IO_CONFIG 0x14-0x2C, function 0 = AIO; AIO_MCLK doubles as BOOT_SEL and AIO_SD_TX as JTAG_SEL at reset).

    Vendor cross-check (2026-11-11, static analysis only, nothing executed: OpenIPC copy of hi3520D_sio.ko, V = vendor module): the module ioremaps only 0x20650000 size 0x10000, programs only registers documented here (observed offsets 0x1000-0x1038 and 0x2028/0x202C by a scripted scan, the AOP0/AOP1 copies use the same HAL with a port index), writes AIP_INF_ATTRI with bit 12 set (the reserved must-be-1 field) and keeps the reserved bits of AIP_CTRL at 0x3210, and does the CRG programming through the sys module (command numbers 0x1D-0x22, 0x2B), not in the AIO module. Vendor MCLK values (confidence HIGH, same formula as the data sheet): 0x0025485F (12.288 MHz = 256 x 48 kHz) for 8/12/16/24/32/48 kHz, 0x002240E4 (11.2896 MHz = 256 x 44.1 kHz) for 11.025/22.05/44.1 kHz, 0x0018DAEA (8.192 MHz = 256 x 32 kHz) in one special case; BCLK/MCLK and FS/BCLK dividers follow the table in data sheet 3.2.3. No undocumented AIO register was seen, so no UNK stubs. Audit record: docs/rdl-campaign/aio.md. Not verified on hardware.
    ";

    reg {
        name = "AIO global interrupt enable register";
        desc = "AIO_INT_ENA is an AIO global interrupt enable register.

Source: data sheet (Hi3520D/Hi3515A/Hi3515C user guide, 13.6 AIO_INT_ENA, offset 0x0, printed page 13-12), confidence HIGH: offset, fields, access and reset compared by script with the Chinese issue 02 edition on 2026-11-11, no difference. Not verified on hardware.";

        enum AIO_INT_ENA_aop1_int_ena_enum {
            DISABLED = 0 { name = "Disabled"; desc = "disabled"; };
            ENABLED = 1 { name = "Enabled"; desc = "enabled"; };
        };

        field {
            name = "aop1_int_ena";
            desc = "AOP1 interrupt enable.";
            sw = rw;
            hw = r;
            encode = AIO_INT_ENA_aop1_int_ena_enum;
            reset = 0x0;
        } aop1_int_ena[17:17];

        enum AIO_INT_ENA_aop0_int_ena_enum {
            DISABLED = 0 { name = "Disabled"; desc = "disabled"; };
            ENABLED = 1 { name = "Enabled"; desc = "enabled"; };
        };

        field {
            name = "aop0_int_ena";
            desc = "AOP0 interrupt enable.";
            sw = rw;
            hw = r;
            encode = AIO_INT_ENA_aop0_int_ena_enum;
            reset = 0x0;
        } aop0_int_ena[16:16];

        enum AIO_INT_ENA_aip_int_ena_enum {
            DISABLED = 0 { name = "Disabled"; desc = "disabled"; };
            ENABLED = 1 { name = "Enabled"; desc = "enabled"; };
        };

        field {
            name = "aip_int_ena";
            desc = "AIP interrupt enable.";
            sw = rw;
            hw = r;
            encode = AIO_INT_ENA_aip_int_ena_enum;
            reset = 0x0;
        } aip_int_ena[0:0];
    } AIO_INT_ENA @ 0x0;

    reg {
        name = "AIO global interrupt status register";
        desc = "AIO_INT_STATUS is an AIO global interrupt status register.

Source: data sheet (Hi3520D/Hi3515A/Hi3515C user guide, 13.6 AIO_INT_STATUS, offset 0x4, printed page 13-13), confidence HIGH: offset, fields, access and reset compared by script with the Chinese issue 02 edition on 2026-11-11, no difference. Not verified on hardware.";

        enum AIO_INT_STATUS_aop1_int_status_enum {
            NO_INTERRUPT_GENERATED = 0 { name = "No Interrupt Generated"; desc = "No interrupt is generated."; };
            INTERRUPT_GENERATED = 1 { name = "Interrupt Generated"; desc = "An interrupt is generated."; };
        };

        field {
            name = "aop1_int_status";
            desc = "AOP1 interrupt status.";
            sw = r;
            hw = w;
            encode = AIO_INT_STATUS_aop1_int_status_enum;
            reset = 0x0;
        } aop1_int_status[17:17];

        enum AIO_INT_STATUS_aop0_int_status_enum {
            NO_INTERRUPT_GENERATED = 0 { name = "No Interrupt Generated"; desc = "No interrupt is generated."; };
            INTERRUPT_GENERATED = 1 { name = "Interrupt Generated"; desc = "An interrupt is generated."; };
        };

        field {
            name = "aop0_int_status";
            desc = "AOP0 interrupt status.";
            sw = r;
            hw = w;
            encode = AIO_INT_STATUS_aop0_int_status_enum;
            reset = 0x0;
        } aop0_int_status[16:16];

        enum AIO_INT_STATUS_aip_int_status_enum {
            NO_INTERRUPT_GENERATED = 0 { name = "No Interrupt Generated"; desc = "No interrupt is generated."; };
            INTERRUPT_GENERATED = 1 { name = "Interrupt Generated"; desc = "An interrupt is generated."; };
        };

        field {
            name = "aip_int_status";
            desc = "AIP interrupt status.";
            sw = r;
            hw = w;
            encode = AIO_INT_STATUS_aip_int_status_enum;
            reset = 0x0;
        } aip_int_status[0:0];
    } AIO_INT_STATUS @ 0x4;

    reg {
        name = "Raw AIO global interrupt register";
        desc = "AIO_INT_RAW is a raw AIO global interrupt register.

Source: data sheet (Hi3520D/Hi3515A/Hi3515C user guide, 13.6 AIO_INT_RAW, offset 0x8, printed page 13-14), confidence HIGH: offset, fields, access and reset compared by script with the Chinese issue 02 edition on 2026-11-11, no difference. Not verified on hardware.";

        enum AIO_INT_RAW_aop1_int_raw_enum {
            NO_RAW_INTERRUPT = 0 { name = "No Raw Interrupt"; desc = "No raw interrupt is generated."; };
            RAW_INTERRUPT_GENERATED = 1 { name = "Raw Interrupt Generated"; desc = "A raw interrupt is generated."; };
        };

        field {
            name = "aop1_int_raw";
            desc = "Raw AOP1 interrupt status.";
            sw = r;
            hw = w;
            encode = AIO_INT_RAW_aop1_int_raw_enum;
            reset = 0x0;
        } aop1_int_raw[17:17];

        enum AIO_INT_RAW_aop0_int_raw_enum {
            NO_RAW_INTERRUPT = 0 { name = "No Raw Interrupt"; desc = "No raw interrupt is generated."; };
            RAW_INTERRUPT_GENERATED = 1 { name = "Raw Interrupt Generated"; desc = "A raw interrupt is generated."; };
        };

        field {
            name = "aop0_int_raw";
            desc = "Raw AOP0 interrupt status.";
            sw = r;
            hw = w;
            encode = AIO_INT_RAW_aop0_int_raw_enum;
            reset = 0x0;
        } aop0_int_raw[16:16];

        enum AIO_INT_RAW_aip_int_raw_enum {
            NO_RAW_INTERRUPT = 0 { name = "No Raw Interrupt"; desc = "No raw interrupt is generated."; };
            RAW_INTERRUPT_GENERATED = 1 { name = "Raw Interrupt Generated"; desc = "A raw interrupt is generated."; };
        };

        field {
            name = "aip_int_raw";
            desc = "Raw AIP interrupt status.";
            sw = r;
            hw = w;
            encode = AIO_INT_RAW_aip_int_raw_enum;
            reset = 0x0;
        } aip_int_raw[0:0];
    } AIO_INT_RAW @ 0x8;

    reg {
        name = "AIP attribute configuration register";
        desc = "AIP_INF_ATTRI is an AIP attribute configuration register.

Source: data sheet (Hi3520D/Hi3515A/Hi3515C user guide, 13.6 AIP_INF_ATTRI, offset 0x1000, printed page 13-15), confidence HIGH: offset, fields, access and reset compared by script with the Chinese issue 02 edition on 2026-11-11, no difference. Not verified on hardware.";

        enum AIP_INF_ATTRI_aip_samp_precision_enum {
            V_8_BITS = 0 { name = "V 8 Bits"; desc = "8 bits"; };
            V_16_BITS = 1 { name = "V 16 Bits"; desc = "16 bits"; };
            V_24_BITS = 2 { name = "V 24 Bits"; desc = "24 bits"; };
            V_32_BITS_IF = 3 { name = "V 32 Bits If"; desc = "32 bits If multi-channel RX is enabled, only the 8-/16-bit sampling accuracy is supported. If multi-channel RX is not enabled, the 8-/16-/24-/32-bit sampling accuracy is supported in I 2 S mode. The 8-/16-bit sampling accuracy is supported in PCM standard or customized mode."; };
        };

        field {
            name = "aip_samp_precision";
            desc = "Sampling accuracy of data received over the AIP.";
            sw = rw;
            hw = r;
            encode = AIP_INF_ATTRI_aip_samp_precision_enum;
            reset = 0x0;
        } aip_samp_precision[11:10];

        field {
            name = "reserved_must_be_1";
            desc = "Reserved, RW; the data sheet says it must be configured to 0x1 (total reset value 0x0000_1000).";
            sw = rw;
            hw = r;
            reset = 0x1;
        } reserved_must_be_1[31:12];

        enum AIP_INF_ATTRI_aip_clk_edge_sel_enum {
            DATA_SAMPLED_AT = 0 { name = "Data Sampled At"; desc = "Data is sampled at the rising edge of the clock."; };
            DATA_SAMPLED_AT_2 = 1 { name = "Data Sampled At 2"; desc = "Data is sampled at the falling edge of the clock."; };
        };

        field {
            name = "aip_clk_edge_sel";
            desc = "AIP data sampling edge select.";
            sw = rw;
            hw = r;
            encode = AIP_INF_ATTRI_aip_clk_edge_sel_enum;
            reset = 0x0;
        } aip_clk_edge_sel[7:7];

        enum AIP_INF_ATTRI_aip_timedivision_sel_enum {
            DISABLED = 0 { name = "Disabled"; desc = "disabled"; };
            ENABLED = 1 { name = "Enabled"; desc = "enabled"; };
        };

        field {
            name = "aip_timedivision_sel";
            desc = "AIP multi-channel RX enable.";
            sw = rw;
            hw = r;
            encode = AIP_INF_ATTRI_aip_timedivision_sel_enum;
            reset = 0x0;
        } aip_timedivision_sel[6:6];

        enum AIP_INF_ATTRI_aip_routes_sel_enum {
            V_2_CHANNELS = 0 { name = "V 2 Channels"; desc = "2 channels"; };
            V_4_CHANNELS = 1 { name = "V 4 Channels"; desc = "4 channels"; };
            V_8_CHANNELS = 2 { name = "V 8 Channels"; desc = "8 channels"; };
            V_16_CHANNELS = 3 { name = "V 16 Channels"; desc = "16 channels"; };
        };

        field {
            name = "aip_routes_sel";
            desc = "Number of channels in AIP multi-channel RX mode.";
            sw = rw;
            hw = r;
            encode = AIP_INF_ATTRI_aip_routes_sel_enum;
            reset = 0x0;
        } aip_routes_sel[5:4];

        enum AIP_INF_ATTRI_aip_mode_enum {
            I_2_S = 0 { name = "I 2 S"; desc = "I 2 S mode"; };
            PCM_STANDARD_MODE = 1 { name = "Pcm Standard Mode"; desc = "PCM standard mode"; };
            PCM_CUSTOMIZED_MODE = 2 { name = "Pcm Customized Mode"; desc = "PCM customized mode"; };
            RESERVED = 3 { name = "Reserved"; desc = "reserved"; };
        };

        field {
            name = "aip_mode";
            desc = "AIP mode select.";
            sw = rw;
            hw = r;
            encode = AIP_INF_ATTRI_aip_mode_enum;
            reset = 0x0;
        } aip_mode[1:0];
    } AIP_INF_ATTRI @ 0x1000;

    reg {
        name = "AIP control register";
        desc = "AIP_CTRL is an AIP control register.

Source: data sheet (Hi3520D/Hi3515A/Hi3515C user guide, 13.6 AIP_CTRL, offset 0x1004, printed page 13-16), confidence HIGH: offset, fields, access and reset compared by script with the Chinese issue 02 edition on 2026-11-11, no difference. Not verified on hardware.";

        enum AIP_CTRL_aip_shift8_en_enum {
            DISABLED_DATA_STORED = 0 { name = "Disabled Data Stored"; desc = "disabled. Data is stored to the memory in 8-bit format."; };
            ENABLED_DATA_STORED = 1 { name = "Enabled Data Stored"; desc = "enabled. Data is stored to the memory in 16-bit format. Each received sampling data segment is shifted 8 bits left. The lower 8 bits are filled with 0."; };
        };

        field {
            name = "aip_shift8_en";
            desc = "AIP data shifting storage enable. (This bit is valid only if the sampling accuracy of the received data is 8 bits.)";
            sw = rw;
            hw = r;
            encode = AIP_CTRL_aip_shift8_en_enum;
            reset = 0x0;
        } aip_shift8_en[14:14];

        field {
            name = "reserved_must_be_0x3210";
            desc = "Reserved, RW; the data sheet says it must be configured to 0x3210 (total reset value 0x0000_3210). Bits [31:15] are reserved too and must be 0.";
            sw = rw;
            hw = r;
            reset = 0x3210;
        } reserved_must_be_0x3210[13:0];
    } AIP_CTRL @ 0x1004;

    reg {
        name = "AIP cyclic buffer start address register";
        desc = "AIP_BUF_SADDR is an AIP cyclic buffer start address register.

Source: data sheet (Hi3520D/Hi3515A/Hi3515C user guide, 13.6 AIP_BUF_SADDR, offset 0x1008, printed page 13-17), confidence HIGH: offset, fields, access and reset compared by script with the Chinese issue 02 edition on 2026-11-11, no difference. Not verified on hardware.";

        field {
            name = "aip_buf_saddr";
            desc = "AIP cyclic buffer start address.";
            sw = rw;
            hw = r;
            reset = 0x0;
        } aip_buf_saddr[31:0];
    } AIP_BUF_SADDR @ 0x1008;

    reg {
        name = "AIP cyclic buffer size register";
        desc = "AIP_BUF_SIZE is an AIP cyclic buffer size register.

Source: data sheet (Hi3520D/Hi3515A/Hi3515C user guide, 13.6 AIP_BUF_SIZE, offset 0x100C, printed page 13-17), confidence HIGH: offset, fields, access and reset compared by script with the Chinese issue 02 edition on 2026-11-11, no difference. Not verified on hardware.";

        field {
            name = "aip_buf_size";
            desc = "Size of the AIP cyclic buffer, in byte.";
            sw = rw;
            hw = r;
            reset = 0x200;
        } aip_buf_size[23:0];
    } AIP_BUF_SIZE @ 0x100C;

    reg {
        name = "AIP cyclic buffer write address register";
        desc = "AIP_BUF_WPTR is an AIP cyclic buffer write address register.

Source: data sheet (Hi3520D/Hi3515A/Hi3515C user guide, 13.6 AIP_BUF_WPTR, offset 0x1010, printed page 13-18), confidence HIGH: offset, fields, access and reset compared by script with the Chinese issue 02 edition on 2026-11-11, no difference. Not verified on hardware.";

        field {
            name = "aip_buf_wptr";
            desc = "Write address of the AIP cyclic buffer, in byte.";
            sw = rw;
            hw = r;
            reset = 0x0;
        } aip_buf_wptr[23:0];
    } AIP_BUF_WPTR @ 0x1010;

    reg {
        name = "AIP cyclic buffer read address register";
        desc = "AIP_BUF_RPTR is an AIP cyclic buffer read address register.

Source: data sheet (Hi3520D/Hi3515A/Hi3515C user guide, 13.6 AIP_BUF_RPTR, offset 0x1014, printed page 13-18), confidence HIGH: offset, fields, access and reset compared by script with the Chinese issue 02 edition on 2026-11-11, no difference. Not verified on hardware.";

        field {
            name = "aip_buf_rptr";
            desc = "Read address of the AIP cyclic buffer, in byte.";
            sw = rw;
            hw = r;
            reset = 0x0;
        } aip_buf_rptr[23:0];
    } AIP_BUF_RPTR @ 0x1014;

    reg {
        name = "AIP cyclic buffer almost full threshold H register";
        desc = "AIP_BUF_AFULL_TH is an AIP cyclic buffer almost full threshold register.

Source: data sheet (Hi3520D/Hi3515A/Hi3515C user guide, 13.6 AIP_BUF_AFULL_TH, offset 0x1018, printed page 13-19), confidence HIGH: offset, fields, access and reset compared by script with the Chinese issue 02 edition on 2026-11-11, no difference. Not verified on hardware.";

        field {
            name = "aip_buf_afull_th";
            desc = "Almost full threshold of the AIP cyclic buffer, in byte. If the available space of the AIP cyclic buffer is smaller than the threshold, an AIP cyclic buffer almost full interrupt is generated.";
            sw = rw;
            hw = r;
            reset = 0x0;
        } aip_buf_afull_th[23:0];
    } AIP_BUF_AFULL_TH @ 0x1018;

    reg {
        name = "AIP data transfer length register";
        desc = "AIP_TRANS_SIZE is an AIP data transfer length register.

Source: data sheet (Hi3520D/Hi3515A/Hi3515C user guide, 13.6 AIP_TRANS_SIZE, offset 0x101C, printed page 13-19), confidence HIGH: offset, fields, access and reset compared by script with the Chinese issue 02 edition on 2026-11-11, no difference. Not verified on hardware.";

        field {
            name = "aip_trans_size";
            desc = "AIP data transfer length. An aip_trans_int interrupt is generated when the AIP has received audio data whose length is aip_trans_size (in byte).";
            sw = rw;
            hw = r;
            reset = 0x0;
        } aip_trans_size[23:0];
    } AIP_TRANS_SIZE @ 0x101C;

    reg {
        name = "AIP interrupt enable register";
        desc = "AIP_INT_ENA is an AIP interrupt enable register.

Source: data sheet (Hi3520D/Hi3515A/Hi3515C user guide, 13.6 AIP_INT_ENA, offset 0x1020, printed page 13-20), confidence HIGH: offset, fields, access and reset compared by script with the Chinese issue 02 edition on 2026-11-11, no difference. Not verified on hardware.";

        enum AIP_INT_ENA_aip_stop_int_en_enum {
            DISABLED = 0 { name = "Disabled"; desc = "disabled"; };
            ENABLED = 1 { name = "Enabled"; desc = "enabled"; };
        };

        field {
            name = "aip_stop_int_en";
            desc = "AIP stop interrupt enable.";
            sw = rw;
            hw = r;
            encode = AIP_INT_ENA_aip_stop_int_en_enum;
            reset = 0x0;
        } aip_stop_int_en[4:4];

        enum AIP_INT_ENA_aip_fifo_full_int_en_enum {
            DISABLED = 0 { name = "Disabled"; desc = "disabled"; };
            ENABLED = 1 { name = "Enabled"; desc = "enabled"; };
        };

        field {
            name = "aip_fifo_full_int_en";
            desc = "AIP FIFO full interrupt enable.";
            sw = rw;
            hw = r;
            encode = AIP_INT_ENA_aip_fifo_full_int_en_enum;
            reset = 0x0;
        } aip_fifo_full_int_en[3:3];

        enum AIP_INT_ENA_aip_buf_afull_int_en_enum {
            DISABLED = 0 { name = "Disabled"; desc = "disabled"; };
            ENABLED = 1 { name = "Enabled"; desc = "enabled"; };
        };

        field {
            name = "aip_buf_afull_int_en";
            desc = "AIP cyclic buffer almost full interrupt enable.";
            sw = rw;
            hw = r;
            encode = AIP_INT_ENA_aip_buf_afull_int_en_enum;
            reset = 0x0;
        } aip_buf_afull_int_en[2:2];

        enum AIP_INT_ENA_aip_buf_full_int_en_enum {
            DISABLED = 0 { name = "Disabled"; desc = "disabled"; };
            ENABLED = 1 { name = "Enabled"; desc = "enabled"; };
        };

        field {
            name = "aip_buf_full_int_en";
            desc = "AIP cyclic buffer full interrupt enable.";
            sw = rw;
            hw = r;
            encode = AIP_INT_ENA_aip_buf_full_int_en_enum;
            reset = 0x0;
        } aip_buf_full_int_en[1:1];

        enum AIP_INT_ENA_aip_trans_int_en_enum {
            DISABLED = 0 { name = "Disabled"; desc = "disabled"; };
            ENABLED = 1 { name = "Enabled"; desc = "enabled"; };
        };

        field {
            name = "aip_trans_int_en";
            desc = "AIP transfer completion interrupt enable.";
            sw = rw;
            hw = r;
            encode = AIP_INT_ENA_aip_trans_int_en_enum;
            reset = 0x0;
        } aip_trans_int_en[0:0];
    } AIP_INT_ENA @ 0x1020;

    reg {
        name = "Raw AIP interrupt register";
        desc = "AIP_INT_RAW is a raw AIP interrupt register.

Source: data sheet (Hi3520D/Hi3515A/Hi3515C user guide, 13.6 AIP_INT_RAW, offset 0x1024, printed page 13-21), confidence HIGH: offset, fields, access and reset compared by script with the Chinese issue 02 edition on 2026-11-11, no difference. Not verified on hardware.";

        enum AIP_INT_RAW_aip_stop_int_raw_enum {
            NO_RAW_INTERRUPT = 0 { name = "No Raw Interrupt"; desc = "No raw interrupt is generated."; };
            RAW_INTERRUPT_GENERATED = 1 { name = "Raw Interrupt Generated"; desc = "A raw interrupt is generated."; };
        };

        field {
            name = "aip_stop_int_raw";
            desc = "Raw AIP stop interrupt.";
            sw = r;
            hw = w;
            encode = AIP_INT_RAW_aip_stop_int_raw_enum;
            reset = 0x0;
        } aip_stop_int_raw[4:4];

        enum AIP_INT_RAW_aip_fifo_full_int_raw_enum {
            NO_RAW_INTERRUPT = 0 { name = "No Raw Interrupt"; desc = "No raw interrupt is generated."; };
            RAW_INTERRUPT_GENERATED = 1 { name = "Raw Interrupt Generated"; desc = "A raw interrupt is generated."; };
        };

        field {
            name = "aip_fifo_full_int_raw";
            desc = "Raw AIP FIFO full interrupt.";
            sw = r;
            hw = w;
            encode = AIP_INT_RAW_aip_fifo_full_int_raw_enum;
            reset = 0x0;
        } aip_fifo_full_int_raw[3:3];

        enum AIP_INT_RAW_aip_buf_afull_int_raw_enum {
            NO_RAW_INTERRUPT = 0 { name = "No Raw Interrupt"; desc = "No raw interrupt is generated."; };
            RAW_INTERRUPT_GENERATED = 1 { name = "Raw Interrupt Generated"; desc = "A raw interrupt is generated."; };
        };

        field {
            name = "aip_buf_afull_int_raw";
            desc = "Raw AIP cyclic buffer almost full interrupt.";
            sw = r;
            hw = w;
            encode = AIP_INT_RAW_aip_buf_afull_int_raw_enum;
            reset = 0x0;
        } aip_buf_afull_int_raw[2:2];

        enum AIP_INT_RAW_aip_buf_full_int_raw_enum {
            NO_RAW_INTERRUPT = 0 { name = "No Raw Interrupt"; desc = "No raw interrupt is generated."; };
            RAW_INTERRUPT_GENERATED = 1 { name = "Raw Interrupt Generated"; desc = "A raw interrupt is generated."; };
        };

        field {
            name = "aip_buf_full_int_raw";
            desc = "Raw AIP cyclic buffer full interrupt.";
            sw = r;
            hw = w;
            encode = AIP_INT_RAW_aip_buf_full_int_raw_enum;
            reset = 0x0;
        } aip_buf_full_int_raw[1:1];

        enum AIP_INT_RAW_aip_trans_int_raw_enum {
            NO_RAW_INTERRUPT = 0 { name = "No Raw Interrupt"; desc = "No raw interrupt is generated."; };
            RAW_INTERRUPT_GENERATED = 1 { name = "Raw Interrupt Generated"; desc = "A raw interrupt is generated."; };
        };

        field {
            name = "aip_trans_int_raw";
            desc = "Raw AIP transfer completion interrupt.";
            sw = r;
            hw = w;
            encode = AIP_INT_RAW_aip_trans_int_raw_enum;
            reset = 0x0;
        } aip_trans_int_raw[0:0];
    } AIP_INT_RAW @ 0x1024;

    reg {
        name = "AIP interrupt status register";
        desc = "AIP_INT_STATUS is an AIP interrupt status register.

Source: data sheet (Hi3520D/Hi3515A/Hi3515C user guide, 13.6 AIP_INT_STATUS, offset 0x1028, printed page 13-22), confidence HIGH: offset, fields, access and reset compared by script with the Chinese issue 02 edition on 2026-11-11, no difference. Not verified on hardware.";

        enum AIP_INT_STATUS_aip_stop_int_status_enum {
            NO_INTERRUPT_GENERATED = 0 { name = "No Interrupt Generated"; desc = "No interrupt is generated."; };
            INTERRUPT_GENERATED = 1 { name = "Interrupt Generated"; desc = "An interrupt is generated."; };
        };

        field {
            name = "aip_stop_int_status";
            desc = "AIP stop interrupt status.";
            sw = r;
            hw = w;
            encode = AIP_INT_STATUS_aip_stop_int_status_enum;
            reset = 0x0;
        } aip_stop_int_status[4:4];

        enum AIP_INT_STATUS_aip_fifo_full_int_status_enum {
            NO_INTERRUPT_GENERATED = 0 { name = "No Interrupt Generated"; desc = "No interrupt is generated."; };
            INTERRUPT_GENERATED = 1 { name = "Interrupt Generated"; desc = "An interrupt is generated."; };
        };

        field {
            name = "aip_fifo_full_int_status";
            desc = "AIP FIFO full interrupt status.";
            sw = r;
            hw = w;
            encode = AIP_INT_STATUS_aip_fifo_full_int_status_enum;
            reset = 0x0;
        } aip_fifo_full_int_status[3:3];

        enum AIP_INT_STATUS_aip_buf_afull_int_status_enum {
            NO_INTERRUPT_GENERATED = 0 { name = "No Interrupt Generated"; desc = "No interrupt is generated."; };
            INTERRUPT_GENERATED = 1 { name = "Interrupt Generated"; desc = "An interrupt is generated."; };
        };

        field {
            name = "aip_buf_afull_int_status";
            desc = "AIP cyclic buffer almost full interrupt status.";
            sw = r;
            hw = w;
            encode = AIP_INT_STATUS_aip_buf_afull_int_status_enum;
            reset = 0x0;
        } aip_buf_afull_int_status[2:2];

        enum AIP_INT_STATUS_aip_buf_full_int_status_enum {
            NO_INTERRUPT_GENERATED = 0 { name = "No Interrupt Generated"; desc = "No interrupt is generated."; };
            INTERRUPT_GENERATED = 1 { name = "Interrupt Generated"; desc = "An interrupt is generated."; };
        };

        field {
            name = "aip_buf_full_int_status";
            desc = "AIP cyclic buffer full interrupt status.";
            sw = r;
            hw = w;
            encode = AIP_INT_STATUS_aip_buf_full_int_status_enum;
            reset = 0x0;
        } aip_buf_full_int_status[1:1];

        enum AIP_INT_STATUS_aip_trans_int_status_enum {
            NO_INTERRUPT_GENERATED = 0 { name = "No Interrupt Generated"; desc = "No interrupt is generated."; };
            INTERRUPT_GENERATED = 1 { name = "Interrupt Generated"; desc = "An interrupt is generated."; };
        };

        field {
            name = "aip_trans_int_status";
            desc = "AIP transfer completion interrupt status.";
            sw = r;
            hw = w;
            encode = AIP_INT_STATUS_aip_trans_int_status_enum;
            reset = 0x0;
        } aip_trans_int_status[0:0];
    } AIP_INT_STATUS @ 0x1028;

    reg {
        name = "AIP interrupt clear register";
        desc = "AIP_INT_CLR is an AIP interrupt clear register. The value 0 is returned when the register is read, and the value 0 has no meaning.

Source: data sheet (Hi3520D/Hi3515A/Hi3515C user guide, 13.6 AIP_INT_CLR, offset 0x102C, printed page 13-23), confidence HIGH: offset, fields, access and reset compared by script with the Chinese issue 02 edition on 2026-11-11, no difference. Not verified on hardware.";

        enum AIP_INT_CLR_aip_stop_int_clr_enum {
            NOT_CLEARED = 0 { name = "Not Cleared"; desc = "not cleared"; };
            CLEARED = 1 { name = "Cleared"; desc = "cleared"; };
        };

        field {
            name = "aip_stop_int_clr";
            desc = "AIP stop interrupt clear.";
            sw = rw;
            hw = r;
            encode = AIP_INT_CLR_aip_stop_int_clr_enum;
            reset = 0x0;
        } aip_stop_int_clr[4:4];

        enum AIP_INT_CLR_aip_fifo_full_int_clr_enum {
            NOT_CLEARED = 0 { name = "Not Cleared"; desc = "not cleared"; };
            CLEARED = 1 { name = "Cleared"; desc = "cleared"; };
        };

        field {
            name = "aip_fifo_full_int_clr";
            desc = "AIP FIFO full interrupt clear.";
            sw = rw;
            hw = r;
            encode = AIP_INT_CLR_aip_fifo_full_int_clr_enum;
            reset = 0x0;
        } aip_fifo_full_int_clr[3:3];

        enum AIP_INT_CLR_aip_buf_afull_int_clr_enum {
            NOT_CLEARED = 0 { name = "Not Cleared"; desc = "not cleared"; };
            CLEARED = 1 { name = "Cleared"; desc = "cleared"; };
        };

        field {
            name = "aip_buf_afull_int_clr";
            desc = "AIP cyclic buffer almost full interrupt clear.";
            sw = rw;
            hw = r;
            encode = AIP_INT_CLR_aip_buf_afull_int_clr_enum;
            reset = 0x0;
        } aip_buf_afull_int_clr[2:2];

        enum AIP_INT_CLR_aip_buf_full_int_clr_enum {
            NOT_CLEARED = 0 { name = "Not Cleared"; desc = "not cleared"; };
            CLEARED = 1 { name = "Cleared"; desc = "cleared"; };
        };

        field {
            name = "aip_buf_full_int_clr";
            desc = "AIP cyclic buffer full interrupt clear.";
            sw = rw;
            hw = r;
            encode = AIP_INT_CLR_aip_buf_full_int_clr_enum;
            reset = 0x0;
        } aip_buf_full_int_clr[1:1];

        enum AIP_INT_CLR_aip_trans_int_clr_enum {
            NOT_CLEARED = 0 { name = "Not Cleared"; desc = "not cleared"; };
            CLEARED = 1 { name = "Cleared"; desc = "cleared"; };
        };

        field {
            name = "aip_trans_int_clr";
            desc = "AIP transfer completion interrupt clear.";
            sw = rw;
            hw = r;
            encode = AIP_INT_CLR_aip_trans_int_clr_enum;
            reset = 0x0;
        } aip_trans_int_clr[0:0];
    } AIP_INT_CLR @ 0x102C;

    reg {
        name = "AIP cyclic buffer write address lock MP register";
        desc = "AIP_BUF_WPTR_TMP is an AIP cyclic buffer write address lock register.

Source: data sheet (Hi3520D/Hi3515A/Hi3515C user guide, 13.6 AIP_BUF_WPTR_TMP, offset 0x1030, printed page 13-24), confidence HIGH: offset, fields, access and reset compared by script with the Chinese issue 02 edition on 2026-11-11, no difference. Not verified on hardware.";

        field {
            name = "aip_buf_wptr_tmp";
            desc = "When an AIP transfer completion interrupt is generated, the value of aip_buf_wptr is stored to aip_buf_wptr_tmp until the next AIP transfer completion interrupt is generated.";
            sw = r;
            hw = w;
            reset = 0x0;
        } aip_buf_wptr_tmp[23:0];
    } AIP_BUF_WPTR_TMP @ 0x1030;

    reg {
        name = "AIP cyclic buffer read address lock register MP";
        desc = "AIP_BUF_RPTR_TMP is an AIP cyclic buffer read address lock register.

Source: data sheet (Hi3520D/Hi3515A/Hi3515C user guide, 13.6 AIP_BUF_RPTR_TMP, offset 0x1034, printed page 13-24), confidence HIGH: offset, fields, access and reset compared by script with the Chinese issue 02 edition on 2026-11-11, no difference. Not verified on hardware.";

        field {
            name = "aip_buf_rptr_tmp";
            desc = "When an AIP transfer completion interrupt is generated, the value of aip_buf_rptr is stored to aip_buf_rptr_tmp until the next AIP transfer completion interrupt is generated.";
            sw = r;
            hw = w;
            reset = 0x0;
        } aip_buf_rptr_tmp[23:0];
    } AIP_BUF_RPTR_TMP @ 0x1034;

    reg {
        name = "AIP enable/disable control register";
        desc = "AIP_STOP is an AIP enable/disable control register.

Source: data sheet (Hi3520D/Hi3515A/Hi3515C user guide, 13.6 AIP_STOP, offset 0x1038, printed page 13-25), confidence HIGH: offset, fields, access and reset compared by script with the Chinese issue 02 edition on 2026-11-11, no difference. Not verified on hardware.";

        enum AIP_STOP_aip_stop_done_enum {
            NOT_COMPLETE = 0 { name = "Not Complete"; desc = "not complete"; };
            COMPLETE = 1 { name = "Complete"; desc = "complete"; };
        };

        field {
            name = "aip_stop_done";
            desc = "AIP data receive completion status.";
            sw = r;
            hw = w;
            encode = AIP_STOP_aip_stop_done_enum;
            reset = 0x1;
        } aip_stop_done[1:1];

        enum AIP_STOP_aip_enable_enum {
            DISABLED = 0 { name = "Disabled"; desc = "disabled"; };
            ENABLED = 1 { name = "Enabled"; desc = "enabled"; };
        };

        field {
            name = "aip_enable";
            desc = "AIP data receive enable.";
            sw = rw;
            hw = r;
            encode = AIP_STOP_aip_enable_enum;
            reset = 0x0;
        } aip_enable[0:0];
    } AIP_STOP @ 0x1038;

    reg {
        name = "AOP0 attribute configuration register";
        desc = "AOP0_INF_ATTRI is an AOP0 attribute configuration register.

Source: data sheet (Hi3520D/Hi3515A/Hi3515C user guide, 13.6 AOP0_INF_ATTRI, offset 0x2000, printed page 13-26), confidence HIGH: offset, fields, access and reset compared by script with the Chinese issue 02 edition on 2026-11-11, no difference. Not verified on hardware.";

        enum AOP0_INF_ATTRI_aop0_samp_precision_enum {
            V_8_BITS = 0 { name = "V 8 Bits"; desc = "8 bits"; };
            V_16_BITS = 1 { name = "V 16 Bits"; desc = "16 bits"; };
            V_24_BITS = 2 { name = "V 24 Bits"; desc = "24 bits"; };
            V_32_BITS_IF = 3 { name = "V 32 Bits If"; desc = "32 bits If multi-channel TX is enabled, only the 8-/16-bit sampling accuracy is supported. If multi-channel TX is not enabled, the 8-/16-/24-/32-bit sampling accuracy is supported in I 2 S mode. The 8-/16-bit sampling accuracy is supported in PCM standard or customized mode."; };
        };

        field {
            name = "aop0_samp_precision";
            desc = "Sampling accuracy of data transmitted over AOP0.";
            sw = rw;
            hw = r;
            encode = AOP0_INF_ATTRI_aop0_samp_precision_enum;
            reset = 0x0;
        } aop0_samp_precision[11:10];

        enum AOP0_INF_ATTRI_aop0_clk_edge_sel_enum {
            TRANSMITTED_DATA_VALID = 0 { name = "Transmitted Data Valid"; desc = "The transmitted data is valid on the rising edge of the clock."; };
            TRANSMITTED_DATA_VALID_2 = 1 { name = "Transmitted Data Valid 2"; desc = "The transmitted data is valid on the falling edge of the clock."; };
        };

        field {
            name = "aop0_clk_edge_sel";
            desc = "Clock polarity select for data transmitted over AOP0.";
            sw = rw;
            hw = r;
            encode = AOP0_INF_ATTRI_aop0_clk_edge_sel_enum;
            reset = 0x0;
        } aop0_clk_edge_sel[7:7];

        enum AOP0_INF_ATTRI_aop0_timedivision_sel_enum {
            DISABLED = 0 { name = "Disabled"; desc = "disabled"; };
            ENABLED = 1 { name = "Enabled"; desc = "enabled"; };
        };

        field {
            name = "aop0_timedivision_sel";
            desc = "AOP0 multi-channel TX enable.";
            sw = rw;
            hw = r;
            encode = AOP0_INF_ATTRI_aop0_timedivision_sel_enum;
            reset = 0x0;
        } aop0_timedivision_sel[6:6];

        enum AOP0_INF_ATTRI_aop0_routes_sel_enum {
            V_2_CHANNELS = 0 { name = "V 2 Channels"; desc = "2 channels"; };
            V_4_CHANNELS = 1 { name = "V 4 Channels"; desc = "4 channels"; };
            V_8_CHANNELS = 2 { name = "V 8 Channels"; desc = "8 channels"; };
            V_16_CHANNELS = 3 { name = "V 16 Channels"; desc = "16 channels"; };
        };

        field {
            name = "aop0_routes_sel";
            desc = "Number of channels in AOP0 multi-channel TX mode.";
            sw = rw;
            hw = r;
            encode = AOP0_INF_ATTRI_aop0_routes_sel_enum;
            reset = 0x0;
        } aop0_routes_sel[5:4];

        enum AOP0_INF_ATTRI_aop0_mode_enum {
            I_2_S = 0 { name = "I 2 S"; desc = "I 2 S mode"; };
            PCM_STANDARD_MODE = 1 { name = "Pcm Standard Mode"; desc = "PCM standard mode"; };
            PCM_CUSTOMIZED_MODE = 2 { name = "Pcm Customized Mode"; desc = "PCM customized mode"; };
            RESERVED = 3 { name = "Reserved"; desc = "reserved"; };
        };

        field {
            name = "aop0_mode";
            desc = "AOP0 mode select.";
            sw = rw;
            hw = r;
            encode = AOP0_INF_ATTRI_aop0_mode_enum;
            reset = 0x0;
        } aop0_mode[1:0];
    } AOP0_INF_ATTRI @ 0x2000;

    reg {
        name = "AOP0 control register";
        desc = "AOP0_CTRL is an AOP0 control register.

Source: data sheet (Hi3520D/Hi3515A/Hi3515C user guide, 13.6 AOP0_CTRL, offset 0x2004, printed page 13-27), confidence HIGH: offset, fields, access and reset compared by script with the Chinese issue 02 edition on 2026-11-11, no difference. Not verified on hardware.";

        enum AOP0_CTRL_aop0_mute_enum {
            UNMUTED = 0 { name = "Unmuted"; desc = "unmuted"; };
            MUTE = 1 { name = "Mute"; desc = "mute"; };
        };

        field {
            name = "aop0_mute";
            desc = "Mute enable for AOP0 transmission.";
            sw = rw;
            hw = r;
            encode = AOP0_CTRL_aop0_mute_enum;
            reset = 0x0;
        } aop0_mute[15:15];
    } AOP0_CTRL @ 0x2004;

    reg {
        name = "AOP0 cyclic buffer start address register";
        desc = "AOP0_BUF_SADDR is an AOP0 cyclic buffer start address register.

Source: data sheet (Hi3520D/Hi3515A/Hi3515C user guide, 13.6 AOP0_BUF_SADDR, offset 0x2008, printed page 13-28), confidence HIGH: offset, fields, access and reset compared by script with the Chinese issue 02 edition on 2026-11-11, no difference. Not verified on hardware.";

        field {
            name = "aop0_buf_saddr";
            desc = "AOP0 cyclic buffer start address.";
            sw = rw;
            hw = r;
            reset = 0x0;
        } aop0_buf_saddr[31:0];
    } AOP0_BUF_SADDR @ 0x2008;

    reg {
        name = "AOP0 cyclic buffer size register";
        desc = "AOP0_BUF_SIZE is an AOP0 cyclic buffer size register.

Source: data sheet (Hi3520D/Hi3515A/Hi3515C user guide, 13.6 AOP0_BUF_SIZE, offset 0x200C, printed page 13-28), confidence HIGH: offset, fields, access and reset compared by script with the Chinese issue 02 edition on 2026-11-11, no difference. Not verified on hardware.";

        field {
            name = "aop0_buf_size";
            desc = "Size of the AOP0 cyclic buffer, in byte.";
            sw = rw;
            hw = r;
            reset = 0x200;
        } aop0_buf_size[23:0];
    } AOP0_BUF_SIZE @ 0x200C;

    reg {
        name = "AOP0 cyclic buffer write address register";
        desc = "AOP0_BUF_WPTR is an AOP0 cyclic buffer write address register.

Source: data sheet (Hi3520D/Hi3515A/Hi3515C user guide, 13.6 AOP0_BUF_WPTR, offset 0x2010, printed page 13-29), confidence HIGH: offset, fields, access and reset compared by script with the Chinese issue 02 edition on 2026-11-11, no difference. Not verified on hardware.";

        field {
            name = "aop0_buf_wptr";
            desc = "aop0_buf_wptr";
            sw = rw;
            hw = r;
            reset = 0x0;
        } aop0_buf_wptr[23:0];
    } AOP0_BUF_WPTR @ 0x2010;

    reg {
        name = "AOP0 cyclic buffer read address register";
        desc = "AOP0_BUF_RPTR is an AOP0 cyclic buffer read address register.

Source: data sheet (Hi3520D/Hi3515A/Hi3515C user guide, 13.6 AOP0_BUF_RPTR, offset 0x2014, printed page 13-29), confidence HIGH: offset, fields, access and reset compared by script with the Chinese issue 02 edition on 2026-11-11, no difference. Not verified on hardware.";

        field {
            name = "aop0_buf_rptr";
            desc = "Read address of the AOP0 cyclic buffer, in byte.";
            sw = rw;
            hw = r;
            reset = 0x0;
        } aop0_buf_rptr[23:0];
    } AOP0_BUF_RPTR @ 0x2014;

    reg {
        name = "AOP0 cyclic buffer almost empty threshold Y_TH register";
        desc = "AOP0_BUF_AEMPTY_TH is an AOP0 cyclic buffer almost empty threshold register.

Source: data sheet (Hi3520D/Hi3515A/Hi3515C user guide, 13.6 AOP0_BUF_AEMPTY_TH, offset 0x2018, printed page 13-30), confidence HIGH: offset, fields, access and reset compared by script with the Chinese issue 02 edition on 2026-11-11, no difference. Not verified on hardware.";

        field {
            name = "aop0_buf_aempty_th";
            desc = "Almost empty threshold of the AOP0 cyclic buffer, in byte. If the quantity of valid data in the AOP0 cyclic buffer is smaller than the threshold, an AOP0 cyclic buffer almost empty interrupt is generated.";
            sw = rw;
            hw = r;
            reset = 0x0;
        } aop0_buf_aempty_th[23:0];
    } AOP0_BUF_AEMPTY_TH @ 0x2018;

    reg {
        name = "AOP0 data transfer length register";
        desc = "AOP0_TRANS_SIZE is an AOP0 data transfer length register.

Source: data sheet (Hi3520D/Hi3515A/Hi3515C user guide, 13.6 AOP0_TRANS_SIZE, offset 0x201C, printed page 13-30), confidence HIGH: offset, fields, access and reset compared by script with the Chinese issue 02 edition on 2026-11-11, no difference. Not verified on hardware.";

        field {
            name = "aop0_trans_size";
            desc = "AOP0 data transfer length. An aop0_trans_int interrupt is generated when AOP0 has transmitted audio data whose length is aop0_trans_size (in byte).";
            sw = rw;
            hw = r;
            reset = 0x0;
        } aop0_trans_size[23:0];
    } AOP0_TRANS_SIZE @ 0x201C;

    reg {
        name = "AOP0 interrupt enable register";
        desc = "AOP0_INT_ENA is an AOP0 interrupt enable register.

Source: data sheet (Hi3520D/Hi3515A/Hi3515C user guide, 13.6 AOP0_INT_ENA, offset 0x2020, printed page 13-31), confidence HIGH: offset, fields, access and reset compared by script with the Chinese issue 02 edition on 2026-11-11, no difference. Not verified on hardware.";

        enum AOP0_INT_ENA_aop0_stop_int_en_enum {
            DISABLED = 0 { name = "Disabled"; desc = "disabled"; };
            ENABLED = 1 { name = "Enabled"; desc = "enabled"; };
        };

        field {
            name = "aop0_stop_int_en";
            desc = "AOP0 stop interrupt enable.";
            sw = rw;
            hw = r;
            encode = AOP0_INT_ENA_aop0_stop_int_en_enum;
            reset = 0x0;
        } aop0_stop_int_en[4:4];

        enum AOP0_INT_ENA_aop0_fifo_empty_int_en_enum {
            DISABLED = 0 { name = "Disabled"; desc = "disabled"; };
            ENABLED = 1 { name = "Enabled"; desc = "enabled"; };
        };

        field {
            name = "aop0_fifo_empty_int_en";
            desc = "AOP0 FIFO empty interrupt enable.";
            sw = rw;
            hw = r;
            encode = AOP0_INT_ENA_aop0_fifo_empty_int_en_enum;
            reset = 0x0;
        } aop0_fifo_empty_int_en[3:3];

        enum AOP0_INT_ENA_aop0_buf_aempty_int_en_enum {
            DISABLED = 0 { name = "Disabled"; desc = "disabled"; };
            ENABLED = 1 { name = "Enabled"; desc = "enabled"; };
        };

        field {
            name = "aop0_buf_aempty_int_en";
            desc = "AOP0 cyclic buffer almost empty interrupt enable.";
            sw = rw;
            hw = r;
            encode = AOP0_INT_ENA_aop0_buf_aempty_int_en_enum;
            reset = 0x0;
        } aop0_buf_aempty_int_en[2:2];

        enum AOP0_INT_ENA_aop0_buf_empty_int_en_enum {
            DISABLED = 0 { name = "Disabled"; desc = "disabled"; };
            ENABLED = 1 { name = "Enabled"; desc = "enabled"; };
        };

        field {
            name = "aop0_buf_empty_int_en";
            desc = "AOP0 cyclic buffer empty interrupt enable.";
            sw = rw;
            hw = r;
            encode = AOP0_INT_ENA_aop0_buf_empty_int_en_enum;
            reset = 0x0;
        } aop0_buf_empty_int_en[1:1];

        enum AOP0_INT_ENA_aop0_trans_int_en_enum {
            DISABLED = 0 { name = "Disabled"; desc = "disabled"; };
            ENABLED = 1 { name = "Enabled"; desc = "enabled"; };
        };

        field {
            name = "aop0_trans_int_en";
            desc = "AOP0 transfer completion interrupt enable.";
            sw = rw;
            hw = r;
            encode = AOP0_INT_ENA_aop0_trans_int_en_enum;
            reset = 0x0;
        } aop0_trans_int_en[0:0];
    } AOP0_INT_ENA @ 0x2020;

    reg {
        name = "Raw AOP0 interrupt register";
        desc = "AOP0_INT_RAW is a raw AOP0 interrupt register.

Source: data sheet (Hi3520D/Hi3515A/Hi3515C user guide, 13.6 AOP0_INT_RAW, offset 0x2024, printed page 13-32), confidence HIGH: offset, fields, access and reset compared by script with the Chinese issue 02 edition on 2026-11-11, no difference. Not verified on hardware.";

        enum AOP0_INT_RAW_aop0_stop_int_raw_enum {
            NO_RAW_INTERRUPT = 0 { name = "No Raw Interrupt"; desc = "No raw interrupt is generated."; };
            RAW_INTERRUPT_GENERATED = 1 { name = "Raw Interrupt Generated"; desc = "A raw interrupt is generated."; };
        };

        field {
            name = "aop0_stop_int_raw";
            desc = "Raw AOP0 stop interrupt.";
            sw = r;
            hw = w;
            encode = AOP0_INT_RAW_aop0_stop_int_raw_enum;
            reset = 0x0;
        } aop0_stop_int_raw[4:4];

        enum AOP0_INT_RAW_aop0_fifo_empty_int_raw_enum {
            NO_RAW_INTERRUPT = 0 { name = "No Raw Interrupt"; desc = "No raw interrupt is generated."; };
            RAW_INTERRUPT_GENERATED = 1 { name = "Raw Interrupt Generated"; desc = "A raw interrupt is generated."; };
        };

        field {
            name = "aop0_fifo_empty_int_raw";
            desc = "Raw AOP0 FIFO empty interrupt.";
            sw = r;
            hw = w;
            encode = AOP0_INT_RAW_aop0_fifo_empty_int_raw_enum;
            reset = 0x0;
        } aop0_fifo_empty_int_raw[3:3];

        enum AOP0_INT_RAW_aop0_buf_aempty_int_raw_enum {
            NO_RAW_INTERRUPT = 0 { name = "No Raw Interrupt"; desc = "No raw interrupt is generated."; };
            RAW_INTERRUPT_GENERATED = 1 { name = "Raw Interrupt Generated"; desc = "A raw interrupt is generated."; };
        };

        field {
            name = "aop0_buf_aempty_int_raw";
            desc = "Raw AOP0 cyclic buffer almost empty interrupt.";
            sw = r;
            hw = w;
            encode = AOP0_INT_RAW_aop0_buf_aempty_int_raw_enum;
            reset = 0x0;
        } aop0_buf_aempty_int_raw[2:2];

        enum AOP0_INT_RAW_aop0_buf_empty_int_raw_enum {
            NO_RAW_INTERRUPT = 0 { name = "No Raw Interrupt"; desc = "No raw interrupt is generated."; };
            RAW_INTERRUPT_GENERATED = 1 { name = "Raw Interrupt Generated"; desc = "A raw interrupt is generated."; };
        };

        field {
            name = "aop0_buf_empty_int_raw";
            desc = "Raw AOP0 cyclic buffer empty interrupt.";
            sw = r;
            hw = w;
            encode = AOP0_INT_RAW_aop0_buf_empty_int_raw_enum;
            reset = 0x0;
        } aop0_buf_empty_int_raw[1:1];

        enum AOP0_INT_RAW_aop0_trans_int_raw_enum {
            NO_RAW_INTERRUPT = 0 { name = "No Raw Interrupt"; desc = "No raw interrupt is generated."; };
            RAW_INTERRUPT_GENERATED = 1 { name = "Raw Interrupt Generated"; desc = "A raw interrupt is generated."; };
        };

        field {
            name = "aop0_trans_int_raw";
            desc = "Raw AOP0 transfer completion interrupt.";
            sw = r;
            hw = w;
            encode = AOP0_INT_RAW_aop0_trans_int_raw_enum;
            reset = 0x0;
        } aop0_trans_int_raw[0:0];
    } AOP0_INT_RAW @ 0x2024;

    reg {
        name = "AOP0 interrupt status register";
        desc = "AOP0_INT_STATUS is an AOP0 interrupt status register.

Source: data sheet (Hi3520D/Hi3515A/Hi3515C user guide, 13.6 AOP0_INT_STATUS, offset 0x2028, printed page 13-33), confidence HIGH: offset, fields, access and reset compared by script with the Chinese issue 02 edition on 2026-11-11, no difference. Not verified on hardware.";

        enum AOP0_INT_STATUS_aop0_stop_int_status_enum {
            NO_INTERRUPT_GENERATED = 0 { name = "No Interrupt Generated"; desc = "No interrupt is generated."; };
            INTERRUPT_GENERATED = 1 { name = "Interrupt Generated"; desc = "An interrupt is generated."; };
        };

        field {
            name = "aop0_stop_int_status";
            desc = "AOP0 stop interrupt status.";
            sw = r;
            hw = w;
            encode = AOP0_INT_STATUS_aop0_stop_int_status_enum;
            reset = 0x0;
        } aop0_stop_int_status[4:4];

        enum AOP0_INT_STATUS_aop0_fifo_empty_int_status_enum {
            NO_INTERRUPT_GENERATED = 0 { name = "No Interrupt Generated"; desc = "No interrupt is generated."; };
            INTERRUPT_GENERATED = 1 { name = "Interrupt Generated"; desc = "An interrupt is generated."; };
        };

        field {
            name = "aop0_fifo_empty_int_status";
            desc = "AOP0 FIFO empty interrupt status.";
            sw = r;
            hw = w;
            encode = AOP0_INT_STATUS_aop0_fifo_empty_int_status_enum;
            reset = 0x0;
        } aop0_fifo_empty_int_status[3:3];

        enum AOP0_INT_STATUS_aop0_buf_aempty_int_status_enum {
            NO_INTERRUPT_GENERATED = 0 { name = "No Interrupt Generated"; desc = "No interrupt is generated."; };
            INTERRUPT_GENERATED = 1 { name = "Interrupt Generated"; desc = "An interrupt is generated."; };
        };

        field {
            name = "aop0_buf_aempty_int_status";
            desc = "AOP0 cyclic buffer almost empty interrupt status.";
            sw = r;
            hw = w;
            encode = AOP0_INT_STATUS_aop0_buf_aempty_int_status_enum;
            reset = 0x0;
        } aop0_buf_aempty_int_status[2:2];

        enum AOP0_INT_STATUS_aop0_buf_empty_int_status_enum {
            NO_INTERRUPT_GENERATED = 0 { name = "No Interrupt Generated"; desc = "No interrupt is generated."; };
            INTERRUPT_GENERATED = 1 { name = "Interrupt Generated"; desc = "An interrupt is generated."; };
        };

        field {
            name = "aop0_buf_empty_int_status";
            desc = "AOP0 cyclic buffer empty interrupt status.";
            sw = r;
            hw = w;
            encode = AOP0_INT_STATUS_aop0_buf_empty_int_status_enum;
            reset = 0x0;
        } aop0_buf_empty_int_status[1:1];

        enum AOP0_INT_STATUS_aop0_trans_int_status_enum {
            NO_INTERRUPT_GENERATED = 0 { name = "No Interrupt Generated"; desc = "No interrupt is generated."; };
            INTERRUPT_GENERATED = 1 { name = "Interrupt Generated"; desc = "An interrupt is generated."; };
        };

        field {
            name = "aop0_trans_int_status";
            desc = "AOP0 transfer completion interrupt status.";
            sw = r;
            hw = w;
            encode = AOP0_INT_STATUS_aop0_trans_int_status_enum;
            reset = 0x0;
        } aop0_trans_int_status[0:0];
    } AOP0_INT_STATUS @ 0x2028;

    reg {
        name = "AOP0 interrupt clear register";
        desc = "AOP0_INT_CLR is an AOP0 interrupt clear register. The value 0 is returned when the register is read, and the value 0 has no meaning.

Source: data sheet (Hi3520D/Hi3515A/Hi3515C user guide, 13.6 AOP0_INT_CLR, offset 0x202C, printed page 13-34), confidence HIGH: offset, fields, access and reset compared by script with the Chinese issue 02 edition on 2026-11-11, no difference. Not verified on hardware.";

        enum AOP0_INT_CLR_aop0_stop_int_clr_enum {
            NOT_CLEARED = 0 { name = "Not Cleared"; desc = "not cleared"; };
            CLEARED = 1 { name = "Cleared"; desc = "cleared"; };
        };

        field {
            name = "aop0_stop_int_clr";
            desc = "AOP0 stop interrupt clear.";
            sw = rw;
            hw = r;
            encode = AOP0_INT_CLR_aop0_stop_int_clr_enum;
            reset = 0x0;
        } aop0_stop_int_clr[4:4];

        enum AOP0_INT_CLR_aop0_fifo_empty_int_clr_enum {
            NOT_CLEARED = 0 { name = "Not Cleared"; desc = "not cleared"; };
            CLEARED = 1 { name = "Cleared"; desc = "cleared"; };
        };

        field {
            name = "aop0_fifo_empty_int_clr";
            desc = "AOP0 FIFO empty interrupt clear.";
            sw = rw;
            hw = r;
            encode = AOP0_INT_CLR_aop0_fifo_empty_int_clr_enum;
            reset = 0x0;
        } aop0_fifo_empty_int_clr[3:3];

        enum AOP0_INT_CLR_aop0_buf_aempty_int_clr_enum {
            NOT_CLEARED = 0 { name = "Not Cleared"; desc = "not cleared"; };
            CLEARED = 1 { name = "Cleared"; desc = "cleared"; };
        };

        field {
            name = "aop0_buf_aempty_int_clr";
            desc = "AOP0 cyclic buffer almost empty interrupt clear.";
            sw = rw;
            hw = r;
            encode = AOP0_INT_CLR_aop0_buf_aempty_int_clr_enum;
            reset = 0x0;
        } aop0_buf_aempty_int_clr[2:2];

        enum AOP0_INT_CLR_aop0_buf_empty_int_clr_enum {
            NOT_CLEARED = 0 { name = "Not Cleared"; desc = "not cleared"; };
            CLEARED = 1 { name = "Cleared"; desc = "cleared"; };
        };

        field {
            name = "aop0_buf_empty_int_clr";
            desc = "AOP0 cyclic buffer empty interrupt clear.";
            sw = rw;
            hw = r;
            encode = AOP0_INT_CLR_aop0_buf_empty_int_clr_enum;
            reset = 0x0;
        } aop0_buf_empty_int_clr[1:1];

        enum AOP0_INT_CLR_aop0_trans_int_clr_enum {
            NOT_CLEARED = 0 { name = "Not Cleared"; desc = "not cleared"; };
            CLEARED = 1 { name = "Cleared"; desc = "cleared"; };
        };

        field {
            name = "aop0_trans_int_clr";
            desc = "AOP0 transfer completion interrupt clear.";
            sw = rw;
            hw = r;
            encode = AOP0_INT_CLR_aop0_trans_int_clr_enum;
            reset = 0x0;
        } aop0_trans_int_clr[0:0];
    } AOP0_INT_CLR @ 0x202C;

    reg {
        name = "AOP0 cyclic buffer write address lock TMP register";
        desc = "AOP0_BUF_WPTR_TMP is an AOP0 cyclic buffer write address lock register.

Source: data sheet (Hi3520D/Hi3515A/Hi3515C user guide, 13.6 AOP0_BUF_WPTR_TMP, offset 0x2030, printed page 13-35), confidence HIGH: offset, fields, access and reset compared by script with the Chinese issue 02 edition on 2026-11-11, no difference. Not verified on hardware.";

        field {
            name = "aop0_buf_wptr_tmp";
            desc = "When an AOP0 transfer completion interrupt is generated, the value of aop0_buf_wptr is stored to aop0_buf_wptr_tmp until the next AOP0 transfer completion interrupt is generated.";
            sw = r;
            hw = w;
            reset = 0x0;
        } aop0_buf_wptr_tmp[23:0];
    } AOP0_BUF_WPTR_TMP @ 0x2030;

    reg {
        name = "AOP0 cyclic buffer read address lock TMP register";
        desc = "AOP0_BUF_RPTR_TMP is an AOP0 cyclic buffer read address lock register.

Source: data sheet (Hi3520D/Hi3515A/Hi3515C user guide, 13.6 AOP0_BUF_RPTR_TMP, offset 0x2034, printed page 13-35), confidence HIGH: offset, fields, access and reset compared by script with the Chinese issue 02 edition on 2026-11-11, no difference. Not verified on hardware.";

        field {
            name = "aop0_buf_rptr_tmp";
            desc = "When an AOP0 transfer completion interrupt is generated, the value of aop_buf_rptr is stored to aop0_buf_rptr_tmp until the next AOP0 transfer completion interrupt is generated.";
            sw = r;
            hw = w;
            reset = 0x0;
        } aop0_buf_rptr_tmp[23:0];
    } AOP0_BUF_RPTR_TMP @ 0x2034;

    reg {
        name = "AOP0 enable/disable control register";
        desc = "AOP0_STOP is an AOP0 enable/disable control register.

Source: data sheet (Hi3520D/Hi3515A/Hi3515C user guide, 13.6 AOP0_STOP, offset 0x2038, printed page 13-36), confidence HIGH: offset, fields, access and reset compared by script with the Chinese issue 02 edition on 2026-11-11, no difference. Not verified on hardware.";

        enum AOP0_STOP_aop0_stop_done_enum {
            NOT_COMPLETE = 0 { name = "Not Complete"; desc = "not complete"; };
            COMPLETE = 1 { name = "Complete"; desc = "complete"; };
        };

        field {
            name = "aop0_stop_done";
            desc = "AOP0 data transmission completion status.";
            sw = r;
            hw = w;
            encode = AOP0_STOP_aop0_stop_done_enum;
            reset = 0x1;
        } aop0_stop_done[1:1];

        enum AOP0_STOP_aop0_enable_enum {
            DISABLED = 0 { name = "Disabled"; desc = "disabled"; };
            ENABLED = 1 { name = "Enabled"; desc = "enabled"; };
        };

        field {
            name = "aop0_enable";
            desc = "AOP0 data transmission enable.";
            sw = rw;
            hw = r;
            encode = AOP0_STOP_aop0_enable_enum;
            reset = 0x0;
        } aop0_enable[0:0];
    } AOP0_STOP @ 0x2038;

    reg {
        name = "AOP1 attribute configuration register";
        desc = "AOP1_INF_ATTRI is an AOP1 attribute configuration register.

Source: data sheet (Hi3520D/Hi3515A/Hi3515C user guide, 13.6 AOP1_INF_ATTRI, offset 0x2100, printed page 13-37), confidence HIGH: offset, fields, access and reset compared by script with the Chinese issue 02 edition on 2026-11-11, no difference. Not verified on hardware.";

        enum AOP1_INF_ATTRI_aop1_samp_precision_enum {
            V_8_BITS = 0 { name = "V 8 Bits"; desc = "8 bits"; };
            V_16_BITS = 1 { name = "V 16 Bits"; desc = "16 bits"; };
            V_24_BITS = 2 { name = "V 24 Bits"; desc = "24 bits"; };
            V_32_BITS_IF = 3 { name = "V 32 Bits If"; desc = "32 bits If multi-channel TX is enabled, only the 8-/16-bit sampling accuracy is supported. If multi-channel TX is not enabled, the 8-/16-/24-/32-bit sampling accuracy is supported in I 2 S mode. The 8-/16-bit sampling accuracy is supported in PCM standard or customized mode."; };
        };

        field {
            name = "aop1_samp_precision";
            desc = "Sampling accuracy of data transmitted over AOP1.";
            sw = rw;
            hw = r;
            encode = AOP1_INF_ATTRI_aop1_samp_precision_enum;
            reset = 0x0;
        } aop1_samp_precision[11:10];

        enum AOP1_INF_ATTRI_aop1_clk_edge_sel_enum {
            TRANSMITTED_DATA_VALID = 0 { name = "Transmitted Data Valid"; desc = "The transmitted data is valid on the rising edge of the clock."; };
            TRANSMITTED_DATA_VALID_2 = 1 { name = "Transmitted Data Valid 2"; desc = "The transmitted data is valid on the falling edge of the clock."; };
        };

        field {
            name = "aop1_clk_edge_sel";
            desc = "Clock polarity select for data transmitted over AOP1.";
            sw = rw;
            hw = r;
            encode = AOP1_INF_ATTRI_aop1_clk_edge_sel_enum;
            reset = 0x0;
        } aop1_clk_edge_sel[7:7];

        enum AOP1_INF_ATTRI_aop1_timedivision_sel_enum {
            DISABLED = 0 { name = "Disabled"; desc = "disabled"; };
            ENABLED = 1 { name = "Enabled"; desc = "enabled"; };
        };

        field {
            name = "aop1_timedivision_sel";
            desc = "AOP1 multi-channel TX enable.";
            sw = rw;
            hw = r;
            encode = AOP1_INF_ATTRI_aop1_timedivision_sel_enum;
            reset = 0x0;
        } aop1_timedivision_sel[6:6];

        enum AOP1_INF_ATTRI_aop1_routes_sel_enum {
            V_2_CHANNELS = 0 { name = "V 2 Channels"; desc = "2 channels"; };
            V_4_CHANNELS = 1 { name = "V 4 Channels"; desc = "4 channels"; };
            V_8_CHANNELS = 2 { name = "V 8 Channels"; desc = "8 channels"; };
            V_16_CHANNELS = 3 { name = "V 16 Channels"; desc = "16 channels"; };
        };

        field {
            name = "aop1_routes_sel";
            desc = "Number of channels in AOP1 multi-channel TX mode.";
            sw = rw;
            hw = r;
            encode = AOP1_INF_ATTRI_aop1_routes_sel_enum;
            reset = 0x0;
        } aop1_routes_sel[5:4];

        enum AOP1_INF_ATTRI_aop1_mode_enum {
            I_2_S = 0 { name = "I 2 S"; desc = "I 2 S mode"; };
            PCM_STANDARD_MODE = 1 { name = "Pcm Standard Mode"; desc = "PCM standard mode"; };
            PCM_CUSTOMIZED_MODE = 2 { name = "Pcm Customized Mode"; desc = "PCM customized mode"; };
            RESERVED = 3 { name = "Reserved"; desc = "reserved"; };
        };

        field {
            name = "aop1_mode";
            desc = "AOP1 mode select.";
            sw = rw;
            hw = r;
            encode = AOP1_INF_ATTRI_aop1_mode_enum;
            reset = 0x0;
        } aop1_mode[1:0];
    } AOP1_INF_ATTRI @ 0x2100;

    reg {
        name = "AOP1 control register";
        desc = "AOP1_CTRL is an AOP1 control register.

Source: data sheet (Hi3520D/Hi3515A/Hi3515C user guide, 13.6 AOP1_CTRL, offset 0x2104, printed page 13-38), confidence HIGH: offset, fields, access and reset compared by script with the Chinese issue 02 edition on 2026-11-11, no difference. Not verified on hardware.";

        enum AOP1_CTRL_aop1_mute_enum {
            UNMUTED = 0 { name = "Unmuted"; desc = "unmuted"; };
            MUTE = 1 { name = "Mute"; desc = "mute"; };
        };

        field {
            name = "aop1_mute";
            desc = "Mute enable for AOP1 transmission.";
            sw = rw;
            hw = r;
            encode = AOP1_CTRL_aop1_mute_enum;
            reset = 0x0;
        } aop1_mute[15:15];
    } AOP1_CTRL @ 0x2104;

    reg {
        name = "AOP1 cyclic buffer start address register";
        desc = "AOP1_BUF_SADDR is an AOP1 cyclic buffer start address register.

Source: data sheet (Hi3520D/Hi3515A/Hi3515C user guide, 13.6 AOP1_BUF_SADDR, offset 0x2108, printed page 13-39), confidence HIGH: offset, fields, access and reset compared by script with the Chinese issue 02 edition on 2026-11-11, no difference. Not verified on hardware.";

        field {
            name = "aop1_buf_saddr";
            desc = "AOP1 cyclic buffer start address.";
            sw = rw;
            hw = r;
            reset = 0x0;
        } aop1_buf_saddr[31:0];
    } AOP1_BUF_SADDR @ 0x2108;

    reg {
        name = "AOP1 cyclic buffer size register";
        desc = "AOP1_BUF_SIZE is an AOP1 cyclic buffer size register.

Source: data sheet (Hi3520D/Hi3515A/Hi3515C user guide, 13.6 AOP1_BUF_SIZE, offset 0x210C, printed page 13-39), confidence HIGH: offset, fields, access and reset compared by script with the Chinese issue 02 edition on 2026-11-11, no difference. Not verified on hardware.";

        field {
            name = "aop1_buf_size";
            desc = "Size of the AOP1 cyclic buffer, in byte.";
            sw = rw;
            hw = r;
            reset = 0x200;
        } aop1_buf_size[23:0];
    } AOP1_BUF_SIZE @ 0x210C;

    reg {
        name = "AOP1 cyclic buffer write address register";
        desc = "AOP1_BUF_WPTR is an AOP1 cyclic buffer write address register.

Source: data sheet (Hi3520D/Hi3515A/Hi3515C user guide, 13.6 AOP1_BUF_WPTR, offset 0x2110, printed page 13-40), confidence HIGH: offset, fields, access and reset compared by script with the Chinese issue 02 edition on 2026-11-11, no difference. Not verified on hardware.";

        field {
            name = "aop1_buf_wptr";
            desc = "aop1_buf_wptr";
            sw = rw;
            hw = r;
            reset = 0x0;
        } aop1_buf_wptr[23:0];
    } AOP1_BUF_WPTR @ 0x2110;

    reg {
        name = "AOP1 cyclic buffer read address register";
        desc = "AOP1_BUF_RPTR is an AOP1 cyclic buffer read address register.

Source: data sheet (Hi3520D/Hi3515A/Hi3515C user guide, 13.6 AOP1_BUF_RPTR, offset 0x2114, printed page 13-40), confidence HIGH: offset, fields, access and reset compared by script with the Chinese issue 02 edition on 2026-11-11, no difference. Not verified on hardware.";

        field {
            name = "aop1_buf_rptr";
            desc = "Read address of the AOP1 cyclic buffer, in byte.";
            sw = rw;
            hw = r;
            reset = 0x0;
        } aop1_buf_rptr[23:0];
    } AOP1_BUF_RPTR @ 0x2114;

    reg {
        name = "AOP1 cyclic buffer almost empty threshold Y_TH register";
        desc = "AOP1_BUF_AEMPTY_TH is an AOP1 cyclic buffer almost empty threshold register.

Source: data sheet (Hi3520D/Hi3515A/Hi3515C user guide, 13.6 AOP1_BUF_AEMPTY_TH, offset 0x2118, printed page 13-41), confidence HIGH: offset, fields, access and reset compared by script with the Chinese issue 02 edition on 2026-11-11, no difference. Not verified on hardware.";

        field {
            name = "aop1_buf_aempty_th";
            desc = "Almost empty threshold of the AOP1 cyclic buffer, in byte. If the quantity of valid data in the AOP1 cyclic buffer is smaller than the threshold, an AOP1 cyclic buffer almost empty interrupt is generated.";
            sw = rw;
            hw = r;
            reset = 0x0;
        } aop1_buf_aempty_th[23:0];
    } AOP1_BUF_AEMPTY_TH @ 0x2118;

    reg {
        name = "AOP1 data transfer length register";
        desc = "AOP1_TRANS_SIZE is an AOP1 data transfer length register.

Source: data sheet (Hi3520D/Hi3515A/Hi3515C user guide, 13.6 AOP1_TRANS_SIZE, offset 0x211C, printed page 13-41), confidence HIGH: offset, fields, access and reset compared by script with the Chinese issue 02 edition on 2026-11-11, no difference. Not verified on hardware.";

        field {
            name = "aop1_trans_size";
            desc = "AOP1 data transfer length. An aop1_trans_int interrupt is generated when AOP1 has transmitted audio data whose length is aop1_trans_size (in byte).";
            sw = rw;
            hw = r;
            reset = 0x0;
        } aop1_trans_size[23:0];
    } AOP1_TRANS_SIZE @ 0x211C;

    reg {
        name = "AOP1 interrupt enable register";
        desc = "AOP1_INT_ENA is an AOP1 interrupt enable register.

Source: data sheet (Hi3520D/Hi3515A/Hi3515C user guide, 13.6 AOP1_INT_ENA, offset 0x2120, printed page 13-42), confidence HIGH: offset, fields, access and reset compared by script with the Chinese issue 02 edition on 2026-11-11, no difference. Not verified on hardware.";

        enum AOP1_INT_ENA_aop1_stop_int_en_enum {
            DISABLED = 0 { name = "Disabled"; desc = "disabled"; };
            ENABLED = 1 { name = "Enabled"; desc = "enabled"; };
        };

        field {
            name = "aop1_stop_int_en";
            desc = "AOP1 stop interrupt enable.";
            sw = rw;
            hw = r;
            encode = AOP1_INT_ENA_aop1_stop_int_en_enum;
            reset = 0x0;
        } aop1_stop_int_en[4:4];

        enum AOP1_INT_ENA_aop1_fifo_empty_int_en_enum {
            DISABLED = 0 { name = "Disabled"; desc = "disabled"; };
            ENABLED = 1 { name = "Enabled"; desc = "enabled"; };
        };

        field {
            name = "aop1_fifo_empty_int_en";
            desc = "AOP1 FIFO empty interrupt enable.";
            sw = rw;
            hw = r;
            encode = AOP1_INT_ENA_aop1_fifo_empty_int_en_enum;
            reset = 0x0;
        } aop1_fifo_empty_int_en[3:3];

        enum AOP1_INT_ENA_aop1_buf_aempty_int_en_enum {
            DISABLED = 0 { name = "Disabled"; desc = "disabled"; };
            ENABLED = 1 { name = "Enabled"; desc = "enabled"; };
        };

        field {
            name = "aop1_buf_aempty_int_en";
            desc = "AOP1 cyclic buffer almost empty interrupt enable.";
            sw = rw;
            hw = r;
            encode = AOP1_INT_ENA_aop1_buf_aempty_int_en_enum;
            reset = 0x0;
        } aop1_buf_aempty_int_en[2:2];

        enum AOP1_INT_ENA_aop1_buf_empty_int_en_enum {
            DISABLED = 0 { name = "Disabled"; desc = "disabled"; };
            ENABLED = 1 { name = "Enabled"; desc = "enabled"; };
        };

        field {
            name = "aop1_buf_empty_int_en";
            desc = "AOP1 cyclic buffer empty interrupt enable.";
            sw = rw;
            hw = r;
            encode = AOP1_INT_ENA_aop1_buf_empty_int_en_enum;
            reset = 0x0;
        } aop1_buf_empty_int_en[1:1];

        enum AOP1_INT_ENA_aop1_trans_int_en_enum {
            DISABLED = 0 { name = "Disabled"; desc = "disabled"; };
            ENABLED = 1 { name = "Enabled"; desc = "enabled"; };
        };

        field {
            name = "aop1_trans_int_en";
            desc = "AOP1 transfer completion interrupt enable.";
            sw = rw;
            hw = r;
            encode = AOP1_INT_ENA_aop1_trans_int_en_enum;
            reset = 0x0;
        } aop1_trans_int_en[0:0];
    } AOP1_INT_ENA @ 0x2120;

    reg {
        name = "Raw AOP1 interrupt register";
        desc = "AOP1_INT_RAW is a raw AOP1 interrupt register.

Source: data sheet (Hi3520D/Hi3515A/Hi3515C user guide, 13.6 AOP1_INT_RAW, offset 0x2124, printed page 13-43), confidence HIGH: offset, fields, access and reset compared by script with the Chinese issue 02 edition on 2026-11-11, no difference. Not verified on hardware.";

        enum AOP1_INT_RAW_aop1_stop_int_raw_enum {
            NO_RAW_INTERRUPT = 0 { name = "No Raw Interrupt"; desc = "No raw interrupt is generated."; };
            RAW_INTERRUPT_GENERATED = 1 { name = "Raw Interrupt Generated"; desc = "A raw interrupt is generated."; };
        };

        field {
            name = "aop1_stop_int_raw";
            desc = "Raw AOP1 stop interrupt.";
            sw = r;
            hw = w;
            encode = AOP1_INT_RAW_aop1_stop_int_raw_enum;
            reset = 0x0;
        } aop1_stop_int_raw[4:4];

        enum AOP1_INT_RAW_aop1_fifo_empty_int_raw_enum {
            NO_RAW_INTERRUPT = 0 { name = "No Raw Interrupt"; desc = "No raw interrupt is generated."; };
            RAW_INTERRUPT_GENERATED = 1 { name = "Raw Interrupt Generated"; desc = "A raw interrupt is generated."; };
        };

        field {
            name = "aop1_fifo_empty_int_raw";
            desc = "Raw AOP1 FIFO empty interrupt.";
            sw = r;
            hw = w;
            encode = AOP1_INT_RAW_aop1_fifo_empty_int_raw_enum;
            reset = 0x0;
        } aop1_fifo_empty_int_raw[3:3];

        enum AOP1_INT_RAW_aop1_buf_aempty_int_raw_enum {
            NO_RAW_INTERRUPT = 0 { name = "No Raw Interrupt"; desc = "No raw interrupt is generated."; };
            RAW_INTERRUPT_GENERATED = 1 { name = "Raw Interrupt Generated"; desc = "A raw interrupt is generated."; };
        };

        field {
            name = "aop1_buf_aempty_int_raw";
            desc = "Raw AOP1 cyclic buffer almost empty interrupt.";
            sw = r;
            hw = w;
            encode = AOP1_INT_RAW_aop1_buf_aempty_int_raw_enum;
            reset = 0x0;
        } aop1_buf_aempty_int_raw[2:2];

        enum AOP1_INT_RAW_aop1_buf_empty_int_raw_enum {
            NO_RAW_INTERRUPT = 0 { name = "No Raw Interrupt"; desc = "No raw interrupt is generated."; };
            RAW_INTERRUPT_GENERATED = 1 { name = "Raw Interrupt Generated"; desc = "A raw interrupt is generated."; };
        };

        field {
            name = "aop1_buf_empty_int_raw";
            desc = "Raw AOP1 cyclic buffer empty interrupt.";
            sw = r;
            hw = w;
            encode = AOP1_INT_RAW_aop1_buf_empty_int_raw_enum;
            reset = 0x0;
        } aop1_buf_empty_int_raw[1:1];

        enum AOP1_INT_RAW_aop1_trans_int_raw_enum {
            NO_RAW_INTERRUPT = 0 { name = "No Raw Interrupt"; desc = "No raw interrupt is generated."; };
            RAW_INTERRUPT_GENERATED = 1 { name = "Raw Interrupt Generated"; desc = "A raw interrupt is generated."; };
        };

        field {
            name = "aop1_trans_int_raw";
            desc = "Raw AOP1 transfer completion interrupt.";
            sw = r;
            hw = w;
            encode = AOP1_INT_RAW_aop1_trans_int_raw_enum;
            reset = 0x0;
        } aop1_trans_int_raw[0:0];
    } AOP1_INT_RAW @ 0x2124;

    reg {
        name = "AOP1 interrupt status register";
        desc = "AOP1_INT_STATUS is an AOP1 interrupt status register.

Source: data sheet (Hi3520D/Hi3515A/Hi3515C user guide, 13.6 AOP1_INT_STATUS, offset 0x2128, printed page 13-44), confidence HIGH: offset, fields, access and reset compared by script with the Chinese issue 02 edition on 2026-11-11, no difference. Not verified on hardware.";

        enum AOP1_INT_STATUS_aop1_stop_int_status_enum {
            NO_INTERRUPT_GENERATED = 0 { name = "No Interrupt Generated"; desc = "No interrupt is generated."; };
            INTERRUPT_GENERATED = 1 { name = "Interrupt Generated"; desc = "An interrupt is generated."; };
        };

        field {
            name = "aop1_stop_int_status";
            desc = "AOP1 stop interrupt status.";
            sw = r;
            hw = w;
            encode = AOP1_INT_STATUS_aop1_stop_int_status_enum;
            reset = 0x0;
        } aop1_stop_int_status[4:4];

        enum AOP1_INT_STATUS_aop1_fifo_empty_int_status_enum {
            NO_INTERRUPT_GENERATED = 0 { name = "No Interrupt Generated"; desc = "No interrupt is generated."; };
            INTERRUPT_GENERATED = 1 { name = "Interrupt Generated"; desc = "An interrupt is generated."; };
        };

        field {
            name = "aop1_fifo_empty_int_status";
            desc = "AOP1 FIFO empty interrupt status.";
            sw = r;
            hw = w;
            encode = AOP1_INT_STATUS_aop1_fifo_empty_int_status_enum;
            reset = 0x0;
        } aop1_fifo_empty_int_status[3:3];

        enum AOP1_INT_STATUS_aop1_buf_aempty_int_status_enum {
            NO_INTERRUPT_GENERATED = 0 { name = "No Interrupt Generated"; desc = "No interrupt is generated."; };
            INTERRUPT_GENERATED = 1 { name = "Interrupt Generated"; desc = "An interrupt is generated."; };
        };

        field {
            name = "aop1_buf_aempty_int_status";
            desc = "AOP1 cyclic buffer almost empty interrupt status.";
            sw = r;
            hw = w;
            encode = AOP1_INT_STATUS_aop1_buf_aempty_int_status_enum;
            reset = 0x0;
        } aop1_buf_aempty_int_status[2:2];

        enum AOP1_INT_STATUS_aop1_buf_empty_int_status_enum {
            NO_INTERRUPT_GENERATED = 0 { name = "No Interrupt Generated"; desc = "No interrupt is generated."; };
            INTERRUPT_GENERATED = 1 { name = "Interrupt Generated"; desc = "An interrupt is generated."; };
        };

        field {
            name = "aop1_buf_empty_int_status";
            desc = "AOP1 cyclic buffer empty interrupt status.";
            sw = r;
            hw = w;
            encode = AOP1_INT_STATUS_aop1_buf_empty_int_status_enum;
            reset = 0x0;
        } aop1_buf_empty_int_status[1:1];

        enum AOP1_INT_STATUS_aop1_trans_int_status_enum {
            NO_INTERRUPT_GENERATED = 0 { name = "No Interrupt Generated"; desc = "No interrupt is generated."; };
            INTERRUPT_GENERATED = 1 { name = "Interrupt Generated"; desc = "An interrupt is generated."; };
        };

        field {
            name = "aop1_trans_int_status";
            desc = "AOP1 transfer completion interrupt status.";
            sw = r;
            hw = w;
            encode = AOP1_INT_STATUS_aop1_trans_int_status_enum;
            reset = 0x0;
        } aop1_trans_int_status[0:0];
    } AOP1_INT_STATUS @ 0x2128;

    reg {
        name = "AOP1 interrupt clear register";
        desc = "AOP1_INT_CLR is an AOP1 interrupt clear register.

Source: data sheet (Hi3520D/Hi3515A/Hi3515C user guide, 13.6 AOP1_INT_CLR, offset 0x212C, printed page 13-45), confidence HIGH: offset, fields, access and reset compared by script with the Chinese issue 02 edition on 2026-11-11, no difference. Not verified on hardware.";

        enum AOP1_INT_CLR_aop1_stop_int_clr_enum {
            NOT_CLEARED = 0 { name = "Not Cleared"; desc = "not cleared"; };
            CLEARED = 1 { name = "Cleared"; desc = "cleared"; };
        };

        field {
            name = "aop1_stop_int_clr";
            desc = "AOP1 stop interrupt clear.";
            sw = rw;
            hw = r;
            encode = AOP1_INT_CLR_aop1_stop_int_clr_enum;
            reset = 0x0;
        } aop1_stop_int_clr[4:4];

        enum AOP1_INT_CLR_aop1_fifo_empty_int_clr_enum {
            NOT_CLEARED = 0 { name = "Not Cleared"; desc = "not cleared"; };
            CLEARED = 1 { name = "Cleared"; desc = "cleared"; };
        };

        field {
            name = "aop1_fifo_empty_int_clr";
            desc = "AOP1 FIFO empty interrupt clear.";
            sw = rw;
            hw = r;
            encode = AOP1_INT_CLR_aop1_fifo_empty_int_clr_enum;
            reset = 0x0;
        } aop1_fifo_empty_int_clr[3:3];

        enum AOP1_INT_CLR_aop1_buf_aempty_int_clr_enum {
            NOT_CLEARED = 0 { name = "Not Cleared"; desc = "not cleared"; };
            CLEARED = 1 { name = "Cleared"; desc = "cleared"; };
        };

        field {
            name = "aop1_buf_aempty_int_clr";
            desc = "AOP1 cyclic buffer almost empty interrupt clear.";
            sw = rw;
            hw = r;
            encode = AOP1_INT_CLR_aop1_buf_aempty_int_clr_enum;
            reset = 0x0;
        } aop1_buf_aempty_int_clr[2:2];

        enum AOP1_INT_CLR_aop1_buf_empty_int_clr_enum {
            NOT_CLEARED = 0 { name = "Not Cleared"; desc = "not cleared"; };
            CLEARED = 1 { name = "Cleared"; desc = "cleared"; };
        };

        field {
            name = "aop1_buf_empty_int_clr";
            desc = "AOP1 cyclic buffer empty interrupt clear.";
            sw = rw;
            hw = r;
            encode = AOP1_INT_CLR_aop1_buf_empty_int_clr_enum;
            reset = 0x0;
        } aop1_buf_empty_int_clr[1:1];

        enum AOP1_INT_CLR_aop1_trans_int_clr_enum {
            NOT_CLEARED = 0 { name = "Not Cleared"; desc = "not cleared"; };
            CLEARED = 1 { name = "Cleared"; desc = "cleared"; };
        };

        field {
            name = "aop1_trans_int_clr";
            desc = "AOP1 transfer completion interrupt clear.";
            sw = rw;
            hw = r;
            encode = AOP1_INT_CLR_aop1_trans_int_clr_enum;
            reset = 0x0;
        } aop1_trans_int_clr[0:0];
    } AOP1_INT_CLR @ 0x212C;

    reg {
        name = "AOP1 cyclic buffer write address lock TMP register";
        desc = "AOP1_BUF_WPTR_TMP is an AOP1 cyclic buffer write address lock register.

Source: data sheet (Hi3520D/Hi3515A/Hi3515C user guide, 13.6 AOP1_BUF_WPTR_TMP, offset 0x2130, printed page 13-46), confidence HIGH: offset, fields, access and reset compared by script with the Chinese issue 02 edition on 2026-11-11, no difference. Not verified on hardware.";

        field {
            name = "aop1_buf_wptr_tmp";
            desc = "When an AOP1 transfer completion interrupt is generated, the value of aop1_buf_wptr is stored to aop1_buf_wptr_tmp until the next AOP1 transfer completion interrupt is generated.";
            sw = r;
            hw = w;
            reset = 0x0;
        } aop1_buf_wptr_tmp[23:0];
    } AOP1_BUF_WPTR_TMP @ 0x2130;

    reg {
        name = "AOP1 cyclic buffer read address lock TMP register";
        desc = "AOP1_BUF_RPTR_TMP is an AOP1 cyclic buffer read address lock register.

Source: data sheet (Hi3520D/Hi3515A/Hi3515C user guide, 13.6 AOP1_BUF_RPTR_TMP, offset 0x2134, printed page 13-46), confidence HIGH: offset, fields, access and reset compared by script with the Chinese issue 02 edition on 2026-11-11, no difference. Not verified on hardware.";

        field {
            name = "aop1_buf_rptr_tmp";
            desc = "When an AOP1 transfer completion interrupt is generated, the value of aop_buf_rptr is stored to aop1_buf_rptr_tmp until the next AOP1 transfer completion interrupt is generated.";
            sw = r;
            hw = w;
            reset = 0x0;
        } aop1_buf_rptr_tmp[23:0];
    } AOP1_BUF_RPTR_TMP @ 0x2134;

    reg {
        name = "AOP1 enable/disable control register";
        desc = "AOP1_STOP is an AOP1 enable/disable control register.

Source: data sheet (Hi3520D/Hi3515A/Hi3515C user guide, 13.6 AOP1_STOP, offset 0x2138, printed page 13-47), confidence HIGH: offset, fields, access and reset compared by script with the Chinese issue 02 edition on 2026-11-11, no difference. Not verified on hardware.";

        enum AOP1_STOP_aop1_stop_done_enum {
            NOT_COMPLETE = 0 { name = "Not Complete"; desc = "not complete"; };
            COMPLETE = 1 { name = "Complete"; desc = "complete"; };
        };

        field {
            name = "aop1_stop_done";
            desc = "AOP1 data transmission completion status.";
            sw = r;
            hw = w;
            encode = AOP1_STOP_aop1_stop_done_enum;
            reset = 0x1;
        } aop1_stop_done[1:1];

        enum AOP1_STOP_aop1_enable_enum {
            DISABLED = 0 { name = "Disabled"; desc = "disabled"; };
            ENABLED = 1 { name = "Enabled"; desc = "enabled"; };
        };

        field {
            name = "aop1_enable";
            desc = "AOP1 data transmission enable.";
            sw = rw;
            hw = r;
            encode = AOP1_STOP_aop1_enable_enum;
            reset = 0x0;
        } aop1_enable[0:0];
    } AOP1_STOP @ 0x2138;

};

`endif
