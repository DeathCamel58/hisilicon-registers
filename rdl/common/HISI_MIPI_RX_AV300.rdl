`ifndef HISI_MIPI_RX_AV300_RDL
`define HISI_MIPI_RX_AV300_RDL


regfile eHISI_MIPI_RX_AV300 {
    name = "MIPI Rx (sensor serial interface receiver, Hi3516A V300)";
    desc = "MIPI Rx (combo PHY + controller for MIPI D-PHY CSI-2, LVDS/HiSPi and CMOS sensors, feeding the VICAP) of the Hi3516A V300 at 0x113A0000 (64 KB, data sheet chapter 9.3; interrupt 89 in the data sheet interrupt table). Layout: one PHY link block at 0x0 (PHY_*_LINK, CIL interrupts 0x1F0), channel/system registers at 0x800 (HS_MODE_SELECT: 4-lane or 2+2 lane scene, PHY_EN, LANE_EN, CHN0/CHN1 memory and clear control), MIPI_INT_* at 0xFF0, then two combo-device windows N = 0 and 1 at +0x1000 each: MIPI controller (MIPIN_*, 0x1004..), LVDS controller (LVDSN_*, 0x1300..), lane-ID map (LANE_ID0_CHNN 0x1800), ALIGNN_INT_* (0x18F0) and CHNN_INT_* (0x1FF0). The data sheet writes the offsets with the variables N (device, stride 0x1000) and M (lane 0..3 on device 0, 0..1 on device 1, stride 0x20); this regfile expands them into explicit registers (MIPI0_*, MIPI1_*, LVDS0_LANE2_SOF_01 ...). The data sheet heading CHN_INT_MASK (offset 0x1FF8 + N x 0x1000) is named CHNN_INT_MASK here like the CHNN_INT_RAW/CHNN_INT registers next to it. MIPI_CIL_INT_MSK_LINK fields are named err3_* in the data sheet while the RAW and status registers use err0_* (kept as printed). The register tables of this data sheet carry a diagonal watermark that corrupts the text extraction: field names were reconstructed by a custom parser (scripts/rdl-extract/parse_av300_mipi.py) and cleaned of watermark fragments; total reset values are taken from the 'Total Reset Value' lines. Different from the Hi3516A V200 / Hi3519 `eHISI_MIPI_RX_AV200` (no register name in common). The data sheet of this chip is Chinese-only: this block transcribes register offsets, names, bit ranges, access types and reset values from the data sheet register tables; the Chinese description text and value encodings were NOT translated, so every description here is generated from the register or field name. Generated 2026-11-15 by scripts/rdl-extract/gen_m_cells.py from the data sheet register tables (ds_extract2 + description extraction from the PDF); PROVENANCE: PROVEN = offsets, names, bit fields, access and reset values from the data sheet tables; nothing here is hardware verified.

    Register sources: 242 registers from the data sheet (hi3516av300--Hi3516AV300-Datasheet.txt, section 9.3.6). ";

    reg {
        name = "PHY_MODE_LINK";
        desc = "Data sheet 9.3.6 PHY_MODE_LINK (offset 0x0, printed page 9-139, `hi3516av300--Hi3516AV300-Datasheet.txt` line 42667).";

        field {
            name = "phy0_rg_mipi_mode1";
            desc = "Phy0 rg mipi mode1. Chinese-only data sheet: description and value encoding not translated.";
            sw = rw;
            hw = r;
            reset = 0x0;
        } phy0_rg_mipi_mode1[25:25];

        field {
            name = "phy0_rg_mipi_mode0";
            desc = "Phy0 rg mipi mode0. Chinese-only data sheet: description and value encoding not translated.";
            sw = rw;
            hw = r;
            reset = 0x0;
        } phy0_rg_mipi_mode0[24:24];

        field {
            name = "phy0_rg_en_2l2l";
            desc = "Phy0 rg enable 2l2l. Chinese-only data sheet: description and value encoding not translated.";
            sw = rw;
            hw = r;
            reset = 0x0;
        } phy0_rg_en_2l2l[20:20];

        field {
            name = "phy0_rg_faclk1_en";
            desc = "Phy0 rg faclk1 enable. Chinese-only data sheet: description and value encoding not translated.";
            sw = rw;
            hw = r;
            reset = 0x0;
        } phy0_rg_faclk1_en[17:17];

        field {
            name = "phy0_rg_faclk0_en";
            desc = "Phy0 rg faclk0 enable. Chinese-only data sheet: description and value encoding not translated.";
            sw = rw;
            hw = r;
            reset = 0x0;
        } phy0_rg_faclk0_en[16:16];

        field {
            name = "phy0_rg_en_lp1";
            desc = "Phy0 rg enable lp1. Chinese-only data sheet: description and value encoding not translated.";
            sw = rw;
            hw = r;
            reset = 0x0;
        } phy0_rg_en_lp1[13:13];

        field {
            name = "phy0_rg_en_lp0";
            desc = "Phy0 rg enable lp0. Chinese-only data sheet: description and value encoding not translated.";
            sw = rw;
            hw = r;
            reset = 0x0;
        } phy0_rg_en_lp0[12:12];

        field {
            name = "phy0_rg_en_cmos";
            desc = "Phy0 rg enable cmos. Chinese-only data sheet: description and value encoding not translated.";
            sw = rw;
            hw = r;
            reset = 0x0;
        } phy0_rg_en_cmos[8:8];

        field {
            name = "phy0_rg_en_clk1";
            desc = "Phy0 rg enable clk1. Chinese-only data sheet: description and value encoding not translated.";
            sw = rw;
            hw = r;
            reset = 0x0;
        } phy0_rg_en_clk1[5:5];

        field {
            name = "phy0_rg_en_clk0";
            desc = "Phy0 rg enable clk0. Chinese-only data sheet: description and value encoding not translated.";
            sw = rw;
            hw = r;
            reset = 0x0;
        } phy0_rg_en_clk0[4:4];

        field {
            name = "phy0_rg_en_d";
            desc = "Phy0 rg enable d. Chinese-only data sheet: description and value encoding not translated.";
            sw = rw;
            hw = r;
            reset = 0x0;
        } phy0_rg_en_d[3:0];
    } PHY_MODE_LINK @ 0x0;

    reg {
        name = "PHY_SKEW_LINK";
        desc = "Data sheet 9.3.6 PHY_SKEW_LINK (offset 0x4, printed page 9-140, `hi3516av300--Hi3516AV300-Datasheet.txt` line 42783).";

        field {
            name = "phy0_d3_skew";
            desc = "Phy0 d3 skew. Chinese-only data sheet: description and value encoding not translated.";
            sw = rw;
            hw = r;
            reset = 0x0;
        } phy0_d3_skew[22:20];

        field {
            name = "phy0_d2_skew";
            desc = "Phy0 d2 skew. Chinese-only data sheet: description and value encoding not translated.";
            sw = rw;
            hw = r;
            reset = 0x0;
        } phy0_d2_skew[18:16];

        field {
            name = "phy0_d1_skew";
            desc = "Phy0 d1 skew. Chinese-only data sheet: description and value encoding not translated.";
            sw = rw;
            hw = r;
            reset = 0x0;
        } phy0_d1_skew[14:12];

        field {
            name = "phy0_d0_skew";
            desc = "Phy0 d0 skew. Chinese-only data sheet: description and value encoding not translated.";
            sw = rw;
            hw = r;
            reset = 0x0;
        } phy0_d0_skew[10:8];

        field {
            name = "phy0_clk1_skew";
            desc = "Phy0 clk1 skew. Chinese-only data sheet: description and value encoding not translated.";
            sw = rw;
            hw = r;
            reset = 0x0;
        } phy0_clk1_skew[6:4];

        field {
            name = "phy0_clk0_skew";
            desc = "Phy0 clk0 skew. Chinese-only data sheet: description and value encoding not translated.";
            sw = rw;
            hw = r;
            reset = 0x0;
        } phy0_clk0_skew[2:0];
    } PHY_SKEW_LINK @ 0x4;

    reg {
        name = "PHY_EN_LINK";
        desc = "Data sheet 9.3.6 PHY_EN_LINK (offset 0xC, printed page 9-141, `hi3516av300--Hi3516AV300-Datasheet.txt` line 42841).";

        field {
            name = "phy_clk1_term_en";
            desc = "PHY clk1 term enable. Chinese-only data sheet: description and value encoding not translated.";
            sw = rw;
            hw = r;
            reset = 0x0;
        } phy_clk1_term_en[13:13];

        field {
            name = "phy_clk0_term_en";
            desc = "PHY clk0 term enable. Chinese-only data sheet: description and value encoding not translated.";
            sw = rw;
            hw = r;
            reset = 0x0;
        } phy_clk0_term_en[12:12];

        field {
            name = "phy_d3_term_en";
            desc = "PHY d3 term enable. Chinese-only data sheet: description and value encoding not translated.";
            sw = rw;
            hw = r;
            reset = 0x0;
        } phy_d3_term_en[11:11];

        field {
            name = "phy_d2_term_en";
            desc = "PHY d2 term enable. Chinese-only data sheet: description and value encoding not translated.";
            sw = rw;
            hw = r;
            reset = 0x0;
        } phy_d2_term_en[10:10];

        field {
            name = "phy_d1_term_en";
            desc = "PHY d1 term enable. Chinese-only data sheet: description and value encoding not translated.";
            sw = rw;
            hw = r;
            reset = 0x0;
        } phy_d1_term_en[9:9];

        field {
            name = "phy_d0_term_en";
            desc = "PHY d0 term enable. Chinese-only data sheet: description and value encoding not translated.";
            sw = rw;
            hw = r;
            reset = 0x0;
        } phy_d0_term_en[8:8];

        field {
            name = "phy_da_d3_valid";
            desc = "PHY da d3 valid. Chinese-only data sheet: description and value encoding not translated.";
            sw = rw;
            hw = r;
            reset = 0x0;
        } phy_da_d3_valid[3:3];

        field {
            name = "phy_da_d2_valid";
            desc = "PHY da d2 valid. Chinese-only data sheet: description and value encoding not translated.";
            sw = rw;
            hw = r;
            reset = 0x0;
        } phy_da_d2_valid[2:2];

        field {
            name = "phy_da_d1_valid";
            desc = "PHY da d1 valid. Chinese-only data sheet: description and value encoding not translated.";
            sw = rw;
            hw = r;
            reset = 0x0;
        } phy_da_d1_valid[1:1];

        field {
            name = "phy_da_d0_valid";
            desc = "PHY da d0 valid. Chinese-only data sheet: description and value encoding not translated.";
            sw = rw;
            hw = r;
            reset = 0x0;
        } phy_da_d0_valid[0:0];
    } PHY_EN_LINK @ 0xC;

    reg {
        name = "PHY_DATA_LINK";
        desc = "Data sheet 9.3.6 PHY_DATA_LINK (offset 0x18, printed page 9-142, `hi3516av300--Hi3516AV300-Datasheet.txt` line 42926).";

        field {
            name = "phy_data3_mipi";
            desc = "PHY data3 mipi. Chinese-only data sheet: description and value encoding not translated.";
            sw = r;
            hw = w;
            reset = 0x0;
        } phy_data3_mipi[31:24];

        field {
            name = "phy_data2_mipi";
            desc = "PHY data2 mipi. Chinese-only data sheet: description and value encoding not translated.";
            sw = r;
            hw = w;
            reset = 0x0;
        } phy_data2_mipi[23:16];

        field {
            name = "phy_data1_mipi";
            desc = "PHY data1 mipi. Chinese-only data sheet: description and value encoding not translated.";
            sw = r;
            hw = w;
            reset = 0x0;
        } phy_data1_mipi[15:8];

        field {
            name = "phy_data0_mipi";
            desc = "PHY data0 mipi. Chinese-only data sheet: description and value encoding not translated.";
            sw = r;
            hw = w;
            reset = 0x0;
        } phy_data0_mipi[7:0];
    } PHY_DATA_LINK @ 0x18;

    reg {
        name = "PHY_PH_MIPI_LINK";
        desc = "Data sheet 9.3.6 PHY_PH_MIPI_LINK (offset 0x1C, printed page 9-143, `hi3516av300--Hi3516AV300-Datasheet.txt` line 42947).";

        field {
            name = "phy_ph3_mipi";
            desc = "PHY ph3 mipi. Chinese-only data sheet: description and value encoding not translated.";
            sw = r;
            hw = w;
            reset = 0x0;
        } phy_ph3_mipi[31:24];

        field {
            name = "phy_ph2_mipi";
            desc = "PHY ph2 mipi. Chinese-only data sheet: description and value encoding not translated.";
            sw = r;
            hw = w;
            reset = 0x0;
        } phy_ph2_mipi[23:16];

        field {
            name = "phy_ph1_mipi";
            desc = "PHY ph1 mipi. Chinese-only data sheet: description and value encoding not translated.";
            sw = r;
            hw = w;
            reset = 0x0;
        } phy_ph1_mipi[15:8];

        field {
            name = "phy_ph0_mipi";
            desc = "PHY ph0 mipi. Chinese-only data sheet: description and value encoding not translated.";
            sw = r;
            hw = w;
            reset = 0x0;
        } phy_ph0_mipi[7:0];
    } PHY_PH_MIPI_LINK @ 0x1C;

    reg {
        name = "PHY_DATA_MIPI_LINK";
        desc = "Data sheet 9.3.6 PHY_DATA_MIPI_LINK (offset 0x20, printed page 9-143, `hi3516av300--Hi3516AV300-Datasheet.txt` line 42966).";

        field {
            name = "phy_data3_mipi_hs";
            desc = "PHY data3 mipi horizontal sync. Chinese-only data sheet: description and value encoding not translated.";
            sw = r;
            hw = w;
            reset = 0x0;
        } phy_data3_mipi_hs[31:24];

        field {
            name = "phy_data2_mipi_hs";
            desc = "PHY data2 mipi horizontal sync. Chinese-only data sheet: description and value encoding not translated.";
            sw = r;
            hw = w;
            reset = 0x0;
        } phy_data2_mipi_hs[23:16];

        field {
            name = "phy_data1_mipi_hs";
            desc = "PHY data1 mipi horizontal sync. Chinese-only data sheet: description and value encoding not translated.";
            sw = r;
            hw = w;
            reset = 0x0;
        } phy_data1_mipi_hs[15:8];

        field {
            name = "phy_data0_mipi_hs";
            desc = "PHY data0 mipi horizontal sync. Chinese-only data sheet: description and value encoding not translated.";
            sw = r;
            hw = w;
            reset = 0xC;
        } phy_data0_mipi_hs[7:0];
    } PHY_DATA_MIPI_LINK @ 0x20;

    reg {
        name = "PHY_SYNC_DCT_LINK";
        desc = "Data sheet 9.3.6 PHY_SYNC_DCT_LINK (offset 0x24, printed page 9-143, `hi3516av300--Hi3516AV300-Datasheet.txt` line 42995).";

        field {
            name = "cil_code_big_endian1";
            desc = "Cil code big endian1. Chinese-only data sheet: description and value encoding not translated.";
            sw = rw;
            hw = r;
            reset = 0x1;
        } cil_code_big_endian1[20:20];

        field {
            name = "cil_raw_type1";
            desc = "Cil raw type1. Chinese-only data sheet: description and value encoding not translated.";
            sw = rw;
            hw = r;
            reset = 0x1;
        } cil_raw_type1[14:12];

        field {
            name = "cil_code_big_endian0";
            desc = "Cil code big endian0. Chinese-only data sheet: description and value encoding not translated.";
            sw = rw;
            hw = r;
            reset = 0x1;
        } cil_code_big_endian0[8:8];

        field {
            name = "cil_raw_type0";
            desc = "Cil raw type0. Chinese-only data sheet: description and value encoding not translated.";
            sw = rw;
            hw = r;
            reset = 0x1;
        } cil_raw_type0[2:0];
    } PHY_SYNC_DCT_LINK @ 0x24;

    reg {
        name = "PHY_SYNC_SOF0_LINK";
        desc = "Data sheet 9.3.6 PHY_SYNC_SOF0_LINK (offset 0x30, printed page 9-144, `hi3516av300--Hi3516AV300-Datasheet.txt` line 43072).";

        field {
            name = "cil_sof1_word4_0";
            desc = "Cil sof1 word4 0. Chinese-only data sheet: description and value encoding not translated.";
            sw = rw;
            hw = r;
            reset = 0x0;
        } cil_sof1_word4_0[31:16];

        field {
            name = "cil_sof0_word4_0";
            desc = "Cil sof0 word4 0. Chinese-only data sheet: description and value encoding not translated.";
            sw = rw;
            hw = r;
            reset = 0x0;
        } cil_sof0_word4_0[15:0];
    } PHY_SYNC_SOF0_LINK @ 0x30;

    reg {
        name = "PHY_SYNC_SOF1_LINK";
        desc = "Data sheet 9.3.6 PHY_SYNC_SOF1_LINK (offset 0x34, printed page 9-145, `hi3516av300--Hi3516AV300-Datasheet.txt` line 43089).";

        field {
            name = "cil_sof1_word4_1";
            desc = "Cil sof1 word4 1. Chinese-only data sheet: description and value encoding not translated.";
            sw = rw;
            hw = r;
            reset = 0x0;
        } cil_sof1_word4_1[31:16];

        field {
            name = "cil_sof0_word4_1";
            desc = "Cil sof0 word4 1. Chinese-only data sheet: description and value encoding not translated.";
            sw = rw;
            hw = r;
            reset = 0x0;
        } cil_sof0_word4_1[15:0];
    } PHY_SYNC_SOF1_LINK @ 0x34;

    reg {
        name = "PHY_SYNC_SOF2_LINK";
        desc = "Data sheet 9.3.6 PHY_SYNC_SOF2_LINK (offset 0x38, printed page 9-145, `hi3516av300--Hi3516AV300-Datasheet.txt` line 43103).";

        field {
            name = "cil_sof1_word4_2";
            desc = "Cil sof1 word4 2. Chinese-only data sheet: description and value encoding not translated.";
            sw = rw;
            hw = r;
            reset = 0x0;
        } cil_sof1_word4_2[31:16];

        field {
            name = "cil_sof0_word4_2";
            desc = "Cil sof0 word4 2. Chinese-only data sheet: description and value encoding not translated.";
            sw = rw;
            hw = r;
            reset = 0x0;
        } cil_sof0_word4_2[15:0];
    } PHY_SYNC_SOF2_LINK @ 0x38;

    reg {
        name = "PHY_SYNC_SOF3_LINK";
        desc = "Data sheet 9.3.6 PHY_SYNC_SOF3_LINK (offset 0x3C, printed page 9-145, `hi3516av300--Hi3516AV300-Datasheet.txt` line 43126).";

        field {
            name = "cil_sof1_word4_3";
            desc = "Cil sof1 word4 3. Chinese-only data sheet: description and value encoding not translated.";
            sw = rw;
            hw = r;
            reset = 0x0;
        } cil_sof1_word4_3[31:16];

        field {
            name = "cil_sof0_word4_3";
            desc = "Cil sof0 word4 3. Chinese-only data sheet: description and value encoding not translated.";
            sw = rw;
            hw = r;
            reset = 0x0;
        } cil_sof0_word4_3[15:0];
    } PHY_SYNC_SOF3_LINK @ 0x3C;

    reg {
        name = "PHY_ST2_LINK";
        desc = "Data sheet 9.3.6 PHY_ST2_LINK (offset 0x118, printed page 9-145, `hi3516av300--Hi3516AV300-Datasheet.txt` line 43144).";

        field {
            name = "physt_clk1_term_en";
            desc = "Physt clk1 term enable. Chinese-only data sheet: description and value encoding not translated.";
            sw = r;
            hw = w;
            reset = 0x0;
        } physt_clk1_term_en[13:13];

        field {
            name = "physt_clk0_term_en";
            desc = "Physt clk0 term enable. Chinese-only data sheet: description and value encoding not translated.";
            sw = r;
            hw = w;
            reset = 0x0;
        } physt_clk0_term_en[12:12];

        field {
            name = "physt_d3_term_en";
            desc = "Physt d3 term enable. Chinese-only data sheet: description and value encoding not translated.";
            sw = r;
            hw = w;
            reset = 0x0;
        } physt_d3_term_en[11:11];

        field {
            name = "physt_d2_term_en";
            desc = "Physt d2 term enable. Chinese-only data sheet: description and value encoding not translated.";
            sw = r;
            hw = w;
            reset = 0x0;
        } physt_d2_term_en[10:10];

        field {
            name = "physt_d1_term_en";
            desc = "Physt d1 term enable. Chinese-only data sheet: description and value encoding not translated.";
            sw = r;
            hw = w;
            reset = 0x0;
        } physt_d1_term_en[9:9];

        field {
            name = "physt_d0_term_en";
            desc = "Physt d0 term enable. Chinese-only data sheet: description and value encoding not translated.";
            sw = r;
            hw = w;
            reset = 0x0;
        } physt_d0_term_en[8:8];
    } PHY_ST2_LINK @ 0x118;

    reg {
        name = "MIPI_CIL_INT_RAW_LINK";
        desc = "Data sheet 9.3.6 MIPI_CIL_INT_RAW_LINK (offset 0x1F0, printed page 9-146, `hi3516av300--Hi3516AV300-Datasheet.txt` line 43203).";

        field {
            name = "err0_timeout_ck1_raw";
            desc = "Err0 timeout ck1 raw. Chinese-only data sheet: description and value encoding not translated.";
            sw = rw;
            hw = w;
            onwrite = woclr;
            reset = 0x0;
        } err0_timeout_ck1_raw[13:13];

        field {
            name = "err0_timeout_ck0_raw";
            desc = "Err0 timeout ck0 raw. Chinese-only data sheet: description and value encoding not translated.";
            sw = rw;
            hw = w;
            onwrite = woclr;
            reset = 0x0;
        } err0_timeout_ck0_raw[12:12];

        field {
            name = "err0_timeout_d3_raw";
            desc = "Err0 timeout d3 raw. Chinese-only data sheet: description and value encoding not translated.";
            sw = rw;
            hw = w;
            onwrite = woclr;
            reset = 0x0;
        } err0_timeout_d3_raw[11:11];

        field {
            name = "err0_timeout_d2_raw";
            desc = "Err0 timeout d2 raw. Chinese-only data sheet: description and value encoding not translated.";
            sw = rw;
            hw = w;
            onwrite = woclr;
            reset = 0x0;
        } err0_timeout_d2_raw[10:10];

        field {
            name = "err0_timeout_d1_raw";
            desc = "Err0 timeout d1 raw. Chinese-only data sheet: description and value encoding not translated.";
            sw = rw;
            hw = w;
            onwrite = woclr;
            reset = 0x0;
        } err0_timeout_d1_raw[9:9];

        field {
            name = "err0_timeout_d0_raw";
            desc = "Err0 timeout d0 raw. Chinese-only data sheet: description and value encoding not translated.";
            sw = rw;
            hw = w;
            onwrite = woclr;
            reset = 0x0;
        } err0_timeout_d0_raw[8:8];

        field {
            name = "err0_escape_ck1_raw";
            desc = "Err0 escape ck1 raw. Chinese-only data sheet: description and value encoding not translated.";
            sw = rw;
            hw = w;
            onwrite = woclr;
            reset = 0x0;
        } err0_escape_ck1_raw[5:5];

        field {
            name = "err0_escape_ck0_raw";
            desc = "Err0 escape ck0 raw. Chinese-only data sheet: description and value encoding not translated.";
            sw = rw;
            hw = w;
            onwrite = woclr;
            reset = 0x0;
        } err0_escape_ck0_raw[4:4];

        field {
            name = "err0_escape_d3_raw";
            desc = "Err0 escape d3 raw. Chinese-only data sheet: description and value encoding not translated.";
            sw = rw;
            hw = w;
            onwrite = woclr;
            reset = 0x0;
        } err0_escape_d3_raw[3:3];

        field {
            name = "err0_escape_d2_raw";
            desc = "Err0 escape d2 raw. Chinese-only data sheet: description and value encoding not translated.";
            sw = rw;
            hw = w;
            onwrite = woclr;
            reset = 0x0;
        } err0_escape_d2_raw[2:2];

        field {
            name = "err0_escape_d1_raw";
            desc = "Err0 escape d1 raw. Chinese-only data sheet: description and value encoding not translated.";
            sw = rw;
            hw = w;
            onwrite = woclr;
            reset = 0x0;
        } err0_escape_d1_raw[1:1];

        field {
            name = "err0_escape_d0_raw";
            desc = "Err0 escape d0 raw. Chinese-only data sheet: description and value encoding not translated.";
            sw = rw;
            hw = w;
            onwrite = woclr;
            reset = 0x0;
        } err0_escape_d0_raw[0:0];
    } MIPI_CIL_INT_RAW_LINK @ 0x1F0;

    reg {
        name = "MIPI_CIL_INT_LINK";
        desc = "Data sheet 9.3.6 MIPI_CIL_INT_LINK (offset 0x1F4, printed page 9-147, `hi3516av300--Hi3516AV300-Datasheet.txt` line 43303).";

        field {
            name = "err0_timeout_ck1_st";
            desc = "Err0 timeout ck1 st. Chinese-only data sheet: description and value encoding not translated.";
            sw = r;
            hw = w;
            reset = 0x0;
        } err0_timeout_ck1_st[13:13];

        field {
            name = "err0_timeout_ck0_st";
            desc = "Err0 timeout ck0 st. Chinese-only data sheet: description and value encoding not translated.";
            sw = r;
            hw = w;
            reset = 0x0;
        } err0_timeout_ck0_st[12:12];

        field {
            name = "err0_timeout_d3_st";
            desc = "Err0 timeout d3 st. Chinese-only data sheet: description and value encoding not translated.";
            sw = r;
            hw = w;
            reset = 0x0;
        } err0_timeout_d3_st[11:11];

        field {
            name = "err0_timeout_d2_st";
            desc = "Err0 timeout d2 st. Chinese-only data sheet: description and value encoding not translated.";
            sw = r;
            hw = w;
            reset = 0x0;
        } err0_timeout_d2_st[10:10];

        field {
            name = "err0_timeout_d1_st";
            desc = "Err0 timeout d1 st. Chinese-only data sheet: description and value encoding not translated.";
            sw = r;
            hw = w;
            reset = 0x0;
        } err0_timeout_d1_st[9:9];

        field {
            name = "err0_timeout_d0_st";
            desc = "Err0 timeout d0 st. Chinese-only data sheet: description and value encoding not translated.";
            sw = r;
            hw = w;
            reset = 0x0;
        } err0_timeout_d0_st[8:8];

        field {
            name = "err0_escape_ck1_st";
            desc = "Err0 escape ck1 st. Chinese-only data sheet: description and value encoding not translated.";
            sw = r;
            hw = w;
            reset = 0x0;
        } err0_escape_ck1_st[5:5];

        field {
            name = "err0_escape_ck0_st";
            desc = "Err0 escape ck0 st. Chinese-only data sheet: description and value encoding not translated.";
            sw = r;
            hw = w;
            reset = 0x0;
        } err0_escape_ck0_st[4:4];

        field {
            name = "err0_escape_d3_st";
            desc = "Err0 escape d3 st. Chinese-only data sheet: description and value encoding not translated.";
            sw = r;
            hw = w;
            reset = 0x0;
        } err0_escape_d3_st[3:3];

        field {
            name = "err0_escape_d2_st";
            desc = "Err0 escape d2 st. Chinese-only data sheet: description and value encoding not translated.";
            sw = r;
            hw = w;
            reset = 0x0;
        } err0_escape_d2_st[2:2];

        field {
            name = "err0_escape_d1_st";
            desc = "Err0 escape d1 st. Chinese-only data sheet: description and value encoding not translated.";
            sw = r;
            hw = w;
            reset = 0x0;
        } err0_escape_d1_st[1:1];

        field {
            name = "err0_escape_d0_st";
            desc = "Err0 escape d0 st. Chinese-only data sheet: description and value encoding not translated.";
            sw = r;
            hw = w;
            reset = 0x0;
        } err0_escape_d0_st[0:0];
    } MIPI_CIL_INT_LINK @ 0x1F4;

    reg {
        name = "MIPI_CIL_INT_MSK_LINK";
        desc = "Data sheet 9.3.6 MIPI_CIL_INT_MSK_LINK (offset 0x1F8, printed page 9-149, `hi3516av300--Hi3516AV300-Datasheet.txt` line 43398).";

        field {
            name = "err3_timeout_ck1_msk";
            desc = "Err3 timeout ck1 mask. Chinese-only data sheet: description and value encoding not translated.";
            sw = rw;
            hw = r;
            reset = 0x0;
        } err3_timeout_ck1_msk[13:13];

        field {
            name = "err3_timeout_ck0_msk";
            desc = "Err3 timeout ck0 mask. Chinese-only data sheet: description and value encoding not translated.";
            sw = rw;
            hw = r;
            reset = 0x0;
        } err3_timeout_ck0_msk[12:12];

        field {
            name = "err3_timeout_d3_msk";
            desc = "Err3 timeout d3 mask. Chinese-only data sheet: description and value encoding not translated.";
            sw = rw;
            hw = r;
            reset = 0x0;
        } err3_timeout_d3_msk[11:11];

        field {
            name = "err3_timeout_d2_msk";
            desc = "Err3 timeout d2 mask. Chinese-only data sheet: description and value encoding not translated.";
            sw = rw;
            hw = r;
            reset = 0x0;
        } err3_timeout_d2_msk[10:10];

        field {
            name = "err3_timeout_d1_msk";
            desc = "Err3 timeout d1 mask. Chinese-only data sheet: description and value encoding not translated.";
            sw = rw;
            hw = r;
            reset = 0x0;
        } err3_timeout_d1_msk[9:9];

        field {
            name = "err3_timeout_d0_msk";
            desc = "Err3 timeout d0 mask. Chinese-only data sheet: description and value encoding not translated.";
            sw = rw;
            hw = r;
            reset = 0x0;
        } err3_timeout_d0_msk[8:8];

        field {
            name = "err3_escape_ck1_msk";
            desc = "Err3 escape ck1 mask. Chinese-only data sheet: description and value encoding not translated.";
            sw = rw;
            hw = r;
            reset = 0x0;
        } err3_escape_ck1_msk[5:5];

        field {
            name = "err3_escape_ck0_msk";
            desc = "Err3 escape ck0 mask. Chinese-only data sheet: description and value encoding not translated.";
            sw = rw;
            hw = r;
            reset = 0x0;
        } err3_escape_ck0_msk[4:4];

        field {
            name = "err3_escape_d3_msk";
            desc = "Err3 escape d3 mask. Chinese-only data sheet: description and value encoding not translated.";
            sw = rw;
            hw = r;
            reset = 0x0;
        } err3_escape_d3_msk[3:3];

        field {
            name = "err3_escape_d2_msk";
            desc = "Err3 escape d2 mask. Chinese-only data sheet: description and value encoding not translated.";
            sw = rw;
            hw = r;
            reset = 0x0;
        } err3_escape_d2_msk[2:2];

        field {
            name = "err3_escape_d1_msk";
            desc = "Err3 escape d1 mask. Chinese-only data sheet: description and value encoding not translated.";
            sw = rw;
            hw = r;
            reset = 0x0;
        } err3_escape_d1_msk[1:1];

        field {
            name = "err3_escape_d0_msk";
            desc = "Err3 escape d0 mask. Chinese-only data sheet: description and value encoding not translated.";
            sw = rw;
            hw = r;
            reset = 0x0;
        } err3_escape_d0_msk[0:0];
    } MIPI_CIL_INT_MSK_LINK @ 0x1F8;

    reg {
        name = "HS_MODE_SELECT";
        desc = "Data sheet 9.3.6 HS_MODE_SELECT (offset 0x800, printed page 9-150, `hi3516av300--Hi3516AV300-Datasheet.txt` line 43504).";

        field {
            name = "hs_mode";
            desc = "Horizontal sync mode. Chinese-only data sheet: description and value encoding not translated.";
            sw = rw;
            hw = r;
            reset = 0x0;
        } hs_mode[0:0];
    } HS_MODE_SELECT @ 0x800;

    reg {
        name = "PHY_EN";
        desc = "Data sheet 9.3.6 PHY_EN (offset 0x808, printed page 9-150, `hi3516av300--Hi3516AV300-Datasheet.txt` line 43525).";

        field {
            name = "phy0_en";
            desc = "Phy0 enable. Chinese-only data sheet: description and value encoding not translated.";
            sw = rw;
            hw = r;
            reset = 0x0;
        } phy0_en[0:0];
    } PHY_EN @ 0x808;

    reg {
        name = "LANE_EN";
        desc = "Data sheet 9.3.6 LANE_EN (offset 0x80C, printed page 9-151, `hi3516av300--Hi3516AV300-Datasheet.txt` line 43548).";

        field {
            name = "lane3_en";
            desc = "Lane3 enable. Chinese-only data sheet: description and value encoding not translated.";
            sw = rw;
            hw = r;
            reset = 0x0;
        } lane3_en[3:3];

        field {
            name = "lane2_en";
            desc = "Lane2 enable. Chinese-only data sheet: description and value encoding not translated.";
            sw = rw;
            hw = r;
            reset = 0x0;
        } lane2_en[2:2];

        field {
            name = "lane1_en";
            desc = "Lane1 enable. Chinese-only data sheet: description and value encoding not translated.";
            sw = rw;
            hw = r;
            reset = 0x0;
        } lane1_en[1:1];

        field {
            name = "lane0_en";
            desc = "Lane0 enable. Chinese-only data sheet: description and value encoding not translated.";
            sw = rw;
            hw = r;
            reset = 0x0;
        } lane0_en[0:0];
    } LANE_EN @ 0x80C;

    reg {
        name = "PHY_CIL_CTRL";
        desc = "Data sheet 9.3.6 PHY_CIL_CTRL (offset 0x810, printed page 9-151, `hi3516av300--Hi3516AV300-Datasheet.txt` line 43588).";

        field {
            name = "cil1_rst_req";
            desc = "Cil1 rst request. Chinese-only data sheet: description and value encoding not translated.";
            sw = rw;
            hw = r;
            reset = 0x0;
        } cil1_rst_req[9:9];

        field {
            name = "cil0_rst_req";
            desc = "Cil0 rst request. Chinese-only data sheet: description and value encoding not translated.";
            sw = rw;
            hw = r;
            reset = 0x0;
        } cil0_rst_req[8:8];

        field {
            name = "phycil0_cken";
            desc = "Phycil0 cken. Chinese-only data sheet: description and value encoding not translated.";
            sw = rw;
            hw = r;
            reset = 0x0;
        } phycil0_cken[0:0];
    } PHY_CIL_CTRL @ 0x810;

    reg {
        name = "PHYCFG_MODE";
        desc = "Data sheet 9.3.6 PHYCFG_MODE (offset 0x818, printed page 9-152, `hi3516av300--Hi3516AV300-Datasheet.txt` line 43624).";

        field {
            name = "phycil0_1_cfg_mode";
            desc = "Phycil0 1 configuration mode. Chinese-only data sheet: description and value encoding not translated.";
            sw = rw;
            hw = r;
            reset = 0x0;
        } phycil0_1_cfg_mode[6:4];

        field {
            name = "phycil0_cfg_mode_sel";
            desc = "Phycil0 configuration mode select. Chinese-only data sheet: description and value encoding not translated.";
            sw = rw;
            hw = r;
            reset = 0x0;
        } phycil0_cfg_mode_sel[3:3];

        field {
            name = "phycil0_0_cfg_mode";
            desc = "Phycil0 0 configuration mode. Chinese-only data sheet: description and value encoding not translated.";
            sw = rw;
            hw = r;
            reset = 0x0;
        } phycil0_0_cfg_mode[2:0];
    } PHYCFG_MODE @ 0x818;

    reg {
        name = "PHYCFG_EN";
        desc = "Data sheet 9.3.6 PHYCFG_EN (offset 0x81C, printed page 9-153, `hi3516av300--Hi3516AV300-Datasheet.txt` line 43683).";

        field {
            name = "phycil0_cfg_en";
            desc = "Phycil0 configuration enable. Chinese-only data sheet: description and value encoding not translated.";
            sw = w;
            hw = r;
            reset = 0x0;
        } phycil0_cfg_en[0:0];
    } PHYCFG_EN @ 0x81C;

    reg {
        name = "CHN0_MEM_CTRL";
        desc = "Data sheet 9.3.6 CHN0_MEM_CTRL (offset 0x820, printed page 9-153, `hi3516av300--Hi3516AV300-Datasheet.txt` line 43708).";

        field {
            name = "chn0_mem_ck_gt";
            desc = "Chn0 mem ck gt. Chinese-only data sheet: description and value encoding not translated.";
            sw = rw;
            hw = r;
            reset = 0x0;
        } chn0_mem_ck_gt[0:0];
    } CHN0_MEM_CTRL @ 0x820;

    reg {
        name = "CHN0_CLR_EN";
        desc = "Data sheet 9.3.6 CHN0_CLR_EN (offset 0x824, printed page 9-154, `hi3516av300--Hi3516AV300-Datasheet.txt` line 43746).";

        field {
            name = "chn0_clr_en_align";
            desc = "Chn0 clear enable align. Chinese-only data sheet: description and value encoding not translated.";
            sw = rw;
            hw = r;
            reset = 0x0;
        } chn0_clr_en_align[1:1];

        field {
            name = "chn0_clr_en_lvds";
            desc = "Chn0 clear enable lvds. Chinese-only data sheet: description and value encoding not translated.";
            sw = rw;
            hw = r;
            reset = 0x0;
        } chn0_clr_en_lvds[0:0];
    } CHN0_CLR_EN @ 0x824;

    reg {
        name = "CHN1_MEM_CTRL";
        desc = "Data sheet 9.3.6 CHN1_MEM_CTRL (offset 0x828, printed page 9-154, `hi3516av300--Hi3516AV300-Datasheet.txt` line 43776).";

        field {
            name = "chn1_mem_ck_gt";
            desc = "Chn1 mem ck gt. Chinese-only data sheet: description and value encoding not translated.";
            sw = rw;
            hw = r;
            reset = 0x0;
        } chn1_mem_ck_gt[0:0];
    } CHN1_MEM_CTRL @ 0x828;

    reg {
        name = "CHN1_CLR_EN";
        desc = "Data sheet 9.3.6 CHN1_CLR_EN (offset 0x82C, printed page 9-155, `hi3516av300--Hi3516AV300-Datasheet.txt` line 43813).";

        field {
            name = "chn1_clr_en_align";
            desc = "Chn1 clear enable align. Chinese-only data sheet: description and value encoding not translated.";
            sw = rw;
            hw = r;
            reset = 0x0;
        } chn1_clr_en_align[1:1];

        field {
            name = "chn1_clr_en_lvds";
            desc = "Chn1 clear enable lvds. Chinese-only data sheet: description and value encoding not translated.";
            sw = rw;
            hw = r;
            reset = 0x0;
        } chn1_clr_en_lvds[0:0];
    } CHN1_CLR_EN @ 0x82C;

    reg {
        name = "MIPI_INT_RAW";
        desc = "Data sheet 9.3.6 MIPI_INT_RAW (offset 0xFF0, printed page 9-155, `hi3516av300--Hi3516AV300-Datasheet.txt` line 43838).";

        field {
            name = "int_chn1_raw";
            desc = "Interrupt chn1 raw. Chinese-only data sheet: description and value encoding not translated.";
            sw = rw;
            hw = w;
            onwrite = woclr;
            reset = 0x0;
        } int_chn1_raw[5:5];

        field {
            name = "int_chn0_raw";
            desc = "Interrupt chn0 raw. Chinese-only data sheet: description and value encoding not translated.";
            sw = rw;
            hw = w;
            onwrite = woclr;
            reset = 0x0;
        } int_chn0_raw[4:4];

        field {
            name = "int_phycil0_raw";
            desc = "Interrupt phycil0 raw. Chinese-only data sheet: description and value encoding not translated.";
            sw = rw;
            hw = w;
            onwrite = woclr;
            reset = 0x0;
        } int_phycil0_raw[0:0];
    } MIPI_INT_RAW @ 0xFF0;

    reg {
        name = "MIPI_INT_ST";
        desc = "Data sheet 9.3.6 MIPI_INT_ST (offset 0xFF4, printed page 9-156, `hi3516av300--Hi3516AV300-Datasheet.txt` line 43877).";

        field {
            name = "int_chn1_st";
            desc = "Interrupt chn1 st. Chinese-only data sheet: description and value encoding not translated.";
            sw = r;
            hw = w;
            reset = 0x0;
        } int_chn1_st[5:5];

        field {
            name = "int_chn0_st";
            desc = "Interrupt chn0 st. Chinese-only data sheet: description and value encoding not translated.";
            sw = r;
            hw = w;
            reset = 0x0;
        } int_chn0_st[4:4];

        field {
            name = "int_phycil0_st";
            desc = "Interrupt phycil0 st. Chinese-only data sheet: description and value encoding not translated.";
            sw = r;
            hw = w;
            reset = 0x0;
        } int_phycil0_st[0:0];
    } MIPI_INT_ST @ 0xFF4;

    reg {
        name = "MIPI_INT_MSK";
        desc = "Data sheet 9.3.6 MIPI_INT_MSK (offset 0xFF8, printed page 9-156, `hi3516av300--Hi3516AV300-Datasheet.txt` line 43908).";

        field {
            name = "int_chn1_mask";
            desc = "Interrupt chn1 mask. Chinese-only data sheet: description and value encoding not translated.";
            sw = rw;
            hw = r;
            reset = 0x0;
        } int_chn1_mask[5:5];

        field {
            name = "int_chn0_mask";
            desc = "Interrupt chn0 mask. Chinese-only data sheet: description and value encoding not translated.";
            sw = rw;
            hw = r;
            reset = 0x0;
        } int_chn0_mask[4:4];

        field {
            name = "int_phycil0_mask";
            desc = "Interrupt phycil0 mask. Chinese-only data sheet: description and value encoding not translated.";
            sw = rw;
            hw = r;
            reset = 0x0;
        } int_phycil0_mask[0:0];
    } MIPI_INT_MSK @ 0xFF8;

    reg {
        name = "MIPI0_LANES_NUM";
        desc = "Data sheet 9.3.6 MIPI0_LANES_NUM (offset 0x1004, printed page 9-157, `hi3516av300--Hi3516AV300-Datasheet.txt` line 43944).";

        field {
            name = "lane_num";
            desc = "Lane number. Chinese-only data sheet: description and value encoding not translated.";
            sw = rw;
            hw = r;
            reset = 0x3;
        } lane_num[2:0];
    } MIPI0_LANES_NUM @ 0x1004;

    reg {
        name = "MIPI0_MAIN_INT_ST";
        desc = "Data sheet 9.3.6 MIPI0_MAIN_INT_ST (offset 0x100C, printed page 9-157, `hi3516av300--Hi3516AV300-Datasheet.txt` line 43973).";

        field {
            name = "status_int_line";
            desc = "Status interrupt line. Chinese-only data sheet: description and value encoding not translated.";
            sw = r;
            hw = w;
            reset = 0x0;
        } status_int_line[18:18];

        field {
            name = "status_int_pkt";
            desc = "Status interrupt pkt. Chinese-only data sheet: description and value encoding not translated.";
            sw = r;
            hw = w;
            reset = 0x0;
        } status_int_pkt[17:17];

        field {
            name = "status_int_frame_fatal";
            desc = "Status interrupt frame fatal. Chinese-only data sheet: description and value encoding not translated.";
            sw = r;
            hw = w;
            reset = 0x0;
        } status_int_frame_fatal[2:2];

        field {
            name = "status_int_pkt_fatal";
            desc = "Status interrupt pkt fatal. Chinese-only data sheet: description and value encoding not translated.";
            sw = r;
            hw = w;
            reset = 0x0;
        } status_int_pkt_fatal[1:1];
    } MIPI0_MAIN_INT_ST @ 0x100C;

    reg {
        name = "MIPI0_DI_1";
        desc = "Data sheet 9.3.6 MIPI0_DI_1 (offset 0x1010, printed page 9-158, `hi3516av300--Hi3516AV300-Datasheet.txt` line 44029).";

        field {
            name = "di3_vc";
            desc = "Di3 vc. Chinese-only data sheet: description and value encoding not translated.";
            sw = rw;
            hw = r;
            reset = 0x0;
        } di3_vc[31:30];

        field {
            name = "di3_dt";
            desc = "Di3 dt. Chinese-only data sheet: description and value encoding not translated.";
            sw = rw;
            hw = r;
            reset = 0x0;
        } di3_dt[29:24];

        field {
            name = "di2_vc";
            desc = "Di2 vc. Chinese-only data sheet: description and value encoding not translated.";
            sw = rw;
            hw = r;
            reset = 0x0;
        } di2_vc[23:22];

        field {
            name = "di2_dt";
            desc = "Di2 dt. Chinese-only data sheet: description and value encoding not translated.";
            sw = rw;
            hw = r;
            reset = 0x0;
        } di2_dt[21:16];

        field {
            name = "di1_vc";
            desc = "Di1 vc. Chinese-only data sheet: description and value encoding not translated.";
            sw = rw;
            hw = r;
            reset = 0x0;
        } di1_vc[15:14];

        field {
            name = "di1_dt";
            desc = "Di1 dt. Chinese-only data sheet: description and value encoding not translated.";
            sw = rw;
            hw = r;
            reset = 0x0;
        } di1_dt[13:8];

        field {
            name = "di0_vc";
            desc = "Di0 vc. Chinese-only data sheet: description and value encoding not translated.";
            sw = rw;
            hw = r;
            reset = 0x0;
        } di0_vc[7:6];

        field {
            name = "di0_dt";
            desc = "Di0 dt. Chinese-only data sheet: description and value encoding not translated.";
            sw = rw;
            hw = r;
            reset = 0x0;
        } di0_dt[5:0];
    } MIPI0_DI_1 @ 0x1010;

    reg {
        name = "MIPI0_DI_2";
        desc = "Data sheet 9.3.6 MIPI0_DI_2 (offset 0x1014, printed page 9-159, `hi3516av300--Hi3516AV300-Datasheet.txt` line 44102).";

        field {
            name = "di7_vc";
            desc = "Di7 vc. Chinese-only data sheet: description and value encoding not translated.";
            sw = rw;
            hw = r;
            reset = 0x0;
        } di7_vc[31:30];

        field {
            name = "di7_dt";
            desc = "Di7 dt. Chinese-only data sheet: description and value encoding not translated.";
            sw = rw;
            hw = r;
            reset = 0x0;
        } di7_dt[29:24];

        field {
            name = "di6_vc";
            desc = "Di6 vc. Chinese-only data sheet: description and value encoding not translated.";
            sw = rw;
            hw = r;
            reset = 0x0;
        } di6_vc[23:22];

        field {
            name = "di6_dt";
            desc = "Di6 dt. Chinese-only data sheet: description and value encoding not translated.";
            sw = rw;
            hw = r;
            reset = 0x0;
        } di6_dt[21:16];

        field {
            name = "di5_vc";
            desc = "Di5 vc. Chinese-only data sheet: description and value encoding not translated.";
            sw = rw;
            hw = r;
            reset = 0x0;
        } di5_vc[15:14];

        field {
            name = "di5_dt";
            desc = "Di5 dt. Chinese-only data sheet: description and value encoding not translated.";
            sw = rw;
            hw = r;
            reset = 0x0;
        } di5_dt[13:8];

        field {
            name = "di4_vc";
            desc = "Di4 vc. Chinese-only data sheet: description and value encoding not translated.";
            sw = rw;
            hw = r;
            reset = 0x0;
        } di4_vc[7:6];

        field {
            name = "di4_dt";
            desc = "Di4 dt. Chinese-only data sheet: description and value encoding not translated.";
            sw = rw;
            hw = r;
            reset = 0x0;
        } di4_dt[5:0];
    } MIPI0_DI_2 @ 0x1014;

    reg {
        name = "MIPI0_PKT_INTR_ST";
        desc = "Data sheet 9.3.6 MIPI0_PKT_INTR_ST (offset 0x1060, printed page 9-160, `hi3516av300--Hi3516AV300-Datasheet.txt` line 44175).";

        field {
            name = "err_ecc_double";
            desc = "Error ecc double. Chinese-only data sheet: description and value encoding not translated.";
            sw = r;
            hw = w;
            reset = 0x0;
        } err_ecc_double[16:16];

        field {
            name = "vc3_err_crc";
            desc = "Vc3 error crc. Chinese-only data sheet: description and value encoding not translated.";
            sw = r;
            hw = w;
            reset = 0x0;
        } vc3_err_crc[3:3];

        field {
            name = "vc2_err_crc";
            desc = "Vc2 error crc. Chinese-only data sheet: description and value encoding not translated.";
            sw = r;
            hw = w;
            reset = 0x0;
        } vc2_err_crc[2:2];

        field {
            name = "vc1_err_crc";
            desc = "Vc1 error crc. Chinese-only data sheet: description and value encoding not translated.";
            sw = r;
            hw = w;
            reset = 0x0;
        } vc1_err_crc[1:1];

        field {
            name = "vc0_err_crc";
            desc = "Vc0 error crc. Chinese-only data sheet: description and value encoding not translated.";
            sw = r;
            hw = w;
            reset = 0x0;
        } vc0_err_crc[0:0];
    } MIPI0_PKT_INTR_ST @ 0x1060;

    reg {
        name = "MIPI0_PKT_INTR_MSK";
        desc = "Data sheet 9.3.6 MIPI0_PKT_INTR_MSK (offset 0x1064, printed page 9-161, `hi3516av300--Hi3516AV300-Datasheet.txt` line 44229).";

        field {
            name = "mask_err_ecc_double";
            desc = "Mask error ecc double. Chinese-only data sheet: description and value encoding not translated.";
            sw = rw;
            hw = r;
            reset = 0x0;
        } mask_err_ecc_double[16:16];

        field {
            name = "mask_vc3_err_crc";
            desc = "Mask vc3 error crc. Chinese-only data sheet: description and value encoding not translated.";
            sw = rw;
            hw = r;
            reset = 0x0;
        } mask_vc3_err_crc[3:3];

        field {
            name = "mask_vc2_err_crc";
            desc = "Mask vc2 error crc. Chinese-only data sheet: description and value encoding not translated.";
            sw = rw;
            hw = r;
            reset = 0x0;
        } mask_vc2_err_crc[2:2];

        field {
            name = "mask_vc1_err_crc";
            desc = "Mask vc1 error crc. Chinese-only data sheet: description and value encoding not translated.";
            sw = rw;
            hw = r;
            reset = 0x0;
        } mask_vc1_err_crc[1:1];

        field {
            name = "mask_vc0_err_crc";
            desc = "Mask vc0 error crc. Chinese-only data sheet: description and value encoding not translated.";
            sw = rw;
            hw = r;
            reset = 0x0;
        } mask_vc0_err_crc[0:0];
    } MIPI0_PKT_INTR_MSK @ 0x1064;

    reg {
        name = "MIPI0_PKT_INTR2_ST";
        desc = "Data sheet 9.3.6 MIPI0_PKT_INTR2_ST (offset 0x1070, printed page 9-161, `hi3516av300--Hi3516AV300-Datasheet.txt` line 44280).";

        field {
            name = "vc3_err_ecc_corrected";
            desc = "Vc3 error ecc corrected. Chinese-only data sheet: description and value encoding not translated.";
            sw = r;
            hw = w;
            reset = 0x0;
        } vc3_err_ecc_corrected[19:19];

        field {
            name = "vc2_err_ecc_corrected";
            desc = "Vc2 error ecc corrected. Chinese-only data sheet: description and value encoding not translated.";
            sw = r;
            hw = w;
            reset = 0x0;
        } vc2_err_ecc_corrected[18:18];

        field {
            name = "vc1_err_ecc_corrected";
            desc = "Vc1 error ecc corrected. Chinese-only data sheet: description and value encoding not translated.";
            sw = r;
            hw = w;
            reset = 0x0;
        } vc1_err_ecc_corrected[17:17];

        field {
            name = "vc0_err_ecc_corrected";
            desc = "Vc0 error ecc corrected. Chinese-only data sheet: description and value encoding not translated.";
            sw = r;
            hw = w;
            reset = 0x0;
        } vc0_err_ecc_corrected[16:16];

        field {
            name = "err_id_vc3";
            desc = "Error id vc3. Chinese-only data sheet: description and value encoding not translated.";
            sw = r;
            hw = w;
            reset = 0x0;
        } err_id_vc3[3:3];

        field {
            name = "err_id_vc2";
            desc = "Error id vc2. Chinese-only data sheet: description and value encoding not translated.";
            sw = r;
            hw = w;
            reset = 0x0;
        } err_id_vc2[2:2];

        field {
            name = "err_id_vc1";
            desc = "Error id vc1. Chinese-only data sheet: description and value encoding not translated.";
            sw = r;
            hw = w;
            reset = 0x0;
        } err_id_vc1[1:1];

        field {
            name = "err_id_vc0";
            desc = "Error id vc0. Chinese-only data sheet: description and value encoding not translated.";
            sw = r;
            hw = w;
            reset = 0x0;
        } err_id_vc0[0:0];
    } MIPI0_PKT_INTR2_ST @ 0x1070;

    reg {
        name = "MIPI0_PKT_INTR2_MSK";
        desc = "Data sheet 9.3.6 MIPI0_PKT_INTR2_MSK (offset 0x1074, printed page 9-163, `hi3516av300--Hi3516AV300-Datasheet.txt` line 44368).";

        field {
            name = "mask_vc3_err_ecc_corrected";
            desc = "Mask vc3 error ecc corrected. Chinese-only data sheet: description and value encoding not translated.";
            sw = rw;
            hw = r;
            reset = 0x0;
        } mask_vc3_err_ecc_corrected[19:19];

        field {
            name = "mask_vc2_err_ecc_corrected";
            desc = "Mask vc2 error ecc corrected. Chinese-only data sheet: description and value encoding not translated.";
            sw = rw;
            hw = r;
            reset = 0x0;
        } mask_vc2_err_ecc_corrected[18:18];

        field {
            name = "mask_vc1_err_ecc_corrected";
            desc = "Mask vc1 error ecc corrected. Chinese-only data sheet: description and value encoding not translated.";
            sw = rw;
            hw = r;
            reset = 0x0;
        } mask_vc1_err_ecc_corrected[17:17];

        field {
            name = "mask_vc0_err_ecc_corrected";
            desc = "Mask vc0 error ecc corrected. Chinese-only data sheet: description and value encoding not translated.";
            sw = rw;
            hw = r;
            reset = 0x0;
        } mask_vc0_err_ecc_corrected[16:16];

        field {
            name = "mask_err_id_vc3";
            desc = "Mask error id vc3. Chinese-only data sheet: description and value encoding not translated.";
            sw = rw;
            hw = r;
            reset = 0x0;
        } mask_err_id_vc3[3:3];

        field {
            name = "mask_err_id_vc2";
            desc = "Mask error id vc2. Chinese-only data sheet: description and value encoding not translated.";
            sw = rw;
            hw = r;
            reset = 0x0;
        } mask_err_id_vc2[2:2];

        field {
            name = "mask_err_id_vc1";
            desc = "Mask error id vc1. Chinese-only data sheet: description and value encoding not translated.";
            sw = rw;
            hw = r;
            reset = 0x0;
        } mask_err_id_vc1[1:1];

        field {
            name = "mask_err_id_vc0";
            desc = "Mask error id vc0. Chinese-only data sheet: description and value encoding not translated.";
            sw = rw;
            hw = r;
            reset = 0x0;
        } mask_err_id_vc0[0:0];
    } MIPI0_PKT_INTR2_MSK @ 0x1074;

    reg {
        name = "MIPI0_FRAME_INTR_ST";
        desc = "Data sheet 9.3.6 MIPI0_FRAME_INTR_ST (offset 0x1080, printed page 9-163, `hi3516av300--Hi3516AV300-Datasheet.txt` line 44435).";

        field {
            name = "err_frame_data_vc3";
            desc = "Error frame data vc3. Chinese-only data sheet: description and value encoding not translated.";
            sw = r;
            hw = w;
            reset = 0x0;
        } err_frame_data_vc3[19:19];

        field {
            name = "err_frame_data_vc2";
            desc = "Error frame data vc2. Chinese-only data sheet: description and value encoding not translated.";
            sw = r;
            hw = w;
            reset = 0x0;
        } err_frame_data_vc2[18:18];

        field {
            name = "err_frame_data_vc1";
            desc = "Error frame data vc1. Chinese-only data sheet: description and value encoding not translated.";
            sw = r;
            hw = w;
            reset = 0x0;
        } err_frame_data_vc1[17:17];

        field {
            name = "err_frame_data_vc0";
            desc = "Error frame data vc0. Chinese-only data sheet: description and value encoding not translated.";
            sw = r;
            hw = w;
            reset = 0x0;
        } err_frame_data_vc0[16:16];

        field {
            name = "err_f_seq_vc3";
            desc = "Error f seq vc3. Chinese-only data sheet: description and value encoding not translated.";
            sw = r;
            hw = w;
            reset = 0x0;
        } err_f_seq_vc3[11:11];

        field {
            name = "err_f_seq_vc2";
            desc = "Error f seq vc2. Chinese-only data sheet: description and value encoding not translated.";
            sw = r;
            hw = w;
            reset = 0x0;
        } err_f_seq_vc2[10:10];

        field {
            name = "err_f_seq_vc1";
            desc = "Error f seq vc1. Chinese-only data sheet: description and value encoding not translated.";
            sw = r;
            hw = w;
            reset = 0x0;
        } err_f_seq_vc1[9:9];

        field {
            name = "err_f_seq_vc0";
            desc = "Error f seq vc0. Chinese-only data sheet: description and value encoding not translated.";
            sw = r;
            hw = w;
            reset = 0x0;
        } err_f_seq_vc0[8:8];

        field {
            name = "err_f_bndry_match_vc3";
            desc = "Error f bndry match vc3. Chinese-only data sheet: description and value encoding not translated.";
            sw = r;
            hw = w;
            reset = 0x0;
        } err_f_bndry_match_vc3[3:3];

        field {
            name = "err_f_bndry_match_vc2";
            desc = "Error f bndry match vc2. Chinese-only data sheet: description and value encoding not translated.";
            sw = r;
            hw = w;
            reset = 0x0;
        } err_f_bndry_match_vc2[2:2];

        field {
            name = "err_f_bndry_match_vc1";
            desc = "Error f bndry match vc1. Chinese-only data sheet: description and value encoding not translated.";
            sw = r;
            hw = w;
            reset = 0x0;
        } err_f_bndry_match_vc1[1:1];

        field {
            name = "err_f_bndry_match_vc0";
            desc = "Error f bndry match vc0. Chinese-only data sheet: description and value encoding not translated.";
            sw = r;
            hw = w;
            reset = 0x0;
        } err_f_bndry_match_vc0[0:0];
    } MIPI0_FRAME_INTR_ST @ 0x1080;

    reg {
        name = "MIPI0_FRAME_INTR_MSK";
        desc = "Data sheet 9.3.6 MIPI0_FRAME_INTR_MSK (offset 0x1084, printed page 9-165, `hi3516av300--Hi3516AV300-Datasheet.txt` line 44557).";

        field {
            name = "mask_err_frame_data_vc3";
            desc = "Mask error frame data vc3. Chinese-only data sheet: description and value encoding not translated.";
            sw = rw;
            hw = r;
            reset = 0x0;
        } mask_err_frame_data_vc3[19:19];

        field {
            name = "mask_err_frame_data_vc2";
            desc = "Mask error frame data vc2. Chinese-only data sheet: description and value encoding not translated.";
            sw = rw;
            hw = r;
            reset = 0x0;
        } mask_err_frame_data_vc2[18:18];

        field {
            name = "mask_err_frame_data_vc1";
            desc = "Mask error frame data vc1. Chinese-only data sheet: description and value encoding not translated.";
            sw = rw;
            hw = r;
            reset = 0x0;
        } mask_err_frame_data_vc1[17:17];

        field {
            name = "mask_err_frame_data_vc0";
            desc = "Mask error frame data vc0. Chinese-only data sheet: description and value encoding not translated.";
            sw = rw;
            hw = r;
            reset = 0x0;
        } mask_err_frame_data_vc0[16:16];

        field {
            name = "mask_err_f_seq_vc3";
            desc = "Mask error f seq vc3. Chinese-only data sheet: description and value encoding not translated.";
            sw = rw;
            hw = r;
            reset = 0x0;
        } mask_err_f_seq_vc3[11:11];

        field {
            name = "mask_err_f_seq_vc2";
            desc = "Mask error f seq vc2. Chinese-only data sheet: description and value encoding not translated.";
            sw = rw;
            hw = r;
            reset = 0x0;
        } mask_err_f_seq_vc2[10:10];

        field {
            name = "mask_err_f_seq_vc1";
            desc = "Mask error f seq vc1. Chinese-only data sheet: description and value encoding not translated.";
            sw = rw;
            hw = r;
            reset = 0x0;
        } mask_err_f_seq_vc1[9:9];

        field {
            name = "mask_err_f_seq_vc0";
            desc = "Mask error f seq vc0. Chinese-only data sheet: description and value encoding not translated.";
            sw = rw;
            hw = r;
            reset = 0x0;
        } mask_err_f_seq_vc0[8:8];

        field {
            name = "mask_err_f_bndry_match_vc3";
            desc = "Mask error f bndry match vc3. Chinese-only data sheet: description and value encoding not translated.";
            sw = rw;
            hw = r;
            reset = 0x0;
        } mask_err_f_bndry_match_vc3[3:3];

        field {
            name = "mask_err_f_bndry_match_vc2";
            desc = "Mask error f bndry match vc2. Chinese-only data sheet: description and value encoding not translated.";
            sw = rw;
            hw = r;
            reset = 0x0;
        } mask_err_f_bndry_match_vc2[2:2];

        field {
            name = "mask_err_f_bndry_match_vc1";
            desc = "Mask error f bndry match vc1. Chinese-only data sheet: description and value encoding not translated.";
            sw = rw;
            hw = r;
            reset = 0x0;
        } mask_err_f_bndry_match_vc1[1:1];

        field {
            name = "mask_err_f_bndry_match_vc0";
            desc = "Mask error f bndry match vc0. Chinese-only data sheet: description and value encoding not translated.";
            sw = rw;
            hw = r;
            reset = 0x0;
        } mask_err_f_bndry_match_vc0[0:0];
    } MIPI0_FRAME_INTR_MSK @ 0x1084;

    reg {
        name = "MIPI0_LINE_INTR_ST";
        desc = "Data sheet 9.3.6 MIPI0_LINE_INTR_ST (offset 0x1090, printed page 9-167, `hi3516av300--Hi3516AV300-Datasheet.txt` line 44670).";

        field {
            name = "err_l_seq_di7";
            desc = "Error l seq di7. Chinese-only data sheet: description and value encoding not translated.";
            sw = r;
            hw = w;
            reset = 0x0;
        } err_l_seq_di7[23:23];

        field {
            name = "err_l_seq_di6";
            desc = "Error l seq di6. Chinese-only data sheet: description and value encoding not translated.";
            sw = r;
            hw = w;
            reset = 0x0;
        } err_l_seq_di6[22:22];

        field {
            name = "err_l_seq_di5";
            desc = "Error l seq di5. Chinese-only data sheet: description and value encoding not translated.";
            sw = r;
            hw = w;
            reset = 0x0;
        } err_l_seq_di5[21:21];

        field {
            name = "err_l_seq_di4";
            desc = "Error l seq di4. Chinese-only data sheet: description and value encoding not translated.";
            sw = r;
            hw = w;
            reset = 0x0;
        } err_l_seq_di4[20:20];

        field {
            name = "err_l_seq_di3";
            desc = "Error l seq di3. Chinese-only data sheet: description and value encoding not translated.";
            sw = r;
            hw = w;
            reset = 0x0;
        } err_l_seq_di3[19:19];

        field {
            name = "err_l_seq_di2";
            desc = "Error l seq di2. Chinese-only data sheet: description and value encoding not translated.";
            sw = r;
            hw = w;
            reset = 0x0;
        } err_l_seq_di2[18:18];

        field {
            name = "err_l_seq_di1";
            desc = "Error l seq di1. Chinese-only data sheet: description and value encoding not translated.";
            sw = r;
            hw = w;
            reset = 0x0;
        } err_l_seq_di1[17:17];

        field {
            name = "err_l_seq_di0";
            desc = "Error l seq di0. Chinese-only data sheet: description and value encoding not translated.";
            sw = r;
            hw = w;
            reset = 0x0;
        } err_l_seq_di0[16:16];

        field {
            name = "err_l_bndry_match_di7";
            desc = "Error l bndry match di7. Chinese-only data sheet: description and value encoding not translated.";
            sw = r;
            hw = w;
            reset = 0x0;
        } err_l_bndry_match_di7[7:7];

        field {
            name = "err_l_bndry_match_di6";
            desc = "Error l bndry match di6. Chinese-only data sheet: description and value encoding not translated.";
            sw = r;
            hw = w;
            reset = 0x0;
        } err_l_bndry_match_di6[6:6];

        field {
            name = "err_l_bndry_match_di5";
            desc = "Error l bndry match di5. Chinese-only data sheet: description and value encoding not translated.";
            sw = r;
            hw = w;
            reset = 0x0;
        } err_l_bndry_match_di5[5:5];

        field {
            name = "err_l_bndry_match_di4";
            desc = "Error l bndry match di4. Chinese-only data sheet: description and value encoding not translated.";
            sw = r;
            hw = w;
            reset = 0x0;
        } err_l_bndry_match_di4[4:4];

        field {
            name = "err_l_bndry_match_di3";
            desc = "Error l bndry match di3. Chinese-only data sheet: description and value encoding not translated.";
            sw = r;
            hw = w;
            reset = 0x0;
        } err_l_bndry_match_di3[3:3];

        field {
            name = "err_l_bndry_match_di2";
            desc = "Error l bndry match di2. Chinese-only data sheet: description and value encoding not translated.";
            sw = r;
            hw = w;
            reset = 0x0;
        } err_l_bndry_match_di2[2:2];

        field {
            name = "err_l_bndry_match_di1";
            desc = "Error l bndry match di1. Chinese-only data sheet: description and value encoding not translated.";
            sw = r;
            hw = w;
            reset = 0x0;
        } err_l_bndry_match_di1[1:1];

        field {
            name = "err_l_bndry_match_di0";
            desc = "Error l bndry match di0. Chinese-only data sheet: description and value encoding not translated.";
            sw = r;
            hw = w;
            reset = 0x0;
        } err_l_bndry_match_di0[0:0];
    } MIPI0_LINE_INTR_ST @ 0x1090;

    reg {
        name = "MIPI0_LINE_INTR_MSK";
        desc = "Data sheet 9.3.6 MIPI0_LINE_INTR_MSK (offset 0x1094, printed page 9-168, `hi3516av300--Hi3516AV300-Datasheet.txt` line 44804).";

        field {
            name = "mask_err_l_seq_di7";
            desc = "Mask error l seq di7. Chinese-only data sheet: description and value encoding not translated.";
            sw = rw;
            hw = r;
            reset = 0x0;
        } mask_err_l_seq_di7[23:23];

        field {
            name = "mask_err_l_seq_di6";
            desc = "Mask error l seq di6. Chinese-only data sheet: description and value encoding not translated.";
            sw = rw;
            hw = r;
            reset = 0x0;
        } mask_err_l_seq_di6[22:22];

        field {
            name = "mask_err_l_seq_di5";
            desc = "Mask error l seq di5. Chinese-only data sheet: description and value encoding not translated.";
            sw = rw;
            hw = r;
            reset = 0x0;
        } mask_err_l_seq_di5[21:21];

        field {
            name = "mask_err_l_seq_di4";
            desc = "Mask error l seq di4. Chinese-only data sheet: description and value encoding not translated.";
            sw = rw;
            hw = r;
            reset = 0x0;
        } mask_err_l_seq_di4[20:20];

        field {
            name = "mask_err_l_seq_di3";
            desc = "Mask error l seq di3. Chinese-only data sheet: description and value encoding not translated.";
            sw = rw;
            hw = r;
            reset = 0x0;
        } mask_err_l_seq_di3[19:19];

        field {
            name = "mask_err_l_seq_di2";
            desc = "Mask error l seq di2. Chinese-only data sheet: description and value encoding not translated.";
            sw = rw;
            hw = r;
            reset = 0x0;
        } mask_err_l_seq_di2[18:18];

        field {
            name = "mask_err_l_seq_di1";
            desc = "Mask error l seq di1. Chinese-only data sheet: description and value encoding not translated.";
            sw = rw;
            hw = r;
            reset = 0x0;
        } mask_err_l_seq_di1[17:17];

        field {
            name = "mask_err_l_seq_di0";
            desc = "Mask error l seq di0. Chinese-only data sheet: description and value encoding not translated.";
            sw = rw;
            hw = r;
            reset = 0x0;
        } mask_err_l_seq_di0[16:16];

        field {
            name = "mask_err_l_bndry_match_di7";
            desc = "Mask error l bndry match di7. Chinese-only data sheet: description and value encoding not translated.";
            sw = rw;
            hw = r;
            reset = 0x0;
        } mask_err_l_bndry_match_di7[7:7];

        field {
            name = "mask_err_l_bndry_match_di6";
            desc = "Mask error l bndry match di6. Chinese-only data sheet: description and value encoding not translated.";
            sw = rw;
            hw = r;
            reset = 0x0;
        } mask_err_l_bndry_match_di6[6:6];

        field {
            name = "mask_err_l_bndry_match_di5";
            desc = "Mask error l bndry match di5. Chinese-only data sheet: description and value encoding not translated.";
            sw = rw;
            hw = r;
            reset = 0x0;
        } mask_err_l_bndry_match_di5[5:5];

        field {
            name = "mask_err_l_bndry_match_di4";
            desc = "Mask error l bndry match di4. Chinese-only data sheet: description and value encoding not translated.";
            sw = rw;
            hw = r;
            reset = 0x0;
        } mask_err_l_bndry_match_di4[4:4];

        field {
            name = "mask_err_l_bndry_match_di3";
            desc = "Mask error l bndry match di3. Chinese-only data sheet: description and value encoding not translated.";
            sw = rw;
            hw = r;
            reset = 0x0;
        } mask_err_l_bndry_match_di3[3:3];

        field {
            name = "mask_err_l_bndry_match_di2";
            desc = "Mask error l bndry match di2. Chinese-only data sheet: description and value encoding not translated.";
            sw = rw;
            hw = r;
            reset = 0x0;
        } mask_err_l_bndry_match_di2[2:2];

        field {
            name = "mask_err_l_bndry_match_di1";
            desc = "Mask error l bndry match di1. Chinese-only data sheet: description and value encoding not translated.";
            sw = rw;
            hw = r;
            reset = 0x0;
        } mask_err_l_bndry_match_di1[1:1];

        field {
            name = "mask_err_l_bndry_match_di0";
            desc = "Mask error l bndry match di0. Chinese-only data sheet: description and value encoding not translated.";
            sw = rw;
            hw = r;
            reset = 0x0;
        } mask_err_l_bndry_match_di0[0:0];
    } MIPI0_LINE_INTR_MSK @ 0x1094;

    reg {
        name = "MIPI0_USERDEF_DT";
        desc = "Data sheet 9.3.6 MIPI0_USERDEF_DT (offset 0x1100, printed page 9-170, `hi3516av300--Hi3516AV300-Datasheet.txt` line 44943).";

        field {
            name = "user_def3_dt";
            desc = "User def3 dt. Chinese-only data sheet: description and value encoding not translated.";
            sw = rw;
            hw = r;
            reset = 0x0;
        } user_def3_dt[14:12];

        field {
            name = "user_def2_dt";
            desc = "User def2 dt. Chinese-only data sheet: description and value encoding not translated.";
            sw = rw;
            hw = r;
            reset = 0x0;
        } user_def2_dt[10:8];

        field {
            name = "user_def1_dt";
            desc = "User def1 dt. Chinese-only data sheet: description and value encoding not translated.";
            sw = rw;
            hw = r;
            reset = 0x0;
        } user_def1_dt[6:4];

        field {
            name = "user_def0_dt";
            desc = "User def0 dt. Chinese-only data sheet: description and value encoding not translated.";
            sw = rw;
            hw = r;
            reset = 0x0;
        } user_def0_dt[2:0];
    } MIPI0_USERDEF_DT @ 0x1100;

    reg {
        name = "MIPI0_USER_DEF";
        desc = "Data sheet 9.3.6 MIPI0_USER_DEF (offset 0x1104, printed page 9-171, `hi3516av300--Hi3516AV300-Datasheet.txt` line 45027).";

        field {
            name = "user_def3";
            desc = "User def3. Chinese-only data sheet: description and value encoding not translated.";
            sw = rw;
            hw = r;
            reset = 0x10;
        } user_def3[29:24];

        field {
            name = "user_def2";
            desc = "User def2. Chinese-only data sheet: description and value encoding not translated.";
            sw = rw;
            hw = r;
            reset = 0x36;
        } user_def2[21:16];

        field {
            name = "user_def1";
            desc = "User def1. Chinese-only data sheet: description and value encoding not translated.";
            sw = rw;
            hw = r;
            reset = 0x35;
        } user_def1[13:8];

        field {
            name = "user_def0";
            desc = "User def0. Chinese-only data sheet: description and value encoding not translated.";
            sw = rw;
            hw = r;
            reset = 0x34;
        } user_def0[5:0];
    } MIPI0_USER_DEF @ 0x1104;

    reg {
        name = "MIPI0_CTRL_MODE_HS";
        desc = "Data sheet 9.3.6 MIPI0_CTRL_MODE_HS (offset 0x1108, printed page 9-172, `hi3516av300--Hi3516AV300-Datasheet.txt` line 45073).";

        field {
            name = "user_def_en";
            desc = "User def enable. Chinese-only data sheet: description and value encoding not translated.";
            sw = rw;
            hw = r;
            reset = 0x0;
        } user_def_en[8:8];

        field {
            name = "vc_mode";
            desc = "Vc mode. Chinese-only data sheet: description and value encoding not translated.";
            sw = rw;
            hw = r;
            reset = 0x0;
        } vc_mode[4:4];

        field {
            name = "hdr_mode";
            desc = "Hdr mode. Chinese-only data sheet: description and value encoding not translated.";
            sw = rw;
            hw = r;
            reset = 0x0;
        } hdr_mode[0:0];
    } MIPI0_CTRL_MODE_HS @ 0x1108;

    reg {
        name = "MIPI0_DOL_ID_CODE0";
        desc = "Data sheet 9.3.6 MIPI0_DOL_ID_CODE0 (offset 0x1200, printed page 9-173, `hi3516av300--Hi3516AV300-Datasheet.txt` line 45117).";

        field {
            name = "id_code_reg1";
            desc = "Id code reg1. Chinese-only data sheet: description and value encoding not translated.";
            sw = rw;
            hw = r;
            reset = 0x242;
        } id_code_reg1[31:16];

        field {
            name = "id_code_reg0";
            desc = "Id code reg0. Chinese-only data sheet: description and value encoding not translated.";
            sw = rw;
            hw = r;
            reset = 0x241;
        } id_code_reg0[15:0];
    } MIPI0_DOL_ID_CODE0 @ 0x1200;

    reg {
        name = "MIPI0_DOL_ID_CODE1";
        desc = "Data sheet 9.3.6 MIPI0_DOL_ID_CODE1 (offset 0x1204, printed page 9-173, `hi3516av300--Hi3516AV300-Datasheet.txt` line 45132).";

        field {
            name = "id_code_reg3";
            desc = "Id code reg3. Chinese-only data sheet: description and value encoding not translated.";
            sw = rw;
            hw = r;
            reset = 0x251;
        } id_code_reg3[31:16];

        field {
            name = "id_code_reg2";
            desc = "Id code reg2. Chinese-only data sheet: description and value encoding not translated.";
            sw = rw;
            hw = r;
            reset = 0x244;
        } id_code_reg2[15:0];
    } MIPI0_DOL_ID_CODE1 @ 0x1204;

    reg {
        name = "MIPI0_DOL_ID_CODE2";
        desc = "Data sheet 9.3.6 MIPI0_DOL_ID_CODE2 (offset 0x1208, printed page 9-173, `hi3516av300--Hi3516AV300-Datasheet.txt` line 45155).";

        field {
            name = "id_code_reg5";
            desc = "Id code reg5. Chinese-only data sheet: description and value encoding not translated.";
            sw = rw;
            hw = r;
            reset = 0x254;
        } id_code_reg5[31:16];

        field {
            name = "id_code_reg4";
            desc = "Id code reg4. Chinese-only data sheet: description and value encoding not translated.";
            sw = rw;
            hw = r;
            reset = 0x252;
        } id_code_reg4[15:0];
    } MIPI0_DOL_ID_CODE2 @ 0x1208;

    reg {
        name = "MIPI0_CROP_START_CHN0";
        desc = "Data sheet 9.3.6 MIPI0_CROP_START_CHN0 (offset 0x1210, printed page 9-173, `hi3516av300--Hi3516AV300-Datasheet.txt` line 45175).";

        field {
            name = "mipi_start_y_chn0";
            desc = "Mipi start y chn0. Chinese-only data sheet: description and value encoding not translated.";
            sw = rw;
            hw = r;
            reset = 0x0;
        } mipi_start_y_chn0[31:16];

        field {
            name = "mipi_start_x_chn0";
            desc = "Mipi start x chn0. Chinese-only data sheet: description and value encoding not translated.";
            sw = rw;
            hw = r;
            reset = 0x0;
        } mipi_start_x_chn0[15:0];
    } MIPI0_CROP_START_CHN0 @ 0x1210;

    reg {
        name = "MIPI0_CROP_START_CHN1";
        desc = "Data sheet 9.3.6 MIPI0_CROP_START_CHN1 (offset 0x1214, printed page 9-174, `hi3516av300--Hi3516AV300-Datasheet.txt` line 45193).";

        field {
            name = "mipi_start_y_chn1";
            desc = "Mipi start y chn1. Chinese-only data sheet: description and value encoding not translated.";
            sw = rw;
            hw = r;
            reset = 0x0;
        } mipi_start_y_chn1[31:16];

        field {
            name = "mipi_start_x_chn1";
            desc = "Mipi start x chn1. Chinese-only data sheet: description and value encoding not translated.";
            sw = rw;
            hw = r;
            reset = 0x0;
        } mipi_start_x_chn1[15:0];
    } MIPI0_CROP_START_CHN1 @ 0x1214;

    reg {
        name = "MIPI0_CROP_START_CHN2";
        desc = "Data sheet 9.3.6 MIPI0_CROP_START_CHN2 (offset 0x1218, printed page 9-174, `hi3516av300--Hi3516AV300-Datasheet.txt` line 45208).";

        field {
            name = "mipi_start_y_chn2";
            desc = "Mipi start y chn2. Chinese-only data sheet: description and value encoding not translated.";
            sw = rw;
            hw = r;
            reset = 0x0;
        } mipi_start_y_chn2[31:16];

        field {
            name = "mipi_start_x_chn2";
            desc = "Mipi start x chn2. Chinese-only data sheet: description and value encoding not translated.";
            sw = rw;
            hw = r;
            reset = 0x0;
        } mipi_start_x_chn2[15:0];
    } MIPI0_CROP_START_CHN2 @ 0x1218;

    reg {
        name = "MIPI0_CROP_START_CHN3";
        desc = "Data sheet 9.3.6 MIPI0_CROP_START_CHN3 (offset 0x121C, printed page 9-174, `hi3516av300--Hi3516AV300-Datasheet.txt` line 45229).";

        field {
            name = "mipi_start_y_chn3";
            desc = "Mipi start y chn3. Chinese-only data sheet: description and value encoding not translated.";
            sw = rw;
            hw = r;
            reset = 0x0;
        } mipi_start_y_chn3[31:16];

        field {
            name = "mipi_start_x_chn3";
            desc = "Mipi start x chn3. Chinese-only data sheet: description and value encoding not translated.";
            sw = rw;
            hw = r;
            reset = 0x0;
        } mipi_start_x_chn3[15:0];
    } MIPI0_CROP_START_CHN3 @ 0x121C;

    reg {
        name = "MIPI0_IMGSIZE";
        desc = "Data sheet 9.3.6 MIPI0_IMGSIZE (offset 0x1224, printed page 9-174, `hi3516av300--Hi3516AV300-Datasheet.txt` line 45249).";

        field {
            name = "mipi_imgheight";
            desc = "Mipi imgheight. Chinese-only data sheet: description and value encoding not translated.";
            sw = rw;
            hw = r;
            reset = 0x0;
        } mipi_imgheight[31:16];

        field {
            name = "mipi_imgwidth";
            desc = "Mipi imgwidth. Chinese-only data sheet: description and value encoding not translated.";
            sw = rw;
            hw = r;
            reset = 0x0;
        } mipi_imgwidth[15:0];
    } MIPI0_IMGSIZE @ 0x1224;

    reg {
        name = "MIPI0_CTRL_MODE_PIXEL";
        desc = "Data sheet 9.3.6 MIPI0_CTRL_MODE_PIXEL (offset 0x1230, printed page 9-175, `hi3516av300--Hi3516AV300-Datasheet.txt` line 45267).";

        field {
            name = "mipi_yuv420_even_detect";
            desc = "Mipi yuv420 even detect. Chinese-only data sheet: description and value encoding not translated.";
            sw = rw;
            hw = r;
            reset = 0x0;
        } mipi_yuv420_even_detect[22:22];

        field {
            name = "mipi_yuv_420_legacy_en";
            desc = "Mipi yuv 420 legacy enable. Chinese-only data sheet: description and value encoding not translated.";
            sw = rw;
            hw = r;
            reset = 0x0;
        } mipi_yuv_420_legacy_en[20:20];

        field {
            name = "mipi_yuv_420_nolegacy_en";
            desc = "Mipi yuv 420 nolegacy enable. Chinese-only data sheet: description and value encoding not translated.";
            sw = rw;
            hw = r;
            reset = 0x0;
        } mipi_yuv_420_nolegacy_en[19:19];

        field {
            name = "mipi_yuv_422_en";
            desc = "Mipi yuv 422 enable. Chinese-only data sheet: description and value encoding not translated.";
            sw = rw;
            hw = r;
            reset = 0x0;
        } mipi_yuv_422_en[18:18];

        field {
            name = "stagger_frm_num";
            desc = "Stagger frm number. Chinese-only data sheet: description and value encoding not translated.";
            sw = rw;
            hw = r;
            reset = 0x0;
        } stagger_frm_num[14:13];

        field {
            name = "stagger_hdr_mode";
            desc = "Stagger hdr mode. Chinese-only data sheet: description and value encoding not translated.";
            sw = rw;
            hw = r;
            reset = 0x0;
        } stagger_hdr_mode[12:12];

        field {
            name = "sync_clear_en";
            desc = "Sync clear enable. Chinese-only data sheet: description and value encoding not translated.";
            sw = rw;
            hw = r;
            reset = 0x0;
        } sync_clear_en[11:11];

        field {
            name = "mipi_dol_mode";
            desc = "Mipi dol mode. Chinese-only data sheet: description and value encoding not translated.";
            sw = rw;
            hw = r;
            reset = 0x0;
        } mipi_dol_mode[4:4];

        field {
            name = "crop_en";
            desc = "Crop enable. Chinese-only data sheet: description and value encoding not translated.";
            sw = rw;
            hw = r;
            reset = 0x0;
        } crop_en[0:0];
    } MIPI0_CTRL_MODE_PIXEL @ 0x1230;

    reg {
        name = "MIPI0_DUMMY_PIX_REG";
        desc = "Data sheet 9.3.6 MIPI0_DUMMY_PIX_REG (offset 0x1240, printed page 9-176, `hi3516av300--Hi3516AV300-Datasheet.txt` line 45355).";

        field {
            name = "dummy_pix_reg";
            desc = "Dummy pix reg. Chinese-only data sheet: description and value encoding not translated.";
            sw = rw;
            hw = r;
            reset = 0x0;
        } dummy_pix_reg[15:0];
    } MIPI0_DUMMY_PIX_REG @ 0x1240;

    reg {
        name = "MIPI0_YUVEVEN_THOLD";
        desc = "Data sheet 9.3.6 MIPI0_YUVEVEN_THOLD (offset 0x1244, printed page 9-176, `hi3516av300--Hi3516AV300-Datasheet.txt` line 45378).";

        field {
            name = "mipi_yuv_even_thold";
            desc = "Mipi yuv even thold. Chinese-only data sheet: description and value encoding not translated.";
            sw = rw;
            hw = r;
            reset = 0x9D0;
        } mipi_yuv_even_thold[15:0];
    } MIPI0_YUVEVEN_THOLD @ 0x1244;

    reg {
        name = "MIPI0_IMGSIZE0_STATIS";
        desc = "Data sheet 9.3.6 MIPI0_IMGSIZE0_STATIS (offset 0x1250, printed page 9-176, `hi3516av300--Hi3516AV300-Datasheet.txt` line 45399).";

        field {
            name = "imgheight_statis_vc0";
            desc = "Imgheight statis vc0. Chinese-only data sheet: description and value encoding not translated.";
            sw = r;
            hw = w;
            reset = 0x0;
        } imgheight_statis_vc0[31:16];

        field {
            name = "imgwidth_statis_vc0";
            desc = "Imgwidth statis vc0. Chinese-only data sheet: description and value encoding not translated.";
            sw = r;
            hw = w;
            reset = 0x0;
        } imgwidth_statis_vc0[15:0];
    } MIPI0_IMGSIZE0_STATIS @ 0x1250;

    reg {
        name = "MIPI0_IMGSIZE1_STATIS";
        desc = "Data sheet 9.3.6 MIPI0_IMGSIZE1_STATIS (offset 0x1254, printed page 9-177, `hi3516av300--Hi3516AV300-Datasheet.txt` line 45423).";

        field {
            name = "imgheight_statis_vc1";
            desc = "Imgheight statis vc1. Chinese-only data sheet: description and value encoding not translated.";
            sw = r;
            hw = w;
            reset = 0x0;
        } imgheight_statis_vc1[31:16];

        field {
            name = "imgwidth_statis_vc1";
            desc = "Imgwidth statis vc1. Chinese-only data sheet: description and value encoding not translated.";
            sw = r;
            hw = w;
            reset = 0x0;
        } imgwidth_statis_vc1[15:0];
    } MIPI0_IMGSIZE1_STATIS @ 0x1254;

    reg {
        name = "MIPI0_IMGSIZE2_STATIS";
        desc = "Data sheet 9.3.6 MIPI0_IMGSIZE2_STATIS (offset 0x1258, printed page 9-177, `hi3516av300--Hi3516AV300-Datasheet.txt` line 45443).";

        field {
            name = "imgheight_statis_vc2";
            desc = "Imgheight statis vc2. Chinese-only data sheet: description and value encoding not translated.";
            sw = r;
            hw = w;
            reset = 0x0;
        } imgheight_statis_vc2[31:16];

        field {
            name = "imgwidth_statis_vc2";
            desc = "Imgwidth statis vc2. Chinese-only data sheet: description and value encoding not translated.";
            sw = r;
            hw = w;
            reset = 0x0;
        } imgwidth_statis_vc2[15:0];
    } MIPI0_IMGSIZE2_STATIS @ 0x1258;

    reg {
        name = "MIPI0_IMGSIZE3_STATIS";
        desc = "Data sheet 9.3.6 MIPI0_IMGSIZE3_STATIS (offset 0x125C, printed page 9-177, `hi3516av300--Hi3516AV300-Datasheet.txt` line 45471).";

        field {
            name = "imgheight_statis_vc3";
            desc = "Imgheight statis vc3. Chinese-only data sheet: description and value encoding not translated.";
            sw = r;
            hw = w;
            reset = 0x0;
        } imgheight_statis_vc3[31:16];

        field {
            name = "imgwidth_statis_vc3";
            desc = "Imgwidth statis vc3. Chinese-only data sheet: description and value encoding not translated.";
            sw = r;
            hw = w;
            reset = 0x0;
        } imgwidth_statis_vc3[15:0];
    } MIPI0_IMGSIZE3_STATIS @ 0x125C;

    reg {
        name = "MIPI0_CTRL_INT_RAW";
        desc = "Data sheet 9.3.6 MIPI0_CTRL_INT_RAW (offset 0x12F0, printed page 9-178, `hi3516av300--Hi3516AV300-Datasheet.txt` line 45497).";

        field {
            name = "int_dfifo_rderr_raw";
            desc = "Interrupt dfifo rderr raw. Chinese-only data sheet: description and value encoding not translated.";
            sw = rw;
            hw = w;
            onwrite = woclr;
            reset = 0x0;
        } int_dfifo_rderr_raw[17:17];

        field {
            name = "int_cfifo_rderr_raw";
            desc = "Interrupt cfifo rderr raw. Chinese-only data sheet: description and value encoding not translated.";
            sw = rw;
            hw = w;
            onwrite = woclr;
            reset = 0x0;
        } int_cfifo_rderr_raw[16:16];

        field {
            name = "int_vsync_raw";
            desc = "Interrupt vertical sync raw. Chinese-only data sheet: description and value encoding not translated.";
            sw = rw;
            hw = w;
            onwrite = woclr;
            reset = 0x0;
        } int_vsync_raw[4:4];

        field {
            name = "int_dfifo_wrerr_raw";
            desc = "Interrupt dfifo wrerr raw. Chinese-only data sheet: description and value encoding not translated.";
            sw = rw;
            hw = w;
            onwrite = woclr;
            reset = 0x0;
        } int_dfifo_wrerr_raw[1:1];

        field {
            name = "int_cfifo_wrerr_raw";
            desc = "Interrupt cfifo wrerr raw. Chinese-only data sheet: description and value encoding not translated.";
            sw = rw;
            hw = w;
            onwrite = woclr;
            reset = 0x0;
        } int_cfifo_wrerr_raw[0:0];
    } MIPI0_CTRL_INT_RAW @ 0x12F0;

    reg {
        name = "MIPI0_CTRL_INT";
        desc = "Data sheet 9.3.6 MIPI0_CTRL_INT (offset 0x12F4, printed page 9-178, `hi3516av300--Hi3516AV300-Datasheet.txt` line 45546).";

        field {
            name = "int_dfifo_rderr_st";
            desc = "Interrupt dfifo rderr st. Chinese-only data sheet: description and value encoding not translated.";
            sw = r;
            hw = w;
            reset = 0x0;
        } int_dfifo_rderr_st[17:17];

        field {
            name = "int_cfifo_rderr_st";
            desc = "Interrupt cfifo rderr st. Chinese-only data sheet: description and value encoding not translated.";
            sw = r;
            hw = w;
            reset = 0x0;
        } int_cfifo_rderr_st[16:16];

        field {
            name = "int_vsync_st";
            desc = "Interrupt vertical sync st. Chinese-only data sheet: description and value encoding not translated.";
            sw = r;
            hw = w;
            reset = 0x0;
        } int_vsync_st[4:4];

        field {
            name = "int_dfifo_wrerr_st";
            desc = "Interrupt dfifo wrerr st. Chinese-only data sheet: description and value encoding not translated.";
            sw = r;
            hw = w;
            reset = 0x0;
        } int_dfifo_wrerr_st[1:1];

        field {
            name = "int_cfifo_wrerr_st";
            desc = "Interrupt cfifo wrerr st. Chinese-only data sheet: description and value encoding not translated.";
            sw = r;
            hw = w;
            reset = 0x0;
        } int_cfifo_wrerr_st[0:0];
    } MIPI0_CTRL_INT @ 0x12F4;

    reg {
        name = "MIPI0_CTRL_INT_MSK";
        desc = "Data sheet 9.3.6 MIPI0_CTRL_INT_MSK (offset 0x12F8, printed page 9-179, `hi3516av300--Hi3516AV300-Datasheet.txt` line 45596).";

        field {
            name = "int_dfifo_rderr_msk";
            desc = "Interrupt dfifo rderr mask. Chinese-only data sheet: description and value encoding not translated.";
            sw = rw;
            hw = r;
            reset = 0x0;
        } int_dfifo_rderr_msk[17:17];

        field {
            name = "int_cfifo_rderr_msk";
            desc = "Interrupt cfifo rderr mask. Chinese-only data sheet: description and value encoding not translated.";
            sw = rw;
            hw = r;
            reset = 0x0;
        } int_cfifo_rderr_msk[16:16];

        field {
            name = "int_vsync_msk";
            desc = "Interrupt vertical sync mask. Chinese-only data sheet: description and value encoding not translated.";
            sw = rw;
            hw = r;
            reset = 0x0;
        } int_vsync_msk[4:4];

        field {
            name = "int_dfifo_wrerr_msk";
            desc = "Interrupt dfifo wrerr mask. Chinese-only data sheet: description and value encoding not translated.";
            sw = rw;
            hw = r;
            reset = 0x0;
        } int_dfifo_wrerr_msk[1:1];

        field {
            name = "int_cfifo_wrerr_msk";
            desc = "Interrupt cfifo wrerr mask. Chinese-only data sheet: description and value encoding not translated.";
            sw = rw;
            hw = r;
            reset = 0x0;
        } int_cfifo_wrerr_msk[0:0];
    } MIPI0_CTRL_INT_MSK @ 0x12F8;

    reg {
        name = "LVDS0_WDR";
        desc = "Data sheet 9.3.6 LVDS0_WDR (offset 0x1300, printed page 9-180, `hi3516av300--Hi3516AV300-Datasheet.txt` line 45652).";

        field {
            name = "lvds_wdr_id_shift";
            desc = "Lvds WDR id shift. Chinese-only data sheet: description and value encoding not translated.";
            sw = rw;
            hw = r;
            reset = 0x0;
        } lvds_wdr_id_shift[15:12];

        field {
            name = "lvds_wdr_mode";
            desc = "Lvds WDR mode. Chinese-only data sheet: description and value encoding not translated.";
            sw = rw;
            hw = r;
            reset = 0x0;
        } lvds_wdr_mode[11:8];

        field {
            name = "lvds_wdr_num";
            desc = "Lvds WDR number. Chinese-only data sheet: description and value encoding not translated.";
            sw = rw;
            hw = r;
            reset = 0x0;
        } lvds_wdr_num[5:4];

        field {
            name = "lvds_wdr_en";
            desc = "Lvds WDR enable. Chinese-only data sheet: description and value encoding not translated.";
            sw = rw;
            hw = r;
            reset = 0x0;
        } lvds_wdr_en[0:0];
    } LVDS0_WDR @ 0x1300;

    reg {
        name = "LVDS0_DOLSCD_HBLK";
        desc = "Data sheet 9.3.6 LVDS0_DOLSCD_HBLK (offset 0x1304, printed page 9-181, `hi3516av300--Hi3516AV300-Datasheet.txt` line 45734).";

        field {
            name = "dol_hblank2";
            desc = "Dol hblank2. Chinese-only data sheet: description and value encoding not translated.";
            sw = rw;
            hw = r;
            reset = 0x0;
        } dol_hblank2[31:16];

        field {
            name = "dol_hblank1";
            desc = "Dol hblank1. Chinese-only data sheet: description and value encoding not translated.";
            sw = rw;
            hw = r;
            reset = 0x0;
        } dol_hblank1[15:0];
    } LVDS0_DOLSCD_HBLK @ 0x1304;

    reg {
        name = "LVDS0_CTRL";
        desc = "Data sheet 9.3.6 LVDS0_CTRL (offset 0x1308, printed page 9-181, `hi3516av300--Hi3516AV300-Datasheet.txt` line 45757).";

        field {
            name = "lvds_crop_en";
            desc = "Lvds crop enable. Chinese-only data sheet: description and value encoding not translated.";
            sw = rw;
            hw = r;
            reset = 0x0;
        } lvds_crop_en[12:12];

        field {
            name = "lvds_code_big_endian";
            desc = "Lvds code big endian. Chinese-only data sheet: description and value encoding not translated.";
            sw = rw;
            hw = r;
            reset = 0x1;
        } lvds_code_big_endian[9:9];

        field {
            name = "lvds_pix_big_endian";
            desc = "Lvds pix big endian. Chinese-only data sheet: description and value encoding not translated.";
            sw = rw;
            hw = r;
            reset = 0x1;
        } lvds_pix_big_endian[8:8];

        field {
            name = "lvds_raw_type";
            desc = "Lvds raw type. Chinese-only data sheet: description and value encoding not translated.";
            sw = rw;
            hw = r;
            reset = 0x3;
        } lvds_raw_type[6:4];

        field {
            name = "lvds_sync_mode";
            desc = "Lvds sync mode. Chinese-only data sheet: description and value encoding not translated.";
            sw = rw;
            hw = r;
            reset = 0x0;
        } lvds_sync_mode[0:0];
    } LVDS0_CTRL @ 0x1308;

    reg {
        name = "LVDS0_IMGSIZE";
        desc = "Data sheet 9.3.6 LVDS0_IMGSIZE (offset 0x130C, printed page 9-182, `hi3516av300--Hi3516AV300-Datasheet.txt` line 45847).";

        field {
            name = "lvds_imgheight";
            desc = "Lvds imgheight. Chinese-only data sheet: description and value encoding not translated.";
            sw = rw;
            hw = r;
            reset = 0x0;
        } lvds_imgheight[31:16];

        field {
            name = "lvds_imgwidth_lane";
            desc = "Lvds imgwidth lane. Chinese-only data sheet: description and value encoding not translated.";
            sw = rw;
            hw = r;
            reset = 0x0;
        } lvds_imgwidth_lane[15:0];
    } LVDS0_IMGSIZE @ 0x130C;

    reg {
        name = "LVDS0_CROP_START0";
        desc = "Data sheet 9.3.6 LVDS0_CROP_START0 (offset 0x1310, printed page 9-183, `hi3516av300--Hi3516AV300-Datasheet.txt` line 45868).";

        field {
            name = "lvds_start_y0";
            desc = "Lvds start y0. Chinese-only data sheet: description and value encoding not translated.";
            sw = rw;
            hw = r;
            reset = 0x0;
        } lvds_start_y0[31:16];

        field {
            name = "lvds_start_x0_lane";
            desc = "Lvds start x0 lane. Chinese-only data sheet: description and value encoding not translated.";
            sw = rw;
            hw = r;
            reset = 0x0;
        } lvds_start_x0_lane[15:0];
    } LVDS0_CROP_START0 @ 0x1310;

    reg {
        name = "LVDS0_CROP_START1";
        desc = "Data sheet 9.3.6 LVDS0_CROP_START1 (offset 0x1314, printed page 9-183, `hi3516av300--Hi3516AV300-Datasheet.txt` line 45887).";

        field {
            name = "lvds_start_y1";
            desc = "Lvds start y1. Chinese-only data sheet: description and value encoding not translated.";
            sw = rw;
            hw = r;
            reset = 0x0;
        } lvds_start_y1[31:16];

        field {
            name = "lvds_start_x1_lane";
            desc = "Lvds start x1 lane. Chinese-only data sheet: description and value encoding not translated.";
            sw = rw;
            hw = r;
            reset = 0x0;
        } lvds_start_x1_lane[15:0];
    } LVDS0_CROP_START1 @ 0x1314;

    reg {
        name = "LVDS0_CROP_START2";
        desc = "Data sheet 9.3.6 LVDS0_CROP_START2 (offset 0x1318, printed page 9-183, `hi3516av300--Hi3516AV300-Datasheet.txt` line 45913).";

        field {
            name = "lvds_start_y2";
            desc = "Lvds start y2. Chinese-only data sheet: description and value encoding not translated.";
            sw = rw;
            hw = r;
            reset = 0x0;
        } lvds_start_y2[31:16];

        field {
            name = "lvds_start_x2_lane";
            desc = "Lvds start x2 lane. Chinese-only data sheet: description and value encoding not translated.";
            sw = rw;
            hw = r;
            reset = 0x0;
        } lvds_start_x2_lane[15:0];
    } LVDS0_CROP_START2 @ 0x1318;

    reg {
        name = "LVDS0_CROP_START3";
        desc = "Data sheet 9.3.6 LVDS0_CROP_START3 (offset 0x131C, printed page 9-183, `hi3516av300--Hi3516AV300-Datasheet.txt` line 45932).";

        field {
            name = "lvds_start_y3";
            desc = "Lvds start y3. Chinese-only data sheet: description and value encoding not translated.";
            sw = rw;
            hw = r;
            reset = 0x0;
        } lvds_start_y3[31:16];

        field {
            name = "lvds_start_x3_lane";
            desc = "Lvds start x3 lane. Chinese-only data sheet: description and value encoding not translated.";
            sw = rw;
            hw = r;
            reset = 0x0;
        } lvds_start_x3_lane[15:0];
    } LVDS0_CROP_START3 @ 0x131C;

    reg {
        name = "LVDS0_LANE0_SOF_01";
        desc = "Data sheet 9.3.6 LVDS0_LANE0_SOF_01 (offset 0x1320, printed page 9-184, `hi3516av300--Hi3516AV300-Datasheet.txt` line 45957).";

        field {
            name = "lane0_sof_1";
            desc = "Lane0 sof 1. Chinese-only data sheet: description and value encoding not translated.";
            sw = rw;
            hw = r;
            reset = 0x0;
        } lane0_sof_1[31:16];

        field {
            name = "lane0_sof_0";
            desc = "Lane0 sof 0. Chinese-only data sheet: description and value encoding not translated.";
            sw = rw;
            hw = r;
            reset = 0x0;
        } lane0_sof_0[15:0];
    } LVDS0_LANE0_SOF_01 @ 0x1320;

    reg {
        name = "LVDS0_LANE0_SOF_23";
        desc = "Data sheet 9.3.6 LVDS0_LANE0_SOF_23 (offset 0x1324, printed page 9-184, `hi3516av300--Hi3516AV300-Datasheet.txt` line 45991).";

        field {
            name = "lane0_sof_3";
            desc = "Lane0 sof 3. Chinese-only data sheet: description and value encoding not translated.";
            sw = rw;
            hw = r;
            reset = 0x0;
        } lane0_sof_3[31:16];

        field {
            name = "lane0_sof_2";
            desc = "Lane0 sof 2. Chinese-only data sheet: description and value encoding not translated.";
            sw = rw;
            hw = r;
            reset = 0x0;
        } lane0_sof_2[15:0];
    } LVDS0_LANE0_SOF_23 @ 0x1324;

    reg {
        name = "LVDS0_LANE0_EOF_01";
        desc = "Data sheet 9.3.6 LVDS0_LANE0_EOF_01 (offset 0x1328, printed page 9-185, `hi3516av300--Hi3516AV300-Datasheet.txt` line 46021).";

        field {
            name = "lane0_eof_1";
            desc = "Lane0 eof 1. Chinese-only data sheet: description and value encoding not translated.";
            sw = rw;
            hw = r;
            reset = 0x0;
        } lane0_eof_1[31:16];

        field {
            name = "lane0_eof_0";
            desc = "Lane0 eof 0. Chinese-only data sheet: description and value encoding not translated.";
            sw = rw;
            hw = r;
            reset = 0x0;
        } lane0_eof_0[15:0];
    } LVDS0_LANE0_EOF_01 @ 0x1328;

    reg {
        name = "LVDS0_LANE0_EOF_23";
        desc = "Data sheet 9.3.6 LVDS0_LANE0_EOF_23 (offset 0x132C, printed page 9-185, `hi3516av300--Hi3516AV300-Datasheet.txt` line 46049).";

        field {
            name = "lane0_eof_3";
            desc = "Lane0 eof 3. Chinese-only data sheet: description and value encoding not translated.";
            sw = rw;
            hw = r;
            reset = 0x0;
        } lane0_eof_3[31:16];

        field {
            name = "lane0_eof_2";
            desc = "Lane0 eof 2. Chinese-only data sheet: description and value encoding not translated.";
            sw = rw;
            hw = r;
            reset = 0x0;
        } lane0_eof_2[15:0];
    } LVDS0_LANE0_EOF_23 @ 0x132C;

    reg {
        name = "LVDS0_LANE0_SOL_01";
        desc = "Data sheet 9.3.6 LVDS0_LANE0_SOL_01 (offset 0x1330, printed page 9-185, `hi3516av300--Hi3516AV300-Datasheet.txt` line 46077).";

        field {
            name = "lane0_sol_1";
            desc = "Lane0 sol 1. Chinese-only data sheet: description and value encoding not translated.";
            sw = rw;
            hw = r;
            reset = 0x0;
        } lane0_sol_1[31:16];

        field {
            name = "lane0_sol_0";
            desc = "Lane0 sol 0. Chinese-only data sheet: description and value encoding not translated.";
            sw = rw;
            hw = r;
            reset = 0x0;
        } lane0_sol_0[15:0];
    } LVDS0_LANE0_SOL_01 @ 0x1330;

    reg {
        name = "LVDS0_LANE0_SOL_23";
        desc = "Data sheet 9.3.6 LVDS0_LANE0_SOL_23 (offset 0x1334, printed page 9-186, `hi3516av300--Hi3516AV300-Datasheet.txt` line 46111).";

        field {
            name = "lane0_sol_3";
            desc = "Lane0 sol 3. Chinese-only data sheet: description and value encoding not translated.";
            sw = rw;
            hw = r;
            reset = 0x0;
        } lane0_sol_3[31:16];

        field {
            name = "lane0_sol_2";
            desc = "Lane0 sol 2. Chinese-only data sheet: description and value encoding not translated.";
            sw = rw;
            hw = r;
            reset = 0x0;
        } lane0_sol_2[15:0];
    } LVDS0_LANE0_SOL_23 @ 0x1334;

    reg {
        name = "LVDS0_LANE0_EOL_01";
        desc = "Data sheet 9.3.6 LVDS0_LANE0_EOL_01 (offset 0x1338, printed page 9-186, `hi3516av300--Hi3516AV300-Datasheet.txt` line 46145).";

        field {
            name = "lane0_eol_1";
            desc = "Lane0 eol 1. Chinese-only data sheet: description and value encoding not translated.";
            sw = rw;
            hw = r;
            reset = 0x0;
        } lane0_eol_1[31:16];

        field {
            name = "lane0_eol_0";
            desc = "Lane0 eol 0. Chinese-only data sheet: description and value encoding not translated.";
            sw = rw;
            hw = r;
            reset = 0x0;
        } lane0_eol_0[15:0];
    } LVDS0_LANE0_EOL_01 @ 0x1338;

    reg {
        name = "LVDS0_LANE0_EOL_23";
        desc = "Data sheet 9.3.6 LVDS0_LANE0_EOL_23 (offset 0x133C, printed page 9-187, `hi3516av300--Hi3516AV300-Datasheet.txt` line 46176).";

        field {
            name = "lane0_eol_3";
            desc = "Lane0 eol 3. Chinese-only data sheet: description and value encoding not translated.";
            sw = rw;
            hw = r;
            reset = 0x0;
        } lane0_eol_3[31:16];

        field {
            name = "lane0_eol_2";
            desc = "Lane0 eol 2. Chinese-only data sheet: description and value encoding not translated.";
            sw = rw;
            hw = r;
            reset = 0x0;
        } lane0_eol_2[15:0];
    } LVDS0_LANE0_EOL_23 @ 0x133C;

    reg {
        name = "LVDS0_LANE1_SOF_01";
        desc = "Data sheet 9.3.6 LVDS0_LANE1_SOF_01 (offset 0x1340, printed page 9-184, `hi3516av300--Hi3516AV300-Datasheet.txt` line 45957).";

        field {
            name = "lane1_sof_1";
            desc = "Lane1 sof 1. Chinese-only data sheet: description and value encoding not translated.";
            sw = rw;
            hw = r;
            reset = 0x0;
        } lane1_sof_1[31:16];

        field {
            name = "lane1_sof_0";
            desc = "Lane1 sof 0. Chinese-only data sheet: description and value encoding not translated.";
            sw = rw;
            hw = r;
            reset = 0x0;
        } lane1_sof_0[15:0];
    } LVDS0_LANE1_SOF_01 @ 0x1340;

    reg {
        name = "LVDS0_LANE1_SOF_23";
        desc = "Data sheet 9.3.6 LVDS0_LANE1_SOF_23 (offset 0x1344, printed page 9-184, `hi3516av300--Hi3516AV300-Datasheet.txt` line 45991).";

        field {
            name = "lane1_sof_3";
            desc = "Lane1 sof 3. Chinese-only data sheet: description and value encoding not translated.";
            sw = rw;
            hw = r;
            reset = 0x0;
        } lane1_sof_3[31:16];

        field {
            name = "lane1_sof_2";
            desc = "Lane1 sof 2. Chinese-only data sheet: description and value encoding not translated.";
            sw = rw;
            hw = r;
            reset = 0x0;
        } lane1_sof_2[15:0];
    } LVDS0_LANE1_SOF_23 @ 0x1344;

    reg {
        name = "LVDS0_LANE1_EOF_01";
        desc = "Data sheet 9.3.6 LVDS0_LANE1_EOF_01 (offset 0x1348, printed page 9-185, `hi3516av300--Hi3516AV300-Datasheet.txt` line 46021).";

        field {
            name = "lane1_eof_1";
            desc = "Lane1 eof 1. Chinese-only data sheet: description and value encoding not translated.";
            sw = rw;
            hw = r;
            reset = 0x0;
        } lane1_eof_1[31:16];

        field {
            name = "lane1_eof_0";
            desc = "Lane1 eof 0. Chinese-only data sheet: description and value encoding not translated.";
            sw = rw;
            hw = r;
            reset = 0x0;
        } lane1_eof_0[15:0];
    } LVDS0_LANE1_EOF_01 @ 0x1348;

    reg {
        name = "LVDS0_LANE1_EOF_23";
        desc = "Data sheet 9.3.6 LVDS0_LANE1_EOF_23 (offset 0x134C, printed page 9-185, `hi3516av300--Hi3516AV300-Datasheet.txt` line 46049).";

        field {
            name = "lane1_eof_3";
            desc = "Lane1 eof 3. Chinese-only data sheet: description and value encoding not translated.";
            sw = rw;
            hw = r;
            reset = 0x0;
        } lane1_eof_3[31:16];

        field {
            name = "lane1_eof_2";
            desc = "Lane1 eof 2. Chinese-only data sheet: description and value encoding not translated.";
            sw = rw;
            hw = r;
            reset = 0x0;
        } lane1_eof_2[15:0];
    } LVDS0_LANE1_EOF_23 @ 0x134C;

    reg {
        name = "LVDS0_LANE1_SOL_01";
        desc = "Data sheet 9.3.6 LVDS0_LANE1_SOL_01 (offset 0x1350, printed page 9-185, `hi3516av300--Hi3516AV300-Datasheet.txt` line 46077).";

        field {
            name = "lane1_sol_1";
            desc = "Lane1 sol 1. Chinese-only data sheet: description and value encoding not translated.";
            sw = rw;
            hw = r;
            reset = 0x0;
        } lane1_sol_1[31:16];

        field {
            name = "lane1_sol_0";
            desc = "Lane1 sol 0. Chinese-only data sheet: description and value encoding not translated.";
            sw = rw;
            hw = r;
            reset = 0x0;
        } lane1_sol_0[15:0];
    } LVDS0_LANE1_SOL_01 @ 0x1350;

    reg {
        name = "LVDS0_LANE1_SOL_23";
        desc = "Data sheet 9.3.6 LVDS0_LANE1_SOL_23 (offset 0x1354, printed page 9-186, `hi3516av300--Hi3516AV300-Datasheet.txt` line 46111).";

        field {
            name = "lane1_sol_3";
            desc = "Lane1 sol 3. Chinese-only data sheet: description and value encoding not translated.";
            sw = rw;
            hw = r;
            reset = 0x0;
        } lane1_sol_3[31:16];

        field {
            name = "lane1_sol_2";
            desc = "Lane1 sol 2. Chinese-only data sheet: description and value encoding not translated.";
            sw = rw;
            hw = r;
            reset = 0x0;
        } lane1_sol_2[15:0];
    } LVDS0_LANE1_SOL_23 @ 0x1354;

    reg {
        name = "LVDS0_LANE1_EOL_01";
        desc = "Data sheet 9.3.6 LVDS0_LANE1_EOL_01 (offset 0x1358, printed page 9-186, `hi3516av300--Hi3516AV300-Datasheet.txt` line 46145).";

        field {
            name = "lane1_eol_1";
            desc = "Lane1 eol 1. Chinese-only data sheet: description and value encoding not translated.";
            sw = rw;
            hw = r;
            reset = 0x0;
        } lane1_eol_1[31:16];

        field {
            name = "lane1_eol_0";
            desc = "Lane1 eol 0. Chinese-only data sheet: description and value encoding not translated.";
            sw = rw;
            hw = r;
            reset = 0x0;
        } lane1_eol_0[15:0];
    } LVDS0_LANE1_EOL_01 @ 0x1358;

    reg {
        name = "LVDS0_LANE1_EOL_23";
        desc = "Data sheet 9.3.6 LVDS0_LANE1_EOL_23 (offset 0x135C, printed page 9-187, `hi3516av300--Hi3516AV300-Datasheet.txt` line 46176).";

        field {
            name = "lane1_eol_3";
            desc = "Lane1 eol 3. Chinese-only data sheet: description and value encoding not translated.";
            sw = rw;
            hw = r;
            reset = 0x0;
        } lane1_eol_3[31:16];

        field {
            name = "lane1_eol_2";
            desc = "Lane1 eol 2. Chinese-only data sheet: description and value encoding not translated.";
            sw = rw;
            hw = r;
            reset = 0x0;
        } lane1_eol_2[15:0];
    } LVDS0_LANE1_EOL_23 @ 0x135C;

    reg {
        name = "LVDS0_LANE2_SOF_01";
        desc = "Data sheet 9.3.6 LVDS0_LANE2_SOF_01 (offset 0x1360, printed page 9-184, `hi3516av300--Hi3516AV300-Datasheet.txt` line 45957).";

        field {
            name = "lane2_sof_1";
            desc = "Lane2 sof 1. Chinese-only data sheet: description and value encoding not translated.";
            sw = rw;
            hw = r;
            reset = 0x0;
        } lane2_sof_1[31:16];

        field {
            name = "lane2_sof_0";
            desc = "Lane2 sof 0. Chinese-only data sheet: description and value encoding not translated.";
            sw = rw;
            hw = r;
            reset = 0x0;
        } lane2_sof_0[15:0];
    } LVDS0_LANE2_SOF_01 @ 0x1360;

    reg {
        name = "LVDS0_LANE2_SOF_23";
        desc = "Data sheet 9.3.6 LVDS0_LANE2_SOF_23 (offset 0x1364, printed page 9-184, `hi3516av300--Hi3516AV300-Datasheet.txt` line 45991).";

        field {
            name = "lane2_sof_3";
            desc = "Lane2 sof 3. Chinese-only data sheet: description and value encoding not translated.";
            sw = rw;
            hw = r;
            reset = 0x0;
        } lane2_sof_3[31:16];

        field {
            name = "lane2_sof_2";
            desc = "Lane2 sof 2. Chinese-only data sheet: description and value encoding not translated.";
            sw = rw;
            hw = r;
            reset = 0x0;
        } lane2_sof_2[15:0];
    } LVDS0_LANE2_SOF_23 @ 0x1364;

    reg {
        name = "LVDS0_LANE2_EOF_01";
        desc = "Data sheet 9.3.6 LVDS0_LANE2_EOF_01 (offset 0x1368, printed page 9-185, `hi3516av300--Hi3516AV300-Datasheet.txt` line 46021).";

        field {
            name = "lane2_eof_1";
            desc = "Lane2 eof 1. Chinese-only data sheet: description and value encoding not translated.";
            sw = rw;
            hw = r;
            reset = 0x0;
        } lane2_eof_1[31:16];

        field {
            name = "lane2_eof_0";
            desc = "Lane2 eof 0. Chinese-only data sheet: description and value encoding not translated.";
            sw = rw;
            hw = r;
            reset = 0x0;
        } lane2_eof_0[15:0];
    } LVDS0_LANE2_EOF_01 @ 0x1368;

    reg {
        name = "LVDS0_LANE2_EOF_23";
        desc = "Data sheet 9.3.6 LVDS0_LANE2_EOF_23 (offset 0x136C, printed page 9-185, `hi3516av300--Hi3516AV300-Datasheet.txt` line 46049).";

        field {
            name = "lane2_eof_3";
            desc = "Lane2 eof 3. Chinese-only data sheet: description and value encoding not translated.";
            sw = rw;
            hw = r;
            reset = 0x0;
        } lane2_eof_3[31:16];

        field {
            name = "lane2_eof_2";
            desc = "Lane2 eof 2. Chinese-only data sheet: description and value encoding not translated.";
            sw = rw;
            hw = r;
            reset = 0x0;
        } lane2_eof_2[15:0];
    } LVDS0_LANE2_EOF_23 @ 0x136C;

    reg {
        name = "LVDS0_LANE2_SOL_01";
        desc = "Data sheet 9.3.6 LVDS0_LANE2_SOL_01 (offset 0x1370, printed page 9-185, `hi3516av300--Hi3516AV300-Datasheet.txt` line 46077).";

        field {
            name = "lane2_sol_1";
            desc = "Lane2 sol 1. Chinese-only data sheet: description and value encoding not translated.";
            sw = rw;
            hw = r;
            reset = 0x0;
        } lane2_sol_1[31:16];

        field {
            name = "lane2_sol_0";
            desc = "Lane2 sol 0. Chinese-only data sheet: description and value encoding not translated.";
            sw = rw;
            hw = r;
            reset = 0x0;
        } lane2_sol_0[15:0];
    } LVDS0_LANE2_SOL_01 @ 0x1370;

    reg {
        name = "LVDS0_LANE2_SOL_23";
        desc = "Data sheet 9.3.6 LVDS0_LANE2_SOL_23 (offset 0x1374, printed page 9-186, `hi3516av300--Hi3516AV300-Datasheet.txt` line 46111).";

        field {
            name = "lane2_sol_3";
            desc = "Lane2 sol 3. Chinese-only data sheet: description and value encoding not translated.";
            sw = rw;
            hw = r;
            reset = 0x0;
        } lane2_sol_3[31:16];

        field {
            name = "lane2_sol_2";
            desc = "Lane2 sol 2. Chinese-only data sheet: description and value encoding not translated.";
            sw = rw;
            hw = r;
            reset = 0x0;
        } lane2_sol_2[15:0];
    } LVDS0_LANE2_SOL_23 @ 0x1374;

    reg {
        name = "LVDS0_LANE2_EOL_01";
        desc = "Data sheet 9.3.6 LVDS0_LANE2_EOL_01 (offset 0x1378, printed page 9-186, `hi3516av300--Hi3516AV300-Datasheet.txt` line 46145).";

        field {
            name = "lane2_eol_1";
            desc = "Lane2 eol 1. Chinese-only data sheet: description and value encoding not translated.";
            sw = rw;
            hw = r;
            reset = 0x0;
        } lane2_eol_1[31:16];

        field {
            name = "lane2_eol_0";
            desc = "Lane2 eol 0. Chinese-only data sheet: description and value encoding not translated.";
            sw = rw;
            hw = r;
            reset = 0x0;
        } lane2_eol_0[15:0];
    } LVDS0_LANE2_EOL_01 @ 0x1378;

    reg {
        name = "LVDS0_LANE2_EOL_23";
        desc = "Data sheet 9.3.6 LVDS0_LANE2_EOL_23 (offset 0x137C, printed page 9-187, `hi3516av300--Hi3516AV300-Datasheet.txt` line 46176).";

        field {
            name = "lane2_eol_3";
            desc = "Lane2 eol 3. Chinese-only data sheet: description and value encoding not translated.";
            sw = rw;
            hw = r;
            reset = 0x0;
        } lane2_eol_3[31:16];

        field {
            name = "lane2_eol_2";
            desc = "Lane2 eol 2. Chinese-only data sheet: description and value encoding not translated.";
            sw = rw;
            hw = r;
            reset = 0x0;
        } lane2_eol_2[15:0];
    } LVDS0_LANE2_EOL_23 @ 0x137C;

    reg {
        name = "LVDS0_LANE3_SOF_01";
        desc = "Data sheet 9.3.6 LVDS0_LANE3_SOF_01 (offset 0x1380, printed page 9-184, `hi3516av300--Hi3516AV300-Datasheet.txt` line 45957).";

        field {
            name = "lane3_sof_1";
            desc = "Lane3 sof 1. Chinese-only data sheet: description and value encoding not translated.";
            sw = rw;
            hw = r;
            reset = 0x0;
        } lane3_sof_1[31:16];

        field {
            name = "lane3_sof_0";
            desc = "Lane3 sof 0. Chinese-only data sheet: description and value encoding not translated.";
            sw = rw;
            hw = r;
            reset = 0x0;
        } lane3_sof_0[15:0];
    } LVDS0_LANE3_SOF_01 @ 0x1380;

    reg {
        name = "LVDS0_LANE3_SOF_23";
        desc = "Data sheet 9.3.6 LVDS0_LANE3_SOF_23 (offset 0x1384, printed page 9-184, `hi3516av300--Hi3516AV300-Datasheet.txt` line 45991).";

        field {
            name = "lane3_sof_3";
            desc = "Lane3 sof 3. Chinese-only data sheet: description and value encoding not translated.";
            sw = rw;
            hw = r;
            reset = 0x0;
        } lane3_sof_3[31:16];

        field {
            name = "lane3_sof_2";
            desc = "Lane3 sof 2. Chinese-only data sheet: description and value encoding not translated.";
            sw = rw;
            hw = r;
            reset = 0x0;
        } lane3_sof_2[15:0];
    } LVDS0_LANE3_SOF_23 @ 0x1384;

    reg {
        name = "LVDS0_LANE3_EOF_01";
        desc = "Data sheet 9.3.6 LVDS0_LANE3_EOF_01 (offset 0x1388, printed page 9-185, `hi3516av300--Hi3516AV300-Datasheet.txt` line 46021).";

        field {
            name = "lane3_eof_1";
            desc = "Lane3 eof 1. Chinese-only data sheet: description and value encoding not translated.";
            sw = rw;
            hw = r;
            reset = 0x0;
        } lane3_eof_1[31:16];

        field {
            name = "lane3_eof_0";
            desc = "Lane3 eof 0. Chinese-only data sheet: description and value encoding not translated.";
            sw = rw;
            hw = r;
            reset = 0x0;
        } lane3_eof_0[15:0];
    } LVDS0_LANE3_EOF_01 @ 0x1388;

    reg {
        name = "LVDS0_LANE3_EOF_23";
        desc = "Data sheet 9.3.6 LVDS0_LANE3_EOF_23 (offset 0x138C, printed page 9-185, `hi3516av300--Hi3516AV300-Datasheet.txt` line 46049).";

        field {
            name = "lane3_eof_3";
            desc = "Lane3 eof 3. Chinese-only data sheet: description and value encoding not translated.";
            sw = rw;
            hw = r;
            reset = 0x0;
        } lane3_eof_3[31:16];

        field {
            name = "lane3_eof_2";
            desc = "Lane3 eof 2. Chinese-only data sheet: description and value encoding not translated.";
            sw = rw;
            hw = r;
            reset = 0x0;
        } lane3_eof_2[15:0];
    } LVDS0_LANE3_EOF_23 @ 0x138C;

    reg {
        name = "LVDS0_LANE3_SOL_01";
        desc = "Data sheet 9.3.6 LVDS0_LANE3_SOL_01 (offset 0x1390, printed page 9-185, `hi3516av300--Hi3516AV300-Datasheet.txt` line 46077).";

        field {
            name = "lane3_sol_1";
            desc = "Lane3 sol 1. Chinese-only data sheet: description and value encoding not translated.";
            sw = rw;
            hw = r;
            reset = 0x0;
        } lane3_sol_1[31:16];

        field {
            name = "lane3_sol_0";
            desc = "Lane3 sol 0. Chinese-only data sheet: description and value encoding not translated.";
            sw = rw;
            hw = r;
            reset = 0x0;
        } lane3_sol_0[15:0];
    } LVDS0_LANE3_SOL_01 @ 0x1390;

    reg {
        name = "LVDS0_LANE3_SOL_23";
        desc = "Data sheet 9.3.6 LVDS0_LANE3_SOL_23 (offset 0x1394, printed page 9-186, `hi3516av300--Hi3516AV300-Datasheet.txt` line 46111).";

        field {
            name = "lane3_sol_3";
            desc = "Lane3 sol 3. Chinese-only data sheet: description and value encoding not translated.";
            sw = rw;
            hw = r;
            reset = 0x0;
        } lane3_sol_3[31:16];

        field {
            name = "lane3_sol_2";
            desc = "Lane3 sol 2. Chinese-only data sheet: description and value encoding not translated.";
            sw = rw;
            hw = r;
            reset = 0x0;
        } lane3_sol_2[15:0];
    } LVDS0_LANE3_SOL_23 @ 0x1394;

    reg {
        name = "LVDS0_LANE3_EOL_01";
        desc = "Data sheet 9.3.6 LVDS0_LANE3_EOL_01 (offset 0x1398, printed page 9-186, `hi3516av300--Hi3516AV300-Datasheet.txt` line 46145).";

        field {
            name = "lane3_eol_1";
            desc = "Lane3 eol 1. Chinese-only data sheet: description and value encoding not translated.";
            sw = rw;
            hw = r;
            reset = 0x0;
        } lane3_eol_1[31:16];

        field {
            name = "lane3_eol_0";
            desc = "Lane3 eol 0. Chinese-only data sheet: description and value encoding not translated.";
            sw = rw;
            hw = r;
            reset = 0x0;
        } lane3_eol_0[15:0];
    } LVDS0_LANE3_EOL_01 @ 0x1398;

    reg {
        name = "LVDS0_LANE3_EOL_23";
        desc = "Data sheet 9.3.6 LVDS0_LANE3_EOL_23 (offset 0x139C, printed page 9-187, `hi3516av300--Hi3516AV300-Datasheet.txt` line 46176).";

        field {
            name = "lane3_eol_3";
            desc = "Lane3 eol 3. Chinese-only data sheet: description and value encoding not translated.";
            sw = rw;
            hw = r;
            reset = 0x0;
        } lane3_eol_3[31:16];

        field {
            name = "lane3_eol_2";
            desc = "Lane3 eol 2. Chinese-only data sheet: description and value encoding not translated.";
            sw = rw;
            hw = r;
            reset = 0x0;
        } lane3_eol_2[15:0];
    } LVDS0_LANE3_EOL_23 @ 0x139C;

    reg {
        name = "LVDS0_LANE0_NXT_SOF_01";
        desc = "Data sheet 9.3.6 LVDS0_LANE0_NXT_SOF_01 (offset 0x1520, printed page 9-187, `hi3516av300--Hi3516AV300-Datasheet.txt` line 46212).";

        field {
            name = "lane0_nxt_sof_1";
            desc = "Lane0 nxt sof 1. Chinese-only data sheet: description and value encoding not translated.";
            sw = rw;
            hw = r;
            reset = 0x0;
        } lane0_nxt_sof_1[31:16];

        field {
            name = "lane0_nxt_sof_0";
            desc = "Lane0 nxt sof 0. Chinese-only data sheet: description and value encoding not translated.";
            sw = rw;
            hw = r;
            reset = 0x0;
        } lane0_nxt_sof_0[15:0];
    } LVDS0_LANE0_NXT_SOF_01 @ 0x1520;

    reg {
        name = "LVDS0_LANE0_NXT_SOF_23";
        desc = "Data sheet 9.3.6 LVDS0_LANE0_NXT_SOF_23 (offset 0x1524, printed page 9-188, `hi3516av300--Hi3516AV300-Datasheet.txt` line 46242).";

        field {
            name = "lane0_nxt_sof_3";
            desc = "Lane0 nxt sof 3. Chinese-only data sheet: description and value encoding not translated.";
            sw = rw;
            hw = r;
            reset = 0x0;
        } lane0_nxt_sof_3[31:16];

        field {
            name = "lane0_nxt_sof_2";
            desc = "Lane0 nxt sof 2. Chinese-only data sheet: description and value encoding not translated.";
            sw = rw;
            hw = r;
            reset = 0x0;
        } lane0_nxt_sof_2[15:0];
    } LVDS0_LANE0_NXT_SOF_23 @ 0x1524;

    reg {
        name = "LVDS0_LANE0_NXT_EOF_01";
        desc = "Data sheet 9.3.6 LVDS0_LANE0_NXT_EOF_01 (offset 0x1528, printed page 9-188, `hi3516av300--Hi3516AV300-Datasheet.txt` line 46270).";

        field {
            name = "lane0_nxt_eof_1";
            desc = "Lane0 nxt eof 1. Chinese-only data sheet: description and value encoding not translated.";
            sw = rw;
            hw = r;
            reset = 0x0;
        } lane0_nxt_eof_1[31:16];

        field {
            name = "lane0_nxt_eof_0";
            desc = "Lane0 nxt eof 0. Chinese-only data sheet: description and value encoding not translated.";
            sw = rw;
            hw = r;
            reset = 0x0;
        } lane0_nxt_eof_0[15:0];
    } LVDS0_LANE0_NXT_EOF_01 @ 0x1528;

    reg {
        name = "LVDS0_LANE0_NXT_EOF_23";
        desc = "Data sheet 9.3.6 LVDS0_LANE0_NXT_EOF_23 (offset 0x152C, printed page 9-188, `hi3516av300--Hi3516AV300-Datasheet.txt` line 46298).";

        field {
            name = "lane0_nxt_eof_3";
            desc = "Lane0 nxt eof 3. Chinese-only data sheet: description and value encoding not translated.";
            sw = rw;
            hw = r;
            reset = 0x0;
        } lane0_nxt_eof_3[31:16];

        field {
            name = "lane0_nxt_eof_2";
            desc = "Lane0 nxt eof 2. Chinese-only data sheet: description and value encoding not translated.";
            sw = rw;
            hw = r;
            reset = 0x0;
        } lane0_nxt_eof_2[15:0];
    } LVDS0_LANE0_NXT_EOF_23 @ 0x152C;

    reg {
        name = "LVDS0_LANE0_NXT_SOL_01";
        desc = "Data sheet 9.3.6 LVDS0_LANE0_NXT_SOL_01 (offset 0x1530, printed page 9-189, `hi3516av300--Hi3516AV300-Datasheet.txt` line 46332).";

        field {
            name = "lane0_nxt_sol_1";
            desc = "Lane0 nxt sol 1. Chinese-only data sheet: description and value encoding not translated.";
            sw = rw;
            hw = r;
            reset = 0x0;
        } lane0_nxt_sol_1[31:16];

        field {
            name = "lane0_nxt_sol_0";
            desc = "Lane0 nxt sol 0. Chinese-only data sheet: description and value encoding not translated.";
            sw = rw;
            hw = r;
            reset = 0x0;
        } lane0_nxt_sol_0[15:0];
    } LVDS0_LANE0_NXT_SOL_01 @ 0x1530;

    reg {
        name = "LVDS0_LANE0_NXT_SOL_23";
        desc = "Data sheet 9.3.6 LVDS0_LANE0_NXT_SOL_23 (offset 0x1534, printed page 9-189, `hi3516av300--Hi3516AV300-Datasheet.txt` line 46366).";

        field {
            name = "lane0_nxt_sol_3";
            desc = "Lane0 nxt sol 3. Chinese-only data sheet: description and value encoding not translated.";
            sw = rw;
            hw = r;
            reset = 0x0;
        } lane0_nxt_sol_3[31:16];

        field {
            name = "lane0_nxt_sol_2";
            desc = "Lane0 nxt sol 2. Chinese-only data sheet: description and value encoding not translated.";
            sw = rw;
            hw = r;
            reset = 0x0;
        } lane0_nxt_sol_2[15:0];
    } LVDS0_LANE0_NXT_SOL_23 @ 0x1534;

    reg {
        name = "LVDS0_LANE0_NXT_EOL_01";
        desc = "Data sheet 9.3.6 LVDS0_LANE0_NXT_EOL_01 (offset 0x1538, printed page 9-190, `hi3516av300--Hi3516AV300-Datasheet.txt` line 46397).";

        field {
            name = "lane0_nxt_eol_1";
            desc = "Lane0 nxt eol 1. Chinese-only data sheet: description and value encoding not translated.";
            sw = rw;
            hw = r;
            reset = 0x0;
        } lane0_nxt_eol_1[31:16];

        field {
            name = "lane0_nxt_eol_0";
            desc = "Lane0 nxt eol 0. Chinese-only data sheet: description and value encoding not translated.";
            sw = rw;
            hw = r;
            reset = 0x0;
        } lane0_nxt_eol_0[15:0];
    } LVDS0_LANE0_NXT_EOL_01 @ 0x1538;

    reg {
        name = "LVDS0_LANE0_NXT_EOL_23";
        desc = "Data sheet 9.3.6 LVDS0_LANE0_NXT_EOL_23 (offset 0x153C, printed page 9-190, `hi3516av300--Hi3516AV300-Datasheet.txt` line 46433).";

        field {
            name = "lane0_nxt_eol_3";
            desc = "Lane0 nxt eol 3. Chinese-only data sheet: description and value encoding not translated.";
            sw = rw;
            hw = r;
            reset = 0x0;
        } lane0_nxt_eol_3[31:16];

        field {
            name = "lane0_nxt_eol_2";
            desc = "Lane0 nxt eol 2. Chinese-only data sheet: description and value encoding not translated.";
            sw = rw;
            hw = r;
            reset = 0x0;
        } lane0_nxt_eol_2[15:0];
    } LVDS0_LANE0_NXT_EOL_23 @ 0x153C;

    reg {
        name = "LVDS0_LANE1_NXT_SOF_01";
        desc = "Data sheet 9.3.6 LVDS0_LANE1_NXT_SOF_01 (offset 0x1540, printed page 9-187, `hi3516av300--Hi3516AV300-Datasheet.txt` line 46212).";

        field {
            name = "lane1_nxt_sof_1";
            desc = "Lane1 nxt sof 1. Chinese-only data sheet: description and value encoding not translated.";
            sw = rw;
            hw = r;
            reset = 0x0;
        } lane1_nxt_sof_1[31:16];

        field {
            name = "lane1_nxt_sof_0";
            desc = "Lane1 nxt sof 0. Chinese-only data sheet: description and value encoding not translated.";
            sw = rw;
            hw = r;
            reset = 0x0;
        } lane1_nxt_sof_0[15:0];
    } LVDS0_LANE1_NXT_SOF_01 @ 0x1540;

    reg {
        name = "LVDS0_LANE1_NXT_SOF_23";
        desc = "Data sheet 9.3.6 LVDS0_LANE1_NXT_SOF_23 (offset 0x1544, printed page 9-188, `hi3516av300--Hi3516AV300-Datasheet.txt` line 46242).";

        field {
            name = "lane1_nxt_sof_3";
            desc = "Lane1 nxt sof 3. Chinese-only data sheet: description and value encoding not translated.";
            sw = rw;
            hw = r;
            reset = 0x0;
        } lane1_nxt_sof_3[31:16];

        field {
            name = "lane1_nxt_sof_2";
            desc = "Lane1 nxt sof 2. Chinese-only data sheet: description and value encoding not translated.";
            sw = rw;
            hw = r;
            reset = 0x0;
        } lane1_nxt_sof_2[15:0];
    } LVDS0_LANE1_NXT_SOF_23 @ 0x1544;

    reg {
        name = "LVDS0_LANE1_NXT_EOF_01";
        desc = "Data sheet 9.3.6 LVDS0_LANE1_NXT_EOF_01 (offset 0x1548, printed page 9-188, `hi3516av300--Hi3516AV300-Datasheet.txt` line 46270).";

        field {
            name = "lane1_nxt_eof_1";
            desc = "Lane1 nxt eof 1. Chinese-only data sheet: description and value encoding not translated.";
            sw = rw;
            hw = r;
            reset = 0x0;
        } lane1_nxt_eof_1[31:16];

        field {
            name = "lane1_nxt_eof_0";
            desc = "Lane1 nxt eof 0. Chinese-only data sheet: description and value encoding not translated.";
            sw = rw;
            hw = r;
            reset = 0x0;
        } lane1_nxt_eof_0[15:0];
    } LVDS0_LANE1_NXT_EOF_01 @ 0x1548;

    reg {
        name = "LVDS0_LANE1_NXT_EOF_23";
        desc = "Data sheet 9.3.6 LVDS0_LANE1_NXT_EOF_23 (offset 0x154C, printed page 9-188, `hi3516av300--Hi3516AV300-Datasheet.txt` line 46298).";

        field {
            name = "lane1_nxt_eof_3";
            desc = "Lane1 nxt eof 3. Chinese-only data sheet: description and value encoding not translated.";
            sw = rw;
            hw = r;
            reset = 0x0;
        } lane1_nxt_eof_3[31:16];

        field {
            name = "lane1_nxt_eof_2";
            desc = "Lane1 nxt eof 2. Chinese-only data sheet: description and value encoding not translated.";
            sw = rw;
            hw = r;
            reset = 0x0;
        } lane1_nxt_eof_2[15:0];
    } LVDS0_LANE1_NXT_EOF_23 @ 0x154C;

    reg {
        name = "LVDS0_LANE1_NXT_SOL_01";
        desc = "Data sheet 9.3.6 LVDS0_LANE1_NXT_SOL_01 (offset 0x1550, printed page 9-189, `hi3516av300--Hi3516AV300-Datasheet.txt` line 46332).";

        field {
            name = "lane1_nxt_sol_1";
            desc = "Lane1 nxt sol 1. Chinese-only data sheet: description and value encoding not translated.";
            sw = rw;
            hw = r;
            reset = 0x0;
        } lane1_nxt_sol_1[31:16];

        field {
            name = "lane1_nxt_sol_0";
            desc = "Lane1 nxt sol 0. Chinese-only data sheet: description and value encoding not translated.";
            sw = rw;
            hw = r;
            reset = 0x0;
        } lane1_nxt_sol_0[15:0];
    } LVDS0_LANE1_NXT_SOL_01 @ 0x1550;

    reg {
        name = "LVDS0_LANE1_NXT_SOL_23";
        desc = "Data sheet 9.3.6 LVDS0_LANE1_NXT_SOL_23 (offset 0x1554, printed page 9-189, `hi3516av300--Hi3516AV300-Datasheet.txt` line 46366).";

        field {
            name = "lane1_nxt_sol_3";
            desc = "Lane1 nxt sol 3. Chinese-only data sheet: description and value encoding not translated.";
            sw = rw;
            hw = r;
            reset = 0x0;
        } lane1_nxt_sol_3[31:16];

        field {
            name = "lane1_nxt_sol_2";
            desc = "Lane1 nxt sol 2. Chinese-only data sheet: description and value encoding not translated.";
            sw = rw;
            hw = r;
            reset = 0x0;
        } lane1_nxt_sol_2[15:0];
    } LVDS0_LANE1_NXT_SOL_23 @ 0x1554;

    reg {
        name = "LVDS0_LANE1_NXT_EOL_01";
        desc = "Data sheet 9.3.6 LVDS0_LANE1_NXT_EOL_01 (offset 0x1558, printed page 9-190, `hi3516av300--Hi3516AV300-Datasheet.txt` line 46397).";

        field {
            name = "lane1_nxt_eol_1";
            desc = "Lane1 nxt eol 1. Chinese-only data sheet: description and value encoding not translated.";
            sw = rw;
            hw = r;
            reset = 0x0;
        } lane1_nxt_eol_1[31:16];

        field {
            name = "lane1_nxt_eol_0";
            desc = "Lane1 nxt eol 0. Chinese-only data sheet: description and value encoding not translated.";
            sw = rw;
            hw = r;
            reset = 0x0;
        } lane1_nxt_eol_0[15:0];
    } LVDS0_LANE1_NXT_EOL_01 @ 0x1558;

    reg {
        name = "LVDS0_LANE1_NXT_EOL_23";
        desc = "Data sheet 9.3.6 LVDS0_LANE1_NXT_EOL_23 (offset 0x155C, printed page 9-190, `hi3516av300--Hi3516AV300-Datasheet.txt` line 46433).";

        field {
            name = "lane1_nxt_eol_3";
            desc = "Lane1 nxt eol 3. Chinese-only data sheet: description and value encoding not translated.";
            sw = rw;
            hw = r;
            reset = 0x0;
        } lane1_nxt_eol_3[31:16];

        field {
            name = "lane1_nxt_eol_2";
            desc = "Lane1 nxt eol 2. Chinese-only data sheet: description and value encoding not translated.";
            sw = rw;
            hw = r;
            reset = 0x0;
        } lane1_nxt_eol_2[15:0];
    } LVDS0_LANE1_NXT_EOL_23 @ 0x155C;

    reg {
        name = "LVDS0_LANE2_NXT_SOF_01";
        desc = "Data sheet 9.3.6 LVDS0_LANE2_NXT_SOF_01 (offset 0x1560, printed page 9-187, `hi3516av300--Hi3516AV300-Datasheet.txt` line 46212).";

        field {
            name = "lane2_nxt_sof_1";
            desc = "Lane2 nxt sof 1. Chinese-only data sheet: description and value encoding not translated.";
            sw = rw;
            hw = r;
            reset = 0x0;
        } lane2_nxt_sof_1[31:16];

        field {
            name = "lane2_nxt_sof_0";
            desc = "Lane2 nxt sof 0. Chinese-only data sheet: description and value encoding not translated.";
            sw = rw;
            hw = r;
            reset = 0x0;
        } lane2_nxt_sof_0[15:0];
    } LVDS0_LANE2_NXT_SOF_01 @ 0x1560;

    reg {
        name = "LVDS0_LANE2_NXT_SOF_23";
        desc = "Data sheet 9.3.6 LVDS0_LANE2_NXT_SOF_23 (offset 0x1564, printed page 9-188, `hi3516av300--Hi3516AV300-Datasheet.txt` line 46242).";

        field {
            name = "lane2_nxt_sof_3";
            desc = "Lane2 nxt sof 3. Chinese-only data sheet: description and value encoding not translated.";
            sw = rw;
            hw = r;
            reset = 0x0;
        } lane2_nxt_sof_3[31:16];

        field {
            name = "lane2_nxt_sof_2";
            desc = "Lane2 nxt sof 2. Chinese-only data sheet: description and value encoding not translated.";
            sw = rw;
            hw = r;
            reset = 0x0;
        } lane2_nxt_sof_2[15:0];
    } LVDS0_LANE2_NXT_SOF_23 @ 0x1564;

    reg {
        name = "LVDS0_LANE2_NXT_EOF_01";
        desc = "Data sheet 9.3.6 LVDS0_LANE2_NXT_EOF_01 (offset 0x1568, printed page 9-188, `hi3516av300--Hi3516AV300-Datasheet.txt` line 46270).";

        field {
            name = "lane2_nxt_eof_1";
            desc = "Lane2 nxt eof 1. Chinese-only data sheet: description and value encoding not translated.";
            sw = rw;
            hw = r;
            reset = 0x0;
        } lane2_nxt_eof_1[31:16];

        field {
            name = "lane2_nxt_eof_0";
            desc = "Lane2 nxt eof 0. Chinese-only data sheet: description and value encoding not translated.";
            sw = rw;
            hw = r;
            reset = 0x0;
        } lane2_nxt_eof_0[15:0];
    } LVDS0_LANE2_NXT_EOF_01 @ 0x1568;

    reg {
        name = "LVDS0_LANE2_NXT_EOF_23";
        desc = "Data sheet 9.3.6 LVDS0_LANE2_NXT_EOF_23 (offset 0x156C, printed page 9-188, `hi3516av300--Hi3516AV300-Datasheet.txt` line 46298).";

        field {
            name = "lane2_nxt_eof_3";
            desc = "Lane2 nxt eof 3. Chinese-only data sheet: description and value encoding not translated.";
            sw = rw;
            hw = r;
            reset = 0x0;
        } lane2_nxt_eof_3[31:16];

        field {
            name = "lane2_nxt_eof_2";
            desc = "Lane2 nxt eof 2. Chinese-only data sheet: description and value encoding not translated.";
            sw = rw;
            hw = r;
            reset = 0x0;
        } lane2_nxt_eof_2[15:0];
    } LVDS0_LANE2_NXT_EOF_23 @ 0x156C;

    reg {
        name = "LVDS0_LANE2_NXT_SOL_01";
        desc = "Data sheet 9.3.6 LVDS0_LANE2_NXT_SOL_01 (offset 0x1570, printed page 9-189, `hi3516av300--Hi3516AV300-Datasheet.txt` line 46332).";

        field {
            name = "lane2_nxt_sol_1";
            desc = "Lane2 nxt sol 1. Chinese-only data sheet: description and value encoding not translated.";
            sw = rw;
            hw = r;
            reset = 0x0;
        } lane2_nxt_sol_1[31:16];

        field {
            name = "lane2_nxt_sol_0";
            desc = "Lane2 nxt sol 0. Chinese-only data sheet: description and value encoding not translated.";
            sw = rw;
            hw = r;
            reset = 0x0;
        } lane2_nxt_sol_0[15:0];
    } LVDS0_LANE2_NXT_SOL_01 @ 0x1570;

    reg {
        name = "LVDS0_LANE2_NXT_SOL_23";
        desc = "Data sheet 9.3.6 LVDS0_LANE2_NXT_SOL_23 (offset 0x1574, printed page 9-189, `hi3516av300--Hi3516AV300-Datasheet.txt` line 46366).";

        field {
            name = "lane2_nxt_sol_3";
            desc = "Lane2 nxt sol 3. Chinese-only data sheet: description and value encoding not translated.";
            sw = rw;
            hw = r;
            reset = 0x0;
        } lane2_nxt_sol_3[31:16];

        field {
            name = "lane2_nxt_sol_2";
            desc = "Lane2 nxt sol 2. Chinese-only data sheet: description and value encoding not translated.";
            sw = rw;
            hw = r;
            reset = 0x0;
        } lane2_nxt_sol_2[15:0];
    } LVDS0_LANE2_NXT_SOL_23 @ 0x1574;

    reg {
        name = "LVDS0_LANE2_NXT_EOL_01";
        desc = "Data sheet 9.3.6 LVDS0_LANE2_NXT_EOL_01 (offset 0x1578, printed page 9-190, `hi3516av300--Hi3516AV300-Datasheet.txt` line 46397).";

        field {
            name = "lane2_nxt_eol_1";
            desc = "Lane2 nxt eol 1. Chinese-only data sheet: description and value encoding not translated.";
            sw = rw;
            hw = r;
            reset = 0x0;
        } lane2_nxt_eol_1[31:16];

        field {
            name = "lane2_nxt_eol_0";
            desc = "Lane2 nxt eol 0. Chinese-only data sheet: description and value encoding not translated.";
            sw = rw;
            hw = r;
            reset = 0x0;
        } lane2_nxt_eol_0[15:0];
    } LVDS0_LANE2_NXT_EOL_01 @ 0x1578;

    reg {
        name = "LVDS0_LANE2_NXT_EOL_23";
        desc = "Data sheet 9.3.6 LVDS0_LANE2_NXT_EOL_23 (offset 0x157C, printed page 9-190, `hi3516av300--Hi3516AV300-Datasheet.txt` line 46433).";

        field {
            name = "lane2_nxt_eol_3";
            desc = "Lane2 nxt eol 3. Chinese-only data sheet: description and value encoding not translated.";
            sw = rw;
            hw = r;
            reset = 0x0;
        } lane2_nxt_eol_3[31:16];

        field {
            name = "lane2_nxt_eol_2";
            desc = "Lane2 nxt eol 2. Chinese-only data sheet: description and value encoding not translated.";
            sw = rw;
            hw = r;
            reset = 0x0;
        } lane2_nxt_eol_2[15:0];
    } LVDS0_LANE2_NXT_EOL_23 @ 0x157C;

    reg {
        name = "LVDS0_LANE3_NXT_SOF_01";
        desc = "Data sheet 9.3.6 LVDS0_LANE3_NXT_SOF_01 (offset 0x1580, printed page 9-187, `hi3516av300--Hi3516AV300-Datasheet.txt` line 46212).";

        field {
            name = "lane3_nxt_sof_1";
            desc = "Lane3 nxt sof 1. Chinese-only data sheet: description and value encoding not translated.";
            sw = rw;
            hw = r;
            reset = 0x0;
        } lane3_nxt_sof_1[31:16];

        field {
            name = "lane3_nxt_sof_0";
            desc = "Lane3 nxt sof 0. Chinese-only data sheet: description and value encoding not translated.";
            sw = rw;
            hw = r;
            reset = 0x0;
        } lane3_nxt_sof_0[15:0];
    } LVDS0_LANE3_NXT_SOF_01 @ 0x1580;

    reg {
        name = "LVDS0_LANE3_NXT_SOF_23";
        desc = "Data sheet 9.3.6 LVDS0_LANE3_NXT_SOF_23 (offset 0x1584, printed page 9-188, `hi3516av300--Hi3516AV300-Datasheet.txt` line 46242).";

        field {
            name = "lane3_nxt_sof_3";
            desc = "Lane3 nxt sof 3. Chinese-only data sheet: description and value encoding not translated.";
            sw = rw;
            hw = r;
            reset = 0x0;
        } lane3_nxt_sof_3[31:16];

        field {
            name = "lane3_nxt_sof_2";
            desc = "Lane3 nxt sof 2. Chinese-only data sheet: description and value encoding not translated.";
            sw = rw;
            hw = r;
            reset = 0x0;
        } lane3_nxt_sof_2[15:0];
    } LVDS0_LANE3_NXT_SOF_23 @ 0x1584;

    reg {
        name = "LVDS0_LANE3_NXT_EOF_01";
        desc = "Data sheet 9.3.6 LVDS0_LANE3_NXT_EOF_01 (offset 0x1588, printed page 9-188, `hi3516av300--Hi3516AV300-Datasheet.txt` line 46270).";

        field {
            name = "lane3_nxt_eof_1";
            desc = "Lane3 nxt eof 1. Chinese-only data sheet: description and value encoding not translated.";
            sw = rw;
            hw = r;
            reset = 0x0;
        } lane3_nxt_eof_1[31:16];

        field {
            name = "lane3_nxt_eof_0";
            desc = "Lane3 nxt eof 0. Chinese-only data sheet: description and value encoding not translated.";
            sw = rw;
            hw = r;
            reset = 0x0;
        } lane3_nxt_eof_0[15:0];
    } LVDS0_LANE3_NXT_EOF_01 @ 0x1588;

    reg {
        name = "LVDS0_LANE3_NXT_EOF_23";
        desc = "Data sheet 9.3.6 LVDS0_LANE3_NXT_EOF_23 (offset 0x158C, printed page 9-188, `hi3516av300--Hi3516AV300-Datasheet.txt` line 46298).";

        field {
            name = "lane3_nxt_eof_3";
            desc = "Lane3 nxt eof 3. Chinese-only data sheet: description and value encoding not translated.";
            sw = rw;
            hw = r;
            reset = 0x0;
        } lane3_nxt_eof_3[31:16];

        field {
            name = "lane3_nxt_eof_2";
            desc = "Lane3 nxt eof 2. Chinese-only data sheet: description and value encoding not translated.";
            sw = rw;
            hw = r;
            reset = 0x0;
        } lane3_nxt_eof_2[15:0];
    } LVDS0_LANE3_NXT_EOF_23 @ 0x158C;

    reg {
        name = "LVDS0_LANE3_NXT_SOL_01";
        desc = "Data sheet 9.3.6 LVDS0_LANE3_NXT_SOL_01 (offset 0x1590, printed page 9-189, `hi3516av300--Hi3516AV300-Datasheet.txt` line 46332).";

        field {
            name = "lane3_nxt_sol_1";
            desc = "Lane3 nxt sol 1. Chinese-only data sheet: description and value encoding not translated.";
            sw = rw;
            hw = r;
            reset = 0x0;
        } lane3_nxt_sol_1[31:16];

        field {
            name = "lane3_nxt_sol_0";
            desc = "Lane3 nxt sol 0. Chinese-only data sheet: description and value encoding not translated.";
            sw = rw;
            hw = r;
            reset = 0x0;
        } lane3_nxt_sol_0[15:0];
    } LVDS0_LANE3_NXT_SOL_01 @ 0x1590;

    reg {
        name = "LVDS0_LANE3_NXT_SOL_23";
        desc = "Data sheet 9.3.6 LVDS0_LANE3_NXT_SOL_23 (offset 0x1594, printed page 9-189, `hi3516av300--Hi3516AV300-Datasheet.txt` line 46366).";

        field {
            name = "lane3_nxt_sol_3";
            desc = "Lane3 nxt sol 3. Chinese-only data sheet: description and value encoding not translated.";
            sw = rw;
            hw = r;
            reset = 0x0;
        } lane3_nxt_sol_3[31:16];

        field {
            name = "lane3_nxt_sol_2";
            desc = "Lane3 nxt sol 2. Chinese-only data sheet: description and value encoding not translated.";
            sw = rw;
            hw = r;
            reset = 0x0;
        } lane3_nxt_sol_2[15:0];
    } LVDS0_LANE3_NXT_SOL_23 @ 0x1594;

    reg {
        name = "LVDS0_LANE3_NXT_EOL_01";
        desc = "Data sheet 9.3.6 LVDS0_LANE3_NXT_EOL_01 (offset 0x1598, printed page 9-190, `hi3516av300--Hi3516AV300-Datasheet.txt` line 46397).";

        field {
            name = "lane3_nxt_eol_1";
            desc = "Lane3 nxt eol 1. Chinese-only data sheet: description and value encoding not translated.";
            sw = rw;
            hw = r;
            reset = 0x0;
        } lane3_nxt_eol_1[31:16];

        field {
            name = "lane3_nxt_eol_0";
            desc = "Lane3 nxt eol 0. Chinese-only data sheet: description and value encoding not translated.";
            sw = rw;
            hw = r;
            reset = 0x0;
        } lane3_nxt_eol_0[15:0];
    } LVDS0_LANE3_NXT_EOL_01 @ 0x1598;

    reg {
        name = "LVDS0_LANE3_NXT_EOL_23";
        desc = "Data sheet 9.3.6 LVDS0_LANE3_NXT_EOL_23 (offset 0x159C, printed page 9-190, `hi3516av300--Hi3516AV300-Datasheet.txt` line 46433).";

        field {
            name = "lane3_nxt_eol_3";
            desc = "Lane3 nxt eol 3. Chinese-only data sheet: description and value encoding not translated.";
            sw = rw;
            hw = r;
            reset = 0x0;
        } lane3_nxt_eol_3[31:16];

        field {
            name = "lane3_nxt_eol_2";
            desc = "Lane3 nxt eol 2. Chinese-only data sheet: description and value encoding not translated.";
            sw = rw;
            hw = r;
            reset = 0x0;
        } lane3_nxt_eol_2[15:0];
    } LVDS0_LANE3_NXT_EOL_23 @ 0x159C;

    reg {
        name = "LVDS0_LI_WORD0";
        desc = "Data sheet 9.3.6 LVDS0_LI_WORD0 (offset 0x1720, printed page 9-191, `hi3516av300--Hi3516AV300-Datasheet.txt` line 46462).";

        field {
            name = "li_word0_1";
            desc = "Li word0 1. Chinese-only data sheet: description and value encoding not translated.";
            sw = rw;
            hw = r;
            reset = 0x211;
        } li_word0_1[31:16];

        field {
            name = "li_word0_0";
            desc = "Li word0 0. Chinese-only data sheet: description and value encoding not translated.";
            sw = rw;
            hw = r;
            reset = 0x201;
        } li_word0_0[15:0];
    } LVDS0_LI_WORD0 @ 0x1720;

    reg {
        name = "LVDS0_LI_WORD1";
        desc = "Data sheet 9.3.6 LVDS0_LI_WORD1 (offset 0x1724, printed page 9-191, `hi3516av300--Hi3516AV300-Datasheet.txt` line 46482).";

        field {
            name = "li_word1_1";
            desc = "Li word1 1. Chinese-only data sheet: description and value encoding not translated.";
            sw = rw;
            hw = r;
            reset = 0x212;
        } li_word1_1[31:16];

        field {
            name = "li_word1_0";
            desc = "Li word1 0. Chinese-only data sheet: description and value encoding not translated.";
            sw = rw;
            hw = r;
            reset = 0x202;
        } li_word1_0[15:0];
    } LVDS0_LI_WORD1 @ 0x1724;

    reg {
        name = "LVDS0_LI_WORD2";
        desc = "Data sheet 9.3.6 LVDS0_LI_WORD2 (offset 0x1728, printed page 9-191, `hi3516av300--Hi3516AV300-Datasheet.txt` line 46510).";

        field {
            name = "li_word2_1";
            desc = "Li word2 1. Chinese-only data sheet: description and value encoding not translated.";
            sw = rw;
            hw = r;
            reset = 0x214;
        } li_word2_1[31:16];

        field {
            name = "li_word2_0";
            desc = "Li word2 0. Chinese-only data sheet: description and value encoding not translated.";
            sw = rw;
            hw = r;
            reset = 0x204;
        } li_word2_0[15:0];
    } LVDS0_LI_WORD2 @ 0x1728;

    reg {
        name = "LVDS0_LI_WORD3";
        desc = "Data sheet 9.3.6 LVDS0_LI_WORD3 (offset 0x172C, printed page 9-191, `hi3516av300--Hi3516AV300-Datasheet.txt` line 46531).";

        field {
            name = "li_word3_1";
            desc = "Li word3 1. Chinese-only data sheet: description and value encoding not translated.";
            sw = rw;
            hw = r;
            reset = 0x218;
        } li_word3_1[31:16];

        field {
            name = "li_word3_0";
            desc = "Li word3 0. Chinese-only data sheet: description and value encoding not translated.";
            sw = rw;
            hw = r;
            reset = 0x208;
        } li_word3_0[15:0];
    } LVDS0_LI_WORD3 @ 0x172C;

    reg {
        name = "LVDS0_IMGSIZE0_STATIS";
        desc = "Data sheet 9.3.6 LVDS0_IMGSIZE0_STATIS (offset 0x1780, printed page 9-192, `hi3516av300--Hi3516AV300-Datasheet.txt` line 46557).";

        field {
            name = "lvds_imgheight0";
            desc = "Lvds imgheight0. Chinese-only data sheet: description and value encoding not translated.";
            sw = r;
            hw = w;
            reset = 0x0;
        } lvds_imgheight0[31:16];

        field {
            name = "lvds_imgwidth0";
            desc = "Lvds imgwidth0. Chinese-only data sheet: description and value encoding not translated.";
            sw = r;
            hw = w;
            reset = 0x0;
        } lvds_imgwidth0[15:0];
    } LVDS0_IMGSIZE0_STATIS @ 0x1780;

    reg {
        name = "LVDS0_IMGSIZE1_STATIS";
        desc = "Data sheet 9.3.6 LVDS0_IMGSIZE1_STATIS (offset 0x1784, printed page 9-192, `hi3516av300--Hi3516AV300-Datasheet.txt` line 46583).";

        field {
            name = "lvds_imgheight1";
            desc = "Lvds imgheight1. Chinese-only data sheet: description and value encoding not translated.";
            sw = r;
            hw = w;
            reset = 0x0;
        } lvds_imgheight1[31:16];

        field {
            name = "lvds_imgwidth1";
            desc = "Lvds imgwidth1. Chinese-only data sheet: description and value encoding not translated.";
            sw = r;
            hw = w;
            reset = 0x0;
        } lvds_imgwidth1[15:0];
    } LVDS0_IMGSIZE1_STATIS @ 0x1784;

    reg {
        name = "LVDS0_IMGSIZE2_STATIS";
        desc = "Data sheet 9.3.6 LVDS0_IMGSIZE2_STATIS (offset 0x1788, printed page 9-192, `hi3516av300--Hi3516AV300-Datasheet.txt` line 46603).";

        field {
            name = "lvds_imgheight2";
            desc = "Lvds imgheight2. Chinese-only data sheet: description and value encoding not translated.";
            sw = r;
            hw = w;
            reset = 0x0;
        } lvds_imgheight2[31:16];

        field {
            name = "lvds_imgwidth2";
            desc = "Lvds imgwidth2. Chinese-only data sheet: description and value encoding not translated.";
            sw = r;
            hw = w;
            reset = 0x0;
        } lvds_imgwidth2[15:0];
    } LVDS0_IMGSIZE2_STATIS @ 0x1788;

    reg {
        name = "LVDS0_IMGSIZE3_STATIS";
        desc = "Data sheet 9.3.6 LVDS0_IMGSIZE3_STATIS (offset 0x178C, printed page 9-193, `hi3516av300--Hi3516AV300-Datasheet.txt` line 46629).";

        field {
            name = "lvds_imgheight3";
            desc = "Lvds imgheight3. Chinese-only data sheet: description and value encoding not translated.";
            sw = r;
            hw = w;
            reset = 0x0;
        } lvds_imgheight3[31:16];

        field {
            name = "lvds_imgwidth3";
            desc = "Lvds imgwidth3. Chinese-only data sheet: description and value encoding not translated.";
            sw = r;
            hw = w;
            reset = 0x0;
        } lvds_imgwidth3[15:0];
    } LVDS0_IMGSIZE3_STATIS @ 0x178C;

    reg {
        name = "LVDS0_CTRL_INT_RAW";
        desc = "Data sheet 9.3.6 LVDS0_CTRL_INT_RAW (offset 0x17F0, printed page 9-193, `hi3516av300--Hi3516AV300-Datasheet.txt` line 46650).";

        field {
            name = "lvds_vsync_raw";
            desc = "Lvds vertical sync raw. Chinese-only data sheet: description and value encoding not translated.";
            sw = rw;
            hw = w;
            onwrite = woclr;
            reset = 0x0;
        } lvds_vsync_raw[28:28];

        field {
            name = "cmd_rd_err_raw";
            desc = "Cmd read error raw. Chinese-only data sheet: description and value encoding not translated.";
            sw = rw;
            hw = w;
            onwrite = woclr;
            reset = 0x0;
        } cmd_rd_err_raw[27:27];

        field {
            name = "cmd_wr_err_raw";
            desc = "Cmd write error raw. Chinese-only data sheet: description and value encoding not translated.";
            sw = rw;
            hw = w;
            onwrite = woclr;
            reset = 0x0;
        } cmd_wr_err_raw[26:26];

        field {
            name = "pop_err_raw";
            desc = "Pop error raw. Chinese-only data sheet: description and value encoding not translated.";
            sw = rw;
            hw = w;
            onwrite = woclr;
            reset = 0x0;
        } pop_err_raw[25:25];

        field {
            name = "lvds_state_err_raw";
            desc = "Lvds state error raw. Chinese-only data sheet: description and value encoding not translated.";
            sw = rw;
            hw = w;
            onwrite = woclr;
            reset = 0x0;
        } lvds_state_err_raw[24:24];

        field {
            name = "link0_rd_err_raw";
            desc = "Link0 read error raw. Chinese-only data sheet: description and value encoding not translated.";
            sw = rw;
            hw = w;
            onwrite = woclr;
            reset = 0x0;
        } link0_rd_err_raw[20:20];

        field {
            name = "link0_wr_err_raw";
            desc = "Link0 write error raw. Chinese-only data sheet: description and value encoding not translated.";
            sw = rw;
            hw = w;
            onwrite = woclr;
            reset = 0x0;
        } link0_wr_err_raw[16:16];

        field {
            name = "lane3_sync_err_raw";
            desc = "Lane3 sync error raw. Chinese-only data sheet: description and value encoding not translated.";
            sw = rw;
            hw = w;
            onwrite = woclr;
            reset = 0x0;
        } lane3_sync_err_raw[3:3];

        field {
            name = "lane2_sync_err_raw";
            desc = "Lane2 sync error raw. Chinese-only data sheet: description and value encoding not translated.";
            sw = rw;
            hw = w;
            onwrite = woclr;
            reset = 0x0;
        } lane2_sync_err_raw[2:2];

        field {
            name = "lane1_sync_err_raw";
            desc = "Lane1 sync error raw. Chinese-only data sheet: description and value encoding not translated.";
            sw = rw;
            hw = w;
            onwrite = woclr;
            reset = 0x0;
        } lane1_sync_err_raw[1:1];

        field {
            name = "lane0_sync_err_raw";
            desc = "Lane0 sync error raw. Chinese-only data sheet: description and value encoding not translated.";
            sw = rw;
            hw = w;
            onwrite = woclr;
            reset = 0x0;
        } lane0_sync_err_raw[0:0];
    } LVDS0_CTRL_INT_RAW @ 0x17F0;

    reg {
        name = "LVDS0_CTRL_INT";
        desc = "Data sheet 9.3.6 LVDS0_CTRL_INT (offset 0x17F4, printed page 9-194, `hi3516av300--Hi3516AV300-Datasheet.txt` line 46745).";

        field {
            name = "lvds_vsync_st";
            desc = "Lvds vertical sync st. Chinese-only data sheet: description and value encoding not translated.";
            sw = r;
            hw = w;
            reset = 0x0;
        } lvds_vsync_st[28:28];

        field {
            name = "cmd_rd_err_st";
            desc = "Cmd read error st. Chinese-only data sheet: description and value encoding not translated.";
            sw = r;
            hw = w;
            reset = 0x0;
        } cmd_rd_err_st[27:27];

        field {
            name = "cmd_wr_err_st";
            desc = "Cmd write error st. Chinese-only data sheet: description and value encoding not translated.";
            sw = r;
            hw = w;
            reset = 0x0;
        } cmd_wr_err_st[26:26];

        field {
            name = "pop_err_st";
            desc = "Pop error st. Chinese-only data sheet: description and value encoding not translated.";
            sw = r;
            hw = w;
            reset = 0x0;
        } pop_err_st[25:25];

        field {
            name = "lvds_state_err_st";
            desc = "Lvds state error st. Chinese-only data sheet: description and value encoding not translated.";
            sw = r;
            hw = w;
            reset = 0x0;
        } lvds_state_err_st[24:24];

        field {
            name = "link0_rd_err_st";
            desc = "Link0 read error st. Chinese-only data sheet: description and value encoding not translated.";
            sw = r;
            hw = w;
            reset = 0x0;
        } link0_rd_err_st[20:20];

        field {
            name = "link0_wr_err_st";
            desc = "Link0 write error st. Chinese-only data sheet: description and value encoding not translated.";
            sw = r;
            hw = w;
            reset = 0x0;
        } link0_wr_err_st[16:16];

        field {
            name = "lane3_sync_err_st";
            desc = "Lane3 sync error st. Chinese-only data sheet: description and value encoding not translated.";
            sw = r;
            hw = w;
            reset = 0x0;
        } lane3_sync_err_st[3:3];

        field {
            name = "lane2_sync_err_st";
            desc = "Lane2 sync error st. Chinese-only data sheet: description and value encoding not translated.";
            sw = r;
            hw = w;
            reset = 0x0;
        } lane2_sync_err_st[2:2];

        field {
            name = "lane1_sync_err_st";
            desc = "Lane1 sync error st. Chinese-only data sheet: description and value encoding not translated.";
            sw = r;
            hw = w;
            reset = 0x0;
        } lane1_sync_err_st[1:1];

        field {
            name = "lane0_sync_err_st";
            desc = "Lane0 sync error st. Chinese-only data sheet: description and value encoding not translated.";
            sw = r;
            hw = w;
            reset = 0x0;
        } lane0_sync_err_st[0:0];
    } LVDS0_CTRL_INT @ 0x17F4;

    reg {
        name = "LVDS0_CTRL_INT_MSK";
        desc = "Data sheet 9.3.6 LVDS0_CTRL_INT_MSK (offset 0x17F8, printed page 9-196, `hi3516av300--Hi3516AV300-Datasheet.txt` line 46835).";

        field {
            name = "lvds_vsync_msk";
            desc = "Lvds vertical sync mask. Chinese-only data sheet: description and value encoding not translated.";
            sw = rw;
            hw = r;
            reset = 0x0;
        } lvds_vsync_msk[28:28];

        field {
            name = "cmd_rd_err_msk";
            desc = "Cmd read error mask. Chinese-only data sheet: description and value encoding not translated.";
            sw = rw;
            hw = r;
            reset = 0x0;
        } cmd_rd_err_msk[27:27];

        field {
            name = "cmd_wr_err_msk";
            desc = "Cmd write error mask. Chinese-only data sheet: description and value encoding not translated.";
            sw = rw;
            hw = r;
            reset = 0x0;
        } cmd_wr_err_msk[26:26];

        field {
            name = "pop_err_msk";
            desc = "Pop error mask. Chinese-only data sheet: description and value encoding not translated.";
            sw = rw;
            hw = r;
            reset = 0x0;
        } pop_err_msk[25:25];

        field {
            name = "lvds_state_err_msk";
            desc = "Lvds state error mask. Chinese-only data sheet: description and value encoding not translated.";
            sw = rw;
            hw = r;
            reset = 0x0;
        } lvds_state_err_msk[24:24];

        field {
            name = "link0_rd_err_msk";
            desc = "Link0 read error mask. Chinese-only data sheet: description and value encoding not translated.";
            sw = rw;
            hw = r;
            reset = 0x0;
        } link0_rd_err_msk[20:20];

        field {
            name = "link0_wr_err_msk";
            desc = "Link0 write error mask. Chinese-only data sheet: description and value encoding not translated.";
            sw = rw;
            hw = r;
            reset = 0x0;
        } link0_wr_err_msk[16:16];

        field {
            name = "lane3_sync_err_msk";
            desc = "Lane3 sync error mask. Chinese-only data sheet: description and value encoding not translated.";
            sw = rw;
            hw = r;
            reset = 0x0;
        } lane3_sync_err_msk[3:3];

        field {
            name = "lane2_sync_err_msk";
            desc = "Lane2 sync error mask. Chinese-only data sheet: description and value encoding not translated.";
            sw = rw;
            hw = r;
            reset = 0x0;
        } lane2_sync_err_msk[2:2];

        field {
            name = "lane1_sync_err_msk";
            desc = "Lane1 sync error mask. Chinese-only data sheet: description and value encoding not translated.";
            sw = rw;
            hw = r;
            reset = 0x0;
        } lane1_sync_err_msk[1:1];

        field {
            name = "lane0_sync_err_msk";
            desc = "Lane0 sync error mask. Chinese-only data sheet: description and value encoding not translated.";
            sw = rw;
            hw = r;
            reset = 0x0;
        } lane0_sync_err_msk[0:0];
    } LVDS0_CTRL_INT_MSK @ 0x17F8;

    reg {
        name = "LANE_ID0_CHN0";
        desc = "Data sheet 9.3.6 LANE_ID0_CHN0 (offset 0x1800, printed page 9-197, `hi3516av300--Hi3516AV300-Datasheet.txt` line 46924).";

        field {
            name = "lane3_id";
            desc = "Lane3 id. Chinese-only data sheet: description and value encoding not translated.";
            sw = rw;
            hw = r;
            reset = 0x3;
        } lane3_id[15:12];

        field {
            name = "lane2_id";
            desc = "Lane2 id. Chinese-only data sheet: description and value encoding not translated.";
            sw = rw;
            hw = r;
            reset = 0x2;
        } lane2_id[11:8];

        field {
            name = "lane1_id";
            desc = "Lane1 id. Chinese-only data sheet: description and value encoding not translated.";
            sw = rw;
            hw = r;
            reset = 0x1;
        } lane1_id[7:4];

        field {
            name = "lane0_id";
            desc = "Lane0 id. Chinese-only data sheet: description and value encoding not translated.";
            sw = rw;
            hw = r;
            reset = 0x0;
        } lane0_id[3:0];
    } LANE_ID0_CHN0 @ 0x1800;

    reg {
        name = "ALIGN0_INT_RAW";
        desc = "Data sheet 9.3.6 ALIGN0_INT_RAW (offset 0x18F0, printed page 9-197, `hi3516av300--Hi3516AV300-Datasheet.txt` line 46965).";

        field {
            name = "err_lane3_raw";
            desc = "Error lane3 raw. Chinese-only data sheet: description and value encoding not translated.";
            sw = rw;
            hw = w;
            onwrite = woclr;
            reset = 0x0;
        } err_lane3_raw[4:4];

        field {
            name = "err_lane2_raw";
            desc = "Error lane2 raw. Chinese-only data sheet: description and value encoding not translated.";
            sw = rw;
            hw = w;
            onwrite = woclr;
            reset = 0x0;
        } err_lane2_raw[3:3];

        field {
            name = "err_lane1_raw";
            desc = "Error lane1 raw. Chinese-only data sheet: description and value encoding not translated.";
            sw = rw;
            hw = w;
            onwrite = woclr;
            reset = 0x0;
        } err_lane1_raw[2:2];

        field {
            name = "err_lane0_raw";
            desc = "Error lane0 raw. Chinese-only data sheet: description and value encoding not translated.";
            sw = rw;
            hw = w;
            onwrite = woclr;
            reset = 0x0;
        } err_lane0_raw[1:1];

        field {
            name = "err_full_raw";
            desc = "Error full raw. Chinese-only data sheet: description and value encoding not translated.";
            sw = rw;
            hw = w;
            onwrite = woclr;
            reset = 0x0;
        } err_full_raw[0:0];
    } ALIGN0_INT_RAW @ 0x18F0;

    reg {
        name = "ALIGN0_INT";
        desc = "Data sheet 9.3.6 ALIGN0_INT (offset 0x18F4, printed page 9-198, `hi3516av300--Hi3516AV300-Datasheet.txt` line 47017).";

        field {
            name = "err_lane3_st";
            desc = "Error lane3 st. Chinese-only data sheet: description and value encoding not translated.";
            sw = r;
            hw = w;
            reset = 0x0;
        } err_lane3_st[4:4];

        field {
            name = "err_lane2_st";
            desc = "Error lane2 st. Chinese-only data sheet: description and value encoding not translated.";
            sw = r;
            hw = w;
            reset = 0x0;
        } err_lane2_st[3:3];

        field {
            name = "err_lane1_st";
            desc = "Error lane1 st. Chinese-only data sheet: description and value encoding not translated.";
            sw = r;
            hw = w;
            reset = 0x0;
        } err_lane1_st[2:2];

        field {
            name = "err_lane0_st";
            desc = "Error lane0 st. Chinese-only data sheet: description and value encoding not translated.";
            sw = r;
            hw = w;
            reset = 0x0;
        } err_lane0_st[1:1];

        field {
            name = "err_full_st";
            desc = "Error full st. Chinese-only data sheet: description and value encoding not translated.";
            sw = r;
            hw = w;
            reset = 0x0;
        } err_full_st[0:0];
    } ALIGN0_INT @ 0x18F4;

    reg {
        name = "ALIGN0_INT_MSK";
        desc = "Data sheet 9.3.6 ALIGN0_INT_MSK (offset 0x18F8, printed page 9-199, `hi3516av300--Hi3516AV300-Datasheet.txt` line 47060).";

        field {
            name = "err_lane3_mask";
            desc = "Error lane3 mask. Chinese-only data sheet: description and value encoding not translated.";
            sw = rw;
            hw = r;
            reset = 0x0;
        } err_lane3_mask[4:4];

        field {
            name = "err_lane2_mask";
            desc = "Error lane2 mask. Chinese-only data sheet: description and value encoding not translated.";
            sw = rw;
            hw = r;
            reset = 0x0;
        } err_lane2_mask[3:3];

        field {
            name = "err_lane1_mask";
            desc = "Error lane1 mask. Chinese-only data sheet: description and value encoding not translated.";
            sw = rw;
            hw = r;
            reset = 0x0;
        } err_lane1_mask[2:2];

        field {
            name = "err_lane0_mask";
            desc = "Error lane0 mask. Chinese-only data sheet: description and value encoding not translated.";
            sw = rw;
            hw = r;
            reset = 0x0;
        } err_lane0_mask[1:1];

        field {
            name = "err_full_mask";
            desc = "Error full mask. Chinese-only data sheet: description and value encoding not translated.";
            sw = rw;
            hw = r;
            reset = 0x0;
        } err_full_mask[0:0];
    } ALIGN0_INT_MSK @ 0x18F8;

    reg {
        name = "CHN0_INT_RAW";
        desc = "Data sheet 9.3.6 CHN0_INT_RAW (offset 0x1FF0, printed page 9-199, `hi3516av300--Hi3516AV300-Datasheet.txt` line 47108).";

        field {
            name = "int_data_align_raw";
            desc = "Interrupt data align raw. Chinese-only data sheet: description and value encoding not translated.";
            sw = rw;
            hw = w;
            onwrite = woclr;
            reset = 0x0;
        } int_data_align_raw[3:3];

        field {
            name = "int_mipi_ctrl_raw";
            desc = "Interrupt mipi control raw. Chinese-only data sheet: description and value encoding not translated.";
            sw = rw;
            hw = w;
            onwrite = woclr;
            reset = 0x0;
        } int_mipi_ctrl_raw[2:2];

        field {
            name = "int_mipi_csi_raw";
            desc = "Interrupt mipi csi raw. Chinese-only data sheet: description and value encoding not translated.";
            sw = rw;
            hw = w;
            onwrite = woclr;
            reset = 0x0;
        } int_mipi_csi_raw[1:1];

        field {
            name = "int_lvds_ctrl_raw";
            desc = "Interrupt lvds control raw. Chinese-only data sheet: description and value encoding not translated.";
            sw = rw;
            hw = w;
            onwrite = woclr;
            reset = 0x0;
        } int_lvds_ctrl_raw[0:0];
    } CHN0_INT_RAW @ 0x1FF0;

    reg {
        name = "CHN0_INT";
        desc = "Data sheet 9.3.6 CHN0_INT (offset 0x1FF4, printed page 9-200, `hi3516av300--Hi3516AV300-Datasheet.txt` line 47151).";

        field {
            name = "int_data_align_st";
            desc = "Interrupt data align st. Chinese-only data sheet: description and value encoding not translated.";
            sw = r;
            hw = w;
            reset = 0x0;
        } int_data_align_st[3:3];

        field {
            name = "int_mipi_ctrl_st";
            desc = "Interrupt mipi control st. Chinese-only data sheet: description and value encoding not translated.";
            sw = r;
            hw = w;
            reset = 0x0;
        } int_mipi_ctrl_st[2:2];

        field {
            name = "int_mipi_csi_st";
            desc = "Interrupt mipi csi st. Chinese-only data sheet: description and value encoding not translated.";
            sw = r;
            hw = w;
            reset = 0x0;
        } int_mipi_csi_st[1:1];

        field {
            name = "int_lvds_ctrl_st";
            desc = "Interrupt lvds control st. Chinese-only data sheet: description and value encoding not translated.";
            sw = r;
            hw = w;
            reset = 0x0;
        } int_lvds_ctrl_st[0:0];
    } CHN0_INT @ 0x1FF4;

    reg {
        name = "CHN0_INT_MASK";
        desc = "Data sheet 9.3.6 CHN0_INT_MASK (offset 0x1FF8, printed page 9-?, `hi3516av300--Hi3516AV300-Datasheet.txt` line 47190).";

        field {
            name = "int_data_align_mask";
            desc = "Interrupt data align mask. Chinese-only data sheet: description and value encoding not translated.";
            sw = rw;
            hw = r;
            reset = 0x0;
        } int_data_align_mask[3:3];

        field {
            name = "int_mipi_ctrl_mask";
            desc = "Interrupt mipi control mask. Chinese-only data sheet: description and value encoding not translated.";
            sw = rw;
            hw = r;
            reset = 0x0;
        } int_mipi_ctrl_mask[2:2];

        field {
            name = "int_mipi_csi_mask";
            desc = "Interrupt mipi csi mask. Chinese-only data sheet: description and value encoding not translated.";
            sw = rw;
            hw = r;
            reset = 0x0;
        } int_mipi_csi_mask[1:1];

        field {
            name = "int_lvds_ctrl_mask";
            desc = "Interrupt lvds control mask. Chinese-only data sheet: description and value encoding not translated.";
            sw = rw;
            hw = r;
            reset = 0x0;
        } int_lvds_ctrl_mask[0:0];
    } CHN0_INT_MASK @ 0x1FF8;

    reg {
        name = "MIPI1_LANES_NUM";
        desc = "Data sheet 9.3.6 MIPI1_LANES_NUM (offset 0x2004, printed page 9-157, `hi3516av300--Hi3516AV300-Datasheet.txt` line 43944).";

        field {
            name = "lane_num";
            desc = "Lane number. Chinese-only data sheet: description and value encoding not translated.";
            sw = rw;
            hw = r;
            reset = 0x3;
        } lane_num[2:0];
    } MIPI1_LANES_NUM @ 0x2004;

    reg {
        name = "MIPI1_MAIN_INT_ST";
        desc = "Data sheet 9.3.6 MIPI1_MAIN_INT_ST (offset 0x200C, printed page 9-157, `hi3516av300--Hi3516AV300-Datasheet.txt` line 43973).";

        field {
            name = "status_int_line";
            desc = "Status interrupt line. Chinese-only data sheet: description and value encoding not translated.";
            sw = r;
            hw = w;
            reset = 0x0;
        } status_int_line[18:18];

        field {
            name = "status_int_pkt";
            desc = "Status interrupt pkt. Chinese-only data sheet: description and value encoding not translated.";
            sw = r;
            hw = w;
            reset = 0x0;
        } status_int_pkt[17:17];

        field {
            name = "status_int_frame_fatal";
            desc = "Status interrupt frame fatal. Chinese-only data sheet: description and value encoding not translated.";
            sw = r;
            hw = w;
            reset = 0x0;
        } status_int_frame_fatal[2:2];

        field {
            name = "status_int_pkt_fatal";
            desc = "Status interrupt pkt fatal. Chinese-only data sheet: description and value encoding not translated.";
            sw = r;
            hw = w;
            reset = 0x0;
        } status_int_pkt_fatal[1:1];
    } MIPI1_MAIN_INT_ST @ 0x200C;

    reg {
        name = "MIPI1_DI_1";
        desc = "Data sheet 9.3.6 MIPI1_DI_1 (offset 0x2010, printed page 9-158, `hi3516av300--Hi3516AV300-Datasheet.txt` line 44029).";

        field {
            name = "di3_vc";
            desc = "Di3 vc. Chinese-only data sheet: description and value encoding not translated.";
            sw = rw;
            hw = r;
            reset = 0x0;
        } di3_vc[31:30];

        field {
            name = "di3_dt";
            desc = "Di3 dt. Chinese-only data sheet: description and value encoding not translated.";
            sw = rw;
            hw = r;
            reset = 0x0;
        } di3_dt[29:24];

        field {
            name = "di2_vc";
            desc = "Di2 vc. Chinese-only data sheet: description and value encoding not translated.";
            sw = rw;
            hw = r;
            reset = 0x0;
        } di2_vc[23:22];

        field {
            name = "di2_dt";
            desc = "Di2 dt. Chinese-only data sheet: description and value encoding not translated.";
            sw = rw;
            hw = r;
            reset = 0x0;
        } di2_dt[21:16];

        field {
            name = "di1_vc";
            desc = "Di1 vc. Chinese-only data sheet: description and value encoding not translated.";
            sw = rw;
            hw = r;
            reset = 0x0;
        } di1_vc[15:14];

        field {
            name = "di1_dt";
            desc = "Di1 dt. Chinese-only data sheet: description and value encoding not translated.";
            sw = rw;
            hw = r;
            reset = 0x0;
        } di1_dt[13:8];

        field {
            name = "di0_vc";
            desc = "Di0 vc. Chinese-only data sheet: description and value encoding not translated.";
            sw = rw;
            hw = r;
            reset = 0x0;
        } di0_vc[7:6];

        field {
            name = "di0_dt";
            desc = "Di0 dt. Chinese-only data sheet: description and value encoding not translated.";
            sw = rw;
            hw = r;
            reset = 0x0;
        } di0_dt[5:0];
    } MIPI1_DI_1 @ 0x2010;

    reg {
        name = "MIPI1_DI_2";
        desc = "Data sheet 9.3.6 MIPI1_DI_2 (offset 0x2014, printed page 9-159, `hi3516av300--Hi3516AV300-Datasheet.txt` line 44102).";

        field {
            name = "di7_vc";
            desc = "Di7 vc. Chinese-only data sheet: description and value encoding not translated.";
            sw = rw;
            hw = r;
            reset = 0x0;
        } di7_vc[31:30];

        field {
            name = "di7_dt";
            desc = "Di7 dt. Chinese-only data sheet: description and value encoding not translated.";
            sw = rw;
            hw = r;
            reset = 0x0;
        } di7_dt[29:24];

        field {
            name = "di6_vc";
            desc = "Di6 vc. Chinese-only data sheet: description and value encoding not translated.";
            sw = rw;
            hw = r;
            reset = 0x0;
        } di6_vc[23:22];

        field {
            name = "di6_dt";
            desc = "Di6 dt. Chinese-only data sheet: description and value encoding not translated.";
            sw = rw;
            hw = r;
            reset = 0x0;
        } di6_dt[21:16];

        field {
            name = "di5_vc";
            desc = "Di5 vc. Chinese-only data sheet: description and value encoding not translated.";
            sw = rw;
            hw = r;
            reset = 0x0;
        } di5_vc[15:14];

        field {
            name = "di5_dt";
            desc = "Di5 dt. Chinese-only data sheet: description and value encoding not translated.";
            sw = rw;
            hw = r;
            reset = 0x0;
        } di5_dt[13:8];

        field {
            name = "di4_vc";
            desc = "Di4 vc. Chinese-only data sheet: description and value encoding not translated.";
            sw = rw;
            hw = r;
            reset = 0x0;
        } di4_vc[7:6];

        field {
            name = "di4_dt";
            desc = "Di4 dt. Chinese-only data sheet: description and value encoding not translated.";
            sw = rw;
            hw = r;
            reset = 0x0;
        } di4_dt[5:0];
    } MIPI1_DI_2 @ 0x2014;

    reg {
        name = "MIPI1_PKT_INTR_ST";
        desc = "Data sheet 9.3.6 MIPI1_PKT_INTR_ST (offset 0x2060, printed page 9-160, `hi3516av300--Hi3516AV300-Datasheet.txt` line 44175).";

        field {
            name = "err_ecc_double";
            desc = "Error ecc double. Chinese-only data sheet: description and value encoding not translated.";
            sw = r;
            hw = w;
            reset = 0x0;
        } err_ecc_double[16:16];

        field {
            name = "vc3_err_crc";
            desc = "Vc3 error crc. Chinese-only data sheet: description and value encoding not translated.";
            sw = r;
            hw = w;
            reset = 0x0;
        } vc3_err_crc[3:3];

        field {
            name = "vc2_err_crc";
            desc = "Vc2 error crc. Chinese-only data sheet: description and value encoding not translated.";
            sw = r;
            hw = w;
            reset = 0x0;
        } vc2_err_crc[2:2];

        field {
            name = "vc1_err_crc";
            desc = "Vc1 error crc. Chinese-only data sheet: description and value encoding not translated.";
            sw = r;
            hw = w;
            reset = 0x0;
        } vc1_err_crc[1:1];

        field {
            name = "vc0_err_crc";
            desc = "Vc0 error crc. Chinese-only data sheet: description and value encoding not translated.";
            sw = r;
            hw = w;
            reset = 0x0;
        } vc0_err_crc[0:0];
    } MIPI1_PKT_INTR_ST @ 0x2060;

    reg {
        name = "MIPI1_PKT_INTR_MSK";
        desc = "Data sheet 9.3.6 MIPI1_PKT_INTR_MSK (offset 0x2064, printed page 9-161, `hi3516av300--Hi3516AV300-Datasheet.txt` line 44229).";

        field {
            name = "mask_err_ecc_double";
            desc = "Mask error ecc double. Chinese-only data sheet: description and value encoding not translated.";
            sw = rw;
            hw = r;
            reset = 0x0;
        } mask_err_ecc_double[16:16];

        field {
            name = "mask_vc3_err_crc";
            desc = "Mask vc3 error crc. Chinese-only data sheet: description and value encoding not translated.";
            sw = rw;
            hw = r;
            reset = 0x0;
        } mask_vc3_err_crc[3:3];

        field {
            name = "mask_vc2_err_crc";
            desc = "Mask vc2 error crc. Chinese-only data sheet: description and value encoding not translated.";
            sw = rw;
            hw = r;
            reset = 0x0;
        } mask_vc2_err_crc[2:2];

        field {
            name = "mask_vc1_err_crc";
            desc = "Mask vc1 error crc. Chinese-only data sheet: description and value encoding not translated.";
            sw = rw;
            hw = r;
            reset = 0x0;
        } mask_vc1_err_crc[1:1];

        field {
            name = "mask_vc0_err_crc";
            desc = "Mask vc0 error crc. Chinese-only data sheet: description and value encoding not translated.";
            sw = rw;
            hw = r;
            reset = 0x0;
        } mask_vc0_err_crc[0:0];
    } MIPI1_PKT_INTR_MSK @ 0x2064;

    reg {
        name = "MIPI1_PKT_INTR2_ST";
        desc = "Data sheet 9.3.6 MIPI1_PKT_INTR2_ST (offset 0x2070, printed page 9-161, `hi3516av300--Hi3516AV300-Datasheet.txt` line 44280).";

        field {
            name = "vc3_err_ecc_corrected";
            desc = "Vc3 error ecc corrected. Chinese-only data sheet: description and value encoding not translated.";
            sw = r;
            hw = w;
            reset = 0x0;
        } vc3_err_ecc_corrected[19:19];

        field {
            name = "vc2_err_ecc_corrected";
            desc = "Vc2 error ecc corrected. Chinese-only data sheet: description and value encoding not translated.";
            sw = r;
            hw = w;
            reset = 0x0;
        } vc2_err_ecc_corrected[18:18];

        field {
            name = "vc1_err_ecc_corrected";
            desc = "Vc1 error ecc corrected. Chinese-only data sheet: description and value encoding not translated.";
            sw = r;
            hw = w;
            reset = 0x0;
        } vc1_err_ecc_corrected[17:17];

        field {
            name = "vc0_err_ecc_corrected";
            desc = "Vc0 error ecc corrected. Chinese-only data sheet: description and value encoding not translated.";
            sw = r;
            hw = w;
            reset = 0x0;
        } vc0_err_ecc_corrected[16:16];

        field {
            name = "err_id_vc3";
            desc = "Error id vc3. Chinese-only data sheet: description and value encoding not translated.";
            sw = r;
            hw = w;
            reset = 0x0;
        } err_id_vc3[3:3];

        field {
            name = "err_id_vc2";
            desc = "Error id vc2. Chinese-only data sheet: description and value encoding not translated.";
            sw = r;
            hw = w;
            reset = 0x0;
        } err_id_vc2[2:2];

        field {
            name = "err_id_vc1";
            desc = "Error id vc1. Chinese-only data sheet: description and value encoding not translated.";
            sw = r;
            hw = w;
            reset = 0x0;
        } err_id_vc1[1:1];

        field {
            name = "err_id_vc0";
            desc = "Error id vc0. Chinese-only data sheet: description and value encoding not translated.";
            sw = r;
            hw = w;
            reset = 0x0;
        } err_id_vc0[0:0];
    } MIPI1_PKT_INTR2_ST @ 0x2070;

    reg {
        name = "MIPI1_PKT_INTR2_MSK";
        desc = "Data sheet 9.3.6 MIPI1_PKT_INTR2_MSK (offset 0x2074, printed page 9-163, `hi3516av300--Hi3516AV300-Datasheet.txt` line 44368).";

        field {
            name = "mask_vc3_err_ecc_corrected";
            desc = "Mask vc3 error ecc corrected. Chinese-only data sheet: description and value encoding not translated.";
            sw = rw;
            hw = r;
            reset = 0x0;
        } mask_vc3_err_ecc_corrected[19:19];

        field {
            name = "mask_vc2_err_ecc_corrected";
            desc = "Mask vc2 error ecc corrected. Chinese-only data sheet: description and value encoding not translated.";
            sw = rw;
            hw = r;
            reset = 0x0;
        } mask_vc2_err_ecc_corrected[18:18];

        field {
            name = "mask_vc1_err_ecc_corrected";
            desc = "Mask vc1 error ecc corrected. Chinese-only data sheet: description and value encoding not translated.";
            sw = rw;
            hw = r;
            reset = 0x0;
        } mask_vc1_err_ecc_corrected[17:17];

        field {
            name = "mask_vc0_err_ecc_corrected";
            desc = "Mask vc0 error ecc corrected. Chinese-only data sheet: description and value encoding not translated.";
            sw = rw;
            hw = r;
            reset = 0x0;
        } mask_vc0_err_ecc_corrected[16:16];

        field {
            name = "mask_err_id_vc3";
            desc = "Mask error id vc3. Chinese-only data sheet: description and value encoding not translated.";
            sw = rw;
            hw = r;
            reset = 0x0;
        } mask_err_id_vc3[3:3];

        field {
            name = "mask_err_id_vc2";
            desc = "Mask error id vc2. Chinese-only data sheet: description and value encoding not translated.";
            sw = rw;
            hw = r;
            reset = 0x0;
        } mask_err_id_vc2[2:2];

        field {
            name = "mask_err_id_vc1";
            desc = "Mask error id vc1. Chinese-only data sheet: description and value encoding not translated.";
            sw = rw;
            hw = r;
            reset = 0x0;
        } mask_err_id_vc1[1:1];

        field {
            name = "mask_err_id_vc0";
            desc = "Mask error id vc0. Chinese-only data sheet: description and value encoding not translated.";
            sw = rw;
            hw = r;
            reset = 0x0;
        } mask_err_id_vc0[0:0];
    } MIPI1_PKT_INTR2_MSK @ 0x2074;

    reg {
        name = "MIPI1_FRAME_INTR_ST";
        desc = "Data sheet 9.3.6 MIPI1_FRAME_INTR_ST (offset 0x2080, printed page 9-163, `hi3516av300--Hi3516AV300-Datasheet.txt` line 44435).";

        field {
            name = "err_frame_data_vc3";
            desc = "Error frame data vc3. Chinese-only data sheet: description and value encoding not translated.";
            sw = r;
            hw = w;
            reset = 0x0;
        } err_frame_data_vc3[19:19];

        field {
            name = "err_frame_data_vc2";
            desc = "Error frame data vc2. Chinese-only data sheet: description and value encoding not translated.";
            sw = r;
            hw = w;
            reset = 0x0;
        } err_frame_data_vc2[18:18];

        field {
            name = "err_frame_data_vc1";
            desc = "Error frame data vc1. Chinese-only data sheet: description and value encoding not translated.";
            sw = r;
            hw = w;
            reset = 0x0;
        } err_frame_data_vc1[17:17];

        field {
            name = "err_frame_data_vc0";
            desc = "Error frame data vc0. Chinese-only data sheet: description and value encoding not translated.";
            sw = r;
            hw = w;
            reset = 0x0;
        } err_frame_data_vc0[16:16];

        field {
            name = "err_f_seq_vc3";
            desc = "Error f seq vc3. Chinese-only data sheet: description and value encoding not translated.";
            sw = r;
            hw = w;
            reset = 0x0;
        } err_f_seq_vc3[11:11];

        field {
            name = "err_f_seq_vc2";
            desc = "Error f seq vc2. Chinese-only data sheet: description and value encoding not translated.";
            sw = r;
            hw = w;
            reset = 0x0;
        } err_f_seq_vc2[10:10];

        field {
            name = "err_f_seq_vc1";
            desc = "Error f seq vc1. Chinese-only data sheet: description and value encoding not translated.";
            sw = r;
            hw = w;
            reset = 0x0;
        } err_f_seq_vc1[9:9];

        field {
            name = "err_f_seq_vc0";
            desc = "Error f seq vc0. Chinese-only data sheet: description and value encoding not translated.";
            sw = r;
            hw = w;
            reset = 0x0;
        } err_f_seq_vc0[8:8];

        field {
            name = "err_f_bndry_match_vc3";
            desc = "Error f bndry match vc3. Chinese-only data sheet: description and value encoding not translated.";
            sw = r;
            hw = w;
            reset = 0x0;
        } err_f_bndry_match_vc3[3:3];

        field {
            name = "err_f_bndry_match_vc2";
            desc = "Error f bndry match vc2. Chinese-only data sheet: description and value encoding not translated.";
            sw = r;
            hw = w;
            reset = 0x0;
        } err_f_bndry_match_vc2[2:2];

        field {
            name = "err_f_bndry_match_vc1";
            desc = "Error f bndry match vc1. Chinese-only data sheet: description and value encoding not translated.";
            sw = r;
            hw = w;
            reset = 0x0;
        } err_f_bndry_match_vc1[1:1];

        field {
            name = "err_f_bndry_match_vc0";
            desc = "Error f bndry match vc0. Chinese-only data sheet: description and value encoding not translated.";
            sw = r;
            hw = w;
            reset = 0x0;
        } err_f_bndry_match_vc0[0:0];
    } MIPI1_FRAME_INTR_ST @ 0x2080;

    reg {
        name = "MIPI1_FRAME_INTR_MSK";
        desc = "Data sheet 9.3.6 MIPI1_FRAME_INTR_MSK (offset 0x2084, printed page 9-165, `hi3516av300--Hi3516AV300-Datasheet.txt` line 44557).";

        field {
            name = "mask_err_frame_data_vc3";
            desc = "Mask error frame data vc3. Chinese-only data sheet: description and value encoding not translated.";
            sw = rw;
            hw = r;
            reset = 0x0;
        } mask_err_frame_data_vc3[19:19];

        field {
            name = "mask_err_frame_data_vc2";
            desc = "Mask error frame data vc2. Chinese-only data sheet: description and value encoding not translated.";
            sw = rw;
            hw = r;
            reset = 0x0;
        } mask_err_frame_data_vc2[18:18];

        field {
            name = "mask_err_frame_data_vc1";
            desc = "Mask error frame data vc1. Chinese-only data sheet: description and value encoding not translated.";
            sw = rw;
            hw = r;
            reset = 0x0;
        } mask_err_frame_data_vc1[17:17];

        field {
            name = "mask_err_frame_data_vc0";
            desc = "Mask error frame data vc0. Chinese-only data sheet: description and value encoding not translated.";
            sw = rw;
            hw = r;
            reset = 0x0;
        } mask_err_frame_data_vc0[16:16];

        field {
            name = "mask_err_f_seq_vc3";
            desc = "Mask error f seq vc3. Chinese-only data sheet: description and value encoding not translated.";
            sw = rw;
            hw = r;
            reset = 0x0;
        } mask_err_f_seq_vc3[11:11];

        field {
            name = "mask_err_f_seq_vc2";
            desc = "Mask error f seq vc2. Chinese-only data sheet: description and value encoding not translated.";
            sw = rw;
            hw = r;
            reset = 0x0;
        } mask_err_f_seq_vc2[10:10];

        field {
            name = "mask_err_f_seq_vc1";
            desc = "Mask error f seq vc1. Chinese-only data sheet: description and value encoding not translated.";
            sw = rw;
            hw = r;
            reset = 0x0;
        } mask_err_f_seq_vc1[9:9];

        field {
            name = "mask_err_f_seq_vc0";
            desc = "Mask error f seq vc0. Chinese-only data sheet: description and value encoding not translated.";
            sw = rw;
            hw = r;
            reset = 0x0;
        } mask_err_f_seq_vc0[8:8];

        field {
            name = "mask_err_f_bndry_match_vc3";
            desc = "Mask error f bndry match vc3. Chinese-only data sheet: description and value encoding not translated.";
            sw = rw;
            hw = r;
            reset = 0x0;
        } mask_err_f_bndry_match_vc3[3:3];

        field {
            name = "mask_err_f_bndry_match_vc2";
            desc = "Mask error f bndry match vc2. Chinese-only data sheet: description and value encoding not translated.";
            sw = rw;
            hw = r;
            reset = 0x0;
        } mask_err_f_bndry_match_vc2[2:2];

        field {
            name = "mask_err_f_bndry_match_vc1";
            desc = "Mask error f bndry match vc1. Chinese-only data sheet: description and value encoding not translated.";
            sw = rw;
            hw = r;
            reset = 0x0;
        } mask_err_f_bndry_match_vc1[1:1];

        field {
            name = "mask_err_f_bndry_match_vc0";
            desc = "Mask error f bndry match vc0. Chinese-only data sheet: description and value encoding not translated.";
            sw = rw;
            hw = r;
            reset = 0x0;
        } mask_err_f_bndry_match_vc0[0:0];
    } MIPI1_FRAME_INTR_MSK @ 0x2084;

    reg {
        name = "MIPI1_LINE_INTR_ST";
        desc = "Data sheet 9.3.6 MIPI1_LINE_INTR_ST (offset 0x2090, printed page 9-167, `hi3516av300--Hi3516AV300-Datasheet.txt` line 44670).";

        field {
            name = "err_l_seq_di7";
            desc = "Error l seq di7. Chinese-only data sheet: description and value encoding not translated.";
            sw = r;
            hw = w;
            reset = 0x0;
        } err_l_seq_di7[23:23];

        field {
            name = "err_l_seq_di6";
            desc = "Error l seq di6. Chinese-only data sheet: description and value encoding not translated.";
            sw = r;
            hw = w;
            reset = 0x0;
        } err_l_seq_di6[22:22];

        field {
            name = "err_l_seq_di5";
            desc = "Error l seq di5. Chinese-only data sheet: description and value encoding not translated.";
            sw = r;
            hw = w;
            reset = 0x0;
        } err_l_seq_di5[21:21];

        field {
            name = "err_l_seq_di4";
            desc = "Error l seq di4. Chinese-only data sheet: description and value encoding not translated.";
            sw = r;
            hw = w;
            reset = 0x0;
        } err_l_seq_di4[20:20];

        field {
            name = "err_l_seq_di3";
            desc = "Error l seq di3. Chinese-only data sheet: description and value encoding not translated.";
            sw = r;
            hw = w;
            reset = 0x0;
        } err_l_seq_di3[19:19];

        field {
            name = "err_l_seq_di2";
            desc = "Error l seq di2. Chinese-only data sheet: description and value encoding not translated.";
            sw = r;
            hw = w;
            reset = 0x0;
        } err_l_seq_di2[18:18];

        field {
            name = "err_l_seq_di1";
            desc = "Error l seq di1. Chinese-only data sheet: description and value encoding not translated.";
            sw = r;
            hw = w;
            reset = 0x0;
        } err_l_seq_di1[17:17];

        field {
            name = "err_l_seq_di0";
            desc = "Error l seq di0. Chinese-only data sheet: description and value encoding not translated.";
            sw = r;
            hw = w;
            reset = 0x0;
        } err_l_seq_di0[16:16];

        field {
            name = "err_l_bndry_match_di7";
            desc = "Error l bndry match di7. Chinese-only data sheet: description and value encoding not translated.";
            sw = r;
            hw = w;
            reset = 0x0;
        } err_l_bndry_match_di7[7:7];

        field {
            name = "err_l_bndry_match_di6";
            desc = "Error l bndry match di6. Chinese-only data sheet: description and value encoding not translated.";
            sw = r;
            hw = w;
            reset = 0x0;
        } err_l_bndry_match_di6[6:6];

        field {
            name = "err_l_bndry_match_di5";
            desc = "Error l bndry match di5. Chinese-only data sheet: description and value encoding not translated.";
            sw = r;
            hw = w;
            reset = 0x0;
        } err_l_bndry_match_di5[5:5];

        field {
            name = "err_l_bndry_match_di4";
            desc = "Error l bndry match di4. Chinese-only data sheet: description and value encoding not translated.";
            sw = r;
            hw = w;
            reset = 0x0;
        } err_l_bndry_match_di4[4:4];

        field {
            name = "err_l_bndry_match_di3";
            desc = "Error l bndry match di3. Chinese-only data sheet: description and value encoding not translated.";
            sw = r;
            hw = w;
            reset = 0x0;
        } err_l_bndry_match_di3[3:3];

        field {
            name = "err_l_bndry_match_di2";
            desc = "Error l bndry match di2. Chinese-only data sheet: description and value encoding not translated.";
            sw = r;
            hw = w;
            reset = 0x0;
        } err_l_bndry_match_di2[2:2];

        field {
            name = "err_l_bndry_match_di1";
            desc = "Error l bndry match di1. Chinese-only data sheet: description and value encoding not translated.";
            sw = r;
            hw = w;
            reset = 0x0;
        } err_l_bndry_match_di1[1:1];

        field {
            name = "err_l_bndry_match_di0";
            desc = "Error l bndry match di0. Chinese-only data sheet: description and value encoding not translated.";
            sw = r;
            hw = w;
            reset = 0x0;
        } err_l_bndry_match_di0[0:0];
    } MIPI1_LINE_INTR_ST @ 0x2090;

    reg {
        name = "MIPI1_LINE_INTR_MSK";
        desc = "Data sheet 9.3.6 MIPI1_LINE_INTR_MSK (offset 0x2094, printed page 9-168, `hi3516av300--Hi3516AV300-Datasheet.txt` line 44804).";

        field {
            name = "mask_err_l_seq_di7";
            desc = "Mask error l seq di7. Chinese-only data sheet: description and value encoding not translated.";
            sw = rw;
            hw = r;
            reset = 0x0;
        } mask_err_l_seq_di7[23:23];

        field {
            name = "mask_err_l_seq_di6";
            desc = "Mask error l seq di6. Chinese-only data sheet: description and value encoding not translated.";
            sw = rw;
            hw = r;
            reset = 0x0;
        } mask_err_l_seq_di6[22:22];

        field {
            name = "mask_err_l_seq_di5";
            desc = "Mask error l seq di5. Chinese-only data sheet: description and value encoding not translated.";
            sw = rw;
            hw = r;
            reset = 0x0;
        } mask_err_l_seq_di5[21:21];

        field {
            name = "mask_err_l_seq_di4";
            desc = "Mask error l seq di4. Chinese-only data sheet: description and value encoding not translated.";
            sw = rw;
            hw = r;
            reset = 0x0;
        } mask_err_l_seq_di4[20:20];

        field {
            name = "mask_err_l_seq_di3";
            desc = "Mask error l seq di3. Chinese-only data sheet: description and value encoding not translated.";
            sw = rw;
            hw = r;
            reset = 0x0;
        } mask_err_l_seq_di3[19:19];

        field {
            name = "mask_err_l_seq_di2";
            desc = "Mask error l seq di2. Chinese-only data sheet: description and value encoding not translated.";
            sw = rw;
            hw = r;
            reset = 0x0;
        } mask_err_l_seq_di2[18:18];

        field {
            name = "mask_err_l_seq_di1";
            desc = "Mask error l seq di1. Chinese-only data sheet: description and value encoding not translated.";
            sw = rw;
            hw = r;
            reset = 0x0;
        } mask_err_l_seq_di1[17:17];

        field {
            name = "mask_err_l_seq_di0";
            desc = "Mask error l seq di0. Chinese-only data sheet: description and value encoding not translated.";
            sw = rw;
            hw = r;
            reset = 0x0;
        } mask_err_l_seq_di0[16:16];

        field {
            name = "mask_err_l_bndry_match_di7";
            desc = "Mask error l bndry match di7. Chinese-only data sheet: description and value encoding not translated.";
            sw = rw;
            hw = r;
            reset = 0x0;
        } mask_err_l_bndry_match_di7[7:7];

        field {
            name = "mask_err_l_bndry_match_di6";
            desc = "Mask error l bndry match di6. Chinese-only data sheet: description and value encoding not translated.";
            sw = rw;
            hw = r;
            reset = 0x0;
        } mask_err_l_bndry_match_di6[6:6];

        field {
            name = "mask_err_l_bndry_match_di5";
            desc = "Mask error l bndry match di5. Chinese-only data sheet: description and value encoding not translated.";
            sw = rw;
            hw = r;
            reset = 0x0;
        } mask_err_l_bndry_match_di5[5:5];

        field {
            name = "mask_err_l_bndry_match_di4";
            desc = "Mask error l bndry match di4. Chinese-only data sheet: description and value encoding not translated.";
            sw = rw;
            hw = r;
            reset = 0x0;
        } mask_err_l_bndry_match_di4[4:4];

        field {
            name = "mask_err_l_bndry_match_di3";
            desc = "Mask error l bndry match di3. Chinese-only data sheet: description and value encoding not translated.";
            sw = rw;
            hw = r;
            reset = 0x0;
        } mask_err_l_bndry_match_di3[3:3];

        field {
            name = "mask_err_l_bndry_match_di2";
            desc = "Mask error l bndry match di2. Chinese-only data sheet: description and value encoding not translated.";
            sw = rw;
            hw = r;
            reset = 0x0;
        } mask_err_l_bndry_match_di2[2:2];

        field {
            name = "mask_err_l_bndry_match_di1";
            desc = "Mask error l bndry match di1. Chinese-only data sheet: description and value encoding not translated.";
            sw = rw;
            hw = r;
            reset = 0x0;
        } mask_err_l_bndry_match_di1[1:1];

        field {
            name = "mask_err_l_bndry_match_di0";
            desc = "Mask error l bndry match di0. Chinese-only data sheet: description and value encoding not translated.";
            sw = rw;
            hw = r;
            reset = 0x0;
        } mask_err_l_bndry_match_di0[0:0];
    } MIPI1_LINE_INTR_MSK @ 0x2094;

    reg {
        name = "MIPI1_USERDEF_DT";
        desc = "Data sheet 9.3.6 MIPI1_USERDEF_DT (offset 0x2100, printed page 9-170, `hi3516av300--Hi3516AV300-Datasheet.txt` line 44943).";

        field {
            name = "user_def3_dt";
            desc = "User def3 dt. Chinese-only data sheet: description and value encoding not translated.";
            sw = rw;
            hw = r;
            reset = 0x0;
        } user_def3_dt[14:12];

        field {
            name = "user_def2_dt";
            desc = "User def2 dt. Chinese-only data sheet: description and value encoding not translated.";
            sw = rw;
            hw = r;
            reset = 0x0;
        } user_def2_dt[10:8];

        field {
            name = "user_def1_dt";
            desc = "User def1 dt. Chinese-only data sheet: description and value encoding not translated.";
            sw = rw;
            hw = r;
            reset = 0x0;
        } user_def1_dt[6:4];

        field {
            name = "user_def0_dt";
            desc = "User def0 dt. Chinese-only data sheet: description and value encoding not translated.";
            sw = rw;
            hw = r;
            reset = 0x0;
        } user_def0_dt[2:0];
    } MIPI1_USERDEF_DT @ 0x2100;

    reg {
        name = "MIPI1_USER_DEF";
        desc = "Data sheet 9.3.6 MIPI1_USER_DEF (offset 0x2104, printed page 9-171, `hi3516av300--Hi3516AV300-Datasheet.txt` line 45027).";

        field {
            name = "user_def3";
            desc = "User def3. Chinese-only data sheet: description and value encoding not translated.";
            sw = rw;
            hw = r;
            reset = 0x10;
        } user_def3[29:24];

        field {
            name = "user_def2";
            desc = "User def2. Chinese-only data sheet: description and value encoding not translated.";
            sw = rw;
            hw = r;
            reset = 0x36;
        } user_def2[21:16];

        field {
            name = "user_def1";
            desc = "User def1. Chinese-only data sheet: description and value encoding not translated.";
            sw = rw;
            hw = r;
            reset = 0x35;
        } user_def1[13:8];

        field {
            name = "user_def0";
            desc = "User def0. Chinese-only data sheet: description and value encoding not translated.";
            sw = rw;
            hw = r;
            reset = 0x34;
        } user_def0[5:0];
    } MIPI1_USER_DEF @ 0x2104;

    reg {
        name = "MIPI1_CTRL_MODE_HS";
        desc = "Data sheet 9.3.6 MIPI1_CTRL_MODE_HS (offset 0x2108, printed page 9-172, `hi3516av300--Hi3516AV300-Datasheet.txt` line 45073).";

        field {
            name = "user_def_en";
            desc = "User def enable. Chinese-only data sheet: description and value encoding not translated.";
            sw = rw;
            hw = r;
            reset = 0x0;
        } user_def_en[8:8];

        field {
            name = "vc_mode";
            desc = "Vc mode. Chinese-only data sheet: description and value encoding not translated.";
            sw = rw;
            hw = r;
            reset = 0x0;
        } vc_mode[4:4];

        field {
            name = "hdr_mode";
            desc = "Hdr mode. Chinese-only data sheet: description and value encoding not translated.";
            sw = rw;
            hw = r;
            reset = 0x0;
        } hdr_mode[0:0];
    } MIPI1_CTRL_MODE_HS @ 0x2108;

    reg {
        name = "MIPI1_DOL_ID_CODE0";
        desc = "Data sheet 9.3.6 MIPI1_DOL_ID_CODE0 (offset 0x2200, printed page 9-173, `hi3516av300--Hi3516AV300-Datasheet.txt` line 45117).";

        field {
            name = "id_code_reg1";
            desc = "Id code reg1. Chinese-only data sheet: description and value encoding not translated.";
            sw = rw;
            hw = r;
            reset = 0x242;
        } id_code_reg1[31:16];

        field {
            name = "id_code_reg0";
            desc = "Id code reg0. Chinese-only data sheet: description and value encoding not translated.";
            sw = rw;
            hw = r;
            reset = 0x241;
        } id_code_reg0[15:0];
    } MIPI1_DOL_ID_CODE0 @ 0x2200;

    reg {
        name = "MIPI1_DOL_ID_CODE1";
        desc = "Data sheet 9.3.6 MIPI1_DOL_ID_CODE1 (offset 0x2204, printed page 9-173, `hi3516av300--Hi3516AV300-Datasheet.txt` line 45132).";

        field {
            name = "id_code_reg3";
            desc = "Id code reg3. Chinese-only data sheet: description and value encoding not translated.";
            sw = rw;
            hw = r;
            reset = 0x251;
        } id_code_reg3[31:16];

        field {
            name = "id_code_reg2";
            desc = "Id code reg2. Chinese-only data sheet: description and value encoding not translated.";
            sw = rw;
            hw = r;
            reset = 0x244;
        } id_code_reg2[15:0];
    } MIPI1_DOL_ID_CODE1 @ 0x2204;

    reg {
        name = "MIPI1_DOL_ID_CODE2";
        desc = "Data sheet 9.3.6 MIPI1_DOL_ID_CODE2 (offset 0x2208, printed page 9-173, `hi3516av300--Hi3516AV300-Datasheet.txt` line 45155).";

        field {
            name = "id_code_reg5";
            desc = "Id code reg5. Chinese-only data sheet: description and value encoding not translated.";
            sw = rw;
            hw = r;
            reset = 0x254;
        } id_code_reg5[31:16];

        field {
            name = "id_code_reg4";
            desc = "Id code reg4. Chinese-only data sheet: description and value encoding not translated.";
            sw = rw;
            hw = r;
            reset = 0x252;
        } id_code_reg4[15:0];
    } MIPI1_DOL_ID_CODE2 @ 0x2208;

    reg {
        name = "MIPI1_CROP_START_CHN0";
        desc = "Data sheet 9.3.6 MIPI1_CROP_START_CHN0 (offset 0x2210, printed page 9-173, `hi3516av300--Hi3516AV300-Datasheet.txt` line 45175).";

        field {
            name = "mipi_start_y_chn0";
            desc = "Mipi start y chn0. Chinese-only data sheet: description and value encoding not translated.";
            sw = rw;
            hw = r;
            reset = 0x0;
        } mipi_start_y_chn0[31:16];

        field {
            name = "mipi_start_x_chn0";
            desc = "Mipi start x chn0. Chinese-only data sheet: description and value encoding not translated.";
            sw = rw;
            hw = r;
            reset = 0x0;
        } mipi_start_x_chn0[15:0];
    } MIPI1_CROP_START_CHN0 @ 0x2210;

    reg {
        name = "MIPI1_CROP_START_CHN1";
        desc = "Data sheet 9.3.6 MIPI1_CROP_START_CHN1 (offset 0x2214, printed page 9-174, `hi3516av300--Hi3516AV300-Datasheet.txt` line 45193).";

        field {
            name = "mipi_start_y_chn1";
            desc = "Mipi start y chn1. Chinese-only data sheet: description and value encoding not translated.";
            sw = rw;
            hw = r;
            reset = 0x0;
        } mipi_start_y_chn1[31:16];

        field {
            name = "mipi_start_x_chn1";
            desc = "Mipi start x chn1. Chinese-only data sheet: description and value encoding not translated.";
            sw = rw;
            hw = r;
            reset = 0x0;
        } mipi_start_x_chn1[15:0];
    } MIPI1_CROP_START_CHN1 @ 0x2214;

    reg {
        name = "MIPI1_CROP_START_CHN2";
        desc = "Data sheet 9.3.6 MIPI1_CROP_START_CHN2 (offset 0x2218, printed page 9-174, `hi3516av300--Hi3516AV300-Datasheet.txt` line 45208).";

        field {
            name = "mipi_start_y_chn2";
            desc = "Mipi start y chn2. Chinese-only data sheet: description and value encoding not translated.";
            sw = rw;
            hw = r;
            reset = 0x0;
        } mipi_start_y_chn2[31:16];

        field {
            name = "mipi_start_x_chn2";
            desc = "Mipi start x chn2. Chinese-only data sheet: description and value encoding not translated.";
            sw = rw;
            hw = r;
            reset = 0x0;
        } mipi_start_x_chn2[15:0];
    } MIPI1_CROP_START_CHN2 @ 0x2218;

    reg {
        name = "MIPI1_CROP_START_CHN3";
        desc = "Data sheet 9.3.6 MIPI1_CROP_START_CHN3 (offset 0x221C, printed page 9-174, `hi3516av300--Hi3516AV300-Datasheet.txt` line 45229).";

        field {
            name = "mipi_start_y_chn3";
            desc = "Mipi start y chn3. Chinese-only data sheet: description and value encoding not translated.";
            sw = rw;
            hw = r;
            reset = 0x0;
        } mipi_start_y_chn3[31:16];

        field {
            name = "mipi_start_x_chn3";
            desc = "Mipi start x chn3. Chinese-only data sheet: description and value encoding not translated.";
            sw = rw;
            hw = r;
            reset = 0x0;
        } mipi_start_x_chn3[15:0];
    } MIPI1_CROP_START_CHN3 @ 0x221C;

    reg {
        name = "MIPI1_IMGSIZE";
        desc = "Data sheet 9.3.6 MIPI1_IMGSIZE (offset 0x2224, printed page 9-174, `hi3516av300--Hi3516AV300-Datasheet.txt` line 45249).";

        field {
            name = "mipi_imgheight";
            desc = "Mipi imgheight. Chinese-only data sheet: description and value encoding not translated.";
            sw = rw;
            hw = r;
            reset = 0x0;
        } mipi_imgheight[31:16];

        field {
            name = "mipi_imgwidth";
            desc = "Mipi imgwidth. Chinese-only data sheet: description and value encoding not translated.";
            sw = rw;
            hw = r;
            reset = 0x0;
        } mipi_imgwidth[15:0];
    } MIPI1_IMGSIZE @ 0x2224;

    reg {
        name = "MIPI1_CTRL_MODE_PIXEL";
        desc = "Data sheet 9.3.6 MIPI1_CTRL_MODE_PIXEL (offset 0x2230, printed page 9-175, `hi3516av300--Hi3516AV300-Datasheet.txt` line 45267).";

        field {
            name = "mipi_yuv420_even_detect";
            desc = "Mipi yuv420 even detect. Chinese-only data sheet: description and value encoding not translated.";
            sw = rw;
            hw = r;
            reset = 0x0;
        } mipi_yuv420_even_detect[22:22];

        field {
            name = "mipi_yuv_420_legacy_en";
            desc = "Mipi yuv 420 legacy enable. Chinese-only data sheet: description and value encoding not translated.";
            sw = rw;
            hw = r;
            reset = 0x0;
        } mipi_yuv_420_legacy_en[20:20];

        field {
            name = "mipi_yuv_420_nolegacy_en";
            desc = "Mipi yuv 420 nolegacy enable. Chinese-only data sheet: description and value encoding not translated.";
            sw = rw;
            hw = r;
            reset = 0x0;
        } mipi_yuv_420_nolegacy_en[19:19];

        field {
            name = "mipi_yuv_422_en";
            desc = "Mipi yuv 422 enable. Chinese-only data sheet: description and value encoding not translated.";
            sw = rw;
            hw = r;
            reset = 0x0;
        } mipi_yuv_422_en[18:18];

        field {
            name = "stagger_frm_num";
            desc = "Stagger frm number. Chinese-only data sheet: description and value encoding not translated.";
            sw = rw;
            hw = r;
            reset = 0x0;
        } stagger_frm_num[14:13];

        field {
            name = "stagger_hdr_mode";
            desc = "Stagger hdr mode. Chinese-only data sheet: description and value encoding not translated.";
            sw = rw;
            hw = r;
            reset = 0x0;
        } stagger_hdr_mode[12:12];

        field {
            name = "sync_clear_en";
            desc = "Sync clear enable. Chinese-only data sheet: description and value encoding not translated.";
            sw = rw;
            hw = r;
            reset = 0x0;
        } sync_clear_en[11:11];

        field {
            name = "mipi_dol_mode";
            desc = "Mipi dol mode. Chinese-only data sheet: description and value encoding not translated.";
            sw = rw;
            hw = r;
            reset = 0x0;
        } mipi_dol_mode[4:4];

        field {
            name = "crop_en";
            desc = "Crop enable. Chinese-only data sheet: description and value encoding not translated.";
            sw = rw;
            hw = r;
            reset = 0x0;
        } crop_en[0:0];
    } MIPI1_CTRL_MODE_PIXEL @ 0x2230;

    reg {
        name = "MIPI1_DUMMY_PIX_REG";
        desc = "Data sheet 9.3.6 MIPI1_DUMMY_PIX_REG (offset 0x2240, printed page 9-176, `hi3516av300--Hi3516AV300-Datasheet.txt` line 45355).";

        field {
            name = "dummy_pix_reg";
            desc = "Dummy pix reg. Chinese-only data sheet: description and value encoding not translated.";
            sw = rw;
            hw = r;
            reset = 0x0;
        } dummy_pix_reg[15:0];
    } MIPI1_DUMMY_PIX_REG @ 0x2240;

    reg {
        name = "MIPI1_YUVEVEN_THOLD";
        desc = "Data sheet 9.3.6 MIPI1_YUVEVEN_THOLD (offset 0x2244, printed page 9-176, `hi3516av300--Hi3516AV300-Datasheet.txt` line 45378).";

        field {
            name = "mipi_yuv_even_thold";
            desc = "Mipi yuv even thold. Chinese-only data sheet: description and value encoding not translated.";
            sw = rw;
            hw = r;
            reset = 0x9D0;
        } mipi_yuv_even_thold[15:0];
    } MIPI1_YUVEVEN_THOLD @ 0x2244;

    reg {
        name = "MIPI1_IMGSIZE0_STATIS";
        desc = "Data sheet 9.3.6 MIPI1_IMGSIZE0_STATIS (offset 0x2250, printed page 9-176, `hi3516av300--Hi3516AV300-Datasheet.txt` line 45399).";

        field {
            name = "imgheight_statis_vc0";
            desc = "Imgheight statis vc0. Chinese-only data sheet: description and value encoding not translated.";
            sw = r;
            hw = w;
            reset = 0x0;
        } imgheight_statis_vc0[31:16];

        field {
            name = "imgwidth_statis_vc0";
            desc = "Imgwidth statis vc0. Chinese-only data sheet: description and value encoding not translated.";
            sw = r;
            hw = w;
            reset = 0x0;
        } imgwidth_statis_vc0[15:0];
    } MIPI1_IMGSIZE0_STATIS @ 0x2250;

    reg {
        name = "MIPI1_IMGSIZE1_STATIS";
        desc = "Data sheet 9.3.6 MIPI1_IMGSIZE1_STATIS (offset 0x2254, printed page 9-177, `hi3516av300--Hi3516AV300-Datasheet.txt` line 45423).";

        field {
            name = "imgheight_statis_vc1";
            desc = "Imgheight statis vc1. Chinese-only data sheet: description and value encoding not translated.";
            sw = r;
            hw = w;
            reset = 0x0;
        } imgheight_statis_vc1[31:16];

        field {
            name = "imgwidth_statis_vc1";
            desc = "Imgwidth statis vc1. Chinese-only data sheet: description and value encoding not translated.";
            sw = r;
            hw = w;
            reset = 0x0;
        } imgwidth_statis_vc1[15:0];
    } MIPI1_IMGSIZE1_STATIS @ 0x2254;

    reg {
        name = "MIPI1_IMGSIZE2_STATIS";
        desc = "Data sheet 9.3.6 MIPI1_IMGSIZE2_STATIS (offset 0x2258, printed page 9-177, `hi3516av300--Hi3516AV300-Datasheet.txt` line 45443).";

        field {
            name = "imgheight_statis_vc2";
            desc = "Imgheight statis vc2. Chinese-only data sheet: description and value encoding not translated.";
            sw = r;
            hw = w;
            reset = 0x0;
        } imgheight_statis_vc2[31:16];

        field {
            name = "imgwidth_statis_vc2";
            desc = "Imgwidth statis vc2. Chinese-only data sheet: description and value encoding not translated.";
            sw = r;
            hw = w;
            reset = 0x0;
        } imgwidth_statis_vc2[15:0];
    } MIPI1_IMGSIZE2_STATIS @ 0x2258;

    reg {
        name = "MIPI1_IMGSIZE3_STATIS";
        desc = "Data sheet 9.3.6 MIPI1_IMGSIZE3_STATIS (offset 0x225C, printed page 9-177, `hi3516av300--Hi3516AV300-Datasheet.txt` line 45471).";

        field {
            name = "imgheight_statis_vc3";
            desc = "Imgheight statis vc3. Chinese-only data sheet: description and value encoding not translated.";
            sw = r;
            hw = w;
            reset = 0x0;
        } imgheight_statis_vc3[31:16];

        field {
            name = "imgwidth_statis_vc3";
            desc = "Imgwidth statis vc3. Chinese-only data sheet: description and value encoding not translated.";
            sw = r;
            hw = w;
            reset = 0x0;
        } imgwidth_statis_vc3[15:0];
    } MIPI1_IMGSIZE3_STATIS @ 0x225C;

    reg {
        name = "MIPI1_CTRL_INT_RAW";
        desc = "Data sheet 9.3.6 MIPI1_CTRL_INT_RAW (offset 0x22F0, printed page 9-178, `hi3516av300--Hi3516AV300-Datasheet.txt` line 45497).";

        field {
            name = "int_dfifo_rderr_raw";
            desc = "Interrupt dfifo rderr raw. Chinese-only data sheet: description and value encoding not translated.";
            sw = rw;
            hw = w;
            onwrite = woclr;
            reset = 0x0;
        } int_dfifo_rderr_raw[17:17];

        field {
            name = "int_cfifo_rderr_raw";
            desc = "Interrupt cfifo rderr raw. Chinese-only data sheet: description and value encoding not translated.";
            sw = rw;
            hw = w;
            onwrite = woclr;
            reset = 0x0;
        } int_cfifo_rderr_raw[16:16];

        field {
            name = "int_vsync_raw";
            desc = "Interrupt vertical sync raw. Chinese-only data sheet: description and value encoding not translated.";
            sw = rw;
            hw = w;
            onwrite = woclr;
            reset = 0x0;
        } int_vsync_raw[4:4];

        field {
            name = "int_dfifo_wrerr_raw";
            desc = "Interrupt dfifo wrerr raw. Chinese-only data sheet: description and value encoding not translated.";
            sw = rw;
            hw = w;
            onwrite = woclr;
            reset = 0x0;
        } int_dfifo_wrerr_raw[1:1];

        field {
            name = "int_cfifo_wrerr_raw";
            desc = "Interrupt cfifo wrerr raw. Chinese-only data sheet: description and value encoding not translated.";
            sw = rw;
            hw = w;
            onwrite = woclr;
            reset = 0x0;
        } int_cfifo_wrerr_raw[0:0];
    } MIPI1_CTRL_INT_RAW @ 0x22F0;

    reg {
        name = "MIPI1_CTRL_INT";
        desc = "Data sheet 9.3.6 MIPI1_CTRL_INT (offset 0x22F4, printed page 9-178, `hi3516av300--Hi3516AV300-Datasheet.txt` line 45546).";

        field {
            name = "int_dfifo_rderr_st";
            desc = "Interrupt dfifo rderr st. Chinese-only data sheet: description and value encoding not translated.";
            sw = r;
            hw = w;
            reset = 0x0;
        } int_dfifo_rderr_st[17:17];

        field {
            name = "int_cfifo_rderr_st";
            desc = "Interrupt cfifo rderr st. Chinese-only data sheet: description and value encoding not translated.";
            sw = r;
            hw = w;
            reset = 0x0;
        } int_cfifo_rderr_st[16:16];

        field {
            name = "int_vsync_st";
            desc = "Interrupt vertical sync st. Chinese-only data sheet: description and value encoding not translated.";
            sw = r;
            hw = w;
            reset = 0x0;
        } int_vsync_st[4:4];

        field {
            name = "int_dfifo_wrerr_st";
            desc = "Interrupt dfifo wrerr st. Chinese-only data sheet: description and value encoding not translated.";
            sw = r;
            hw = w;
            reset = 0x0;
        } int_dfifo_wrerr_st[1:1];

        field {
            name = "int_cfifo_wrerr_st";
            desc = "Interrupt cfifo wrerr st. Chinese-only data sheet: description and value encoding not translated.";
            sw = r;
            hw = w;
            reset = 0x0;
        } int_cfifo_wrerr_st[0:0];
    } MIPI1_CTRL_INT @ 0x22F4;

    reg {
        name = "MIPI1_CTRL_INT_MSK";
        desc = "Data sheet 9.3.6 MIPI1_CTRL_INT_MSK (offset 0x22F8, printed page 9-179, `hi3516av300--Hi3516AV300-Datasheet.txt` line 45596).";

        field {
            name = "int_dfifo_rderr_msk";
            desc = "Interrupt dfifo rderr mask. Chinese-only data sheet: description and value encoding not translated.";
            sw = rw;
            hw = r;
            reset = 0x0;
        } int_dfifo_rderr_msk[17:17];

        field {
            name = "int_cfifo_rderr_msk";
            desc = "Interrupt cfifo rderr mask. Chinese-only data sheet: description and value encoding not translated.";
            sw = rw;
            hw = r;
            reset = 0x0;
        } int_cfifo_rderr_msk[16:16];

        field {
            name = "int_vsync_msk";
            desc = "Interrupt vertical sync mask. Chinese-only data sheet: description and value encoding not translated.";
            sw = rw;
            hw = r;
            reset = 0x0;
        } int_vsync_msk[4:4];

        field {
            name = "int_dfifo_wrerr_msk";
            desc = "Interrupt dfifo wrerr mask. Chinese-only data sheet: description and value encoding not translated.";
            sw = rw;
            hw = r;
            reset = 0x0;
        } int_dfifo_wrerr_msk[1:1];

        field {
            name = "int_cfifo_wrerr_msk";
            desc = "Interrupt cfifo wrerr mask. Chinese-only data sheet: description and value encoding not translated.";
            sw = rw;
            hw = r;
            reset = 0x0;
        } int_cfifo_wrerr_msk[0:0];
    } MIPI1_CTRL_INT_MSK @ 0x22F8;

    reg {
        name = "LVDS1_WDR";
        desc = "Data sheet 9.3.6 LVDS1_WDR (offset 0x2300, printed page 9-180, `hi3516av300--Hi3516AV300-Datasheet.txt` line 45652).";

        field {
            name = "lvds_wdr_id_shift";
            desc = "Lvds WDR id shift. Chinese-only data sheet: description and value encoding not translated.";
            sw = rw;
            hw = r;
            reset = 0x0;
        } lvds_wdr_id_shift[15:12];

        field {
            name = "lvds_wdr_mode";
            desc = "Lvds WDR mode. Chinese-only data sheet: description and value encoding not translated.";
            sw = rw;
            hw = r;
            reset = 0x0;
        } lvds_wdr_mode[11:8];

        field {
            name = "lvds_wdr_num";
            desc = "Lvds WDR number. Chinese-only data sheet: description and value encoding not translated.";
            sw = rw;
            hw = r;
            reset = 0x0;
        } lvds_wdr_num[5:4];

        field {
            name = "lvds_wdr_en";
            desc = "Lvds WDR enable. Chinese-only data sheet: description and value encoding not translated.";
            sw = rw;
            hw = r;
            reset = 0x0;
        } lvds_wdr_en[0:0];
    } LVDS1_WDR @ 0x2300;

    reg {
        name = "LVDS1_DOLSCD_HBLK";
        desc = "Data sheet 9.3.6 LVDS1_DOLSCD_HBLK (offset 0x2304, printed page 9-181, `hi3516av300--Hi3516AV300-Datasheet.txt` line 45734).";

        field {
            name = "dol_hblank2";
            desc = "Dol hblank2. Chinese-only data sheet: description and value encoding not translated.";
            sw = rw;
            hw = r;
            reset = 0x0;
        } dol_hblank2[31:16];

        field {
            name = "dol_hblank1";
            desc = "Dol hblank1. Chinese-only data sheet: description and value encoding not translated.";
            sw = rw;
            hw = r;
            reset = 0x0;
        } dol_hblank1[15:0];
    } LVDS1_DOLSCD_HBLK @ 0x2304;

    reg {
        name = "LVDS1_CTRL";
        desc = "Data sheet 9.3.6 LVDS1_CTRL (offset 0x2308, printed page 9-181, `hi3516av300--Hi3516AV300-Datasheet.txt` line 45757).";

        field {
            name = "lvds_crop_en";
            desc = "Lvds crop enable. Chinese-only data sheet: description and value encoding not translated.";
            sw = rw;
            hw = r;
            reset = 0x0;
        } lvds_crop_en[12:12];

        field {
            name = "lvds_code_big_endian";
            desc = "Lvds code big endian. Chinese-only data sheet: description and value encoding not translated.";
            sw = rw;
            hw = r;
            reset = 0x1;
        } lvds_code_big_endian[9:9];

        field {
            name = "lvds_pix_big_endian";
            desc = "Lvds pix big endian. Chinese-only data sheet: description and value encoding not translated.";
            sw = rw;
            hw = r;
            reset = 0x1;
        } lvds_pix_big_endian[8:8];

        field {
            name = "lvds_raw_type";
            desc = "Lvds raw type. Chinese-only data sheet: description and value encoding not translated.";
            sw = rw;
            hw = r;
            reset = 0x3;
        } lvds_raw_type[6:4];

        field {
            name = "lvds_sync_mode";
            desc = "Lvds sync mode. Chinese-only data sheet: description and value encoding not translated.";
            sw = rw;
            hw = r;
            reset = 0x0;
        } lvds_sync_mode[0:0];
    } LVDS1_CTRL @ 0x2308;

    reg {
        name = "LVDS1_IMGSIZE";
        desc = "Data sheet 9.3.6 LVDS1_IMGSIZE (offset 0x230C, printed page 9-182, `hi3516av300--Hi3516AV300-Datasheet.txt` line 45847).";

        field {
            name = "lvds_imgheight";
            desc = "Lvds imgheight. Chinese-only data sheet: description and value encoding not translated.";
            sw = rw;
            hw = r;
            reset = 0x0;
        } lvds_imgheight[31:16];

        field {
            name = "lvds_imgwidth_lane";
            desc = "Lvds imgwidth lane. Chinese-only data sheet: description and value encoding not translated.";
            sw = rw;
            hw = r;
            reset = 0x0;
        } lvds_imgwidth_lane[15:0];
    } LVDS1_IMGSIZE @ 0x230C;

    reg {
        name = "LVDS1_CROP_START0";
        desc = "Data sheet 9.3.6 LVDS1_CROP_START0 (offset 0x2310, printed page 9-183, `hi3516av300--Hi3516AV300-Datasheet.txt` line 45868).";

        field {
            name = "lvds_start_y0";
            desc = "Lvds start y0. Chinese-only data sheet: description and value encoding not translated.";
            sw = rw;
            hw = r;
            reset = 0x0;
        } lvds_start_y0[31:16];

        field {
            name = "lvds_start_x0_lane";
            desc = "Lvds start x0 lane. Chinese-only data sheet: description and value encoding not translated.";
            sw = rw;
            hw = r;
            reset = 0x0;
        } lvds_start_x0_lane[15:0];
    } LVDS1_CROP_START0 @ 0x2310;

    reg {
        name = "LVDS1_CROP_START1";
        desc = "Data sheet 9.3.6 LVDS1_CROP_START1 (offset 0x2314, printed page 9-183, `hi3516av300--Hi3516AV300-Datasheet.txt` line 45887).";

        field {
            name = "lvds_start_y1";
            desc = "Lvds start y1. Chinese-only data sheet: description and value encoding not translated.";
            sw = rw;
            hw = r;
            reset = 0x0;
        } lvds_start_y1[31:16];

        field {
            name = "lvds_start_x1_lane";
            desc = "Lvds start x1 lane. Chinese-only data sheet: description and value encoding not translated.";
            sw = rw;
            hw = r;
            reset = 0x0;
        } lvds_start_x1_lane[15:0];
    } LVDS1_CROP_START1 @ 0x2314;

    reg {
        name = "LVDS1_CROP_START2";
        desc = "Data sheet 9.3.6 LVDS1_CROP_START2 (offset 0x2318, printed page 9-183, `hi3516av300--Hi3516AV300-Datasheet.txt` line 45913).";

        field {
            name = "lvds_start_y2";
            desc = "Lvds start y2. Chinese-only data sheet: description and value encoding not translated.";
            sw = rw;
            hw = r;
            reset = 0x0;
        } lvds_start_y2[31:16];

        field {
            name = "lvds_start_x2_lane";
            desc = "Lvds start x2 lane. Chinese-only data sheet: description and value encoding not translated.";
            sw = rw;
            hw = r;
            reset = 0x0;
        } lvds_start_x2_lane[15:0];
    } LVDS1_CROP_START2 @ 0x2318;

    reg {
        name = "LVDS1_CROP_START3";
        desc = "Data sheet 9.3.6 LVDS1_CROP_START3 (offset 0x231C, printed page 9-183, `hi3516av300--Hi3516AV300-Datasheet.txt` line 45932).";

        field {
            name = "lvds_start_y3";
            desc = "Lvds start y3. Chinese-only data sheet: description and value encoding not translated.";
            sw = rw;
            hw = r;
            reset = 0x0;
        } lvds_start_y3[31:16];

        field {
            name = "lvds_start_x3_lane";
            desc = "Lvds start x3 lane. Chinese-only data sheet: description and value encoding not translated.";
            sw = rw;
            hw = r;
            reset = 0x0;
        } lvds_start_x3_lane[15:0];
    } LVDS1_CROP_START3 @ 0x231C;

    reg {
        name = "LVDS1_LANE0_SOF_01";
        desc = "Data sheet 9.3.6 LVDS1_LANE0_SOF_01 (offset 0x2320, printed page 9-184, `hi3516av300--Hi3516AV300-Datasheet.txt` line 45957).";

        field {
            name = "lane0_sof_1";
            desc = "Lane0 sof 1. Chinese-only data sheet: description and value encoding not translated.";
            sw = rw;
            hw = r;
            reset = 0x0;
        } lane0_sof_1[31:16];

        field {
            name = "lane0_sof_0";
            desc = "Lane0 sof 0. Chinese-only data sheet: description and value encoding not translated.";
            sw = rw;
            hw = r;
            reset = 0x0;
        } lane0_sof_0[15:0];
    } LVDS1_LANE0_SOF_01 @ 0x2320;

    reg {
        name = "LVDS1_LANE0_SOF_23";
        desc = "Data sheet 9.3.6 LVDS1_LANE0_SOF_23 (offset 0x2324, printed page 9-184, `hi3516av300--Hi3516AV300-Datasheet.txt` line 45991).";

        field {
            name = "lane0_sof_3";
            desc = "Lane0 sof 3. Chinese-only data sheet: description and value encoding not translated.";
            sw = rw;
            hw = r;
            reset = 0x0;
        } lane0_sof_3[31:16];

        field {
            name = "lane0_sof_2";
            desc = "Lane0 sof 2. Chinese-only data sheet: description and value encoding not translated.";
            sw = rw;
            hw = r;
            reset = 0x0;
        } lane0_sof_2[15:0];
    } LVDS1_LANE0_SOF_23 @ 0x2324;

    reg {
        name = "LVDS1_LANE0_EOF_01";
        desc = "Data sheet 9.3.6 LVDS1_LANE0_EOF_01 (offset 0x2328, printed page 9-185, `hi3516av300--Hi3516AV300-Datasheet.txt` line 46021).";

        field {
            name = "lane0_eof_1";
            desc = "Lane0 eof 1. Chinese-only data sheet: description and value encoding not translated.";
            sw = rw;
            hw = r;
            reset = 0x0;
        } lane0_eof_1[31:16];

        field {
            name = "lane0_eof_0";
            desc = "Lane0 eof 0. Chinese-only data sheet: description and value encoding not translated.";
            sw = rw;
            hw = r;
            reset = 0x0;
        } lane0_eof_0[15:0];
    } LVDS1_LANE0_EOF_01 @ 0x2328;

    reg {
        name = "LVDS1_LANE0_EOF_23";
        desc = "Data sheet 9.3.6 LVDS1_LANE0_EOF_23 (offset 0x232C, printed page 9-185, `hi3516av300--Hi3516AV300-Datasheet.txt` line 46049).";

        field {
            name = "lane0_eof_3";
            desc = "Lane0 eof 3. Chinese-only data sheet: description and value encoding not translated.";
            sw = rw;
            hw = r;
            reset = 0x0;
        } lane0_eof_3[31:16];

        field {
            name = "lane0_eof_2";
            desc = "Lane0 eof 2. Chinese-only data sheet: description and value encoding not translated.";
            sw = rw;
            hw = r;
            reset = 0x0;
        } lane0_eof_2[15:0];
    } LVDS1_LANE0_EOF_23 @ 0x232C;

    reg {
        name = "LVDS1_LANE0_SOL_01";
        desc = "Data sheet 9.3.6 LVDS1_LANE0_SOL_01 (offset 0x2330, printed page 9-185, `hi3516av300--Hi3516AV300-Datasheet.txt` line 46077).";

        field {
            name = "lane0_sol_1";
            desc = "Lane0 sol 1. Chinese-only data sheet: description and value encoding not translated.";
            sw = rw;
            hw = r;
            reset = 0x0;
        } lane0_sol_1[31:16];

        field {
            name = "lane0_sol_0";
            desc = "Lane0 sol 0. Chinese-only data sheet: description and value encoding not translated.";
            sw = rw;
            hw = r;
            reset = 0x0;
        } lane0_sol_0[15:0];
    } LVDS1_LANE0_SOL_01 @ 0x2330;

    reg {
        name = "LVDS1_LANE0_SOL_23";
        desc = "Data sheet 9.3.6 LVDS1_LANE0_SOL_23 (offset 0x2334, printed page 9-186, `hi3516av300--Hi3516AV300-Datasheet.txt` line 46111).";

        field {
            name = "lane0_sol_3";
            desc = "Lane0 sol 3. Chinese-only data sheet: description and value encoding not translated.";
            sw = rw;
            hw = r;
            reset = 0x0;
        } lane0_sol_3[31:16];

        field {
            name = "lane0_sol_2";
            desc = "Lane0 sol 2. Chinese-only data sheet: description and value encoding not translated.";
            sw = rw;
            hw = r;
            reset = 0x0;
        } lane0_sol_2[15:0];
    } LVDS1_LANE0_SOL_23 @ 0x2334;

    reg {
        name = "LVDS1_LANE0_EOL_01";
        desc = "Data sheet 9.3.6 LVDS1_LANE0_EOL_01 (offset 0x2338, printed page 9-186, `hi3516av300--Hi3516AV300-Datasheet.txt` line 46145).";

        field {
            name = "lane0_eol_1";
            desc = "Lane0 eol 1. Chinese-only data sheet: description and value encoding not translated.";
            sw = rw;
            hw = r;
            reset = 0x0;
        } lane0_eol_1[31:16];

        field {
            name = "lane0_eol_0";
            desc = "Lane0 eol 0. Chinese-only data sheet: description and value encoding not translated.";
            sw = rw;
            hw = r;
            reset = 0x0;
        } lane0_eol_0[15:0];
    } LVDS1_LANE0_EOL_01 @ 0x2338;

    reg {
        name = "LVDS1_LANE0_EOL_23";
        desc = "Data sheet 9.3.6 LVDS1_LANE0_EOL_23 (offset 0x233C, printed page 9-187, `hi3516av300--Hi3516AV300-Datasheet.txt` line 46176).";

        field {
            name = "lane0_eol_3";
            desc = "Lane0 eol 3. Chinese-only data sheet: description and value encoding not translated.";
            sw = rw;
            hw = r;
            reset = 0x0;
        } lane0_eol_3[31:16];

        field {
            name = "lane0_eol_2";
            desc = "Lane0 eol 2. Chinese-only data sheet: description and value encoding not translated.";
            sw = rw;
            hw = r;
            reset = 0x0;
        } lane0_eol_2[15:0];
    } LVDS1_LANE0_EOL_23 @ 0x233C;

    reg {
        name = "LVDS1_LANE1_SOF_01";
        desc = "Data sheet 9.3.6 LVDS1_LANE1_SOF_01 (offset 0x2340, printed page 9-184, `hi3516av300--Hi3516AV300-Datasheet.txt` line 45957).";

        field {
            name = "lane1_sof_1";
            desc = "Lane1 sof 1. Chinese-only data sheet: description and value encoding not translated.";
            sw = rw;
            hw = r;
            reset = 0x0;
        } lane1_sof_1[31:16];

        field {
            name = "lane1_sof_0";
            desc = "Lane1 sof 0. Chinese-only data sheet: description and value encoding not translated.";
            sw = rw;
            hw = r;
            reset = 0x0;
        } lane1_sof_0[15:0];
    } LVDS1_LANE1_SOF_01 @ 0x2340;

    reg {
        name = "LVDS1_LANE1_SOF_23";
        desc = "Data sheet 9.3.6 LVDS1_LANE1_SOF_23 (offset 0x2344, printed page 9-184, `hi3516av300--Hi3516AV300-Datasheet.txt` line 45991).";

        field {
            name = "lane1_sof_3";
            desc = "Lane1 sof 3. Chinese-only data sheet: description and value encoding not translated.";
            sw = rw;
            hw = r;
            reset = 0x0;
        } lane1_sof_3[31:16];

        field {
            name = "lane1_sof_2";
            desc = "Lane1 sof 2. Chinese-only data sheet: description and value encoding not translated.";
            sw = rw;
            hw = r;
            reset = 0x0;
        } lane1_sof_2[15:0];
    } LVDS1_LANE1_SOF_23 @ 0x2344;

    reg {
        name = "LVDS1_LANE1_EOF_01";
        desc = "Data sheet 9.3.6 LVDS1_LANE1_EOF_01 (offset 0x2348, printed page 9-185, `hi3516av300--Hi3516AV300-Datasheet.txt` line 46021).";

        field {
            name = "lane1_eof_1";
            desc = "Lane1 eof 1. Chinese-only data sheet: description and value encoding not translated.";
            sw = rw;
            hw = r;
            reset = 0x0;
        } lane1_eof_1[31:16];

        field {
            name = "lane1_eof_0";
            desc = "Lane1 eof 0. Chinese-only data sheet: description and value encoding not translated.";
            sw = rw;
            hw = r;
            reset = 0x0;
        } lane1_eof_0[15:0];
    } LVDS1_LANE1_EOF_01 @ 0x2348;

    reg {
        name = "LVDS1_LANE1_EOF_23";
        desc = "Data sheet 9.3.6 LVDS1_LANE1_EOF_23 (offset 0x234C, printed page 9-185, `hi3516av300--Hi3516AV300-Datasheet.txt` line 46049).";

        field {
            name = "lane1_eof_3";
            desc = "Lane1 eof 3. Chinese-only data sheet: description and value encoding not translated.";
            sw = rw;
            hw = r;
            reset = 0x0;
        } lane1_eof_3[31:16];

        field {
            name = "lane1_eof_2";
            desc = "Lane1 eof 2. Chinese-only data sheet: description and value encoding not translated.";
            sw = rw;
            hw = r;
            reset = 0x0;
        } lane1_eof_2[15:0];
    } LVDS1_LANE1_EOF_23 @ 0x234C;

    reg {
        name = "LVDS1_LANE1_SOL_01";
        desc = "Data sheet 9.3.6 LVDS1_LANE1_SOL_01 (offset 0x2350, printed page 9-185, `hi3516av300--Hi3516AV300-Datasheet.txt` line 46077).";

        field {
            name = "lane1_sol_1";
            desc = "Lane1 sol 1. Chinese-only data sheet: description and value encoding not translated.";
            sw = rw;
            hw = r;
            reset = 0x0;
        } lane1_sol_1[31:16];

        field {
            name = "lane1_sol_0";
            desc = "Lane1 sol 0. Chinese-only data sheet: description and value encoding not translated.";
            sw = rw;
            hw = r;
            reset = 0x0;
        } lane1_sol_0[15:0];
    } LVDS1_LANE1_SOL_01 @ 0x2350;

    reg {
        name = "LVDS1_LANE1_SOL_23";
        desc = "Data sheet 9.3.6 LVDS1_LANE1_SOL_23 (offset 0x2354, printed page 9-186, `hi3516av300--Hi3516AV300-Datasheet.txt` line 46111).";

        field {
            name = "lane1_sol_3";
            desc = "Lane1 sol 3. Chinese-only data sheet: description and value encoding not translated.";
            sw = rw;
            hw = r;
            reset = 0x0;
        } lane1_sol_3[31:16];

        field {
            name = "lane1_sol_2";
            desc = "Lane1 sol 2. Chinese-only data sheet: description and value encoding not translated.";
            sw = rw;
            hw = r;
            reset = 0x0;
        } lane1_sol_2[15:0];
    } LVDS1_LANE1_SOL_23 @ 0x2354;

    reg {
        name = "LVDS1_LANE1_EOL_01";
        desc = "Data sheet 9.3.6 LVDS1_LANE1_EOL_01 (offset 0x2358, printed page 9-186, `hi3516av300--Hi3516AV300-Datasheet.txt` line 46145).";

        field {
            name = "lane1_eol_1";
            desc = "Lane1 eol 1. Chinese-only data sheet: description and value encoding not translated.";
            sw = rw;
            hw = r;
            reset = 0x0;
        } lane1_eol_1[31:16];

        field {
            name = "lane1_eol_0";
            desc = "Lane1 eol 0. Chinese-only data sheet: description and value encoding not translated.";
            sw = rw;
            hw = r;
            reset = 0x0;
        } lane1_eol_0[15:0];
    } LVDS1_LANE1_EOL_01 @ 0x2358;

    reg {
        name = "LVDS1_LANE1_EOL_23";
        desc = "Data sheet 9.3.6 LVDS1_LANE1_EOL_23 (offset 0x235C, printed page 9-187, `hi3516av300--Hi3516AV300-Datasheet.txt` line 46176).";

        field {
            name = "lane1_eol_3";
            desc = "Lane1 eol 3. Chinese-only data sheet: description and value encoding not translated.";
            sw = rw;
            hw = r;
            reset = 0x0;
        } lane1_eol_3[31:16];

        field {
            name = "lane1_eol_2";
            desc = "Lane1 eol 2. Chinese-only data sheet: description and value encoding not translated.";
            sw = rw;
            hw = r;
            reset = 0x0;
        } lane1_eol_2[15:0];
    } LVDS1_LANE1_EOL_23 @ 0x235C;

    reg {
        name = "LVDS1_LANE0_NXT_SOF_01";
        desc = "Data sheet 9.3.6 LVDS1_LANE0_NXT_SOF_01 (offset 0x2520, printed page 9-187, `hi3516av300--Hi3516AV300-Datasheet.txt` line 46212).";

        field {
            name = "lane0_nxt_sof_1";
            desc = "Lane0 nxt sof 1. Chinese-only data sheet: description and value encoding not translated.";
            sw = rw;
            hw = r;
            reset = 0x0;
        } lane0_nxt_sof_1[31:16];

        field {
            name = "lane0_nxt_sof_0";
            desc = "Lane0 nxt sof 0. Chinese-only data sheet: description and value encoding not translated.";
            sw = rw;
            hw = r;
            reset = 0x0;
        } lane0_nxt_sof_0[15:0];
    } LVDS1_LANE0_NXT_SOF_01 @ 0x2520;

    reg {
        name = "LVDS1_LANE0_NXT_SOF_23";
        desc = "Data sheet 9.3.6 LVDS1_LANE0_NXT_SOF_23 (offset 0x2524, printed page 9-188, `hi3516av300--Hi3516AV300-Datasheet.txt` line 46242).";

        field {
            name = "lane0_nxt_sof_3";
            desc = "Lane0 nxt sof 3. Chinese-only data sheet: description and value encoding not translated.";
            sw = rw;
            hw = r;
            reset = 0x0;
        } lane0_nxt_sof_3[31:16];

        field {
            name = "lane0_nxt_sof_2";
            desc = "Lane0 nxt sof 2. Chinese-only data sheet: description and value encoding not translated.";
            sw = rw;
            hw = r;
            reset = 0x0;
        } lane0_nxt_sof_2[15:0];
    } LVDS1_LANE0_NXT_SOF_23 @ 0x2524;

    reg {
        name = "LVDS1_LANE0_NXT_EOF_01";
        desc = "Data sheet 9.3.6 LVDS1_LANE0_NXT_EOF_01 (offset 0x2528, printed page 9-188, `hi3516av300--Hi3516AV300-Datasheet.txt` line 46270).";

        field {
            name = "lane0_nxt_eof_1";
            desc = "Lane0 nxt eof 1. Chinese-only data sheet: description and value encoding not translated.";
            sw = rw;
            hw = r;
            reset = 0x0;
        } lane0_nxt_eof_1[31:16];

        field {
            name = "lane0_nxt_eof_0";
            desc = "Lane0 nxt eof 0. Chinese-only data sheet: description and value encoding not translated.";
            sw = rw;
            hw = r;
            reset = 0x0;
        } lane0_nxt_eof_0[15:0];
    } LVDS1_LANE0_NXT_EOF_01 @ 0x2528;

    reg {
        name = "LVDS1_LANE0_NXT_EOF_23";
        desc = "Data sheet 9.3.6 LVDS1_LANE0_NXT_EOF_23 (offset 0x252C, printed page 9-188, `hi3516av300--Hi3516AV300-Datasheet.txt` line 46298).";

        field {
            name = "lane0_nxt_eof_3";
            desc = "Lane0 nxt eof 3. Chinese-only data sheet: description and value encoding not translated.";
            sw = rw;
            hw = r;
            reset = 0x0;
        } lane0_nxt_eof_3[31:16];

        field {
            name = "lane0_nxt_eof_2";
            desc = "Lane0 nxt eof 2. Chinese-only data sheet: description and value encoding not translated.";
            sw = rw;
            hw = r;
            reset = 0x0;
        } lane0_nxt_eof_2[15:0];
    } LVDS1_LANE0_NXT_EOF_23 @ 0x252C;

    reg {
        name = "LVDS1_LANE0_NXT_SOL_01";
        desc = "Data sheet 9.3.6 LVDS1_LANE0_NXT_SOL_01 (offset 0x2530, printed page 9-189, `hi3516av300--Hi3516AV300-Datasheet.txt` line 46332).";

        field {
            name = "lane0_nxt_sol_1";
            desc = "Lane0 nxt sol 1. Chinese-only data sheet: description and value encoding not translated.";
            sw = rw;
            hw = r;
            reset = 0x0;
        } lane0_nxt_sol_1[31:16];

        field {
            name = "lane0_nxt_sol_0";
            desc = "Lane0 nxt sol 0. Chinese-only data sheet: description and value encoding not translated.";
            sw = rw;
            hw = r;
            reset = 0x0;
        } lane0_nxt_sol_0[15:0];
    } LVDS1_LANE0_NXT_SOL_01 @ 0x2530;

    reg {
        name = "LVDS1_LANE0_NXT_SOL_23";
        desc = "Data sheet 9.3.6 LVDS1_LANE0_NXT_SOL_23 (offset 0x2534, printed page 9-189, `hi3516av300--Hi3516AV300-Datasheet.txt` line 46366).";

        field {
            name = "lane0_nxt_sol_3";
            desc = "Lane0 nxt sol 3. Chinese-only data sheet: description and value encoding not translated.";
            sw = rw;
            hw = r;
            reset = 0x0;
        } lane0_nxt_sol_3[31:16];

        field {
            name = "lane0_nxt_sol_2";
            desc = "Lane0 nxt sol 2. Chinese-only data sheet: description and value encoding not translated.";
            sw = rw;
            hw = r;
            reset = 0x0;
        } lane0_nxt_sol_2[15:0];
    } LVDS1_LANE0_NXT_SOL_23 @ 0x2534;

    reg {
        name = "LVDS1_LANE0_NXT_EOL_01";
        desc = "Data sheet 9.3.6 LVDS1_LANE0_NXT_EOL_01 (offset 0x2538, printed page 9-190, `hi3516av300--Hi3516AV300-Datasheet.txt` line 46397).";

        field {
            name = "lane0_nxt_eol_1";
            desc = "Lane0 nxt eol 1. Chinese-only data sheet: description and value encoding not translated.";
            sw = rw;
            hw = r;
            reset = 0x0;
        } lane0_nxt_eol_1[31:16];

        field {
            name = "lane0_nxt_eol_0";
            desc = "Lane0 nxt eol 0. Chinese-only data sheet: description and value encoding not translated.";
            sw = rw;
            hw = r;
            reset = 0x0;
        } lane0_nxt_eol_0[15:0];
    } LVDS1_LANE0_NXT_EOL_01 @ 0x2538;

    reg {
        name = "LVDS1_LANE0_NXT_EOL_23";
        desc = "Data sheet 9.3.6 LVDS1_LANE0_NXT_EOL_23 (offset 0x253C, printed page 9-190, `hi3516av300--Hi3516AV300-Datasheet.txt` line 46433).";

        field {
            name = "lane0_nxt_eol_3";
            desc = "Lane0 nxt eol 3. Chinese-only data sheet: description and value encoding not translated.";
            sw = rw;
            hw = r;
            reset = 0x0;
        } lane0_nxt_eol_3[31:16];

        field {
            name = "lane0_nxt_eol_2";
            desc = "Lane0 nxt eol 2. Chinese-only data sheet: description and value encoding not translated.";
            sw = rw;
            hw = r;
            reset = 0x0;
        } lane0_nxt_eol_2[15:0];
    } LVDS1_LANE0_NXT_EOL_23 @ 0x253C;

    reg {
        name = "LVDS1_LANE1_NXT_SOF_01";
        desc = "Data sheet 9.3.6 LVDS1_LANE1_NXT_SOF_01 (offset 0x2540, printed page 9-187, `hi3516av300--Hi3516AV300-Datasheet.txt` line 46212).";

        field {
            name = "lane1_nxt_sof_1";
            desc = "Lane1 nxt sof 1. Chinese-only data sheet: description and value encoding not translated.";
            sw = rw;
            hw = r;
            reset = 0x0;
        } lane1_nxt_sof_1[31:16];

        field {
            name = "lane1_nxt_sof_0";
            desc = "Lane1 nxt sof 0. Chinese-only data sheet: description and value encoding not translated.";
            sw = rw;
            hw = r;
            reset = 0x0;
        } lane1_nxt_sof_0[15:0];
    } LVDS1_LANE1_NXT_SOF_01 @ 0x2540;

    reg {
        name = "LVDS1_LANE1_NXT_SOF_23";
        desc = "Data sheet 9.3.6 LVDS1_LANE1_NXT_SOF_23 (offset 0x2544, printed page 9-188, `hi3516av300--Hi3516AV300-Datasheet.txt` line 46242).";

        field {
            name = "lane1_nxt_sof_3";
            desc = "Lane1 nxt sof 3. Chinese-only data sheet: description and value encoding not translated.";
            sw = rw;
            hw = r;
            reset = 0x0;
        } lane1_nxt_sof_3[31:16];

        field {
            name = "lane1_nxt_sof_2";
            desc = "Lane1 nxt sof 2. Chinese-only data sheet: description and value encoding not translated.";
            sw = rw;
            hw = r;
            reset = 0x0;
        } lane1_nxt_sof_2[15:0];
    } LVDS1_LANE1_NXT_SOF_23 @ 0x2544;

    reg {
        name = "LVDS1_LANE1_NXT_EOF_01";
        desc = "Data sheet 9.3.6 LVDS1_LANE1_NXT_EOF_01 (offset 0x2548, printed page 9-188, `hi3516av300--Hi3516AV300-Datasheet.txt` line 46270).";

        field {
            name = "lane1_nxt_eof_1";
            desc = "Lane1 nxt eof 1. Chinese-only data sheet: description and value encoding not translated.";
            sw = rw;
            hw = r;
            reset = 0x0;
        } lane1_nxt_eof_1[31:16];

        field {
            name = "lane1_nxt_eof_0";
            desc = "Lane1 nxt eof 0. Chinese-only data sheet: description and value encoding not translated.";
            sw = rw;
            hw = r;
            reset = 0x0;
        } lane1_nxt_eof_0[15:0];
    } LVDS1_LANE1_NXT_EOF_01 @ 0x2548;

    reg {
        name = "LVDS1_LANE1_NXT_EOF_23";
        desc = "Data sheet 9.3.6 LVDS1_LANE1_NXT_EOF_23 (offset 0x254C, printed page 9-188, `hi3516av300--Hi3516AV300-Datasheet.txt` line 46298).";

        field {
            name = "lane1_nxt_eof_3";
            desc = "Lane1 nxt eof 3. Chinese-only data sheet: description and value encoding not translated.";
            sw = rw;
            hw = r;
            reset = 0x0;
        } lane1_nxt_eof_3[31:16];

        field {
            name = "lane1_nxt_eof_2";
            desc = "Lane1 nxt eof 2. Chinese-only data sheet: description and value encoding not translated.";
            sw = rw;
            hw = r;
            reset = 0x0;
        } lane1_nxt_eof_2[15:0];
    } LVDS1_LANE1_NXT_EOF_23 @ 0x254C;

    reg {
        name = "LVDS1_LANE1_NXT_SOL_01";
        desc = "Data sheet 9.3.6 LVDS1_LANE1_NXT_SOL_01 (offset 0x2550, printed page 9-189, `hi3516av300--Hi3516AV300-Datasheet.txt` line 46332).";

        field {
            name = "lane1_nxt_sol_1";
            desc = "Lane1 nxt sol 1. Chinese-only data sheet: description and value encoding not translated.";
            sw = rw;
            hw = r;
            reset = 0x0;
        } lane1_nxt_sol_1[31:16];

        field {
            name = "lane1_nxt_sol_0";
            desc = "Lane1 nxt sol 0. Chinese-only data sheet: description and value encoding not translated.";
            sw = rw;
            hw = r;
            reset = 0x0;
        } lane1_nxt_sol_0[15:0];
    } LVDS1_LANE1_NXT_SOL_01 @ 0x2550;

    reg {
        name = "LVDS1_LANE1_NXT_SOL_23";
        desc = "Data sheet 9.3.6 LVDS1_LANE1_NXT_SOL_23 (offset 0x2554, printed page 9-189, `hi3516av300--Hi3516AV300-Datasheet.txt` line 46366).";

        field {
            name = "lane1_nxt_sol_3";
            desc = "Lane1 nxt sol 3. Chinese-only data sheet: description and value encoding not translated.";
            sw = rw;
            hw = r;
            reset = 0x0;
        } lane1_nxt_sol_3[31:16];

        field {
            name = "lane1_nxt_sol_2";
            desc = "Lane1 nxt sol 2. Chinese-only data sheet: description and value encoding not translated.";
            sw = rw;
            hw = r;
            reset = 0x0;
        } lane1_nxt_sol_2[15:0];
    } LVDS1_LANE1_NXT_SOL_23 @ 0x2554;

    reg {
        name = "LVDS1_LANE1_NXT_EOL_01";
        desc = "Data sheet 9.3.6 LVDS1_LANE1_NXT_EOL_01 (offset 0x2558, printed page 9-190, `hi3516av300--Hi3516AV300-Datasheet.txt` line 46397).";

        field {
            name = "lane1_nxt_eol_1";
            desc = "Lane1 nxt eol 1. Chinese-only data sheet: description and value encoding not translated.";
            sw = rw;
            hw = r;
            reset = 0x0;
        } lane1_nxt_eol_1[31:16];

        field {
            name = "lane1_nxt_eol_0";
            desc = "Lane1 nxt eol 0. Chinese-only data sheet: description and value encoding not translated.";
            sw = rw;
            hw = r;
            reset = 0x0;
        } lane1_nxt_eol_0[15:0];
    } LVDS1_LANE1_NXT_EOL_01 @ 0x2558;

    reg {
        name = "LVDS1_LANE1_NXT_EOL_23";
        desc = "Data sheet 9.3.6 LVDS1_LANE1_NXT_EOL_23 (offset 0x255C, printed page 9-190, `hi3516av300--Hi3516AV300-Datasheet.txt` line 46433).";

        field {
            name = "lane1_nxt_eol_3";
            desc = "Lane1 nxt eol 3. Chinese-only data sheet: description and value encoding not translated.";
            sw = rw;
            hw = r;
            reset = 0x0;
        } lane1_nxt_eol_3[31:16];

        field {
            name = "lane1_nxt_eol_2";
            desc = "Lane1 nxt eol 2. Chinese-only data sheet: description and value encoding not translated.";
            sw = rw;
            hw = r;
            reset = 0x0;
        } lane1_nxt_eol_2[15:0];
    } LVDS1_LANE1_NXT_EOL_23 @ 0x255C;

    reg {
        name = "LVDS1_LI_WORD0";
        desc = "Data sheet 9.3.6 LVDS1_LI_WORD0 (offset 0x2720, printed page 9-191, `hi3516av300--Hi3516AV300-Datasheet.txt` line 46462).";

        field {
            name = "li_word0_1";
            desc = "Li word0 1. Chinese-only data sheet: description and value encoding not translated.";
            sw = rw;
            hw = r;
            reset = 0x211;
        } li_word0_1[31:16];

        field {
            name = "li_word0_0";
            desc = "Li word0 0. Chinese-only data sheet: description and value encoding not translated.";
            sw = rw;
            hw = r;
            reset = 0x201;
        } li_word0_0[15:0];
    } LVDS1_LI_WORD0 @ 0x2720;

    reg {
        name = "LVDS1_LI_WORD1";
        desc = "Data sheet 9.3.6 LVDS1_LI_WORD1 (offset 0x2724, printed page 9-191, `hi3516av300--Hi3516AV300-Datasheet.txt` line 46482).";

        field {
            name = "li_word1_1";
            desc = "Li word1 1. Chinese-only data sheet: description and value encoding not translated.";
            sw = rw;
            hw = r;
            reset = 0x212;
        } li_word1_1[31:16];

        field {
            name = "li_word1_0";
            desc = "Li word1 0. Chinese-only data sheet: description and value encoding not translated.";
            sw = rw;
            hw = r;
            reset = 0x202;
        } li_word1_0[15:0];
    } LVDS1_LI_WORD1 @ 0x2724;

    reg {
        name = "LVDS1_LI_WORD2";
        desc = "Data sheet 9.3.6 LVDS1_LI_WORD2 (offset 0x2728, printed page 9-191, `hi3516av300--Hi3516AV300-Datasheet.txt` line 46510).";

        field {
            name = "li_word2_1";
            desc = "Li word2 1. Chinese-only data sheet: description and value encoding not translated.";
            sw = rw;
            hw = r;
            reset = 0x214;
        } li_word2_1[31:16];

        field {
            name = "li_word2_0";
            desc = "Li word2 0. Chinese-only data sheet: description and value encoding not translated.";
            sw = rw;
            hw = r;
            reset = 0x204;
        } li_word2_0[15:0];
    } LVDS1_LI_WORD2 @ 0x2728;

    reg {
        name = "LVDS1_LI_WORD3";
        desc = "Data sheet 9.3.6 LVDS1_LI_WORD3 (offset 0x272C, printed page 9-191, `hi3516av300--Hi3516AV300-Datasheet.txt` line 46531).";

        field {
            name = "li_word3_1";
            desc = "Li word3 1. Chinese-only data sheet: description and value encoding not translated.";
            sw = rw;
            hw = r;
            reset = 0x218;
        } li_word3_1[31:16];

        field {
            name = "li_word3_0";
            desc = "Li word3 0. Chinese-only data sheet: description and value encoding not translated.";
            sw = rw;
            hw = r;
            reset = 0x208;
        } li_word3_0[15:0];
    } LVDS1_LI_WORD3 @ 0x272C;

    reg {
        name = "LVDS1_IMGSIZE0_STATIS";
        desc = "Data sheet 9.3.6 LVDS1_IMGSIZE0_STATIS (offset 0x2780, printed page 9-192, `hi3516av300--Hi3516AV300-Datasheet.txt` line 46557).";

        field {
            name = "lvds_imgheight0";
            desc = "Lvds imgheight0. Chinese-only data sheet: description and value encoding not translated.";
            sw = r;
            hw = w;
            reset = 0x0;
        } lvds_imgheight0[31:16];

        field {
            name = "lvds_imgwidth0";
            desc = "Lvds imgwidth0. Chinese-only data sheet: description and value encoding not translated.";
            sw = r;
            hw = w;
            reset = 0x0;
        } lvds_imgwidth0[15:0];
    } LVDS1_IMGSIZE0_STATIS @ 0x2780;

    reg {
        name = "LVDS1_IMGSIZE1_STATIS";
        desc = "Data sheet 9.3.6 LVDS1_IMGSIZE1_STATIS (offset 0x2784, printed page 9-192, `hi3516av300--Hi3516AV300-Datasheet.txt` line 46583).";

        field {
            name = "lvds_imgheight1";
            desc = "Lvds imgheight1. Chinese-only data sheet: description and value encoding not translated.";
            sw = r;
            hw = w;
            reset = 0x0;
        } lvds_imgheight1[31:16];

        field {
            name = "lvds_imgwidth1";
            desc = "Lvds imgwidth1. Chinese-only data sheet: description and value encoding not translated.";
            sw = r;
            hw = w;
            reset = 0x0;
        } lvds_imgwidth1[15:0];
    } LVDS1_IMGSIZE1_STATIS @ 0x2784;

    reg {
        name = "LVDS1_IMGSIZE2_STATIS";
        desc = "Data sheet 9.3.6 LVDS1_IMGSIZE2_STATIS (offset 0x2788, printed page 9-192, `hi3516av300--Hi3516AV300-Datasheet.txt` line 46603).";

        field {
            name = "lvds_imgheight2";
            desc = "Lvds imgheight2. Chinese-only data sheet: description and value encoding not translated.";
            sw = r;
            hw = w;
            reset = 0x0;
        } lvds_imgheight2[31:16];

        field {
            name = "lvds_imgwidth2";
            desc = "Lvds imgwidth2. Chinese-only data sheet: description and value encoding not translated.";
            sw = r;
            hw = w;
            reset = 0x0;
        } lvds_imgwidth2[15:0];
    } LVDS1_IMGSIZE2_STATIS @ 0x2788;

    reg {
        name = "LVDS1_IMGSIZE3_STATIS";
        desc = "Data sheet 9.3.6 LVDS1_IMGSIZE3_STATIS (offset 0x278C, printed page 9-193, `hi3516av300--Hi3516AV300-Datasheet.txt` line 46629).";

        field {
            name = "lvds_imgheight3";
            desc = "Lvds imgheight3. Chinese-only data sheet: description and value encoding not translated.";
            sw = r;
            hw = w;
            reset = 0x0;
        } lvds_imgheight3[31:16];

        field {
            name = "lvds_imgwidth3";
            desc = "Lvds imgwidth3. Chinese-only data sheet: description and value encoding not translated.";
            sw = r;
            hw = w;
            reset = 0x0;
        } lvds_imgwidth3[15:0];
    } LVDS1_IMGSIZE3_STATIS @ 0x278C;

    reg {
        name = "LVDS1_CTRL_INT_RAW";
        desc = "Data sheet 9.3.6 LVDS1_CTRL_INT_RAW (offset 0x27F0, printed page 9-193, `hi3516av300--Hi3516AV300-Datasheet.txt` line 46650).";

        field {
            name = "lvds_vsync_raw";
            desc = "Lvds vertical sync raw. Chinese-only data sheet: description and value encoding not translated.";
            sw = rw;
            hw = w;
            onwrite = woclr;
            reset = 0x0;
        } lvds_vsync_raw[28:28];

        field {
            name = "cmd_rd_err_raw";
            desc = "Cmd read error raw. Chinese-only data sheet: description and value encoding not translated.";
            sw = rw;
            hw = w;
            onwrite = woclr;
            reset = 0x0;
        } cmd_rd_err_raw[27:27];

        field {
            name = "cmd_wr_err_raw";
            desc = "Cmd write error raw. Chinese-only data sheet: description and value encoding not translated.";
            sw = rw;
            hw = w;
            onwrite = woclr;
            reset = 0x0;
        } cmd_wr_err_raw[26:26];

        field {
            name = "pop_err_raw";
            desc = "Pop error raw. Chinese-only data sheet: description and value encoding not translated.";
            sw = rw;
            hw = w;
            onwrite = woclr;
            reset = 0x0;
        } pop_err_raw[25:25];

        field {
            name = "lvds_state_err_raw";
            desc = "Lvds state error raw. Chinese-only data sheet: description and value encoding not translated.";
            sw = rw;
            hw = w;
            onwrite = woclr;
            reset = 0x0;
        } lvds_state_err_raw[24:24];

        field {
            name = "link0_rd_err_raw";
            desc = "Link0 read error raw. Chinese-only data sheet: description and value encoding not translated.";
            sw = rw;
            hw = w;
            onwrite = woclr;
            reset = 0x0;
        } link0_rd_err_raw[20:20];

        field {
            name = "link0_wr_err_raw";
            desc = "Link0 write error raw. Chinese-only data sheet: description and value encoding not translated.";
            sw = rw;
            hw = w;
            onwrite = woclr;
            reset = 0x0;
        } link0_wr_err_raw[16:16];

        field {
            name = "lane3_sync_err_raw";
            desc = "Lane3 sync error raw. Chinese-only data sheet: description and value encoding not translated.";
            sw = rw;
            hw = w;
            onwrite = woclr;
            reset = 0x0;
        } lane3_sync_err_raw[3:3];

        field {
            name = "lane2_sync_err_raw";
            desc = "Lane2 sync error raw. Chinese-only data sheet: description and value encoding not translated.";
            sw = rw;
            hw = w;
            onwrite = woclr;
            reset = 0x0;
        } lane2_sync_err_raw[2:2];

        field {
            name = "lane1_sync_err_raw";
            desc = "Lane1 sync error raw. Chinese-only data sheet: description and value encoding not translated.";
            sw = rw;
            hw = w;
            onwrite = woclr;
            reset = 0x0;
        } lane1_sync_err_raw[1:1];

        field {
            name = "lane0_sync_err_raw";
            desc = "Lane0 sync error raw. Chinese-only data sheet: description and value encoding not translated.";
            sw = rw;
            hw = w;
            onwrite = woclr;
            reset = 0x0;
        } lane0_sync_err_raw[0:0];
    } LVDS1_CTRL_INT_RAW @ 0x27F0;

    reg {
        name = "LVDS1_CTRL_INT";
        desc = "Data sheet 9.3.6 LVDS1_CTRL_INT (offset 0x27F4, printed page 9-194, `hi3516av300--Hi3516AV300-Datasheet.txt` line 46745).";

        field {
            name = "lvds_vsync_st";
            desc = "Lvds vertical sync st. Chinese-only data sheet: description and value encoding not translated.";
            sw = r;
            hw = w;
            reset = 0x0;
        } lvds_vsync_st[28:28];

        field {
            name = "cmd_rd_err_st";
            desc = "Cmd read error st. Chinese-only data sheet: description and value encoding not translated.";
            sw = r;
            hw = w;
            reset = 0x0;
        } cmd_rd_err_st[27:27];

        field {
            name = "cmd_wr_err_st";
            desc = "Cmd write error st. Chinese-only data sheet: description and value encoding not translated.";
            sw = r;
            hw = w;
            reset = 0x0;
        } cmd_wr_err_st[26:26];

        field {
            name = "pop_err_st";
            desc = "Pop error st. Chinese-only data sheet: description and value encoding not translated.";
            sw = r;
            hw = w;
            reset = 0x0;
        } pop_err_st[25:25];

        field {
            name = "lvds_state_err_st";
            desc = "Lvds state error st. Chinese-only data sheet: description and value encoding not translated.";
            sw = r;
            hw = w;
            reset = 0x0;
        } lvds_state_err_st[24:24];

        field {
            name = "link0_rd_err_st";
            desc = "Link0 read error st. Chinese-only data sheet: description and value encoding not translated.";
            sw = r;
            hw = w;
            reset = 0x0;
        } link0_rd_err_st[20:20];

        field {
            name = "link0_wr_err_st";
            desc = "Link0 write error st. Chinese-only data sheet: description and value encoding not translated.";
            sw = r;
            hw = w;
            reset = 0x0;
        } link0_wr_err_st[16:16];

        field {
            name = "lane3_sync_err_st";
            desc = "Lane3 sync error st. Chinese-only data sheet: description and value encoding not translated.";
            sw = r;
            hw = w;
            reset = 0x0;
        } lane3_sync_err_st[3:3];

        field {
            name = "lane2_sync_err_st";
            desc = "Lane2 sync error st. Chinese-only data sheet: description and value encoding not translated.";
            sw = r;
            hw = w;
            reset = 0x0;
        } lane2_sync_err_st[2:2];

        field {
            name = "lane1_sync_err_st";
            desc = "Lane1 sync error st. Chinese-only data sheet: description and value encoding not translated.";
            sw = r;
            hw = w;
            reset = 0x0;
        } lane1_sync_err_st[1:1];

        field {
            name = "lane0_sync_err_st";
            desc = "Lane0 sync error st. Chinese-only data sheet: description and value encoding not translated.";
            sw = r;
            hw = w;
            reset = 0x0;
        } lane0_sync_err_st[0:0];
    } LVDS1_CTRL_INT @ 0x27F4;

    reg {
        name = "LVDS1_CTRL_INT_MSK";
        desc = "Data sheet 9.3.6 LVDS1_CTRL_INT_MSK (offset 0x27F8, printed page 9-196, `hi3516av300--Hi3516AV300-Datasheet.txt` line 46835).";

        field {
            name = "lvds_vsync_msk";
            desc = "Lvds vertical sync mask. Chinese-only data sheet: description and value encoding not translated.";
            sw = rw;
            hw = r;
            reset = 0x0;
        } lvds_vsync_msk[28:28];

        field {
            name = "cmd_rd_err_msk";
            desc = "Cmd read error mask. Chinese-only data sheet: description and value encoding not translated.";
            sw = rw;
            hw = r;
            reset = 0x0;
        } cmd_rd_err_msk[27:27];

        field {
            name = "cmd_wr_err_msk";
            desc = "Cmd write error mask. Chinese-only data sheet: description and value encoding not translated.";
            sw = rw;
            hw = r;
            reset = 0x0;
        } cmd_wr_err_msk[26:26];

        field {
            name = "pop_err_msk";
            desc = "Pop error mask. Chinese-only data sheet: description and value encoding not translated.";
            sw = rw;
            hw = r;
            reset = 0x0;
        } pop_err_msk[25:25];

        field {
            name = "lvds_state_err_msk";
            desc = "Lvds state error mask. Chinese-only data sheet: description and value encoding not translated.";
            sw = rw;
            hw = r;
            reset = 0x0;
        } lvds_state_err_msk[24:24];

        field {
            name = "link0_rd_err_msk";
            desc = "Link0 read error mask. Chinese-only data sheet: description and value encoding not translated.";
            sw = rw;
            hw = r;
            reset = 0x0;
        } link0_rd_err_msk[20:20];

        field {
            name = "link0_wr_err_msk";
            desc = "Link0 write error mask. Chinese-only data sheet: description and value encoding not translated.";
            sw = rw;
            hw = r;
            reset = 0x0;
        } link0_wr_err_msk[16:16];

        field {
            name = "lane3_sync_err_msk";
            desc = "Lane3 sync error mask. Chinese-only data sheet: description and value encoding not translated.";
            sw = rw;
            hw = r;
            reset = 0x0;
        } lane3_sync_err_msk[3:3];

        field {
            name = "lane2_sync_err_msk";
            desc = "Lane2 sync error mask. Chinese-only data sheet: description and value encoding not translated.";
            sw = rw;
            hw = r;
            reset = 0x0;
        } lane2_sync_err_msk[2:2];

        field {
            name = "lane1_sync_err_msk";
            desc = "Lane1 sync error mask. Chinese-only data sheet: description and value encoding not translated.";
            sw = rw;
            hw = r;
            reset = 0x0;
        } lane1_sync_err_msk[1:1];

        field {
            name = "lane0_sync_err_msk";
            desc = "Lane0 sync error mask. Chinese-only data sheet: description and value encoding not translated.";
            sw = rw;
            hw = r;
            reset = 0x0;
        } lane0_sync_err_msk[0:0];
    } LVDS1_CTRL_INT_MSK @ 0x27F8;

    reg {
        name = "LANE_ID0_CHN1";
        desc = "Data sheet 9.3.6 LANE_ID0_CHN1 (offset 0x2800, printed page 9-197, `hi3516av300--Hi3516AV300-Datasheet.txt` line 46924).";

        field {
            name = "lane3_id";
            desc = "Lane3 id. Chinese-only data sheet: description and value encoding not translated.";
            sw = rw;
            hw = r;
            reset = 0x3;
        } lane3_id[15:12];

        field {
            name = "lane2_id";
            desc = "Lane2 id. Chinese-only data sheet: description and value encoding not translated.";
            sw = rw;
            hw = r;
            reset = 0x2;
        } lane2_id[11:8];

        field {
            name = "lane1_id";
            desc = "Lane1 id. Chinese-only data sheet: description and value encoding not translated.";
            sw = rw;
            hw = r;
            reset = 0x1;
        } lane1_id[7:4];

        field {
            name = "lane0_id";
            desc = "Lane0 id. Chinese-only data sheet: description and value encoding not translated.";
            sw = rw;
            hw = r;
            reset = 0x0;
        } lane0_id[3:0];
    } LANE_ID0_CHN1 @ 0x2800;

    reg {
        name = "ALIGN1_INT_RAW";
        desc = "Data sheet 9.3.6 ALIGN1_INT_RAW (offset 0x28F0, printed page 9-197, `hi3516av300--Hi3516AV300-Datasheet.txt` line 46965).";

        field {
            name = "err_lane3_raw";
            desc = "Error lane3 raw. Chinese-only data sheet: description and value encoding not translated.";
            sw = rw;
            hw = w;
            onwrite = woclr;
            reset = 0x0;
        } err_lane3_raw[4:4];

        field {
            name = "err_lane2_raw";
            desc = "Error lane2 raw. Chinese-only data sheet: description and value encoding not translated.";
            sw = rw;
            hw = w;
            onwrite = woclr;
            reset = 0x0;
        } err_lane2_raw[3:3];

        field {
            name = "err_lane1_raw";
            desc = "Error lane1 raw. Chinese-only data sheet: description and value encoding not translated.";
            sw = rw;
            hw = w;
            onwrite = woclr;
            reset = 0x0;
        } err_lane1_raw[2:2];

        field {
            name = "err_lane0_raw";
            desc = "Error lane0 raw. Chinese-only data sheet: description and value encoding not translated.";
            sw = rw;
            hw = w;
            onwrite = woclr;
            reset = 0x0;
        } err_lane0_raw[1:1];

        field {
            name = "err_full_raw";
            desc = "Error full raw. Chinese-only data sheet: description and value encoding not translated.";
            sw = rw;
            hw = w;
            onwrite = woclr;
            reset = 0x0;
        } err_full_raw[0:0];
    } ALIGN1_INT_RAW @ 0x28F0;

    reg {
        name = "ALIGN1_INT";
        desc = "Data sheet 9.3.6 ALIGN1_INT (offset 0x28F4, printed page 9-198, `hi3516av300--Hi3516AV300-Datasheet.txt` line 47017).";

        field {
            name = "err_lane3_st";
            desc = "Error lane3 st. Chinese-only data sheet: description and value encoding not translated.";
            sw = r;
            hw = w;
            reset = 0x0;
        } err_lane3_st[4:4];

        field {
            name = "err_lane2_st";
            desc = "Error lane2 st. Chinese-only data sheet: description and value encoding not translated.";
            sw = r;
            hw = w;
            reset = 0x0;
        } err_lane2_st[3:3];

        field {
            name = "err_lane1_st";
            desc = "Error lane1 st. Chinese-only data sheet: description and value encoding not translated.";
            sw = r;
            hw = w;
            reset = 0x0;
        } err_lane1_st[2:2];

        field {
            name = "err_lane0_st";
            desc = "Error lane0 st. Chinese-only data sheet: description and value encoding not translated.";
            sw = r;
            hw = w;
            reset = 0x0;
        } err_lane0_st[1:1];

        field {
            name = "err_full_st";
            desc = "Error full st. Chinese-only data sheet: description and value encoding not translated.";
            sw = r;
            hw = w;
            reset = 0x0;
        } err_full_st[0:0];
    } ALIGN1_INT @ 0x28F4;

    reg {
        name = "ALIGN1_INT_MSK";
        desc = "Data sheet 9.3.6 ALIGN1_INT_MSK (offset 0x28F8, printed page 9-199, `hi3516av300--Hi3516AV300-Datasheet.txt` line 47060).";

        field {
            name = "err_lane3_mask";
            desc = "Error lane3 mask. Chinese-only data sheet: description and value encoding not translated.";
            sw = rw;
            hw = r;
            reset = 0x0;
        } err_lane3_mask[4:4];

        field {
            name = "err_lane2_mask";
            desc = "Error lane2 mask. Chinese-only data sheet: description and value encoding not translated.";
            sw = rw;
            hw = r;
            reset = 0x0;
        } err_lane2_mask[3:3];

        field {
            name = "err_lane1_mask";
            desc = "Error lane1 mask. Chinese-only data sheet: description and value encoding not translated.";
            sw = rw;
            hw = r;
            reset = 0x0;
        } err_lane1_mask[2:2];

        field {
            name = "err_lane0_mask";
            desc = "Error lane0 mask. Chinese-only data sheet: description and value encoding not translated.";
            sw = rw;
            hw = r;
            reset = 0x0;
        } err_lane0_mask[1:1];

        field {
            name = "err_full_mask";
            desc = "Error full mask. Chinese-only data sheet: description and value encoding not translated.";
            sw = rw;
            hw = r;
            reset = 0x0;
        } err_full_mask[0:0];
    } ALIGN1_INT_MSK @ 0x28F8;

    reg {
        name = "CHN1_INT_RAW";
        desc = "Data sheet 9.3.6 CHN1_INT_RAW (offset 0x2FF0, printed page 9-199, `hi3516av300--Hi3516AV300-Datasheet.txt` line 47108).";

        field {
            name = "int_data_align_raw";
            desc = "Interrupt data align raw. Chinese-only data sheet: description and value encoding not translated.";
            sw = rw;
            hw = w;
            onwrite = woclr;
            reset = 0x0;
        } int_data_align_raw[3:3];

        field {
            name = "int_mipi_ctrl_raw";
            desc = "Interrupt mipi control raw. Chinese-only data sheet: description and value encoding not translated.";
            sw = rw;
            hw = w;
            onwrite = woclr;
            reset = 0x0;
        } int_mipi_ctrl_raw[2:2];

        field {
            name = "int_mipi_csi_raw";
            desc = "Interrupt mipi csi raw. Chinese-only data sheet: description and value encoding not translated.";
            sw = rw;
            hw = w;
            onwrite = woclr;
            reset = 0x0;
        } int_mipi_csi_raw[1:1];

        field {
            name = "int_lvds_ctrl_raw";
            desc = "Interrupt lvds control raw. Chinese-only data sheet: description and value encoding not translated.";
            sw = rw;
            hw = w;
            onwrite = woclr;
            reset = 0x0;
        } int_lvds_ctrl_raw[0:0];
    } CHN1_INT_RAW @ 0x2FF0;

    reg {
        name = "CHN1_INT";
        desc = "Data sheet 9.3.6 CHN1_INT (offset 0x2FF4, printed page 9-200, `hi3516av300--Hi3516AV300-Datasheet.txt` line 47151).";

        field {
            name = "int_data_align_st";
            desc = "Interrupt data align st. Chinese-only data sheet: description and value encoding not translated.";
            sw = r;
            hw = w;
            reset = 0x0;
        } int_data_align_st[3:3];

        field {
            name = "int_mipi_ctrl_st";
            desc = "Interrupt mipi control st. Chinese-only data sheet: description and value encoding not translated.";
            sw = r;
            hw = w;
            reset = 0x0;
        } int_mipi_ctrl_st[2:2];

        field {
            name = "int_mipi_csi_st";
            desc = "Interrupt mipi csi st. Chinese-only data sheet: description and value encoding not translated.";
            sw = r;
            hw = w;
            reset = 0x0;
        } int_mipi_csi_st[1:1];

        field {
            name = "int_lvds_ctrl_st";
            desc = "Interrupt lvds control st. Chinese-only data sheet: description and value encoding not translated.";
            sw = r;
            hw = w;
            reset = 0x0;
        } int_lvds_ctrl_st[0:0];
    } CHN1_INT @ 0x2FF4;

    reg {
        name = "CHN1_INT_MASK";
        desc = "Data sheet 9.3.6 CHN1_INT_MASK (offset 0x2FF8, printed page 9-?, `hi3516av300--Hi3516AV300-Datasheet.txt` line 47190).";

        field {
            name = "int_data_align_mask";
            desc = "Interrupt data align mask. Chinese-only data sheet: description and value encoding not translated.";
            sw = rw;
            hw = r;
            reset = 0x0;
        } int_data_align_mask[3:3];

        field {
            name = "int_mipi_ctrl_mask";
            desc = "Interrupt mipi control mask. Chinese-only data sheet: description and value encoding not translated.";
            sw = rw;
            hw = r;
            reset = 0x0;
        } int_mipi_ctrl_mask[2:2];

        field {
            name = "int_mipi_csi_mask";
            desc = "Interrupt mipi csi mask. Chinese-only data sheet: description and value encoding not translated.";
            sw = rw;
            hw = r;
            reset = 0x0;
        } int_mipi_csi_mask[1:1];

        field {
            name = "int_lvds_ctrl_mask";
            desc = "Interrupt lvds control mask. Chinese-only data sheet: description and value encoding not translated.";
            sw = rw;
            hw = r;
            reset = 0x0;
        } int_lvds_ctrl_mask[0:0];
    } CHN1_INT_MASK @ 0x2FF8;
};

`endif
