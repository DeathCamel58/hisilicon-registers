`ifndef HISI_MIPI_RX_AV200_RDL
`define HISI_MIPI_RX_AV200_RDL


regfile eHISI_MIPI_RX_AV200 {
    name = "MIPI RX (sensor serial interface receiver, Hi3516A V200 / Hi3519 V101)";
    desc = "
    MIPI RX (combo PHY + controller for MIPI D-PHY CSI-2, LVDS / sub-LVDS / HiSPI and CMOS parallel sensors, feeding the VICAP) of the Hi3516A V200 and Hi3519 V101 (both data sheets, section 9.3.6, list the same 421 registers) at 0x11300000 (MIPI0/MIPI1 window). Three PHY links at 0x0/0x200/0x400 (PHY_*_LINKn), system/channel registers at 0x800 (CHN0/CHN1 *, PHY_ID, PHY_LP_SELECT), two combo devices: device 0 MIPI controller at 0x1000 (MIPI0_*), LVDS controller at 0x1300 (LVDS0_*), ALIGN0 at 0x1600; device 1 at 0x2000/0x2300/0x2600 (MIPI1_*, LVDS1_*, ALIGN1_*). The vendor header (COMBO_MAX_DEV_NUM 2, LANE_NUM_PER_LINK 4) adds PHY_CFG/PHY_OUT_VALID/PHY_DATA_LVDS per link, CHNn_HS_CK_SELECT, the interrupt force registers, MIPI crop/image-size, LVDS DOL H-blank and per-lane image-size statistics. Non-hardware-verified transcription.

    Generated 2026-11-10 by build/rdl-audit/video-rdl-scratch/gen_blocks.py: mechanical transcription of the data sheet register tables (ds_extract2 + description extraction from the PDF) merged with the vendor header; not hardware verified.

    Register sources: 421 registers from the data sheet (hi3516av200--Hi3516AV200-Datasheet.txt, section 9.3.6); 163 registers (2 of them arrays) and 119 fields from OpenIPC openhisilicon `kernel/mipi_rx/hi3519v101/mipi_reg.h` (GPL-3.0 repository, HiSilicon copyright; local copy sources/openhisilicon) (GPL-3.0 repository, HiSilicon copyright; one header for Hi3519 V101 and Hi3516A V200), each marked `[inferred]` in its desc (names from the header, meanings inferred from the names, reset/access unknown). 12 field names that the data-sheet text extraction garbled (two column cells run together) were taken from the header. Name differences, data sheet kept: 0x20 PHY_DATA_MIPI_LINK0 [7:0] DS sphy0_data0_mipi_hs / header phy_data0_mipi_hs; 0x20 PHY_DATA_MIPI_LINK0 [15:8] DS sphy0_data1_mipi_hsphy0_data0_mipi_h / header phy_data1_mipi_hs; 0x20 PHY_DATA_MIPI_LINK0 [23:16] DS sphy0_data2_mipi_hsphy0_data1_mipi_h / header phy_data2_mipi_hs; 0x20 PHY_DATA_MIPI_LINK0 [31:24] DS phy0_data3_mipi_hsphy0_data2_mipi_h / header phy_data3_mipi_hs; 0x220 PHY_DATA_MIPI_LINK1 [7:0] DS sphy1_data0_mipi_hs / header phy_data0_mipi_hs; 0x220 PHY_DATA_MIPI_LINK1 [15:8] DS sphy1_data1_mipi_hsphy1_data0_mipi_h / header phy_data1_mipi_hs; 0x220 PHY_DATA_MIPI_LINK1 [23:16] DS sphy1_data2_mipi_hsphy1_data1_mipi_h / header phy_data2_mipi_hs; 0x220 PHY_DATA_MIPI_LINK1 [31:24] DS phy1_data3_mipi_hsphy1_data2_mipi_h / header phy_data3_mipi_hs; 0x420 PHY_DATA_MIPI_LINK2 [7:0] DS sphy2_data0_mipi_hs / header phy_data0_mipi_hs; 0x420 PHY_DATA_MIPI_LINK2 [15:8] DS sphy2_data1_mipi_hsphy2_data0_mipi_h / header phy_data1_mipi_hs; 0x420 PHY_DATA_MIPI_LINK2 [23:16] DS sphy2_data2_mipi_hsphy2_data1_mipi_h / header phy_data2_mipi_hs; 0x420 PHY_DATA_MIPI_LINK2 [31:24] DS phy2_data3_mipi_hsphy2_data2_mipi_h / header phy_data3_mipi_hs; 0x830 CHN1_PHY_EN [0:0] DS chn1_phy2_en / header lane0_en; 0x83C CHN1_LANE_EN [0:0] DS chn1_lane0_en / header lane0_en; 0x83C CHN1_LANE_EN [1:1] DS chn1_lane1_en / header lane1_en; 0x83C CHN1_LANE_EN [2:2] DS chn1_lane2_en / header lane2_en; 0x83C CHN1_LANE_EN [3:3] DS chn1_lane3_en / header lane3_en; 0xFF0 MIPI_CHN1_INT_RAW [2:2] DS mipi1_int_phycil2_raw / header int_phycil2_raw; 0xFF4 MIPI_CHN1_INT [2:2] DS mipi1_int_phycil2_st / header chn1_int_phycil2_st; 0xFF4 MIPI_CHN1_INT [3:3] DS int_lvds1_ctrl_st / header chn1_int_lvds_ctrl_st; 0xFF4 MIPI_CHN1_INT [4:4] DS int_mipi1_csi_st / header chn1_int_mipi_csi_st; 0xFF4 MIPI_CHN1_INT [5:5] DS int_mipi1_ctrl_st / header chn1_int_mipi_ctrl_st; 0xFF4 MIPI_CHN1_INT [6:6] DS int_data_align1_st / header chn1_int_data_align_st; 0xFF8 MIPI_CHN1_INT_MSK [2:2] DS mipi1_int_phycil2_msk / header chn1_int_phycil2_msk; 0xFF8 MIPI_CHN1_INT_MSK [3:3] DS int_lvds1_ctrl_msk / header chn1_int_lvds_msk; 0xFF8 MIPI_CHN1_INT_MSK [4:4] DS int_mipi1_csi_msk / header chn1_int_mipi_csi_msk; 0xFF8 MIPI_CHN1_INT_MSK [5:5] DS int_mipi1_ctrl_msk / header chn1_int_mipi_ctrl_msk; 0xFF8 MIPI_CHN1_INT_MSK [6:6] DS int_data_align1_msk / header chn1_int_data_align_msk; 0x1250 MIPI0_IMGSIZE0_STATIS [15:0] data-sheet text `c0imgwidth_statis_vc` garbled, header name imgwidth_statis_vc used; 0x1250 MIPI0_IMGSIZE0_STATIS [31:16] data-sheet text `imgheight_statis_vc0imgwidth_statis_vc` garbled, header name imgheight_statis_vc used; 0x1258 MIPI0_IMGSIZE2_STATIS [15:0] data-sheet text `c2imgwidth_statis_vc` garbled, header name imgwidth_statis_vc used; 0x1258 MIPI0_IMGSIZE2_STATIS [31:16] data-sheet text `imgheight_statis_vc2imgwidth_statis_vc` garbled, header name imgheight_statis_vc used; 0x125C MIPI0_IMGSIZE3_STATIS [15:0] data-sheet text `c3imgwidth_statis_vc` garbled, header name imgwidth_statis_vc used; 0x125C MIPI0_IMGSIZE3_STATIS [31:16] data-sheet text `imgheight_statis_vc3imgwidth_statis_vc` garbled, header name imgheight_statis_vc used; 0x14A0 LVDS0_LANE0_NXT_SOF_01 [15:0] DS lane0_nxt_sof_0 / header lane_sof_0; 0x14A0 LVDS0_LANE0_NXT_SOF_01 [31:16] DS lane0_nxt_sof_1 / header lane_sof_1; 0x14A4 LVDS0_LANE0_NXT_SOF_23 [15:0] DS lane0_nxt_sof_2 / header lane_sof_2; 0x14A4 LVDS0_LANE0_NXT_SOF_23 [31:16] DS lane0_nxt_sof_3 / header lane_sof_3; 0x14A8 LVDS0_LANE0_NXT_EOF_01 [15:0] DS lane0_nxt_eof_0 / header lane_eof_0; 0x14A8 LVDS0_LANE0_NXT_EOF_01 [31:16] DS lane0_nxt_eof_1 / header lane_eof_1 (and 495 more).";

    reg {
        name = "Link 0 PHY operating mode register _LINK0";
        desc = "PHY_MODE_LINK0 is a link 0 PHY operating mode register.

Data sheet 9.3.6 PHY_MODE_LINK0 (offset 0x0, printed page 9-202, `hi3516av200--Hi3516AV200-Datasheet.txt` line 48663).";

        enum PHY_MODE_LINK0_phy0_rg_mipi_mode_enum {
            COMMON_VOLTAGE_HIGHER = 0 { name = "Common Voltage Higher"; desc = "The common voltage is higher than 1.25 V."; };
            COMMON_VOLTAGE_1 = 1 { name = "Common Voltage 1"; desc = "The common voltage is 1.25 V or lower."; };
        };

        field {
            name = "phy0_rg_mipi_mode";
            desc = "MIPI/LVDS input mode select. This field is set to 0 when the PHY works in LVDS mode and the common voltage is greater than or equal to 1.25 V.";
            sw = rw;
            hw = r;
            encode = PHY_MODE_LINK0_phy0_rg_mipi_mode_enum;
            reset = 0x0;
        } phy0_rg_mipi_mode[24:24];

        enum PHY_MODE_LINK0_phy0_rg_ext_clk_en_enum {
            PAD_INPUT_DIFFERENTIAL = 0 { name = "Pad Input Differential"; desc = "PAD input differential clock"; };
            DIFFERENTIAL_CLOCK_OTHER = 1 { name = "Differential Clock Other"; desc = "differential clock of other links"; };
        };

        field {
            name = "phy0_rg_ext_clk_en";
            desc = "Differential clock source select";
            sw = rw;
            hw = r;
            encode = PHY_MODE_LINK0_phy0_rg_ext_clk_en_enum;
            reset = 0x0;
        } phy0_rg_ext_clk_en[20:20];

        enum PHY_MODE_LINK0_phy0_rg_faclk_en_enum {
            DATA_OUTPUT_AT = 0 { name = "Data Output At"; desc = "Data is output at the rising edge of the clock."; };
            DATA_OUTPUT_AT_2 = 1 { name = "Data Output At 2"; desc = "Data is output at the falling edge of the clock."; };
        };

        field {
            name = "phy0_rg_faclk_en";
            desc = "Phase of the associated clock for the PHY output data";
            sw = rw;
            hw = r;
            encode = PHY_MODE_LINK0_phy0_rg_faclk_en_enum;
            reset = 0x0;
        } phy0_rg_faclk_en[16:16];

        enum PHY_MODE_LINK0_phy0_rg_en_lp_enum {
            DISABLED = 0 { name = "Disabled"; desc = "disabled"; };
            ENABLED = 1 { name = "Enabled"; desc = "enabled"; };
        };

        field {
            name = "phy0_rg_en_lp";
            desc = "PHY LP mode enable. The LP mode is enabled in MIPI mode and disabled in other modes.";
            sw = rw;
            hw = r;
            encode = PHY_MODE_LINK0_phy0_rg_en_lp_enum;
            reset = 0x0;
        } phy0_rg_en_lp[12:12];

        enum PHY_MODE_LINK0_phy0_rg_en_cmos_enum {
            DISABLED = 0 { name = "Disabled"; desc = "disabled"; };
            ENABLED = 1 { name = "Enabled"; desc = "enabled"; };
        };

        field {
            name = "phy0_rg_en_cmos";
            desc = "PHY CMOS mode enable";
            sw = rw;
            hw = r;
            encode = PHY_MODE_LINK0_phy0_rg_en_cmos_enum;
            reset = 0x0;
        } phy0_rg_en_cmos[8:8];

        enum PHY_MODE_LINK0_phy0_rg_en_clk_enum {
            DISABLED = 0 { name = "Disabled"; desc = "disabled"; };
            ENABLED = 1 { name = "Enabled"; desc = "enabled"; };
        };

        field {
            name = "phy0_rg_en_clk";
            desc = "Clock lane enable";
            sw = rw;
            hw = r;
            encode = PHY_MODE_LINK0_phy0_rg_en_clk_enum;
            reset = 0x0;
        } phy0_rg_en_clk[4:4];

        enum PHY_MODE_LINK0_phy0_rg_en_d_enum {
            DISABLED = 0 { name = "Disabled"; desc = "disabled"; };
            ENABLED = 1 { name = "Enabled"; desc = "enabled"; };
        };

        field {
            name = "phy0_rg_en_d";
            desc = "Data lane enable";
            sw = rw;
            hw = r;
            encode = PHY_MODE_LINK0_phy0_rg_en_d_enum;
            reset = 0x0;
        } phy0_rg_en_d[3:0];
    } PHY_MODE_LINK0 @ 0x0;

    reg {
        name = "Link 0 PHY channel delay adjustment _LINK0 register";
        desc = "PHY_SKEW_LINK0 is a link 0 PHY channel delay adjustment register. Hi3516A V200 Professional HD IP Camera SoC

Data sheet 9.3.6 PHY_SKEW_LINK0 (offset 0x4, printed page 9-204, `hi3516av200--Hi3516AV200-Datasheet.txt` line 48745).";

        field {
            name = "phy0_d3_skew";
            desc = "Timing delay adjustment for data lane 3. The phase is delayed by about 62.5 ps each time the register value is incremented by 1.";
            sw = rw;
            hw = r;
            reset = 0x0;
        } phy0_d3_skew[18:16];

        field {
            name = "phy0_d2_skew";
            desc = "Timing delay adjustment for data lane 2. The phase is delayed by about 62.5 ps each time the register value is incremented by 1.";
            sw = rw;
            hw = r;
            reset = 0x0;
        } phy0_d2_skew[14:12];

        field {
            name = "phy0_d1_skew";
            desc = "Timing delay adjustment for data lane 1. The phase is delayed by about 62.5 ps each time the register value is incremented by 1.";
            sw = rw;
            hw = r;
            reset = 0x0;
        } phy0_d1_skew[10:8];

        field {
            name = "phy0_d0_skew";
            desc = "Timing delay adjustment for data lane 0. The phase is delayed by about 62.5 ps each time the register value is incremented by 1.";
            sw = rw;
            hw = r;
            reset = 0x0;
        } phy0_d0_skew[6:4];

        field {
            name = "phy0_clk_skew";
            desc = "Timing delay adjustment for the clock lane. The phase is delayed by about 62.5 ps each time the register value is incremented by 1.";
            sw = rw;
            hw = r;
            reset = 0x0;
        } phy0_clk_skew[2:0];
    } PHY_SKEW_LINK0 @ 0x4;

    reg {
        name = "Link 0 PHY channel enable register NK0";
        desc = "PHY_EN_LINK0 is a link 0 PHY channel enable register. Hi3516A V200 Professional HD IP Camera SoC

Data sheet 9.3.6 PHY_EN_LINK0 (offset 0x8, printed page 9-205, `hi3516av200--Hi3516AV200-Datasheet.txt` line 48800).";

        enum PHY_EN_LINK0_phy0_clk_term_en_enum {
            INTERNAL_MATCHED_RESISTOR = 0 { name = "Internal Matched Resistor"; desc = "The internal matched resistor is disabled."; };
            INTERNAL_MATCHED_RESISTOR_2 = 1 { name = "Internal Matched Resistor 2"; desc = "The internal matched resistor is enabled."; };
        };

        field {
            name = "phy0_clk_term_en";
            desc = "Termination matched impedance enable for the clock lane";
            sw = rw;
            hw = r;
            encode = PHY_EN_LINK0_phy0_clk_term_en_enum;
            reset = 0x0;
        } phy0_clk_term_en[8:8];

        enum PHY_EN_LINK0_phy0_d3_term_en_enum {
            INTERNAL_MATCHED_RESISTOR = 0 { name = "Internal Matched Resistor"; desc = "The internal matched resistor is disabled."; };
            INTERNAL_MATCHED_RESISTOR_2 = 1 { name = "Internal Matched Resistor 2"; desc = "The internal matched resistor is enabled."; };
        };

        field {
            name = "phy0_d3_term_en";
            desc = "Termination matched impedance enable for data lane 3";
            sw = rw;
            hw = r;
            encode = PHY_EN_LINK0_phy0_d3_term_en_enum;
            reset = 0x0;
        } phy0_d3_term_en[7:7];

        enum PHY_EN_LINK0_phy0_d2_term_en_enum {
            INTERNAL_MATCHED_RESISTOR = 0 { name = "Internal Matched Resistor"; desc = "The internal matched resistor is disabled."; };
            INTERNAL_MATCHED_RESISTOR_2 = 1 { name = "Internal Matched Resistor 2"; desc = "The internal matched resistor is enabled."; };
        };

        field {
            name = "phy0_d2_term_en";
            desc = "Termination matched impedance enable for data lane 2";
            sw = rw;
            hw = r;
            encode = PHY_EN_LINK0_phy0_d2_term_en_enum;
            reset = 0x0;
        } phy0_d2_term_en[6:6];

        enum PHY_EN_LINK0_phy0_d1_term_en_enum {
            INTERNAL_MATCHED_RESISTOR = 0 { name = "Internal Matched Resistor"; desc = "The internal matched resistor is disabled."; };
            INTERNAL_MATCHED_RESISTOR_2 = 1 { name = "Internal Matched Resistor 2"; desc = "The internal matched resistor is enabled."; };
        };

        field {
            name = "phy0_d1_term_en";
            desc = "Termination matched impedance enable for data lane 1";
            sw = rw;
            hw = r;
            encode = PHY_EN_LINK0_phy0_d1_term_en_enum;
            reset = 0x0;
        } phy0_d1_term_en[5:5];

        enum PHY_EN_LINK0_phy0_d0_term_en_enum {
            INTERNAL_MATCHED_RESISTOR = 0 { name = "Internal Matched Resistor"; desc = "The internal matched resistor is disabled."; };
            INTERNAL_MATCHED_RESISTOR_2 = 1 { name = "Internal Matched Resistor 2"; desc = "The internal matched resistor is enabled."; };
        };

        field {
            name = "phy0_d0_term_en";
            desc = "Termination matched impedance enable for data lane 0";
            sw = rw;
            hw = r;
            encode = PHY_EN_LINK0_phy0_d0_term_en_enum;
            reset = 0x0;
        } phy0_d0_term_en[4:4];

        enum PHY_EN_LINK0_phy0_da_d3_valid_enum {
            DISABLED = 0 { name = "Disabled"; desc = "disabled"; };
            ENABLED = 1 { name = "Enabled"; desc = "enabled"; };
        };

        field {
            name = "phy0_da_d3_valid";
            desc = "High-speed mode enable for data lane 3";
            sw = rw;
            hw = r;
            encode = PHY_EN_LINK0_phy0_da_d3_valid_enum;
            reset = 0x0;
        } phy0_da_d3_valid[3:3];

        enum PHY_EN_LINK0_phy0_da_d2_valid_enum {
            DISABLED = 0 { name = "Disabled"; desc = "disabled"; };
            ENABLED = 1 { name = "Enabled"; desc = "enabled"; };
        };

        field {
            name = "phy0_da_d2_valid";
            desc = "High-speed mode enable for data lane 2";
            sw = rw;
            hw = r;
            encode = PHY_EN_LINK0_phy0_da_d2_valid_enum;
            reset = 0x0;
        } phy0_da_d2_valid[2:2];

        enum PHY_EN_LINK0_phy0_da_d1_valid_enum {
            DISABLED = 0 { name = "Disabled"; desc = "disabled"; };
            ENABLED = 1 { name = "Enabled"; desc = "enabled"; };
        };

        field {
            name = "phy0_da_d1_valid";
            desc = "High-speed mode enable for data lane 1";
            sw = rw;
            hw = r;
            encode = PHY_EN_LINK0_phy0_da_d1_valid_enum;
            reset = 0x0;
        } phy0_da_d1_valid[1:1];

        enum PHY_EN_LINK0_phy0_da_d0_valid_enum {
            DISABLED = 0 { name = "Disabled"; desc = "disabled"; };
            ENABLED = 1 { name = "Enabled"; desc = "enabled"; };
        };

        field {
            name = "phy0_da_d0_valid";
            desc = "High-speed mode enable for data lane 0";
            sw = rw;
            hw = r;
            encode = PHY_EN_LINK0_phy0_da_d0_valid_enum;
            reset = 0x0;
        } phy0_da_d0_valid[0:0];
    } PHY_EN_LINK0 @ 0x8;

    reg {
        name = "PHY configuration LINK0";
        desc = "[inferred] PHY configuration LINK0. Not in the data sheet. Source: OpenIPC openhisilicon `kernel/mipi_rx/hi3519v101/mipi_reg.h` (GPL-3.0 repository, HiSilicon copyright; local copy sources/openhisilicon), union `U_PHY_CFG_LINK`, struct offset 0xC (GPL-3.0 repository, HiSilicon copyright; one header for Hi3519 V101 and Hi3516A V200). Reset value and access type unknown (modelled RW, no reset). Confidence: medium (vendor header for this chip family, not hardware verified).";

        field {
            name = "phy0_rg_sa_en";
            desc = "[inferred] Phy0 rg sa enable. (vendor header `hi3519v101/mipi_reg.h` field `phy0_rg_sa_en`; access and reset unknown, modelled RW)";
            sw = rw;
            hw = r;
        } phy0_rg_sa_en[14:14];

        field {
            name = "phy0_rg_it_dt";
            desc = "[inferred] Phy0 rg it dt. (vendor header `hi3519v101/mipi_reg.h` field `phy0_rg_it_dt`; access and reset unknown, modelled RW)";
            sw = rw;
            hw = r;
        } phy0_rg_it_dt[13:12];

        field {
            name = "phy0_rg_it_ck";
            desc = "[inferred] Phy0 rg it ck. (vendor header `hi3519v101/mipi_reg.h` field `phy0_rg_it_ck`; access and reset unknown, modelled RW)";
            sw = rw;
            hw = r;
        } phy0_rg_it_ck[11:10];

        field {
            name = "phy0_rg_it_lp";
            desc = "[inferred] Phy0 rg it low-power. (vendor header `hi3519v101/mipi_reg.h` field `phy0_rg_it_lp`; access and reset unknown, modelled RW)";
            sw = rw;
            hw = r;
        } phy0_rg_it_lp[9:8];

        field {
            name = "phy0_da_ulpb_ck";
            desc = "[inferred] Phy0 da ulpb ck. (vendor header `hi3519v101/mipi_reg.h` field `phy0_da_ulpb_ck`; access and reset unknown, modelled RW)";
            sw = rw;
            hw = r;
        } phy0_da_ulpb_ck[4:4];

        field {
            name = "phy0_da_ulpb";
            desc = "[inferred] Phy0 da ulpb. (vendor header `hi3519v101/mipi_reg.h` field `phy0_da_ulpb`; access and reset unknown, modelled RW)";
            sw = rw;
            hw = r;
        } phy0_da_ulpb[3:0];
    } PHY_CFG_LINK0 @ 0xC;

    reg {
        name = "Link 0 PHY output parallel data register _LINK0";
        desc = "PHY_DATA_LINK0 is a link 0 PHY output parallel data register.

Data sheet 9.3.6 PHY_DATA_LINK0 (offset 0x18, printed page 9-206, `hi3516av200--Hi3516AV200-Datasheet.txt` line 48863).";

        field {
            name = "phy0_data3_mipi";
            desc = "Data received by data lane 3";
            sw = r;
            hw = w;
            reset = 0x0;
        } phy0_data3_mipi[31:24];

        field {
            name = "phy0_data2_mipi";
            desc = "Data received by data lane 2";
            sw = r;
            hw = w;
            reset = 0x0;
        } phy0_data2_mipi[23:16];

        field {
            name = "phy0_data1_mipi";
            desc = "Data received by data lane 1";
            sw = r;
            hw = w;
            reset = 0x0;
        } phy0_data1_mipi[15:8];

        field {
            name = "phy0_data0_mipi";
            desc = "Data received by data lane 0";
            sw = r;
            hw = w;
            reset = 0x0;
        } phy0_data0_mipi[7:0];
    } PHY_DATA_LINK0 @ 0x18;

    reg {
        name = "Link 0 MIPI data packet header register PI_LINK0";
        desc = "PHY_PH_MIPI_LINK0 is a link 0 MIPI data packet header register.

Data sheet 9.3.6 PHY_PH_MIPI_LINK0 (offset 0x1C, printed page 9-206, `hi3516av200--Hi3516AV200-Datasheet.txt` line 48884).";

        field {
            name = "phy0_ph3_mipi";
            desc = "Data packet header received by data lane 3";
            sw = r;
            hw = w;
            reset = 0x0;
        } phy0_ph3_mipi[31:24];

        field {
            name = "phy0_ph2_mipi";
            desc = "Data packet header received by data lane 2";
            sw = r;
            hw = w;
            reset = 0x0;
        } phy0_ph2_mipi[23:16];

        field {
            name = "phy0_ph1_mipi";
            desc = "Data packet header received by data lane 1";
            sw = r;
            hw = w;
            reset = 0x0;
        } phy0_ph1_mipi[15:8];

        field {
            name = "phy0_ph0_mipi";
            desc = "Data packet header received by data lane 0";
            sw = r;
            hw = w;
            reset = 0x0;
        } phy0_ph0_mipi[7:0];
    } PHY_PH_MIPI_LINK0 @ 0x1C;

    reg {
        name = "Link 0 MIPI mode data register _MIPI_LINK 0";
        desc = "PHY_DATA_MIPI_LINK0 is a link 0 MIPI mode data register.

Data sheet 9.3.6 PHY_DATA_MIPI_LINK0 (offset 0x20, printed page 9-207, `hi3516av200--Hi3516AV200-Datasheet.txt` line 48911).";

        field {
            name = "phy0_data3_mipi_hsphy0_data2_mipi_h";
            desc = "MIPI data for data lane 3";
            sw = r;
            hw = w;
            reset = 0x0;
        } phy0_data3_mipi_hsphy0_data2_mipi_h[31:24];

        field {
            name = "sphy0_data2_mipi_hsphy0_data1_mipi_h";
            desc = "MIPI data for data lane 2";
            sw = r;
            hw = w;
            reset = 0x0;
        } sphy0_data2_mipi_hsphy0_data1_mipi_h[23:16];

        field {
            name = "sphy0_data1_mipi_hsphy0_data0_mipi_h";
            desc = "MIPI data for data lane 1";
            sw = r;
            hw = w;
            reset = 0x0;
        } sphy0_data1_mipi_hsphy0_data0_mipi_h[15:8];

        field {
            name = "sphy0_data0_mipi_hs";
            desc = "MIPI data for data lane 0";
            sw = r;
            hw = w;
            reset = 0x0;
        } sphy0_data0_mipi_hs[7:0];
    } PHY_DATA_MIPI_LINK0 @ 0x20;

    reg {
        name = "Link 0 PHY LVDS mode synchronization _DCT_LINK header detection control register 0";
        desc = "PHY_SYNC_DCT_LINK0 is a link 0 PHY LVDS mode synchronization header detection control register.

Data sheet 9.3.6 PHY_SYNC_DCT_LINK0 (offset 0x24, printed page 9-207, `hi3516av200--Hi3516AV200-Datasheet.txt` line 48942).";

        enum PHY_SYNC_DCT_LINK0_cil0_code_big_endian_enum {
            LSB_LOWER_BITS = 0 { name = "Lsb Lower Bits"; desc = "LSB. The lower bits are transmitted first. The serial data sequence of the received synchronization code is bit 0, bit 1, …, bit 11."; };
            MSB_UPPER_BITS = 1 { name = "Msb Upper Bits"; desc = "MSB. The upper bits are transmitted first. The serial data sequence of the received synchronization code is bit 11, bit 10, …, bit 0."; };
        };

        field {
            name = "cil0_code_big_endian";
            desc = "Serial bit transmission sequence for the synchronization code (sync_code) of the raw data to be transmitted in LVDS or HiSPi mode";
            sw = rw;
            hw = r;
            encode = PHY_SYNC_DCT_LINK0_cil0_code_big_endian_enum;
            reset = 0x1;
        } cil0_code_big_endian[8:8];

        enum PHY_SYNC_DCT_LINK0_cil0_split_mode_enum {
            PER_LANE_MODE = 0 { name = "Per Lane Mode"; desc = "per lane mode"; };
            SPLIT_2_LANE = 3 { name = "Split 2 Lane"; desc = "split-2 lane mode"; };
            SPLIT_4_LANE = 7 { name = "Split 4 Lane"; desc = "split-4 lane mode Other values: reserved"; };
        };

        field {
            name = "cil0_split_mode";
            desc = "Transfer type for the synchronization code in LVDS or HiSPi mode";
            sw = rw;
            hw = r;
            encode = PHY_SYNC_DCT_LINK0_cil0_split_mode_enum;
            reset = 0x0;
        } cil0_split_mode[6:4];

        enum PHY_SYNC_DCT_LINK0_cil0_raw_type_enum {
            V_8_BIT_RAW = 1 { name = "V 8 Bit Raw"; desc = "8-bit raw data"; };
            V_10_BIT_RAW = 2 { name = "V 10 Bit Raw"; desc = "10-bit raw data"; };
            V_12_BIT_RAW = 3 { name = "V 12 Bit Raw"; desc = "12-bit raw data"; };
            V_14_BIT_RAW = 4 { name = "V 14 Bit Raw"; desc = "14-bit raw data"; };
            V_16_BIT_RAW = 5 { name = "V 16 Bit Raw"; desc = "16-bit raw data Other values: reserved"; };
        };

        field {
            name = "cil0_raw_type";
            desc = "Type of the raw data to be transmitted in LVDS or HiSPi mode";
            sw = rw;
            hw = r;
            encode = PHY_SYNC_DCT_LINK0_cil0_raw_type_enum;
            reset = 0x1;
        } cil0_raw_type[2:0];
    } PHY_SYNC_DCT_LINK0 @ 0x24;

    reg {
        name = "Link 0 PHY LVDS mode lane 0 _CODE0_LI synchronization header register. NK0";
        desc = "PHY_SYNC_CODE0_LINK0 is link 0 PHY LVDS mode lane 0 synchronization header register.

Data sheet 9.3.6 PHY_SYNC_CODE0_LINK0 (offset 0x30, printed page 9-208, `hi3516av200--Hi3516AV200-Datasheet.txt` line 49008).";

        field {
            name = "cil0_sof1_word4_0";
            desc = "Lane 0 SOF synchronization code (for frame + 1)";
            sw = rw;
            hw = r;
            reset = 0x0;
        } cil0_sof1_word4_0[31:16];

        field {
            name = "cil0_sof0_word4_0";
            desc = "Lane 0 SOF synchronization code (for frame";
            sw = rw;
            hw = r;
            reset = 0x0;
        } cil0_sof0_word4_0[15:0];
    } PHY_SYNC_CODE0_LINK0 @ 0x30;

    reg {
        name = "Link 0 PHY LVDS mode lane 1 _CODE1_LI synchronization header register. NK0";
        desc = "PHY_SYNC_CODE1_LINK0 is link 0 PHY LVDS mode lane 1 synchronization header register.

Data sheet 9.3.6 PHY_SYNC_CODE1_LINK0 (offset 0x34, printed page 9-209, `hi3516av200--Hi3516AV200-Datasheet.txt` line 49035).";

        field {
            name = "cil0_sof1_word4_1";
            desc = "Lane 1 SOF synchronization code (for frame + 1)";
            sw = rw;
            hw = r;
            reset = 0x0;
        } cil0_sof1_word4_1[31:16];

        field {
            name = "cil0_sof0_word4_1";
            desc = "Lane 1 SOF synchronization code (for frame N)";
            sw = rw;
            hw = r;
            reset = 0x0;
        } cil0_sof0_word4_1[15:0];
    } PHY_SYNC_CODE1_LINK0 @ 0x34;

    reg {
        name = "Link 0 PHY LVDS mode lane 2 _CODE2_LI synchronization header register. NK0";
        desc = "PHY_SYNC_CODE2_LINK0 is link 0 PHY LVDS mode lane 2 synchronization header register.

Data sheet 9.3.6 PHY_SYNC_CODE2_LINK0 (offset 0x38, printed page 9-209, `hi3516av200--Hi3516AV200-Datasheet.txt` line 49056).";

        field {
            name = "cil0_sof1_word4_2";
            desc = "Lane 2 SOF synchronization code (for frame N + 1)";
            sw = rw;
            hw = r;
            reset = 0x0;
        } cil0_sof1_word4_2[31:16];

        field {
            name = "cil0_sof0_word4_2";
            desc = "Lane 2 SOF synchronization code (for frame N)";
            sw = rw;
            hw = r;
            reset = 0x0;
        } cil0_sof0_word4_2[15:0];
    } PHY_SYNC_CODE2_LINK0 @ 0x38;

    reg {
        name = "Link 0 PHY LVDS mode lane 3 _CODE3_LI synchronization header register. NK0";
        desc = "PHY_SYNC_CODE3_LINK0 is link 0 PHY LVDS mode lane 3 synchronization header register. Hi3516A V200 Professional HD IP Camera SoC

Data sheet 9.3.6 PHY_SYNC_CODE3_LINK0 (offset 0x3C, printed page 9-210, `hi3516av200--Hi3516AV200-Datasheet.txt` line 49086).";

        field {
            name = "cil0_sof1_word4_3";
            desc = "Lane 3 SOF synchronization code (for frame N + 1)";
            sw = rw;
            hw = r;
            reset = 0x0;
        } cil0_sof1_word4_3[31:16];

        field {
            name = "cil0_sof0_word4_3";
            desc = "Lane 3 SOF synchronization code (for frame N)";
            sw = rw;
            hw = r;
            reset = 0x0;
        } cil0_sof0_word4_3[15:0];
    } PHY_SYNC_CODE3_LINK0 @ 0x3C;

    reg {
        name = "PHY OUT VALID LINK0";
        desc = "[inferred] PHY OUT VALID LINK0. Not in the data sheet. Source: OpenIPC openhisilicon `kernel/mipi_rx/hi3519v101/mipi_reg.h` (GPL-3.0 repository, HiSilicon copyright; local copy sources/openhisilicon), union `U_PHY_OUT_VALID_LINK`, struct offset 0x40 (GPL-3.0 repository, HiSilicon copyright; one header for Hi3519 V101 and Hi3516A V200). Reset value and access type unknown (modelled RW, no reset). Confidence: medium (vendor header for this chip family, not hardware verified).";

        field {
            name = "cil0_mipi_out_valid";
            desc = "[inferred] Cil0 mipi out valid. (vendor header `hi3519v101/mipi_reg.h` field `cil0_mipi_out_valid`; access and reset unknown, modelled RW)";
            sw = rw;
            hw = r;
        } cil0_mipi_out_valid[7:4];

        field {
            name = "cil0_lvds_out_valid";
            desc = "[inferred] Cil0 lvds out valid. (vendor header `hi3519v101/mipi_reg.h` field `cil0_lvds_out_valid`; access and reset unknown, modelled RW)";
            sw = rw;
            hw = r;
        } cil0_lvds_out_valid[3:0];
    } PHY_OUT_VALID_LINK0 @ 0x40;

    reg {
        name = "PHY DATA LVDS LINK0";
        desc = "[inferred] PHY DATA LVDS LINK0. Not in the data sheet. Source: OpenIPC openhisilicon `kernel/mipi_rx/hi3519v101/mipi_reg.h` (GPL-3.0 repository, HiSilicon copyright; local copy sources/openhisilicon), union `U_PHY_DATA_LVDS_LINK`, struct offset 0x44 (GPL-3.0 repository, HiSilicon copyright; one header for Hi3519 V101 and Hi3516A V200). Reset value and access type unknown (modelled RW, no reset). Confidence: medium (vendor header for this chip family, not hardware verified).";

        field {
            name = "phy0_data3_lvds_hs";
            desc = "[inferred] Phy0 data3 lvds horizontal sync. (vendor header `hi3519v101/mipi_reg.h` field `phy0_data3_lvds_hs`; access and reset unknown, modelled RW)";
            sw = rw;
            hw = r;
        } phy0_data3_lvds_hs[31:24];

        field {
            name = "phy0_data2_lvds_hs";
            desc = "[inferred] Phy0 data2 lvds horizontal sync. (vendor header `hi3519v101/mipi_reg.h` field `phy0_data2_lvds_hs`; access and reset unknown, modelled RW)";
            sw = rw;
            hw = r;
        } phy0_data2_lvds_hs[23:16];

        field {
            name = "phy0_data1_lvds_hs";
            desc = "[inferred] Phy0 data1 lvds horizontal sync. (vendor header `hi3519v101/mipi_reg.h` field `phy0_data1_lvds_hs`; access and reset unknown, modelled RW)";
            sw = rw;
            hw = r;
        } phy0_data1_lvds_hs[15:8];

        field {
            name = "phy0_data0_lvds_hs";
            desc = "[inferred] Phy0 data0 lvds horizontal sync. (vendor header `hi3519v101/mipi_reg.h` field `phy0_data0_lvds_hs`; access and reset unknown, modelled RW)";
            sw = rw;
            hw = r;
        } phy0_data0_lvds_hs[7:0];
    } PHY_DATA_LVDS_LINK0 @ 0x44;

    reg {
        name = "Link 0 MIPI CIL raw interrupt status NT_RAW_LI register NK0";
        desc = "MIPI_CIL_INT_RAW_LINK0 is a link 0 MIPI CIL raw interrupt status register.

Data sheet 9.3.6 MIPI_CIL_INT_RAW_LINK0 (offset 0x1F0, printed page 9-210, `hi3516av200--Hi3516AV200-Datasheet.txt` line 49105).";

        enum MIPI_CIL_INT_RAW_LINK0_err0_timeout_ck_raw_enum {
            NO_RAW_INTERRUPT = 0 { name = "No Raw Interrupt"; desc = "No raw interrupt is generated."; };
            RAW_INTERRUPT_GENERATED = 1 { name = "Raw Interrupt Generated"; desc = "A raw interrupt is generated."; };
        };

        field {
            name = "err0_timeout_ck_raw";
            desc = "Status of the raw FSM timeout interrupt for the clock lane";
            sw = rw;
            hw = w;
            onwrite = woclr;
            encode = MIPI_CIL_INT_RAW_LINK0_err0_timeout_ck_raw_enum;
            reset = 0x0;
        } err0_timeout_ck_raw[12:12];

        enum MIPI_CIL_INT_RAW_LINK0_err0_timeout_d3_raw_enum {
            NO_RAW_INTERRUPT = 0 { name = "No Raw Interrupt"; desc = "No raw interrupt is generated."; };
            RAW_INTERRUPT_GENERATED = 1 { name = "Raw Interrupt Generated"; desc = "A raw interrupt is generated."; };
        };

        field {
            name = "err0_timeout_d3_raw";
            desc = "Status of the raw FSM timeout interrupt for data lane 3";
            sw = rw;
            hw = w;
            onwrite = woclr;
            encode = MIPI_CIL_INT_RAW_LINK0_err0_timeout_d3_raw_enum;
            reset = 0x0;
        } err0_timeout_d3_raw[11:11];

        enum MIPI_CIL_INT_RAW_LINK0_err0_timeout_d2_raw_enum {
            NO_RAW_INTERRUPT = 0 { name = "No Raw Interrupt"; desc = "No raw interrupt is generated."; };
            RAW_INTERRUPT_GENERATED = 1 { name = "Raw Interrupt Generated"; desc = "A raw interrupt is generated."; };
        };

        field {
            name = "err0_timeout_d2_raw";
            desc = "Status of the raw FSM timeout interrupt for data lane 2";
            sw = rw;
            hw = w;
            onwrite = woclr;
            encode = MIPI_CIL_INT_RAW_LINK0_err0_timeout_d2_raw_enum;
            reset = 0x0;
        } err0_timeout_d2_raw[10:10];

        enum MIPI_CIL_INT_RAW_LINK0_err0_timeout_d1_raw_enum {
            NO_RAW_INTERRUPT = 0 { name = "No Raw Interrupt"; desc = "No raw interrupt is generated."; };
            RAW_INTERRUPT_GENERATED = 1 { name = "Raw Interrupt Generated"; desc = "A raw interrupt is generated."; };
        };

        field {
            name = "err0_timeout_d1_raw";
            desc = "Status of the raw FSM timeout interrupt for data lane 1";
            sw = rw;
            hw = w;
            onwrite = woclr;
            encode = MIPI_CIL_INT_RAW_LINK0_err0_timeout_d1_raw_enum;
            reset = 0x0;
        } err0_timeout_d1_raw[9:9];

        enum MIPI_CIL_INT_RAW_LINK0_err0_timeout_d0_raw_enum {
            NO_RAW_INTERRUPT = 0 { name = "No Raw Interrupt"; desc = "No raw interrupt is generated."; };
            RAW_INTERRUPT_GENERATED = 1 { name = "Raw Interrupt Generated"; desc = "A raw interrupt is generated."; };
        };

        field {
            name = "err0_timeout_d0_raw";
            desc = "Status of the raw FSM timeout interrupt for data lane 0";
            sw = rw;
            hw = w;
            onwrite = woclr;
            encode = MIPI_CIL_INT_RAW_LINK0_err0_timeout_d0_raw_enum;
            reset = 0x0;
        } err0_timeout_d0_raw[8:8];

        enum MIPI_CIL_INT_RAW_LINK0_err0_escape_ck_raw_enum {
            NO_RAW_INTERRUPT = 0 { name = "No Raw Interrupt"; desc = "No raw interrupt is generated."; };
            RAW_INTERRUPT_GENERATED = 1 { name = "Raw Interrupt Generated"; desc = "A raw interrupt is generated."; };
        };

        field {
            name = "err0_escape_ck_raw";
            desc = "Status of the raw escape sequence interrupt for the clock lane";
            sw = rw;
            hw = w;
            onwrite = woclr;
            encode = MIPI_CIL_INT_RAW_LINK0_err0_escape_ck_raw_enum;
            reset = 0x0;
        } err0_escape_ck_raw[4:4];

        enum MIPI_CIL_INT_RAW_LINK0_err0_escape_d3_raw_enum {
            NO_RAW_INTERRUPT = 0 { name = "No Raw Interrupt"; desc = "No raw interrupt is generated."; };
            RAW_INTERRUPT_GENERATED = 1 { name = "Raw Interrupt Generated"; desc = "A raw interrupt is generated."; };
        };

        field {
            name = "err0_escape_d3_raw";
            desc = "Status of the raw escape sequence interrupt for data lane 3";
            sw = rw;
            hw = w;
            onwrite = woclr;
            encode = MIPI_CIL_INT_RAW_LINK0_err0_escape_d3_raw_enum;
            reset = 0x0;
        } err0_escape_d3_raw[3:3];

        enum MIPI_CIL_INT_RAW_LINK0_err0_escape_d2_raw_enum {
            NO_RAW_INTERRUPT = 0 { name = "No Raw Interrupt"; desc = "No raw interrupt is generated."; };
            RAW_INTERRUPT_GENERATED = 1 { name = "Raw Interrupt Generated"; desc = "A raw interrupt is generated."; };
        };

        field {
            name = "err0_escape_d2_raw";
            desc = "Status of the raw escape sequence interrupt for data lane 2";
            sw = rw;
            hw = w;
            onwrite = woclr;
            encode = MIPI_CIL_INT_RAW_LINK0_err0_escape_d2_raw_enum;
            reset = 0x0;
        } err0_escape_d2_raw[2:2];

        enum MIPI_CIL_INT_RAW_LINK0_err0_escape_d1_raw_enum {
            NO_RAW_INTERRUPT = 0 { name = "No Raw Interrupt"; desc = "No raw interrupt is generated."; };
            RAW_INTERRUPT_GENERATED = 1 { name = "Raw Interrupt Generated"; desc = "A raw interrupt is generated."; };
        };

        field {
            name = "err0_escape_d1_raw";
            desc = "Status of the raw escape sequence interrupt for data lane 1";
            sw = rw;
            hw = w;
            onwrite = woclr;
            encode = MIPI_CIL_INT_RAW_LINK0_err0_escape_d1_raw_enum;
            reset = 0x0;
        } err0_escape_d1_raw[1:1];

        enum MIPI_CIL_INT_RAW_LINK0_err0_escape_d0_raw_enum {
            NO_RAW_INTERRUPT = 0 { name = "No Raw Interrupt"; desc = "No raw interrupt is generated."; };
            RAW_INTERRUPT_GENERATED = 1 { name = "Raw Interrupt Generated"; desc = "A raw interrupt is generated."; };
        };

        field {
            name = "err0_escape_d0_raw";
            desc = "Status of the raw escape sequence interrupt for data lane 0";
            sw = rw;
            hw = w;
            onwrite = woclr;
            encode = MIPI_CIL_INT_RAW_LINK0_err0_escape_d0_raw_enum;
            reset = 0x0;
        } err0_escape_d0_raw[0:0];
    } MIPI_CIL_INT_RAW_LINK0 @ 0x1F0;

    reg {
        name = "Link 0 MIPI CIL interrupt status register NT_LINK0";
        desc = "MIPI_CIL_INT_LINK0 is a link 0 MIPI CIL interrupt status register. Hi3516A V200 Professional HD IP Camera SoC

Data sheet 9.3.6 MIPI_CIL_INT_LINK0 (offset 0x1F4, printed page 9-212, `hi3516av200--Hi3516AV200-Datasheet.txt` line 49203).";

        enum MIPI_CIL_INT_LINK0_err0_timeout_ck_st_enum {
            NO_INTERRUPT_GENERATED = 0 { name = "No Interrupt Generated"; desc = "No interrupt is generated."; };
            INTERRUPT_GENERATED = 1 { name = "Interrupt Generated"; desc = "An interrupt is generated."; };
        };

        field {
            name = "err0_timeout_ck_st";
            desc = "Status of the FSM timeout interrupt for the clock lane";
            sw = r;
            hw = w;
            encode = MIPI_CIL_INT_LINK0_err0_timeout_ck_st_enum;
            reset = 0x0;
        } err0_timeout_ck_st[12:12];

        enum MIPI_CIL_INT_LINK0_err0_timeout_d3_st_enum {
            NO_INTERRUPT_GENERATED = 0 { name = "No Interrupt Generated"; desc = "No interrupt is generated."; };
            INTERRUPT_GENERATED = 1 { name = "Interrupt Generated"; desc = "An interrupt is generated."; };
        };

        field {
            name = "err0_timeout_d3_st";
            desc = "Status of the FSM timeout interrupt for data lane 3";
            sw = r;
            hw = w;
            encode = MIPI_CIL_INT_LINK0_err0_timeout_d3_st_enum;
            reset = 0x0;
        } err0_timeout_d3_st[11:11];

        enum MIPI_CIL_INT_LINK0_err0_timeout_d2_st_enum {
            NO_INTERRUPT_GENERATED = 0 { name = "No Interrupt Generated"; desc = "No interrupt is generated."; };
            INTERRUPT_GENERATED = 1 { name = "Interrupt Generated"; desc = "An interrupt is generated."; };
        };

        field {
            name = "err0_timeout_d2_st";
            desc = "Status of the FSM timeout interrupt for data lane 2";
            sw = r;
            hw = w;
            encode = MIPI_CIL_INT_LINK0_err0_timeout_d2_st_enum;
            reset = 0x0;
        } err0_timeout_d2_st[10:10];

        enum MIPI_CIL_INT_LINK0_err0_timeout_d1_st_enum {
            NO_INTERRUPT_GENERATED = 0 { name = "No Interrupt Generated"; desc = "No interrupt is generated."; };
            INTERRUPT_GENERATED = 1 { name = "Interrupt Generated"; desc = "An interrupt is generated."; };
        };

        field {
            name = "err0_timeout_d1_st";
            desc = "Status of the FSM timeout interrupt for data lane 1";
            sw = r;
            hw = w;
            encode = MIPI_CIL_INT_LINK0_err0_timeout_d1_st_enum;
            reset = 0x0;
        } err0_timeout_d1_st[9:9];

        enum MIPI_CIL_INT_LINK0_err0_timeout_d0_st_enum {
            NO_INTERRUPT_GENERATED = 0 { name = "No Interrupt Generated"; desc = "No interrupt is generated."; };
            INTERRUPT_GENERATED = 1 { name = "Interrupt Generated"; desc = "An interrupt is generated."; };
        };

        field {
            name = "err0_timeout_d0_st";
            desc = "Status of the FSM timeout interrupt for data lane 0";
            sw = r;
            hw = w;
            encode = MIPI_CIL_INT_LINK0_err0_timeout_d0_st_enum;
            reset = 0x0;
        } err0_timeout_d0_st[8:8];

        enum MIPI_CIL_INT_LINK0_err0_escape_ck_st_enum {
            NO_INTERRUPT_GENERATED = 0 { name = "No Interrupt Generated"; desc = "No interrupt is generated."; };
            INTERRUPT_GENERATED = 1 { name = "Interrupt Generated"; desc = "An interrupt is generated."; };
        };

        field {
            name = "err0_escape_ck_st";
            desc = "Status of the escape sequence interrupt for the clock lane";
            sw = r;
            hw = w;
            encode = MIPI_CIL_INT_LINK0_err0_escape_ck_st_enum;
            reset = 0x0;
        } err0_escape_ck_st[4:4];

        enum MIPI_CIL_INT_LINK0_err0_escape_d3_st_enum {
            NO_INTERRUPT_GENERATED = 0 { name = "No Interrupt Generated"; desc = "No interrupt is generated."; };
            INTERRUPT_GENERATED = 1 { name = "Interrupt Generated"; desc = "An interrupt is generated."; };
        };

        field {
            name = "err0_escape_d3_st";
            desc = "Status of the escape sequence interrupt for data lane 3";
            sw = r;
            hw = w;
            encode = MIPI_CIL_INT_LINK0_err0_escape_d3_st_enum;
            reset = 0x0;
        } err0_escape_d3_st[3:3];

        enum MIPI_CIL_INT_LINK0_err0_escape_d2_st_enum {
            NO_INTERRUPT_GENERATED = 0 { name = "No Interrupt Generated"; desc = "No interrupt is generated."; };
            INTERRUPT_GENERATED = 1 { name = "Interrupt Generated"; desc = "An interrupt is generated."; };
        };

        field {
            name = "err0_escape_d2_st";
            desc = "Status of the escape sequence interrupt for data lane 2";
            sw = r;
            hw = w;
            encode = MIPI_CIL_INT_LINK0_err0_escape_d2_st_enum;
            reset = 0x0;
        } err0_escape_d2_st[2:2];

        enum MIPI_CIL_INT_LINK0_err0_escape_d1_st_enum {
            NO_INTERRUPT_GENERATED = 0 { name = "No Interrupt Generated"; desc = "No interrupt is generated."; };
            INTERRUPT_GENERATED = 1 { name = "Interrupt Generated"; desc = "An interrupt is generated."; };
        };

        field {
            name = "err0_escape_d1_st";
            desc = "Status of the escape sequence interrupt for data lane 1";
            sw = r;
            hw = w;
            encode = MIPI_CIL_INT_LINK0_err0_escape_d1_st_enum;
            reset = 0x0;
        } err0_escape_d1_st[1:1];

        enum MIPI_CIL_INT_LINK0_err0_escape_d0_st_enum {
            NO_INTERRUPT_GENERATED = 0 { name = "No Interrupt Generated"; desc = "No interrupt is generated."; };
            INTERRUPT_GENERATED = 1 { name = "Interrupt Generated"; desc = "An interrupt is generated."; };
        };

        field {
            name = "err0_escape_d0_st";
            desc = "Status of the escape sequence interrupt for data lane 0";
            sw = r;
            hw = w;
            encode = MIPI_CIL_INT_LINK0_err0_escape_d0_st_enum;
            reset = 0x0;
        } err0_escape_d0_st[0:0];
    } MIPI_CIL_INT_LINK0 @ 0x1F4;

    reg {
        name = "Link 0 MIPI CIL interrupt mask register NT_MSK_LI NK0";
        desc = "MIPI_CIL_INT_MSK_LINK0 is a link 0 MIPI CIL interrupt mask register.

Data sheet 9.3.6 MIPI_CIL_INT_MSK_LINK0 (offset 0x1F8, printed page 9-213, `hi3516av200--Hi3516AV200-Datasheet.txt` line 49271).";

        enum MIPI_CIL_INT_MSK_LINK0_err0_timeout_ck_msk_enum {
            MASKED = 0 { name = "Masked"; desc = "masked"; };
            ENABLED = 1 { name = "Enabled"; desc = "enabled"; };
        };

        field {
            name = "err0_timeout_ck_msk";
            desc = "Enable of the FSM timeout interrupt for the clock lane";
            sw = rw;
            hw = r;
            encode = MIPI_CIL_INT_MSK_LINK0_err0_timeout_ck_msk_enum;
            reset = 0x0;
        } err0_timeout_ck_msk[12:12];

        enum MIPI_CIL_INT_MSK_LINK0_err0_timeout_d3_msk_enum {
            MASKED = 0 { name = "Masked"; desc = "masked"; };
            ENABLED = 1 { name = "Enabled"; desc = "enabled"; };
        };

        field {
            name = "err0_timeout_d3_msk";
            desc = "Enable of the FSM timeout interrupt for data lane 3";
            sw = rw;
            hw = r;
            encode = MIPI_CIL_INT_MSK_LINK0_err0_timeout_d3_msk_enum;
            reset = 0x0;
        } err0_timeout_d3_msk[11:11];

        enum MIPI_CIL_INT_MSK_LINK0_err0_timeout_d2_msk_enum {
            MASKED = 0 { name = "Masked"; desc = "masked"; };
            ENABLED = 1 { name = "Enabled"; desc = "enabled"; };
        };

        field {
            name = "err0_timeout_d2_msk";
            desc = "Enable of the FSM timeout interrupt for data lane 2";
            sw = rw;
            hw = r;
            encode = MIPI_CIL_INT_MSK_LINK0_err0_timeout_d2_msk_enum;
            reset = 0x0;
        } err0_timeout_d2_msk[10:10];

        enum MIPI_CIL_INT_MSK_LINK0_err0_timeout_d1_msk_enum {
            MASKED = 0 { name = "Masked"; desc = "masked"; };
            ENABLED = 1 { name = "Enabled"; desc = "enabled"; };
        };

        field {
            name = "err0_timeout_d1_msk";
            desc = "Enable of the FSM timeout interrupt for data lane 1";
            sw = rw;
            hw = r;
            encode = MIPI_CIL_INT_MSK_LINK0_err0_timeout_d1_msk_enum;
            reset = 0x0;
        } err0_timeout_d1_msk[9:9];

        enum MIPI_CIL_INT_MSK_LINK0_err0_timeout_d0_msk_enum {
            MASKED = 0 { name = "Masked"; desc = "masked"; };
            ENABLED = 1 { name = "Enabled"; desc = "enabled"; };
        };

        field {
            name = "err0_timeout_d0_msk";
            desc = "Enable of the FSM timeout interrupt for data lane 0";
            sw = rw;
            hw = r;
            encode = MIPI_CIL_INT_MSK_LINK0_err0_timeout_d0_msk_enum;
            reset = 0x0;
        } err0_timeout_d0_msk[8:8];

        enum MIPI_CIL_INT_MSK_LINK0_err0_escape_ck_msk_enum {
            MASKED = 0 { name = "Masked"; desc = "masked"; };
            ENABLED = 1 { name = "Enabled"; desc = "enabled"; };
        };

        field {
            name = "err0_escape_ck_msk";
            desc = "Enable of the escape sequence interrupt for the clock lane";
            sw = rw;
            hw = r;
            encode = MIPI_CIL_INT_MSK_LINK0_err0_escape_ck_msk_enum;
            reset = 0x0;
        } err0_escape_ck_msk[4:4];

        enum MIPI_CIL_INT_MSK_LINK0_err0_escape_d3_msk_enum {
            MASKED = 0 { name = "Masked"; desc = "masked"; };
            ENABLED = 1 { name = "Enabled"; desc = "enabled"; };
        };

        field {
            name = "err0_escape_d3_msk";
            desc = "Enable of the escape sequence interrupt for data lane 3";
            sw = rw;
            hw = r;
            encode = MIPI_CIL_INT_MSK_LINK0_err0_escape_d3_msk_enum;
            reset = 0x0;
        } err0_escape_d3_msk[3:3];

        enum MIPI_CIL_INT_MSK_LINK0_err0_escape_d2_msk_enum {
            MASKED = 0 { name = "Masked"; desc = "masked"; };
            ENABLED = 1 { name = "Enabled"; desc = "enabled"; };
        };

        field {
            name = "err0_escape_d2_msk";
            desc = "Enable of the escape sequence interrupt for data lane 2";
            sw = rw;
            hw = r;
            encode = MIPI_CIL_INT_MSK_LINK0_err0_escape_d2_msk_enum;
            reset = 0x0;
        } err0_escape_d2_msk[2:2];

        enum MIPI_CIL_INT_MSK_LINK0_err0_escape_d1_msk_enum {
            MASKED = 0 { name = "Masked"; desc = "masked"; };
            ENABLED = 1 { name = "Enabled"; desc = "enabled"; };
        };

        field {
            name = "err0_escape_d1_msk";
            desc = "Enable of the escape sequence interrupt for data lane 1";
            sw = rw;
            hw = r;
            encode = MIPI_CIL_INT_MSK_LINK0_err0_escape_d1_msk_enum;
            reset = 0x0;
        } err0_escape_d1_msk[1:1];

        enum MIPI_CIL_INT_MSK_LINK0_err0_escape_d0_msk_enum {
            MASKED = 0 { name = "Masked"; desc = "masked"; };
            ENABLED = 1 { name = "Enabled"; desc = "enabled"; };
        };

        field {
            name = "err0_escape_d0_msk";
            desc = "Enable of the escape sequence interrupt for data lane 0";
            sw = rw;
            hw = r;
            encode = MIPI_CIL_INT_MSK_LINK0_err0_escape_d0_msk_enum;
            reset = 0x0;
        } err0_escape_d0_msk[0:0];
    } MIPI_CIL_INT_MSK_LINK0 @ 0x1F8;

    reg {
        name = "Link 1 PHY operating mode register _LINK1";
        desc = "PHY_MODE_LINK1 is a link 1 PHY operating mode register. Hi3516A V200 Professional HD IP Camera SoC

Data sheet 9.3.6 PHY_MODE_LINK1 (offset 0x200, printed page 9-215, `hi3516av200--Hi3516AV200-Datasheet.txt` line 49368).";

        enum PHY_MODE_LINK1_phy1_rg_mipi_mode_enum {
            COMMON_VOLTAGE_HIGHER = 0 { name = "Common Voltage Higher"; desc = "The common voltage is higher than 1.25 V."; };
            COMMON_VOLTAGE_1 = 1 { name = "Common Voltage 1"; desc = "The common voltage is 1.25 V or lower."; };
        };

        field {
            name = "phy1_rg_mipi_mode";
            desc = "MIPI/LVDS input mode select. This field is set to 0 when the PHY works in LVDS mode and the common voltage is greater than or equal to 1.25 V.";
            sw = rw;
            hw = r;
            encode = PHY_MODE_LINK1_phy1_rg_mipi_mode_enum;
            reset = 0x0;
        } phy1_rg_mipi_mode[24:24];

        enum PHY_MODE_LINK1_phy1_rg_ext_clk_en_enum {
            PAD_INPUT_DIFFERENTIAL = 0 { name = "Pad Input Differential"; desc = "PAD input differential clock"; };
            DIFFERENTIAL_CLOCK_OTHER = 1 { name = "Differential Clock Other"; desc = "differential clock of other links"; };
        };

        field {
            name = "phy1_rg_ext_clk_en";
            desc = "Differential clock source select";
            sw = rw;
            hw = r;
            encode = PHY_MODE_LINK1_phy1_rg_ext_clk_en_enum;
            reset = 0x0;
        } phy1_rg_ext_clk_en[20:20];

        enum PHY_MODE_LINK1_phy1_rg_faclk_en_enum {
            DATA_OUTPUT_AT = 0 { name = "Data Output At"; desc = "Data is output at the rising edge of the clock."; };
            DATA_OUTPUT_AT_2 = 1 { name = "Data Output At 2"; desc = "Data is output at the falling edge of the clock."; };
        };

        field {
            name = "phy1_rg_faclk_en";
            desc = "Phase of the associated clock for the PHY output data";
            sw = rw;
            hw = r;
            encode = PHY_MODE_LINK1_phy1_rg_faclk_en_enum;
            reset = 0x0;
        } phy1_rg_faclk_en[16:16];

        enum PHY_MODE_LINK1_phy1_rg_en_lp_enum {
            DISABLED = 0 { name = "Disabled"; desc = "disabled"; };
            ENABLED = 1 { name = "Enabled"; desc = "enabled"; };
        };

        field {
            name = "phy1_rg_en_lp";
            desc = "PHY LP mode enable. The LP mode is enabled in MIPI mode and disabled in other modes.";
            sw = rw;
            hw = r;
            encode = PHY_MODE_LINK1_phy1_rg_en_lp_enum;
            reset = 0x0;
        } phy1_rg_en_lp[12:12];

        enum PHY_MODE_LINK1_phy1_rg_en_cmos_enum {
            DISABLED = 0 { name = "Disabled"; desc = "disabled"; };
            ENABLED = 1 { name = "Enabled"; desc = "enabled"; };
        };

        field {
            name = "phy1_rg_en_cmos";
            desc = "PHY CMOS mode enable";
            sw = rw;
            hw = r;
            encode = PHY_MODE_LINK1_phy1_rg_en_cmos_enum;
            reset = 0x0;
        } phy1_rg_en_cmos[8:8];

        enum PHY_MODE_LINK1_phy1_rg_en_clk_enum {
            DISABLED = 0 { name = "Disabled"; desc = "disabled"; };
            ENABLED = 1 { name = "Enabled"; desc = "enabled"; };
        };

        field {
            name = "phy1_rg_en_clk";
            desc = "Clock lane enable";
            sw = rw;
            hw = r;
            encode = PHY_MODE_LINK1_phy1_rg_en_clk_enum;
            reset = 0x0;
        } phy1_rg_en_clk[4:4];

        enum PHY_MODE_LINK1_phy1_rg_en_d_enum {
            DISABLED = 0 { name = "Disabled"; desc = "disabled"; };
            ENABLED = 1 { name = "Enabled"; desc = "enabled"; };
        };

        field {
            name = "phy1_rg_en_d";
            desc = "Data lane enable";
            sw = rw;
            hw = r;
            encode = PHY_MODE_LINK1_phy1_rg_en_d_enum;
            reset = 0x0;
        } phy1_rg_en_d[3:0];
    } PHY_MODE_LINK1 @ 0x200;

    reg {
        name = "Link 1 PHY channel delay adjustment _LINK1 register";
        desc = "PHY_SKEW_LINK1 is a link 1 PHY channel delay adjustment register.

Data sheet 9.3.6 PHY_SKEW_LINK1 (offset 0x204, printed page 9-216, `hi3516av200--Hi3516AV200-Datasheet.txt` line 49440).";

        field {
            name = "phy1_d3_skew";
            desc = "Timing delay adjustment for data lane 3. The phase is delayed by about 62.5 ps each time the register value is incremented by 1.";
            sw = rw;
            hw = r;
            reset = 0x0;
        } phy1_d3_skew[18:16];

        field {
            name = "phy1_d2_skew";
            desc = "Timing delay adjustment for data lane 2. The phase is delayed by about 62.5 ps each time the register value is incremented by 1.";
            sw = rw;
            hw = r;
            reset = 0x0;
        } phy1_d2_skew[14:12];

        field {
            name = "phy1_d1_skew";
            desc = "Timing delay adjustment for data lane 1. The phase is delayed by about 62.5 ps each time the register value is incremented by 1.";
            sw = rw;
            hw = r;
            reset = 0x0;
        } phy1_d1_skew[10:8];

        field {
            name = "phy1_d0_skew";
            desc = "Timing delay adjustment for data lane 0. The phase is delayed by about 62.5 ps each time the register value is incremented by 1.";
            sw = rw;
            hw = r;
            reset = 0x0;
        } phy1_d0_skew[6:4];

        field {
            name = "phy1_clk_skew";
            desc = "Timing delay adjustment for the clock lane. The phase is delayed by about 62.5 ps each time the register value is incremented by 1.";
            sw = rw;
            hw = r;
            reset = 0x0;
        } phy1_clk_skew[2:0];
    } PHY_SKEW_LINK1 @ 0x204;

    reg {
        name = "Link 1 PHY channel enable register NK1";
        desc = "PHY_EN_LINK1 is a link 1 PHY channel enable register.

Data sheet 9.3.6 PHY_EN_LINK1 (offset 0x208, printed page 9-217, `hi3516av200--Hi3516AV200-Datasheet.txt` line 49490).";

        enum PHY_EN_LINK1_phy1_clk_term_en_enum {
            INTERNAL_MATCHED_RESISTOR = 0 { name = "Internal Matched Resistor"; desc = "The internal matched resistor is disabled."; };
            INTERNAL_MATCHED_RESISTOR_2 = 1 { name = "Internal Matched Resistor 2"; desc = "The internal matched resistor is enabled."; };
        };

        field {
            name = "phy1_clk_term_en";
            desc = "Termination matched impedance enable for the clock lane";
            sw = rw;
            hw = r;
            encode = PHY_EN_LINK1_phy1_clk_term_en_enum;
            reset = 0x0;
        } phy1_clk_term_en[8:8];

        enum PHY_EN_LINK1_phy1_d3_term_en_enum {
            INTERNAL_MATCHED_RESISTOR = 0 { name = "Internal Matched Resistor"; desc = "The internal matched resistor is disabled."; };
            INTERNAL_MATCHED_RESISTOR_2 = 1 { name = "Internal Matched Resistor 2"; desc = "The internal matched resistor is enabled."; };
        };

        field {
            name = "phy1_d3_term_en";
            desc = "Termination matched impedance enable for data lane 3";
            sw = rw;
            hw = r;
            encode = PHY_EN_LINK1_phy1_d3_term_en_enum;
            reset = 0x0;
        } phy1_d3_term_en[7:7];

        enum PHY_EN_LINK1_phy1_d2_term_en_enum {
            INTERNAL_MATCHED_RESISTOR = 0 { name = "Internal Matched Resistor"; desc = "The internal matched resistor is disabled."; };
            INTERNAL_MATCHED_RESISTOR_2 = 1 { name = "Internal Matched Resistor 2"; desc = "The internal matched resistor is enabled."; };
        };

        field {
            name = "phy1_d2_term_en";
            desc = "Termination matched impedance enable for data lane 2";
            sw = rw;
            hw = r;
            encode = PHY_EN_LINK1_phy1_d2_term_en_enum;
            reset = 0x0;
        } phy1_d2_term_en[6:6];

        enum PHY_EN_LINK1_phy1_d1_term_en_enum {
            INTERNAL_MATCHED_RESISTOR = 0 { name = "Internal Matched Resistor"; desc = "The internal matched resistor is disabled."; };
            INTERNAL_MATCHED_RESISTOR_2 = 1 { name = "Internal Matched Resistor 2"; desc = "The internal matched resistor is enabled."; };
        };

        field {
            name = "phy1_d1_term_en";
            desc = "Termination matched impedance enable for data lane 1";
            sw = rw;
            hw = r;
            encode = PHY_EN_LINK1_phy1_d1_term_en_enum;
            reset = 0x0;
        } phy1_d1_term_en[5:5];

        enum PHY_EN_LINK1_phy1_d0_term_en_enum {
            INTERNAL_MATCHED_RESISTOR = 0 { name = "Internal Matched Resistor"; desc = "The internal matched resistor is disabled."; };
            INTERNAL_MATCHED_RESISTOR_2 = 1 { name = "Internal Matched Resistor 2"; desc = "The internal matched resistor is enabled."; };
        };

        field {
            name = "phy1_d0_term_en";
            desc = "Termination matched impedance enable for data lane 0";
            sw = rw;
            hw = r;
            encode = PHY_EN_LINK1_phy1_d0_term_en_enum;
            reset = 0x0;
        } phy1_d0_term_en[4:4];

        enum PHY_EN_LINK1_phy1_da_d3_valid_enum {
            DISABLED = 0 { name = "Disabled"; desc = "disabled"; };
            ENABLED = 1 { name = "Enabled"; desc = "enabled"; };
        };

        field {
            name = "phy1_da_d3_valid";
            desc = "High-speed mode enable for data lane 3";
            sw = rw;
            hw = r;
            encode = PHY_EN_LINK1_phy1_da_d3_valid_enum;
            reset = 0x0;
        } phy1_da_d3_valid[3:3];

        enum PHY_EN_LINK1_phy1_da_d2_valid_enum {
            DISABLED = 0 { name = "Disabled"; desc = "disabled"; };
            ENABLED = 1 { name = "Enabled"; desc = "enabled"; };
        };

        field {
            name = "phy1_da_d2_valid";
            desc = "High-speed mode enable for data lane 2";
            sw = rw;
            hw = r;
            encode = PHY_EN_LINK1_phy1_da_d2_valid_enum;
            reset = 0x0;
        } phy1_da_d2_valid[2:2];

        enum PHY_EN_LINK1_phy1_da_d1_valid_enum {
            DISABLED = 0 { name = "Disabled"; desc = "disabled"; };
            ENABLED = 1 { name = "Enabled"; desc = "enabled"; };
        };

        field {
            name = "phy1_da_d1_valid";
            desc = "High-speed mode enable for data lane 1";
            sw = rw;
            hw = r;
            encode = PHY_EN_LINK1_phy1_da_d1_valid_enum;
            reset = 0x0;
        } phy1_da_d1_valid[1:1];

        enum PHY_EN_LINK1_phy1_da_d0_valid_enum {
            DISABLED = 0 { name = "Disabled"; desc = "disabled"; };
            ENABLED = 1 { name = "Enabled"; desc = "enabled"; };
        };

        field {
            name = "phy1_da_d0_valid";
            desc = "High-speed mode enable for data lane 0";
            sw = rw;
            hw = r;
            encode = PHY_EN_LINK1_phy1_da_d0_valid_enum;
            reset = 0x0;
        } phy1_da_d0_valid[0:0];
    } PHY_EN_LINK1 @ 0x208;

    reg {
        name = "PHY configuration LINK1";
        desc = "[inferred] PHY configuration LINK1. Not in the data sheet. Source: OpenIPC openhisilicon `kernel/mipi_rx/hi3519v101/mipi_reg.h` (GPL-3.0 repository, HiSilicon copyright; local copy sources/openhisilicon), union `U_PHY_CFG_LINK`, struct offset 0x20C (GPL-3.0 repository, HiSilicon copyright; one header for Hi3519 V101 and Hi3516A V200). Reset value and access type unknown (modelled RW, no reset). Confidence: medium (vendor header for this chip family, not hardware verified).";

        field {
            name = "phy0_rg_sa_en";
            desc = "[inferred] Phy0 rg sa enable. (vendor header `hi3519v101/mipi_reg.h` field `phy0_rg_sa_en`; access and reset unknown, modelled RW)";
            sw = rw;
            hw = r;
        } phy0_rg_sa_en[14:14];

        field {
            name = "phy0_rg_it_dt";
            desc = "[inferred] Phy0 rg it dt. (vendor header `hi3519v101/mipi_reg.h` field `phy0_rg_it_dt`; access and reset unknown, modelled RW)";
            sw = rw;
            hw = r;
        } phy0_rg_it_dt[13:12];

        field {
            name = "phy0_rg_it_ck";
            desc = "[inferred] Phy0 rg it ck. (vendor header `hi3519v101/mipi_reg.h` field `phy0_rg_it_ck`; access and reset unknown, modelled RW)";
            sw = rw;
            hw = r;
        } phy0_rg_it_ck[11:10];

        field {
            name = "phy0_rg_it_lp";
            desc = "[inferred] Phy0 rg it low-power. (vendor header `hi3519v101/mipi_reg.h` field `phy0_rg_it_lp`; access and reset unknown, modelled RW)";
            sw = rw;
            hw = r;
        } phy0_rg_it_lp[9:8];

        field {
            name = "phy0_da_ulpb_ck";
            desc = "[inferred] Phy0 da ulpb ck. (vendor header `hi3519v101/mipi_reg.h` field `phy0_da_ulpb_ck`; access and reset unknown, modelled RW)";
            sw = rw;
            hw = r;
        } phy0_da_ulpb_ck[4:4];

        field {
            name = "phy0_da_ulpb";
            desc = "[inferred] Phy0 da ulpb. (vendor header `hi3519v101/mipi_reg.h` field `phy0_da_ulpb`; access and reset unknown, modelled RW)";
            sw = rw;
            hw = r;
        } phy0_da_ulpb[3:0];
    } PHY_CFG_LINK1 @ 0x20C;

    reg {
        name = "Link 1 PHY output parallel data register _LINK1";
        desc = "PHY_DATA_LINK1 is a link 1 PHY output parallel data register.

Data sheet 9.3.6 PHY_DATA_LINK1 (offset 0x218, printed page 9-218, `hi3516av200--Hi3516AV200-Datasheet.txt` line 49553).";

        field {
            name = "phy1_data3_mipi";
            desc = "Data received by data lane 3";
            sw = r;
            hw = w;
            reset = 0x0;
        } phy1_data3_mipi[31:24];

        field {
            name = "phy1_data2_mipi";
            desc = "Data received by data lane 2";
            sw = r;
            hw = w;
            reset = 0x0;
        } phy1_data2_mipi[23:16];

        field {
            name = "phy1_data1_mipi";
            desc = "Data received by data lane 1";
            sw = r;
            hw = w;
            reset = 0x0;
        } phy1_data1_mipi[15:8];

        field {
            name = "phy1_data0_mipi";
            desc = "Data received by data lane 0";
            sw = r;
            hw = w;
            reset = 0x0;
        } phy1_data0_mipi[7:0];
    } PHY_DATA_LINK1 @ 0x218;

    reg {
        name = "Link 1 MIPI data packet header register PI_LINK1";
        desc = "PHY_PH_MIPI_LINK1 is a link 1 MIPI data packet header register.

Data sheet 9.3.6 PHY_PH_MIPI_LINK1 (offset 0x21C, printed page 9-218, `hi3516av200--Hi3516AV200-Datasheet.txt` line 49575).";

        field {
            name = "phy1_ph3_mipi";
            desc = "Data packet header received by data lane 3";
            sw = r;
            hw = w;
            reset = 0x0;
        } phy1_ph3_mipi[31:24];

        field {
            name = "phy1_ph2_mipi";
            desc = "Data packet header received by data lane 2";
            sw = r;
            hw = w;
            reset = 0x0;
        } phy1_ph2_mipi[23:16];

        field {
            name = "phy1_ph1_mipi";
            desc = "Data packet header received by data lane 1";
            sw = r;
            hw = w;
            reset = 0x0;
        } phy1_ph1_mipi[15:8];

        field {
            name = "phy1_ph0_mipi";
            desc = "Data packet header received by data lane 0";
            sw = r;
            hw = w;
            reset = 0x0;
        } phy1_ph0_mipi[7:0];
    } PHY_PH_MIPI_LINK1 @ 0x21C;

    reg {
        name = "Link 1 MIPI mode data register _MIPI_LINK 1";
        desc = "PHY_DATA_MIPI_LINK1 is a link 1 MIPI mode data register.

Data sheet 9.3.6 PHY_DATA_MIPI_LINK1 (offset 0x220, printed page 9-219, `hi3516av200--Hi3516AV200-Datasheet.txt` line 49604).";

        field {
            name = "phy1_data3_mipi_hsphy1_data2_mipi_h";
            desc = "MIPI data for data lane 3";
            sw = r;
            hw = w;
            reset = 0x0;
        } phy1_data3_mipi_hsphy1_data2_mipi_h[31:24];

        field {
            name = "sphy1_data2_mipi_hsphy1_data1_mipi_h";
            desc = "MIPI data for data lane 2";
            sw = r;
            hw = w;
            reset = 0x0;
        } sphy1_data2_mipi_hsphy1_data1_mipi_h[23:16];

        field {
            name = "sphy1_data1_mipi_hsphy1_data0_mipi_h";
            desc = "MIPI data for data lane 1";
            sw = r;
            hw = w;
            reset = 0x0;
        } sphy1_data1_mipi_hsphy1_data0_mipi_h[15:8];

        field {
            name = "sphy1_data0_mipi_hs";
            desc = "MIPI data for data lane 0";
            sw = r;
            hw = w;
            reset = 0x0;
        } sphy1_data0_mipi_hs[7:0];
    } PHY_DATA_MIPI_LINK1 @ 0x220;

    reg {
        name = "Link 1 PHY LVDS mode synchronization _DCT_LINK header detection control register 1";
        desc = "PHY_SYNC_DCT_LINK1 is a link 1 PHY LVDS mode synchronization header detection control register.

Data sheet 9.3.6 PHY_SYNC_DCT_LINK1 (offset 0x224, printed page 9-219, `hi3516av200--Hi3516AV200-Datasheet.txt` line 49635).";

        enum PHY_SYNC_DCT_LINK1_cil1_code_big_endian_enum {
            LSB_LOWER_BITS = 0 { name = "Lsb Lower Bits"; desc = "LSB. The lower bits are transmitted first. The serial data sequence of the received synchronization code is bit 0, bit 1, …, bit 11."; };
            MSB_UPPER_BITS = 1 { name = "Msb Upper Bits"; desc = "MSB. The upper bits are transmitted first. The serial data sequence of the received synchronization code is bit 11, bit 10, …, bit 0."; };
        };

        field {
            name = "cil1_code_big_endian";
            desc = "Serial bit transmission sequence for the synchronization code (sync_code) of the raw data to be transmitted in LVDS or HiSPi mode";
            sw = rw;
            hw = r;
            encode = PHY_SYNC_DCT_LINK1_cil1_code_big_endian_enum;
            reset = 0x1;
        } cil1_code_big_endian[8:8];

        enum PHY_SYNC_DCT_LINK1_cil1_split_mode_enum {
            PER_LANE_MODE = 0 { name = "Per Lane Mode"; desc = "per lane mode"; };
            SPLIT_2_LANE = 3 { name = "Split 2 Lane"; desc = "split-2 lane mode"; };
            SPLIT_4_LANE = 7 { name = "Split 4 Lane"; desc = "split-4 lane mode Other values: reserved"; };
        };

        field {
            name = "cil1_split_mode";
            desc = "Transfer type for the synchronization code in LVDS or HiSPi mode";
            sw = rw;
            hw = r;
            encode = PHY_SYNC_DCT_LINK1_cil1_split_mode_enum;
            reset = 0x0;
        } cil1_split_mode[6:4];

        enum PHY_SYNC_DCT_LINK1_cil1_raw_type_enum {
            V_8_BIT_RAW = 1 { name = "V 8 Bit Raw"; desc = "8-bit raw data"; };
            V_10_BIT_RAW = 2 { name = "V 10 Bit Raw"; desc = "10-bit raw data"; };
            V_12_BIT_RAW = 3 { name = "V 12 Bit Raw"; desc = "12-bit raw data"; };
            V_14_BIT_RAW = 4 { name = "V 14 Bit Raw"; desc = "14-bit raw data"; };
            V_16_BIT_RAW = 5 { name = "V 16 Bit Raw"; desc = "16-bit raw data Other values: reserved"; };
        };

        field {
            name = "cil1_raw_type";
            desc = "Type of the raw data to be transmitted in LVDS or HiSPi mode";
            sw = rw;
            hw = r;
            encode = PHY_SYNC_DCT_LINK1_cil1_raw_type_enum;
            reset = 0x1;
        } cil1_raw_type[2:0];
    } PHY_SYNC_DCT_LINK1 @ 0x224;

    reg {
        name = "Link 1 PHY LVDS mode lane 0 _CODE0_LI synchronization header register. NK1";
        desc = "PHY_SYNC_CODE0_LINK1 is link 1 PHY LVDS mode lane 0 synchronization header register.

Data sheet 9.3.6 PHY_SYNC_CODE0_LINK1 (offset 0x230, printed page 9-220, `hi3516av200--Hi3516AV200-Datasheet.txt` line 49700).";

        field {
            name = "cil1_sof1_word4_0";
            desc = "Lane 0 SOF synchronization code (for frame + 1)";
            sw = rw;
            hw = r;
            reset = 0x0;
        } cil1_sof1_word4_0[31:16];

        field {
            name = "cil1_sof0_word4_0";
            desc = "Lane 0 SOF synchronization code (for frame";
            sw = rw;
            hw = r;
            reset = 0x0;
        } cil1_sof0_word4_0[15:0];
    } PHY_SYNC_CODE0_LINK1 @ 0x230;

    reg {
        name = "Link 1 PHY LVDS mode lane 1 _CODE1_LI synchronization header register. NK1";
        desc = "PHY_SYNC_CODE1_LINK1 is link 1 PHY LVDS mode lane 1 synchronization header register.

Data sheet 9.3.6 PHY_SYNC_CODE1_LINK1 (offset 0x234, printed page 9-221, `hi3516av200--Hi3516AV200-Datasheet.txt` line 49727).";

        field {
            name = "cil1_sof1_word4_1";
            desc = "Lane 1 SOF synchronization code (for frame + 1)";
            sw = rw;
            hw = r;
            reset = 0x0;
        } cil1_sof1_word4_1[31:16];

        field {
            name = "cil1_sof0_word4_1";
            desc = "Lane 1 SOF synchronization code (for frame N)";
            sw = rw;
            hw = r;
            reset = 0x0;
        } cil1_sof0_word4_1[15:0];
    } PHY_SYNC_CODE1_LINK1 @ 0x234;

    reg {
        name = "Link 1 PHY LVDS mode lane 2 _CODE2_LI synchronization header register. NK1";
        desc = "PHY_SYNC_CODE2_LINK1 is link 1 PHY LVDS lane 2 mode synchronization header register.

Data sheet 9.3.6 PHY_SYNC_CODE2_LINK1 (offset 0x238, printed page 9-221, `hi3516av200--Hi3516AV200-Datasheet.txt` line 49748).";

        field {
            name = "cil1_sof1_word4_2";
            desc = "Lane 2 SOF synchronization code (for frame N + 1)";
            sw = rw;
            hw = r;
            reset = 0x0;
        } cil1_sof1_word4_2[31:16];

        field {
            name = "cil1_sof0_word4_2";
            desc = "Lane 2 SOF synchronization code (for frame N)";
            sw = rw;
            hw = r;
            reset = 0x0;
        } cil1_sof0_word4_2[15:0];
    } PHY_SYNC_CODE2_LINK1 @ 0x238;

    reg {
        name = "Link 1 PHY LVDS mode lane 3 _CODE3_LI synchronization header register. NK1";
        desc = "PHY_SYNC_CODE3_LINK1 is link 1 PHY LVDS lane 3 mode synchronization header register. Hi3516A V200 Professional HD IP Camera SoC

Data sheet 9.3.6 PHY_SYNC_CODE3_LINK1 (offset 0x23C, printed page 9-222, `hi3516av200--Hi3516AV200-Datasheet.txt` line 49778).";

        field {
            name = "cil1_sof1_word4_3";
            desc = "Lane 3 SOF synchronization code (for frame N + 1)";
            sw = rw;
            hw = r;
            reset = 0x0;
        } cil1_sof1_word4_3[31:16];

        field {
            name = "cil1_sof0_word4_3";
            desc = "Lane 3 SOF synchronization code (for frame N)";
            sw = rw;
            hw = r;
            reset = 0x0;
        } cil1_sof0_word4_3[15:0];
    } PHY_SYNC_CODE3_LINK1 @ 0x23C;

    reg {
        name = "PHY OUT VALID LINK1";
        desc = "[inferred] PHY OUT VALID LINK1. Not in the data sheet. Source: OpenIPC openhisilicon `kernel/mipi_rx/hi3519v101/mipi_reg.h` (GPL-3.0 repository, HiSilicon copyright; local copy sources/openhisilicon), union `U_PHY_OUT_VALID_LINK`, struct offset 0x240 (GPL-3.0 repository, HiSilicon copyright; one header for Hi3519 V101 and Hi3516A V200). Reset value and access type unknown (modelled RW, no reset). Confidence: medium (vendor header for this chip family, not hardware verified).";

        field {
            name = "cil0_mipi_out_valid";
            desc = "[inferred] Cil0 mipi out valid. (vendor header `hi3519v101/mipi_reg.h` field `cil0_mipi_out_valid`; access and reset unknown, modelled RW)";
            sw = rw;
            hw = r;
        } cil0_mipi_out_valid[7:4];

        field {
            name = "cil0_lvds_out_valid";
            desc = "[inferred] Cil0 lvds out valid. (vendor header `hi3519v101/mipi_reg.h` field `cil0_lvds_out_valid`; access and reset unknown, modelled RW)";
            sw = rw;
            hw = r;
        } cil0_lvds_out_valid[3:0];
    } PHY_OUT_VALID_LINK1 @ 0x240;

    reg {
        name = "PHY DATA LVDS LINK1";
        desc = "[inferred] PHY DATA LVDS LINK1. Not in the data sheet. Source: OpenIPC openhisilicon `kernel/mipi_rx/hi3519v101/mipi_reg.h` (GPL-3.0 repository, HiSilicon copyright; local copy sources/openhisilicon), union `U_PHY_DATA_LVDS_LINK`, struct offset 0x244 (GPL-3.0 repository, HiSilicon copyright; one header for Hi3519 V101 and Hi3516A V200). Reset value and access type unknown (modelled RW, no reset). Confidence: medium (vendor header for this chip family, not hardware verified).";

        field {
            name = "phy0_data3_lvds_hs";
            desc = "[inferred] Phy0 data3 lvds horizontal sync. (vendor header `hi3519v101/mipi_reg.h` field `phy0_data3_lvds_hs`; access and reset unknown, modelled RW)";
            sw = rw;
            hw = r;
        } phy0_data3_lvds_hs[31:24];

        field {
            name = "phy0_data2_lvds_hs";
            desc = "[inferred] Phy0 data2 lvds horizontal sync. (vendor header `hi3519v101/mipi_reg.h` field `phy0_data2_lvds_hs`; access and reset unknown, modelled RW)";
            sw = rw;
            hw = r;
        } phy0_data2_lvds_hs[23:16];

        field {
            name = "phy0_data1_lvds_hs";
            desc = "[inferred] Phy0 data1 lvds horizontal sync. (vendor header `hi3519v101/mipi_reg.h` field `phy0_data1_lvds_hs`; access and reset unknown, modelled RW)";
            sw = rw;
            hw = r;
        } phy0_data1_lvds_hs[15:8];

        field {
            name = "phy0_data0_lvds_hs";
            desc = "[inferred] Phy0 data0 lvds horizontal sync. (vendor header `hi3519v101/mipi_reg.h` field `phy0_data0_lvds_hs`; access and reset unknown, modelled RW)";
            sw = rw;
            hw = r;
        } phy0_data0_lvds_hs[7:0];
    } PHY_DATA_LVDS_LINK1 @ 0x244;

    reg {
        name = "Link 1 MIPI CIL raw interrupt status NT_RAW_LI register NK1";
        desc = "MIPI_CIL_INT_RAW_LINK1 is a link 1 MIPI CIL raw interrupt status register.

Data sheet 9.3.6 MIPI_CIL_INT_RAW_LINK1 (offset 0x3F0, printed page 9-222, `hi3516av200--Hi3516AV200-Datasheet.txt` line 49797).";

        enum MIPI_CIL_INT_RAW_LINK1_err1_timeout_ck_raw_enum {
            NO_RAW_INTERRUPT = 0 { name = "No Raw Interrupt"; desc = "No raw interrupt is generated."; };
            RAW_INTERRUPT_GENERATED = 1 { name = "Raw Interrupt Generated"; desc = "A raw interrupt is generated."; };
        };

        field {
            name = "err1_timeout_ck_raw";
            desc = "Status of the raw FSM timeout interrupt for the clock lane";
            sw = rw;
            hw = w;
            onwrite = woclr;
            encode = MIPI_CIL_INT_RAW_LINK1_err1_timeout_ck_raw_enum;
            reset = 0x0;
        } err1_timeout_ck_raw[12:12];

        enum MIPI_CIL_INT_RAW_LINK1_err1_timeout_d3_raw_enum {
            NO_RAW_INTERRUPT = 0 { name = "No Raw Interrupt"; desc = "No raw interrupt is generated."; };
            RAW_INTERRUPT_GENERATED = 1 { name = "Raw Interrupt Generated"; desc = "A raw interrupt is generated."; };
        };

        field {
            name = "err1_timeout_d3_raw";
            desc = "Status of the raw FSM timeout interrupt for data lane 3";
            sw = rw;
            hw = w;
            onwrite = woclr;
            encode = MIPI_CIL_INT_RAW_LINK1_err1_timeout_d3_raw_enum;
            reset = 0x0;
        } err1_timeout_d3_raw[11:11];

        enum MIPI_CIL_INT_RAW_LINK1_err1_timeout_d2_raw_enum {
            NO_RAW_INTERRUPT = 0 { name = "No Raw Interrupt"; desc = "No raw interrupt is generated."; };
            RAW_INTERRUPT_GENERATED = 1 { name = "Raw Interrupt Generated"; desc = "A raw interrupt is generated."; };
        };

        field {
            name = "err1_timeout_d2_raw";
            desc = "Status of the raw FSM timeout interrupt for data lane 2";
            sw = rw;
            hw = w;
            onwrite = woclr;
            encode = MIPI_CIL_INT_RAW_LINK1_err1_timeout_d2_raw_enum;
            reset = 0x0;
        } err1_timeout_d2_raw[10:10];

        enum MIPI_CIL_INT_RAW_LINK1_err1_timeout_d1_raw_enum {
            NO_RAW_INTERRUPT = 0 { name = "No Raw Interrupt"; desc = "No raw interrupt is generated."; };
            RAW_INTERRUPT_GENERATED = 1 { name = "Raw Interrupt Generated"; desc = "A raw interrupt is generated."; };
        };

        field {
            name = "err1_timeout_d1_raw";
            desc = "Status of the raw FSM timeout interrupt for data lane 1";
            sw = rw;
            hw = w;
            onwrite = woclr;
            encode = MIPI_CIL_INT_RAW_LINK1_err1_timeout_d1_raw_enum;
            reset = 0x0;
        } err1_timeout_d1_raw[9:9];

        enum MIPI_CIL_INT_RAW_LINK1_err1_timeout_d0_raw_enum {
            NO_RAW_INTERRUPT = 0 { name = "No Raw Interrupt"; desc = "No raw interrupt is generated."; };
            RAW_INTERRUPT_GENERATED = 1 { name = "Raw Interrupt Generated"; desc = "A raw interrupt is generated."; };
        };

        field {
            name = "err1_timeout_d0_raw";
            desc = "Status of the raw FSM timeout interrupt for data lane 0";
            sw = rw;
            hw = w;
            onwrite = woclr;
            encode = MIPI_CIL_INT_RAW_LINK1_err1_timeout_d0_raw_enum;
            reset = 0x0;
        } err1_timeout_d0_raw[8:8];

        enum MIPI_CIL_INT_RAW_LINK1_err1_escape_ck_raw_enum {
            NO_RAW_INTERRUPT = 0 { name = "No Raw Interrupt"; desc = "No raw interrupt is generated."; };
            RAW_INTERRUPT_GENERATED = 1 { name = "Raw Interrupt Generated"; desc = "A raw interrupt is generated."; };
        };

        field {
            name = "err1_escape_ck_raw";
            desc = "Status of the raw escape sequence interrupt for the clock lane";
            sw = rw;
            hw = w;
            onwrite = woclr;
            encode = MIPI_CIL_INT_RAW_LINK1_err1_escape_ck_raw_enum;
            reset = 0x0;
        } err1_escape_ck_raw[4:4];

        enum MIPI_CIL_INT_RAW_LINK1_err1_escape_d3_raw_enum {
            NO_RAW_INTERRUPT = 0 { name = "No Raw Interrupt"; desc = "No raw interrupt is generated."; };
            RAW_INTERRUPT_GENERATED = 1 { name = "Raw Interrupt Generated"; desc = "A raw interrupt is generated."; };
        };

        field {
            name = "err1_escape_d3_raw";
            desc = "Status of the raw escape sequence interrupt for data lane 3";
            sw = rw;
            hw = w;
            onwrite = woclr;
            encode = MIPI_CIL_INT_RAW_LINK1_err1_escape_d3_raw_enum;
            reset = 0x0;
        } err1_escape_d3_raw[3:3];

        enum MIPI_CIL_INT_RAW_LINK1_err1_escape_d2_raw_enum {
            NO_RAW_INTERRUPT = 0 { name = "No Raw Interrupt"; desc = "No raw interrupt is generated."; };
            RAW_INTERRUPT_GENERATED = 1 { name = "Raw Interrupt Generated"; desc = "A raw interrupt is generated."; };
        };

        field {
            name = "err1_escape_d2_raw";
            desc = "Status of the raw escape sequence interrupt for data lane 2";
            sw = rw;
            hw = w;
            onwrite = woclr;
            encode = MIPI_CIL_INT_RAW_LINK1_err1_escape_d2_raw_enum;
            reset = 0x0;
        } err1_escape_d2_raw[2:2];

        enum MIPI_CIL_INT_RAW_LINK1_err1_escape_d1_raw_enum {
            NO_RAW_INTERRUPT = 0 { name = "No Raw Interrupt"; desc = "No raw interrupt is generated."; };
            RAW_INTERRUPT_GENERATED = 1 { name = "Raw Interrupt Generated"; desc = "A raw interrupt is generated."; };
        };

        field {
            name = "err1_escape_d1_raw";
            desc = "Status of the raw escape sequence interrupt for data lane 1";
            sw = rw;
            hw = w;
            onwrite = woclr;
            encode = MIPI_CIL_INT_RAW_LINK1_err1_escape_d1_raw_enum;
            reset = 0x0;
        } err1_escape_d1_raw[1:1];

        enum MIPI_CIL_INT_RAW_LINK1_err1_escape_d0_raw_enum {
            NO_RAW_INTERRUPT = 0 { name = "No Raw Interrupt"; desc = "No raw interrupt is generated."; };
            RAW_INTERRUPT_GENERATED = 1 { name = "Raw Interrupt Generated"; desc = "A raw interrupt is generated."; };
        };

        field {
            name = "err1_escape_d0_raw";
            desc = "Status of the raw escape sequence interrupt for data lane 0";
            sw = rw;
            hw = w;
            onwrite = woclr;
            encode = MIPI_CIL_INT_RAW_LINK1_err1_escape_d0_raw_enum;
            reset = 0x0;
        } err1_escape_d0_raw[0:0];
    } MIPI_CIL_INT_RAW_LINK1 @ 0x3F0;

    reg {
        name = "Link 1 MIPI CIL interrupt status register NT_LINK1";
        desc = "MIPI_CIL_INT_LINK1 is a link 1 MIPI CIL interrupt status register. Hi3516A V200 Professional HD IP Camera SoC

Data sheet 9.3.6 MIPI_CIL_INT_LINK1 (offset 0x3F4, printed page 9-224, `hi3516av200--Hi3516AV200-Datasheet.txt` line 49895).";

        enum MIPI_CIL_INT_LINK1_err1_timeout_ck_st_enum {
            NO_INTERRUPT_GENERATED = 0 { name = "No Interrupt Generated"; desc = "No interrupt is generated."; };
            INTERRUPT_GENERATED = 1 { name = "Interrupt Generated"; desc = "An interrupt is generated."; };
        };

        field {
            name = "err1_timeout_ck_st";
            desc = "Status of the FSM timeout interrupt for the clock lane";
            sw = r;
            hw = w;
            encode = MIPI_CIL_INT_LINK1_err1_timeout_ck_st_enum;
            reset = 0x0;
        } err1_timeout_ck_st[12:12];

        enum MIPI_CIL_INT_LINK1_err1_timeout_d3_st_enum {
            NO_INTERRUPT_GENERATED = 0 { name = "No Interrupt Generated"; desc = "No interrupt is generated."; };
            INTERRUPT_GENERATED = 1 { name = "Interrupt Generated"; desc = "An interrupt is generated."; };
        };

        field {
            name = "err1_timeout_d3_st";
            desc = "Status of the FSM timeout interrupt for data lane 3";
            sw = r;
            hw = w;
            encode = MIPI_CIL_INT_LINK1_err1_timeout_d3_st_enum;
            reset = 0x0;
        } err1_timeout_d3_st[11:11];

        enum MIPI_CIL_INT_LINK1_err1_timeout_d2_st_enum {
            NO_INTERRUPT_GENERATED = 0 { name = "No Interrupt Generated"; desc = "No interrupt is generated."; };
            INTERRUPT_GENERATED = 1 { name = "Interrupt Generated"; desc = "An interrupt is generated."; };
        };

        field {
            name = "err1_timeout_d2_st";
            desc = "Status of the FSM timeout interrupt for data lane 2";
            sw = r;
            hw = w;
            encode = MIPI_CIL_INT_LINK1_err1_timeout_d2_st_enum;
            reset = 0x0;
        } err1_timeout_d2_st[10:10];

        enum MIPI_CIL_INT_LINK1_err1_timeout_d1_st_enum {
            NO_INTERRUPT_GENERATED = 0 { name = "No Interrupt Generated"; desc = "No interrupt is generated."; };
            INTERRUPT_GENERATED = 1 { name = "Interrupt Generated"; desc = "An interrupt is generated."; };
        };

        field {
            name = "err1_timeout_d1_st";
            desc = "Status of the FSM timeout interrupt for data lane 1";
            sw = r;
            hw = w;
            encode = MIPI_CIL_INT_LINK1_err1_timeout_d1_st_enum;
            reset = 0x0;
        } err1_timeout_d1_st[9:9];

        enum MIPI_CIL_INT_LINK1_err1_timeout_d0_st_enum {
            NO_INTERRUPT_GENERATED = 0 { name = "No Interrupt Generated"; desc = "No interrupt is generated."; };
            INTERRUPT_GENERATED = 1 { name = "Interrupt Generated"; desc = "An interrupt is generated."; };
        };

        field {
            name = "err1_timeout_d0_st";
            desc = "Status of the FSM timeout interrupt for data lane 0";
            sw = r;
            hw = w;
            encode = MIPI_CIL_INT_LINK1_err1_timeout_d0_st_enum;
            reset = 0x0;
        } err1_timeout_d0_st[8:8];

        enum MIPI_CIL_INT_LINK1_err1_escape_ck_st_enum {
            NO_INTERRUPT_GENERATED = 0 { name = "No Interrupt Generated"; desc = "No interrupt is generated."; };
            INTERRUPT_GENERATED = 1 { name = "Interrupt Generated"; desc = "An interrupt is generated."; };
        };

        field {
            name = "err1_escape_ck_st";
            desc = "Status of the escape sequence interrupt for the clock lane";
            sw = r;
            hw = w;
            encode = MIPI_CIL_INT_LINK1_err1_escape_ck_st_enum;
            reset = 0x0;
        } err1_escape_ck_st[4:4];

        enum MIPI_CIL_INT_LINK1_err1_escape_d3_st_enum {
            NO_INTERRUPT_GENERATED = 0 { name = "No Interrupt Generated"; desc = "No interrupt is generated."; };
            INTERRUPT_GENERATED = 1 { name = "Interrupt Generated"; desc = "An interrupt is generated."; };
        };

        field {
            name = "err1_escape_d3_st";
            desc = "Status of the escape sequence interrupt for data lane 3";
            sw = r;
            hw = w;
            encode = MIPI_CIL_INT_LINK1_err1_escape_d3_st_enum;
            reset = 0x0;
        } err1_escape_d3_st[3:3];

        enum MIPI_CIL_INT_LINK1_err1_escape_d2_st_enum {
            NO_INTERRUPT_GENERATED = 0 { name = "No Interrupt Generated"; desc = "No interrupt is generated."; };
            INTERRUPT_GENERATED = 1 { name = "Interrupt Generated"; desc = "An interrupt is generated."; };
        };

        field {
            name = "err1_escape_d2_st";
            desc = "Status of the escape sequence interrupt for data lane 2";
            sw = r;
            hw = w;
            encode = MIPI_CIL_INT_LINK1_err1_escape_d2_st_enum;
            reset = 0x0;
        } err1_escape_d2_st[2:2];

        enum MIPI_CIL_INT_LINK1_err1_escape_d1_st_enum {
            NO_INTERRUPT_GENERATED = 0 { name = "No Interrupt Generated"; desc = "No interrupt is generated."; };
            INTERRUPT_GENERATED = 1 { name = "Interrupt Generated"; desc = "An interrupt is generated."; };
        };

        field {
            name = "err1_escape_d1_st";
            desc = "Status of the escape sequence interrupt for data lane 1";
            sw = r;
            hw = w;
            encode = MIPI_CIL_INT_LINK1_err1_escape_d1_st_enum;
            reset = 0x0;
        } err1_escape_d1_st[1:1];

        enum MIPI_CIL_INT_LINK1_err1_escape_d0_st_enum {
            NO_INTERRUPT_GENERATED = 0 { name = "No Interrupt Generated"; desc = "No interrupt is generated."; };
            INTERRUPT_GENERATED = 1 { name = "Interrupt Generated"; desc = "An interrupt is generated."; };
        };

        field {
            name = "err1_escape_d0_st";
            desc = "Status of the escape sequence interrupt for data lane 0";
            sw = r;
            hw = w;
            encode = MIPI_CIL_INT_LINK1_err1_escape_d0_st_enum;
            reset = 0x0;
        } err1_escape_d0_st[0:0];
    } MIPI_CIL_INT_LINK1 @ 0x3F4;

    reg {
        name = "Link 1 MIPI CIL interrupt mask register NT_MSK_LI NK1";
        desc = "MIPI_CIL_INT_MSK_LINK1 is a link 1 MIPI CIL interrupt mask register.

Data sheet 9.3.6 MIPI_CIL_INT_MSK_LINK1 (offset 0x3F8, printed page 9-225, `hi3516av200--Hi3516AV200-Datasheet.txt` line 49963).";

        enum MIPI_CIL_INT_MSK_LINK1_err1_timeout_ck_msk_enum {
            MASKED = 0 { name = "Masked"; desc = "masked"; };
            ENABLED = 1 { name = "Enabled"; desc = "enabled"; };
        };

        field {
            name = "err1_timeout_ck_msk";
            desc = "Enable of the FSM timeout interrupt for the clock lane";
            sw = rw;
            hw = r;
            encode = MIPI_CIL_INT_MSK_LINK1_err1_timeout_ck_msk_enum;
            reset = 0x0;
        } err1_timeout_ck_msk[12:12];

        enum MIPI_CIL_INT_MSK_LINK1_err1_timeout_d3_msk_enum {
            MASKED = 0 { name = "Masked"; desc = "masked"; };
            ENABLED = 1 { name = "Enabled"; desc = "enabled"; };
        };

        field {
            name = "err1_timeout_d3_msk";
            desc = "Enable of the FSM timeout interrupt for data lane 3";
            sw = rw;
            hw = r;
            encode = MIPI_CIL_INT_MSK_LINK1_err1_timeout_d3_msk_enum;
            reset = 0x0;
        } err1_timeout_d3_msk[11:11];

        enum MIPI_CIL_INT_MSK_LINK1_err1_timeout_d2_msk_enum {
            MASKED = 0 { name = "Masked"; desc = "masked"; };
            ENABLED = 1 { name = "Enabled"; desc = "enabled"; };
        };

        field {
            name = "err1_timeout_d2_msk";
            desc = "Enable of the FSM timeout interrupt for data lane 2";
            sw = rw;
            hw = r;
            encode = MIPI_CIL_INT_MSK_LINK1_err1_timeout_d2_msk_enum;
            reset = 0x0;
        } err1_timeout_d2_msk[10:10];

        enum MIPI_CIL_INT_MSK_LINK1_err1_timeout_d1_msk_enum {
            MASKED = 0 { name = "Masked"; desc = "masked"; };
            ENABLED = 1 { name = "Enabled"; desc = "enabled"; };
        };

        field {
            name = "err1_timeout_d1_msk";
            desc = "Enable of the FSM timeout interrupt for data lane 1";
            sw = rw;
            hw = r;
            encode = MIPI_CIL_INT_MSK_LINK1_err1_timeout_d1_msk_enum;
            reset = 0x0;
        } err1_timeout_d1_msk[9:9];

        enum MIPI_CIL_INT_MSK_LINK1_err1_timeout_d0_msk_enum {
            MASKED = 0 { name = "Masked"; desc = "masked"; };
            ENABLED = 1 { name = "Enabled"; desc = "enabled"; };
        };

        field {
            name = "err1_timeout_d0_msk";
            desc = "Enable of the FSM timeout interrupt for data lane 0";
            sw = rw;
            hw = r;
            encode = MIPI_CIL_INT_MSK_LINK1_err1_timeout_d0_msk_enum;
            reset = 0x0;
        } err1_timeout_d0_msk[8:8];

        enum MIPI_CIL_INT_MSK_LINK1_err1_escape_ck_msk_enum {
            MASKED = 0 { name = "Masked"; desc = "masked"; };
            ENABLED = 1 { name = "Enabled"; desc = "enabled"; };
        };

        field {
            name = "err1_escape_ck_msk";
            desc = "Enable of the escape sequence interrupt for the clock lane";
            sw = rw;
            hw = r;
            encode = MIPI_CIL_INT_MSK_LINK1_err1_escape_ck_msk_enum;
            reset = 0x0;
        } err1_escape_ck_msk[4:4];

        enum MIPI_CIL_INT_MSK_LINK1_err1_escape_d3_msk_enum {
            MASKED = 0 { name = "Masked"; desc = "masked"; };
            ENABLED = 1 { name = "Enabled"; desc = "enabled"; };
        };

        field {
            name = "err1_escape_d3_msk";
            desc = "Enable of the escape sequence interrupt for data lane 3";
            sw = rw;
            hw = r;
            encode = MIPI_CIL_INT_MSK_LINK1_err1_escape_d3_msk_enum;
            reset = 0x0;
        } err1_escape_d3_msk[3:3];

        enum MIPI_CIL_INT_MSK_LINK1_err1_escape_d2_msk_enum {
            MASKED = 0 { name = "Masked"; desc = "masked"; };
            ENABLED = 1 { name = "Enabled"; desc = "enabled"; };
        };

        field {
            name = "err1_escape_d2_msk";
            desc = "Enable of the escape sequence interrupt for data lane 2";
            sw = rw;
            hw = r;
            encode = MIPI_CIL_INT_MSK_LINK1_err1_escape_d2_msk_enum;
            reset = 0x0;
        } err1_escape_d2_msk[2:2];

        enum MIPI_CIL_INT_MSK_LINK1_err1_escape_d1_msk_enum {
            MASKED = 0 { name = "Masked"; desc = "masked"; };
            ENABLED = 1 { name = "Enabled"; desc = "enabled"; };
        };

        field {
            name = "err1_escape_d1_msk";
            desc = "Enable of the escape sequence interrupt for data lane 1";
            sw = rw;
            hw = r;
            encode = MIPI_CIL_INT_MSK_LINK1_err1_escape_d1_msk_enum;
            reset = 0x0;
        } err1_escape_d1_msk[1:1];

        enum MIPI_CIL_INT_MSK_LINK1_err1_escape_d0_msk_enum {
            MASKED = 0 { name = "Masked"; desc = "masked"; };
            ENABLED = 1 { name = "Enabled"; desc = "enabled"; };
        };

        field {
            name = "err1_escape_d0_msk";
            desc = "Enable of the escape sequence interrupt for data lane 0";
            sw = rw;
            hw = r;
            encode = MIPI_CIL_INT_MSK_LINK1_err1_escape_d0_msk_enum;
            reset = 0x0;
        } err1_escape_d0_msk[0:0];
    } MIPI_CIL_INT_MSK_LINK1 @ 0x3F8;

    reg {
        name = "Link 2 PHY operating mode register _LINK2";
        desc = "PHY_MODE_LINK2 is a link 2 PHY operating mode register. Hi3516A V200 Professional HD IP Camera SoC

Data sheet 9.3.6 PHY_MODE_LINK2 (offset 0x400, printed page 9-227, `hi3516av200--Hi3516AV200-Datasheet.txt` line 50060).";

        enum PHY_MODE_LINK2_phy2_rg_mipi_mode_enum {
            COMMON_VOLTAGE_HIGHER = 0 { name = "Common Voltage Higher"; desc = "The common voltage is higher than 1.25 V"; };
            COMMON_VOLTAGE_1 = 1 { name = "Common Voltage 1"; desc = "The common voltage is 1.25 V or lower."; };
        };

        field {
            name = "phy2_rg_mipi_mode";
            desc = "MIPI/LVDS input mode select. This field is set to 0 when the PHY works in LVDS mode and the common voltage is greater than or equal to 1.25 V.";
            sw = rw;
            hw = r;
            encode = PHY_MODE_LINK2_phy2_rg_mipi_mode_enum;
            reset = 0x0;
        } phy2_rg_mipi_mode[24:24];

        enum PHY_MODE_LINK2_phy2_rg_ext_clk_en_enum {
            PAD_INPUT_DIFFERENTIAL = 0 { name = "Pad Input Differential"; desc = "PAD input differential clock"; };
            DIFFERENTIAL_CLOCK_OTHER = 1 { name = "Differential Clock Other"; desc = "differential clock of other links"; };
        };

        field {
            name = "phy2_rg_ext_clk_en";
            desc = "Differential clock source select";
            sw = rw;
            hw = r;
            encode = PHY_MODE_LINK2_phy2_rg_ext_clk_en_enum;
            reset = 0x0;
        } phy2_rg_ext_clk_en[20:20];

        enum PHY_MODE_LINK2_phy2_rg_faclk_en_enum {
            DATA_OUTPUT_AT = 0 { name = "Data Output At"; desc = "Data is output at the rising edge of the clock."; };
            DATA_OUTPUT_AT_2 = 1 { name = "Data Output At 2"; desc = "Data is output at the falling edge of the clock."; };
        };

        field {
            name = "phy2_rg_faclk_en";
            desc = "Phase of the associated clock for the PHY output data";
            sw = rw;
            hw = r;
            encode = PHY_MODE_LINK2_phy2_rg_faclk_en_enum;
            reset = 0x0;
        } phy2_rg_faclk_en[16:16];

        enum PHY_MODE_LINK2_phy2_rg_en_lp_enum {
            DISABLED = 0 { name = "Disabled"; desc = "disabled"; };
            ENABLED = 1 { name = "Enabled"; desc = "enabled"; };
        };

        field {
            name = "phy2_rg_en_lp";
            desc = "PHY LP mode enable. The LP mode is enabled in MIPI mode and disabled in other modes.";
            sw = rw;
            hw = r;
            encode = PHY_MODE_LINK2_phy2_rg_en_lp_enum;
            reset = 0x0;
        } phy2_rg_en_lp[12:12];

        enum PHY_MODE_LINK2_phy2_rg_en_cmos_enum {
            DISABLED = 0 { name = "Disabled"; desc = "disabled"; };
            ENABLED = 1 { name = "Enabled"; desc = "enabled"; };
        };

        field {
            name = "phy2_rg_en_cmos";
            desc = "PHY CMOS mode enable";
            sw = rw;
            hw = r;
            encode = PHY_MODE_LINK2_phy2_rg_en_cmos_enum;
            reset = 0x0;
        } phy2_rg_en_cmos[8:8];

        enum PHY_MODE_LINK2_phy2_rg_en_clk_enum {
            DISABLED = 0 { name = "Disabled"; desc = "disabled"; };
            ENABLED = 1 { name = "Enabled"; desc = "enabled"; };
        };

        field {
            name = "phy2_rg_en_clk";
            desc = "Clock lane enable";
            sw = rw;
            hw = r;
            encode = PHY_MODE_LINK2_phy2_rg_en_clk_enum;
            reset = 0x0;
        } phy2_rg_en_clk[4:4];

        enum PHY_MODE_LINK2_phy2_rg_en_d_enum {
            DISABLED = 0 { name = "Disabled"; desc = "disabled"; };
            ENABLED = 1 { name = "Enabled"; desc = "enabled"; };
        };

        field {
            name = "phy2_rg_en_d";
            desc = "Data lane enable";
            sw = rw;
            hw = r;
            encode = PHY_MODE_LINK2_phy2_rg_en_d_enum;
            reset = 0x0;
        } phy2_rg_en_d[3:0];
    } PHY_MODE_LINK2 @ 0x400;

    reg {
        name = "Link 2 PHY channel delay adjustment _LINK2 register";
        desc = "PHY_SKEW_LINK2 is a link 2 PHY channel delay adjustment register.

Data sheet 9.3.6 PHY_SKEW_LINK2 (offset 0x404, printed page 9-228, `hi3516av200--Hi3516AV200-Datasheet.txt` line 50132).";

        field {
            name = "phy2_d3_skew";
            desc = "Timing delay adjustment for data lane 3. The phase is delayed by about 62.5 ps each time the register value is incremented by 1.";
            sw = rw;
            hw = r;
            reset = 0x0;
        } phy2_d3_skew[18:16];

        field {
            name = "phy2_d2_skew";
            desc = "Timing delay adjustment for data lane 2. The phase is delayed by about 62.5 ps each time the register value is incremented by 1.";
            sw = rw;
            hw = r;
            reset = 0x0;
        } phy2_d2_skew[14:12];

        field {
            name = "phy2_d1_skew";
            desc = "Timing delay adjustment for data lane 1. The phase is delayed by about 62.5 ps each time the register value is incremented by 1.";
            sw = rw;
            hw = r;
            reset = 0x0;
        } phy2_d1_skew[10:8];

        field {
            name = "phy2_d0_skew";
            desc = "Timing delay adjustment for data lane 0. The phase is delayed by about 62.5 ps each time the register value is incremented by 1.";
            sw = rw;
            hw = r;
            reset = 0x0;
        } phy2_d0_skew[6:4];

        field {
            name = "phy2_clk_skew";
            desc = "Timing delay adjustment for the clock lane. The phase is delayed by about 62.5 ps each time the register value is incremented by 1.";
            sw = rw;
            hw = r;
            reset = 0x0;
        } phy2_clk_skew[2:0];
    } PHY_SKEW_LINK2 @ 0x404;

    reg {
        name = "Link 2 PHY channel enable register NK2";
        desc = "PHY_EN_LINK2 is a link 2 PHY channel enable register.

Data sheet 9.3.6 PHY_EN_LINK2 (offset 0x408, printed page 9-229, `hi3516av200--Hi3516AV200-Datasheet.txt` line 50182).";

        enum PHY_EN_LINK2_phy2_clk_term_en_enum {
            INTERNAL_MATCHED_RESISTOR = 0 { name = "Internal Matched Resistor"; desc = "The internal matched resistor is disabled."; };
            INTERNAL_MATCHED_RESISTOR_2 = 1 { name = "Internal Matched Resistor 2"; desc = "The internal matched resistor is enabled."; };
        };

        field {
            name = "phy2_clk_term_en";
            desc = "Termination matched impedance enable for the clock lane";
            sw = rw;
            hw = r;
            encode = PHY_EN_LINK2_phy2_clk_term_en_enum;
            reset = 0x0;
        } phy2_clk_term_en[8:8];

        enum PHY_EN_LINK2_phy2_d3_term_en_enum {
            INTERNAL_MATCHED_RESISTOR = 0 { name = "Internal Matched Resistor"; desc = "The internal matched resistor is disabled."; };
            INTERNAL_MATCHED_RESISTOR_2 = 1 { name = "Internal Matched Resistor 2"; desc = "The internal matched resistor is enabled."; };
        };

        field {
            name = "phy2_d3_term_en";
            desc = "Termination matched impedance enable for data lane 3";
            sw = rw;
            hw = r;
            encode = PHY_EN_LINK2_phy2_d3_term_en_enum;
            reset = 0x0;
        } phy2_d3_term_en[7:7];

        enum PHY_EN_LINK2_phy2_d2_term_en_enum {
            INTERNAL_MATCHED_RESISTOR = 0 { name = "Internal Matched Resistor"; desc = "The internal matched resistor is disabled."; };
            INTERNAL_MATCHED_RESISTOR_2 = 1 { name = "Internal Matched Resistor 2"; desc = "The internal matched resistor is enabled."; };
        };

        field {
            name = "phy2_d2_term_en";
            desc = "Termination matched impedance enable for data lane 2";
            sw = rw;
            hw = r;
            encode = PHY_EN_LINK2_phy2_d2_term_en_enum;
            reset = 0x0;
        } phy2_d2_term_en[6:6];

        enum PHY_EN_LINK2_phy2_d1_term_en_enum {
            INTERNAL_MATCHED_RESISTOR = 0 { name = "Internal Matched Resistor"; desc = "The internal matched resistor is disabled."; };
            INTERNAL_MATCHED_RESISTOR_2 = 1 { name = "Internal Matched Resistor 2"; desc = "The internal matched resistor is enabled."; };
        };

        field {
            name = "phy2_d1_term_en";
            desc = "Termination matched impedance enable for data lane 1";
            sw = rw;
            hw = r;
            encode = PHY_EN_LINK2_phy2_d1_term_en_enum;
            reset = 0x0;
        } phy2_d1_term_en[5:5];

        enum PHY_EN_LINK2_phy2_d0_term_en_enum {
            INTERNAL_MATCHED_RESISTOR = 0 { name = "Internal Matched Resistor"; desc = "The internal matched resistor is disabled."; };
            INTERNAL_MATCHED_RESISTOR_2 = 1 { name = "Internal Matched Resistor 2"; desc = "The internal matched resistor is enabled."; };
        };

        field {
            name = "phy2_d0_term_en";
            desc = "Termination matched impedance enable for data lane 0";
            sw = rw;
            hw = r;
            encode = PHY_EN_LINK2_phy2_d0_term_en_enum;
            reset = 0x0;
        } phy2_d0_term_en[4:4];

        enum PHY_EN_LINK2_phy2_da_d3_valid_enum {
            DISABLED = 0 { name = "Disabled"; desc = "disabled"; };
            ENABLED = 1 { name = "Enabled"; desc = "enabled"; };
        };

        field {
            name = "phy2_da_d3_valid";
            desc = "High-speed mode enable for data lane 3";
            sw = rw;
            hw = r;
            encode = PHY_EN_LINK2_phy2_da_d3_valid_enum;
            reset = 0x0;
        } phy2_da_d3_valid[3:3];

        enum PHY_EN_LINK2_phy2_da_d2_valid_enum {
            DISABLED = 0 { name = "Disabled"; desc = "disabled"; };
            ENABLED = 1 { name = "Enabled"; desc = "enabled"; };
        };

        field {
            name = "phy2_da_d2_valid";
            desc = "High-speed mode enable for data lane 2";
            sw = rw;
            hw = r;
            encode = PHY_EN_LINK2_phy2_da_d2_valid_enum;
            reset = 0x0;
        } phy2_da_d2_valid[2:2];

        enum PHY_EN_LINK2_phy2_da_d1_valid_enum {
            DISABLED = 0 { name = "Disabled"; desc = "disabled"; };
            ENABLED = 1 { name = "Enabled"; desc = "enabled"; };
        };

        field {
            name = "phy2_da_d1_valid";
            desc = "High-speed mode enable for data lane 1";
            sw = rw;
            hw = r;
            encode = PHY_EN_LINK2_phy2_da_d1_valid_enum;
            reset = 0x0;
        } phy2_da_d1_valid[1:1];

        enum PHY_EN_LINK2_phy2_da_d0_valid_enum {
            DISABLED = 0 { name = "Disabled"; desc = "disabled"; };
            ENABLED = 1 { name = "Enabled"; desc = "enabled"; };
        };

        field {
            name = "phy2_da_d0_valid";
            desc = "High-speed mode enable for data lane 0";
            sw = rw;
            hw = r;
            encode = PHY_EN_LINK2_phy2_da_d0_valid_enum;
            reset = 0x0;
        } phy2_da_d0_valid[0:0];
    } PHY_EN_LINK2 @ 0x408;

    reg {
        name = "PHY configuration LINK2";
        desc = "[inferred] PHY configuration LINK2. Not in the data sheet. Source: OpenIPC openhisilicon `kernel/mipi_rx/hi3519v101/mipi_reg.h` (GPL-3.0 repository, HiSilicon copyright; local copy sources/openhisilicon), union `U_PHY_CFG_LINK`, struct offset 0x40C (GPL-3.0 repository, HiSilicon copyright; one header for Hi3519 V101 and Hi3516A V200). Reset value and access type unknown (modelled RW, no reset). Confidence: medium (vendor header for this chip family, not hardware verified).";

        field {
            name = "phy0_rg_sa_en";
            desc = "[inferred] Phy0 rg sa enable. (vendor header `hi3519v101/mipi_reg.h` field `phy0_rg_sa_en`; access and reset unknown, modelled RW)";
            sw = rw;
            hw = r;
        } phy0_rg_sa_en[14:14];

        field {
            name = "phy0_rg_it_dt";
            desc = "[inferred] Phy0 rg it dt. (vendor header `hi3519v101/mipi_reg.h` field `phy0_rg_it_dt`; access and reset unknown, modelled RW)";
            sw = rw;
            hw = r;
        } phy0_rg_it_dt[13:12];

        field {
            name = "phy0_rg_it_ck";
            desc = "[inferred] Phy0 rg it ck. (vendor header `hi3519v101/mipi_reg.h` field `phy0_rg_it_ck`; access and reset unknown, modelled RW)";
            sw = rw;
            hw = r;
        } phy0_rg_it_ck[11:10];

        field {
            name = "phy0_rg_it_lp";
            desc = "[inferred] Phy0 rg it low-power. (vendor header `hi3519v101/mipi_reg.h` field `phy0_rg_it_lp`; access and reset unknown, modelled RW)";
            sw = rw;
            hw = r;
        } phy0_rg_it_lp[9:8];

        field {
            name = "phy0_da_ulpb_ck";
            desc = "[inferred] Phy0 da ulpb ck. (vendor header `hi3519v101/mipi_reg.h` field `phy0_da_ulpb_ck`; access and reset unknown, modelled RW)";
            sw = rw;
            hw = r;
        } phy0_da_ulpb_ck[4:4];

        field {
            name = "phy0_da_ulpb";
            desc = "[inferred] Phy0 da ulpb. (vendor header `hi3519v101/mipi_reg.h` field `phy0_da_ulpb`; access and reset unknown, modelled RW)";
            sw = rw;
            hw = r;
        } phy0_da_ulpb[3:0];
    } PHY_CFG_LINK2 @ 0x40C;

    reg {
        name = "Link 2 PHY output parallel data register _LINK2";
        desc = "PHY_DATA_LINK2 is a link 2 PHY output parallel data register.

Data sheet 9.3.6 PHY_DATA_LINK2 (offset 0x418, printed page 9-230, `hi3516av200--Hi3516AV200-Datasheet.txt` line 50245).";

        field {
            name = "phy2_data3_mipi";
            desc = "Data received by data lane 3";
            sw = r;
            hw = w;
            reset = 0x0;
        } phy2_data3_mipi[31:24];

        field {
            name = "phy2_data2_mipi";
            desc = "Data received by data lane 2";
            sw = r;
            hw = w;
            reset = 0x0;
        } phy2_data2_mipi[23:16];

        field {
            name = "phy2_data1_mipi";
            desc = "Data received by data lane 1";
            sw = r;
            hw = w;
            reset = 0x0;
        } phy2_data1_mipi[15:8];

        field {
            name = "phy2_data0_mipi";
            desc = "Data received by data lane 0";
            sw = r;
            hw = w;
            reset = 0x0;
        } phy2_data0_mipi[7:0];
    } PHY_DATA_LINK2 @ 0x418;

    reg {
        name = "Link 2 MIPI data packet header register PI_LINK2";
        desc = "PHY_PH_MIPI_LINK2 is a link 2 MIPI data packet header register.

Data sheet 9.3.6 PHY_PH_MIPI_LINK2 (offset 0x41C, printed page 9-230, `hi3516av200--Hi3516AV200-Datasheet.txt` line 50267).";

        field {
            name = "phy2_ph3_mipi";
            desc = "Data packet header received by data lane 3";
            sw = r;
            hw = w;
            reset = 0x0;
        } phy2_ph3_mipi[31:24];

        field {
            name = "phy2_ph2_mipi";
            desc = "Data packet header received by data lane 2";
            sw = r;
            hw = w;
            reset = 0x0;
        } phy2_ph2_mipi[23:16];

        field {
            name = "phy2_ph1_mipi";
            desc = "Data packet header received by data lane 1";
            sw = r;
            hw = w;
            reset = 0x0;
        } phy2_ph1_mipi[15:8];

        field {
            name = "phy2_ph0_mipi";
            desc = "Data packet header received by data lane 0";
            sw = r;
            hw = w;
            reset = 0x0;
        } phy2_ph0_mipi[7:0];
    } PHY_PH_MIPI_LINK2 @ 0x41C;

    reg {
        name = "Link 2 MIPI mode data register _MIPI_LINK 2";
        desc = "PHY_DATA_MIPI_LINK2 is a link 2 MIPI mode data register.

Data sheet 9.3.6 PHY_DATA_MIPI_LINK2 (offset 0x420, printed page 9-231, `hi3516av200--Hi3516AV200-Datasheet.txt` line 50296).";

        field {
            name = "phy2_data3_mipi_hsphy2_data2_mipi_h";
            desc = "MIPI data for data lane 3";
            sw = r;
            hw = w;
            reset = 0x0;
        } phy2_data3_mipi_hsphy2_data2_mipi_h[31:24];

        field {
            name = "sphy2_data2_mipi_hsphy2_data1_mipi_h";
            desc = "MIPI data for data lane 2";
            sw = r;
            hw = w;
            reset = 0x0;
        } sphy2_data2_mipi_hsphy2_data1_mipi_h[23:16];

        field {
            name = "sphy2_data1_mipi_hsphy2_data0_mipi_h";
            desc = "MIPI data for data lane 1";
            sw = r;
            hw = w;
            reset = 0x0;
        } sphy2_data1_mipi_hsphy2_data0_mipi_h[15:8];

        field {
            name = "sphy2_data0_mipi_hs";
            desc = "MIPI data for data lane 0";
            sw = r;
            hw = w;
            reset = 0x0;
        } sphy2_data0_mipi_hs[7:0];
    } PHY_DATA_MIPI_LINK2 @ 0x420;

    reg {
        name = "Link 2 PHY LVDS mode synchronization _DCT_LINK header detection control register 2";
        desc = "PHY_SYNC_DCT_LINK2 is a link 2 PHY LVDS mode synchronization header detection control register.

Data sheet 9.3.6 PHY_SYNC_DCT_LINK2 (offset 0x424, printed page 9-231, `hi3516av200--Hi3516AV200-Datasheet.txt` line 50327).";

        enum PHY_SYNC_DCT_LINK2_cil2_code_big_endian_enum {
            LSB_LOWER_BITS = 0 { name = "Lsb Lower Bits"; desc = "LSB. The lower bits are transmitted first. The serial data sequence of the received synchronization code is bit 0, bit 1, …, bit 11."; };
            MSB_UPPER_BITS = 1 { name = "Msb Upper Bits"; desc = "MSB. The upper bits are transmitted first. The serial data sequence of the received synchronization code is bit 11, bit 10, …, bit 0."; };
        };

        field {
            name = "cil2_code_big_endian";
            desc = "Serial bit transmission sequence for the synchronization code (sync_code) of the raw data to be transmitted in LVDS or HiSPi mode";
            sw = rw;
            hw = r;
            encode = PHY_SYNC_DCT_LINK2_cil2_code_big_endian_enum;
            reset = 0x1;
        } cil2_code_big_endian[8:8];

        enum PHY_SYNC_DCT_LINK2_cil2_split_mode_enum {
            PER_LANE_MODE = 0 { name = "Per Lane Mode"; desc = "per lane mode"; };
            SPLIT_2_LANE = 3 { name = "Split 2 Lane"; desc = "split-2 lane mode"; };
            SPLIT_4_LANE = 7 { name = "Split 4 Lane"; desc = "split-4 lane mode Other values: reserved"; };
        };

        field {
            name = "cil2_split_mode";
            desc = "Transfer type for the synchronization code in LVDS or HiSPi mode";
            sw = rw;
            hw = r;
            encode = PHY_SYNC_DCT_LINK2_cil2_split_mode_enum;
            reset = 0x0;
        } cil2_split_mode[6:4];

        enum PHY_SYNC_DCT_LINK2_cil2_raw_type_enum {
            V_8_BIT_RAW = 1 { name = "V 8 Bit Raw"; desc = "8-bit raw data"; };
            V_10_BIT_RAW = 2 { name = "V 10 Bit Raw"; desc = "10-bit raw data"; };
            V_12_BIT_RAW = 3 { name = "V 12 Bit Raw"; desc = "12-bit raw data"; };
            V_14_BIT_RAW = 4 { name = "V 14 Bit Raw"; desc = "14-bit raw data"; };
            V_16_BIT_RAW = 5 { name = "V 16 Bit Raw"; desc = "16-bit raw data Other values: reserved"; };
        };

        field {
            name = "cil2_raw_type";
            desc = "Type of the raw data to be transmitted in LVDS or HiSPi mode";
            sw = rw;
            hw = r;
            encode = PHY_SYNC_DCT_LINK2_cil2_raw_type_enum;
            reset = 0x1;
        } cil2_raw_type[2:0];
    } PHY_SYNC_DCT_LINK2 @ 0x424;

    reg {
        name = "Link 2 PHY LVDS mode lane 0 _CODE0_LI synchronization header register. NK2";
        desc = "PHY_SYNC_CODE0_LINK2 is link 2 PHY LVDS lane 0 mode synchronization header register.

Data sheet 9.3.6 PHY_SYNC_CODE0_LINK2 (offset 0x430, printed page 9-232, `hi3516av200--Hi3516AV200-Datasheet.txt` line 50391).";

        field {
            name = "cil2_sof1_word4_0";
            desc = "Lane 0 SOF synchronization code (for frame + 1)";
            sw = rw;
            hw = r;
            reset = 0x0;
        } cil2_sof1_word4_0[31:16];

        field {
            name = "cil2_sof0_word4_0";
            desc = "Lane 0 SOF synchronization code (for frame";
            sw = rw;
            hw = r;
            reset = 0x0;
        } cil2_sof0_word4_0[15:0];
    } PHY_SYNC_CODE0_LINK2 @ 0x430;

    reg {
        name = "Link 2 PHY LVDS mode lane 1 _CODE1_LI synchronization header register. NK2";
        desc = "PHY_SYNC_CODE1_LINK2 is link 2 PHY LVDS mode lane 1 synchronization header register.

Data sheet 9.3.6 PHY_SYNC_CODE1_LINK2 (offset 0x434, printed page 9-233, `hi3516av200--Hi3516AV200-Datasheet.txt` line 50418).";

        field {
            name = "cil2_sof1_word4_1";
            desc = "Lane 1 SOF synchronization code (for frame + 1)";
            sw = rw;
            hw = r;
            reset = 0x0;
        } cil2_sof1_word4_1[31:16];

        field {
            name = "cil2_sof0_word4_1";
            desc = "Lane 1 SOF synchronization code (for frame N)";
            sw = rw;
            hw = r;
            reset = 0x0;
        } cil2_sof0_word4_1[15:0];
    } PHY_SYNC_CODE1_LINK2 @ 0x434;

    reg {
        name = "Link 2 PHY LVDS mode lane 2 _CODE2_LI synchronization header register. NK2";
        desc = "PHY_SYNC_CODE2_LINK2 is link 2 PHY LVDS mode lane 2 synchronization header register.

Data sheet 9.3.6 PHY_SYNC_CODE2_LINK2 (offset 0x438, printed page 9-233, `hi3516av200--Hi3516AV200-Datasheet.txt` line 50439).";

        field {
            name = "cil2_sof1_word4_2";
            desc = "Lane 2 SOF synchronization code (for frame N + 1)";
            sw = rw;
            hw = r;
            reset = 0x0;
        } cil2_sof1_word4_2[31:16];

        field {
            name = "cil2_sof0_word4_2";
            desc = "Lane 2 SOF synchronization code (for frame N)";
            sw = rw;
            hw = r;
            reset = 0x0;
        } cil2_sof0_word4_2[15:0];
    } PHY_SYNC_CODE2_LINK2 @ 0x438;

    reg {
        name = "Link 2 PHY LVDS mode lane 3 _CODE3_LI synchronization header register. NK2";
        desc = "PHY_SYNC_CODE3_LINK2 is link 2 PHY LVDS mode lane 3 synchronization header register. Hi3516A V200 Professional HD IP Camera SoC

Data sheet 9.3.6 PHY_SYNC_CODE3_LINK2 (offset 0x43C, printed page 9-234, `hi3516av200--Hi3516AV200-Datasheet.txt` line 50469).";

        field {
            name = "cil2_sof1_word4_3";
            desc = "Lane 3 SOF synchronization code (for frame N + 1)";
            sw = rw;
            hw = r;
            reset = 0x0;
        } cil2_sof1_word4_3[31:16];

        field {
            name = "cil2_sof0_word4_3";
            desc = "Lane 3 SOF synchronization code (for frame N)";
            sw = rw;
            hw = r;
            reset = 0x0;
        } cil2_sof0_word4_3[15:0];
    } PHY_SYNC_CODE3_LINK2 @ 0x43C;

    reg {
        name = "PHY OUT VALID LINK2";
        desc = "[inferred] PHY OUT VALID LINK2. Not in the data sheet. Source: OpenIPC openhisilicon `kernel/mipi_rx/hi3519v101/mipi_reg.h` (GPL-3.0 repository, HiSilicon copyright; local copy sources/openhisilicon), union `U_PHY_OUT_VALID_LINK`, struct offset 0x440 (GPL-3.0 repository, HiSilicon copyright; one header for Hi3519 V101 and Hi3516A V200). Reset value and access type unknown (modelled RW, no reset). Confidence: medium (vendor header for this chip family, not hardware verified).";

        field {
            name = "cil0_mipi_out_valid";
            desc = "[inferred] Cil0 mipi out valid. (vendor header `hi3519v101/mipi_reg.h` field `cil0_mipi_out_valid`; access and reset unknown, modelled RW)";
            sw = rw;
            hw = r;
        } cil0_mipi_out_valid[7:4];

        field {
            name = "cil0_lvds_out_valid";
            desc = "[inferred] Cil0 lvds out valid. (vendor header `hi3519v101/mipi_reg.h` field `cil0_lvds_out_valid`; access and reset unknown, modelled RW)";
            sw = rw;
            hw = r;
        } cil0_lvds_out_valid[3:0];
    } PHY_OUT_VALID_LINK2 @ 0x440;

    reg {
        name = "PHY DATA LVDS LINK2";
        desc = "[inferred] PHY DATA LVDS LINK2. Not in the data sheet. Source: OpenIPC openhisilicon `kernel/mipi_rx/hi3519v101/mipi_reg.h` (GPL-3.0 repository, HiSilicon copyright; local copy sources/openhisilicon), union `U_PHY_DATA_LVDS_LINK`, struct offset 0x444 (GPL-3.0 repository, HiSilicon copyright; one header for Hi3519 V101 and Hi3516A V200). Reset value and access type unknown (modelled RW, no reset). Confidence: medium (vendor header for this chip family, not hardware verified).";

        field {
            name = "phy0_data3_lvds_hs";
            desc = "[inferred] Phy0 data3 lvds horizontal sync. (vendor header `hi3519v101/mipi_reg.h` field `phy0_data3_lvds_hs`; access and reset unknown, modelled RW)";
            sw = rw;
            hw = r;
        } phy0_data3_lvds_hs[31:24];

        field {
            name = "phy0_data2_lvds_hs";
            desc = "[inferred] Phy0 data2 lvds horizontal sync. (vendor header `hi3519v101/mipi_reg.h` field `phy0_data2_lvds_hs`; access and reset unknown, modelled RW)";
            sw = rw;
            hw = r;
        } phy0_data2_lvds_hs[23:16];

        field {
            name = "phy0_data1_lvds_hs";
            desc = "[inferred] Phy0 data1 lvds horizontal sync. (vendor header `hi3519v101/mipi_reg.h` field `phy0_data1_lvds_hs`; access and reset unknown, modelled RW)";
            sw = rw;
            hw = r;
        } phy0_data1_lvds_hs[15:8];

        field {
            name = "phy0_data0_lvds_hs";
            desc = "[inferred] Phy0 data0 lvds horizontal sync. (vendor header `hi3519v101/mipi_reg.h` field `phy0_data0_lvds_hs`; access and reset unknown, modelled RW)";
            sw = rw;
            hw = r;
        } phy0_data0_lvds_hs[7:0];
    } PHY_DATA_LVDS_LINK2 @ 0x444;

    reg {
        name = "Link 2 MIPI CIL raw interrupt status NT_RAW_LI register NK2";
        desc = "MIPI_CIL_INT_RAW_LINK2 is a link 2 MIPI CIL raw interrupt status register.

Data sheet 9.3.6 MIPI_CIL_INT_RAW_LINK2 (offset 0x5F0, printed page 9-234, `hi3516av200--Hi3516AV200-Datasheet.txt` line 50488).";

        enum MIPI_CIL_INT_RAW_LINK2_err2_timeout_ck_raw_enum {
            NO_RAW_INTERRUPT = 0 { name = "No Raw Interrupt"; desc = "No raw interrupt is generated."; };
            RAW_INTERRUPT_GENERATED = 1 { name = "Raw Interrupt Generated"; desc = "A raw interrupt is generated."; };
        };

        field {
            name = "err2_timeout_ck_raw";
            desc = "Status of the raw FSM timeout interrupt for the clock lane";
            sw = rw;
            hw = w;
            onwrite = woclr;
            encode = MIPI_CIL_INT_RAW_LINK2_err2_timeout_ck_raw_enum;
            reset = 0x0;
        } err2_timeout_ck_raw[12:12];

        enum MIPI_CIL_INT_RAW_LINK2_err2_timeout_d3_raw_enum {
            NO_RAW_INTERRUPT = 0 { name = "No Raw Interrupt"; desc = "No raw interrupt is generated."; };
            RAW_INTERRUPT_GENERATED = 1 { name = "Raw Interrupt Generated"; desc = "A raw interrupt is generated."; };
        };

        field {
            name = "err2_timeout_d3_raw";
            desc = "Status of the raw FSM timeout interrupt for data lane 3";
            sw = rw;
            hw = w;
            onwrite = woclr;
            encode = MIPI_CIL_INT_RAW_LINK2_err2_timeout_d3_raw_enum;
            reset = 0x0;
        } err2_timeout_d3_raw[11:11];

        enum MIPI_CIL_INT_RAW_LINK2_err2_timeout_d2_raw_enum {
            NO_RAW_INTERRUPT = 0 { name = "No Raw Interrupt"; desc = "No raw interrupt is generated."; };
            RAW_INTERRUPT_GENERATED = 1 { name = "Raw Interrupt Generated"; desc = "A raw interrupt is generated."; };
        };

        field {
            name = "err2_timeout_d2_raw";
            desc = "Status of the raw FSM timeout interrupt for data lane 2";
            sw = rw;
            hw = w;
            onwrite = woclr;
            encode = MIPI_CIL_INT_RAW_LINK2_err2_timeout_d2_raw_enum;
            reset = 0x0;
        } err2_timeout_d2_raw[10:10];

        enum MIPI_CIL_INT_RAW_LINK2_err2_timeout_d1_raw_enum {
            NO_RAW_INTERRUPT = 0 { name = "No Raw Interrupt"; desc = "No raw interrupt is generated."; };
            RAW_INTERRUPT_GENERATED = 1 { name = "Raw Interrupt Generated"; desc = "A raw interrupt is generated."; };
        };

        field {
            name = "err2_timeout_d1_raw";
            desc = "Status of the raw FSM timeout interrupt for data lane 1";
            sw = rw;
            hw = w;
            onwrite = woclr;
            encode = MIPI_CIL_INT_RAW_LINK2_err2_timeout_d1_raw_enum;
            reset = 0x0;
        } err2_timeout_d1_raw[9:9];

        enum MIPI_CIL_INT_RAW_LINK2_err2_timeout_d0_raw_enum {
            NO_RAW_INTERRUPT = 0 { name = "No Raw Interrupt"; desc = "No raw interrupt is generated."; };
            RAW_INTERRUPT_GENERATED = 1 { name = "Raw Interrupt Generated"; desc = "A raw interrupt is generated."; };
        };

        field {
            name = "err2_timeout_d0_raw";
            desc = "Status of the raw FSM timeout interrupt for data lane 0";
            sw = rw;
            hw = w;
            onwrite = woclr;
            encode = MIPI_CIL_INT_RAW_LINK2_err2_timeout_d0_raw_enum;
            reset = 0x0;
        } err2_timeout_d0_raw[8:8];

        enum MIPI_CIL_INT_RAW_LINK2_err2_escape_ck_raw_enum {
            NO_RAW_INTERRUPT = 0 { name = "No Raw Interrupt"; desc = "No raw interrupt is generated."; };
            RAW_INTERRUPT_GENERATED = 1 { name = "Raw Interrupt Generated"; desc = "A raw interrupt is generated."; };
        };

        field {
            name = "err2_escape_ck_raw";
            desc = "Status of the raw escape sequence interrupt for the clock lane";
            sw = rw;
            hw = w;
            onwrite = woclr;
            encode = MIPI_CIL_INT_RAW_LINK2_err2_escape_ck_raw_enum;
            reset = 0x0;
        } err2_escape_ck_raw[4:4];

        enum MIPI_CIL_INT_RAW_LINK2_err2_escape_d3_raw_enum {
            NO_RAW_INTERRUPT = 0 { name = "No Raw Interrupt"; desc = "No raw interrupt is generated."; };
            RAW_INTERRUPT_GENERATED = 1 { name = "Raw Interrupt Generated"; desc = "A raw interrupt is generated."; };
        };

        field {
            name = "err2_escape_d3_raw";
            desc = "Status of the raw escape sequence interrupt for data lane 3";
            sw = rw;
            hw = w;
            onwrite = woclr;
            encode = MIPI_CIL_INT_RAW_LINK2_err2_escape_d3_raw_enum;
            reset = 0x0;
        } err2_escape_d3_raw[3:3];

        enum MIPI_CIL_INT_RAW_LINK2_err2_escape_d2_raw_enum {
            NO_RAW_INTERRUPT = 0 { name = "No Raw Interrupt"; desc = "No raw interrupt is generated."; };
            RAW_INTERRUPT_GENERATED = 1 { name = "Raw Interrupt Generated"; desc = "A raw interrupt is generated."; };
        };

        field {
            name = "err2_escape_d2_raw";
            desc = "Status of the raw escape sequence interrupt for data lane 2";
            sw = rw;
            hw = w;
            onwrite = woclr;
            encode = MIPI_CIL_INT_RAW_LINK2_err2_escape_d2_raw_enum;
            reset = 0x0;
        } err2_escape_d2_raw[2:2];

        enum MIPI_CIL_INT_RAW_LINK2_err2_escape_d1_raw_enum {
            NO_RAW_INTERRUPT = 0 { name = "No Raw Interrupt"; desc = "No raw interrupt is generated."; };
            RAW_INTERRUPT_GENERATED = 1 { name = "Raw Interrupt Generated"; desc = "A raw interrupt is generated."; };
        };

        field {
            name = "err2_escape_d1_raw";
            desc = "Status of the raw escape sequence interrupt for data lane 1";
            sw = rw;
            hw = w;
            onwrite = woclr;
            encode = MIPI_CIL_INT_RAW_LINK2_err2_escape_d1_raw_enum;
            reset = 0x0;
        } err2_escape_d1_raw[1:1];

        enum MIPI_CIL_INT_RAW_LINK2_err2_escape_d0_raw_enum {
            NO_RAW_INTERRUPT = 0 { name = "No Raw Interrupt"; desc = "No raw interrupt is generated."; };
            RAW_INTERRUPT_GENERATED = 1 { name = "Raw Interrupt Generated"; desc = "A raw interrupt is generated."; };
        };

        field {
            name = "err2_escape_d0_raw";
            desc = "Status of the raw escape sequence interrupt for data lane 0";
            sw = rw;
            hw = w;
            onwrite = woclr;
            encode = MIPI_CIL_INT_RAW_LINK2_err2_escape_d0_raw_enum;
            reset = 0x0;
        } err2_escape_d0_raw[0:0];
    } MIPI_CIL_INT_RAW_LINK2 @ 0x5F0;

    reg {
        name = "Link 2 MIPI CIL interrupt status register NT_LINK2";
        desc = "MIPI_CIL_INT_LINK2 is a link 2 MIPI CIL interrupt status register. Hi3516A V200 Professional HD IP Camera SoC

Data sheet 9.3.6 MIPI_CIL_INT_LINK2 (offset 0x5F4, printed page 9-236, `hi3516av200--Hi3516AV200-Datasheet.txt` line 50586).";

        enum MIPI_CIL_INT_LINK2_err2_timeout_ck_st_enum {
            NO_INTERRUPT_GENERATED = 0 { name = "No Interrupt Generated"; desc = "No interrupt is generated."; };
            INTERRUPT_GENERATED = 1 { name = "Interrupt Generated"; desc = "An interrupt is generated."; };
        };

        field {
            name = "err2_timeout_ck_st";
            desc = "Status of the FSM timeout interrupt for the clock lane";
            sw = r;
            hw = w;
            encode = MIPI_CIL_INT_LINK2_err2_timeout_ck_st_enum;
            reset = 0x0;
        } err2_timeout_ck_st[12:12];

        enum MIPI_CIL_INT_LINK2_err2_timeout_d3_st_enum {
            NO_INTERRUPT_GENERATED = 0 { name = "No Interrupt Generated"; desc = "No interrupt is generated."; };
            INTERRUPT_GENERATED = 1 { name = "Interrupt Generated"; desc = "An interrupt is generated."; };
        };

        field {
            name = "err2_timeout_d3_st";
            desc = "Status of the FSM timeout interrupt for data lane 3";
            sw = r;
            hw = w;
            encode = MIPI_CIL_INT_LINK2_err2_timeout_d3_st_enum;
            reset = 0x0;
        } err2_timeout_d3_st[11:11];

        enum MIPI_CIL_INT_LINK2_err2_timeout_d2_st_enum {
            NO_INTERRUPT_GENERATED = 0 { name = "No Interrupt Generated"; desc = "No interrupt is generated."; };
            INTERRUPT_GENERATED = 1 { name = "Interrupt Generated"; desc = "An interrupt is generated."; };
        };

        field {
            name = "err2_timeout_d2_st";
            desc = "Status of the FSM timeout interrupt for data lane 2";
            sw = r;
            hw = w;
            encode = MIPI_CIL_INT_LINK2_err2_timeout_d2_st_enum;
            reset = 0x0;
        } err2_timeout_d2_st[10:10];

        enum MIPI_CIL_INT_LINK2_err2_timeout_d1_st_enum {
            NO_INTERRUPT_GENERATED = 0 { name = "No Interrupt Generated"; desc = "No interrupt is generated."; };
            INTERRUPT_GENERATED = 1 { name = "Interrupt Generated"; desc = "An interrupt is generated."; };
        };

        field {
            name = "err2_timeout_d1_st";
            desc = "Status of the FSM timeout interrupt for data lane 1";
            sw = r;
            hw = w;
            encode = MIPI_CIL_INT_LINK2_err2_timeout_d1_st_enum;
            reset = 0x0;
        } err2_timeout_d1_st[9:9];

        enum MIPI_CIL_INT_LINK2_err2_timeout_d0_st_enum {
            NO_INTERRUPT_GENERATED = 0 { name = "No Interrupt Generated"; desc = "No interrupt is generated."; };
            INTERRUPT_GENERATED = 1 { name = "Interrupt Generated"; desc = "An interrupt is generated."; };
        };

        field {
            name = "err2_timeout_d0_st";
            desc = "Status of the FSM timeout interrupt for data lane 0";
            sw = r;
            hw = w;
            encode = MIPI_CIL_INT_LINK2_err2_timeout_d0_st_enum;
            reset = 0x0;
        } err2_timeout_d0_st[8:8];

        enum MIPI_CIL_INT_LINK2_err2_escape_ck_st_enum {
            NO_INTERRUPT_GENERATED = 0 { name = "No Interrupt Generated"; desc = "No interrupt is generated."; };
            INTERRUPT_GENERATED = 1 { name = "Interrupt Generated"; desc = "An interrupt is generated."; };
        };

        field {
            name = "err2_escape_ck_st";
            desc = "Status of the escape sequence interrupt for the clock lane";
            sw = r;
            hw = w;
            encode = MIPI_CIL_INT_LINK2_err2_escape_ck_st_enum;
            reset = 0x0;
        } err2_escape_ck_st[4:4];

        enum MIPI_CIL_INT_LINK2_err2_escape_d3_st_enum {
            NO_INTERRUPT_GENERATED = 0 { name = "No Interrupt Generated"; desc = "No interrupt is generated."; };
            INTERRUPT_GENERATED = 1 { name = "Interrupt Generated"; desc = "An interrupt is generated."; };
        };

        field {
            name = "err2_escape_d3_st";
            desc = "Status of the escape sequence interrupt for data lane 3";
            sw = r;
            hw = w;
            encode = MIPI_CIL_INT_LINK2_err2_escape_d3_st_enum;
            reset = 0x0;
        } err2_escape_d3_st[3:3];

        enum MIPI_CIL_INT_LINK2_err2_escape_d2_st_enum {
            NO_INTERRUPT_GENERATED = 0 { name = "No Interrupt Generated"; desc = "No interrupt is generated."; };
            INTERRUPT_GENERATED = 1 { name = "Interrupt Generated"; desc = "An interrupt is generated."; };
        };

        field {
            name = "err2_escape_d2_st";
            desc = "Status of the escape sequence interrupt for data lane 2";
            sw = r;
            hw = w;
            encode = MIPI_CIL_INT_LINK2_err2_escape_d2_st_enum;
            reset = 0x0;
        } err2_escape_d2_st[2:2];

        enum MIPI_CIL_INT_LINK2_err2_escape_d1_st_enum {
            NO_INTERRUPT_GENERATED = 0 { name = "No Interrupt Generated"; desc = "No interrupt is generated."; };
            INTERRUPT_GENERATED = 1 { name = "Interrupt Generated"; desc = "An interrupt is generated."; };
        };

        field {
            name = "err2_escape_d1_st";
            desc = "Status of the escape sequence interrupt for data lane 1";
            sw = r;
            hw = w;
            encode = MIPI_CIL_INT_LINK2_err2_escape_d1_st_enum;
            reset = 0x0;
        } err2_escape_d1_st[1:1];

        enum MIPI_CIL_INT_LINK2_err2_escape_d0_st_enum {
            NO_INTERRUPT_GENERATED = 0 { name = "No Interrupt Generated"; desc = "No interrupt is generated."; };
            INTERRUPT_GENERATED = 1 { name = "Interrupt Generated"; desc = "An interrupt is generated."; };
        };

        field {
            name = "err2_escape_d0_st";
            desc = "Status of the escape sequence interrupt for data lane 0";
            sw = r;
            hw = w;
            encode = MIPI_CIL_INT_LINK2_err2_escape_d0_st_enum;
            reset = 0x0;
        } err2_escape_d0_st[0:0];
    } MIPI_CIL_INT_LINK2 @ 0x5F4;

    reg {
        name = "Link 2 MIPI CIL interrupt mask register NT_MSK_LI NK2";
        desc = "MIPI_CIL_INT_MSK_LINK2 is a link 2 MIPI CIL interrupt mask register.

Data sheet 9.3.6 MIPI_CIL_INT_MSK_LINK2 (offset 0x5F8, printed page 9-237, `hi3516av200--Hi3516AV200-Datasheet.txt` line 50654).";

        enum MIPI_CIL_INT_MSK_LINK2_err2_timeout_ck_msk_enum {
            MASKED = 0 { name = "Masked"; desc = "masked"; };
            ENABLED = 1 { name = "Enabled"; desc = "enabled"; };
        };

        field {
            name = "err2_timeout_ck_msk";
            desc = "Enable of the FSM timeout interrupt for the clock lane";
            sw = rw;
            hw = r;
            encode = MIPI_CIL_INT_MSK_LINK2_err2_timeout_ck_msk_enum;
            reset = 0x0;
        } err2_timeout_ck_msk[12:12];

        enum MIPI_CIL_INT_MSK_LINK2_err2_timeout_d3_msk_enum {
            MASKED = 0 { name = "Masked"; desc = "masked"; };
            ENABLED = 1 { name = "Enabled"; desc = "enabled"; };
        };

        field {
            name = "err2_timeout_d3_msk";
            desc = "Enable of the FSM timeout interrupt for data lane 3";
            sw = rw;
            hw = r;
            encode = MIPI_CIL_INT_MSK_LINK2_err2_timeout_d3_msk_enum;
            reset = 0x0;
        } err2_timeout_d3_msk[11:11];

        enum MIPI_CIL_INT_MSK_LINK2_err2_timeout_d2_msk_enum {
            MASKED = 0 { name = "Masked"; desc = "masked"; };
            ENABLED = 1 { name = "Enabled"; desc = "enabled"; };
        };

        field {
            name = "err2_timeout_d2_msk";
            desc = "Enable of the FSM timeout interrupt for data lane 2";
            sw = rw;
            hw = r;
            encode = MIPI_CIL_INT_MSK_LINK2_err2_timeout_d2_msk_enum;
            reset = 0x0;
        } err2_timeout_d2_msk[10:10];

        enum MIPI_CIL_INT_MSK_LINK2_err2_timeout_d1_msk_enum {
            MASKED = 0 { name = "Masked"; desc = "masked"; };
            ENABLED = 1 { name = "Enabled"; desc = "enabled"; };
        };

        field {
            name = "err2_timeout_d1_msk";
            desc = "Enable of the FSM timeout interrupt for data lane 1";
            sw = rw;
            hw = r;
            encode = MIPI_CIL_INT_MSK_LINK2_err2_timeout_d1_msk_enum;
            reset = 0x0;
        } err2_timeout_d1_msk[9:9];

        enum MIPI_CIL_INT_MSK_LINK2_err2_timeout_d0_msk_enum {
            MASKED = 0 { name = "Masked"; desc = "masked"; };
            ENABLED = 1 { name = "Enabled"; desc = "enabled"; };
        };

        field {
            name = "err2_timeout_d0_msk";
            desc = "Enable of the FSM timeout interrupt for data lane 0";
            sw = rw;
            hw = r;
            encode = MIPI_CIL_INT_MSK_LINK2_err2_timeout_d0_msk_enum;
            reset = 0x0;
        } err2_timeout_d0_msk[8:8];

        enum MIPI_CIL_INT_MSK_LINK2_err2_escape_ck_msk_enum {
            MASKED = 0 { name = "Masked"; desc = "masked"; };
            ENABLED = 1 { name = "Enabled"; desc = "enabled"; };
        };

        field {
            name = "err2_escape_ck_msk";
            desc = "Enable of the escape sequence interrupt for the clock lane";
            sw = rw;
            hw = r;
            encode = MIPI_CIL_INT_MSK_LINK2_err2_escape_ck_msk_enum;
            reset = 0x0;
        } err2_escape_ck_msk[4:4];

        enum MIPI_CIL_INT_MSK_LINK2_err2_escape_d3_msk_enum {
            MASKED = 0 { name = "Masked"; desc = "masked"; };
            ENABLED = 1 { name = "Enabled"; desc = "enabled"; };
        };

        field {
            name = "err2_escape_d3_msk";
            desc = "Enable of the escape sequence interrupt for data lane 3";
            sw = rw;
            hw = r;
            encode = MIPI_CIL_INT_MSK_LINK2_err2_escape_d3_msk_enum;
            reset = 0x0;
        } err2_escape_d3_msk[3:3];

        enum MIPI_CIL_INT_MSK_LINK2_err2_escape_d2_msk_enum {
            MASKED = 0 { name = "Masked"; desc = "masked"; };
            ENABLED = 1 { name = "Enabled"; desc = "enabled"; };
        };

        field {
            name = "err2_escape_d2_msk";
            desc = "Enable of the escape sequence interrupt for data lane 2";
            sw = rw;
            hw = r;
            encode = MIPI_CIL_INT_MSK_LINK2_err2_escape_d2_msk_enum;
            reset = 0x0;
        } err2_escape_d2_msk[2:2];

        enum MIPI_CIL_INT_MSK_LINK2_err2_escape_d1_msk_enum {
            MASKED = 0 { name = "Masked"; desc = "masked"; };
            ENABLED = 1 { name = "Enabled"; desc = "enabled"; };
        };

        field {
            name = "err2_escape_d1_msk";
            desc = "Enable of the escape sequence interrupt for data lane 1";
            sw = rw;
            hw = r;
            encode = MIPI_CIL_INT_MSK_LINK2_err2_escape_d1_msk_enum;
            reset = 0x0;
        } err2_escape_d1_msk[1:1];

        enum MIPI_CIL_INT_MSK_LINK2_err2_escape_d0_msk_enum {
            MASKED = 0 { name = "Masked"; desc = "masked"; };
            ENABLED = 1 { name = "Enabled"; desc = "enabled"; };
        };

        field {
            name = "err2_escape_d0_msk";
            desc = "Enable of the escape sequence interrupt for data lane 0";
            sw = rw;
            hw = r;
            encode = MIPI_CIL_INT_MSK_LINK2_err2_escape_d0_msk_enum;
            reset = 0x0;
        } err2_escape_d0_msk[0:0];
    } MIPI_CIL_INT_MSK_LINK2 @ 0x5F8;

    reg {
        name = "PHY ID selection register";
        desc = "PHY_ID is a PHY ID selection register.

Data sheet 9.3.6 PHY_ID (offset 0x800, printed page 9-238, `hi3516av200--Hi3516AV200-Datasheet.txt` line 50741).";

        field {
            name = "phy1_id";
            desc = "[inferred] Phy1 id. (bits reserved in the data sheet; vendor header `hi3519v101/mipi_reg.h` field `phy1_id`; access and reset unknown, modelled RW)";
            sw = rw;
            hw = r;
        } phy1_id[4:4];

        enum PHY_ID_phy2_id_enum {
            CLOCK_DATA_OUTPUT = 0 { name = "Clock Data Output"; desc = "The clock and data output by PHY 2 are sent to the sensor 0 channel."; };
            CLOCK_DATA_OUTPUT_2 = 1 { name = "Clock Data Output 2"; desc = "The clock and data output by PHY 2 are sent to the sensor 1 channel."; };
        };

        field {
            name = "phy2_id";
            desc = "PHY 2 ID select";
            sw = rw;
            hw = r;
            encode = PHY_ID_phy2_id_enum;
            reset = 0x0;
        } phy2_id[0:0];
    } PHY_ID @ 0x800;

    reg {
        name = "PHY 1 LP mode signal selection register LECT";
        desc = "PHY_LP_SELECT is a PHY 1 LP mode signal selection register.

Data sheet 9.3.6 PHY_LP_SELECT (offset 0x804, printed page 9-239, `hi3516av200--Hi3516AV200-Datasheet.txt` line 50779).";

        enum PHY_LP_SELECT_phy1_lp_sel_enum {
            PHY_1_LP = 0 { name = "Phy 1 Lp"; desc = "The PHY 1 LP signal comes from PHY 1."; };
            PHY_1_LP_2 = 1 { name = "Phy 1 Lp 2"; desc = "The PHY 1 LP signal comes from PHY 0."; };
        };

        field {
            name = "phy1_lp_sel";
            desc = "PHY 1 LP mode signal select";
            sw = rw;
            hw = r;
            encode = PHY_LP_SELECT_phy1_lp_sel_enum;
            reset = 0x0;
        } phy1_lp_sel[0:0];
    } PHY_LP_SELECT @ 0x804;

    reg {
        name = "CHN0 PHY enable register EN";
        desc = "CHN0_PHY_EN is a CHN0 PHY enable register.

Data sheet 9.3.6 CHN0_PHY_EN (offset 0x810, printed page 9-239, `hi3516av200--Hi3516AV200-Datasheet.txt` line 50808).";

        enum CHN0_PHY_EN_phy2_en_enum {
            DISABLED = 0 { name = "Disabled"; desc = "disabled"; };
            ENABLED = 1 { name = "Enabled"; desc = "enabled"; };
        };

        field {
            name = "phy2_en";
            desc = "PHY 2 enable";
            sw = rw;
            hw = r;
            encode = CHN0_PHY_EN_phy2_en_enum;
            reset = 0x0;
        } phy2_en[2:2];

        enum CHN0_PHY_EN_phy1_en_enum {
            DISABLED = 0 { name = "Disabled"; desc = "disabled"; };
            ENABLED = 1 { name = "Enabled"; desc = "enabled"; };
        };

        field {
            name = "phy1_en";
            desc = "PHY 1 enable";
            sw = rw;
            hw = r;
            encode = CHN0_PHY_EN_phy1_en_enum;
            reset = 0x0;
        } phy1_en[1:1];

        enum CHN0_PHY_EN_phy0_en_enum {
            DISABLED = 0 { name = "Disabled"; desc = "disabled"; };
            ENABLED = 1 { name = "Enabled"; desc = "enabled"; };
        };

        field {
            name = "phy0_en";
            desc = "PHY 0 enable";
            sw = rw;
            hw = r;
            encode = CHN0_PHY_EN_phy0_en_enum;
            reset = 0x0;
        } phy0_en[0:0];
    } CHN0_PHY_EN @ 0x810;

    reg {
        name = "CHN0 horizontal sync CK SELECT";
        desc = "[inferred] CHN0 horizontal sync CK SELECT. Not in the data sheet. Source: OpenIPC openhisilicon `kernel/mipi_rx/hi3519v101/mipi_reg.h` (GPL-3.0 repository, HiSilicon copyright; local copy sources/openhisilicon), union `U_CHN0_HS_CK_SELECT`, struct offset 0x814 (GPL-3.0 repository, HiSilicon copyright; one header for Hi3519 V101 and Hi3516A V200). Reset value and access type unknown (modelled RW, no reset). Confidence: medium (vendor header for this chip family, not hardware verified).";

        field {
            name = "hs2_ck_sel";
            desc = "[inferred] Hs2 ck select. (vendor header `hi3519v101/mipi_reg.h` field `hs2_ck_sel`; access and reset unknown, modelled RW)";
            sw = rw;
            hw = r;
        } hs2_ck_sel[8:8];

        field {
            name = "hs1_ck_sel";
            desc = "[inferred] Hs1 ck select. (vendor header `hi3519v101/mipi_reg.h` field `hs1_ck_sel`; access and reset unknown, modelled RW)";
            sw = rw;
            hw = r;
        } hs1_ck_sel[4:4];

        field {
            name = "hs0_ck_sel";
            desc = "[inferred] Hs0 ck select. (vendor header `hi3519v101/mipi_reg.h` field `hs0_ck_sel`; access and reset unknown, modelled RW)";
            sw = rw;
            hw = r;
        } hs0_ck_sel[0:0];
    } CHN0_HS_CK_SELECT @ 0x814;

    reg {
        name = "CHN0 memory control register _CTRL";
        desc = "CHN0_MEM_CTRL is a CHN0 memory control register.

Data sheet 9.3.6 CHN0_MEM_CTRL (offset 0x818, printed page 9-240, `hi3516av200--Hi3516AV200-Datasheet.txt` line 50849).";

        enum CHN0_MEM_CTRL_mem_ck_gt_enum {
            DISABLED = 0 { name = "Disabled"; desc = "disabled"; };
            ENABLED_MEMORY_PORT = 1 { name = "Enabled Memory Port"; desc = "enabled. The memory port clock is not inverted when the memory is not read or written."; };
        };

        field {
            name = "mem_ck_gt";
            desc = "CHN0 memory clock gating enable";
            sw = rw;
            hw = r;
            encode = CHN0_MEM_CTRL_mem_ck_gt_enum;
            reset = 0x0;
        } mem_ck_gt[12:12];

        field {
            name = "mem_emab";
            desc = "[inferred] Mem emab. (bits reserved in the data sheet; vendor header `hi3519v101/mipi_reg.h` field `mem_emab`; access and reset unknown, modelled RW)";
            sw = rw;
            hw = r;
        } mem_emab[10:8];

        field {
            name = "mem_emaa";
            desc = "[inferred] Mem emaa. (bits reserved in the data sheet; vendor header `hi3519v101/mipi_reg.h` field `mem_emaa`; access and reset unknown, modelled RW)";
            sw = rw;
            hw = r;
        } mem_emaa[6:4];

        field {
            name = "mem_ret1n";
            desc = "[inferred] Mem ret1n. (bits reserved in the data sheet; vendor header `hi3519v101/mipi_reg.h` field `mem_ret1n`; access and reset unknown, modelled RW)";
            sw = rw;
            hw = r;
        } mem_ret1n[0:0];
    } CHN0_MEM_CTRL @ 0x818;

    reg {
        name = "CHN0 lane enable register E_EN";
        desc = "CHN0_LANE_EN is a CHN0 lane enable register. Hi3516A V200 Professional HD IP Camera SoC

Data sheet 9.3.6 CHN0_LANE_EN (offset 0x81C, printed page 9-241, `hi3516av200--Hi3516AV200-Datasheet.txt` line 50889).";

        enum CHN0_LANE_EN_lane11_en_enum {
            DISABLED = 0 { name = "Disabled"; desc = "disabled"; };
            ENABLED = 1 { name = "Enabled"; desc = "enabled"; };
        };

        field {
            name = "lane11_en";
            desc = "Lane 11 enable";
            sw = rw;
            hw = r;
            encode = CHN0_LANE_EN_lane11_en_enum;
            reset = 0x0;
        } lane11_en[11:11];

        enum CHN0_LANE_EN_lane10_en_enum {
            DISABLED = 0 { name = "Disabled"; desc = "disabled"; };
            ENABLED = 1 { name = "Enabled"; desc = "enabled"; };
        };

        field {
            name = "lane10_en";
            desc = "Lane 10 enable";
            sw = rw;
            hw = r;
            encode = CHN0_LANE_EN_lane10_en_enum;
            reset = 0x0;
        } lane10_en[10:10];

        enum CHN0_LANE_EN_lane9_en_enum {
            DISABLED = 0 { name = "Disabled"; desc = "disabled"; };
            ENABLED = 1 { name = "Enabled"; desc = "enabled"; };
        };

        field {
            name = "lane9_en";
            desc = "Lane 9 enable";
            sw = rw;
            hw = r;
            encode = CHN0_LANE_EN_lane9_en_enum;
            reset = 0x0;
        } lane9_en[9:9];

        enum CHN0_LANE_EN_lane8_en_enum {
            DISABLED = 0 { name = "Disabled"; desc = "disabled"; };
            ENABLED = 1 { name = "Enabled"; desc = "enabled"; };
        };

        field {
            name = "lane8_en";
            desc = "Lane 8 enable";
            sw = rw;
            hw = r;
            encode = CHN0_LANE_EN_lane8_en_enum;
            reset = 0x0;
        } lane8_en[8:8];

        enum CHN0_LANE_EN_lane7_en_enum {
            DISABLED = 0 { name = "Disabled"; desc = "disabled"; };
            ENABLED = 1 { name = "Enabled"; desc = "enabled"; };
        };

        field {
            name = "lane7_en";
            desc = "Lane 7 enable";
            sw = rw;
            hw = r;
            encode = CHN0_LANE_EN_lane7_en_enum;
            reset = 0x0;
        } lane7_en[7:7];

        enum CHN0_LANE_EN_lane6_en_enum {
            DISABLED = 0 { name = "Disabled"; desc = "disabled"; };
            ENABLED = 1 { name = "Enabled"; desc = "enabled"; };
        };

        field {
            name = "lane6_en";
            desc = "Lane 6 enable";
            sw = rw;
            hw = r;
            encode = CHN0_LANE_EN_lane6_en_enum;
            reset = 0x0;
        } lane6_en[6:6];

        enum CHN0_LANE_EN_lane5_en_enum {
            DISABLED = 0 { name = "Disabled"; desc = "disabled"; };
            ENABLED = 1 { name = "Enabled"; desc = "enabled"; };
        };

        field {
            name = "lane5_en";
            desc = "Lane 5 enable";
            sw = rw;
            hw = r;
            encode = CHN0_LANE_EN_lane5_en_enum;
            reset = 0x0;
        } lane5_en[5:5];

        enum CHN0_LANE_EN_lane4_en_enum {
            DISABLED = 0 { name = "Disabled"; desc = "disabled"; };
            ENABLED = 1 { name = "Enabled"; desc = "enabled"; };
        };

        field {
            name = "lane4_en";
            desc = "Lane 4 enable";
            sw = rw;
            hw = r;
            encode = CHN0_LANE_EN_lane4_en_enum;
            reset = 0x0;
        } lane4_en[4:4];

        enum CHN0_LANE_EN_lane3_en_enum {
            DISABLED = 0 { name = "Disabled"; desc = "disabled"; };
            ENABLED = 1 { name = "Enabled"; desc = "enabled"; };
        };

        field {
            name = "lane3_en";
            desc = "Lane 3 enable";
            sw = rw;
            hw = r;
            encode = CHN0_LANE_EN_lane3_en_enum;
            reset = 0x0;
        } lane3_en[3:3];

        enum CHN0_LANE_EN_lane2_en_enum {
            DISABLED = 0 { name = "Disabled"; desc = "disabled"; };
            ENABLED = 1 { name = "Enabled"; desc = "enabled"; };
        };

        field {
            name = "lane2_en";
            desc = "Lane 2 enable";
            sw = rw;
            hw = r;
            encode = CHN0_LANE_EN_lane2_en_enum;
            reset = 0x0;
        } lane2_en[2:2];

        enum CHN0_LANE_EN_lane1_en_enum {
            DISABLED = 0 { name = "Disabled"; desc = "disabled"; };
            ENABLED = 1 { name = "Enabled"; desc = "enabled"; };
        };

        field {
            name = "lane1_en";
            desc = "Lane 1 enable";
            sw = rw;
            hw = r;
            encode = CHN0_LANE_EN_lane1_en_enum;
            reset = 0x0;
        } lane1_en[1:1];

        enum CHN0_LANE_EN_lane0_en_enum {
            DISABLED = 0 { name = "Disabled"; desc = "disabled"; };
            ENABLED = 1 { name = "Enabled"; desc = "enabled"; };
        };

        field {
            name = "lane0_en";
            desc = "Lane 0 enable";
            sw = rw;
            hw = r;
            encode = CHN0_LANE_EN_lane0_en_enum;
            reset = 0x0;
        } lane0_en[0:0];
    } CHN0_LANE_EN @ 0x81C;

    reg {
        name = "CHN0 PHY configuration mode register CFG_MODE";
        desc = "CHN0_PHYCFG_MODE is a CHN0 PHY configuration mode register.

Data sheet 9.3.6 CHN0_PHYCFG_MODE (offset 0x820, printed page 9-242, `hi3516av200--Hi3516AV200-Datasheet.txt` line 50960).";

        enum CHN0_PHYCFG_MODE_chn0_phycfg_mode_enum {
            PHY_CONFIGURATION_CONTROLLED = 0 { name = "Phy Configuration Controlled"; desc = "The PHY configuration is controlled by PHYCFG_EN and FSM."; };
            PHY_CONFIGURATION_CONTROLLED_2 = 1 { name = "Phy Configuration Controlled 2"; desc = "The PHY configuration is controlled by PHYCFG_EN."; };
            PHY_CONFIGURATION_DIRECTLY = 2 { name = "Phy Configuration Directly"; desc = "The PHY configuration is directly controlled by the value of the register."; };
            PHY_CONFIGURATION_CONTROLLED_3 = 3 { name = "Phy Configuration Controlled 3"; desc = "The PHY configuration is controlled by the value of ther register and FSM."; };
            PHY_CONFIGURATION_CONTROLLED_4 = 4 { name = "Phy Configuration Controlled 4"; desc = "The PHY configuration is controlled by PHYCFG_EN and FSM, and the clock channel enable is controlled by PHYCFG_EN. Other values: reserved"; };
        };

        field {
            name = "chn0_phycfg_mode";
            desc = "CHN0 PHY configuration mode";
            sw = rw;
            hw = r;
            encode = CHN0_PHYCFG_MODE_chn0_phycfg_mode_enum;
            reset = 0x0;
        } chn0_phycfg_mode[2:0];
    } CHN0_PHYCFG_MODE @ 0x820;

    reg {
        name = "CHN0 PHY configuration enable register CFG_EN";
        desc = "CHN0_PHYCFG_EN is a CHN0 PHY configuration enable register.

Data sheet 9.3.6 CHN0_PHYCFG_EN (offset 0x824, printed page 9-243, `hi3516av200--Hi3516AV200-Datasheet.txt` line 51003).";

        enum CHN0_PHYCFG_EN_chn0_phycfg_en_enum {
            DISABLED = 0 { name = "Disabled"; desc = "disabled"; };
            ENABLED = 1 { name = "Enabled"; desc = "enabled"; };
        };

        field {
            name = "chn0_phycfg_en";
            desc = "CHN0 PHY configuration enable";
            sw = w;
            hw = r;
            encode = CHN0_PHYCFG_EN_chn0_phycfg_en_enum;
            reset = 0x0;
        } chn0_phycfg_en[0:0];
    } CHN0_PHYCFG_EN @ 0x824;

    reg {
        name = "CHN0 forcible assert enable register EN";
        desc = "CHN0_CLR_EN is a CHN0 forcible assert enable register.

Data sheet 9.3.6 CHN0_CLR_EN (offset 0x828, printed page 9-243, `hi3516av200--Hi3516AV200-Datasheet.txt` line 51032).";

        enum CHN0_CLR_EN_clr_en_align0_enum {
            ALIGN_0_ASSERT = 0 { name = "Align 0 Assert"; desc = "The ALIGN 0 assert request is disabled."; };
            ALIGN_0_ASSERT_2 = 1 { name = "Align 0 Assert 2"; desc = "The ALIGN 0 assert request is enabled."; };
        };

        field {
            name = "clr_en_align0";
            desc = "Forcible assert control for the LVDS 0 PRE SYNC module";
            sw = rw;
            hw = r;
            encode = CHN0_CLR_EN_clr_en_align0_enum;
            reset = 0x0;
        } clr_en_align0[1:1];

        enum CHN0_CLR_EN_clr_en_lvds0_enum {
            LVDS_0_CTRL = 0 { name = "Lvds 0 Ctrl"; desc = "The LVDS 0 CTRL assert request is disabled."; };
            LVDS_0_CTRL_2 = 1 { name = "Lvds 0 Ctrl 2"; desc = "The LVDS 0 CTRL assert request is enabled."; };
        };

        field {
            name = "clr_en_lvds0";
            desc = "Forcible assert control for the LVDS 0 PRE SYNC module";
            sw = rw;
            hw = r;
            encode = CHN0_CLR_EN_clr_en_lvds0_enum;
            reset = 0x0;
        } clr_en_lvds0[0:0];
    } CHN0_CLR_EN @ 0x828;

    reg {
        name = "CHN0 CIL control register CTRL";
        desc = "CHN0_CIL_CTRL is a CHN0 CIL control register.

Data sheet 9.3.6 CHN0_CIL_CTRL (offset 0x82C, printed page 9-244, `hi3516av200--Hi3516AV200-Datasheet.txt` line 51073).";

        enum CHN0_CIL_CTRL_phycil2_cken_enum {
            DISABLED = 0 { name = "Disabled"; desc = "disabled"; };
            ENABLED = 1 { name = "Enabled"; desc = "enabled"; };
        };

        field {
            name = "phycil2_cken";
            desc = "PHYCIL 2 clock gating";
            sw = rw;
            hw = r;
            encode = CHN0_CIL_CTRL_phycil2_cken_enum;
            reset = 0x0;
        } phycil2_cken[2:2];

        enum CHN0_CIL_CTRL_phycil1_cken_enum {
            DISABLED = 0 { name = "Disabled"; desc = "disabled"; };
            ENABLED = 1 { name = "Enabled"; desc = "enabled"; };
        };

        field {
            name = "phycil1_cken";
            desc = "PHYCIL 1 clock gating";
            sw = rw;
            hw = r;
            encode = CHN0_CIL_CTRL_phycil1_cken_enum;
            reset = 0x0;
        } phycil1_cken[1:1];

        enum CHN0_CIL_CTRL_phycil0_cken_enum {
            DISABLED = 0 { name = "Disabled"; desc = "disabled"; };
            ENABLED = 1 { name = "Enabled"; desc = "enabled"; };
        };

        field {
            name = "phycil0_cken";
            desc = "PHYCIL 0 clock gating";
            sw = rw;
            hw = r;
            encode = CHN0_CIL_CTRL_phycil0_cken_enum;
            reset = 0x0;
        } phycil0_cken[0:0];
    } CHN0_CIL_CTRL @ 0x82C;

    reg {
        name = "CHN1 PHY enable register EN";
        desc = "CHN1_PHY_EN is a CHN1 PHY enable register. Hi3516A V200 Professional HD IP Camera SoC

Data sheet 9.3.6 CHN1_PHY_EN (offset 0x830, printed page 9-245, `hi3516av200--Hi3516AV200-Datasheet.txt` line 51118).";

        field {
            name = "lane11_en";
            desc = "[inferred] Lane11 enable. (bits reserved in the data sheet; vendor header `hi3519v101/mipi_reg.h` field `lane11_en`; access and reset unknown, modelled RW)";
            sw = rw;
            hw = r;
        } lane11_en[11:11];

        field {
            name = "lane10_en";
            desc = "[inferred] Lane10 enable. (bits reserved in the data sheet; vendor header `hi3519v101/mipi_reg.h` field `lane10_en`; access and reset unknown, modelled RW)";
            sw = rw;
            hw = r;
        } lane10_en[10:10];

        field {
            name = "lane9_en";
            desc = "[inferred] Lane9 enable. (bits reserved in the data sheet; vendor header `hi3519v101/mipi_reg.h` field `lane9_en`; access and reset unknown, modelled RW)";
            sw = rw;
            hw = r;
        } lane9_en[9:9];

        field {
            name = "lane8_en";
            desc = "[inferred] Lane8 enable. (bits reserved in the data sheet; vendor header `hi3519v101/mipi_reg.h` field `lane8_en`; access and reset unknown, modelled RW)";
            sw = rw;
            hw = r;
        } lane8_en[8:8];

        field {
            name = "lane7_en";
            desc = "[inferred] Lane7 enable. (bits reserved in the data sheet; vendor header `hi3519v101/mipi_reg.h` field `lane7_en`; access and reset unknown, modelled RW)";
            sw = rw;
            hw = r;
        } lane7_en[7:7];

        field {
            name = "lane6_en";
            desc = "[inferred] Lane6 enable. (bits reserved in the data sheet; vendor header `hi3519v101/mipi_reg.h` field `lane6_en`; access and reset unknown, modelled RW)";
            sw = rw;
            hw = r;
        } lane6_en[6:6];

        field {
            name = "lane5_en";
            desc = "[inferred] Lane5 enable. (bits reserved in the data sheet; vendor header `hi3519v101/mipi_reg.h` field `lane5_en`; access and reset unknown, modelled RW)";
            sw = rw;
            hw = r;
        } lane5_en[5:5];

        field {
            name = "lane4_en";
            desc = "[inferred] Lane4 enable. (bits reserved in the data sheet; vendor header `hi3519v101/mipi_reg.h` field `lane4_en`; access and reset unknown, modelled RW)";
            sw = rw;
            hw = r;
        } lane4_en[4:4];

        field {
            name = "lane3_en";
            desc = "[inferred] Lane3 enable. (bits reserved in the data sheet; vendor header `hi3519v101/mipi_reg.h` field `lane3_en`; access and reset unknown, modelled RW)";
            sw = rw;
            hw = r;
        } lane3_en[3:3];

        field {
            name = "lane2_en";
            desc = "[inferred] Lane2 enable. (bits reserved in the data sheet; vendor header `hi3519v101/mipi_reg.h` field `lane2_en`; access and reset unknown, modelled RW)";
            sw = rw;
            hw = r;
        } lane2_en[2:2];

        field {
            name = "lane1_en";
            desc = "[inferred] Lane1 enable. (bits reserved in the data sheet; vendor header `hi3519v101/mipi_reg.h` field `lane1_en`; access and reset unknown, modelled RW)";
            sw = rw;
            hw = r;
        } lane1_en[1:1];

        enum CHN1_PHY_EN_chn1_phy2_en_enum {
            DISABLED = 0 { name = "Disabled"; desc = "disabled"; };
            ENABLED = 1 { name = "Enabled"; desc = "enabled"; };
        };

        field {
            name = "chn1_phy2_en";
            desc = "CHN1 PHY 2 enable";
            sw = rw;
            hw = r;
            encode = CHN1_PHY_EN_chn1_phy2_en_enum;
            reset = 0x0;
        } chn1_phy2_en[0:0];
    } CHN1_PHY_EN @ 0x830;

    reg {
        name = "CHN1 horizontal sync CK SELECT";
        desc = "[inferred] CHN1 horizontal sync CK SELECT. Not in the data sheet. Source: OpenIPC openhisilicon `kernel/mipi_rx/hi3519v101/mipi_reg.h` (GPL-3.0 repository, HiSilicon copyright; local copy sources/openhisilicon), union `U_CHN1_HS_CK_SELECT`, struct offset 0x834 (GPL-3.0 repository, HiSilicon copyright; one header for Hi3519 V101 and Hi3516A V200). Reset value and access type unknown (modelled RW, no reset). Confidence: medium (vendor header for this chip family, not hardware verified).";

        field {
            name = "chn1_hs1_ck_sel";
            desc = "[inferred] Chn1 hs1 ck select. (vendor header `hi3519v101/mipi_reg.h` field `chn1_hs1_ck_sel`; access and reset unknown, modelled RW)";
            sw = rw;
            hw = r;
        } chn1_hs1_ck_sel[4:4];

        field {
            name = "chn1_hs2_ck_sel";
            desc = "[inferred] Chn1 hs2 ck select. (vendor header `hi3519v101/mipi_reg.h` field `chn1_hs2_ck_sel`; access and reset unknown, modelled RW)";
            sw = rw;
            hw = r;
        } chn1_hs2_ck_sel[0:0];
    } CHN1_HS_CK_SELECT @ 0x834;

    reg {
        name = "CHN1 memory control register _CTRL";
        desc = "CHN1_MEM_CTRL is a CHN1 memory control register.

Data sheet 9.3.6 CHN1_MEM_CTRL (offset 0x838, printed page 9-245, `hi3516av200--Hi3516AV200-Datasheet.txt` line 51147).";

        enum CHN1_MEM_CTRL_chn1_mem_ck_gt_enum {
            DISABLED = 0 { name = "Disabled"; desc = "disabled"; };
            ENABLED_MEMORY_PORT = 1 { name = "Enabled Memory Port"; desc = "enabled. The memory port clock is not inverted when the memory is not read or written."; };
        };

        field {
            name = "chn1_mem_ck_gt";
            desc = "CHN1 memory clock gating enable";
            sw = rw;
            hw = r;
            encode = CHN1_MEM_CTRL_chn1_mem_ck_gt_enum;
            reset = 0x0;
        } chn1_mem_ck_gt[12:12];

        field {
            name = "chn1_mem_emab";
            desc = "[inferred] Chn1 mem emab. (bits reserved in the data sheet; vendor header `hi3519v101/mipi_reg.h` field `chn1_mem_emab`; access and reset unknown, modelled RW)";
            sw = rw;
            hw = r;
        } chn1_mem_emab[10:8];

        field {
            name = "chn1_mem_emaa";
            desc = "[inferred] Chn1 mem emaa. (bits reserved in the data sheet; vendor header `hi3519v101/mipi_reg.h` field `chn1_mem_emaa`; access and reset unknown, modelled RW)";
            sw = rw;
            hw = r;
        } chn1_mem_emaa[6:4];

        field {
            name = "chn1_mem_ret1n";
            desc = "[inferred] Chn1 mem ret1n. (bits reserved in the data sheet; vendor header `hi3519v101/mipi_reg.h` field `chn1_mem_ret1n`; access and reset unknown, modelled RW)";
            sw = rw;
            hw = r;
        } chn1_mem_ret1n[0:0];
    } CHN1_MEM_CTRL @ 0x838;

    reg {
        name = "CHN1 lane enable register E_EN";
        desc = "CHN1_LANE_EN is a CHN1 lane enable register.

Data sheet 9.3.6 CHN1_LANE_EN (offset 0x83C, printed page 9-246, `hi3516av200--Hi3516AV200-Datasheet.txt` line 51186).";

        field {
            name = "lane7_en";
            desc = "[inferred] Lane7 enable. (bits reserved in the data sheet; vendor header `hi3519v101/mipi_reg.h` field `lane7_en`; access and reset unknown, modelled RW)";
            sw = rw;
            hw = r;
        } lane7_en[7:7];

        field {
            name = "lane6_en";
            desc = "[inferred] Lane6 enable. (bits reserved in the data sheet; vendor header `hi3519v101/mipi_reg.h` field `lane6_en`; access and reset unknown, modelled RW)";
            sw = rw;
            hw = r;
        } lane6_en[6:6];

        field {
            name = "lane5_en";
            desc = "[inferred] Lane5 enable. (bits reserved in the data sheet; vendor header `hi3519v101/mipi_reg.h` field `lane5_en`; access and reset unknown, modelled RW)";
            sw = rw;
            hw = r;
        } lane5_en[5:5];

        field {
            name = "lane4_en";
            desc = "[inferred] Lane4 enable. (bits reserved in the data sheet; vendor header `hi3519v101/mipi_reg.h` field `lane4_en`; access and reset unknown, modelled RW)";
            sw = rw;
            hw = r;
        } lane4_en[4:4];

        enum CHN1_LANE_EN_chn1_lane3_en_enum {
            DISABLED = 0 { name = "Disabled"; desc = "disabled"; };
            ENABLED = 1 { name = "Enabled"; desc = "enabled"; };
        };

        field {
            name = "chn1_lane3_en";
            desc = "CHN1 lane 3 enable";
            sw = rw;
            hw = r;
            encode = CHN1_LANE_EN_chn1_lane3_en_enum;
            reset = 0x0;
        } chn1_lane3_en[3:3];

        enum CHN1_LANE_EN_chn1_lane2_en_enum {
            DISABLED = 0 { name = "Disabled"; desc = "disabled"; };
            ENABLED = 1 { name = "Enabled"; desc = "enabled"; };
        };

        field {
            name = "chn1_lane2_en";
            desc = "CHN1 lane 2 enable";
            sw = rw;
            hw = r;
            encode = CHN1_LANE_EN_chn1_lane2_en_enum;
            reset = 0x0;
        } chn1_lane2_en[2:2];

        enum CHN1_LANE_EN_chn1_lane1_en_enum {
            DISABLED = 0 { name = "Disabled"; desc = "disabled"; };
            ENABLED = 1 { name = "Enabled"; desc = "enabled"; };
        };

        field {
            name = "chn1_lane1_en";
            desc = "CHN1 lane 1 enable";
            sw = rw;
            hw = r;
            encode = CHN1_LANE_EN_chn1_lane1_en_enum;
            reset = 0x0;
        } chn1_lane1_en[1:1];

        enum CHN1_LANE_EN_chn1_lane0_en_enum {
            DISABLED = 0 { name = "Disabled"; desc = "disabled"; };
            ENABLED = 1 { name = "Enabled"; desc = "enabled"; };
        };

        field {
            name = "chn1_lane0_en";
            desc = "CHN1 lane 0 enable";
            sw = rw;
            hw = r;
            encode = CHN1_LANE_EN_chn1_lane0_en_enum;
            reset = 0x0;
        } chn1_lane0_en[0:0];
    } CHN1_LANE_EN @ 0x83C;

    reg {
        name = "CHN1 PHY configuration mode register CFG_MODE";
        desc = "CHN1_PHYCFG_MODE is a CHN1 PHY configuration mode register. Hi3516A V200 Professional HD IP Camera SoC

Data sheet 9.3.6 CHN1_PHYCFG_MODE (offset 0x840, printed page 9-247, `hi3516av200--Hi3516AV200-Datasheet.txt` line 51233).";

        enum CHN1_PHYCFG_MODE_chn1_phycfg_mode_enum {
            PHY_CONFIGURATION_CONTROLLED = 0 { name = "Phy Configuration Controlled"; desc = "The PHY configuration is controlled by PHYCFG_EN and FSM."; };
            PHY_CONFIGURATION_CONTROLLED_2 = 1 { name = "Phy Configuration Controlled 2"; desc = "The PHY configuration is controlled by PHYCFG_EN."; };
            PHY_CONFIGURATION_DIRECTLY = 2 { name = "Phy Configuration Directly"; desc = "The PHY configuration is directly controlled by the value of the register."; };
            PHY_CONFIGURATION_CONTROLLED_3 = 3 { name = "Phy Configuration Controlled 3"; desc = "The PHY configuration is controlled by the value of the register and FSM."; };
            PHY_CONFIGURATION_CONTROLLED_4 = 4 { name = "Phy Configuration Controlled 4"; desc = "The PHY configuration is controlled by PHYCFG_EN and FSM, and the clock channel enable is controlled by PHYCFG_EN. Other values: reserved"; };
        };

        field {
            name = "chn1_phycfg_mode";
            desc = "CHN1 PHY configuration mode";
            sw = rw;
            hw = r;
            encode = CHN1_PHYCFG_MODE_chn1_phycfg_mode_enum;
            reset = 0x0;
        } chn1_phycfg_mode[2:0];
    } CHN1_PHYCFG_MODE @ 0x840;

    reg {
        name = "CHN1 PHY configuration enable register CFG_EN";
        desc = "CHN1_PHYCFG_EN is a CHN1 PHY configuration enable register. Hi3516A V200 Professional HD IP Camera SoC

Data sheet 9.3.6 CHN1_PHYCFG_EN (offset 0x844, printed page 9-248, `hi3516av200--Hi3516AV200-Datasheet.txt` line 51279).";

        enum CHN1_PHYCFG_EN_chn1_phycfg_en_enum {
            DISABLED = 0 { name = "Disabled"; desc = "disabled"; };
            ENABLED = 1 { name = "Enabled"; desc = "enabled"; };
        };

        field {
            name = "chn1_phycfg_en";
            desc = "CHN1 PHY configuration enable";
            sw = w;
            hw = r;
            encode = CHN1_PHYCFG_EN_chn1_phycfg_en_enum;
            reset = 0x0;
        } chn1_phycfg_en[0:0];
    } CHN1_PHYCFG_EN @ 0x844;

    reg {
        name = "CHN1 forcible assert enable register EN";
        desc = "CHN1_CLR_EN is a CHN1 forcible assert enable register.

Data sheet 9.3.6 CHN1_CLR_EN (offset 0x848, printed page 9-248, `hi3516av200--Hi3516AV200-Datasheet.txt` line 51308).";

        enum CHN1_CLR_EN_clr_en_align1_enum {
            ALIGN_1_ASSERT = 0 { name = "Align 1 Assert"; desc = "The ALIGN 1 assert request is disabled."; };
            ALIGN_1_ASSERT_2 = 1 { name = "Align 1 Assert 2"; desc = "The ALIGN 1 assert request is enabled."; };
        };

        field {
            name = "clr_en_align1";
            desc = "Forcible assert control for the LVDS 1 PRE SYNC module";
            sw = rw;
            hw = r;
            encode = CHN1_CLR_EN_clr_en_align1_enum;
            reset = 0x0;
        } clr_en_align1[1:1];

        enum CHN1_CLR_EN_clr_en_lvds1_enum {
            LVDS_1_CTRL = 0 { name = "Lvds 1 Ctrl"; desc = "The LVDS 1 CTRL assert request is disabled."; };
            LVDS_1_CTRL_2 = 1 { name = "Lvds 1 Ctrl 2"; desc = "The LVDS 1 CTRL assert request is enabled."; };
        };

        field {
            name = "clr_en_lvds1";
            desc = "Forcible assert control for the LVDS 1 PRE SYNC module";
            sw = rw;
            hw = r;
            encode = CHN1_CLR_EN_clr_en_lvds1_enum;
            reset = 0x0;
        } clr_en_lvds1[0:0];
    } CHN1_CLR_EN @ 0x848;

    reg {
        name = "CHN1 CIL control register CTRL";
        desc = "CHN1_CIL_CTRL is a CHN1 CIL control register.

Data sheet 9.3.6 CHN1_CIL_CTRL (offset 0x84C, printed page 9-249, `hi3516av200--Hi3516AV200-Datasheet.txt` line 51350).";

        field {
            name = "chn1_phycil1_cken";
            desc = "[inferred] Chn1 phycil1 cken. (bits reserved in the data sheet; vendor header `hi3519v101/mipi_reg.h` field `chn1_phycil1_cken`; access and reset unknown, modelled RW)";
            sw = rw;
            hw = r;
        } chn1_phycil1_cken[1:1];

        enum CHN1_CIL_CTRL_chn1_phycil2_cken_enum {
            DISABLED = 0 { name = "Disabled"; desc = "disabled"; };
            ENABLED = 1 { name = "Enabled"; desc = "enabled"; };
        };

        field {
            name = "chn1_phycil2_cken";
            desc = "PHYCIL 2 clock gating";
            sw = rw;
            hw = r;
            encode = CHN1_CIL_CTRL_chn1_phycil2_cken_enum;
            reset = 0x0;
        } chn1_phycil2_cken[0:0];
    } CHN1_CIL_CTRL @ 0x84C;

    reg {
        name = "MIPI channel 0 raw interrupt status register _INT_RAW";
        desc = "MIPI_CHN0_INT_RAW is a MIPI channel 0 raw interrupt status register. Hi3516A V200 Professional HD IP Camera SoC

Data sheet 9.3.6 MIPI_CHN0_INT_RAW (offset 0xEF0, printed page 9-250, `hi3516av200--Hi3516AV200-Datasheet.txt` line 51388).";

        enum MIPI_CHN0_INT_RAW_int_data_align_raw_enum {
            NO_RAW_INTERRUPT = 0 { name = "No Raw Interrupt"; desc = "No raw interrupt is generated."; };
            RAW_INTERRUPT_GENERATED = 1 { name = "Raw Interrupt Generated"; desc = "A raw interrupt is generated."; };
        };

        field {
            name = "int_data_align_raw";
            desc = "MIPI ALIGN raw interrupt status";
            sw = rw;
            hw = w;
            onwrite = woclr;
            encode = MIPI_CHN0_INT_RAW_int_data_align_raw_enum;
            reset = 0x0;
        } int_data_align_raw[6:6];

        enum MIPI_CHN0_INT_RAW_int_mipi_ctrl_raw_enum {
            NO_RAW_INTERRUPT = 0 { name = "No Raw Interrupt"; desc = "No raw interrupt is generated."; };
            RAW_INTERRUPT_GENERATED = 1 { name = "Raw Interrupt Generated"; desc = "A raw interrupt is generated."; };
        };

        field {
            name = "int_mipi_ctrl_raw";
            desc = "MIPI CTRL raw interrupt status";
            sw = rw;
            hw = w;
            onwrite = woclr;
            encode = MIPI_CHN0_INT_RAW_int_mipi_ctrl_raw_enum;
            reset = 0x0;
        } int_mipi_ctrl_raw[5:5];

        enum MIPI_CHN0_INT_RAW_int_mipi_csi_raw_enum {
            NO_RAW_INTERRUPT = 0 { name = "No Raw Interrupt"; desc = "No raw interrupt is generated."; };
            RAW_INTERRUPT_GENERATED = 1 { name = "Raw Interrupt Generated"; desc = "A raw interrupt is generated."; };
        };

        field {
            name = "int_mipi_csi_raw";
            desc = "MIPI CSI2 raw interrupt status";
            sw = rw;
            hw = w;
            onwrite = woclr;
            encode = MIPI_CHN0_INT_RAW_int_mipi_csi_raw_enum;
            reset = 0x0;
        } int_mipi_csi_raw[4:4];

        enum MIPI_CHN0_INT_RAW_int_lvds_ctrl_raw_enum {
            NO_RAW_INTERRUPT = 0 { name = "No Raw Interrupt"; desc = "No raw interrupt is generated."; };
            RAW_INTERRUPT_GENERATED = 1 { name = "Raw Interrupt Generated"; desc = "A raw interrupt is generated."; };
        };

        field {
            name = "int_lvds_ctrl_raw";
            desc = "LVDS CTRL raw interrupt status";
            sw = rw;
            hw = w;
            onwrite = woclr;
            encode = MIPI_CHN0_INT_RAW_int_lvds_ctrl_raw_enum;
            reset = 0x0;
        } int_lvds_ctrl_raw[3:3];

        enum MIPI_CHN0_INT_RAW_int_phycil2_raw_enum {
            NO_RAW_INTERRUPT = 0 { name = "No Raw Interrupt"; desc = "No raw interrupt is generated."; };
            RAW_INTERRUPT_GENERATED = 1 { name = "Raw Interrupt Generated"; desc = "A raw interrupt is generated."; };
        };

        field {
            name = "int_phycil2_raw";
            desc = "PHYCIL2 raw interrupt status";
            sw = rw;
            hw = w;
            onwrite = woclr;
            encode = MIPI_CHN0_INT_RAW_int_phycil2_raw_enum;
            reset = 0x0;
        } int_phycil2_raw[2:2];

        enum MIPI_CHN0_INT_RAW_int_phycil1_raw_enum {
            NO_RAW_INTERRUPT = 0 { name = "No Raw Interrupt"; desc = "No raw interrupt is generated."; };
            RAW_INTERRUPT_GENERATED = 1 { name = "Raw Interrupt Generated"; desc = "A raw interrupt is generated."; };
        };

        field {
            name = "int_phycil1_raw";
            desc = "PHYCIL1 raw interrupt status";
            sw = rw;
            hw = w;
            onwrite = woclr;
            encode = MIPI_CHN0_INT_RAW_int_phycil1_raw_enum;
            reset = 0x0;
        } int_phycil1_raw[1:1];

        enum MIPI_CHN0_INT_RAW_int_phycil0_raw_enum {
            NO_RAW_INTERRUPT = 0 { name = "No Raw Interrupt"; desc = "No raw interrupt is generated."; };
            RAW_INTERRUPT_GENERATED = 1 { name = "Raw Interrupt Generated"; desc = "A raw interrupt is generated."; };
        };

        field {
            name = "int_phycil0_raw";
            desc = "PHYCIL0 raw interrupt status";
            sw = rw;
            hw = w;
            onwrite = woclr;
            encode = MIPI_CHN0_INT_RAW_int_phycil0_raw_enum;
            reset = 0x0;
        } int_phycil0_raw[0:0];
    } MIPI_CHN0_INT_RAW @ 0xEF0;

    reg {
        name = "MIPI channel 0 interrupt status register _INT";
        desc = "MIPI_CHN0_INT is a MIPI channel 0 interrupt status register.

Data sheet 9.3.6 MIPI_CHN0_INT (offset 0xEF4, printed page 9-251, `hi3516av200--Hi3516AV200-Datasheet.txt` line 51441).";

        enum MIPI_CHN0_INT_int_data_align_st_enum {
            NO_INTERRUPT_GENERATED = 0 { name = "No Interrupt Generated"; desc = "No interrupt is generated."; };
            INTERRUPT_GENERATED = 1 { name = "Interrupt Generated"; desc = "An interrupt is generated."; };
        };

        field {
            name = "int_data_align_st";
            desc = "MIPI ALIGN interrupt status";
            sw = r;
            hw = w;
            encode = MIPI_CHN0_INT_int_data_align_st_enum;
            reset = 0x0;
        } int_data_align_st[6:6];

        enum MIPI_CHN0_INT_int_mipi_ctrl_st_enum {
            NO_INTERRUPT_GENERATED = 0 { name = "No Interrupt Generated"; desc = "No interrupt is generated."; };
            INTERRUPT_GENERATED = 1 { name = "Interrupt Generated"; desc = "An interrupt is generated."; };
        };

        field {
            name = "int_mipi_ctrl_st";
            desc = "MIPI CTRL interrupt status";
            sw = r;
            hw = w;
            encode = MIPI_CHN0_INT_int_mipi_ctrl_st_enum;
            reset = 0x0;
        } int_mipi_ctrl_st[5:5];

        enum MIPI_CHN0_INT_int_mipi_csi_st_enum {
            NO_INTERRUPT_GENERATED = 0 { name = "No Interrupt Generated"; desc = "No interrupt is generated."; };
            INTERRUPT_GENERATED = 1 { name = "Interrupt Generated"; desc = "An interrupt is generated."; };
        };

        field {
            name = "int_mipi_csi_st";
            desc = "MIPI CSI2 interrupt status";
            sw = r;
            hw = w;
            encode = MIPI_CHN0_INT_int_mipi_csi_st_enum;
            reset = 0x0;
        } int_mipi_csi_st[4:4];

        enum MIPI_CHN0_INT_int_lvds_ctrl_st_enum {
            NO_INTERRUPT_GENERATED = 0 { name = "No Interrupt Generated"; desc = "No interrupt is generated."; };
            INTERRUPT_GENERATED = 1 { name = "Interrupt Generated"; desc = "An interrupt is generated."; };
        };

        field {
            name = "int_lvds_ctrl_st";
            desc = "LVDS CTRL interrupt status";
            sw = r;
            hw = w;
            encode = MIPI_CHN0_INT_int_lvds_ctrl_st_enum;
            reset = 0x0;
        } int_lvds_ctrl_st[3:3];

        enum MIPI_CHN0_INT_int_phycil2_st_enum {
            NO_INTERRUPT_GENERATED = 0 { name = "No Interrupt Generated"; desc = "No interrupt is generated."; };
            INTERRUPT_GENERATED = 1 { name = "Interrupt Generated"; desc = "An interrupt is generated."; };
        };

        field {
            name = "int_phycil2_st";
            desc = "PHYCIL2 interrupt status";
            sw = r;
            hw = w;
            encode = MIPI_CHN0_INT_int_phycil2_st_enum;
            reset = 0x0;
        } int_phycil2_st[2:2];

        enum MIPI_CHN0_INT_int_phycil1_st_enum {
            NO_INTERRUPT_GENERATED = 0 { name = "No Interrupt Generated"; desc = "No interrupt is generated."; };
            INTERRUPT_GENERATED = 1 { name = "Interrupt Generated"; desc = "An interrupt is generated."; };
        };

        field {
            name = "int_phycil1_st";
            desc = "PHYCIL1 interrupt status";
            sw = r;
            hw = w;
            encode = MIPI_CHN0_INT_int_phycil1_st_enum;
            reset = 0x0;
        } int_phycil1_st[1:1];

        enum MIPI_CHN0_INT_int_phycil0_st_enum {
            NO_INTERRUPT_GENERATED = 0 { name = "No Interrupt Generated"; desc = "No interrupt is generated."; };
            INTERRUPT_GENERATED = 1 { name = "Interrupt Generated"; desc = "An interrupt is generated."; };
        };

        field {
            name = "int_phycil0_st";
            desc = "PHYCIL0 interrupt status";
            sw = r;
            hw = w;
            encode = MIPI_CHN0_INT_int_phycil0_st_enum;
            reset = 0x0;
        } int_phycil0_st[0:0];
    } MIPI_CHN0_INT @ 0xEF4;

    reg {
        name = "MIPI channel 0 interrupt mask register _INT_MSK";
        desc = "MIPI_CHN0_INT_MSK is a MIPI channel 0 interrupt mask register.

Data sheet 9.3.6 MIPI_CHN0_INT_MSK (offset 0xEF8, printed page 9-252, `hi3516av200--Hi3516AV200-Datasheet.txt` line 51494).";

        enum MIPI_CHN0_INT_MSK_int_data_align_msk_enum {
            MASKED = 0 { name = "Masked"; desc = "masked"; };
            ENABLED = 1 { name = "Enabled"; desc = "enabled"; };
        };

        field {
            name = "int_data_align_msk";
            desc = "MIPI ALIGN interrupt enable";
            sw = rw;
            hw = r;
            encode = MIPI_CHN0_INT_MSK_int_data_align_msk_enum;
            reset = 0x0;
        } int_data_align_msk[6:6];

        enum MIPI_CHN0_INT_MSK_int_mipi_ctrl_msk_enum {
            MASKED = 0 { name = "Masked"; desc = "masked"; };
            ENABLED = 1 { name = "Enabled"; desc = "enabled"; };
        };

        field {
            name = "int_mipi_ctrl_msk";
            desc = "MIPI CTRL interrupt enable";
            sw = rw;
            hw = r;
            encode = MIPI_CHN0_INT_MSK_int_mipi_ctrl_msk_enum;
            reset = 0x0;
        } int_mipi_ctrl_msk[5:5];

        enum MIPI_CHN0_INT_MSK_int_mipi_csi_msk_enum {
            MASKED = 0 { name = "Masked"; desc = "masked"; };
            ENABLED = 1 { name = "Enabled"; desc = "enabled"; };
        };

        field {
            name = "int_mipi_csi_msk";
            desc = "MIPI CSI2 interrupt enable";
            sw = rw;
            hw = r;
            encode = MIPI_CHN0_INT_MSK_int_mipi_csi_msk_enum;
            reset = 0x0;
        } int_mipi_csi_msk[4:4];

        enum MIPI_CHN0_INT_MSK_int_lvds_ctrl_msk_enum {
            MASKED = 0 { name = "Masked"; desc = "masked"; };
            ENABLED = 1 { name = "Enabled"; desc = "enabled"; };
        };

        field {
            name = "int_lvds_ctrl_msk";
            desc = "LVDS CTRL interrupt enable";
            sw = rw;
            hw = r;
            encode = MIPI_CHN0_INT_MSK_int_lvds_ctrl_msk_enum;
            reset = 0x0;
        } int_lvds_ctrl_msk[3:3];

        enum MIPI_CHN0_INT_MSK_int_phycil2_msk_enum {
            MASKED = 0 { name = "Masked"; desc = "masked"; };
            ENABLED = 1 { name = "Enabled"; desc = "enabled"; };
        };

        field {
            name = "int_phycil2_msk";
            desc = "PHYCIL2 interrupt enable";
            sw = rw;
            hw = r;
            encode = MIPI_CHN0_INT_MSK_int_phycil2_msk_enum;
            reset = 0x0;
        } int_phycil2_msk[2:2];

        enum MIPI_CHN0_INT_MSK_int_phycil1_msk_enum {
            MASKED = 0 { name = "Masked"; desc = "masked"; };
            ENABLED = 1 { name = "Enabled"; desc = "enabled"; };
        };

        field {
            name = "int_phycil1_msk";
            desc = "PHYCIL1 interrupt enable";
            sw = rw;
            hw = r;
            encode = MIPI_CHN0_INT_MSK_int_phycil1_msk_enum;
            reset = 0x0;
        } int_phycil1_msk[1:1];

        enum MIPI_CHN0_INT_MSK_int_phycil0_msk_enum {
            MASKED = 0 { name = "Masked"; desc = "masked"; };
            ENABLED = 1 { name = "Enabled"; desc = "enabled"; };
        };

        field {
            name = "int_phycil0_msk";
            desc = "PHYCIL0 interrupt enable";
            sw = rw;
            hw = r;
            encode = MIPI_CHN0_INT_MSK_int_phycil0_msk_enum;
            reset = 0x0;
        } int_phycil0_msk[0:0];
    } MIPI_CHN0_INT_MSK @ 0xEF8;

    reg {
        name = "MIPI channel 1 raw interrupt status register _INT_RAW";
        desc = "MIPI_CHN1_INT_RAW is a MIPI channel 1 raw interrupt status register.

Data sheet 9.3.6 MIPI_CHN1_INT_RAW (offset 0xFF0, printed page 9-253, `hi3516av200--Hi3516AV200-Datasheet.txt` line 51547).";

        enum MIPI_CHN1_INT_RAW_int_data_align1_raw_enum {
            NO_RAW_INTERRUPT = 0 { name = "No Raw Interrupt"; desc = "No raw interrupt is generated."; };
            RAW_INTERRUPT_GENERATED = 1 { name = "Raw Interrupt Generated"; desc = "A raw interrupt is generated."; };
        };

        field {
            name = "int_data_align1_raw";
            desc = "MIPI 1 ALIGN raw interrupt status";
            sw = rw;
            hw = w;
            onwrite = woclr;
            encode = MIPI_CHN1_INT_RAW_int_data_align1_raw_enum;
            reset = 0x0;
        } int_data_align1_raw[6:6];

        enum MIPI_CHN1_INT_RAW_int_mipi1_ctrl_raw_enum {
            NO_RAW_INTERRUPT = 0 { name = "No Raw Interrupt"; desc = "No raw interrupt is generated."; };
            RAW_INTERRUPT_GENERATED = 1 { name = "Raw Interrupt Generated"; desc = "A raw interrupt is generated."; };
        };

        field {
            name = "int_mipi1_ctrl_raw";
            desc = "MIPI 1 CTRL raw interrupt status";
            sw = rw;
            hw = w;
            onwrite = woclr;
            encode = MIPI_CHN1_INT_RAW_int_mipi1_ctrl_raw_enum;
            reset = 0x0;
        } int_mipi1_ctrl_raw[5:5];

        enum MIPI_CHN1_INT_RAW_int_mipi1_csi_raw_enum {
            NO_RAW_INTERRUPT = 0 { name = "No Raw Interrupt"; desc = "No raw interrupt is generated."; };
            RAW_INTERRUPT_GENERATED = 1 { name = "Raw Interrupt Generated"; desc = "A raw interrupt is generated."; };
        };

        field {
            name = "int_mipi1_csi_raw";
            desc = "MIPI 1 CSI 2 raw interrupt status";
            sw = rw;
            hw = w;
            onwrite = woclr;
            encode = MIPI_CHN1_INT_RAW_int_mipi1_csi_raw_enum;
            reset = 0x0;
        } int_mipi1_csi_raw[4:4];

        enum MIPI_CHN1_INT_RAW_int_lvds1_ctrl_raw_enum {
            NO_RAW_INTERRUPT = 0 { name = "No Raw Interrupt"; desc = "No raw interrupt is generated."; };
            RAW_INTERRUPT_GENERATED = 1 { name = "Raw Interrupt Generated"; desc = "A raw interrupt is generated."; };
        };

        field {
            name = "int_lvds1_ctrl_raw";
            desc = "LVDS 1 CTRL raw interrupt status";
            sw = rw;
            hw = w;
            onwrite = woclr;
            encode = MIPI_CHN1_INT_RAW_int_lvds1_ctrl_raw_enum;
            reset = 0x0;
        } int_lvds1_ctrl_raw[3:3];

        enum MIPI_CHN1_INT_RAW_mipi1_int_phycil2_raw_enum {
            NO_RAW_INTERRUPT = 0 { name = "No Raw Interrupt"; desc = "No raw interrupt is generated."; };
            RAW_INTERRUPT_GENERATED = 1 { name = "Raw Interrupt Generated"; desc = "A raw interrupt is generated."; };
        };

        field {
            name = "mipi1_int_phycil2_raw";
            desc = "MIPI 1 PHYCIL 2 raw interrupt status";
            sw = rw;
            hw = w;
            onwrite = woclr;
            encode = MIPI_CHN1_INT_RAW_mipi1_int_phycil2_raw_enum;
            reset = 0x0;
        } mipi1_int_phycil2_raw[2:2];
    } MIPI_CHN1_INT_RAW @ 0xFF0;

    reg {
        name = "MIPI channel 1 interrupt status register _INT";
        desc = "MIPI_CHN1_INT is a MIPI channel 1 interrupt status register. Hi3516A V200 Professional HD IP Camera SoC

Data sheet 9.3.6 MIPI_CHN1_INT (offset 0xFF4, printed page 9-254, `hi3516av200--Hi3516AV200-Datasheet.txt` line 51602).";

        enum MIPI_CHN1_INT_int_data_align1_st_enum {
            NO_INTERRUPT_GENERATED = 0 { name = "No Interrupt Generated"; desc = "No interrupt is generated."; };
            INTERRUPT_GENERATED = 1 { name = "Interrupt Generated"; desc = "An interrupt is generated."; };
        };

        field {
            name = "int_data_align1_st";
            desc = "MIPI 1 ALIGN interrupt status";
            sw = r;
            hw = w;
            encode = MIPI_CHN1_INT_int_data_align1_st_enum;
            reset = 0x0;
        } int_data_align1_st[6:6];

        enum MIPI_CHN1_INT_int_mipi1_ctrl_st_enum {
            NO_INTERRUPT_GENERATED = 0 { name = "No Interrupt Generated"; desc = "No interrupt is generated."; };
            INTERRUPT_GENERATED = 1 { name = "Interrupt Generated"; desc = "An interrupt is generated."; };
        };

        field {
            name = "int_mipi1_ctrl_st";
            desc = "MIPI 1 CTRL interrupt status";
            sw = r;
            hw = w;
            encode = MIPI_CHN1_INT_int_mipi1_ctrl_st_enum;
            reset = 0x0;
        } int_mipi1_ctrl_st[5:5];

        enum MIPI_CHN1_INT_int_mipi1_csi_st_enum {
            NO_INTERRUPT_GENERATED = 0 { name = "No Interrupt Generated"; desc = "No interrupt is generated."; };
            INTERRUPT_GENERATED = 1 { name = "Interrupt Generated"; desc = "An interrupt is generated."; };
        };

        field {
            name = "int_mipi1_csi_st";
            desc = "MIPI 1 CSI 2 interrupt status";
            sw = r;
            hw = w;
            encode = MIPI_CHN1_INT_int_mipi1_csi_st_enum;
            reset = 0x0;
        } int_mipi1_csi_st[4:4];

        enum MIPI_CHN1_INT_int_lvds1_ctrl_st_enum {
            NO_INTERRUPT_GENERATED = 0 { name = "No Interrupt Generated"; desc = "No interrupt is generated."; };
            INTERRUPT_GENERATED = 1 { name = "Interrupt Generated"; desc = "An interrupt is generated."; };
        };

        field {
            name = "int_lvds1_ctrl_st";
            desc = "LVDS 1 CTR L interrupt status";
            sw = r;
            hw = w;
            encode = MIPI_CHN1_INT_int_lvds1_ctrl_st_enum;
            reset = 0x0;
        } int_lvds1_ctrl_st[3:3];

        enum MIPI_CHN1_INT_mipi1_int_phycil2_st_enum {
            NO_INTERRUPT_GENERATED = 0 { name = "No Interrupt Generated"; desc = "No interrupt is generated."; };
            INTERRUPT_GENERATED = 1 { name = "Interrupt Generated"; desc = "An interrupt is generated."; };
        };

        field {
            name = "mipi1_int_phycil2_st";
            desc = "MIPI 1 PHYCIL 2 interrupt status";
            sw = r;
            hw = w;
            encode = MIPI_CHN1_INT_mipi1_int_phycil2_st_enum;
            reset = 0x0;
        } mipi1_int_phycil2_st[2:2];
    } MIPI_CHN1_INT @ 0xFF4;

    reg {
        name = "MIPI channel 1 interrupt mask register _INT_MSK";
        desc = "MIPI_CHN1_INT_MSK is a MIPI channel 1 interrupt mask register. Hi3516A V200 Professional HD IP Camera SoC

Data sheet 9.3.6 MIPI_CHN1_INT_MSK (offset 0xFF8, printed page 9-255, `hi3516av200--Hi3516AV200-Datasheet.txt` line 51656).";

        enum MIPI_CHN1_INT_MSK_int_data_align1_msk_enum {
            MASKED = 0 { name = "Masked"; desc = "masked"; };
            ENABLED = 1 { name = "Enabled"; desc = "enabled"; };
        };

        field {
            name = "int_data_align1_msk";
            desc = "MIPI 1 ALIGN interrupt enable";
            sw = rw;
            hw = r;
            encode = MIPI_CHN1_INT_MSK_int_data_align1_msk_enum;
            reset = 0x0;
        } int_data_align1_msk[6:6];

        enum MIPI_CHN1_INT_MSK_int_mipi1_ctrl_msk_enum {
            MASKED = 0 { name = "Masked"; desc = "masked"; };
            ENABLED = 1 { name = "Enabled"; desc = "enabled"; };
        };

        field {
            name = "int_mipi1_ctrl_msk";
            desc = "MIPI 1 CTRL interrupt enable";
            sw = rw;
            hw = r;
            encode = MIPI_CHN1_INT_MSK_int_mipi1_ctrl_msk_enum;
            reset = 0x0;
        } int_mipi1_ctrl_msk[5:5];

        enum MIPI_CHN1_INT_MSK_int_mipi1_csi_msk_enum {
            MASKED = 0 { name = "Masked"; desc = "masked"; };
            ENABLED = 1 { name = "Enabled"; desc = "enabled"; };
        };

        field {
            name = "int_mipi1_csi_msk";
            desc = "MIPI 1 CSI 2 interrupt enable";
            sw = rw;
            hw = r;
            encode = MIPI_CHN1_INT_MSK_int_mipi1_csi_msk_enum;
            reset = 0x0;
        } int_mipi1_csi_msk[4:4];

        enum MIPI_CHN1_INT_MSK_int_lvds1_ctrl_msk_enum {
            MASKED = 0 { name = "Masked"; desc = "masked"; };
            ENABLED = 1 { name = "Enabled"; desc = "enabled"; };
        };

        field {
            name = "int_lvds1_ctrl_msk";
            desc = "LVDS 1 CTRL interrupt enable";
            sw = rw;
            hw = r;
            encode = MIPI_CHN1_INT_MSK_int_lvds1_ctrl_msk_enum;
            reset = 0x0;
        } int_lvds1_ctrl_msk[3:3];

        enum MIPI_CHN1_INT_MSK_mipi1_int_phycil2_msk_enum {
            MASKED = 0 { name = "Masked"; desc = "masked"; };
            ENABLED = 1 { name = "Enabled"; desc = "enabled"; };
        };

        field {
            name = "mipi1_int_phycil2_msk";
            desc = "MIPI 1 PHYCIL 2 interrupt enable";
            sw = rw;
            hw = r;
            encode = MIPI_CHN1_INT_MSK_mipi1_int_phycil2_msk_enum;
            reset = 0x0;
        } mipi1_int_phycil2_msk[2:2];
    } MIPI_CHN1_INT_MSK @ 0xFF8;

    reg {
        name = "MIPI0 enabled data channel quantity ES_NUM register";
        desc = "MIPI0_LANES_NUM is a MIPI0 enabled data channel quantity register. Hi3516A V200 Professional HD IP Camera SoC

Data sheet 9.3.6 MIPI0_LANES_NUM (offset 0x1004, printed page 9-256, `hi3516av200--Hi3516AV200-Datasheet.txt` line 51713).";

        enum MIPI0_LANES_NUM_lane_num_enum {
            V_1 = 0 { name = "V 1"; desc = "1"; };
            V_2 = 1 { name = "V 2"; desc = "2"; };
            V_3 = 2 { name = "V 3"; desc = "3"; };
            V_4 = 3 { name = "V 4"; desc = "4"; };
            V_5 = 4 { name = "V 5"; desc = "5"; };
            V_6 = 5 { name = "V 6"; desc = "6"; };
            V_7 = 6 { name = "V 7"; desc = "7"; };
            V_8 = 7 { name = "V 8"; desc = "8"; };
        };

        field {
            name = "lane_num";
            desc = "Number of enabled data channels";
            sw = rw;
            hw = r;
            encode = MIPI0_LANES_NUM_lane_num_enum;
            reset = 0x3;
        } lane_num[2:0];
    } MIPI0_LANES_NUM @ 0x1004;

    reg {
        name = "MIPI 0 global interrupt status register N_INT_ST";
        desc = "MIPI0_MAIN_INT_ST is a MIPI 0 global interrupt status register.

Data sheet 9.3.6 MIPI0_MAIN_INT_ST (offset 0x100C, printed page 9-256, `hi3516av200--Hi3516AV200-Datasheet.txt` line 51747).";

        field {
            name = "status_int_line";
            desc = "Line interrupt status. This bit is set to 1 when any of the bit in the MIPI0_LINE_INTR_ST register is set to 1. This bit is cleared when it is read. To clear the reported interrupt, this bit and MIPI0_LINE_INTR_ST must be cleared.";
            sw = r;
            hw = w;
            reset = 0x0;
        } status_int_line[18:18];

        field {
            name = "status_int_pkt";
            desc = "Packet interrupt status. This bit is set to 1 when any of the bit in the MIPI0_PKT_INTR2_ST register is set to 1. This bit is cleared when it is read. To clear the reported interrupt, this bit and MIPI0_PKT_INTR2_ST must be cleared.";
            sw = r;
            hw = w;
            reset = 0x0;
        } status_int_pkt[17:17];

        field {
            name = "status_int_frame_fatal";
            desc = "Frame interrupt status. This bit is set to 1 when any of the bit in the MIPI0_FRAME_INTR_ST register is set to 1. This bit is cleared when it is read. To clear the reported interrupt, this bit and MIPI0_FRAME_INTR_ST must be cleared.";
            sw = r;
            hw = w;
            reset = 0x0;
        } status_int_frame_fatal[2:2];

        field {
            name = "status_int_pkt_fatal";
            desc = "Packet interrupt status. This bit is set to 1 when any of the bit in the MIPI0_PKT_INTR_ST register is set to 1. This bit is cleared when it is read. To clear the reported interrupt, this bit and MIPI0_PKT_INTR_ST must be cleared.";
            sw = r;
            hw = w;
            reset = 0x0;
        } status_int_pkt_fatal[1:1];
    } MIPI0_MAIN_INT_ST @ 0x100C;

    reg {
        name = "MIPI 0 controller data ID 1 register";
        desc = "MIPI0_DI_1 is a MIPI 0 controller data ID 1 register.

Data sheet 9.3.6 MIPI0_DI_1 (offset 0x1010, printed page 9-257, `hi3516av200--Hi3516AV200-Datasheet.txt` line 51805).";

        field {
            name = "di3_vc";
            desc = "Virtual channel ID of data with the ID 3";
            sw = rw;
            hw = r;
            reset = 0x0;
        } di3_vc[31:30];

        enum MIPI0_DI_1_di3_dt_enum {
            RAW8 = 0x2A { name = "Raw8"; desc = "raw8"; };
            RAW10 = 0x2B { name = "Raw10"; desc = "raw10"; };
            RAW12 = 0x2C { name = "Raw12"; desc = "raw12"; };
            RAW14_OTHER_VALUES = 0x2D { name = "Raw14 Other Values"; desc = "raw14 Other values: reserved"; };
        };

        field {
            name = "di3_dt";
            desc = "Type of data with the ID 3";
            sw = rw;
            hw = r;
            encode = MIPI0_DI_1_di3_dt_enum;
            reset = 0x0;
        } di3_dt[29:24];

        field {
            name = "di2_vc";
            desc = "Virtual channel ID of data with the ID 2";
            sw = rw;
            hw = r;
            reset = 0x0;
        } di2_vc[23:22];

        enum MIPI0_DI_1_di2_dt_enum {
            RAW8 = 0x2A { name = "Raw8"; desc = "raw8"; };
            RAW10 = 0x2B { name = "Raw10"; desc = "raw10"; };
            RAW12 = 0x2C { name = "Raw12"; desc = "raw12"; };
            RAW14_OTHER_VALUES = 0x2D { name = "Raw14 Other Values"; desc = "raw14 Other values: reserved"; };
        };

        field {
            name = "di2_dt";
            desc = "Type of data with the ID 2";
            sw = rw;
            hw = r;
            encode = MIPI0_DI_1_di2_dt_enum;
            reset = 0x0;
        } di2_dt[21:16];

        field {
            name = "di1_vc";
            desc = "Virtual channel ID of data with the ID 1";
            sw = rw;
            hw = r;
            reset = 0x0;
        } di1_vc[15:14];

        enum MIPI0_DI_1_di1_dt_enum {
            RAW8 = 0x2A { name = "Raw8"; desc = "raw8"; };
            RAW10 = 0x2B { name = "Raw10"; desc = "raw10"; };
            RAW12 = 0x2C { name = "Raw12"; desc = "raw12"; };
            RAW14_OTHER_VALUES = 0x2D { name = "Raw14 Other Values"; desc = "raw14 Other values: reserved"; };
        };

        field {
            name = "di1_dt";
            desc = "Type of data with the ID 1";
            sw = rw;
            hw = r;
            encode = MIPI0_DI_1_di1_dt_enum;
            reset = 0x0;
        } di1_dt[13:8];

        field {
            name = "di0_vc";
            desc = "Virtual channel ID of data with the ID 0";
            sw = rw;
            hw = r;
            reset = 0x0;
        } di0_vc[7:6];

        enum MIPI0_DI_1_di0_dt_enum {
            RAW8 = 0x2A { name = "Raw8"; desc = "raw8"; };
            RAW10 = 0x2B { name = "Raw10"; desc = "raw10"; };
            RAW12 = 0x2C { name = "Raw12"; desc = "raw12"; };
            RAW14_OTHER_VALUES = 0x2D { name = "Raw14 Other Values"; desc = "raw14 Other values: reserved"; };
        };

        field {
            name = "di0_dt";
            desc = "Type of data with the ID 0";
            sw = rw;
            hw = r;
            encode = MIPI0_DI_1_di0_dt_enum;
            reset = 0x0;
        } di0_dt[5:0];
    } MIPI0_DI_1 @ 0x1010;

    reg {
        name = "MIPI 0 controller data ID 2 register";
        desc = "MIPI0_DI_2 is a MIPI 0 controller data ID 2 register.

Data sheet 9.3.6 MIPI0_DI_2 (offset 0x1014, printed page 9-258, `hi3516av200--Hi3516AV200-Datasheet.txt` line 51868).";

        field {
            name = "di7_vc";
            desc = "Virtual channel ID of data with the ID 7";
            sw = rw;
            hw = r;
            reset = 0x0;
        } di7_vc[31:30];

        enum MIPI0_DI_2_di7_dt_enum {
            RAW8 = 0x2A { name = "Raw8"; desc = "raw8"; };
            RAW10 = 0x2B { name = "Raw10"; desc = "raw10"; };
            RAW12 = 0x2C { name = "Raw12"; desc = "raw12"; };
            RAW14_OTHER_VALUES = 0x2D { name = "Raw14 Other Values"; desc = "raw14 Other values: reserved"; };
        };

        field {
            name = "di7_dt";
            desc = "Type of data with the ID 7";
            sw = rw;
            hw = r;
            encode = MIPI0_DI_2_di7_dt_enum;
            reset = 0x0;
        } di7_dt[29:24];

        field {
            name = "di6_vc";
            desc = "Virtual channel ID of data with the ID 6";
            sw = rw;
            hw = r;
            reset = 0x0;
        } di6_vc[23:22];

        enum MIPI0_DI_2_di6_dt_enum {
            RAW8 = 0x2A { name = "Raw8"; desc = "raw8"; };
            RAW10 = 0x2B { name = "Raw10"; desc = "raw10"; };
            RAW12 = 0x2C { name = "Raw12"; desc = "raw12"; };
            RAW14_OTHER_VALUES = 0x2D { name = "Raw14 Other Values"; desc = "raw14 Other values: reserved"; };
        };

        field {
            name = "di6_dt";
            desc = "Type of data with the ID 6";
            sw = rw;
            hw = r;
            encode = MIPI0_DI_2_di6_dt_enum;
            reset = 0x0;
        } di6_dt[21:16];

        field {
            name = "di5_vc";
            desc = "Virtual channel ID of data with the ID 5";
            sw = rw;
            hw = r;
            reset = 0x0;
        } di5_vc[15:14];

        enum MIPI0_DI_2_di5_dt_enum {
            RAW8 = 0x2A { name = "Raw8"; desc = "raw8"; };
            RAW10 = 0x2B { name = "Raw10"; desc = "raw10"; };
            RAW12 = 0x2C { name = "Raw12"; desc = "raw12"; };
            RAW14_OTHER_VALUES = 0x2D { name = "Raw14 Other Values"; desc = "raw14 Other values: reserved"; };
        };

        field {
            name = "di5_dt";
            desc = "Type of data with the ID 5";
            sw = rw;
            hw = r;
            encode = MIPI0_DI_2_di5_dt_enum;
            reset = 0x0;
        } di5_dt[13:8];

        field {
            name = "di4_vc";
            desc = "Virtual channel ID of data with the ID 4";
            sw = rw;
            hw = r;
            reset = 0x0;
        } di4_vc[7:6];

        enum MIPI0_DI_2_di4_dt_enum {
            RAW8 = 0x2A { name = "Raw8"; desc = "raw8"; };
            RAW10 = 0x2B { name = "Raw10"; desc = "raw10"; };
            RAW12 = 0x2C { name = "Raw12"; desc = "raw12"; };
            RAW14_OTHER_VALUES = 0x2D { name = "Raw14 Other Values"; desc = "raw14 Other values: reserved"; };
        };

        field {
            name = "di4_dt";
            desc = "Type of data with the ID 4";
            sw = rw;
            hw = r;
            encode = MIPI0_DI_2_di4_dt_enum;
            reset = 0x0;
        } di4_dt[5:0];
    } MIPI0_DI_2 @ 0x1014;

    reg {
        name = "MIPI 0 packet interrupt status register INTR_ST";
        desc = "MIPI0_PKT_INTR_ST is a MIPI 0 packet interrupt status register. Hi3516A V200 Professional HD IP Camera SoC

Data sheet 9.3.6 MIPI0_PKT_INTR_ST (offset 0x1060, printed page 9-260, `hi3516av200--Hi3516AV200-Datasheet.txt` line 51941).";

        enum MIPI0_PKT_INTR_ST_err_ecc_double_enum {
            NO_ECC_ERROR = 0 { name = "No Ecc Error"; desc = "No ECC error occurs."; };
            ECC_ERRORS_OCCUR = 1 { name = "Ecc Errors Occur"; desc = "ECC errors occur."; };
        };

        field {
            name = "err_ecc_double";
            desc = "Whether the header has at least two uncorrectable ECC errors. This bit is cleared when it is read.";
            sw = r;
            hw = w;
            onread = rclr;
            encode = MIPI0_PKT_INTR_ST_err_ecc_double_enum;
            reset = 0x0;
        } err_ecc_double[16:16];

        enum MIPI0_PKT_INTR_ST_vc3_err_crc_enum {
            NO = 0 { name = "No"; desc = "no"; };
            YES = 1 { name = "Yes"; desc = "yes"; };
        };

        field {
            name = "vc3_err_crc";
            desc = "Whether the VC 3 data has CRC errors. This bit is cleared when it is read.";
            sw = r;
            hw = w;
            onread = rclr;
            encode = MIPI0_PKT_INTR_ST_vc3_err_crc_enum;
            reset = 0x0;
        } vc3_err_crc[3:3];

        enum MIPI0_PKT_INTR_ST_vc2_err_crc_enum {
            NO = 0 { name = "No"; desc = "no"; };
            YES = 1 { name = "Yes"; desc = "yes"; };
        };

        field {
            name = "vc2_err_crc";
            desc = "Whether the VC 2 data has CRC errors. This bit is cleared when it is read.";
            sw = r;
            hw = w;
            onread = rclr;
            encode = MIPI0_PKT_INTR_ST_vc2_err_crc_enum;
            reset = 0x0;
        } vc2_err_crc[2:2];

        enum MIPI0_PKT_INTR_ST_vc1_err_crc_enum {
            NO = 0 { name = "No"; desc = "no"; };
            YES = 1 { name = "Yes"; desc = "yes"; };
        };

        field {
            name = "vc1_err_crc";
            desc = "Whether the VC 1 data has CRC errors. This bit is cleared when it is read.";
            sw = r;
            hw = w;
            onread = rclr;
            encode = MIPI0_PKT_INTR_ST_vc1_err_crc_enum;
            reset = 0x0;
        } vc1_err_crc[1:1];

        enum MIPI0_PKT_INTR_ST_vc0_err_crc_enum {
            NO = 0 { name = "No"; desc = "no"; };
            YES = 1 { name = "Yes"; desc = "yes"; };
        };

        field {
            name = "vc0_err_crc";
            desc = "Whether the VC 0 data has CRC errors. This bit is cleared when it is read.";
            sw = r;
            hw = w;
            onread = rclr;
            encode = MIPI0_PKT_INTR_ST_vc0_err_crc_enum;
            reset = 0x0;
        } vc0_err_crc[0:0];
    } MIPI0_PKT_INTR_ST @ 0x1060;

    reg {
        name = "MIPI 0 packet interrupt mask register INTR_MSK";
        desc = "MIPI0_PKT_INTR_MSK is a MIPI 0 packet interrupt mask register. Hi3516A V200 Professional HD IP Camera SoC

Data sheet 9.3.6 MIPI0_PKT_INTR_MSK (offset 0x1064, printed page 9-261, `hi3516av200--Hi3516AV200-Datasheet.txt` line 52003).";

        enum MIPI0_PKT_INTR_MSK_mask_err_ecc_double_enum {
            MASKED = 0 { name = "Masked"; desc = "masked"; };
            ENABLED = 1 { name = "Enabled"; desc = "enabled"; };
        };

        field {
            name = "mask_err_ecc_double";
            desc = "err_ecc_double interrupt mask";
            sw = rw;
            hw = r;
            encode = MIPI0_PKT_INTR_MSK_mask_err_ecc_double_enum;
            reset = 0x0;
        } mask_err_ecc_double[16:16];

        enum MIPI0_PKT_INTR_MSK_mask_vc3_err_crc_enum {
            MASKED = 0 { name = "Masked"; desc = "masked"; };
            ENABLED = 1 { name = "Enabled"; desc = "enabled"; };
        };

        field {
            name = "mask_vc3_err_crc";
            desc = "vc3_err_crc interrupt mask";
            sw = rw;
            hw = r;
            encode = MIPI0_PKT_INTR_MSK_mask_vc3_err_crc_enum;
            reset = 0x0;
        } mask_vc3_err_crc[3:3];

        enum MIPI0_PKT_INTR_MSK_mask_vc2_err_crc_enum {
            MASKED = 0 { name = "Masked"; desc = "masked"; };
            ENABLED = 1 { name = "Enabled"; desc = "enabled"; };
        };

        field {
            name = "mask_vc2_err_crc";
            desc = "vc2_err_crc interrupt mask";
            sw = rw;
            hw = r;
            encode = MIPI0_PKT_INTR_MSK_mask_vc2_err_crc_enum;
            reset = 0x0;
        } mask_vc2_err_crc[2:2];

        enum MIPI0_PKT_INTR_MSK_mask_vc1_err_crc_enum {
            MASKED = 0 { name = "Masked"; desc = "masked"; };
            ENABLED = 1 { name = "Enabled"; desc = "enabled"; };
        };

        field {
            name = "mask_vc1_err_crc";
            desc = "vc1_err_crc interrupt mask";
            sw = rw;
            hw = r;
            encode = MIPI0_PKT_INTR_MSK_mask_vc1_err_crc_enum;
            reset = 0x0;
        } mask_vc1_err_crc[1:1];

        enum MIPI0_PKT_INTR_MSK_mask_vc0_err_crc_enum {
            MASKED = 0 { name = "Masked"; desc = "masked"; };
            ENABLED = 1 { name = "Enabled"; desc = "enabled"; };
        };

        field {
            name = "mask_vc0_err_crc";
            desc = "vc0_err_crc interrupt mask";
            sw = rw;
            hw = r;
            encode = MIPI0_PKT_INTR_MSK_mask_vc0_err_crc_enum;
            reset = 0x0;
        } mask_vc0_err_crc[0:0];
    } MIPI0_PKT_INTR_MSK @ 0x1064;

    reg {
        name = "MIPI0 PKT INTR FORCE";
        desc = "[inferred] MIPI0 PKT INTR FORCE. Not in the data sheet. Source: OpenIPC openhisilicon `kernel/mipi_rx/hi3519v101/mipi_reg.h` (GPL-3.0 repository, HiSilicon copyright; local copy sources/openhisilicon), union `U_MIPI_PKT_INTR_FORCE`, struct offset 0x1068 (GPL-3.0 repository, HiSilicon copyright; one header for Hi3519 V101 and Hi3516A V200). Reset value and access type unknown (modelled RW, no reset). Confidence: medium (vendor header for this chip family, not hardware verified).";

        field {
            name = "force_err_ecc_double";
            desc = "[inferred] Force error ecc double. (vendor header `hi3519v101/mipi_reg.h` field `force_err_ecc_double`; access and reset unknown, modelled RW)";
            sw = rw;
            hw = r;
        } force_err_ecc_double[16:16];

        field {
            name = "force_vc3_err_crc";
            desc = "[inferred] Force vc3 error crc. (vendor header `hi3519v101/mipi_reg.h` field `force_vc3_err_crc`; access and reset unknown, modelled RW)";
            sw = rw;
            hw = r;
        } force_vc3_err_crc[3:3];

        field {
            name = "force_vc2_err_crc";
            desc = "[inferred] Force vc2 error crc. (vendor header `hi3519v101/mipi_reg.h` field `force_vc2_err_crc`; access and reset unknown, modelled RW)";
            sw = rw;
            hw = r;
        } force_vc2_err_crc[2:2];

        field {
            name = "force_vc1_err_crc";
            desc = "[inferred] Force vc1 error crc. (vendor header `hi3519v101/mipi_reg.h` field `force_vc1_err_crc`; access and reset unknown, modelled RW)";
            sw = rw;
            hw = r;
        } force_vc1_err_crc[1:1];

        field {
            name = "force_vc0_err_crc";
            desc = "[inferred] Force vc0 error crc. (vendor header `hi3519v101/mipi_reg.h` field `force_vc0_err_crc`; access and reset unknown, modelled RW)";
            sw = rw;
            hw = r;
        } force_vc0_err_crc[0:0];
    } MIPI0_PKT_INTR_FORCE @ 0x1068;

    reg {
        name = "MIPI 0 packet interrupt status register 2 INTR2_ST";
        desc = "MIPI0_PKT_INTR2_ST is MIPI 0 packet interrupt status register 2. Hi3516A V200 Professional HD IP Camera SoC

Data sheet 9.3.6 MIPI0_PKT_INTR2_ST (offset 0x1070, printed page 9-262, `hi3516av200--Hi3516AV200-Datasheet.txt` line 52056).";

        enum MIPI0_PKT_INTR2_ST_vc3_err_ecc_corrected_enum {
            NO = 0 { name = "No"; desc = "no"; };
            YES_ECC_ERRORS = 1 { name = "Yes Ecc Errors"; desc = "yes. The ECC errors have been corrected."; };
        };

        field {
            name = "vc3_err_ecc_corrected";
            desc = "Whether the VC 3 channel header has ECC errors. This bit is cleared when it is read.";
            sw = r;
            hw = w;
            onread = rclr;
            encode = MIPI0_PKT_INTR2_ST_vc3_err_ecc_corrected_enum;
            reset = 0x0;
        } vc3_err_ecc_corrected[19:19];

        enum MIPI0_PKT_INTR2_ST_vc2_err_ecc_corrected_enum {
            NO = 0 { name = "No"; desc = "no"; };
            YES_ECC_ERRORS = 1 { name = "Yes Ecc Errors"; desc = "yes. The ECC errors have been corrected."; };
        };

        field {
            name = "vc2_err_ecc_corrected";
            desc = "Whether the VC 2 channel header has ECC errors. This bit is cleared when it is read.";
            sw = r;
            hw = w;
            onread = rclr;
            encode = MIPI0_PKT_INTR2_ST_vc2_err_ecc_corrected_enum;
            reset = 0x0;
        } vc2_err_ecc_corrected[18:18];

        enum MIPI0_PKT_INTR2_ST_vc1_err_ecc_corrected_enum {
            NO = 0 { name = "No"; desc = "no"; };
            YES_ECC_ERRORS = 1 { name = "Yes Ecc Errors"; desc = "yes. The ECC errors have been corrected."; };
        };

        field {
            name = "vc1_err_ecc_corrected";
            desc = "Whether the VC 1 channel header has ECC errors. This bit is cleared when it is read.";
            sw = r;
            hw = w;
            onread = rclr;
            encode = MIPI0_PKT_INTR2_ST_vc1_err_ecc_corrected_enum;
            reset = 0x0;
        } vc1_err_ecc_corrected[17:17];

        enum MIPI0_PKT_INTR2_ST_vc0_err_ecc_corrected_enum {
            NO = 0 { name = "No"; desc = "no"; };
            YES_ECC_ERRORS = 1 { name = "Yes Ecc Errors"; desc = "yes. The ECC errors have been corrected."; };
        };

        field {
            name = "vc0_err_ecc_corrected";
            desc = "Whether the VC 0 channel header has ECC errors. This bit is cleared when it is read.";
            sw = r;
            hw = w;
            onread = rclr;
            encode = MIPI0_PKT_INTR2_ST_vc0_err_ecc_corrected_enum;
            reset = 0x0;
        } vc0_err_ecc_corrected[16:16];

        enum MIPI0_PKT_INTR2_ST_err_id_vc3_enum {
            SUPPORTED = 0 { name = "Supported"; desc = "supported"; };
            NOT_SUPPORTED = 1 { name = "Not Supported"; desc = "not supported"; };
        };

        field {
            name = "err_id_vc3";
            desc = "Whether the VC 3 channel data type is supported. This bit is cleared when it is read.";
            sw = r;
            hw = w;
            onread = rclr;
            encode = MIPI0_PKT_INTR2_ST_err_id_vc3_enum;
            reset = 0x0;
        } err_id_vc3[3:3];

        enum MIPI0_PKT_INTR2_ST_err_id_vc2_enum {
            SUPPORTED = 0 { name = "Supported"; desc = "supported"; };
            NOT_SUPPORTED = 1 { name = "Not Supported"; desc = "not supported"; };
        };

        field {
            name = "err_id_vc2";
            desc = "Whether the VC 2 channel data type is supported. This bit is cleared when it is read.";
            sw = r;
            hw = w;
            onread = rclr;
            encode = MIPI0_PKT_INTR2_ST_err_id_vc2_enum;
            reset = 0x0;
        } err_id_vc2[2:2];

        enum MIPI0_PKT_INTR2_ST_err_id_vc1_enum {
            SUPPORTED = 0 { name = "Supported"; desc = "supported"; };
            NOT_SUPPORTED = 1 { name = "Not Supported"; desc = "not supported"; };
        };

        field {
            name = "err_id_vc1";
            desc = "Whether the VC 1 channel data type is supported. This bit is cleared when it is read.";
            sw = r;
            hw = w;
            onread = rclr;
            encode = MIPI0_PKT_INTR2_ST_err_id_vc1_enum;
            reset = 0x0;
        } err_id_vc1[1:1];

        enum MIPI0_PKT_INTR2_ST_err_id_vc0_enum {
            SUPPORTED = 0 { name = "Supported"; desc = "supported"; };
            NOT_SUPPORTED = 1 { name = "Not Supported"; desc = "not supported"; };
        };

        field {
            name = "err_id_vc0";
            desc = "Whether the VC 0 channel data type is supported. This bit is cleared when it is read.";
            sw = r;
            hw = w;
            onread = rclr;
            encode = MIPI0_PKT_INTR2_ST_err_id_vc0_enum;
            reset = 0x0;
        } err_id_vc0[0:0];
    } MIPI0_PKT_INTR2_ST @ 0x1070;

    reg {
        name = "MIPI 0 packet interrupt mask register 2 INTR2_MSK";
        desc = "MIPI0_PKT_INTR2_MSK is MIPI 0 packet interrupt mask register 2.

Data sheet 9.3.6 MIPI0_PKT_INTR2_MSK (offset 0x1074, printed page 9-263, `hi3516av200--Hi3516AV200-Datasheet.txt` line 52134).";

        enum MIPI0_PKT_INTR2_MSK_mask_vc3_err_ecc_corrected_enum {
            MASKED = 0 { name = "Masked"; desc = "masked"; };
            ENABLED = 1 { name = "Enabled"; desc = "enabled"; };
        };

        field {
            name = "mask_vc3_err_ecc_corrected";
            desc = "vc3_err_ecc_corrected interrupt mask";
            sw = rw;
            hw = r;
            encode = MIPI0_PKT_INTR2_MSK_mask_vc3_err_ecc_corrected_enum;
            reset = 0x0;
        } mask_vc3_err_ecc_corrected[19:19];

        enum MIPI0_PKT_INTR2_MSK_mask_vc2_err_ecc_corrected_enum {
            MASKED = 0 { name = "Masked"; desc = "masked"; };
            ENABLED = 1 { name = "Enabled"; desc = "enabled"; };
        };

        field {
            name = "mask_vc2_err_ecc_corrected";
            desc = "vc2_err_ecc_corrected interrupt mask";
            sw = rw;
            hw = r;
            encode = MIPI0_PKT_INTR2_MSK_mask_vc2_err_ecc_corrected_enum;
            reset = 0x0;
        } mask_vc2_err_ecc_corrected[18:18];

        enum MIPI0_PKT_INTR2_MSK_mask_vc1_err_ecc_corrected_enum {
            MASKED = 0 { name = "Masked"; desc = "masked"; };
            ENABLED = 1 { name = "Enabled"; desc = "enabled"; };
        };

        field {
            name = "mask_vc1_err_ecc_corrected";
            desc = "vc1_err_ecc_corrected interrupt mask";
            sw = rw;
            hw = r;
            encode = MIPI0_PKT_INTR2_MSK_mask_vc1_err_ecc_corrected_enum;
            reset = 0x0;
        } mask_vc1_err_ecc_corrected[17:17];

        enum MIPI0_PKT_INTR2_MSK_mask_vc0_err_ecc_corrected_enum {
            MASKED = 0 { name = "Masked"; desc = "masked"; };
            ENABLED = 1 { name = "Enabled"; desc = "enabled"; };
        };

        field {
            name = "mask_vc0_err_ecc_corrected";
            desc = "vc0_err_ecc_corrected interrupt mask";
            sw = rw;
            hw = r;
            encode = MIPI0_PKT_INTR2_MSK_mask_vc0_err_ecc_corrected_enum;
            reset = 0x0;
        } mask_vc0_err_ecc_corrected[16:16];

        enum MIPI0_PKT_INTR2_MSK_mask_err_id_vc3_enum {
            MASKED = 0 { name = "Masked"; desc = "masked"; };
            ENABLED = 1 { name = "Enabled"; desc = "enabled"; };
        };

        field {
            name = "mask_err_id_vc3";
            desc = "err_id_vc3 interrupt mask";
            sw = rw;
            hw = r;
            encode = MIPI0_PKT_INTR2_MSK_mask_err_id_vc3_enum;
            reset = 0x0;
        } mask_err_id_vc3[3:3];

        enum MIPI0_PKT_INTR2_MSK_mask_err_id_vc2_enum {
            MASKED = 0 { name = "Masked"; desc = "masked"; };
            ENABLED = 1 { name = "Enabled"; desc = "enabled"; };
        };

        field {
            name = "mask_err_id_vc2";
            desc = "err_id_vc2 interrupt mask";
            sw = rw;
            hw = r;
            encode = MIPI0_PKT_INTR2_MSK_mask_err_id_vc2_enum;
            reset = 0x0;
        } mask_err_id_vc2[2:2];

        enum MIPI0_PKT_INTR2_MSK_mask_err_id_vc1_enum {
            MASKED = 0 { name = "Masked"; desc = "masked"; };
            ENABLED = 1 { name = "Enabled"; desc = "enabled"; };
        };

        field {
            name = "mask_err_id_vc1";
            desc = "err_id_vc1 interrupt mask";
            sw = rw;
            hw = r;
            encode = MIPI0_PKT_INTR2_MSK_mask_err_id_vc1_enum;
            reset = 0x0;
        } mask_err_id_vc1[1:1];

        enum MIPI0_PKT_INTR2_MSK_mask_err_id_vc0_enum {
            MASKED = 0 { name = "Masked"; desc = "masked"; };
            ENABLED = 1 { name = "Enabled"; desc = "enabled"; };
        };

        field {
            name = "mask_err_id_vc0";
            desc = "err_id_vc0 interrupt mask";
            sw = rw;
            hw = r;
            encode = MIPI0_PKT_INTR2_MSK_mask_err_id_vc0_enum;
            reset = 0x0;
        } mask_err_id_vc0[0:0];
    } MIPI0_PKT_INTR2_MSK @ 0x1074;

    reg {
        name = "MIPI0 PKT INTR2 FORCE";
        desc = "[inferred] MIPI0 PKT INTR2 FORCE. Not in the data sheet. Source: OpenIPC openhisilicon `kernel/mipi_rx/hi3519v101/mipi_reg.h` (GPL-3.0 repository, HiSilicon copyright; local copy sources/openhisilicon), union `U_MIPI_PKT_INTR2_FORCE`, struct offset 0x1078 (GPL-3.0 repository, HiSilicon copyright; one header for Hi3519 V101 and Hi3516A V200). Reset value and access type unknown (modelled RW, no reset). Confidence: medium (vendor header for this chip family, not hardware verified).";

        field {
            name = "force_vc3_err_ecc_corrected";
            desc = "[inferred] Force vc3 error ecc corrected. (vendor header `hi3519v101/mipi_reg.h` field `force_vc3_err_ecc_corrected`; access and reset unknown, modelled RW)";
            sw = rw;
            hw = r;
        } force_vc3_err_ecc_corrected[19:19];

        field {
            name = "force_vc2_err_ecc_corrected";
            desc = "[inferred] Force vc2 error ecc corrected. (vendor header `hi3519v101/mipi_reg.h` field `force_vc2_err_ecc_corrected`; access and reset unknown, modelled RW)";
            sw = rw;
            hw = r;
        } force_vc2_err_ecc_corrected[18:18];

        field {
            name = "force_vc1_err_ecc_corrected";
            desc = "[inferred] Force vc1 error ecc corrected. (vendor header `hi3519v101/mipi_reg.h` field `force_vc1_err_ecc_corrected`; access and reset unknown, modelled RW)";
            sw = rw;
            hw = r;
        } force_vc1_err_ecc_corrected[17:17];

        field {
            name = "force_vc0_err_ecc_corrected";
            desc = "[inferred] Force vc0 error ecc corrected. (vendor header `hi3519v101/mipi_reg.h` field `force_vc0_err_ecc_corrected`; access and reset unknown, modelled RW)";
            sw = rw;
            hw = r;
        } force_vc0_err_ecc_corrected[16:16];

        field {
            name = "force_err_id_vc3";
            desc = "[inferred] Force error id vc3. (vendor header `hi3519v101/mipi_reg.h` field `force_err_id_vc3`; access and reset unknown, modelled RW)";
            sw = rw;
            hw = r;
        } force_err_id_vc3[3:3];

        field {
            name = "force_err_id_vc2";
            desc = "[inferred] Force error id vc2. (vendor header `hi3519v101/mipi_reg.h` field `force_err_id_vc2`; access and reset unknown, modelled RW)";
            sw = rw;
            hw = r;
        } force_err_id_vc2[2:2];

        field {
            name = "force_err_id_vc1";
            desc = "[inferred] Force error id vc1. (vendor header `hi3519v101/mipi_reg.h` field `force_err_id_vc1`; access and reset unknown, modelled RW)";
            sw = rw;
            hw = r;
        } force_err_id_vc1[1:1];

        field {
            name = "force_err_id_vc0";
            desc = "[inferred] Force error id vc0. (vendor header `hi3519v101/mipi_reg.h` field `force_err_id_vc0`; access and reset unknown, modelled RW)";
            sw = rw;
            hw = r;
        } force_err_id_vc0[0:0];
    } MIPI0_PKT_INTR2_FORCE @ 0x1078;

    reg {
        name = "MIPI 0 frame interrupt status register ME_INTR_S T";
        desc = "MIPI0_FRAME_INTR_ST is a MIPI 0 frame interrupt status register.

Data sheet 9.3.6 MIPI0_FRAME_INTR_ST (offset 0x1080, printed page 9-264, `hi3516av200--Hi3516AV200-Datasheet.txt` line 52204).";

        enum MIPI0_FRAME_INTR_ST_err_frame_data_vc3_enum {
            NO_CRC_ERROR = 0 { name = "No Crc Error"; desc = "No CRC error occurs."; };
            CRC_ERRORS_OCCUR = 1 { name = "Crc Errors Occur"; desc = "CRC errors occur."; };
        };

        field {
            name = "err_frame_data_vc3";
            desc = "Whether the last frame of VC 3 channel data has at least one CRC error. This bit is cleared when it is read.";
            sw = r;
            hw = w;
            encode = MIPI0_FRAME_INTR_ST_err_frame_data_vc3_enum;
            reset = 0x0;
        } err_frame_data_vc3[19:19];

        enum MIPI0_FRAME_INTR_ST_err_frame_data_vc2_enum {
            NO_CRC_ERROR = 0 { name = "No Crc Error"; desc = "No CRC error occurs."; };
            CRC_ERRORS_OCCUR = 1 { name = "Crc Errors Occur"; desc = "CRC errors occur."; };
        };

        field {
            name = "err_frame_data_vc2";
            desc = "Whether the last frame of VC 2 channel data has at least one CRC error. This bit is cleared when it is read.";
            sw = r;
            hw = w;
            encode = MIPI0_FRAME_INTR_ST_err_frame_data_vc2_enum;
            reset = 0x0;
        } err_frame_data_vc2[18:18];

        enum MIPI0_FRAME_INTR_ST_err_frame_data_vc1_enum {
            NO_CRC_ERROR = 0 { name = "No Crc Error"; desc = "No CRC error occurs."; };
            CRC_ERRORS_OCCUR = 1 { name = "Crc Errors Occur"; desc = "CRC errors occur."; };
        };

        field {
            name = "err_frame_data_vc1";
            desc = "Whether the last frame of VC 1 channel data has at least one CRC error. This bit is cleared when it is read.";
            sw = r;
            hw = w;
            encode = MIPI0_FRAME_INTR_ST_err_frame_data_vc1_enum;
            reset = 0x0;
        } err_frame_data_vc1[17:17];

        enum MIPI0_FRAME_INTR_ST_err_frame_data_vc0_enum {
            NO_CRC_ERROR = 0 { name = "No Crc Error"; desc = "No CRC error occurs."; };
            CRC_ERRORS_OCCUR = 1 { name = "Crc Errors Occur"; desc = "CRC errors occur."; };
        };

        field {
            name = "err_frame_data_vc0";
            desc = "Whether the last frame of VC 0 channel data has at least one CRC error. This bit is cleared when it is read.";
            sw = r;
            hw = w;
            encode = MIPI0_FRAME_INTR_ST_err_frame_data_vc0_enum;
            reset = 0x0;
        } err_frame_data_vc0[16:16];

        enum MIPI0_FRAME_INTR_ST_err_f_seq_vc3_enum {
            YES = 0 { name = "Yes"; desc = "yes"; };
            NO = 1 { name = "No"; desc = "no"; };
        };

        field {
            name = "err_f_seq_vc3";
            desc = "Whether the VC 3 frame sequence is correct. This bit is cleared when it is read.";
            sw = r;
            hw = w;
            encode = MIPI0_FRAME_INTR_ST_err_f_seq_vc3_enum;
            reset = 0x0;
        } err_f_seq_vc3[11:11];

        enum MIPI0_FRAME_INTR_ST_err_f_seq_vc2_enum {
            YES = 0 { name = "Yes"; desc = "yes"; };
            NO = 1 { name = "No"; desc = "no"; };
        };

        field {
            name = "err_f_seq_vc2";
            desc = "Whether the VC 2 frame sequence is correct. This bit is cleared when it is read.";
            sw = r;
            hw = w;
            encode = MIPI0_FRAME_INTR_ST_err_f_seq_vc2_enum;
            reset = 0x0;
        } err_f_seq_vc2[10:10];

        enum MIPI0_FRAME_INTR_ST_err_f_seq_vc1_enum {
            YES = 0 { name = "Yes"; desc = "yes"; };
            NO = 1 { name = "No"; desc = "no"; };
        };

        field {
            name = "err_f_seq_vc1";
            desc = "Whether the VC 1 frame sequence is correct. This bit is cleared when it is read.";
            sw = r;
            hw = w;
            encode = MIPI0_FRAME_INTR_ST_err_f_seq_vc1_enum;
            reset = 0x0;
        } err_f_seq_vc1[9:9];

        enum MIPI0_FRAME_INTR_ST_err_f_seq_vc0_enum {
            YES = 0 { name = "Yes"; desc = "yes"; };
            NO = 1 { name = "No"; desc = "no"; };
        };

        field {
            name = "err_f_seq_vc0";
            desc = "Whether the VC 0 frame sequence is correct. This bit is cleared when it is read.";
            sw = r;
            hw = w;
            encode = MIPI0_FRAME_INTR_ST_err_f_seq_vc0_enum;
            reset = 0x0;
        } err_f_seq_vc0[8:8];

        enum MIPI0_FRAME_INTR_ST_err_f_bndry_match_vc3_enum {
            YES = 0 { name = "Yes"; desc = "yes"; };
            NO = 1 { name = "No"; desc = "no"; };
        };

        field {
            name = "err_f_bndry_match_vc3";
            desc = "Whether the SOF matches the EOF for the VC 3 channel. This bit is cleared when it is read.";
            sw = r;
            hw = w;
            encode = MIPI0_FRAME_INTR_ST_err_f_bndry_match_vc3_enum;
            reset = 0x0;
        } err_f_bndry_match_vc3[3:3];

        enum MIPI0_FRAME_INTR_ST_err_f_bndry_match_vc2_enum {
            YES = 0 { name = "Yes"; desc = "yes"; };
            NO = 1 { name = "No"; desc = "no"; };
        };

        field {
            name = "err_f_bndry_match_vc2";
            desc = "Whether the SOF matches the EOF for the VC 2 channel. This bit is cleared when it is read.";
            sw = r;
            hw = w;
            encode = MIPI0_FRAME_INTR_ST_err_f_bndry_match_vc2_enum;
            reset = 0x0;
        } err_f_bndry_match_vc2[2:2];

        enum MIPI0_FRAME_INTR_ST_err_f_bndry_match_vc1_enum {
            YES = 0 { name = "Yes"; desc = "yes"; };
            NO = 1 { name = "No"; desc = "no"; };
        };

        field {
            name = "err_f_bndry_match_vc1";
            desc = "Whether the SOF matches the EOF for the VC 1 channel. This bit is cleared when it is read.";
            sw = r;
            hw = w;
            encode = MIPI0_FRAME_INTR_ST_err_f_bndry_match_vc1_enum;
            reset = 0x0;
        } err_f_bndry_match_vc1[1:1];

        enum MIPI0_FRAME_INTR_ST_err_f_bndry_match_vc0_enum {
            YES = 0 { name = "Yes"; desc = "yes"; };
            NO = 1 { name = "No"; desc = "no"; };
        };

        field {
            name = "err_f_bndry_match_vc0";
            desc = "Whether the SOF matches the EOF for the VC 0 channel. This bit is cleared when it is read.";
            sw = r;
            hw = w;
            encode = MIPI0_FRAME_INTR_ST_err_f_bndry_match_vc0_enum;
            reset = 0x0;
        } err_f_bndry_match_vc0[0:0];
    } MIPI0_FRAME_INTR_ST @ 0x1080;

    reg {
        name = "MIPI 0 frame interrupt mask register ME_INTR_ MSK";
        desc = "MIPI0_FRAME_INTR_MSK is a MIPI 0 frame interrupt mask register.

Data sheet 9.3.6 MIPI0_FRAME_INTR_MSK (offset 0x1084, printed page 9-266, `hi3516av200--Hi3516AV200-Datasheet.txt` line 52314).";

        enum MIPI0_FRAME_INTR_MSK_mask_err_frame_data_vc3_enum {
            MASKED = 0 { name = "Masked"; desc = "masked"; };
            ENABLED = 1 { name = "Enabled"; desc = "enabled"; };
        };

        field {
            name = "mask_err_frame_data_vc3";
            desc = "err_frame_data_vc3 interrupt mask";
            sw = rw;
            hw = r;
            encode = MIPI0_FRAME_INTR_MSK_mask_err_frame_data_vc3_enum;
            reset = 0x0;
        } mask_err_frame_data_vc3[19:19];

        enum MIPI0_FRAME_INTR_MSK_mask_err_frame_data_vc2_enum {
            MASKED = 0 { name = "Masked"; desc = "masked"; };
            ENABLED = 1 { name = "Enabled"; desc = "enabled"; };
        };

        field {
            name = "mask_err_frame_data_vc2";
            desc = "err_frame_data_vc2 interrupt mask";
            sw = rw;
            hw = r;
            encode = MIPI0_FRAME_INTR_MSK_mask_err_frame_data_vc2_enum;
            reset = 0x0;
        } mask_err_frame_data_vc2[18:18];

        enum MIPI0_FRAME_INTR_MSK_mask_err_frame_data_vc1_enum {
            MASKED = 0 { name = "Masked"; desc = "masked"; };
            ENABLED = 1 { name = "Enabled"; desc = "enabled"; };
        };

        field {
            name = "mask_err_frame_data_vc1";
            desc = "err_frame_data_vc1 interrupt mask";
            sw = rw;
            hw = r;
            encode = MIPI0_FRAME_INTR_MSK_mask_err_frame_data_vc1_enum;
            reset = 0x0;
        } mask_err_frame_data_vc1[17:17];

        enum MIPI0_FRAME_INTR_MSK_mask_err_frame_data_vc0_enum {
            MASKED = 0 { name = "Masked"; desc = "masked"; };
            ENABLED = 1 { name = "Enabled"; desc = "enabled"; };
        };

        field {
            name = "mask_err_frame_data_vc0";
            desc = "err_frame_data_vc0 interrupt mask";
            sw = rw;
            hw = r;
            encode = MIPI0_FRAME_INTR_MSK_mask_err_frame_data_vc0_enum;
            reset = 0x0;
        } mask_err_frame_data_vc0[16:16];

        enum MIPI0_FRAME_INTR_MSK_mask_err_f_seq_vc_enum {
            MASKED = 0 { name = "Masked"; desc = "masked"; };
            ENABLED = 1 { name = "Enabled"; desc = "enabled"; };
        };

        field {
            name = "mask_err_f_seq_vc";
            desc = "err_f_seq_vc3 interrupt mask";
            sw = rw;
            hw = r;
            encode = MIPI0_FRAME_INTR_MSK_mask_err_f_seq_vc_enum;
            reset = 0x0;
        } mask_err_f_seq_vc[11:11];

        enum MIPI0_FRAME_INTR_MSK_mask_err_f_seq_vc_2_enum {
            MASKED = 0 { name = "Masked"; desc = "masked"; };
            ENABLED = 1 { name = "Enabled"; desc = "enabled"; };
        };

        field {
            name = "mask_err_f_seq_vc";
            desc = "err_f_seq_vc2 interrupt mask";
            sw = rw;
            hw = r;
            encode = MIPI0_FRAME_INTR_MSK_mask_err_f_seq_vc_2_enum;
            reset = 0x0;
        } mask_err_f_seq_vc_2[10:10];

        enum MIPI0_FRAME_INTR_MSK_mask_err_f_seq_vc_3_enum {
            MASKED = 0 { name = "Masked"; desc = "masked"; };
            ENABLED = 1 { name = "Enabled"; desc = "enabled"; };
        };

        field {
            name = "mask_err_f_seq_vc";
            desc = "err_f_seq_vc1 interrupt mask";
            sw = rw;
            hw = r;
            encode = MIPI0_FRAME_INTR_MSK_mask_err_f_seq_vc_3_enum;
            reset = 0x0;
        } mask_err_f_seq_vc_3[9:9];

        enum MIPI0_FRAME_INTR_MSK_mask_err_f_seq_vc_4_enum {
            MASKED = 0 { name = "Masked"; desc = "masked"; };
            ENABLED = 1 { name = "Enabled"; desc = "enabled"; };
        };

        field {
            name = "mask_err_f_seq_vc";
            desc = "err_f_seq_vc0 interrupt mask";
            sw = rw;
            hw = r;
            encode = MIPI0_FRAME_INTR_MSK_mask_err_f_seq_vc_4_enum;
            reset = 0x0;
        } mask_err_f_seq_vc_4[8:8];

        enum MIPI0_FRAME_INTR_MSK_mask_err_f_bndry_match_vc3_enum {
            MASKED = 0 { name = "Masked"; desc = "masked"; };
            ENABLED = 1 { name = "Enabled"; desc = "enabled"; };
        };

        field {
            name = "mask_err_f_bndry_match_vc3";
            desc = "err_f_bndry_match_vc3 interrupt mask";
            sw = rw;
            hw = r;
            encode = MIPI0_FRAME_INTR_MSK_mask_err_f_bndry_match_vc3_enum;
            reset = 0x0;
        } mask_err_f_bndry_match_vc3[3:3];

        enum MIPI0_FRAME_INTR_MSK_mask_err_f_bndry_match_vc2_enum {
            MASKED = 0 { name = "Masked"; desc = "masked"; };
            ENABLED = 1 { name = "Enabled"; desc = "enabled"; };
        };

        field {
            name = "mask_err_f_bndry_match_vc2";
            desc = "err_f_bndry_match_vc2 interrupt mask";
            sw = rw;
            hw = r;
            encode = MIPI0_FRAME_INTR_MSK_mask_err_f_bndry_match_vc2_enum;
            reset = 0x0;
        } mask_err_f_bndry_match_vc2[2:2];

        enum MIPI0_FRAME_INTR_MSK_mask_err_f_bndry_match_vc1_enum {
            MASKED = 0 { name = "Masked"; desc = "masked"; };
            ENABLED = 1 { name = "Enabled"; desc = "enabled"; };
        };

        field {
            name = "mask_err_f_bndry_match_vc1";
            desc = "err_f_bndry_match_vc1 interrupt mask";
            sw = rw;
            hw = r;
            encode = MIPI0_FRAME_INTR_MSK_mask_err_f_bndry_match_vc1_enum;
            reset = 0x0;
        } mask_err_f_bndry_match_vc1[1:1];

        enum MIPI0_FRAME_INTR_MSK_mask_err_f_bndry_match_vc0_enum {
            MASKED = 0 { name = "Masked"; desc = "masked"; };
            ENABLED = 1 { name = "Enabled"; desc = "enabled"; };
        };

        field {
            name = "mask_err_f_bndry_match_vc0";
            desc = "err_f_bndry_match_vc0 interrupt mask";
            sw = rw;
            hw = r;
            encode = MIPI0_FRAME_INTR_MSK_mask_err_f_bndry_match_vc0_enum;
            reset = 0x0;
        } mask_err_f_bndry_match_vc0[0:0];
    } MIPI0_FRAME_INTR_MSK @ 0x1084;

    reg {
        name = "MIPI0 FRAME INTR FORCE";
        desc = "[inferred] MIPI0 FRAME INTR FORCE. Not in the data sheet. Source: OpenIPC openhisilicon `kernel/mipi_rx/hi3519v101/mipi_reg.h` (GPL-3.0 repository, HiSilicon copyright; local copy sources/openhisilicon), union `U_MIPI_FRAME_INTR_FORCE`, struct offset 0x1088 (GPL-3.0 repository, HiSilicon copyright; one header for Hi3519 V101 and Hi3516A V200). Reset value and access type unknown (modelled RW, no reset). Confidence: medium (vendor header for this chip family, not hardware verified).";

        field {
            name = "force_err_frame_data_vc3";
            desc = "[inferred] Force error frame data vc3. (vendor header `hi3519v101/mipi_reg.h` field `force_err_frame_data_vc3`; access and reset unknown, modelled RW)";
            sw = rw;
            hw = r;
        } force_err_frame_data_vc3[19:19];

        field {
            name = "force_err_frame_data_vc2";
            desc = "[inferred] Force error frame data vc2. (vendor header `hi3519v101/mipi_reg.h` field `force_err_frame_data_vc2`; access and reset unknown, modelled RW)";
            sw = rw;
            hw = r;
        } force_err_frame_data_vc2[18:18];

        field {
            name = "force_err_frame_data_vc1";
            desc = "[inferred] Force error frame data vc1. (vendor header `hi3519v101/mipi_reg.h` field `force_err_frame_data_vc1`; access and reset unknown, modelled RW)";
            sw = rw;
            hw = r;
        } force_err_frame_data_vc1[17:17];

        field {
            name = "force_err_frame_data_vc0";
            desc = "[inferred] Force error frame data vc0. (vendor header `hi3519v101/mipi_reg.h` field `force_err_frame_data_vc0`; access and reset unknown, modelled RW)";
            sw = rw;
            hw = r;
        } force_err_frame_data_vc0[16:16];

        field {
            name = "force_err_f_seq_vc3";
            desc = "[inferred] Force error f seq vc3. (vendor header `hi3519v101/mipi_reg.h` field `force_err_f_seq_vc3`; access and reset unknown, modelled RW)";
            sw = rw;
            hw = r;
        } force_err_f_seq_vc3[11:11];

        field {
            name = "force_err_f_seq_vc2";
            desc = "[inferred] Force error f seq vc2. (vendor header `hi3519v101/mipi_reg.h` field `force_err_f_seq_vc2`; access and reset unknown, modelled RW)";
            sw = rw;
            hw = r;
        } force_err_f_seq_vc2[10:10];

        field {
            name = "force_err_f_seq_vc1";
            desc = "[inferred] Force error f seq vc1. (vendor header `hi3519v101/mipi_reg.h` field `force_err_f_seq_vc1`; access and reset unknown, modelled RW)";
            sw = rw;
            hw = r;
        } force_err_f_seq_vc1[9:9];

        field {
            name = "force_err_f_seq_vc0";
            desc = "[inferred] Force error f seq vc0. (vendor header `hi3519v101/mipi_reg.h` field `force_err_f_seq_vc0`; access and reset unknown, modelled RW)";
            sw = rw;
            hw = r;
        } force_err_f_seq_vc0[8:8];

        field {
            name = "force_err_f_bndry_match_vc3";
            desc = "[inferred] Force error f bndry match vc3. (vendor header `hi3519v101/mipi_reg.h` field `force_err_f_bndry_match_vc3`; access and reset unknown, modelled RW)";
            sw = rw;
            hw = r;
        } force_err_f_bndry_match_vc3[3:3];

        field {
            name = "force_err_f_bndry_match_vc2";
            desc = "[inferred] Force error f bndry match vc2. (vendor header `hi3519v101/mipi_reg.h` field `force_err_f_bndry_match_vc2`; access and reset unknown, modelled RW)";
            sw = rw;
            hw = r;
        } force_err_f_bndry_match_vc2[2:2];

        field {
            name = "force_err_f_bndry_match_vc1";
            desc = "[inferred] Force error f bndry match vc1. (vendor header `hi3519v101/mipi_reg.h` field `force_err_f_bndry_match_vc1`; access and reset unknown, modelled RW)";
            sw = rw;
            hw = r;
        } force_err_f_bndry_match_vc1[1:1];

        field {
            name = "force_err_f_bndry_match_vc0";
            desc = "[inferred] Force error f bndry match vc0. (vendor header `hi3519v101/mipi_reg.h` field `force_err_f_bndry_match_vc0`; access and reset unknown, modelled RW)";
            sw = rw;
            hw = r;
        } force_err_f_bndry_match_vc0[0:0];
    } MIPI0_FRAME_INTR_FORCE @ 0x1088;

    reg {
        name = "MIPI 0 line interrupt status register _INTR_ST";
        desc = "MIPI0_LINE_INTR_ST is a MIPI 0 line interrupt status register. Hi3516A V200 Professional HD IP Camera SoC

Data sheet 9.3.6 MIPI0_LINE_INTR_ST (offset 0x1090, printed page 9-268, `hi3516av200--Hi3516AV200-Datasheet.txt` line 52421).";

        enum MIPI0_LINE_INTR_ST_err_l_seq_di7_enum {
            YES = 0 { name = "Yes"; desc = "yes"; };
            NO = 1 { name = "No"; desc = "no"; };
        };

        field {
            name = "err_l_seq_di7";
            desc = "Whether the line sequence of VC 7 and DT 7 is correct. This bit is cleared when it is read.";
            sw = r;
            hw = w;
            onread = rclr;
            encode = MIPI0_LINE_INTR_ST_err_l_seq_di7_enum;
            reset = 0x0;
        } err_l_seq_di7[23:23];

        enum MIPI0_LINE_INTR_ST_err_l_seq_di6_enum {
            YES = 0 { name = "Yes"; desc = "yes"; };
            NO = 1 { name = "No"; desc = "no"; };
        };

        field {
            name = "err_l_seq_di6";
            desc = "Whether the line sequence of VC 6 and DT 6 is correct. This bit is cleared when it is read.";
            sw = r;
            hw = w;
            onread = rclr;
            encode = MIPI0_LINE_INTR_ST_err_l_seq_di6_enum;
            reset = 0x0;
        } err_l_seq_di6[22:22];

        enum MIPI0_LINE_INTR_ST_err_l_seq_di5_enum {
            YES = 0 { name = "Yes"; desc = "yes"; };
            NO = 1 { name = "No"; desc = "no"; };
        };

        field {
            name = "err_l_seq_di5";
            desc = "Whether the line sequence of VC 5 and DT 5 is correct. This bit is cleared when it is read.";
            sw = r;
            hw = w;
            onread = rclr;
            encode = MIPI0_LINE_INTR_ST_err_l_seq_di5_enum;
            reset = 0x0;
        } err_l_seq_di5[21:21];

        enum MIPI0_LINE_INTR_ST_err_l_seq_di4_enum {
            YES = 0 { name = "Yes"; desc = "yes"; };
            NO = 1 { name = "No"; desc = "no"; };
        };

        field {
            name = "err_l_seq_di4";
            desc = "Whether the line sequence of VC 4 and DT 4 is correct. This bit is cleared when it is read.";
            sw = r;
            hw = w;
            onread = rclr;
            encode = MIPI0_LINE_INTR_ST_err_l_seq_di4_enum;
            reset = 0x0;
        } err_l_seq_di4[20:20];

        enum MIPI0_LINE_INTR_ST_err_l_seq_di3_enum {
            YES = 0 { name = "Yes"; desc = "yes"; };
            NO = 1 { name = "No"; desc = "no"; };
        };

        field {
            name = "err_l_seq_di3";
            desc = "Whether the line sequence of VC 3 and DT 3 is correct. This bit is cleared when it is read.";
            sw = r;
            hw = w;
            onread = rclr;
            encode = MIPI0_LINE_INTR_ST_err_l_seq_di3_enum;
            reset = 0x0;
        } err_l_seq_di3[19:19];

        enum MIPI0_LINE_INTR_ST_err_l_seq_di2_enum {
            YES = 0 { name = "Yes"; desc = "yes"; };
            NO = 1 { name = "No"; desc = "no"; };
        };

        field {
            name = "err_l_seq_di2";
            desc = "Whether the line sequence of VC 2 and DT 2 is correct. This bit is cleared when it is read.";
            sw = r;
            hw = w;
            onread = rclr;
            encode = MIPI0_LINE_INTR_ST_err_l_seq_di2_enum;
            reset = 0x0;
        } err_l_seq_di2[18:18];

        enum MIPI0_LINE_INTR_ST_err_l_seq_di1_enum {
            YES = 0 { name = "Yes"; desc = "yes"; };
            NO = 1 { name = "No"; desc = "no"; };
        };

        field {
            name = "err_l_seq_di1";
            desc = "Whether the line sequence of VC 1 and DT 1 is correct. This bit is cleared when it is read.";
            sw = r;
            hw = w;
            onread = rclr;
            encode = MIPI0_LINE_INTR_ST_err_l_seq_di1_enum;
            reset = 0x0;
        } err_l_seq_di1[17:17];

        enum MIPI0_LINE_INTR_ST_err_l_seq_di0_enum {
            YES = 0 { name = "Yes"; desc = "yes"; };
            NO = 1 { name = "No"; desc = "no"; };
        };

        field {
            name = "err_l_seq_di0";
            desc = "Whether the line sequence of VC 0 and DT 0 is correct. This bit is cleared when it is read.";
            sw = r;
            hw = w;
            onread = rclr;
            encode = MIPI0_LINE_INTR_ST_err_l_seq_di0_enum;
            reset = 0x0;
        } err_l_seq_di0[16:16];

        enum MIPI0_LINE_INTR_ST_err_l_bndry_match_di7_enum {
            YES = 0 { name = "Yes"; desc = "yes"; };
            NO = 1 { name = "No"; desc = "no"; };
        };

        field {
            name = "err_l_bndry_match_di7";
            desc = "Whether the SOL matches the EOL for VC 7 and DT 7. This bit is cleared when it is read.";
            sw = r;
            hw = w;
            onread = rclr;
            encode = MIPI0_LINE_INTR_ST_err_l_bndry_match_di7_enum;
            reset = 0x0;
        } err_l_bndry_match_di7[7:7];

        enum MIPI0_LINE_INTR_ST_err_l_bndry_match_di6_enum {
            YES = 0 { name = "Yes"; desc = "yes"; };
            NO = 1 { name = "No"; desc = "no"; };
        };

        field {
            name = "err_l_bndry_match_di6";
            desc = "Whether the SOL matches the EOL for VC 6 and DT 6. This bit is cleared when it is read.";
            sw = r;
            hw = w;
            onread = rclr;
            encode = MIPI0_LINE_INTR_ST_err_l_bndry_match_di6_enum;
            reset = 0x0;
        } err_l_bndry_match_di6[6:6];

        enum MIPI0_LINE_INTR_ST_err_l_bndry_match_di5_enum {
            YES = 0 { name = "Yes"; desc = "yes"; };
            NO = 1 { name = "No"; desc = "no"; };
        };

        field {
            name = "err_l_bndry_match_di5";
            desc = "Whether the SOL matches the EOL for VC 5 and DT 5. This bit is cleared when it is read.";
            sw = r;
            hw = w;
            onread = rclr;
            encode = MIPI0_LINE_INTR_ST_err_l_bndry_match_di5_enum;
            reset = 0x0;
        } err_l_bndry_match_di5[5:5];

        enum MIPI0_LINE_INTR_ST_err_l_bndry_match_di4_enum {
            YES = 0 { name = "Yes"; desc = "yes"; };
            NO = 1 { name = "No"; desc = "no"; };
        };

        field {
            name = "err_l_bndry_match_di4";
            desc = "Whether the SOL matches the EOL for VC 4 and DT 4. This bit is cleared when it is read.";
            sw = r;
            hw = w;
            onread = rclr;
            encode = MIPI0_LINE_INTR_ST_err_l_bndry_match_di4_enum;
            reset = 0x0;
        } err_l_bndry_match_di4[4:4];

        enum MIPI0_LINE_INTR_ST_err_l_bndry_match_di3_enum {
            YES = 0 { name = "Yes"; desc = "yes"; };
            NO = 1 { name = "No"; desc = "no"; };
        };

        field {
            name = "err_l_bndry_match_di3";
            desc = "Whether the SOL matches the EOL for VC 3 and DT 3. This bit is cleared when it is read.";
            sw = r;
            hw = w;
            onread = rclr;
            encode = MIPI0_LINE_INTR_ST_err_l_bndry_match_di3_enum;
            reset = 0x0;
        } err_l_bndry_match_di3[3:3];

        enum MIPI0_LINE_INTR_ST_err_l_bndry_match_di2_enum {
            YES = 0 { name = "Yes"; desc = "yes"; };
            NO = 1 { name = "No"; desc = "no"; };
        };

        field {
            name = "err_l_bndry_match_di2";
            desc = "Whether the SOL matches the EOL for VC 2 and DT 2. This bit is cleared when it is read.";
            sw = r;
            hw = w;
            onread = rclr;
            encode = MIPI0_LINE_INTR_ST_err_l_bndry_match_di2_enum;
            reset = 0x0;
        } err_l_bndry_match_di2[2:2];

        enum MIPI0_LINE_INTR_ST_err_l_bndry_match_di1_enum {
            YES = 0 { name = "Yes"; desc = "yes"; };
            NO = 1 { name = "No"; desc = "no"; };
        };

        field {
            name = "err_l_bndry_match_di1";
            desc = "Whether the SOL matches the EOL for VC 1 and DT 1. This bit is cleared when it is read.";
            sw = r;
            hw = w;
            onread = rclr;
            encode = MIPI0_LINE_INTR_ST_err_l_bndry_match_di1_enum;
            reset = 0x0;
        } err_l_bndry_match_di1[1:1];

        enum MIPI0_LINE_INTR_ST_err_l_bndry_match_di0_enum {
            YES = 0 { name = "Yes"; desc = "yes"; };
            NO = 1 { name = "No"; desc = "no"; };
        };

        field {
            name = "err_l_bndry_match_di0";
            desc = "Whether the SOL matches the EOL for VC 0 and DT 0. This bit is cleared when it is read.";
            sw = r;
            hw = w;
            onread = rclr;
            encode = MIPI0_LINE_INTR_ST_err_l_bndry_match_di0_enum;
            reset = 0x0;
        } err_l_bndry_match_di0[0:0];
    } MIPI0_LINE_INTR_ST @ 0x1090;

    reg {
        name = "MIPI 0 line interrupt mask register _INTR_MSK";
        desc = "MIPI0_LINE_INTR_MSK is a MIPI 0 line interrupt mask register.

Data sheet 9.3.6 MIPI0_LINE_INTR_MSK (offset 0x1094, printed page 9-270, `hi3516av200--Hi3516AV200-Datasheet.txt` line 52547).";

        enum MIPI0_LINE_INTR_MSK_mask_err_l_seq_di_enum {
            MASKED = 0 { name = "Masked"; desc = "masked"; };
            ENABLED = 1 { name = "Enabled"; desc = "enabled"; };
        };

        field {
            name = "mask_err_l_seq_di";
            desc = "err_l_seq_di7 interrupt mask";
            sw = rw;
            hw = r;
            encode = MIPI0_LINE_INTR_MSK_mask_err_l_seq_di_enum;
            reset = 0x0;
        } mask_err_l_seq_di[23:23];

        enum MIPI0_LINE_INTR_MSK_mask_err_l_seq_di_2_enum {
            MASKED = 0 { name = "Masked"; desc = "masked"; };
            ENABLED = 1 { name = "Enabled"; desc = "enabled"; };
        };

        field {
            name = "mask_err_l_seq_di";
            desc = "err_l_seq_di6 interrupt mask";
            sw = rw;
            hw = r;
            encode = MIPI0_LINE_INTR_MSK_mask_err_l_seq_di_2_enum;
            reset = 0x0;
        } mask_err_l_seq_di_2[22:22];

        enum MIPI0_LINE_INTR_MSK_mask_err_l_seq_di_3_enum {
            MASKED = 0 { name = "Masked"; desc = "masked"; };
            ENABLED = 1 { name = "Enabled"; desc = "enabled"; };
        };

        field {
            name = "mask_err_l_seq_di";
            desc = "err_l_seq_di5 interrupt mask";
            sw = rw;
            hw = r;
            encode = MIPI0_LINE_INTR_MSK_mask_err_l_seq_di_3_enum;
            reset = 0x0;
        } mask_err_l_seq_di_3[21:21];

        enum MIPI0_LINE_INTR_MSK_mask_err_l_seq_di_4_enum {
            MASKED = 0 { name = "Masked"; desc = "masked"; };
            ENABLED = 1 { name = "Enabled"; desc = "enabled"; };
        };

        field {
            name = "mask_err_l_seq_di";
            desc = "err_l_seq_di4 interrupt mask";
            sw = rw;
            hw = r;
            encode = MIPI0_LINE_INTR_MSK_mask_err_l_seq_di_4_enum;
            reset = 0x0;
        } mask_err_l_seq_di_4[20:20];

        enum MIPI0_LINE_INTR_MSK_mask_err_l_seq_di_5_enum {
            MASKED = 0 { name = "Masked"; desc = "masked"; };
            ENABLED = 1 { name = "Enabled"; desc = "enabled"; };
        };

        field {
            name = "mask_err_l_seq_di";
            desc = "err_l_seq_di3 interrupt mask";
            sw = rw;
            hw = r;
            encode = MIPI0_LINE_INTR_MSK_mask_err_l_seq_di_5_enum;
            reset = 0x0;
        } mask_err_l_seq_di_5[19:19];

        enum MIPI0_LINE_INTR_MSK_mask_err_l_seq_di_6_enum {
            MASKED = 0 { name = "Masked"; desc = "masked"; };
            ENABLED = 1 { name = "Enabled"; desc = "enabled"; };
        };

        field {
            name = "mask_err_l_seq_di";
            desc = "err_l_seq_di2 interrupt mask";
            sw = rw;
            hw = r;
            encode = MIPI0_LINE_INTR_MSK_mask_err_l_seq_di_6_enum;
            reset = 0x0;
        } mask_err_l_seq_di_6[18:18];

        enum MIPI0_LINE_INTR_MSK_mask_err_l_seq_di_7_enum {
            MASKED = 0 { name = "Masked"; desc = "masked"; };
            ENABLED = 1 { name = "Enabled"; desc = "enabled"; };
        };

        field {
            name = "mask_err_l_seq_di";
            desc = "err_l_seq_di1 interrupt mask";
            sw = rw;
            hw = r;
            encode = MIPI0_LINE_INTR_MSK_mask_err_l_seq_di_7_enum;
            reset = 0x0;
        } mask_err_l_seq_di_7[17:17];

        enum MIPI0_LINE_INTR_MSK_mask_err_l_seq_di_8_enum {
            MASKED = 0 { name = "Masked"; desc = "masked"; };
            ENABLED = 1 { name = "Enabled"; desc = "enabled"; };
        };

        field {
            name = "mask_err_l_seq_di";
            desc = "err_l_seq_di0 interrupt mask";
            sw = rw;
            hw = r;
            encode = MIPI0_LINE_INTR_MSK_mask_err_l_seq_di_8_enum;
            reset = 0x0;
        } mask_err_l_seq_di_8[16:16];

        enum MIPI0_LINE_INTR_MSK_mask_err_l_bndry_match_di7_enum {
            MASKED = 0 { name = "Masked"; desc = "masked"; };
            ENABLED = 1 { name = "Enabled"; desc = "enabled"; };
        };

        field {
            name = "mask_err_l_bndry_match_di7";
            desc = "err_l_bndry_match_di7 interrupt mask";
            sw = rw;
            hw = r;
            encode = MIPI0_LINE_INTR_MSK_mask_err_l_bndry_match_di7_enum;
            reset = 0x0;
        } mask_err_l_bndry_match_di7[7:7];

        enum MIPI0_LINE_INTR_MSK_mask_err_l_bndry_match_di6_enum {
            MASKED = 0 { name = "Masked"; desc = "masked"; };
            ENABLED = 1 { name = "Enabled"; desc = "enabled"; };
        };

        field {
            name = "mask_err_l_bndry_match_di6";
            desc = "err_l_bndry_match_di6 interrupt mask";
            sw = rw;
            hw = r;
            encode = MIPI0_LINE_INTR_MSK_mask_err_l_bndry_match_di6_enum;
            reset = 0x0;
        } mask_err_l_bndry_match_di6[6:6];

        enum MIPI0_LINE_INTR_MSK_mask_err_l_bndry_match_di5_enum {
            MASKED = 0 { name = "Masked"; desc = "masked"; };
            ENABLED = 1 { name = "Enabled"; desc = "enabled"; };
        };

        field {
            name = "mask_err_l_bndry_match_di5";
            desc = "err_l_bndry_match_di5 interrupt mask";
            sw = rw;
            hw = r;
            encode = MIPI0_LINE_INTR_MSK_mask_err_l_bndry_match_di5_enum;
            reset = 0x0;
        } mask_err_l_bndry_match_di5[5:5];

        enum MIPI0_LINE_INTR_MSK_mask_err_l_bndry_match_di4_enum {
            MASKED = 0 { name = "Masked"; desc = "masked"; };
            ENABLED = 1 { name = "Enabled"; desc = "enabled"; };
        };

        field {
            name = "mask_err_l_bndry_match_di4";
            desc = "err_l_bndry_match_di4 interrupt mask";
            sw = rw;
            hw = r;
            encode = MIPI0_LINE_INTR_MSK_mask_err_l_bndry_match_di4_enum;
            reset = 0x0;
        } mask_err_l_bndry_match_di4[4:4];

        enum MIPI0_LINE_INTR_MSK_mask_err_l_bndry_match_di3_enum {
            MASKED = 0 { name = "Masked"; desc = "masked"; };
            ENABLED = 1 { name = "Enabled"; desc = "enabled"; };
        };

        field {
            name = "mask_err_l_bndry_match_di3";
            desc = "err_l_bndry_match_di3 interrupt mask";
            sw = rw;
            hw = r;
            encode = MIPI0_LINE_INTR_MSK_mask_err_l_bndry_match_di3_enum;
            reset = 0x0;
        } mask_err_l_bndry_match_di3[3:3];

        enum MIPI0_LINE_INTR_MSK_mask_err_l_bndry_match_di2_enum {
            MASKED = 0 { name = "Masked"; desc = "masked"; };
            ENABLED = 1 { name = "Enabled"; desc = "enabled"; };
        };

        field {
            name = "mask_err_l_bndry_match_di2";
            desc = "err_l_bndry_match_di2 interrupt mask";
            sw = rw;
            hw = r;
            encode = MIPI0_LINE_INTR_MSK_mask_err_l_bndry_match_di2_enum;
            reset = 0x0;
        } mask_err_l_bndry_match_di2[2:2];

        enum MIPI0_LINE_INTR_MSK_mask_err_l_bndry_match_di1_enum {
            MASKED = 0 { name = "Masked"; desc = "masked"; };
            ENABLED = 1 { name = "Enabled"; desc = "enabled"; };
        };

        field {
            name = "mask_err_l_bndry_match_di1";
            desc = "err_l_bndry_match_di1 interrupt mask";
            sw = rw;
            hw = r;
            encode = MIPI0_LINE_INTR_MSK_mask_err_l_bndry_match_di1_enum;
            reset = 0x0;
        } mask_err_l_bndry_match_di1[1:1];

        enum MIPI0_LINE_INTR_MSK_mask_err_l_bndry_match_di0_enum {
            MASKED = 0 { name = "Masked"; desc = "masked"; };
            ENABLED = 1 { name = "Enabled"; desc = "enabled"; };
        };

        field {
            name = "mask_err_l_bndry_match_di0";
            desc = "err_l_bndry_match_di0 interrupt mask";
            sw = rw;
            hw = r;
            encode = MIPI0_LINE_INTR_MSK_mask_err_l_bndry_match_di0_enum;
            reset = 0x0;
        } mask_err_l_bndry_match_di0[0:0];
    } MIPI0_LINE_INTR_MSK @ 0x1094;

    reg {
        name = "MIPI0 LINE INTR FORCE";
        desc = "[inferred] MIPI0 LINE INTR FORCE. Not in the data sheet. Source: OpenIPC openhisilicon `kernel/mipi_rx/hi3519v101/mipi_reg.h` (GPL-3.0 repository, HiSilicon copyright; local copy sources/openhisilicon), union `U_MIPI_LINE_INTR_FORCE`, struct offset 0x1098 (GPL-3.0 repository, HiSilicon copyright; one header for Hi3519 V101 and Hi3516A V200). Reset value and access type unknown (modelled RW, no reset). Confidence: medium (vendor header for this chip family, not hardware verified).";

        field {
            name = "force_err_l_seq_di7";
            desc = "[inferred] Force error l seq di7. (vendor header `hi3519v101/mipi_reg.h` field `force_err_l_seq_di7`; access and reset unknown, modelled RW)";
            sw = rw;
            hw = r;
        } force_err_l_seq_di7[23:23];

        field {
            name = "force_err_l_seq_di6";
            desc = "[inferred] Force error l seq di6. (vendor header `hi3519v101/mipi_reg.h` field `force_err_l_seq_di6`; access and reset unknown, modelled RW)";
            sw = rw;
            hw = r;
        } force_err_l_seq_di6[22:22];

        field {
            name = "force_err_l_seq_di5";
            desc = "[inferred] Force error l seq di5. (vendor header `hi3519v101/mipi_reg.h` field `force_err_l_seq_di5`; access and reset unknown, modelled RW)";
            sw = rw;
            hw = r;
        } force_err_l_seq_di5[21:21];

        field {
            name = "force_err_l_seq_di4";
            desc = "[inferred] Force error l seq di4. (vendor header `hi3519v101/mipi_reg.h` field `force_err_l_seq_di4`; access and reset unknown, modelled RW)";
            sw = rw;
            hw = r;
        } force_err_l_seq_di4[20:20];

        field {
            name = "force_err_l_seq_di3";
            desc = "[inferred] Force error l seq di3. (vendor header `hi3519v101/mipi_reg.h` field `force_err_l_seq_di3`; access and reset unknown, modelled RW)";
            sw = rw;
            hw = r;
        } force_err_l_seq_di3[19:19];

        field {
            name = "force_err_l_seq_di2";
            desc = "[inferred] Force error l seq di2. (vendor header `hi3519v101/mipi_reg.h` field `force_err_l_seq_di2`; access and reset unknown, modelled RW)";
            sw = rw;
            hw = r;
        } force_err_l_seq_di2[18:18];

        field {
            name = "force_err_l_seq_di1";
            desc = "[inferred] Force error l seq di1. (vendor header `hi3519v101/mipi_reg.h` field `force_err_l_seq_di1`; access and reset unknown, modelled RW)";
            sw = rw;
            hw = r;
        } force_err_l_seq_di1[17:17];

        field {
            name = "force_err_l_seq_di0";
            desc = "[inferred] Force error l seq di0. (vendor header `hi3519v101/mipi_reg.h` field `force_err_l_seq_di0`; access and reset unknown, modelled RW)";
            sw = rw;
            hw = r;
        } force_err_l_seq_di0[16:16];

        field {
            name = "force_err_l_bndry_match_di7";
            desc = "[inferred] Force error l bndry match di7. (vendor header `hi3519v101/mipi_reg.h` field `force_err_l_bndry_match_di7`; access and reset unknown, modelled RW)";
            sw = rw;
            hw = r;
        } force_err_l_bndry_match_di7[7:7];

        field {
            name = "force_err_l_bndry_match_di6";
            desc = "[inferred] Force error l bndry match di6. (vendor header `hi3519v101/mipi_reg.h` field `force_err_l_bndry_match_di6`; access and reset unknown, modelled RW)";
            sw = rw;
            hw = r;
        } force_err_l_bndry_match_di6[6:6];

        field {
            name = "force_err_l_bndry_match_di5";
            desc = "[inferred] Force error l bndry match di5. (vendor header `hi3519v101/mipi_reg.h` field `force_err_l_bndry_match_di5`; access and reset unknown, modelled RW)";
            sw = rw;
            hw = r;
        } force_err_l_bndry_match_di5[5:5];

        field {
            name = "force_err_l_bndry_match_di4";
            desc = "[inferred] Force error l bndry match di4. (vendor header `hi3519v101/mipi_reg.h` field `force_err_l_bndry_match_di4`; access and reset unknown, modelled RW)";
            sw = rw;
            hw = r;
        } force_err_l_bndry_match_di4[4:4];

        field {
            name = "force_err_l_bndry_match_di3";
            desc = "[inferred] Force error l bndry match di3. (vendor header `hi3519v101/mipi_reg.h` field `force_err_l_bndry_match_di3`; access and reset unknown, modelled RW)";
            sw = rw;
            hw = r;
        } force_err_l_bndry_match_di3[3:3];

        field {
            name = "force_err_l_bndry_match_di2";
            desc = "[inferred] Force error l bndry match di2. (vendor header `hi3519v101/mipi_reg.h` field `force_err_l_bndry_match_di2`; access and reset unknown, modelled RW)";
            sw = rw;
            hw = r;
        } force_err_l_bndry_match_di2[2:2];

        field {
            name = "force_err_l_bndry_match_di1";
            desc = "[inferred] Force error l bndry match di1. (vendor header `hi3519v101/mipi_reg.h` field `force_err_l_bndry_match_di1`; access and reset unknown, modelled RW)";
            sw = rw;
            hw = r;
        } force_err_l_bndry_match_di1[1:1];

        field {
            name = "force_err_l_bndry_match_di0";
            desc = "[inferred] Force error l bndry match di0. (vendor header `hi3519v101/mipi_reg.h` field `force_err_l_bndry_match_di0`; access and reset unknown, modelled RW)";
            sw = rw;
            hw = r;
        } force_err_l_bndry_match_di0[0:0];
    } MIPI0_LINE_INTR_FORCE @ 0x1098;

    reg {
        name = "MIPI 0 pixel bit width configuration RDEF_DT register for the user-defined data type";
        desc = "MIPI0_USERDEF_DT is a MIPI 0 pixel bit width configuration register for the user-defined data type.

Data sheet 9.3.6 MIPI0_USERDEF_DT (offset 0x1100, printed page 9-272, `hi3516av200--Hi3516AV200-Datasheet.txt` line 52673).";

        enum MIPI0_USERDEF_DT_user_def3_dt_enum {
            V_8_BITS = 0 { name = "V 8 Bits"; desc = "8 bits"; };
            V_10_BITS = 1 { name = "V 10 Bits"; desc = "10 bits"; };
            V_12_BITS = 2 { name = "V 12 Bits"; desc = "12 bits"; };
            V_14_BITS = 3 { name = "V 14 Bits"; desc = "14 bits"; };
            V_16_BITS_OTHER = 4 { name = "V 16 Bits Other"; desc = "16 bits Other values: reserved"; };
        };

        field {
            name = "user_def3_dt";
            desc = "Bit width of the transferred pixel when the data type is user_def3";
            sw = rw;
            hw = r;
            encode = MIPI0_USERDEF_DT_user_def3_dt_enum;
            reset = 0x0;
        } user_def3_dt[14:12];

        enum MIPI0_USERDEF_DT_user_def2_dt_enum {
            V_8_BITS = 0 { name = "V 8 Bits"; desc = "8 bits"; };
            V_10_BITS = 1 { name = "V 10 Bits"; desc = "10 bits"; };
            V_12_BITS = 2 { name = "V 12 Bits"; desc = "12 bits"; };
            V_14_BITS = 3 { name = "V 14 Bits"; desc = "14 bits"; };
            V_16_BITS_OTHER = 4 { name = "V 16 Bits Other"; desc = "16 bits Other values: reserved"; };
        };

        field {
            name = "user_def2_dt";
            desc = "Bit width of the transferred pixel when the data type is user_def2";
            sw = rw;
            hw = r;
            encode = MIPI0_USERDEF_DT_user_def2_dt_enum;
            reset = 0x0;
        } user_def2_dt[10:8];

        enum MIPI0_USERDEF_DT_user_def1_dt_enum {
            V_8_BITS = 0 { name = "V 8 Bits"; desc = "8 bits"; };
            V_10_BITS = 1 { name = "V 10 Bits"; desc = "10 bits"; };
            V_12_BITS = 2 { name = "V 12 Bits"; desc = "12 bits"; };
            V_14_BITS = 3 { name = "V 14 Bits"; desc = "14 bits"; };
            V_16_BITS_OTHER = 4 { name = "V 16 Bits Other"; desc = "16 bits Other values: reserved"; };
        };

        field {
            name = "user_def1_dt";
            desc = "Bit width of the transferred pixel when the data type is user_def1";
            sw = rw;
            hw = r;
            encode = MIPI0_USERDEF_DT_user_def1_dt_enum;
            reset = 0x0;
        } user_def1_dt[6:4];

        enum MIPI0_USERDEF_DT_user_def0_dt_enum {
            V_8_BITS = 0 { name = "V 8 Bits"; desc = "8 bits"; };
            V_10_BITS = 1 { name = "V 10 Bits"; desc = "10 bits"; };
            V_12_BITS = 2 { name = "V 12 Bits"; desc = "12 bits"; };
            V_14_BITS = 3 { name = "V 14 Bits"; desc = "14 bits"; };
            V_16_BITS_OTHER = 4 { name = "V 16 Bits Other"; desc = "16 bits Other values: reserved"; };
        };

        field {
            name = "user_def0_dt";
            desc = "Bit width of the transferred pixel when the data type is user_def0";
            sw = rw;
            hw = r;
            encode = MIPI0_USERDEF_DT_user_def0_dt_enum;
            reset = 0x0;
        } user_def0_dt[2:0];
    } MIPI0_USERDEF_DT @ 0x1100;

    reg {
        name = "MIPI 0 user-defined data type enable R_DEF configuration register";
        desc = "MIPI0_USER_DEF is a MIPI 0 user-defined data type enable configuration register.

Data sheet 9.3.6 MIPI0_USER_DEF (offset 0x1104, printed page 9-273, `hi3516av200--Hi3516AV200-Datasheet.txt` line 52739).";

        field {
            name = "user_def3";
            desc = "User-defined data type 3 The value of this field is used for matching the type of the sensor output data. This field works with MIPI0_USERDEF_DT[user_def3_dt].";
            sw = rw;
            hw = r;
            reset = 0x10;
        } user_def3[29:24];

        field {
            name = "user_def2";
            desc = "User-defined data type 2 The value of this field is used for matching the type of the sensor output data. This field works with MIPI0_USERDEF_DT[user_def2_dt].";
            sw = rw;
            hw = r;
            reset = 0x36;
        } user_def2[21:16];

        field {
            name = "user_def1";
            desc = "User-defined data type 1 The value of this field is used for matching the type of the sensor output data. This field works with MIPI0_USERDEF_DT[user_def1_dt].";
            sw = rw;
            hw = r;
            reset = 0x35;
        } user_def1[13:8];

        field {
            name = "user_def0";
            desc = "User-defined data type 0 The value of this field is used for matching the type of the sensor output data. This field works with MIPI0_USERDEF_DT [user_def0_dt].";
            sw = rw;
            hw = r;
            reset = 0x34;
        } user_def0[5:0];
    } MIPI0_USER_DEF @ 0x1104;

    reg {
        name = "MIPI 0 operating mode enable register L_MODE_H S";
        desc = "MIPI0_CTRL_MODE_HS is a MIPI 0 operating mode enable register.

Data sheet 9.3.6 MIPI0_CTRL_MODE_HS (offset 0x1108, printed page 9-274, `hi3516av200--Hi3516AV200-Datasheet.txt` line 52792).";

        enum MIPI0_CTRL_MODE_HS_user_def_en_enum {
            DISABLED = 0 { name = "Disabled"; desc = "disabled"; };
            ENABLED = 1 { name = "Enabled"; desc = "enabled"; };
        };

        field {
            name = "user_def_en";
            desc = "User-defined mode enable";
            sw = rw;
            hw = r;
            encode = MIPI0_CTRL_MODE_HS_user_def_en_enum;
            reset = 0x0;
        } user_def_en[8:8];
    } MIPI0_CTRL_MODE_HS @ 0x1108;

    reg {
        name = "MIPI 0 DOL mode frame identification _ID_CODE0 register 0";
        desc = "MIPI0_DOL_ID_CODE0 is MIPI 0 DOL mode frame identification register 0.

Data sheet 9.3.6 MIPI0_DOL_ID_CODE0 (offset 0x1200, printed page 9-274, `hi3516av200--Hi3516AV200-Datasheet.txt` line 52822).";

        field {
            name = "id_code_reg1";
            desc = "ID of SEF1 frame N in MIPI DOL mode";
            sw = rw;
            hw = r;
            reset = 0x242;
        } id_code_reg1[31:16];

        field {
            name = "id_code_reg0";
            desc = "ID of LEF frame N in MIPI DOL mode";
            sw = rw;
            hw = r;
            reset = 0x241;
        } id_code_reg0[15:0];
    } MIPI0_DOL_ID_CODE0 @ 0x1200;

    reg {
        name = "MIPI 0 DOL mode frame identification _ID_CODE1 register 1";
        desc = "MIPI0_DOL_ID_CODE1 is MIPI 0 DOL mode frame identification register 1.

Data sheet 9.3.6 MIPI0_DOL_ID_CODE1 (offset 0x1204, printed page 9-275, `hi3516av200--Hi3516AV200-Datasheet.txt` line 52850).";

        field {
            name = "id_code_reg3";
            desc = "ID of LEF frame + 1 in MIPI DOL mode";
            sw = rw;
            hw = r;
            reset = 0x251;
        } id_code_reg3[31:16];

        field {
            name = "id_code_reg2";
            desc = "ID of SEF2 frame N in MIPI DOL mode";
            sw = rw;
            hw = r;
            reset = 0x244;
        } id_code_reg2[15:0];
    } MIPI0_DOL_ID_CODE1 @ 0x1204;

    reg {
        name = "MIPI 0 DOL mode frame identification _ID_CODE2 register 2";
        desc = "MIPI0_DOL_ID_CODE2 is MIPI 0 DOL mode frame identification register 2.

Data sheet 9.3.6 MIPI0_DOL_ID_CODE2 (offset 0x1208, printed page 9-275, `hi3516av200--Hi3516AV200-Datasheet.txt` line 52870).";

        field {
            name = "id_code_reg5";
            desc = "ID of SEF2 frame N + 1 in MIPI DOL mode";
            sw = rw;
            hw = r;
            reset = 0x254;
        } id_code_reg5[31:16];

        field {
            name = "id_code_reg4";
            desc = "ID of SEF1 frame N + 1 in MIPI DOL mode";
            sw = rw;
            hw = r;
            reset = 0x252;
        } id_code_reg4[15:0];
    } MIPI0_DOL_ID_CODE2 @ 0x1208;

    reg {
        name = "MIPI0 CROP START CHN0";
        desc = "[inferred] MIPI0 CROP START CHN0. Not in the data sheet. Source: OpenIPC openhisilicon `kernel/mipi_rx/hi3519v101/mipi_reg.h` (GPL-3.0 repository, HiSilicon copyright; local copy sources/openhisilicon), union `U_MIPI_CROP_START_CHN0`, struct offset 0x1210 (GPL-3.0 repository, HiSilicon copyright; one header for Hi3519 V101 and Hi3516A V200). Reset value and access type unknown (modelled RW, no reset). Confidence: medium (vendor header for this chip family, not hardware verified).";

        field {
            name = "mipi_start_y_chn0";
            desc = "[inferred] Mipi start y chn0. (vendor header `hi3519v101/mipi_reg.h` field `mipi_start_y_chn0`; access and reset unknown, modelled RW)";
            sw = rw;
            hw = r;
        } mipi_start_y_chn0[31:16];

        field {
            name = "mipi_start_x_chn0";
            desc = "[inferred] Mipi start x chn0. (vendor header `hi3519v101/mipi_reg.h` field `mipi_start_x_chn0`; access and reset unknown, modelled RW)";
            sw = rw;
            hw = r;
        } mipi_start_x_chn0[15:0];
    } MIPI0_CROP_START_CHN0 @ 0x1210;

    reg {
        name = "MIPI0 CROP START CHN1";
        desc = "[inferred] MIPI0 CROP START CHN1. Not in the data sheet. Source: OpenIPC openhisilicon `kernel/mipi_rx/hi3519v101/mipi_reg.h` (GPL-3.0 repository, HiSilicon copyright; local copy sources/openhisilicon), union `U_MIPI_CROP_START_CHN1`, struct offset 0x1214 (GPL-3.0 repository, HiSilicon copyright; one header for Hi3519 V101 and Hi3516A V200). Reset value and access type unknown (modelled RW, no reset). Confidence: medium (vendor header for this chip family, not hardware verified).";

        field {
            name = "mipi_start_y_chn1";
            desc = "[inferred] Mipi start y chn1. (vendor header `hi3519v101/mipi_reg.h` field `mipi_start_y_chn1`; access and reset unknown, modelled RW)";
            sw = rw;
            hw = r;
        } mipi_start_y_chn1[31:16];

        field {
            name = "mipi_start_x_chn1";
            desc = "[inferred] Mipi start x chn1. (vendor header `hi3519v101/mipi_reg.h` field `mipi_start_x_chn1`; access and reset unknown, modelled RW)";
            sw = rw;
            hw = r;
        } mipi_start_x_chn1[15:0];
    } MIPI0_CROP_START_CHN1 @ 0x1214;

    reg {
        name = "MIPI0 CROP START CHN2";
        desc = "[inferred] MIPI0 CROP START CHN2. Not in the data sheet. Source: OpenIPC openhisilicon `kernel/mipi_rx/hi3519v101/mipi_reg.h` (GPL-3.0 repository, HiSilicon copyright; local copy sources/openhisilicon), union `U_MIPI_CROP_START_CHN2`, struct offset 0x1218 (GPL-3.0 repository, HiSilicon copyright; one header for Hi3519 V101 and Hi3516A V200). Reset value and access type unknown (modelled RW, no reset). Confidence: medium (vendor header for this chip family, not hardware verified).";

        field {
            name = "mipi_start_y_chn2";
            desc = "[inferred] Mipi start y chn2. (vendor header `hi3519v101/mipi_reg.h` field `mipi_start_y_chn2`; access and reset unknown, modelled RW)";
            sw = rw;
            hw = r;
        } mipi_start_y_chn2[31:16];

        field {
            name = "mipi_start_x_chn2";
            desc = "[inferred] Mipi start x chn2. (vendor header `hi3519v101/mipi_reg.h` field `mipi_start_x_chn2`; access and reset unknown, modelled RW)";
            sw = rw;
            hw = r;
        } mipi_start_x_chn2[15:0];
    } MIPI0_CROP_START_CHN2 @ 0x1218;

    reg {
        name = "MIPI0 CROP START CHN3";
        desc = "[inferred] MIPI0 CROP START CHN3. Not in the data sheet. Source: OpenIPC openhisilicon `kernel/mipi_rx/hi3519v101/mipi_reg.h` (GPL-3.0 repository, HiSilicon copyright; local copy sources/openhisilicon), union `U_MIPI_CROP_START_CHN3`, struct offset 0x121C (GPL-3.0 repository, HiSilicon copyright; one header for Hi3519 V101 and Hi3516A V200). Reset value and access type unknown (modelled RW, no reset). Confidence: medium (vendor header for this chip family, not hardware verified).";

        field {
            name = "mipi_start_y_chn3";
            desc = "[inferred] Mipi start y chn3. (vendor header `hi3519v101/mipi_reg.h` field `mipi_start_y_chn3`; access and reset unknown, modelled RW)";
            sw = rw;
            hw = r;
        } mipi_start_y_chn3[31:16];

        field {
            name = "mipi_start_x_chn3";
            desc = "[inferred] Mipi start x chn3. (vendor header `hi3519v101/mipi_reg.h` field `mipi_start_x_chn3`; access and reset unknown, modelled RW)";
            sw = rw;
            hw = r;
        } mipi_start_x_chn3[15:0];
    } MIPI0_CROP_START_CHN3 @ 0x121C;

    reg {
        name = "MIPI0 IMGSIZE";
        desc = "[inferred] MIPI0 IMGSIZE. Not in the data sheet. Source: OpenIPC openhisilicon `kernel/mipi_rx/hi3519v101/mipi_reg.h` (GPL-3.0 repository, HiSilicon copyright; local copy sources/openhisilicon), union `U_MIPI_IMGSIZE`, struct offset 0x1224 (GPL-3.0 repository, HiSilicon copyright; one header for Hi3519 V101 and Hi3516A V200). Reset value and access type unknown (modelled RW, no reset). Confidence: medium (vendor header for this chip family, not hardware verified).";

        field {
            name = "mipi_imgheight";
            desc = "[inferred] Mipi imgheight. (vendor header `hi3519v101/mipi_reg.h` field `mipi_imgheight`; access and reset unknown, modelled RW)";
            sw = rw;
            hw = r;
        } mipi_imgheight[31:16];

        field {
            name = "mipi_imgwidth";
            desc = "[inferred] Mipi imgwidth. (vendor header `hi3519v101/mipi_reg.h` field `mipi_imgwidth`; access and reset unknown, modelled RW)";
            sw = rw;
            hw = r;
        } mipi_imgwidth[15:0];
    } MIPI0_IMGSIZE @ 0x1224;

    reg {
        name = "MIPI 0 output operating mode enable L_MODE_PI register XEL";
        desc = "MIPI0_CTRL_MODE_PIXEL is a MIPI 0 output operating mode enable register. Hi3516A V200 Professional HD IP Camera SoC

Data sheet 9.3.6 MIPI0_CTRL_MODE_PIXEL (offset 0x1230, printed page 9-276, `hi3516av200--Hi3516AV200-Datasheet.txt` line 52899).";

        enum MIPI0_CTRL_MODE_PIXEL_stagger_frm_num_enum {
            V_2_FRAME_HDR = 1 { name = "V 2 Frame Hdr"; desc = "2-frame HDR"; };
            V_3_FRAME_HDR = 2 { name = "V 3 Frame Hdr"; desc = "3-frame HDR"; };
            V_4_FRAME_HDR = 3 { name = "V 4 Frame Hdr"; desc = "4-frame HDR Other values: reserved"; };
        };

        field {
            name = "stagger_frm_num";
            desc = "Number of frames in staggered HDR mode";
            sw = rw;
            hw = r;
            encode = MIPI0_CTRL_MODE_PIXEL_stagger_frm_num_enum;
            reset = 0x0;
        } stagger_frm_num[14:13];

        enum MIPI0_CTRL_MODE_PIXEL_stagger_hdr_mode_enum {
            DISABLED = 0 { name = "Disabled"; desc = "disabled"; };
            ENABLED = 1 { name = "Enabled"; desc = "enabled"; };
        };

        field {
            name = "stagger_hdr_mode";
            desc = "OmniVision staggered HDR mode enable";
            sw = rw;
            hw = r;
            encode = MIPI0_CTRL_MODE_PIXEL_stagger_hdr_mode_enum;
            reset = 0x0;
        } stagger_hdr_mode[12:12];

        enum MIPI0_CTRL_MODE_PIXEL_mipi_dol_mode_enum {
            DISABLED = 0 { name = "Disabled"; desc = "disabled"; };
            ENABLED = 1 { name = "Enabled"; desc = "enabled"; };
        };

        field {
            name = "mipi_dol_mode";
            desc = "MIPI DOL mode enable";
            sw = rw;
            hw = r;
            encode = MIPI0_CTRL_MODE_PIXEL_mipi_dol_mode_enum;
            reset = 0x0;
        } mipi_dol_mode[4:4];

        enum MIPI0_CTRL_MODE_PIXEL_crop_en_enum {
            DISABLED = 0 { name = "Disabled"; desc = "disabled"; };
            ENABLED = 1 { name = "Enabled"; desc = "enabled"; };
        };

        field {
            name = "crop_en";
            desc = "Cropping enable";
            sw = rw;
            hw = r;
            encode = MIPI0_CTRL_MODE_PIXEL_crop_en_enum;
            reset = 0x0;
        } crop_en[0:0];
    } MIPI0_CTRL_MODE_PIXEL @ 0x1230;

    reg {
        name = "MIPI 0 dummy line pixel value register MY_PIX_RE G";
        desc = "MIPI0_DUMMY_PIX_REG is a MIPI 0 dummy line pixel value register. Hi3516A V200 Professional HD IP Camera SoC

Data sheet 9.3.6 MIPI0_DUMMY_PIX_REG (offset 0x1240, printed page 9-277, `hi3516av200--Hi3516AV200-Datasheet.txt` line 52950).";

        field {
            name = "dummy_pix_reg";
            desc = "Dummy line pixel value in staggered HDR mode";
            sw = rw;
            hw = r;
            reset = 0x0;
        } dummy_pix_reg[15:0];
    } MIPI0_DUMMY_PIX_REG @ 0x1240;

    reg {
        name = "MIPI 0 VC 0 transferred image size IZE0_STATI register S";
        desc = "MIPI0_IMGSIZE0_STATIS is a MIPI 0 VC 0 transferred image size register.

Data sheet 9.3.6 MIPI0_IMGSIZE0_STATIS (offset 0x1250, printed page 9-277, `hi3516av200--Hi3516AV200-Datasheet.txt` line 52969).";

        field {
            name = "imgheight_statis_vc";
            desc = "Height of the previous frame of image transferred by virtual channel 0 in MIPI mode";
            sw = r;
            hw = w;
            reset = 0x0;
        } imgheight_statis_vc[31:16];

        field {
            name = "imgwidth_statis_vc";
            desc = "Width of the previous frame of image transferred by virtual channel 0 in MIPI mode";
            sw = r;
            hw = w;
            reset = 0x0;
        } imgwidth_statis_vc[15:0];
    } MIPI0_IMGSIZE0_STATIS @ 0x1250;

    reg {
        name = "MIPI 0 VC 1 transferred image size IZE1_STATI register S";
        desc = "MIPI0_IMGSIZE1_STATIS is a MIPI 0 VC 1 transferred image size register.

Data sheet 9.3.6 MIPI0_IMGSIZE1_STATIS (offset 0x1254, printed page 9-277, `hi3516av200--Hi3516AV200-Datasheet.txt` line 52993).";

        field {
            name = "imgheight_statis_vc1";
            desc = "Height of the previous frame of image transferred by virtual channel 1 in MIPI mode";
            sw = r;
            hw = w;
            reset = 0x0;
        } imgheight_statis_vc1[31:16];

        field {
            name = "imgwidth_statis_vc";
            desc = "Width of the previous frame of image transferred by virtual channel 1 in MIPI mode";
            sw = r;
            hw = w;
            reset = 0x0;
        } imgwidth_statis_vc[15:0];
    } MIPI0_IMGSIZE1_STATIS @ 0x1254;

    reg {
        name = "MIPI 0 VC 2 transferred image size IZE2_STATI register S";
        desc = "MIPI0_IMGSIZE2_STATIS is a MIPI 0 VC 2 transferred image size register.

Data sheet 9.3.6 MIPI0_IMGSIZE2_STATIS (offset 0x1258, printed page 9-278, `hi3516av200--Hi3516AV200-Datasheet.txt` line 53028).";

        field {
            name = "imgheight_statis_vc";
            desc = "Height of the previous frame of image transferred by virtual channel 2 in MIPI mode";
            sw = r;
            hw = w;
            reset = 0x0;
        } imgheight_statis_vc[31:16];

        field {
            name = "imgwidth_statis_vc";
            desc = "Width of the previous frame of image transferred by virtual channel 2 in MIPI mode";
            sw = r;
            hw = w;
            reset = 0x0;
        } imgwidth_statis_vc[15:0];
    } MIPI0_IMGSIZE2_STATIS @ 0x1258;

    reg {
        name = "MIPI 0 VC 3 transferred image size IZE3_STATI register S";
        desc = "MIPI0_IMGSIZE3_STATIS is a MIPI 0 VC 3 transferred image size register.

Data sheet 9.3.6 MIPI0_IMGSIZE3_STATIS (offset 0x125C, printed page 9-278, `hi3516av200--Hi3516AV200-Datasheet.txt` line 53052).";

        field {
            name = "imgheight_statis_vc";
            desc = "Height of the previous frame of image transferred by virtual channel 3 in MIPI mode";
            sw = r;
            hw = w;
            reset = 0x0;
        } imgheight_statis_vc[31:16];

        field {
            name = "imgwidth_statis_vc";
            desc = "Width of the previous frame of image transferred by virtual channel 3 in MIPI mode";
            sw = r;
            hw = w;
            reset = 0x0;
        } imgwidth_statis_vc[15:0];
    } MIPI0_IMGSIZE3_STATIS @ 0x125C;

    reg {
        name = "MIPI 0 read data error raw interrupt status L_INT_RAW register";
        desc = "MIPI0_CTRL_INT_RAW is a MIPI 0 read data error raw interrupt status register. Hi3516A V200 Professional HD IP Camera SoC

Data sheet 9.3.6 MIPI0_CTRL_INT_RAW (offset 0x12F0, printed page 9-279, `hi3516av200--Hi3516AV200-Datasheet.txt` line 53086).";

        enum MIPI0_CTRL_INT_RAW_int_dfifo_rderr_raw_enum {
            NO_RAW_INTERRUPT = 0 { name = "No Raw Interrupt"; desc = "No raw interrupt is generated."; };
            RAW_INTERRUPT_GENERATED = 1 { name = "Raw Interrupt Generated"; desc = "A raw interrupt is generated."; };
        };

        field {
            name = "int_dfifo_rderr_raw";
            desc = "MIPI CTRL read data FIFO raw interrupt status";
            sw = rw;
            hw = w;
            onwrite = woclr;
            encode = MIPI0_CTRL_INT_RAW_int_dfifo_rderr_raw_enum;
            reset = 0x0;
        } int_dfifo_rderr_raw[17:17];

        enum MIPI0_CTRL_INT_RAW_int_cfifo_rderr_raw_enum {
            NO_RAW_INTERRUPT = 0 { name = "No Raw Interrupt"; desc = "No raw interrupt is generated."; };
            RAW_INTERRUPT_GENERATED = 1 { name = "Raw Interrupt Generated"; desc = "A raw interrupt is generated."; };
        };

        field {
            name = "int_cfifo_rderr_raw";
            desc = "MIPI CTRL read command FIFO raw interrupt status";
            sw = rw;
            hw = w;
            onwrite = woclr;
            encode = MIPI0_CTRL_INT_RAW_int_cfifo_rderr_raw_enum;
            reset = 0x0;
        } int_cfifo_rderr_raw[16:16];

        enum MIPI0_CTRL_INT_RAW_int_dfifo_wrerr_raw_enum {
            NO_RAW_INTERRUPT = 0 { name = "No Raw Interrupt"; desc = "No raw interrupt is generated."; };
            RAW_INTERRUPT_GENERATED = 1 { name = "Raw Interrupt Generated"; desc = "A raw interrupt is generated."; };
        };

        field {
            name = "int_dfifo_wrerr_raw";
            desc = "MIPI CTRL write data FIFO raw interrupt status";
            sw = rw;
            hw = w;
            onwrite = woclr;
            encode = MIPI0_CTRL_INT_RAW_int_dfifo_wrerr_raw_enum;
            reset = 0x0;
        } int_dfifo_wrerr_raw[1:1];

        enum MIPI0_CTRL_INT_RAW_int_cfifo_wrerr_raw_enum {
            NO_RAW_INTERRUPT = 0 { name = "No Raw Interrupt"; desc = "No raw interrupt is generated."; };
            RAW_INTERRUPT_GENERATED = 1 { name = "Raw Interrupt Generated"; desc = "A raw interrupt is generated."; };
        };

        field {
            name = "int_cfifo_wrerr_raw";
            desc = "MIPI CTRL write command FIFO raw interrupt status";
            sw = rw;
            hw = w;
            onwrite = woclr;
            encode = MIPI0_CTRL_INT_RAW_int_cfifo_wrerr_raw_enum;
            reset = 0x0;
        } int_cfifo_wrerr_raw[0:0];
    } MIPI0_CTRL_INT_RAW @ 0x12F0;

    reg {
        name = "MIPI 0 read data error interrupt status L_INT register";
        desc = "MIPI0_CTRL_INT is a MIPI 0 read data error interrupt status register. Hi3516A V200 Professional HD IP Camera SoC

Data sheet 9.3.6 MIPI0_CTRL_INT (offset 0x12F4, printed page 9-280, `hi3516av200--Hi3516AV200-Datasheet.txt` line 53138).";

        enum MIPI0_CTRL_INT_int_dfifo_rderr_st_enum {
            NO_INTERRUPT_GENERATED = 0 { name = "No Interrupt Generated"; desc = "No interrupt is generated."; };
            INTERRUPT_GENERATED = 1 { name = "Interrupt Generated"; desc = "An interrupt is generated."; };
        };

        field {
            name = "int_dfifo_rderr_st";
            desc = "MIPI CTRL read data FIFO interrupt status";
            sw = r;
            hw = w;
            encode = MIPI0_CTRL_INT_int_dfifo_rderr_st_enum;
            reset = 0x0;
        } int_dfifo_rderr_st[17:17];

        enum MIPI0_CTRL_INT_int_cfifo_rderr_st_enum {
            NO_INTERRUPT_GENERATED = 0 { name = "No Interrupt Generated"; desc = "No interrupt is generated."; };
            INTERRUPT_GENERATED = 1 { name = "Interrupt Generated"; desc = "An interrupt is generated."; };
        };

        field {
            name = "int_cfifo_rderr_st";
            desc = "MIPI CTRL read command FIFO interrupt status";
            sw = r;
            hw = w;
            encode = MIPI0_CTRL_INT_int_cfifo_rderr_st_enum;
            reset = 0x0;
        } int_cfifo_rderr_st[16:16];

        enum MIPI0_CTRL_INT_int_dfifo_wrerr_st_enum {
            NO_INTERRUPT_GENERATED = 0 { name = "No Interrupt Generated"; desc = "No interrupt is generated."; };
            INTERRUPT_GENERATED = 1 { name = "Interrupt Generated"; desc = "An interrupt is generated."; };
        };

        field {
            name = "int_dfifo_wrerr_st";
            desc = "MIPI CTRL write data FIFO interrupt status";
            sw = r;
            hw = w;
            encode = MIPI0_CTRL_INT_int_dfifo_wrerr_st_enum;
            reset = 0x0;
        } int_dfifo_wrerr_st[1:1];

        enum MIPI0_CTRL_INT_int_cfifo_wrerr_st_enum {
            NO_INTERRUPT_GENERATED = 0 { name = "No Interrupt Generated"; desc = "No interrupt is generated."; };
            INTERRUPT_GENERATED = 1 { name = "Interrupt Generated"; desc = "An interrupt is generated."; };
        };

        field {
            name = "int_cfifo_wrerr_st";
            desc = "MIPI CTRL write command FIFO interrupt status";
            sw = r;
            hw = w;
            encode = MIPI0_CTRL_INT_int_cfifo_wrerr_st_enum;
            reset = 0x0;
        } int_cfifo_wrerr_st[0:0];
    } MIPI0_CTRL_INT @ 0x12F4;

    reg {
        name = "MIPI 0 read data error interrupt mask L_INT_MSK register";
        desc = "MIPI0_CTRL_INT_MSK is a MIPI 0 read data error interrupt mask register. Hi3516A V200 Professional HD IP Camera SoC

Data sheet 9.3.6 MIPI0_CTRL_INT_MSK (offset 0x12F8, printed page 9-281, `hi3516av200--Hi3516AV200-Datasheet.txt` line 53187).";

        enum MIPI0_CTRL_INT_MSK_int_dfifo_rderr_msk_enum {
            MASKED = 0 { name = "Masked"; desc = "masked"; };
            ENABLED = 1 { name = "Enabled"; desc = "enabled"; };
        };

        field {
            name = "int_dfifo_rderr_msk";
            desc = "MIPI CTRL read data FIFO interrupt enable";
            sw = rw;
            hw = r;
            encode = MIPI0_CTRL_INT_MSK_int_dfifo_rderr_msk_enum;
            reset = 0x0;
        } int_dfifo_rderr_msk[17:17];

        enum MIPI0_CTRL_INT_MSK_int_cfifo_rderr_msk_enum {
            MASKED = 0 { name = "Masked"; desc = "masked"; };
            ENABLED = 1 { name = "Enabled"; desc = "enabled"; };
        };

        field {
            name = "int_cfifo_rderr_msk";
            desc = "MIPI CTRL read command FIFO interrupt enable";
            sw = rw;
            hw = r;
            encode = MIPI0_CTRL_INT_MSK_int_cfifo_rderr_msk_enum;
            reset = 0x0;
        } int_cfifo_rderr_msk[16:16];

        enum MIPI0_CTRL_INT_MSK_int_dfifo_wrerr_msk_enum {
            MASKED = 0 { name = "Masked"; desc = "masked"; };
            ENABLED = 1 { name = "Enabled"; desc = "enabled"; };
        };

        field {
            name = "int_dfifo_wrerr_msk";
            desc = "MIPI CTRL write data FIFO interrupt enable";
            sw = rw;
            hw = r;
            encode = MIPI0_CTRL_INT_MSK_int_dfifo_wrerr_msk_enum;
            reset = 0x0;
        } int_dfifo_wrerr_msk[1:1];

        enum MIPI0_CTRL_INT_MSK_int_cfifo_wrerr_msk_enum {
            MASKED = 0 { name = "Masked"; desc = "masked"; };
            ENABLED = 1 { name = "Enabled"; desc = "enabled"; };
        };

        field {
            name = "int_cfifo_wrerr_msk";
            desc = "MIPI CTRL write command FIFO interrupt enable";
            sw = rw;
            hw = r;
            encode = MIPI0_CTRL_INT_MSK_int_cfifo_wrerr_msk_enum;
            reset = 0x0;
        } int_cfifo_wrerr_msk[0:0];
    } MIPI0_CTRL_INT_MSK @ 0x12F8;

    reg {
        name = "LVDS WDR control register R";
        desc = "LVDS0_WDR is an LVDS WDR control register. Hi3516A V200 Professional HD IP Camera SoC

Data sheet 9.3.6 LVDS0_WDR (offset 0x1300, printed page 9-282, `hi3516av200--Hi3516AV200-Datasheet.txt` line 53243).";

        field {
            name = "lvds_wdr_id_shift";
            desc = "IMX136 frame ID flag shift. This field indicates the number of bits to be shifted rightwards to move the frame ID to bit 0.";
            sw = rw;
            hw = r;
            reset = 0x0;
        } lvds_wdr_id_shift[15:12];

        enum LVDS0_WDR_lvds_wdr_mode_enum {
            WDR_MODE_WITH = 0 { name = "Wdr Mode With"; desc = "WDR mode with the SOF-EOF flag. In this mode, the long exposure frame and short exposure frame have independent synchronization codes."; };
            HISPI_WDR_MODE = 2 { name = "Hispi Wdr Mode"; desc = "HiSPi WDR mode. In this mode, the long and short exposure frames share one SOF-EOF flag, and the first several lines of the short exposure frame are stuffed with 0x04."; };
            SONY_DOL_WDR = 4 { name = "Sony Dol Wdr"; desc = "SONY DOL WDR mode. In this mode, the synchronization code consists of four fields, the SAV-EAV flag is used, and the long exposure frame and short exposure frame have independent synchronization codes."; };
            SONY_DOL_WDR_2 = 6 { name = "Sony Dol Wdr 2"; desc = "SONY DOL WDR mode. In this mode, the synchronization code consists of five fields. The fifth field indicates whether the frame is a long frame or a short frame."; };
            SONY_IMX136_FRAME = 8 { name = "Sony Imx136 Frame"; desc = "SONY IMX136 frame WDR mode. Do not enable WDR_EN in this mode."; };
            SHARP_LONG_SHORT = 9 { name = "Sharp Long Short"; desc = "Sharp long/short exposure 2-line alternating mode. The long frame is before the short frame."; };
            SHARP_LONG_SHORT_2 = 10 { name = "Sharp Long Short 2"; desc = "Sharp long/short exposure 2-line alternating mode. The long frame is after the short frame. Other values: reserved"; };
        };

        field {
            name = "lvds_wdr_mode";
            desc = "LVDS WDR mode select";
            sw = rw;
            hw = r;
            encode = LVDS0_WDR_lvds_wdr_mode_enum;
            reset = 0x0;
        } lvds_wdr_mode[11:8];

        enum LVDS0_WDR_lvds_wdr_num_enum {
            RESERVED = 0 { name = "Reserved"; desc = "reserved"; };
            V_2_FRAME_WDR = 1 { name = "V 2 Frame Wdr"; desc = "2-frame WDR"; };
            V_3_FRAME_WDR = 2 { name = "V 3 Frame Wdr"; desc = "3-frame WDR"; };
            V_4_FRAME_WDR = 3 { name = "V 4 Frame Wdr"; desc = "4-frame WDR"; };
        };

        field {
            name = "lvds_wdr_num";
            desc = "WDR mode configuration";
            sw = rw;
            hw = r;
            encode = LVDS0_WDR_lvds_wdr_num_enum;
            reset = 0x0;
        } lvds_wdr_num[5:4];

        enum LVDS0_WDR_lvds_wdr_en_enum {
            LINEAR_MODE = 0 { name = "Linear Mode"; desc = "linear mode"; };
            WDR_MODE = 1 { name = "Wdr Mode"; desc = "WDR mode"; };
        };

        field {
            name = "lvds_wdr_en";
            desc = "WDR enable";
            sw = rw;
            hw = r;
            encode = LVDS0_WDR_lvds_wdr_en_enum;
            reset = 0x0;
        } lvds_wdr_en[0:0];
    } LVDS0_WDR @ 0x1300;

    reg {
        name = "LVDS0 DOLSCD HBLK";
        desc = "[inferred] LVDS0 DOLSCD HBLK. Not in the data sheet. Source: OpenIPC openhisilicon `kernel/mipi_rx/hi3519v101/mipi_reg.h` (GPL-3.0 repository, HiSilicon copyright; local copy sources/openhisilicon), union `U_LVDS_DOLSCD_HBLK`, struct offset 0x1304 (GPL-3.0 repository, HiSilicon copyright; one header for Hi3519 V101 and Hi3516A V200). Reset value and access type unknown (modelled RW, no reset). Confidence: medium (vendor header for this chip family, not hardware verified).";

        field {
            name = "dol_hblank2";
            desc = "[inferred] Dol hblank2. (vendor header `hi3519v101/mipi_reg.h` field `dol_hblank2`; access and reset unknown, modelled RW)";
            sw = rw;
            hw = r;
        } dol_hblank2[27:16];

        field {
            name = "dol_hblank1";
            desc = "[inferred] Dol hblank1. (vendor header `hi3519v101/mipi_reg.h` field `dol_hblank1`; access and reset unknown, modelled RW)";
            sw = rw;
            hw = r;
        } dol_hblank1[11:0];
    } LVDS0_DOLSCD_HBLK @ 0x1304;

    reg {
        name = "LVDS fourth frame cropping register OP_START3";
        desc = "LVDS0_CROP_START3 is an LVDS fourth frame cropping register.

Data sheet 9.3.6 LVDS0_CROP_START3 (offset 0x1308, printed page 9-283, `hi3516av200--Hi3516AV200-Datasheet.txt` line 53316).";

        field {
            name = "lvds_start_y3";
            desc = "[inferred] Lvds start y3. (bits reserved in the data sheet; vendor header `hi3519v101/mipi_reg.h` field `lvds_start_y3`; access and reset unknown, modelled RW)";
            sw = rw;
            hw = r;
        } lvds_start_y3[31:16];

        field {
            name = "lvds_start_x3_lane";
            desc = "Width of the cropping start point for the fourth frame. The configured value is the start pixel to be cropped divided by the number of channels.";
            sw = rw;
            hw = r;
            reset = 0x0;
        } lvds_start_x3_lane[15:0];
    } LVDS0_CROP_START3 @ 0x1308;

    reg {
        name = "LVDS image size register SIZE";
        desc = "LVDS0_IMGSIZE is an LVDS image size register.

Data sheet 9.3.6 LVDS0_IMGSIZE (offset 0x130C, printed page 9-283, `hi3516av200--Hi3516AV200-Datasheet.txt` line 53337).";

        field {
            name = "lvds_imgheight";
            desc = "Image height minus 1";
            sw = rw;
            hw = r;
            reset = 0x0;
        } lvds_imgheight[31:16];

        field {
            name = "lvds_imgwidth_lane";
            desc = "Width of the image transferred in each channel minus 1";
            sw = rw;
            hw = r;
            reset = 0x0;
        } lvds_imgwidth_lane[15:0];
    } LVDS0_IMGSIZE @ 0x130C;

    reg {
        name = "LVDS control register L";
        desc = "LVDS0_CTRL is an LVDS control register. Hi3516A V200 Professional HD IP Camera SoC

Data sheet 9.3.6 LVDS0_CTRL (offset 0x1310, printed page 9-284, `hi3516av200--Hi3516AV200-Datasheet.txt` line 53369).";

        enum LVDS0_CTRL_lvds_split_mode_enum {
            PER_LANE_MODE = 0 { name = "Per Lane Mode"; desc = "per lane mode"; };
            SPLIT_2_LANE = 3 { name = "Split 2 Lane"; desc = "split-2 lane mode"; };
            SPLIT_4_LANE = 7 { name = "Split 4 Lane"; desc = "split-4 lane mode Other values: reserved"; };
        };

        field {
            name = "lvds_split_mode";
            desc = "Transfer type for the synchronization code in LVDS or HiSPi mode";
            sw = rw;
            hw = r;
            encode = LVDS0_CTRL_lvds_split_mode_enum;
            reset = 0x0;
        } lvds_split_mode[18:16];

        enum LVDS0_CTRL_lvds_crop_en_enum {
            DISABLED = 0 { name = "Disabled"; desc = "disabled"; };
            ENABLED = 1 { name = "Enabled"; desc = "enabled"; };
        };

        field {
            name = "lvds_crop_en";
            desc = "Image cropping enable in LVDS or HiSPi mode";
            sw = rw;
            hw = r;
            encode = LVDS0_CTRL_lvds_crop_en_enum;
            reset = 0x0;
        } lvds_crop_en[12:12];

        enum LVDS0_CTRL_lvds_code_big_endian_enum {
            LSB_LOWER_BITS = 0 { name = "Lsb Lower Bits"; desc = "LSB. The lower bits are transmitted first. The serial data sequence of the received synchronization code is bit 0, bit 1, …, bit 11."; };
            MSB_UPPER_BITS = 1 { name = "Msb Upper Bits"; desc = "MSB. The upper bits are transmitted first. The serial data sequence of the received synchronization code is bit 11, bit 10, …, bit 0."; };
        };

        field {
            name = "lvds_code_big_endian";
            desc = "Serial bit transmission sequence for the synchronization code (sync_code) of the raw data to be transmitted in LVDS or HiSPi mode";
            sw = rw;
            hw = r;
            encode = LVDS0_CTRL_lvds_code_big_endian_enum;
            reset = 0x1;
        } lvds_code_big_endian[9:9];

        enum LVDS0_CTRL_lvds_pix_big_endian_enum {
            LSB_LOWER_BITS = 0 { name = "Lsb Lower Bits"; desc = "LSB. The lower bits are transmitted first. The serial data sequence of the received valid pixels is bit 0, bit 1, …, bit 11."; };
            MSB_UPPER_BITS = 1 { name = "Msb Upper Bits"; desc = "MSB. The upper bits are transmitted first. The serial data sequence of the received valid pixels is bit 11, bit 10, …, bit 0."; };
        };

        field {
            name = "lvds_pix_big_endian";
            desc = "Serial bit transmission sequence for the valid pixels of the raw data to be transmitted in LVDS or HiSPi mode";
            sw = rw;
            hw = r;
            encode = LVDS0_CTRL_lvds_pix_big_endian_enum;
            reset = 0x1;
        } lvds_pix_big_endian[8:8];

        enum LVDS0_CTRL_lvds_raw_type_enum {
            V_8_BIT_RAW = 1 { name = "V 8 Bit Raw"; desc = "8-bit raw data"; };
            V_10_BIT_RAW = 2 { name = "V 10 Bit Raw"; desc = "10-bit raw data"; };
            V_12_BIT_RAW = 3 { name = "V 12 Bit Raw"; desc = "12-bit raw data"; };
            V_14_BIT_RAW = 4 { name = "V 14 Bit Raw"; desc = "14-bit raw data"; };
            V_16_BIT_RAW = 5 { name = "V 16 Bit Raw"; desc = "16-bit raw data Other values: reserved"; };
        };

        field {
            name = "lvds_raw_type";
            desc = "Type of the raw data to be transmitted in LVDS or HiSPi mode";
            sw = rw;
            hw = r;
            encode = LVDS0_CTRL_lvds_raw_type_enum;
            reset = 0x1;
        } lvds_raw_type[6:4];

        enum LVDS0_CTRL_lvds_sync_mode_enum {
            SOF_EOF_SOL = 0 { name = "Sof Eof Sol"; desc = "SOF/EOF/SOL/EOL mode. SOF specifies the start of the first line in the active region, EOF specifies the end of the last line in the active region, SOL and EOL specify the start and end of other lines in the active region respectively."; };
            SAV_EAV_MODE = 1 { name = "Sav Eav Mode"; desc = "SAV/EAV mode. SAV (Invalid) and EAV (Invalid) identify invalid data of the blanking region, whereas SAV (Valid) and EAV (Valid) identify pixel data of the active region."; };
        };

        field {
            name = "lvds_sync_mode";
            desc = "Frame or line synchronization mode in LVDS mode";
            sw = rw;
            hw = r;
            encode = LVDS0_CTRL_lvds_sync_mode_enum;
            reset = 0x0;
        } lvds_sync_mode[0:0];
    } LVDS0_CTRL @ 0x1310;

    reg {
        name = "LVDS first frame cropping register OP_START0";
        desc = "LVDS0_CROP_START0 is an LVDS first frame cropping register.

Data sheet 9.3.6 LVDS0_CROP_START0 (offset 0x1314, printed page 9-285, `hi3516av200--Hi3516AV200-Datasheet.txt` line 53454).";

        field {
            name = "lvds_start_y0";
            desc = "[inferred] Lvds start y0. (bits reserved in the data sheet; vendor header `hi3519v101/mipi_reg.h` field `lvds_start_y0`; access and reset unknown, modelled RW)";
            sw = rw;
            hw = r;
        } lvds_start_y0[31:16];

        field {
            name = "lvds_start_x_lane";
            desc = "Width of the cropping start point for the first frame. The configured value is the start pixel to be cropped divided by the number of channels.";
            sw = rw;
            hw = r;
            reset = 0x0;
        } lvds_start_x_lane[15:0];
    } LVDS0_CROP_START0 @ 0x1314;

    reg {
        name = "LVDS second frame cropping register OP_START1";
        desc = "LVDS0_CROP_START1 is an LVDS second frame cropping register. Hi3516A V200 Professional HD IP Camera SoC

Data sheet 9.3.6 LVDS0_CROP_START1 (offset 0x1318, printed page 9-286, `hi3516av200--Hi3516AV200-Datasheet.txt` line 53485).";

        field {
            name = "lvds_start_y1";
            desc = "[inferred] Lvds start y1. (bits reserved in the data sheet; vendor header `hi3519v101/mipi_reg.h` field `lvds_start_y1`; access and reset unknown, modelled RW)";
            sw = rw;
            hw = r;
        } lvds_start_y1[31:16];

        field {
            name = "lvds_start_x_lane";
            desc = "Width of the cropping start point for the second frame. The configured value is the start pixel to be cropped divided by the number of channels.";
            sw = rw;
            hw = r;
            reset = 0x0;
        } lvds_start_x_lane[15:0];
    } LVDS0_CROP_START1 @ 0x1318;

    reg {
        name = "LVDS third frame cropping register OP_START2";
        desc = "LVDS0_CROP_START2 is an LVDS third frame cropping register.

Data sheet 9.3.6 LVDS0_CROP_START2 (offset 0x131C, printed page 9-286, `hi3516av200--Hi3516AV200-Datasheet.txt` line 53506).";

        field {
            name = "lvds_start_y2";
            desc = "[inferred] Lvds start y2. (bits reserved in the data sheet; vendor header `hi3519v101/mipi_reg.h` field `lvds_start_y2`; access and reset unknown, modelled RW)";
            sw = rw;
            hw = r;
        } lvds_start_y2[31:16];

        field {
            name = "lvds_start_x_lane";
            desc = "Width of the cropping start point for the third frame. The configured value is the start pixel to be cropped divided by the number of channels.";
            sw = rw;
            hw = r;
            reset = 0x0;
        } lvds_start_x_lane[15:0];
    } LVDS0_CROP_START2 @ 0x131C;

    reg {
        name = "Lane 0 SOF synchronization code NE0_SOF_0 configuration register in LVDS or HiSPi 1 mode";
        desc = "LVDS0_LANE0_SOF_01 is a lane 0 SOF synchronization code configuration register in LVDS or HiSPi mode. Hi3516A V200 Professional HD IP Camera SoC

Data sheet 9.3.6 LVDS0_LANE0_SOF_01 (offset 0x1320, printed page 9-287, `hi3516av200--Hi3516AV200-Datasheet.txt` line 53538).";

        field {
            name = "lane0_sof_1";
            desc = "Lane 0 SOF synchronization code of frame 1 in LVDS or HiSPi mode This field is configurable only in WDR mode, and the configuration is invalid in linear mode.";
            sw = rw;
            hw = r;
            reset = 0x0;
        } lane0_sof_1[31:16];

        field {
            name = "lane0_sof_0";
            desc = "Lane 0 SOF synchronization code of frame 0 in LVDS or HiSPi mode In WDR mode, the value is the SOF of frame 0. In linear mode, the value is the SOF.";
            sw = rw;
            hw = r;
            reset = 0x0;
        } lane0_sof_0[15:0];
    } LVDS0_LANE0_SOF_01 @ 0x1320;

    reg {
        name = "Lane 0 SOF synchronization code NE0_SOF_2 configuration register in LVDS or HiSPi 3 mode";
        desc = "LVDS0_LANE0_SOF_23 is a lane 0 SOF synchronization code configuration register in LVDS or HiSPi mode.

Data sheet 9.3.6 LVDS0_LANE0_SOF_23 (offset 0x1324, printed page 9-287, `hi3516av200--Hi3516AV200-Datasheet.txt` line 53566).";

        field {
            name = "lane0_sof_3";
            desc = "Lane 0 SOF synchronization code of frame 3 in LVDS or HiSPi mode This field is configurable only in WDR mode, and the configuration is invalid in linear mode.";
            sw = rw;
            hw = r;
            reset = 0x0;
        } lane0_sof_3[31:16];

        field {
            name = "lane0_sof_2";
            desc = "Lane 0 SOF synchronization code of frame 2 in LVDS or HiSPi mode This field is configurable only in WDR mode, and the configuration is invalid in linear mode.";
            sw = rw;
            hw = r;
            reset = 0x0;
        } lane0_sof_2[15:0];
    } LVDS0_LANE0_SOF_23 @ 0x1324;

    reg {
        name = "Lane 0 EOF synchronization code NE0_EOF_0 configuration register in LVDS or HiSPi 1 mode";
        desc = "LVDS0_LANE0_EOF_01 is a lane 0 EOF synchronization code configuration register in LVDS or HiSPi mode. Hi3516A V200 Professional HD IP Camera SoC

Data sheet 9.3.6 LVDS0_LANE0_EOF_01 (offset 0x1328, printed page 9-288, `hi3516av200--Hi3516AV200-Datasheet.txt` line 53603).";

        field {
            name = "lane0_eof_1";
            desc = "Lane 0 EOF synchronization code of frame 1 in LVDS or HiSPi mode This field is configurable only in WDR mode, and the configuration is invalid in linear mode.";
            sw = rw;
            hw = r;
            reset = 0x0;
        } lane0_eof_1[31:16];

        field {
            name = "lane0_eof_0";
            desc = "Lane 0 EOF synchronization code of frame 0 in LVDS or HiSPi mode In WDR mode, the value is the EOF of frame 0. In linear mode, the value is the EOF.";
            sw = rw;
            hw = r;
            reset = 0x0;
        } lane0_eof_0[15:0];
    } LVDS0_LANE0_EOF_01 @ 0x1328;

    reg {
        name = "Lane 0 EOF synchronization code NE0_EOF_2 configuration register in LVDS or HiSPi 3 mode";
        desc = "LVDS0_LANE0_EOF_23 is a lane 0 EOF synchronization code configuration register in LVDS or HiSPi mode.

Data sheet 9.3.6 LVDS0_LANE0_EOF_23 (offset 0x132C, printed page 9-288, `hi3516av200--Hi3516AV200-Datasheet.txt` line 53631).";

        field {
            name = "lane0_eof_3";
            desc = "Lane 0 EOF synchronization code of frame 3 in LVDS or HiSPi mode This field is configurable only in WDR mode, and the configuration is invalid in linear mode.";
            sw = rw;
            hw = r;
            reset = 0x0;
        } lane0_eof_3[31:16];

        field {
            name = "lane0_eof_2";
            desc = "Lane 0 EOF synchronization code of frame 2 in LVDS or HiSPi mode This field is configurable only in WDR mode, and the configuration is invalid in linear mode.";
            sw = rw;
            hw = r;
            reset = 0x0;
        } lane0_eof_2[15:0];
    } LVDS0_LANE0_EOF_23 @ 0x132C;

    reg {
        name = "Lane 0 SOL synchronization code NE0_SOL_0 configuration register in LVDS or HiSPi 1 mode";
        desc = "LVDS0_LANE0_SOL_01 is a lane 0 SOL synchronization code configuration register in LVDS or HiSPi mode. Hi3516A V200 Professional HD IP Camera SoC

Data sheet 9.3.6 LVDS0_LANE0_SOL_01 (offset 0x1330, printed page 9-289, `hi3516av200--Hi3516AV200-Datasheet.txt` line 53668).";

        field {
            name = "lane0_sol_1";
            desc = "Lane 0 SOL synchronization code of frame 1 in LVDS or HiSPi mode This field is configurable only in WDR mode, and the configuration is invalid in linear mode.";
            sw = rw;
            hw = r;
            reset = 0x0;
        } lane0_sol_1[31:16];

        field {
            name = "lane0_sol_0";
            desc = "Lane 0 SOL synchronization code of frame 0 in LVDS or HiSPi mode In WDR mode, the value is the SOL of frame 0. In linear mode, the value is the SOL.";
            sw = rw;
            hw = r;
            reset = 0x0;
        } lane0_sol_0[15:0];
    } LVDS0_LANE0_SOL_01 @ 0x1330;

    reg {
        name = "Lane 0 SOL synchronization code NE0_SOL_2 configuration register in LVDS or HiSPi 3 mode";
        desc = "LVDS0_LANE0_SOL_23 is a lane 0 SOL synchronization code configuration register in LVDS or HiSPi mode.

Data sheet 9.3.6 LVDS0_LANE0_SOL_23 (offset 0x1334, printed page 9-289, `hi3516av200--Hi3516AV200-Datasheet.txt` line 53696).";

        field {
            name = "lane0_sol_3";
            desc = "Lane 0 SOL synchronization code of frame 3 in LVDS or HiSPi mode This field is configurable only in WDR mode, and the configuration is invalid in linear mode.";
            sw = rw;
            hw = r;
            reset = 0x0;
        } lane0_sol_3[31:16];

        field {
            name = "lane0_sol_2";
            desc = "Lane 0 SOL synchronization code of frame 2 in LVDS or HiSPi mode This field is configurable only in WDR mode, and the configuration is invalid in linear mode.";
            sw = rw;
            hw = r;
            reset = 0x0;
        } lane0_sol_2[15:0];
    } LVDS0_LANE0_SOL_23 @ 0x1334;

    reg {
        name = "Lane 0 EOL synchronization code NE0_EOL_0 configuration register in LVDS or HiSPi 1 mode";
        desc = "LVDS0_LANE0_EOL_01 is a lane 0 EOL synchronization code configuration register in LVDS or HiSPi mode. Hi3516A V200 Professional HD IP Camera SoC

Data sheet 9.3.6 LVDS0_LANE0_EOL_01 (offset 0x1338, printed page 9-290, `hi3516av200--Hi3516AV200-Datasheet.txt` line 53733).";

        field {
            name = "lane0_eol_1";
            desc = "Lane 0 EOL synchronization code of frame 1 in LVDS or HiSPi mode This field is configurable only in WDR mode, and the configuration is invalid in linear mode.";
            sw = rw;
            hw = r;
            reset = 0x0;
        } lane0_eol_1[31:16];

        field {
            name = "lane0_eol_0";
            desc = "Lane 0 EOL synchronization code of frame 0 in LVDS or HiSPi mode In WDR mode, the value is the EOL of frame 0. In linear mode, the value is the EOL.";
            sw = rw;
            hw = r;
            reset = 0x0;
        } lane0_eol_0[15:0];
    } LVDS0_LANE0_EOL_01 @ 0x1338;

    reg {
        name = "Lane 0 EOL synchronization code NE0_EOL_2 configuration register in LVDS or HiSPi 3 mode";
        desc = "LVDS0_LANE0_EOL_23 is a lane 0 EOL synchronization code configuration register in LVDS or HiSPi mode.

Data sheet 9.3.6 LVDS0_LANE0_EOL_23 (offset 0x133C, printed page 9-290, `hi3516av200--Hi3516AV200-Datasheet.txt` line 53761).";

        field {
            name = "lane0_eol_3";
            desc = "Lane 0 EOL synchronization code of frame 3 in LVDS or HiSPi mode This field is configurable only in WDR mode, and the configuration is invalid in linear mode.";
            sw = rw;
            hw = r;
            reset = 0x0;
        } lane0_eol_3[31:16];

        field {
            name = "lane0_eol_2";
            desc = "Lane 0 EOL synchronization code of frame 2 in LVDS or HiSPi mode This field is configurable only in WDR mode, and the configuration is invalid in linear mode.";
            sw = rw;
            hw = r;
            reset = 0x0;
        } lane0_eol_2[15:0];
    } LVDS0_LANE0_EOL_23 @ 0x133C;

    reg {
        name = "Lane 1 SOF synchronization code NE1_SOF_0 configuration register in LVDS or HiSPi 1 mode";
        desc = "LVDS0_LANE1_SOF_01 is a lane 1 SOF synchronization code configuration register in LVDS or HiSPi mode. Hi3516A V200 Professional HD IP Camera SoC

Data sheet 9.3.6 LVDS0_LANE1_SOF_01 (offset 0x1340, printed page 9-291, `hi3516av200--Hi3516AV200-Datasheet.txt` line 53798).";

        field {
            name = "lane1_sof_1";
            desc = "Lane 1 SOF synchronization code of frame 1 in LVDS or HiSPi mode This field is configurable only in WDR mode, and the configuration is invalid in linear mode.";
            sw = rw;
            hw = r;
            reset = 0x0;
        } lane1_sof_1[31:16];

        field {
            name = "lane1_sof_0";
            desc = "Lane 1 SOF synchronization code of frame 0 in LVDS or HiSPi mode In WDR mode, the value is the SOF of frame 0. In linear mode, the value is the SOF.";
            sw = rw;
            hw = r;
            reset = 0x0;
        } lane1_sof_0[15:0];
    } LVDS0_LANE1_SOF_01 @ 0x1340;

    reg {
        name = "Lane 1 SOF synchronization code NE1_SOF_2 configuration register in LVDS or HiSPi 3 mode";
        desc = "LVDS0_LANE1_SOF_23 is a lane 1 SOF synchronization code configuration register in LVDS or HiSPi mode.

Data sheet 9.3.6 LVDS0_LANE1_SOF_23 (offset 0x1344, printed page 9-291, `hi3516av200--Hi3516AV200-Datasheet.txt` line 53826).";

        field {
            name = "lane1_sof_3";
            desc = "Lane 1 SOF synchronization code of frame 3 in LVDS or HiSPi mode This field is configurable only in WDR mode, and the configuration is invalid in linear mode.";
            sw = rw;
            hw = r;
            reset = 0x0;
        } lane1_sof_3[31:16];

        field {
            name = "lane1_sof_2";
            desc = "Lane 1 SOF synchronization code of frame 2 in LVDS or HiSPi mode This field is configurable only in WDR mode, and the configuration is invalid in linear mode.";
            sw = rw;
            hw = r;
            reset = 0x0;
        } lane1_sof_2[15:0];
    } LVDS0_LANE1_SOF_23 @ 0x1344;

    reg {
        name = "Lane 1 EOF synchronization code NE1_EOF_0 configuration register in LVDS or HiSPi 1 mode";
        desc = "LVDS0_LANE1_EOF_01 is a lane 1 EOF synchronization code configuration register in LVDS or HiSPi mode. Hi3516A V200 Professional HD IP Camera SoC

Data sheet 9.3.6 LVDS0_LANE1_EOF_01 (offset 0x1348, printed page 9-292, `hi3516av200--Hi3516AV200-Datasheet.txt` line 53863).";

        field {
            name = "lane1_eof_1";
            desc = "Lane 1 EOF synchronization code of frame 1 in LVDS or HiSPi mode This field is configurable only in WDR mode, and the configuration is invalid in linear mode.";
            sw = rw;
            hw = r;
            reset = 0x0;
        } lane1_eof_1[31:16];

        field {
            name = "lane1_eof_0";
            desc = "Lane 1 EOF synchronization code of frame 0 in LVDS or HiSPi mode In WDR mode, the value is the EOF of frame 0. In linear mode, the value is the EOF.";
            sw = rw;
            hw = r;
            reset = 0x0;
        } lane1_eof_0[15:0];
    } LVDS0_LANE1_EOF_01 @ 0x1348;

    reg {
        name = "Lane 1 EOF synchronization code NE1_EOF_2 configuration register in LVDS or HiSPi 3 mode";
        desc = "LVDS0_LANE1_EOF_23 is a lane 1 EOF synchronization code configuration register in LVDS or HiSPi mode.

Data sheet 9.3.6 LVDS0_LANE1_EOF_23 (offset 0x134C, printed page 9-292, `hi3516av200--Hi3516AV200-Datasheet.txt` line 53891).";

        field {
            name = "lane1_eof_3";
            desc = "Lane 1 EOF synchronization code of frame 3 in LVDS or HiSPi mode This field is configurable only in WDR mode, and the configuration is invalid in linear mode.";
            sw = rw;
            hw = r;
            reset = 0x0;
        } lane1_eof_3[31:16];

        field {
            name = "lane1_eof_2";
            desc = "Lane 1 EOF synchronization code of frame 2 in LVDS or HiSPi mode This field is configurable only in WDR mode, and the configuration is invalid in linear mode.";
            sw = rw;
            hw = r;
            reset = 0x0;
        } lane1_eof_2[15:0];
    } LVDS0_LANE1_EOF_23 @ 0x134C;

    reg {
        name = "Lane 1 SOL synchronization code NE1_SOL_0 configuration register in LVDS or HiSPi 1 mode";
        desc = "LVDS0_LANE1_SOL_01 is a lane 1 SOL synchronization code configuration register in LVDS or HiSPi mode. Hi3516A V200 Professional HD IP Camera SoC

Data sheet 9.3.6 LVDS0_LANE1_SOL_01 (offset 0x1350, printed page 9-293, `hi3516av200--Hi3516AV200-Datasheet.txt` line 53928).";

        field {
            name = "lane1_sol_1";
            desc = "Lane 1 SOL synchronization code of frame 1 in LVDS or HiSPi mode This field is configurable only in WDR mode, and the configuration is invalid in linear mode.";
            sw = rw;
            hw = r;
            reset = 0x0;
        } lane1_sol_1[31:16];

        field {
            name = "lane1_sol_0";
            desc = "Lane 1 SOL synchronization code of frame 0 in LVDS or HiSPi mode In WDR mode, the value is the SOL of frame 0. In linear mode, the value is the SOL.";
            sw = rw;
            hw = r;
            reset = 0x0;
        } lane1_sol_0[15:0];
    } LVDS0_LANE1_SOL_01 @ 0x1350;

    reg {
        name = "Lane 1 SOL synchronization code NE1_SOL_2 configuration register in LVDS or HiSPi 3 mode";
        desc = "LVDS0_LANE1_SOL_23 is a lane 1 SOL synchronization code configuration register in LVDS or HiSPi mode.

Data sheet 9.3.6 LVDS0_LANE1_SOL_23 (offset 0x1354, printed page 9-293, `hi3516av200--Hi3516AV200-Datasheet.txt` line 53956).";

        field {
            name = "lane1_sol_3";
            desc = "Lane 1 SOL synchronization code of frame 3 in LVDS or HiSPi mode This field is configurable only in WDR mode, and the configuration is invalid in linear mode.";
            sw = rw;
            hw = r;
            reset = 0x0;
        } lane1_sol_3[31:16];

        field {
            name = "lane1_sol_2";
            desc = "Lane 1 SOL synchronization code of frame 2 in LVDS or HiSPi mode This field is configurable only in WDR mode, and the configuration is invalid in linear mode.";
            sw = rw;
            hw = r;
            reset = 0x0;
        } lane1_sol_2[15:0];
    } LVDS0_LANE1_SOL_23 @ 0x1354;

    reg {
        name = "Lane 1 EOL synchronization code NE1_EOL_0 configuration register in LVDS or HiSPi 1 mode";
        desc = "LVDS0_LANE1_EOL_01 is a lane 1 EOL synchronization code configuration register in LVDS or HiSPi mode. Hi3516A V200 Professional HD IP Camera SoC

Data sheet 9.3.6 LVDS0_LANE1_EOL_01 (offset 0x1358, printed page 9-294, `hi3516av200--Hi3516AV200-Datasheet.txt` line 53993).";

        field {
            name = "lane1_eol_1";
            desc = "Lane 1 EOL synchronization code of frame 1 in LVDS or HiSPi mode This field is configurable only in WDR mode, and the configuration is invalid in linear mode.";
            sw = rw;
            hw = r;
            reset = 0x0;
        } lane1_eol_1[31:16];

        field {
            name = "lane1_eol_0";
            desc = "Lane 1 EOL synchronization code of frame 0 in LVDS or HiSPi mode In WDR mode, the value is the EOL of frame 0. In linear mode, the value is the EOL.";
            sw = rw;
            hw = r;
            reset = 0x0;
        } lane1_eol_0[15:0];
    } LVDS0_LANE1_EOL_01 @ 0x1358;

    reg {
        name = "Lane 1 EOL synchronization code NE1_EOL_2 configuration register in LVDS or HiSPi 3 mode";
        desc = "LVDS0_LANE1_EOL_23 is a lane 1 EOL synchronization code configuration register in LVDS or HiSPi mode.

Data sheet 9.3.6 LVDS0_LANE1_EOL_23 (offset 0x135C, printed page 9-294, `hi3516av200--Hi3516AV200-Datasheet.txt` line 54021).";

        field {
            name = "lane1_eol_3";
            desc = "Lane 1 EOL synchronization code of frame 3 in LVDS or HiSPi mode This field is configurable only in WDR mode, and the configuration is invalid in linear mode.";
            sw = rw;
            hw = r;
            reset = 0x0;
        } lane1_eol_3[31:16];

        field {
            name = "lane1_eol_2";
            desc = "Lane 1 EOL synchronization code of frame 2 in LVDS or HiSPi mode This field is configurable only in WDR mode, and the configuration is invalid in linear mode.";
            sw = rw;
            hw = r;
            reset = 0x0;
        } lane1_eol_2[15:0];
    } LVDS0_LANE1_EOL_23 @ 0x135C;

    reg {
        name = "Lane 2 SOF synchronization code NE2_SOF_0 configuration register in LVDS or HiSPi 1 mode";
        desc = "LVDS0_LANE2_SOF_01 is a lane 2 SOF synchronization code configuration register in LVDS or HiSPi mode. Hi3516A V200 Professional HD IP Camera SoC

Data sheet 9.3.6 LVDS0_LANE2_SOF_01 (offset 0x1360, printed page 9-295, `hi3516av200--Hi3516AV200-Datasheet.txt` line 54058).";

        field {
            name = "lane2_sof_1";
            desc = "Lane 2 SOF synchronization code of frame 1 in LVDS or HiSPi mode This field is configurable only in WDR mode, and the configuration is invalid in linear mode.";
            sw = rw;
            hw = r;
            reset = 0x0;
        } lane2_sof_1[31:16];

        field {
            name = "lane2_sof_0";
            desc = "Lane 2 SOF synchronization code of frame 0 in LVDS or HiSPi mode In WDR mode, the value is the SOF of frame 0. In linear mode, the value is the SOF.";
            sw = rw;
            hw = r;
            reset = 0x0;
        } lane2_sof_0[15:0];
    } LVDS0_LANE2_SOF_01 @ 0x1360;

    reg {
        name = "Lane 2 SOF synchronization code NE2_SOF_2 configuration register in LVDS or HiSPi 3 mode";
        desc = "LVDS0_LANE2_SOF_23 is a lane 2 SOF synchronization code configuration register in LVDS or HiSPi mode.

Data sheet 9.3.6 LVDS0_LANE2_SOF_23 (offset 0x1364, printed page 9-295, `hi3516av200--Hi3516AV200-Datasheet.txt` line 54086).";

        field {
            name = "lane2_sof_3";
            desc = "Lane 2 SOF synchronization code of frame 3 in LVDS or HiSPi mode This field is configurable only in WDR mode, and the configuration is invalid in linear mode.";
            sw = rw;
            hw = r;
            reset = 0x0;
        } lane2_sof_3[31:16];

        field {
            name = "lane2_sof_2";
            desc = "Lane 2 SOF synchronization code of frame 2 in LVDS or HiSPi mode This field is configurable only in WDR mode, and the configuration is invalid in linear mode.";
            sw = rw;
            hw = r;
            reset = 0x0;
        } lane2_sof_2[15:0];
    } LVDS0_LANE2_SOF_23 @ 0x1364;

    reg {
        name = "Lane 2 EOF synchronization code NE2_EOF_0 configuration register in LVDS or HiSPi 1 mode";
        desc = "LVDS0_LANE2_EOF_01 is a lane 2 EOF synchronization code configuration register in LVDS or HiSPi mode. Hi3516A V200 Professional HD IP Camera SoC

Data sheet 9.3.6 LVDS0_LANE2_EOF_01 (offset 0x1368, printed page 9-296, `hi3516av200--Hi3516AV200-Datasheet.txt` line 54123).";

        field {
            name = "lane2_eof_1";
            desc = "Lane 2 EOF synchronization code of frame 1 in LVDS or HiSPi mode This field is configurable only in WDR mode, and the configuration is invalid in linear mode.";
            sw = rw;
            hw = r;
            reset = 0x0;
        } lane2_eof_1[31:16];

        field {
            name = "lane2_eof_0";
            desc = "Lane 2 EOF synchronization code of frame 0 in LVDS or HiSPi mode In WDR mode, the value is the EOF of frame 0. In linear mode, the value is the EOF.";
            sw = rw;
            hw = r;
            reset = 0x0;
        } lane2_eof_0[15:0];
    } LVDS0_LANE2_EOF_01 @ 0x1368;

    reg {
        name = "Lane 2 EOF synchronization code NE2_EOF_2 configuration register in LVDS or HiSPi 3 mode";
        desc = "LVDS0_LANE2_EOF_23 is a lane 2 EOF synchronization code configuration register in LVDS or HiSPi mode.

Data sheet 9.3.6 LVDS0_LANE2_EOF_23 (offset 0x136C, printed page 9-296, `hi3516av200--Hi3516AV200-Datasheet.txt` line 54151).";

        field {
            name = "lane2_eof_3";
            desc = "Lane 2 EOF synchronization code of frame 3 in LVDS or HiSPi mode This field is configurable only in WDR mode, and the configuration is invalid in linear mode.";
            sw = rw;
            hw = r;
            reset = 0x0;
        } lane2_eof_3[31:16];

        field {
            name = "lane2_eof_2";
            desc = "Lane 2 EOF synchronization code of frame 2 in LVDS or HiSPi mode This field is configurable only in WDR mode, and the configuration is invalid in linear mode.";
            sw = rw;
            hw = r;
            reset = 0x0;
        } lane2_eof_2[15:0];
    } LVDS0_LANE2_EOF_23 @ 0x136C;

    reg {
        name = "Lane 2 SOL synchronization code NE2_SOL_0 configuration register in LVDS or HiSPi 1 mode";
        desc = "LVDS0_LANE2_SOL_01 is a lane 2 SOL synchronization code configuration register in LVDS or HiSPi mode. Hi3516A V200 Professional HD IP Camera SoC

Data sheet 9.3.6 LVDS0_LANE2_SOL_01 (offset 0x1370, printed page 9-297, `hi3516av200--Hi3516AV200-Datasheet.txt` line 54188).";

        field {
            name = "lane2_sol_1";
            desc = "Lane 2 SOL synchronization code of frame 1 in LVDS or HiSPi mode This field is configurable only in WDR mode, and the configuration is invalid in linear mode.";
            sw = rw;
            hw = r;
            reset = 0x0;
        } lane2_sol_1[31:16];

        field {
            name = "lane2_sol_0";
            desc = "Lane 2 SOL synchronization code of frame 0 in LVDS or HiSPi mode In WDR mode, the value is the SOL of frame 0. In linear mode, the value is the SOL.";
            sw = rw;
            hw = r;
            reset = 0x0;
        } lane2_sol_0[15:0];
    } LVDS0_LANE2_SOL_01 @ 0x1370;

    reg {
        name = "Lane 2 SOL synchronization code NE2_SOL_2 configuration register in LVDS or HiSPi 3 mode";
        desc = "LVDS0_LANE2_SOL_23 is a lane 2 SOL synchronization code configuration register in LVDS or HiSPi mode.

Data sheet 9.3.6 LVDS0_LANE2_SOL_23 (offset 0x1374, printed page 9-297, `hi3516av200--Hi3516AV200-Datasheet.txt` line 54216).";

        field {
            name = "lane2_sol_3";
            desc = "Lane 2 SOL synchronization code of frame 3 in LVDS or HiSPi mode This field is configurable only in WDR mode, and the configuration is invalid in linear mode.";
            sw = rw;
            hw = r;
            reset = 0x0;
        } lane2_sol_3[31:16];

        field {
            name = "lane2_sol_2";
            desc = "Lane 2 SOL synchronization code of frame 2 in LVDS or HiSPi mode This field is configurable only in WDR mode, and the configuration is invalid in linear mode.";
            sw = rw;
            hw = r;
            reset = 0x0;
        } lane2_sol_2[15:0];
    } LVDS0_LANE2_SOL_23 @ 0x1374;

    reg {
        name = "Lane 2 EOL synchronization code NE2_EOL_0 configuration register in LVDS or HiSPi 1 mode";
        desc = "LVDS0_LANE2_EOL_01 is a lane 2 EOL synchronization code configuration register in LVDS or HiSPi mode. Hi3516A V200 Professional HD IP Camera SoC

Data sheet 9.3.6 LVDS0_LANE2_EOL_01 (offset 0x1378, printed page 9-298, `hi3516av200--Hi3516AV200-Datasheet.txt` line 54253).";

        field {
            name = "lane2_eol_1";
            desc = "Lane 2 EOL synchronization code of frame 1 in LVDS or HiSPi mode This field is configurable only in WDR mode, and the configuration is invalid in linear mode.";
            sw = rw;
            hw = r;
            reset = 0x0;
        } lane2_eol_1[31:16];

        field {
            name = "lane2_eol_0";
            desc = "Lane 2 EOL synchronization code of frame 0 in LVDS or HiSPi mode In WDR mode, the value is the EOL of frame 0. In linear mode, the value is the EOL.";
            sw = rw;
            hw = r;
            reset = 0x0;
        } lane2_eol_0[15:0];
    } LVDS0_LANE2_EOL_01 @ 0x1378;

    reg {
        name = "Lane 2 EOL synchronization code NE2_EOL_2 configuration register in LVDS or HiSPi 3 mode";
        desc = "LVDS0_LANE2_EOL_23 is a lane 2 EOL synchronization code configuration register in LVDS or HiSPi mode.

Data sheet 9.3.6 LVDS0_LANE2_EOL_23 (offset 0x137C, printed page 9-298, `hi3516av200--Hi3516AV200-Datasheet.txt` line 54281).";

        field {
            name = "lane2_eol_3";
            desc = "Lane 2 EOL synchronization code of frame 3 in LVDS or HiSPi mode This field is configurable only in WDR mode, and the configuration is invalid in linear mode.";
            sw = rw;
            hw = r;
            reset = 0x0;
        } lane2_eol_3[31:16];

        field {
            name = "lane2_eol_2";
            desc = "Lane 2 EOL synchronization code of frame 2 in LVDS or HiSPi mode This field is configurable only in WDR mode, and the configuration is invalid in linear mode.";
            sw = rw;
            hw = r;
            reset = 0x0;
        } lane2_eol_2[15:0];
    } LVDS0_LANE2_EOL_23 @ 0x137C;

    reg {
        name = "Lane 3 SOF synchronization code NE3_SOF_0 configuration register in LVDS or HiSPi 1 mode";
        desc = "LVDS0_LANE3_SOF_01 is a lane 3 SOF synchronization code configuration register in LVDS or HiSPi mode. Hi3516A V200 Professional HD IP Camera SoC

Data sheet 9.3.6 LVDS0_LANE3_SOF_01 (offset 0x1380, printed page 9-299, `hi3516av200--Hi3516AV200-Datasheet.txt` line 54318).";

        field {
            name = "lane3_sof_1";
            desc = "Lane 3 SOF synchronization code of frame 1 in LVDS or HiSPi mode This field is configurable only in WDR mode, and the configuration is invalid in linear mode.";
            sw = rw;
            hw = r;
            reset = 0x0;
        } lane3_sof_1[31:16];

        field {
            name = "lane3_sof_0";
            desc = "Lane 3 SOF synchronization code of frame 0 in LVDS or HiSPi mode In WDR mode, the value is the SOF of frame 0. In linear mode, the value is the SOF.";
            sw = rw;
            hw = r;
            reset = 0x0;
        } lane3_sof_0[15:0];
    } LVDS0_LANE3_SOF_01 @ 0x1380;

    reg {
        name = "Lane 3 SOF synchronization code NE3_SOF_2 configuration register in LVDS or HiSPi 3 mode";
        desc = "LVDS0_LANE3_SOF_23 is a lane 3 SOF synchronization code configuration register in LVDS or HiSPi mode.

Data sheet 9.3.6 LVDS0_LANE3_SOF_23 (offset 0x1384, printed page 9-299, `hi3516av200--Hi3516AV200-Datasheet.txt` line 54346).";

        field {
            name = "lane3_sof_3";
            desc = "Lane 3 SOF synchronization code of frame 3 in LVDS or HiSPi mode This field is configurable only in WDR mode, and the configuration is invalid in linear mode.";
            sw = rw;
            hw = r;
            reset = 0x0;
        } lane3_sof_3[31:16];

        field {
            name = "lane3_sof_2";
            desc = "Lane 3 SOF synchronization code of frame 2 in LVDS or HiSPi mode This field is configurable only in WDR mode, and the configuration is invalid in linear mode.";
            sw = rw;
            hw = r;
            reset = 0x0;
        } lane3_sof_2[15:0];
    } LVDS0_LANE3_SOF_23 @ 0x1384;

    reg {
        name = "Lane 3 EOF synchronization code NE3_EOF_0 configuration register in LVDS or HiSPi 1 mode";
        desc = "LVDS0_LANE3_EOF_01 is a lane 3 EOF synchronization code configuration register in LVDS or HiSPi mode. Hi3516A V200 Professional HD IP Camera SoC

Data sheet 9.3.6 LVDS0_LANE3_EOF_01 (offset 0x1388, printed page 9-300, `hi3516av200--Hi3516AV200-Datasheet.txt` line 54383).";

        field {
            name = "lane3_eof_1";
            desc = "Lane 3 EOF synchronization code of frame 1 in LVDS or HiSPi mode This field is configurable only in WDR mode, and the configuration is invalid in linear mode.";
            sw = rw;
            hw = r;
            reset = 0x0;
        } lane3_eof_1[31:16];

        field {
            name = "lane3_eof_0";
            desc = "Lane 3 EOF synchronization code of frame 0 in LVDS or HiSPi mode In WDR mode, the value is the EOF of frame 0. In linear mode, the value is the EOF.";
            sw = rw;
            hw = r;
            reset = 0x0;
        } lane3_eof_0[15:0];
    } LVDS0_LANE3_EOF_01 @ 0x1388;

    reg {
        name = "Lane 3 EOF synchronization code NE3_EOF_2 configuration register in LVDS or HiSPi 3 mode";
        desc = "LVDS0_LANE3_EOF_23 is a lane 3 EOF synchronization code configuration register in LVDS or HiSPi mode.

Data sheet 9.3.6 LVDS0_LANE3_EOF_23 (offset 0x138C, printed page 9-300, `hi3516av200--Hi3516AV200-Datasheet.txt` line 54411).";

        field {
            name = "lane3_eof_3";
            desc = "Lane 3 EOF synchronization code of frame 3 in LVDS or HiSPi mode This field is configurable only in WDR mode, and the configuration is invalid in linear mode.";
            sw = rw;
            hw = r;
            reset = 0x0;
        } lane3_eof_3[31:16];

        field {
            name = "lane3_eof_2";
            desc = "Lane 3 EOF synchronization code of frame 2 in LVDS or HiSPi mode This field is configurable only in WDR mode, and the configuration is invalid in linear mode.";
            sw = rw;
            hw = r;
            reset = 0x0;
        } lane3_eof_2[15:0];
    } LVDS0_LANE3_EOF_23 @ 0x138C;

    reg {
        name = "Lane 3 SOL synchronization code NE3_SOL_0 configuration register in LVDS or HiSPi 1 mode";
        desc = "LVDS0_LANE3_SOL_01 is a lane 3 SOL synchronization code configuration register in LVDS or HiSPi mode. Hi3516A V200 Professional HD IP Camera SoC

Data sheet 9.3.6 LVDS0_LANE3_SOL_01 (offset 0x1390, printed page 9-301, `hi3516av200--Hi3516AV200-Datasheet.txt` line 54448).";

        field {
            name = "lane3_sol_1";
            desc = "Lane 3 SOL synchronization code of frame 1 in LVDS or HiSPi mode This field is configurable only in WDR mode, and the configuration is invalid in linear mode.";
            sw = rw;
            hw = r;
            reset = 0x0;
        } lane3_sol_1[31:16];

        field {
            name = "lane3_sol_0";
            desc = "Lane 3 SOL synchronization code of frame 0 in LVDS or HiSPi mode In WDR mode, the value is the SOL of frame 0. In linear mode, the value is the SOL.";
            sw = rw;
            hw = r;
            reset = 0x0;
        } lane3_sol_0[15:0];
    } LVDS0_LANE3_SOL_01 @ 0x1390;

    reg {
        name = "Lane 3 SOL synchronization code NE3_SOL_2 configuration register in LVDS or HiSPi 3 mode";
        desc = "LVDS0_LANE3_SOL_23 is a lane 3 SOL synchronization code configuration register in LVDS or HiSPi mode.

Data sheet 9.3.6 LVDS0_LANE3_SOL_23 (offset 0x1394, printed page 9-301, `hi3516av200--Hi3516AV200-Datasheet.txt` line 54476).";

        field {
            name = "lane3_sol_3";
            desc = "Lane 3 SOL synchronization code of frame 3 in LVDS or HiSPi mode This field is configurable only in WDR mode, and the configuration is invalid in linear mode.";
            sw = rw;
            hw = r;
            reset = 0x0;
        } lane3_sol_3[31:16];

        field {
            name = "lane3_sol_2";
            desc = "Lane 3 SOL synchronization code of frame 2 in LVDS or HiSPi mode This field is configurable only in WDR mode, and the configuration is invalid in linear mode.";
            sw = rw;
            hw = r;
            reset = 0x0;
        } lane3_sol_2[15:0];
    } LVDS0_LANE3_SOL_23 @ 0x1394;

    reg {
        name = "Lane 3 EOL synchronization code NE3_EOL_0 configuration register in LVDS or HiSPi 1 mode";
        desc = "LVDS0_LANE3_EOL_01 is a lane 3 EOL synchronization code configuration register in LVDS or HiSPi mode. Hi3516A V200 Professional HD IP Camera SoC

Data sheet 9.3.6 LVDS0_LANE3_EOL_01 (offset 0x1398, printed page 9-302, `hi3516av200--Hi3516AV200-Datasheet.txt` line 54513).";

        field {
            name = "lane3_eol_1";
            desc = "Lane 3 EOL synchronization code of frame 1 in LVDS or HiSPi mode This field is configurable only in WDR mode, and the configuration is invalid in linear mode.";
            sw = rw;
            hw = r;
            reset = 0x0;
        } lane3_eol_1[31:16];

        field {
            name = "lane3_eol_0";
            desc = "Lane 3 EOL synchronization code of frame 0 in LVDS or HiSPi mode In WDR mode, the value is the EOL of frame 0. In linear mode, the value is the EOL.";
            sw = rw;
            hw = r;
            reset = 0x0;
        } lane3_eol_0[15:0];
    } LVDS0_LANE3_EOL_01 @ 0x1398;

    reg {
        name = "Lane 3 EOL synchronization code NE3_EOL_2 configuration register in LVDS or HiSPi 3 mode";
        desc = "LVDS0_LANE3_EOL_23 is a lane 3 EOL synchronization code configuration register in LVDS or HiSPi mode.

Data sheet 9.3.6 LVDS0_LANE3_EOL_23 (offset 0x139C, printed page 9-302, `hi3516av200--Hi3516AV200-Datasheet.txt` line 54541).";

        field {
            name = "lane3_eol_3";
            desc = "Lane 3 EOL synchronization code of frame 3 in LVDS or HiSPi mode This field is configurable only in WDR mode, and the configuration is invalid in linear mode.";
            sw = rw;
            hw = r;
            reset = 0x0;
        } lane3_eol_3[31:16];

        field {
            name = "lane3_eol_2";
            desc = "Lane 3 EOL synchronization code of frame 2 in LVDS or HiSPi mode This field is configurable only in WDR mode, and the configuration is invalid in linear mode.";
            sw = rw;
            hw = r;
            reset = 0x0;
        } lane3_eol_2[15:0];
    } LVDS0_LANE3_EOL_23 @ 0x139C;

    reg {
        name = "Lane 4 SOF synchronization code NE4_SOF_0 configuration register in LVDS or HiSPi 1 mode";
        desc = "LVDS0_LANE4_SOF_01 is a lane 4 SOF synchronization code configuration register in LVDS or HiSPi mode. Hi3516A V200 Professional HD IP Camera SoC

Data sheet 9.3.6 LVDS0_LANE4_SOF_01 (offset 0x13A0, printed page 9-303, `hi3516av200--Hi3516AV200-Datasheet.txt` line 54578).";

        field {
            name = "lane4_sof_1";
            desc = "Lane 4 SOF synchronization code of frame 1 in LVDS or HiSPi mode This field is configurable only in WDR mode, and the configuration is invalid in linear mode.";
            sw = rw;
            hw = r;
            reset = 0x0;
        } lane4_sof_1[31:16];

        field {
            name = "lane4_sof_0";
            desc = "Lane 4 SOF synchronization code of frame 0 in LVDS or HiSPi mode In WDR mode, the value is the SOF of frame 0. In linear mode, the value is the SOF.";
            sw = rw;
            hw = r;
            reset = 0x0;
        } lane4_sof_0[15:0];
    } LVDS0_LANE4_SOF_01 @ 0x13A0;

    reg {
        name = "Lane 4 SOF synchronization code NE4_SOF_2 configuration register in LVDS or HiSPi 3 mode";
        desc = "LVDS0_LANE4_SOF_23 is a lane 4 SOF synchronization code configuration register in LVDS or HiSPi mode.

Data sheet 9.3.6 LVDS0_LANE4_SOF_23 (offset 0x13A4, printed page 9-303, `hi3516av200--Hi3516AV200-Datasheet.txt` line 54606).";

        field {
            name = "lane4_sof_3";
            desc = "Lane 4 SOF synchronization code of frame 3 in LVDS or HiSPi mode This field is configurable only in WDR mode, and the configuration is invalid in linear mode.";
            sw = rw;
            hw = r;
            reset = 0x0;
        } lane4_sof_3[31:16];

        field {
            name = "lane4_sof_2";
            desc = "Lane 4 SOF synchronization code of frame 2 in LVDS or HiSPi mode This field is configurable only in WDR mode, and the configuration is invalid in linear mode.";
            sw = rw;
            hw = r;
            reset = 0x0;
        } lane4_sof_2[15:0];
    } LVDS0_LANE4_SOF_23 @ 0x13A4;

    reg {
        name = "Lane 4 EOF synchronization code NE4_EOF_0 configuration register in LVDS or HiSPi 1 mode";
        desc = "LVDS0_LANE4_EOF_01 is a lane 4 EOF synchronization code configuration register in LVDS or HiSPi mode. Hi3516A V200 Professional HD IP Camera SoC

Data sheet 9.3.6 LVDS0_LANE4_EOF_01 (offset 0x13A8, printed page 9-304, `hi3516av200--Hi3516AV200-Datasheet.txt` line 54643).";

        field {
            name = "lane4_eof_1";
            desc = "Lane 4 EOF synchronization code of frame 1 in LVDS or HiSPi mode This field is configurable only in WDR mode, and the configuration is invalid in linear mode.";
            sw = rw;
            hw = r;
            reset = 0x0;
        } lane4_eof_1[31:16];

        field {
            name = "lane4_eof_0";
            desc = "Lane 4 EOF synchronization code of frame 0 in LVDS or HiSPi mode In WDR mode, the value is the EOF of frame 0. In linear mode, the value is the EOF.";
            sw = rw;
            hw = r;
            reset = 0x0;
        } lane4_eof_0[15:0];
    } LVDS0_LANE4_EOF_01 @ 0x13A8;

    reg {
        name = "Lane 4 EOF synchronization code NE4_EOF_2 configuration register in LVDS or HiSPi 3 mode";
        desc = "LVDS0_LANE4_EOF_23 is a lane 4 EOF synchronization code configuration register in LVDS or HiSPi mode.

Data sheet 9.3.6 LVDS0_LANE4_EOF_23 (offset 0x13AC, printed page 9-304, `hi3516av200--Hi3516AV200-Datasheet.txt` line 54671).";

        field {
            name = "lane4_eof_3";
            desc = "Lane 4 EOF synchronization code of frame 3 in LVDS or HiSPi mode This field is configurable only in WDR mode, and the configuration is invalid in linear mode.";
            sw = rw;
            hw = r;
            reset = 0x0;
        } lane4_eof_3[31:16];

        field {
            name = "lane4_eof_2";
            desc = "Lane 4 EOF synchronization code of frame 2 in LVDS or HiSPi mode This field is configurable only in WDR mode, and the configuration is invalid in linear mode.";
            sw = rw;
            hw = r;
            reset = 0x0;
        } lane4_eof_2[15:0];
    } LVDS0_LANE4_EOF_23 @ 0x13AC;

    reg {
        name = "Lane 4 SOL synchronization code NE4_SOL_0 configuration register in LVDS or HiSPi 1 mode";
        desc = "LVDS0_LANE4_SOL_01 is a lane 4 SOL synchronization code configuration register in LVDS or HiSPi mode. Hi3516A V200 Professional HD IP Camera SoC

Data sheet 9.3.6 LVDS0_LANE4_SOL_01 (offset 0x13B0, printed page 9-305, `hi3516av200--Hi3516AV200-Datasheet.txt` line 54708).";

        field {
            name = "lane4_sol_1";
            desc = "Lane 4 SOL synchronization code of frame 1 in LVDS or HiSPi mode This field is configurable only in WDR mode, and the configuration is invalid in linear mode.";
            sw = rw;
            hw = r;
            reset = 0x0;
        } lane4_sol_1[31:16];

        field {
            name = "lane4_sol_0";
            desc = "Lane 4 SOL synchronization code of frame 0 in LVDS or HiSPi mode In WDR mode, the value is the SOL of frame 0. In linear mode, the value is the SOL.";
            sw = rw;
            hw = r;
            reset = 0x0;
        } lane4_sol_0[15:0];
    } LVDS0_LANE4_SOL_01 @ 0x13B0;

    reg {
        name = "Lane 4 SOL synchronization code NE4_SOL_2 configuration register in LVDS or HiSPi 3 mode";
        desc = "LVDS0_LANE4_SOL_23 is a lane 4 SOL synchronization code configuration register in LVDS or HiSPi mode.

Data sheet 9.3.6 LVDS0_LANE4_SOL_23 (offset 0x13B4, printed page 9-305, `hi3516av200--Hi3516AV200-Datasheet.txt` line 54736).";

        field {
            name = "lane4_sol_3";
            desc = "Lane 4 SOL synchronization code of frame 3 in LVDS or HiSPi mode This field is configurable only in WDR mode, and the configuration is invalid in linear mode.";
            sw = rw;
            hw = r;
            reset = 0x0;
        } lane4_sol_3[31:16];

        field {
            name = "lane4_sol_2";
            desc = "Lane 4 SOL synchronization code of frame 2 in LVDS or HiSPi mode This field is configurable only in WDR mode, and the configuration is invalid in linear mode.";
            sw = rw;
            hw = r;
            reset = 0x0;
        } lane4_sol_2[15:0];
    } LVDS0_LANE4_SOL_23 @ 0x13B4;

    reg {
        name = "Lane 4 EOL synchronization code NE4_EOL_0 configuration register in LVDS or HiSPi 1 mode";
        desc = "LVDS0_LANE4_EOL_01 is a lane 4 EOL synchronization code configuration register in LVDS or HiSPi mode. Hi3516A V200 Professional HD IP Camera SoC

Data sheet 9.3.6 LVDS0_LANE4_EOL_01 (offset 0x13B8, printed page 9-306, `hi3516av200--Hi3516AV200-Datasheet.txt` line 54773).";

        field {
            name = "lane4_eol_1";
            desc = "Lane 4 EOL synchronization code of frame 1 in LVDS or HiSPi mode This field is configurable only in WDR mode, and the configuration is invalid in linear mode.";
            sw = rw;
            hw = r;
            reset = 0x0;
        } lane4_eol_1[31:16];

        field {
            name = "lane4_eol_0";
            desc = "Lane 4 EOL synchronization code of frame 0 in LVDS or HiSPi mode In WDR mode, the value is the EOL of frame 0. In linear mode, the value is the EOL.";
            sw = rw;
            hw = r;
            reset = 0x0;
        } lane4_eol_0[15:0];
    } LVDS0_LANE4_EOL_01 @ 0x13B8;

    reg {
        name = "Lane 4 EOL synchronization code NE4_EOL_2 configuration register in LVDS or HiSPi 3 mode";
        desc = "LVDS0_LANE4_EOL_23 is a lane 4 EOL synchronization code configuration register in LVDS or HiSPi mode.

Data sheet 9.3.6 LVDS0_LANE4_EOL_23 (offset 0x13BC, printed page 9-306, `hi3516av200--Hi3516AV200-Datasheet.txt` line 54801).";

        field {
            name = "lane4_eol_3";
            desc = "Lane 4 EOL synchronization code of frame 3 in LVDS or HiSPi mode This field is configurable only in WDR mode, and the configuration is invalid in linear mode.";
            sw = rw;
            hw = r;
            reset = 0x0;
        } lane4_eol_3[31:16];

        field {
            name = "lane4_eol_2";
            desc = "Lane 4 EOL synchronization code of frame 2 in LVDS or HiSPi mode This field is configurable only in WDR mode, and the configuration is invalid in linear mode.";
            sw = rw;
            hw = r;
            reset = 0x0;
        } lane4_eol_2[15:0];
    } LVDS0_LANE4_EOL_23 @ 0x13BC;

    reg {
        name = "Lane 5 SOF synchronization code NE5_SOF_0 configuration register in LVDS or HiSPi 1 mode";
        desc = "LVDS0_LANE5_SOF_01 is a lane 5 SOF synchronization code configuration register in LVDS or HiSPi mode. Hi3516A V200 Professional HD IP Camera SoC

Data sheet 9.3.6 LVDS0_LANE5_SOF_01 (offset 0x13C0, printed page 9-307, `hi3516av200--Hi3516AV200-Datasheet.txt` line 54838).";

        field {
            name = "lane5_sof_1";
            desc = "Lane 5 SOF synchronization code of frame 1 in LVDS or HiSPi mode This field is configurable only in WDR mode, and the configuration is invalid in linear mode.";
            sw = rw;
            hw = r;
            reset = 0x0;
        } lane5_sof_1[31:16];

        field {
            name = "lane5_sof_0";
            desc = "Lane 5 SOF synchronization code of frame 0 in LVDS or HiSPi mode In WDR mode, the value is the SOF of frame 0. In linear mode, the value is the SOF.";
            sw = rw;
            hw = r;
            reset = 0x0;
        } lane5_sof_0[15:0];
    } LVDS0_LANE5_SOF_01 @ 0x13C0;

    reg {
        name = "Lane 5 SOF synchronization code NE5_SOF_2 configuration register in LVDS or HiSPi 3 mode";
        desc = "LVDS0_LANE5_SOF_23 is a lane 5 SOF synchronization code configuration register in LVDS or HiSPi mode.

Data sheet 9.3.6 LVDS0_LANE5_SOF_23 (offset 0x13C4, printed page 9-307, `hi3516av200--Hi3516AV200-Datasheet.txt` line 54866).";

        field {
            name = "lane5_sof_3";
            desc = "Lane 5 SOF synchronization code of frame 3 in LVDS or HiSPi mode This field is configurable only in WDR mode, and the configuration is invalid in linear mode.";
            sw = rw;
            hw = r;
            reset = 0x0;
        } lane5_sof_3[31:16];

        field {
            name = "lane5_sof_2";
            desc = "Lane 5 SOF synchronization code of frame 2 in LVDS or HiSPi mode This field is configurable only in WDR mode, and the configuration is invalid in linear mode.";
            sw = rw;
            hw = r;
            reset = 0x0;
        } lane5_sof_2[15:0];
    } LVDS0_LANE5_SOF_23 @ 0x13C4;

    reg {
        name = "Lane 5 EOF synchronization code NE5_EOF_0 configuration register in LVDS or HiSPi 1 mode";
        desc = "LVDS0_LANE5_EOF_01 is a lane 5 EOF synchronization code configuration register in LVDS or HiSPi mode. Hi3516A V200 Professional HD IP Camera SoC

Data sheet 9.3.6 LVDS0_LANE5_EOF_01 (offset 0x13C8, printed page 9-308, `hi3516av200--Hi3516AV200-Datasheet.txt` line 54903).";

        field {
            name = "lane5_eof_1";
            desc = "Lane 5 EOF synchronization code of frame 1 in LVDS or HiSPi mode This field is configurable only in WDR mode, and the configuration is invalid in linear mode.";
            sw = rw;
            hw = r;
            reset = 0x0;
        } lane5_eof_1[31:16];

        field {
            name = "lane5_eof_0";
            desc = "Lane 5 EOF synchronization code of frame 0 in LVDS or HiSPi mode In WDR mode, the value is the EOF of frame 0. In linear mode, the value is the EOF.";
            sw = rw;
            hw = r;
            reset = 0x0;
        } lane5_eof_0[15:0];
    } LVDS0_LANE5_EOF_01 @ 0x13C8;

    reg {
        name = "Lane 5 EOF synchronization code NE5_EOF_2 configuration register in LVDS or HiSPi 3 mode";
        desc = "LVDS0_LANE5_EOF_23 is a lane 5 EOF synchronization code configuration register in LVDS or HiSPi mode.

Data sheet 9.3.6 LVDS0_LANE5_EOF_23 (offset 0x13CC, printed page 9-308, `hi3516av200--Hi3516AV200-Datasheet.txt` line 54931).";

        field {
            name = "lane5_eof_3";
            desc = "Lane 5 EOF synchronization code of frame 3 in LVDS or HiSPi mode This field is configurable only in WDR mode, and the configuration is invalid in linear mode.";
            sw = rw;
            hw = r;
            reset = 0x0;
        } lane5_eof_3[31:16];

        field {
            name = "lane5_eof_2";
            desc = "Lane 5 EOF synchronization code of frame 2 in LVDS or HiSPi mode This field is configurable only in WDR mode, and the configuration is invalid in linear mode.";
            sw = rw;
            hw = r;
            reset = 0x0;
        } lane5_eof_2[15:0];
    } LVDS0_LANE5_EOF_23 @ 0x13CC;

    reg {
        name = "Lane 5 SOL synchronization code NE5_SOL_0 configuration register in LVDS or HiSPi 1 mode";
        desc = "LVDS0_LANE5_SOL_01 is a lane 5 SOL synchronization code configuration register in LVDS or HiSPi mode. Hi3516A V200 Professional HD IP Camera SoC

Data sheet 9.3.6 LVDS0_LANE5_SOL_01 (offset 0x13D0, printed page 9-309, `hi3516av200--Hi3516AV200-Datasheet.txt` line 54968).";

        field {
            name = "lane5_sol_1";
            desc = "Lane 5 SOL synchronization code of frame 1 in LVDS or HiSPi mode This field is configurable only in WDR mode, and the configuration is invalid in linear mode.";
            sw = rw;
            hw = r;
            reset = 0x0;
        } lane5_sol_1[31:16];

        field {
            name = "lane5_sol_0";
            desc = "Lane 5 SOL synchronization code of frame 0 in LVDS or HiSPi mode In WDR mode, the value is the SOL of frame 0. In linear mode, the value is the SOL.";
            sw = rw;
            hw = r;
            reset = 0x0;
        } lane5_sol_0[15:0];
    } LVDS0_LANE5_SOL_01 @ 0x13D0;

    reg {
        name = "Lane 5 SOL synchronization code NE5_SOL_2 configuration register in LVDS or HiSPi 3 mode";
        desc = "LVDS0_LANE5_SOL_23 is a lane 5 SOL synchronization code configuration register in LVDS or HiSPi mode.

Data sheet 9.3.6 LVDS0_LANE5_SOL_23 (offset 0x13D4, printed page 9-309, `hi3516av200--Hi3516AV200-Datasheet.txt` line 54996).";

        field {
            name = "lane5_sol_3";
            desc = "Lane 5 SOL synchronization code of frame 3 in LVDS or HiSPi mode This field is configurable only in WDR mode, and the configuration is invalid in linear mode.";
            sw = rw;
            hw = r;
            reset = 0x0;
        } lane5_sol_3[31:16];

        field {
            name = "lane5_sol_2";
            desc = "Lane 5 SOL synchronization code of frame 2 in LVDS or HiSPi mode This field is configurable only in WDR mode, and the configuration is invalid in linear mode.";
            sw = rw;
            hw = r;
            reset = 0x0;
        } lane5_sol_2[15:0];
    } LVDS0_LANE5_SOL_23 @ 0x13D4;

    reg {
        name = "Lane 5 EOL synchronization code NE5_EOL_0 configuration register in LVDS or HiSPi 1 mode";
        desc = "LVDS0_LANE5_EOL_01 is a lane 5 EOL synchronization code configuration register in LVDS or HiSPi mode. Hi3516A V200 Professional HD IP Camera SoC

Data sheet 9.3.6 LVDS0_LANE5_EOL_01 (offset 0x13D8, printed page 9-310, `hi3516av200--Hi3516AV200-Datasheet.txt` line 55033).";

        field {
            name = "lane5_eol_1";
            desc = "Lane 5 EOL synchronization code of frame 1 in LVDS or HiSPi mode This field is configurable only in WDR mode, and the configuration is invalid in linear mode.";
            sw = rw;
            hw = r;
            reset = 0x0;
        } lane5_eol_1[31:16];

        field {
            name = "lane5_eol_0";
            desc = "Lane 5 EOL synchronization code of frame 0 in LVDS or HiSPi mode In WDR mode, the value is the EOL of frame 0. In linear mode, the value is the EOL.";
            sw = rw;
            hw = r;
            reset = 0x0;
        } lane5_eol_0[15:0];
    } LVDS0_LANE5_EOL_01 @ 0x13D8;

    reg {
        name = "Lane 5 EOL synchronization code NE5_EOL_2 configuration register in LVDS or HiSPi 3 mode";
        desc = "LVDS0_LANE5_EOL_23 is a lane 5 EOL synchronization code configuration register in LVDS or HiSPi mode.

Data sheet 9.3.6 LVDS0_LANE5_EOL_23 (offset 0x13DC, printed page 9-310, `hi3516av200--Hi3516AV200-Datasheet.txt` line 55061).";

        field {
            name = "lane5_eol_3";
            desc = "Lane 5 EOL synchronization code of frame 3 in LVDS or HiSPi mode This field is configurable only in WDR mode, and the configuration is invalid in linear mode.";
            sw = rw;
            hw = r;
            reset = 0x0;
        } lane5_eol_3[31:16];

        field {
            name = "lane5_eol_2";
            desc = "Lane 5 EOL synchronization code of frame 2 in LVDS or HiSPi mode This field is configurable only in WDR mode, and the configuration is invalid in linear mode.";
            sw = rw;
            hw = r;
            reset = 0x0;
        } lane5_eol_2[15:0];
    } LVDS0_LANE5_EOL_23 @ 0x13DC;

    reg {
        name = "Lane 6 SOF synchronization code NE6_SOF_0 configuration register in LVDS or HiSPi 1 mode";
        desc = "LVDS0_LANE6_SOF_01 is a lane 6 SOF synchronization code configuration register in LVDS or HiSPi mode. Hi3516A V200 Professional HD IP Camera SoC

Data sheet 9.3.6 LVDS0_LANE6_SOF_01 (offset 0x13E0, printed page 9-311, `hi3516av200--Hi3516AV200-Datasheet.txt` line 55098).";

        field {
            name = "lane6_sof_1";
            desc = "Lane 6 SOF synchronization code of frame 1 in LVDS or HiSPi mode This field is configurable only in WDR mode, and the configuration is invalid in linear mode.";
            sw = rw;
            hw = r;
            reset = 0x0;
        } lane6_sof_1[31:16];

        field {
            name = "lane6_sof_0";
            desc = "Lane 6 SOF synchronization code of frame 0 in LVDS or HiSPi mode In WDR mode, the value is the SOF of frame 0. In linear mode, the value is the SOF.";
            sw = rw;
            hw = r;
            reset = 0x0;
        } lane6_sof_0[15:0];
    } LVDS0_LANE6_SOF_01 @ 0x13E0;

    reg {
        name = "Lane 6 SOF synchronization code NE6_SOF_2 configuration register in LVDS or HiSPi 3 mode";
        desc = "LVDS0_LANE6_SOF_23 is a lane 6 SOF synchronization code configuration register in LVDS or HiSPi mode.

Data sheet 9.3.6 LVDS0_LANE6_SOF_23 (offset 0x13E4, printed page 9-311, `hi3516av200--Hi3516AV200-Datasheet.txt` line 55126).";

        field {
            name = "lane6_sof_3";
            desc = "Lane 6 SOF synchronization code of frame 3 in LVDS or HiSPi mode This field is configurable only in WDR mode, and the configuration is invalid in linear mode.";
            sw = rw;
            hw = r;
            reset = 0x0;
        } lane6_sof_3[31:16];

        field {
            name = "lane6_sof_2";
            desc = "Lane 6 SOF synchronization code of frame 2 in LVDS or HiSPi mode This field is configurable only in WDR mode, and the configuration is invalid in linear mode.";
            sw = rw;
            hw = r;
            reset = 0x0;
        } lane6_sof_2[15:0];
    } LVDS0_LANE6_SOF_23 @ 0x13E4;

    reg {
        name = "Lane 6 EOF synchronization code NE6_EOF_0 configuration register in LVDS or HiSPi 1 mode";
        desc = "LVDS0_LANE6_EOF_01 is a lane 6 EOF synchronization code configuration register in LVDS or HiSPi mode. Hi3516A V200 Professional HD IP Camera SoC

Data sheet 9.3.6 LVDS0_LANE6_EOF_01 (offset 0x13E8, printed page 9-312, `hi3516av200--Hi3516AV200-Datasheet.txt` line 55163).";

        field {
            name = "lane6_eof_1";
            desc = "Lane 6 EOF synchronization code of frame 1 in LVDS or HiSPi mode This field is configurable only in WDR mode, and the configuration is invalid in linear mode.";
            sw = rw;
            hw = r;
            reset = 0x0;
        } lane6_eof_1[31:16];

        field {
            name = "lane6_eof_0";
            desc = "Lane 6 EOF synchronization code of frame 0 in LVDS or HiSPi mode In WDR mode, the value is the EOF of frame 0. In linear mode, the value is the EOF.";
            sw = rw;
            hw = r;
            reset = 0x0;
        } lane6_eof_0[15:0];
    } LVDS0_LANE6_EOF_01 @ 0x13E8;

    reg {
        name = "Lane 6 EOF synchronization code NE6_EOF_2 configuration register in LVDS or HiSPi 3 mode";
        desc = "LVDS0_LANE6_EOF_23 is a lane 6 EOF synchronization code configuration register in LVDS or HiSPi mode.

Data sheet 9.3.6 LVDS0_LANE6_EOF_23 (offset 0x13EC, printed page 9-312, `hi3516av200--Hi3516AV200-Datasheet.txt` line 55191).";

        field {
            name = "lane6_eof_3";
            desc = "Lane 6 EOF synchronization code of frame 3 in LVDS or HiSPi mode This field is configurable only in WDR mode, and the configuration is invalid in linear mode.";
            sw = rw;
            hw = r;
            reset = 0x0;
        } lane6_eof_3[31:16];

        field {
            name = "lane6_eof_2";
            desc = "Lane 6 EOF synchronization code of frame 2 in LVDS or HiSPi mode This field is configurable only in WDR mode, and the configuration is invalid in linear mode.";
            sw = rw;
            hw = r;
            reset = 0x0;
        } lane6_eof_2[15:0];
    } LVDS0_LANE6_EOF_23 @ 0x13EC;

    reg {
        name = "Lane 6 SOL synchronization code NE6_SOL_0 configuration register in LVDS or HiSPi 1 mode";
        desc = "LVDS0_LANE6_SOL_01 is a lane 6 SOL synchronization code configuration register in LVDS or HiSPi mode. Hi3516A V200 Professional HD IP Camera SoC

Data sheet 9.3.6 LVDS0_LANE6_SOL_01 (offset 0x13F0, printed page 9-313, `hi3516av200--Hi3516AV200-Datasheet.txt` line 55228).";

        field {
            name = "lane6_sol_1";
            desc = "Lane 6 SOL synchronization code of frame 1 in LVDS or HiSPi mode This field is configurable only in WDR mode, and the configuration is invalid in linear mode.";
            sw = rw;
            hw = r;
            reset = 0x0;
        } lane6_sol_1[31:16];

        field {
            name = "lane6_sol_0";
            desc = "Lane 6 SOL synchronization code of frame 0 in LVDS or HiSPi mode In WDR mode, the value is the SOL of frame 0. In linear mode, the value is the SOL.";
            sw = rw;
            hw = r;
            reset = 0x0;
        } lane6_sol_0[15:0];
    } LVDS0_LANE6_SOL_01 @ 0x13F0;

    reg {
        name = "Lane 6 SOL synchronization code NE6_SOL_2 configuration register in LVDS or HiSPi 3 mode";
        desc = "LVDS0_LANE6_SOL_23 is a lane 6 SOL synchronization code configuration register in LVDS or HiSPi mode.

Data sheet 9.3.6 LVDS0_LANE6_SOL_23 (offset 0x13F4, printed page 9-313, `hi3516av200--Hi3516AV200-Datasheet.txt` line 55256).";

        field {
            name = "lane6_sol_3";
            desc = "Lane 6 SOL synchronization code of frame 3 in LVDS or HiSPi mode This field is configurable only in WDR mode, and the configuration is invalid in linear mode.";
            sw = rw;
            hw = r;
            reset = 0x0;
        } lane6_sol_3[31:16];

        field {
            name = "lane6_sol_2";
            desc = "Lane 6 SOL synchronization code of frame 2 in LVDS or HiSPi mode This field is configurable only in WDR mode, and the configuration is invalid in linear mode.";
            sw = rw;
            hw = r;
            reset = 0x0;
        } lane6_sol_2[15:0];
    } LVDS0_LANE6_SOL_23 @ 0x13F4;

    reg {
        name = "Lane 6 EOL synchronization code NE6_EOL_0 configuration register in LVDS or HiSPi 1 mode";
        desc = "LVDS0_LANE6_EOL_01 is a lane 6 EOL synchronization code configuration register in LVDS or HiSPi mode. Hi3516A V200 Professional HD IP Camera SoC

Data sheet 9.3.6 LVDS0_LANE6_EOL_01 (offset 0x13F8, printed page 9-314, `hi3516av200--Hi3516AV200-Datasheet.txt` line 55293).";

        field {
            name = "lane6_eol_1";
            desc = "Lane 6 EOL synchronization code of frame 1 in LVDS or HiSPi mode This field is configurable only in WDR mode, and the configuration is invalid in linear mode.";
            sw = rw;
            hw = r;
            reset = 0x0;
        } lane6_eol_1[31:16];

        field {
            name = "lane6_eol_0";
            desc = "Lane 6 EOL synchronization code of frame 0 in LVDS or HiSPi mode In WDR mode, the value is the EOL of frame 0. In linear mode, the value is the EOL.";
            sw = rw;
            hw = r;
            reset = 0x0;
        } lane6_eol_0[15:0];
    } LVDS0_LANE6_EOL_01 @ 0x13F8;

    reg {
        name = "Lane 6 EOL synchronization code NE6_EOL_2 configuration register in LVDS or HiSPi 3 mode";
        desc = "LVDS0_LANE6_EOL_23 is a lane 6 EOL synchronization code configuration register in LVDS or HiSPi mode.

Data sheet 9.3.6 LVDS0_LANE6_EOL_23 (offset 0x13FC, printed page 9-314, `hi3516av200--Hi3516AV200-Datasheet.txt` line 55321).";

        field {
            name = "lane6_eol_3";
            desc = "Lane 6 EOL synchronization code of frame 3 in LVDS or HiSPi mode This field is configurable only in WDR mode, and the configuration is invalid in linear mode.";
            sw = rw;
            hw = r;
            reset = 0x0;
        } lane6_eol_3[31:16];

        field {
            name = "lane6_eol_2";
            desc = "Lane 6 EOL synchronization code of frame 2 in LVDS or HiSPi mode This field is configurable only in WDR mode, and the configuration is invalid in linear mode.";
            sw = rw;
            hw = r;
            reset = 0x0;
        } lane6_eol_2[15:0];
    } LVDS0_LANE6_EOL_23 @ 0x13FC;

    reg {
        name = "Lane 7 SOF synchronization code NE7_SOF_0 configuration register in LVDS or HiSPi 1 mode";
        desc = "LVDS0_LANE7_SOF_01 is a lane 7 SOF synchronization code configuration register in LVDS or HiSPi mode. Hi3516A V200 Professional HD IP Camera SoC

Data sheet 9.3.6 LVDS0_LANE7_SOF_01 (offset 0x1400, printed page 9-315, `hi3516av200--Hi3516AV200-Datasheet.txt` line 55358).";

        field {
            name = "lane7_sof_1";
            desc = "Lane 7 SOF synchronization code of frame 1 in LVDS or HiSPi mode This field is configurable only in WDR mode, and the configuration is invalid in linear mode.";
            sw = rw;
            hw = r;
            reset = 0x0;
        } lane7_sof_1[31:16];

        field {
            name = "lane7_sof_0";
            desc = "Lane 7 SOF synchronization code of frame 0 in LVDS or HiSPi mode In WDR mode, the value is the SOF of frame 0. In linear mode, the value is the SOF.";
            sw = rw;
            hw = r;
            reset = 0x0;
        } lane7_sof_0[15:0];
    } LVDS0_LANE7_SOF_01 @ 0x1400;

    reg {
        name = "Lane 7 SOF synchronization code NE7_SOF_2 configuration register in LVDS or HiSPi 3 mode";
        desc = "LVDS0_LANE7_SOF_23 is a lane 7 SOF synchronization code configuration register in LVDS or HiSPi mode.

Data sheet 9.3.6 LVDS0_LANE7_SOF_23 (offset 0x1404, printed page 9-315, `hi3516av200--Hi3516AV200-Datasheet.txt` line 55386).";

        field {
            name = "lane7_sof_3";
            desc = "Lane 7 SOF synchronization code of frame 3 in LVDS or HiSPi mode This field is configurable only in WDR mode, and the configuration is invalid in linear mode.";
            sw = rw;
            hw = r;
            reset = 0x0;
        } lane7_sof_3[31:16];

        field {
            name = "lane7_sof_2";
            desc = "Lane 7 SOF synchronization code of frame 2 in LVDS or HiSPi mode This field is configurable only in WDR mode, and the configuration is invalid in linear mode.";
            sw = rw;
            hw = r;
            reset = 0x0;
        } lane7_sof_2[15:0];
    } LVDS0_LANE7_SOF_23 @ 0x1404;

    reg {
        name = "Lane 7 EOF synchronization code NE7_EOF_0 configuration register in LVDS or HiSPi 1 mode";
        desc = "LVDS0_LANE7_EOF_01 is a lane 7 EOF synchronization code configuration register in LVDS or HiSPi mode. Hi3516A V200 Professional HD IP Camera SoC

Data sheet 9.3.6 LVDS0_LANE7_EOF_01 (offset 0x1408, printed page 9-316, `hi3516av200--Hi3516AV200-Datasheet.txt` line 55423).";

        field {
            name = "lane7_eof_1";
            desc = "Lane 7 EOF synchronization code of frame 1 in LVDS or HiSPi mode This field is configurable only in WDR mode, and the configuration is invalid in linear mode.";
            sw = rw;
            hw = r;
            reset = 0x0;
        } lane7_eof_1[31:16];

        field {
            name = "lane7_eof_0";
            desc = "Lane 7 EOF synchronization code of frame 0 in LVDS or HiSPi mode In WDR mode, the value is the EOF of frame 0. In linear mode, the value is the EOF.";
            sw = rw;
            hw = r;
            reset = 0x0;
        } lane7_eof_0[15:0];
    } LVDS0_LANE7_EOF_01 @ 0x1408;

    reg {
        name = "Lane 7 EOF synchronization code NE7_EOF_2 configuration register in LVDS or HiSPi 3 mode";
        desc = "LVDS0_LANE7_EOF_23 is a lane 7 EOF synchronization code configuration register in LVDS or HiSPi mode.

Data sheet 9.3.6 LVDS0_LANE7_EOF_23 (offset 0x140C, printed page 9-316, `hi3516av200--Hi3516AV200-Datasheet.txt` line 55451).";

        field {
            name = "lane7_eof_3";
            desc = "Lane 7 EOF synchronization code of frame 3 in LVDS or HiSPi mode This field is configurable only in WDR mode, and the configuration is invalid in linear mode.";
            sw = rw;
            hw = r;
            reset = 0x0;
        } lane7_eof_3[31:16];

        field {
            name = "lane7_eof_2";
            desc = "Lane 7 EOF synchronization code of frame 2 in LVDS or HiSPi mode This field is configurable only in WDR mode, and the configuration is invalid in linear mode.";
            sw = rw;
            hw = r;
            reset = 0x0;
        } lane7_eof_2[15:0];
    } LVDS0_LANE7_EOF_23 @ 0x140C;

    reg {
        name = "Lane 7 SOL synchronization code NE7_SOL_0 configuration register in LVDS or HiSPi 1 mode";
        desc = "LVDS0_LANE7_SOL_01 is a lane 7 SOL synchronization code configuration register in LVDS or HiSPi mode. Hi3516A V200 Professional HD IP Camera SoC

Data sheet 9.3.6 LVDS0_LANE7_SOL_01 (offset 0x1410, printed page 9-317, `hi3516av200--Hi3516AV200-Datasheet.txt` line 55488).";

        field {
            name = "lane7_sol_1";
            desc = "Lane 7 SOL synchronization code of frame 1 in LVDS or HiSPi mode This field is configurable only in WDR mode, and the configuration is invalid in linear mode.";
            sw = rw;
            hw = r;
            reset = 0x0;
        } lane7_sol_1[31:16];

        field {
            name = "lane7_sol_0";
            desc = "Lane 7 SOL synchronization code of frame 0 in LVDS or HiSPi mode In WDR mode, the value is the SOL of frame 0. In linear mode, the value is the SOL.";
            sw = rw;
            hw = r;
            reset = 0x0;
        } lane7_sol_0[15:0];
    } LVDS0_LANE7_SOL_01 @ 0x1410;

    reg {
        name = "Lane 7 SOL synchronization code NE7_SOL_2 configuration register in LVDS or HiSPi 3 mode";
        desc = "LVDS0_LANE7_SOL_23 is a lane 7 SOL synchronization code configuration register in LVDS or HiSPi mode.

Data sheet 9.3.6 LVDS0_LANE7_SOL_23 (offset 0x1414, printed page 9-317, `hi3516av200--Hi3516AV200-Datasheet.txt` line 55516).";

        field {
            name = "lane7_sol_3";
            desc = "Lane 7 SOL synchronization code of frame 3 in LVDS or HiSPi mode This field is configurable only in WDR mode, and the configuration is invalid in linear mode.";
            sw = rw;
            hw = r;
            reset = 0x0;
        } lane7_sol_3[31:16];

        field {
            name = "lane7_sol_2";
            desc = "Lane 7 SOL synchronization code of frame 2 in LVDS or HiSPi mode This field is configurable only in WDR mode, and the configuration is invalid in linear mode.";
            sw = rw;
            hw = r;
            reset = 0x0;
        } lane7_sol_2[15:0];
    } LVDS0_LANE7_SOL_23 @ 0x1414;

    reg {
        name = "Lane 7 EOL synchronization code NE7_EOL_0 configuration register in LVDS or HiSPi 1 mode";
        desc = "LVDS0_LANE7_EOL_01 is a lane 7 EOL synchronization code configuration register in LVDS or HiSPi mode. Hi3516A V200 Professional HD IP Camera SoC

Data sheet 9.3.6 LVDS0_LANE7_EOL_01 (offset 0x1418, printed page 9-318, `hi3516av200--Hi3516AV200-Datasheet.txt` line 55553).";

        field {
            name = "lane7_eol_1";
            desc = "Lane 7 EOL synchronization code of frame 1 in LVDS or HiSPi mode This field is configurable only in WDR mode, and the configuration is invalid in linear mode.";
            sw = rw;
            hw = r;
            reset = 0x0;
        } lane7_eol_1[31:16];

        field {
            name = "lane7_eol_0";
            desc = "Lane 7 EOL synchronization code of frame 0 in LVDS or HiSPi mode In WDR mode, the value is the EOL of frame 0. In linear mode, the value is the EOL.";
            sw = rw;
            hw = r;
            reset = 0x0;
        } lane7_eol_0[15:0];
    } LVDS0_LANE7_EOL_01 @ 0x1418;

    reg {
        name = "Lane 7 EOL synchronization code NE7_EOL_2 configuration register in LVDS or HiSPi 3 mode";
        desc = "LVDS0_LANE7_EOL_23 is a lane 7 EOL synchronization code configuration register in LVDS or HiSPi mode.

Data sheet 9.3.6 LVDS0_LANE7_EOL_23 (offset 0x141C, printed page 9-318, `hi3516av200--Hi3516AV200-Datasheet.txt` line 55581).";

        field {
            name = "lane7_eol_3";
            desc = "Lane 7 EOL synchronization code of frame 3 in LVDS or HiSPi mode This field is configurable only in WDR mode, and the configuration is invalid in linear mode.";
            sw = rw;
            hw = r;
            reset = 0x0;
        } lane7_eol_3[31:16];

        field {
            name = "lane7_eol_2";
            desc = "Lane 7 EOL synchronization code of frame 2 in LVDS or HiSPi mode This field is configurable only in WDR mode, and the configuration is invalid in linear mode.";
            sw = rw;
            hw = r;
            reset = 0x0;
        } lane7_eol_2[15:0];
    } LVDS0_LANE7_EOL_23 @ 0x141C;

    reg {
        name = "Lane 8 SOF synchronization code NE8_SOF_0 configuration register in LVDS or HiSPi 1 mode";
        desc = "LVDS0_LANE8_SOF_01 is a lane 8 SOF synchronization code configuration register in LVDS or HiSPi mode. Hi3516A V200 Professional HD IP Camera SoC

Data sheet 9.3.6 LVDS0_LANE8_SOF_01 (offset 0x1420, printed page 9-319, `hi3516av200--Hi3516AV200-Datasheet.txt` line 55618).";

        field {
            name = "lane8_sof_1";
            desc = "Lane 8 SOF synchronization code of frame 1 in LVDS or HiSPi mode This field is configurable only in WDR mode, and the configuration is invalid in linear mode.";
            sw = rw;
            hw = r;
            reset = 0x0;
        } lane8_sof_1[31:16];

        field {
            name = "lane8_sof_0";
            desc = "Lane 8 SOF synchronization code of frame 0 in LVDS or HiSPi mode In WDR mode, the value is the SOF of frame 0. In linear mode, the value is the SOF.";
            sw = rw;
            hw = r;
            reset = 0x0;
        } lane8_sof_0[15:0];
    } LVDS0_LANE8_SOF_01 @ 0x1420;

    reg {
        name = "Lane 8 SOF synchronization code NE8_SOF_2 configuration register in LVDS or HiSPi 3 mode";
        desc = "LVDS0_LANE8_SOF_23 is a lane 8 SOF synchronization code configuration register in LVDS or HiSPi mode.

Data sheet 9.3.6 LVDS0_LANE8_SOF_23 (offset 0x1424, printed page 9-319, `hi3516av200--Hi3516AV200-Datasheet.txt` line 55646).";

        field {
            name = "lane8_sof_3";
            desc = "Lane 8 SOF synchronization code of frame 3 in LVDS or HiSPi mode This field is configurable only in WDR mode, and the configuration is invalid in linear mode.";
            sw = rw;
            hw = r;
            reset = 0x0;
        } lane8_sof_3[31:16];

        field {
            name = "lane8_sof_2";
            desc = "Lane 8 SOF synchronization code of frame 2 in LVDS or HiSPi mode This field is configurable only in WDR mode, and the configuration is invalid in linear mode.";
            sw = rw;
            hw = r;
            reset = 0x0;
        } lane8_sof_2[15:0];
    } LVDS0_LANE8_SOF_23 @ 0x1424;

    reg {
        name = "Lane 8 EOF synchronization code NE8_EOF_0 configuration register in LVDS or HiSPi 1 mode";
        desc = "LVDS0_LANE8_EOF_01 is a lane 8 EOF synchronization code configuration register in LVDS or HiSPi mode. Hi3516A V200 Professional HD IP Camera SoC

Data sheet 9.3.6 LVDS0_LANE8_EOF_01 (offset 0x1428, printed page 9-320, `hi3516av200--Hi3516AV200-Datasheet.txt` line 55683).";

        field {
            name = "lane8_eof_1";
            desc = "Lane 8 EOF synchronization code of frame 1 in LVDS or HiSPi mode This field is configurable only in WDR mode, and the configuration is invalid in linear mode.";
            sw = rw;
            hw = r;
            reset = 0x0;
        } lane8_eof_1[31:16];

        field {
            name = "lane8_eof_0";
            desc = "Lane 8 EOF synchronization code of frame 0 in LVDS or HiSPi mode In WDR mode, the value is the EOF of frame 0. In linear mode, the value is the EOF.";
            sw = rw;
            hw = r;
            reset = 0x0;
        } lane8_eof_0[15:0];
    } LVDS0_LANE8_EOF_01 @ 0x1428;

    reg {
        name = "Lane 8 EOF synchronization code NE8_EOF_2 configuration register in LVDS or HiSPi 3 mode";
        desc = "LVDS0_LANE8_EOF_23 is a lane 8 EOF synchronization code configuration register in LVDS or HiSPi mode.

Data sheet 9.3.6 LVDS0_LANE8_EOF_23 (offset 0x142C, printed page 9-320, `hi3516av200--Hi3516AV200-Datasheet.txt` line 55711).";

        field {
            name = "lane8_eof_3";
            desc = "Lane 8 EOF synchronization code of frame 3 in LVDS or HiSPi mode This field is configurable only in WDR mode, and the configuration is invalid in linear mode.";
            sw = rw;
            hw = r;
            reset = 0x0;
        } lane8_eof_3[31:16];

        field {
            name = "lane8_eof_2";
            desc = "Lane 8 EOF synchronization code of frame 2 in LVDS or HiSPi mode This field is configurable only in WDR mode, and the configuration is invalid in linear mode.";
            sw = rw;
            hw = r;
            reset = 0x0;
        } lane8_eof_2[15:0];
    } LVDS0_LANE8_EOF_23 @ 0x142C;

    reg {
        name = "Lane 8 SOL synchronization code NE8_SOL_0 configuration register in LVDS or HiSPi 1 mode";
        desc = "LVDS0_LANE8_SOL_01 is a lane 8 SOL synchronization code configuration register in LVDS or HiSPi mode. Hi3516A V200 Professional HD IP Camera SoC

Data sheet 9.3.6 LVDS0_LANE8_SOL_01 (offset 0x1430, printed page 9-321, `hi3516av200--Hi3516AV200-Datasheet.txt` line 55748).";

        field {
            name = "lane8_sol_1";
            desc = "Lane 8 SOL synchronization code of frame 1 in LVDS or HiSPi mode This field is configurable only in WDR mode, and the configuration is invalid in linear mode.";
            sw = rw;
            hw = r;
            reset = 0x0;
        } lane8_sol_1[31:16];

        field {
            name = "lane8_sol_0";
            desc = "Lane 8 SOL synchronization code of frame 0 in LVDS or HiSPi mode In WDR mode, the value is the SOL of frame 0. In linear mode, the value is the SOL.";
            sw = rw;
            hw = r;
            reset = 0x0;
        } lane8_sol_0[15:0];
    } LVDS0_LANE8_SOL_01 @ 0x1430;

    reg {
        name = "Lane 8 SOL synchronization code NE8_SOL_2 configuration register in LVDS or HiSPi 3 mode";
        desc = "LVDS0_LANE8_SOL_23 is a lane 8 SOL synchronization code configuration register in LVDS or HiSPi mode.

Data sheet 9.3.6 LVDS0_LANE8_SOL_23 (offset 0x1434, printed page 9-321, `hi3516av200--Hi3516AV200-Datasheet.txt` line 55776).";

        field {
            name = "lane8_sol_3";
            desc = "Lane 8 SOL synchronization code of frame 3 in LVDS or HiSPi mode This field is configurable only in WDR mode, and the configuration is invalid in linear mode.";
            sw = rw;
            hw = r;
            reset = 0x0;
        } lane8_sol_3[31:16];

        field {
            name = "lane8_sol_2";
            desc = "Lane 8 SOL synchronization code of frame 2 in LVDS or HiSPi mode This field is configurable only in WDR mode, and the configuration is invalid in linear mode.";
            sw = rw;
            hw = r;
            reset = 0x0;
        } lane8_sol_2[15:0];
    } LVDS0_LANE8_SOL_23 @ 0x1434;

    reg {
        name = "Lane 8 EOL synchronization code NE8_EOL_0 configuration register in LVDS or HiSPi 1 mode";
        desc = "LVDS0_LANE8_EOL_01 is a lane 8 EOL synchronization code configuration register in LVDS or HiSPi mode. Hi3516A V200 Professional HD IP Camera SoC

Data sheet 9.3.6 LVDS0_LANE8_EOL_01 (offset 0x1438, printed page 9-322, `hi3516av200--Hi3516AV200-Datasheet.txt` line 55813).";

        field {
            name = "lane8_eol_1";
            desc = "Lane 8 EOL synchronization code of frame 1 in LVDS or HiSPi mode This field is configurable only in WDR mode, and the configuration is invalid in linear mode.";
            sw = rw;
            hw = r;
            reset = 0x0;
        } lane8_eol_1[31:16];

        field {
            name = "lane8_eol_0";
            desc = "Lane 8 EOL synchronization code of frame 0 in LVDS or HiSPi mode In WDR mode, the value is the EOL of frame 0. In linear mode, the value is the EOL.";
            sw = rw;
            hw = r;
            reset = 0x0;
        } lane8_eol_0[15:0];
    } LVDS0_LANE8_EOL_01 @ 0x1438;

    reg {
        name = "Lane 8 EOL synchronization code NE8_EOL_2 configuration register in LVDS or HiSPi 3 mode";
        desc = "LVDS0_LANE8_EOL_23 is a lane 8 EOL synchronization code configuration register in LVDS or HiSPi mode.

Data sheet 9.3.6 LVDS0_LANE8_EOL_23 (offset 0x143C, printed page 9-322, `hi3516av200--Hi3516AV200-Datasheet.txt` line 55841).";

        field {
            name = "lane8_eol_3";
            desc = "Lane 8 EOL synchronization code of frame 3 in LVDS or HiSPi mode This field is configurable only in WDR mode, and the configuration is invalid in linear mode.";
            sw = rw;
            hw = r;
            reset = 0x0;
        } lane8_eol_3[31:16];

        field {
            name = "lane8_eol_2";
            desc = "Lane 8 EOL synchronization code of frame 2 in LVDS or HiSPi mode This field is configurable only in WDR mode, and the configuration is invalid in linear mode.";
            sw = rw;
            hw = r;
            reset = 0x0;
        } lane8_eol_2[15:0];
    } LVDS0_LANE8_EOL_23 @ 0x143C;

    reg {
        name = "Lane 9 SOF synchronization code NE9_SOF_0 configuration register in LVDS or HiSPi 1 mode";
        desc = "LVDS0_LANE9_SOF_01 is a lane 9 SOF synchronization code configuration register in LVDS or HiSPi mode. Hi3516A V200 Professional HD IP Camera SoC

Data sheet 9.3.6 LVDS0_LANE9_SOF_01 (offset 0x1440, printed page 9-323, `hi3516av200--Hi3516AV200-Datasheet.txt` line 55878).";

        field {
            name = "lane9_sof_1";
            desc = "Lane 9 SOF synchronization code of frame 1 in LVDS or HiSPi mode This field is configurable only in WDR mode, and the configuration is invalid in linear mode.";
            sw = rw;
            hw = r;
            reset = 0x0;
        } lane9_sof_1[31:16];

        field {
            name = "lane9_sof_0";
            desc = "Lane 9 SOF synchronization code of frame 0 in LVDS or HiSPi mode In WDR mode, the value is the SOF of frame 0. In linear mode, the value is the SOF.";
            sw = rw;
            hw = r;
            reset = 0x0;
        } lane9_sof_0[15:0];
    } LVDS0_LANE9_SOF_01 @ 0x1440;

    reg {
        name = "Lane 9 SOF synchronization code NE9_SOF_2 configuration register in LVDS or HiSPi 3 mode";
        desc = "LVDS0_LANE9_SOF_23 is a lane 9 SOF synchronization code configuration register in LVDS or HiSPi mode.

Data sheet 9.3.6 LVDS0_LANE9_SOF_23 (offset 0x1444, printed page 9-323, `hi3516av200--Hi3516AV200-Datasheet.txt` line 55906).";

        field {
            name = "lane9_sof_3";
            desc = "Lane 9 SOF synchronization code of frame 3 in LVDS or HiSPi mode This field is configurable only in WDR mode, and the configuration is invalid in linear mode.";
            sw = rw;
            hw = r;
            reset = 0x0;
        } lane9_sof_3[31:16];

        field {
            name = "lane9_sof_2";
            desc = "Lane 9 SOF synchronization code of frame 2 in LVDS or HiSPi mode This field is configurable only in WDR mode, and the configuration is invalid in linear mode.";
            sw = rw;
            hw = r;
            reset = 0x0;
        } lane9_sof_2[15:0];
    } LVDS0_LANE9_SOF_23 @ 0x1444;

    reg {
        name = "Lane 9 EOF synchronization code NE9_EOF_0 configuration register in LVDS or HiSPi 1 mode";
        desc = "LVDS0_LANE9_EOF_01 is a lane 9 EOF synchronization code configuration register in LVDS or HiSPi mode. Hi3516A V200 Professional HD IP Camera SoC

Data sheet 9.3.6 LVDS0_LANE9_EOF_01 (offset 0x1448, printed page 9-324, `hi3516av200--Hi3516AV200-Datasheet.txt` line 55943).";

        field {
            name = "lane9_eof_1";
            desc = "Lane 9 EOF synchronization code of frame 1 in LVDS or HiSPi mode This field is configurable only in WDR mode, and the configuration is invalid in linear mode.";
            sw = rw;
            hw = r;
            reset = 0x0;
        } lane9_eof_1[31:16];

        field {
            name = "lane9_eof_0";
            desc = "Lane 9 EOF synchronization code of frame 0 in LVDS or HiSPi mode In WDR mode, the value is the EOF of frame 0. In linear mode, the value is the EOF.";
            sw = rw;
            hw = r;
            reset = 0x0;
        } lane9_eof_0[15:0];
    } LVDS0_LANE9_EOF_01 @ 0x1448;

    reg {
        name = "Lane 9 EOF synchronization code NE9_EOF_2 configuration register in LVDS or HiSPi 3 mode";
        desc = "LVDS0_LANE9_EOF_23 is a lane 9 EOF synchronization code configuration register in LVDS or HiSPi mode.

Data sheet 9.3.6 LVDS0_LANE9_EOF_23 (offset 0x144C, printed page 9-324, `hi3516av200--Hi3516AV200-Datasheet.txt` line 55971).";

        field {
            name = "lane9_eof_3";
            desc = "Lane 9 EOF synchronization code of frame 3 in LVDS or HiSPi mode This field is configurable only in WDR mode, and the configuration is invalid in linear mode.";
            sw = rw;
            hw = r;
            reset = 0x0;
        } lane9_eof_3[31:16];

        field {
            name = "lane9_eof_2";
            desc = "Lane 9 EOF synchronization code of frame 2 in LVDS or HiSPi mode This field is configurable only in WDR mode, and the configuration is invalid in linear mode.";
            sw = rw;
            hw = r;
            reset = 0x0;
        } lane9_eof_2[15:0];
    } LVDS0_LANE9_EOF_23 @ 0x144C;

    reg {
        name = "Lane 9 SOL synchronization code NE9_SOL_0 configuration register in LVDS or HiSPi 1 mode";
        desc = "LVDS0_LANE9_SOL_01 is a lane 9 SOL synchronization code configuration register in LVDS or HiSPi mode. Hi3516A V200 Professional HD IP Camera SoC

Data sheet 9.3.6 LVDS0_LANE9_SOL_01 (offset 0x1450, printed page 9-325, `hi3516av200--Hi3516AV200-Datasheet.txt` line 56008).";

        field {
            name = "lane9_sol_1";
            desc = "Lane 9 SOL synchronization code of frame 1 in LVDS or HiSPi mode This field is configurable only in WDR mode, and the configuration is invalid in linear mode.";
            sw = rw;
            hw = r;
            reset = 0x0;
        } lane9_sol_1[31:16];

        field {
            name = "lane9_sol_0";
            desc = "Lane 9 SOL synchronization code of frame 0 in LVDS or HiSPi mode In WDR mode, the value is the SOL of frame 0. In linear mode, the value is the SOL.";
            sw = rw;
            hw = r;
            reset = 0x0;
        } lane9_sol_0[15:0];
    } LVDS0_LANE9_SOL_01 @ 0x1450;

    reg {
        name = "Lane 9 SOL synchronization code NE9_SOL_2 configuration register in LVDS or HiSPi 3 mode";
        desc = "LVDS0_LANE9_SOL_23 is a lane 9 SOL synchronization code configuration register in LVDS or HiSPi mode.

Data sheet 9.3.6 LVDS0_LANE9_SOL_23 (offset 0x1454, printed page 9-325, `hi3516av200--Hi3516AV200-Datasheet.txt` line 56036).";

        field {
            name = "lane9_sol_3";
            desc = "Lane 9 SOL synchronization code of frame 3 in LVDS or HiSPi mode This field is configurable only in WDR mode, and the configuration is invalid in linear mode.";
            sw = rw;
            hw = r;
            reset = 0x0;
        } lane9_sol_3[31:16];

        field {
            name = "lane9_sol_2";
            desc = "Lane 9 SOL synchronization code of frame 2 in LVDS or HiSPi mode This field is configurable only in WDR mode, and the configuration is invalid in linear mode.";
            sw = rw;
            hw = r;
            reset = 0x0;
        } lane9_sol_2[15:0];
    } LVDS0_LANE9_SOL_23 @ 0x1454;

    reg {
        name = "Lane 9 EOL synchronization code NE9_EOL_0 configuration register in LVDS or HiSPi 1 mode";
        desc = "LVDS0_LANE9_EOL_01 is a lane 9 EOL synchronization code configuration register in LVDS or HiSPi mode. Hi3516A V200 Professional HD IP Camera SoC

Data sheet 9.3.6 LVDS0_LANE9_EOL_01 (offset 0x1458, printed page 9-326, `hi3516av200--Hi3516AV200-Datasheet.txt` line 56073).";

        field {
            name = "lane9_eol_1";
            desc = "Lane 9 EOL synchronization code of frame 1 in LVDS or HiSPi mode This field is configurable only in WDR mode, and the configuration is invalid in linear mode.";
            sw = rw;
            hw = r;
            reset = 0x0;
        } lane9_eol_1[31:16];

        field {
            name = "lane9_eol_0";
            desc = "Lane 9 EOL synchronization code of frame 0 in LVDS or HiSPi mode In WDR mode, the value is the EOL of frame 0. In linear mode, the value is the EOL.";
            sw = rw;
            hw = r;
            reset = 0x0;
        } lane9_eol_0[15:0];
    } LVDS0_LANE9_EOL_01 @ 0x1458;

    reg {
        name = "Lane 9 EOL synchronization code NE9_EOL_2 configuration register in LVDS or HiSPi 3 mode";
        desc = "LVDS0_LANE9_EOL_23 is a lane 9 EOL synchronization code configuration register in LVDS or HiSPi mode.

Data sheet 9.3.6 LVDS0_LANE9_EOL_23 (offset 0x145C, printed page 9-326, `hi3516av200--Hi3516AV200-Datasheet.txt` line 56101).";

        field {
            name = "lane9_eol_3";
            desc = "Lane 9 EOL synchronization code of frame 3 in LVDS or HiSPi mode This field is configurable only in WDR mode, and the configuration is invalid in linear mode.";
            sw = rw;
            hw = r;
            reset = 0x0;
        } lane9_eol_3[31:16];

        field {
            name = "lane9_eol_2";
            desc = "Lane 9 EOL synchronization code of frame 2 in LVDS or HiSPi mode This field is configurable only in WDR mode, and the configuration is invalid in linear mode.";
            sw = rw;
            hw = r;
            reset = 0x0;
        } lane9_eol_2[15:0];
    } LVDS0_LANE9_EOL_23 @ 0x145C;

    reg {
        name = "Lane 10 SOF synchronization code NE10_SOF_ configuration register in LVDS or HiSPi 01 mode";
        desc = "LVDS0_LANE10_SOF_01 is a lane 10 SOF synchronization code configuration register in LVDS or HiSPi mode. Hi3516A V200 Professional HD IP Camera SoC

Data sheet 9.3.6 LVDS0_LANE10_SOF_01 (offset 0x1460, printed page 9-327, `hi3516av200--Hi3516AV200-Datasheet.txt` line 56138).";

        field {
            name = "lane10_sof_1";
            desc = "Lane 10 SOF synchronization code of frame 1 in LVDS or HiSPi mode This field is configurable only in WDR mode, and the configuration is invalid in linear mode.";
            sw = rw;
            hw = r;
            reset = 0x0;
        } lane10_sof_1[31:16];

        field {
            name = "lane10_sof_0";
            desc = "Lane 10 SOF synchronization code of frame 0 in LVDS or HiSPi mode In WDR mode, the value is the SOF of frame 0. In linear mode, the value is the SOF.";
            sw = rw;
            hw = r;
            reset = 0x0;
        } lane10_sof_0[15:0];
    } LVDS0_LANE10_SOF_01 @ 0x1460;

    reg {
        name = "Lane 10 SOF synchronization code NE10_SOF_ configuration register in LVDS or HiSPi 23 mode";
        desc = "LVDS0_LANE10_SOF_23 is a lane 10 SOF synchronization code configuration register in LVDS or HiSPi mode.

Data sheet 9.3.6 LVDS0_LANE10_SOF_23 (offset 0x1464, printed page 9-327, `hi3516av200--Hi3516AV200-Datasheet.txt` line 56166).";

        field {
            name = "lane10_sof_3";
            desc = "Lane 10 SOF synchronization code of frame 3 in LVDS or HiSPi mode This field is configurable only in WDR mode, and the configuration is invalid in linear mode.";
            sw = rw;
            hw = r;
            reset = 0x0;
        } lane10_sof_3[31:16];

        field {
            name = "lane10_sof_2";
            desc = "Lane 10 SOF synchronization code of frame 2 in LVDS or HiSPi mode This field is configurable only in WDR mode, and the configuration is invalid in linear mode.";
            sw = rw;
            hw = r;
            reset = 0x0;
        } lane10_sof_2[15:0];
    } LVDS0_LANE10_SOF_23 @ 0x1464;

    reg {
        name = "Lane 10 EOF synchronization code NE10_EOF_ configuration register in LVDS or HiSPi 01 mode";
        desc = "LVDS0_LANE10_EOF_01 is a lane 10 EOF synchronization code configuration register in LVDS or HiSPi mode. Hi3516A V200 Professional HD IP Camera SoC

Data sheet 9.3.6 LVDS0_LANE10_EOF_01 (offset 0x1468, printed page 9-328, `hi3516av200--Hi3516AV200-Datasheet.txt` line 56203).";

        field {
            name = "lane10_eof_1";
            desc = "Lane 10 EOF synchronization code of frame 1 in LVDS or HiSPi mode This field is configurable only in WDR mode, and the configuration is invalid in linear mode.";
            sw = rw;
            hw = r;
            reset = 0x0;
        } lane10_eof_1[31:16];

        field {
            name = "lane10_eof_0";
            desc = "Lane 10 EOF synchronization code of frame 0 in LVDS or HiSPi mode In WDR mode, the value is the EOF of frame 0. In linear mode, the value is the EOF.";
            sw = rw;
            hw = r;
            reset = 0x0;
        } lane10_eof_0[15:0];
    } LVDS0_LANE10_EOF_01 @ 0x1468;

    reg {
        name = "Lane 10 EOF synchronization code NE10_EOF_ configuration register in LVDS or HiSPi 23 mode";
        desc = "LVDS0_LANE10_EOF_23 is a lane 10 EOF synchronization code configuration register in LVDS or HiSPi mode.

Data sheet 9.3.6 LVDS0_LANE10_EOF_23 (offset 0x146C, printed page 9-328, `hi3516av200--Hi3516AV200-Datasheet.txt` line 56231).";

        field {
            name = "lane10_eof_3";
            desc = "Lane 10 EOF synchronization code of frame 3 in LVDS or HiSPi mode This field is configurable only in WDR mode, and the configuration is invalid in linear mode.";
            sw = rw;
            hw = r;
            reset = 0x0;
        } lane10_eof_3[31:16];

        field {
            name = "lane10_eof_2";
            desc = "Lane 10 EOF synchronization code of frame 2 in LVDS or HiSPi mode This field is configurable only in WDR mode, and the configuration is invalid in linear mode.";
            sw = rw;
            hw = r;
            reset = 0x0;
        } lane10_eof_2[15:0];
    } LVDS0_LANE10_EOF_23 @ 0x146C;

    reg {
        name = "Lane 10 SOL synchronization code NE10_SOL_ configuration register in LVDS or HiSPi 01 mode";
        desc = "LVDS0_LANE10_SOL_01 is a lane 10 SOL synchronization code configuration register in LVDS or HiSPi mode. Hi3516A V200 Professional HD IP Camera SoC

Data sheet 9.3.6 LVDS0_LANE10_SOL_01 (offset 0x1470, printed page 9-329, `hi3516av200--Hi3516AV200-Datasheet.txt` line 56268).";

        field {
            name = "lane10_sol_1";
            desc = "Lane 10 SOL synchronization code of frame 1 in LVDS or HiSPi mode This field is configurable only in WDR mode, and the configuration is invalid in linear mode.";
            sw = rw;
            hw = r;
            reset = 0x0;
        } lane10_sol_1[31:16];

        field {
            name = "lane10_sol_0";
            desc = "Lane 10 SOL synchronization code of frame 0 in LVDS or HiSPi mode In WDR mode, the value is the SOL of frame 0. In linear mode, the value is the SOL.";
            sw = rw;
            hw = r;
            reset = 0x0;
        } lane10_sol_0[15:0];
    } LVDS0_LANE10_SOL_01 @ 0x1470;

    reg {
        name = "Lane 10 SOL synchronization code NE10_SOL_ configuration register in LVDS or HiSPi 23 mode";
        desc = "LVDS0_LANE10_SOL_23 is a lane 10 SOL synchronization code configuration register in LVDS or HiSPi mode.

Data sheet 9.3.6 LVDS0_LANE10_SOL_23 (offset 0x1474, printed page 9-329, `hi3516av200--Hi3516AV200-Datasheet.txt` line 56296).";

        field {
            name = "lane10_sol_3";
            desc = "Lane 10 SOL synchronization code of frame 3 in LVDS or HiSPi mode This field is configurable only in WDR mode, and the configuration is invalid in linear mode.";
            sw = rw;
            hw = r;
            reset = 0x0;
        } lane10_sol_3[31:16];

        field {
            name = "lane10_sol_2";
            desc = "Lane 10 SOL synchronization code of frame 2 in LVDS or HiSPi mode This field is configurable only in WDR mode, and the configuration is invalid in linear mode.";
            sw = rw;
            hw = r;
            reset = 0x0;
        } lane10_sol_2[15:0];
    } LVDS0_LANE10_SOL_23 @ 0x1474;

    reg {
        name = "Lane 10 EOL synchronization code NE10_EOL_ configuration register in LVDS or HiSPi 01 mode";
        desc = "LVDS0_LANE10_EOL_01 is a lane 10 EOL synchronization code configuration register in LVDS or HiSPi mode. Hi3516A V200 Professional HD IP Camera SoC

Data sheet 9.3.6 LVDS0_LANE10_EOL_01 (offset 0x1478, printed page 9-330, `hi3516av200--Hi3516AV200-Datasheet.txt` line 56333).";

        field {
            name = "lane10_eol_1";
            desc = "Lane 10 EOL synchronization code of frame 1 in LVDS or HiSPi mode This field is configurable only in WDR mode, and the configuration is invalid in linear mode.";
            sw = rw;
            hw = r;
            reset = 0x0;
        } lane10_eol_1[31:16];

        field {
            name = "lane10_eol_0";
            desc = "Lane 10 EOL synchronization code of frame 0 in LVDS or HiSPi mode In WDR mode, the value is the EOL of frame 0. In linear mode, the value is the EOL.";
            sw = rw;
            hw = r;
            reset = 0x0;
        } lane10_eol_0[15:0];
    } LVDS0_LANE10_EOL_01 @ 0x1478;

    reg {
        name = "Lane 10 EOL synchronization code NE10_EOL_ configuration register in LVDS or HiSPi 23 mode";
        desc = "LVDS0_LANE10_EOL_23 is a lane 10 EOL synchronization code configuration register in LVDS or HiSPi mode.

Data sheet 9.3.6 LVDS0_LANE10_EOL_23 (offset 0x147C, printed page 9-330, `hi3516av200--Hi3516AV200-Datasheet.txt` line 56361).";

        field {
            name = "lane10_eol_3";
            desc = "Lane 10 EOL synchronization code of frame 3 in LVDS or HiSPi mode This field is configurable only in WDR mode, and the configuration is invalid in linear mode.";
            sw = rw;
            hw = r;
            reset = 0x0;
        } lane10_eol_3[31:16];

        field {
            name = "lane10_eol_2";
            desc = "Lane 10 EOL synchronization code of frame 2 in LVDS or HiSPi mode This field is configurable only in WDR mode, and the configuration is invalid in linear mode.";
            sw = rw;
            hw = r;
            reset = 0x0;
        } lane10_eol_2[15:0];
    } LVDS0_LANE10_EOL_23 @ 0x147C;

    reg {
        name = "Lane 11 SOF synchronization code NE11_SOF_ configuration register in LVDS or HiSPi 01 mode";
        desc = "LVDS0_LANE11_SOF_01 is a lane 11 SOF synchronization code configuration register in LVDS or HiSPi mode. Hi3516A V200 Professional HD IP Camera SoC

Data sheet 9.3.6 LVDS0_LANE11_SOF_01 (offset 0x1480, printed page 9-331, `hi3516av200--Hi3516AV200-Datasheet.txt` line 56398).";

        field {
            name = "lane11_sof_1";
            desc = "Lane 11 SOF synchronization code of frame 1 in LVDS or HiSPi mode This field is configurable only in WDR mode, and the configuration is invalid in linear mode.";
            sw = rw;
            hw = r;
            reset = 0x0;
        } lane11_sof_1[31:16];

        field {
            name = "lane11_sof_0";
            desc = "Lane 11 SOF synchronization code of frame 0 in LVDS or HiSPi mode In WDR mode, the value is the SOF of frame 0. In linear mode, the value is the SOF.";
            sw = rw;
            hw = r;
            reset = 0x0;
        } lane11_sof_0[15:0];
    } LVDS0_LANE11_SOF_01 @ 0x1480;

    reg {
        name = "Lane 11 SOF synchronization code NE11_SOF_ configuration register in LVDS or HiSPi 23 mode";
        desc = "LVDS0_LANE11_SOF_23 is a lane 11 SOF synchronization code configuration register in LVDS or HiSPi mode.

Data sheet 9.3.6 LVDS0_LANE11_SOF_23 (offset 0x1484, printed page 9-331, `hi3516av200--Hi3516AV200-Datasheet.txt` line 56426).";

        field {
            name = "lane11_sof_3";
            desc = "Lane 11 SOF synchronization code of frame 3 in LVDS or HiSPi mode This field is configurable only in WDR mode, and the configuration is invalid in linear mode.";
            sw = rw;
            hw = r;
            reset = 0x0;
        } lane11_sof_3[31:16];

        field {
            name = "lane11_sof_2";
            desc = "Lane 11 SOF synchronization code of frame 2 in LVDS or HiSPi mode This field is configurable only in WDR mode, and the configuration is invalid in linear mode.";
            sw = rw;
            hw = r;
            reset = 0x0;
        } lane11_sof_2[15:0];
    } LVDS0_LANE11_SOF_23 @ 0x1484;

    reg {
        name = "Lane 11 EOF synchronization code NE11_EOF_ configuration register in LVDS or HiSPi 01 mode";
        desc = "LVDS0_LANE11_EOF_01 is a lane 11 EOF synchronization code configuration register in LVDS or HiSPi mode. Hi3516A V200 Professional HD IP Camera SoC

Data sheet 9.3.6 LVDS0_LANE11_EOF_01 (offset 0x1488, printed page 9-332, `hi3516av200--Hi3516AV200-Datasheet.txt` line 56463).";

        field {
            name = "lane11_eof_1";
            desc = "Lane 11 EOF synchronization code of frame 1 in LVDS or HiSPi mode This field is configurable only in WDR mode, and the configuration is invalid in linear mode.";
            sw = rw;
            hw = r;
            reset = 0x0;
        } lane11_eof_1[31:16];

        field {
            name = "lane11_eof_0";
            desc = "Lane 11 EOF synchronization code of frame 0 in LVDS or HiSPi mode In WDR mode, the value is the EOF of frame 0. In linear mode, the value is the EOF.";
            sw = rw;
            hw = r;
            reset = 0x0;
        } lane11_eof_0[15:0];
    } LVDS0_LANE11_EOF_01 @ 0x1488;

    reg {
        name = "Lane 11 EOF synchronization code NE11_EOF_ configuration register in LVDS or HiSPi 23 mode";
        desc = "LVDS0_LANE11_EOF_23 is a lane 11 EOF synchronization code configuration register in LVDS or HiSPi mode.

Data sheet 9.3.6 LVDS0_LANE11_EOF_23 (offset 0x148C, printed page 9-332, `hi3516av200--Hi3516AV200-Datasheet.txt` line 56491).";

        field {
            name = "lane11_eof_3";
            desc = "Lane 11 EOF synchronization code of frame 3 in LVDS or HiSPi mode This field is configurable only in WDR mode, and the configuration is invalid in linear mode.";
            sw = rw;
            hw = r;
            reset = 0x0;
        } lane11_eof_3[31:16];

        field {
            name = "lane11_eof_2";
            desc = "Lane 11 EOF synchronization code of frame 2 in LVDS or HiSPi mode This field is configurable only in WDR mode, and the configuration is invalid in linear mode.";
            sw = rw;
            hw = r;
            reset = 0x0;
        } lane11_eof_2[15:0];
    } LVDS0_LANE11_EOF_23 @ 0x148C;

    reg {
        name = "Lane 11 SOL synchronization code NE11_SOL_ configuration register in LVDS or HiSPi 01 mode";
        desc = "LVDS0_LANE11_SOL_01 is a lane 11 SOL synchronization code configuration register in LVDS or HiSPi mode. Hi3516A V200 Professional HD IP Camera SoC

Data sheet 9.3.6 LVDS0_LANE11_SOL_01 (offset 0x1490, printed page 9-333, `hi3516av200--Hi3516AV200-Datasheet.txt` line 56528).";

        field {
            name = "lane11_sol_1";
            desc = "Lane 11 SOL synchronization code of frame 1 in LVDS or HiSPi mode This field is configurable only in WDR mode, and the configuration is invalid in linear mode.";
            sw = rw;
            hw = r;
            reset = 0x0;
        } lane11_sol_1[31:16];

        field {
            name = "lane11_sol_0";
            desc = "Lane 11 SOL synchronization code of frame 0 in LVDS or HiSPi mode In WDR mode, the value is the SOL of frame 0. In linear mode, the value is the SOL.";
            sw = rw;
            hw = r;
            reset = 0x0;
        } lane11_sol_0[15:0];
    } LVDS0_LANE11_SOL_01 @ 0x1490;

    reg {
        name = "Lane 11 SOL synchronization code NE11_SOL_ configuration register in LVDS or HiSPi 23 mode";
        desc = "LVDS0_LANE11_SOL_23 is a lane 11 SOL synchronization code configuration register in LVDS or HiSPi mode.

Data sheet 9.3.6 LVDS0_LANE11_SOL_23 (offset 0x1494, printed page 9-333, `hi3516av200--Hi3516AV200-Datasheet.txt` line 56556).";

        field {
            name = "lane11_sol_3";
            desc = "Lane 11 SOL synchronization code of frame 3 in LVDS or HiSPi mode This field is configurable only in WDR mode, and the configuration is invalid in linear mode.";
            sw = rw;
            hw = r;
            reset = 0x0;
        } lane11_sol_3[31:16];

        field {
            name = "lane11_sol_2";
            desc = "Lane 11 SOL synchronization code of frame 2 in LVDS or HiSPi mode This field is configurable only in WDR mode, and the configuration is invalid in linear mode.";
            sw = rw;
            hw = r;
            reset = 0x0;
        } lane11_sol_2[15:0];
    } LVDS0_LANE11_SOL_23 @ 0x1494;

    reg {
        name = "Lane 11 EOL synchronization code NE11_EOL_ configuration register in LVDS or HiSPi 01 mode";
        desc = "LVDS0_LANE11_EOL_01 is a lane 11 EOL synchronization code configuration register in LVDS or HiSPi mode. Hi3516A V200 Professional HD IP Camera SoC

Data sheet 9.3.6 LVDS0_LANE11_EOL_01 (offset 0x1498, printed page 9-334, `hi3516av200--Hi3516AV200-Datasheet.txt` line 56593).";

        field {
            name = "lane11_eol_1";
            desc = "Lane 11 EOL synchronization code of frame 1 in LVDS or HiSPi mode This field is configurable only in WDR mode, and the configuration is invalid in linear mode.";
            sw = rw;
            hw = r;
            reset = 0x0;
        } lane11_eol_1[31:16];

        field {
            name = "lane11_eol_0";
            desc = "Lane 11 EOL synchronization code of frame 0 in LVDS or HiSPi mode In WDR mode, the value is the EOL of frame 0. In linear mode, the value is the EOL.";
            sw = rw;
            hw = r;
            reset = 0x0;
        } lane11_eol_0[15:0];
    } LVDS0_LANE11_EOL_01 @ 0x1498;

    reg {
        name = "Lane 11 EOL synchronization code NE11_EOL_ configuration register in LVDS or HiSPi 23 mode";
        desc = "LVDS0_LANE11_EOL_23 is a lane 11 EOL synchronization code configuration register in LVDS or HiSPi mode.

Data sheet 9.3.6 LVDS0_LANE11_EOL_23 (offset 0x149C, printed page 9-334, `hi3516av200--Hi3516AV200-Datasheet.txt` line 56621).";

        field {
            name = "lane11_eol_3";
            desc = "Lane 11 EOL synchronization code of frame 3 in LVDS or HiSPi mode This field is configurable only in WDR mode, and the configuration is invalid in linear mode.";
            sw = rw;
            hw = r;
            reset = 0x0;
        } lane11_eol_3[31:16];

        field {
            name = "lane11_eol_2";
            desc = "Lane 11 EOL synchronization code of frame 2 in LVDS or HiSPi mode This field is configurable only in WDR mode, and the configuration is invalid in linear mode.";
            sw = rw;
            hw = r;
            reset = 0x0;
        } lane11_eol_2[15:0];
    } LVDS0_LANE11_EOL_23 @ 0x149C;

    reg {
        name = "Lane 0 SOF synchronization code NE0_NXT_S configuration register for frame (N + 1) in OF_01 LVDS or HiSPi mode";
        desc = "LVDS0_LANE0_NXT_SOF_01 is a lane 0 SOF synchronization code configuration register for frame (N + 1) in LVDS or HiSPi mode. Hi3516A V200 Professional HD IP Camera SoC

Data sheet 9.3.6 LVDS0_LANE0_NXT_SOF_01 (offset 0x14A0, printed page 9-335, `hi3516av200--Hi3516AV200-Datasheet.txt` line 56658).";

        field {
            name = "lane0_nxt_sof_1";
            desc = "Lane 0 SOF synchronization code of frame 1 in LVDS or HiSPi mode This field is configurable only in WDR mode, and the configuration is invalid in linear mode.";
            sw = rw;
            hw = r;
            reset = 0x0;
        } lane0_nxt_sof_1[31:16];

        field {
            name = "lane0_nxt_sof_0";
            desc = "Lane 0 SOF synchronization code of frame 0 in LVDS or HiSPi mode In WDR mode, the value is the SOF of frame 0. In linear mode, the value is the SOF.";
            sw = rw;
            hw = r;
            reset = 0x0;
        } lane0_nxt_sof_0[15:0];
    } LVDS0_LANE0_NXT_SOF_01 @ 0x14A0;

    reg {
        name = "Lane 0 SOF synchronization code NE0_NXT_S configuration register for frame (N + 1) in OF_23 LVDS or HiSPi mode";
        desc = "LVDS0_LANE0_NXT_SOF_23 is a lane 0 SOF synchronization code configuration register for frame (N + 1) in LVDS or HiSPi mode.

Data sheet 9.3.6 LVDS0_LANE0_NXT_SOF_23 (offset 0x14A4, printed page 9-335, `hi3516av200--Hi3516AV200-Datasheet.txt` line 56686).";

        field {
            name = "lane0_nxt_sof_3";
            desc = "Lane 0 SOF synchronization code of frame 3 in LVDS or HiSPi mode This field is configurable only in WDR mode, and the configuration is invalid in linear mode.";
            sw = rw;
            hw = r;
            reset = 0x0;
        } lane0_nxt_sof_3[31:16];

        field {
            name = "lane0_nxt_sof_2";
            desc = "Lane 0 SOF synchronization code of frame 2 in LVDS or HiSPi mode This field is configurable only in WDR mode, and the configuration is invalid in linear mode.";
            sw = rw;
            hw = r;
            reset = 0x0;
        } lane0_nxt_sof_2[15:0];
    } LVDS0_LANE0_NXT_SOF_23 @ 0x14A4;

    reg {
        name = "Lane 0 EOF synchronization code NE0_NXT_E configuration register for frame (N + 1) in OF_01 LVDS or HiSPi mode";
        desc = "LVDS0_LANE0_NXT_EOF_01 is a lane 0 EOF synchronization code configuration register for frame (N + 1) in LVDS or HiSPi mode. Hi3516A V200 Professional HD IP Camera SoC

Data sheet 9.3.6 LVDS0_LANE0_NXT_EOF_01 (offset 0x14A8, printed page 9-336, `hi3516av200--Hi3516AV200-Datasheet.txt` line 56723).";

        field {
            name = "lane0_nxt_eof_1";
            desc = "Lane 0 EOF synchronization code of frame 1 in LVDS or HiSPi mode This field is configurable only in WDR mode, and the configuration is invalid in linear mode.";
            sw = rw;
            hw = r;
            reset = 0x0;
        } lane0_nxt_eof_1[31:16];

        field {
            name = "lane0_nxt_eof_0";
            desc = "Lane 0 EOF synchronization code of frame 0 in LVDS or HiSPi mode In WDR mode, the value is the EOF of frame 0. In linear mode, the value is the EOF.";
            sw = rw;
            hw = r;
            reset = 0x0;
        } lane0_nxt_eof_0[15:0];
    } LVDS0_LANE0_NXT_EOF_01 @ 0x14A8;

    reg {
        name = "Lane 0 EOF synchronization code NE0_NXT_E configuration register for frame (N + 1) in OF_23 LVDS or HiSPi mode";
        desc = "LVDS0_LANE0_NXT_EOF_23 is a lane 0 EOF synchronization code configuration register for frame (N + 1) in LVDS or HiSPi mode.

Data sheet 9.3.6 LVDS0_LANE0_NXT_EOF_23 (offset 0x14AC, printed page 9-336, `hi3516av200--Hi3516AV200-Datasheet.txt` line 56751).";

        field {
            name = "lane0_nxt_eof_3";
            desc = "Lane 0 EOF synchronization code of frame 3 in LVDS or HiSPi mode This field is configurable only in WDR mode, and the configuration is invalid in linear mode.";
            sw = rw;
            hw = r;
            reset = 0x0;
        } lane0_nxt_eof_3[31:16];

        field {
            name = "lane0_nxt_eof_2";
            desc = "Lane 0 EOF synchronization code of frame 2 in LVDS or HiSPi mode This field is configurable only in WDR mode, and the configuration is invalid in linear mode.";
            sw = rw;
            hw = r;
            reset = 0x0;
        } lane0_nxt_eof_2[15:0];
    } LVDS0_LANE0_NXT_EOF_23 @ 0x14AC;

    reg {
        name = "Lane 0 SOL synchronization code NE0_NXT_S configuration register for frame (N + 1) in OL_01 LVDS or HiSPi mode";
        desc = "LVDS0_LANE0_NXT_SOL_01 is a lane 0 SOL synchronization code configuration register for frame (N + 1) in LVDS or HiSPi mode. Hi3516A V200 Professional HD IP Camera SoC

Data sheet 9.3.6 LVDS0_LANE0_NXT_SOL_01 (offset 0x14B0, printed page 9-337, `hi3516av200--Hi3516AV200-Datasheet.txt` line 56788).";

        field {
            name = "lane0_nxt_sol_1";
            desc = "Lane 0 SOL synchronization code of frame 1 in LVDS or HiSPi mode This field is configurable only in WDR mode, and the configuration is invalid in linear mode.";
            sw = rw;
            hw = r;
            reset = 0x0;
        } lane0_nxt_sol_1[31:16];

        field {
            name = "lane0_nxt_sol_0";
            desc = "Lane 0 SOL synchronization code of frame 0 in LVDS or HiSPi mode In WDR mode, the value is the SOL of frame 0. In linear mode, the value is the SOL.";
            sw = rw;
            hw = r;
            reset = 0x0;
        } lane0_nxt_sol_0[15:0];
    } LVDS0_LANE0_NXT_SOL_01 @ 0x14B0;

    reg {
        name = "Lane 0 SOL synchronization code NE0_NXT_S configuration register for frame (N + 1) in OL_23 LVDS or HiSPi mode";
        desc = "LVDS0_LANE0_NXT_SOL_23 is a lane 0 SOL synchronization code configuration register for frame (N + 1) in LVDS or HiSPi mode.

Data sheet 9.3.6 LVDS0_LANE0_NXT_SOL_23 (offset 0x14B4, printed page 9-337, `hi3516av200--Hi3516AV200-Datasheet.txt` line 56816).";

        field {
            name = "lane0_nxt_sol_3";
            desc = "Lane 0 SOL synchronization code of frame 3 in LVDS or HiSPi mode This field is configurable only in WDR mode, and the configuration is invalid in linear mode.";
            sw = rw;
            hw = r;
            reset = 0x0;
        } lane0_nxt_sol_3[31:16];

        field {
            name = "lane0_nxt_sol_2";
            desc = "Lane 0 SOL synchronization code of frame 2 in LVDS or HiSPi mode This field is configurable only in WDR mode, and the configuration is invalid in linear mode.";
            sw = rw;
            hw = r;
            reset = 0x0;
        } lane0_nxt_sol_2[15:0];
    } LVDS0_LANE0_NXT_SOL_23 @ 0x14B4;

    reg {
        name = "Lane 0 EOL synchronization code NE0_NXT_E configuration register for frame (N + 1) in OL_01 LVDS or HiSPi mode";
        desc = "LVDS0_LANE0_NXT_EOL_01 is a lane 0 EOL synchronization code configuration register for frame (N + 1) in LVDS or HiSPi mode. Hi3516A V200 Professional HD IP Camera SoC

Data sheet 9.3.6 LVDS0_LANE0_NXT_EOL_01 (offset 0x14B8, printed page 9-338, `hi3516av200--Hi3516AV200-Datasheet.txt` line 56853).";

        field {
            name = "lane0_nxt_eol_1";
            desc = "Lane 0 EOL synchronization code of frame 1 in LVDS or HiSPi mode This field is configurable only in WDR mode, and the configuration is invalid in linear mode.";
            sw = rw;
            hw = r;
            reset = 0x0;
        } lane0_nxt_eol_1[31:16];

        field {
            name = "lane0_nxt_eol_0";
            desc = "Lane 0 EOL synchronization code of frame 0 in LVDS or HiSPi mode In WDR mode, the value is the EOL of frame 0. In linear mode, the value is the EOL.";
            sw = rw;
            hw = r;
            reset = 0x0;
        } lane0_nxt_eol_0[15:0];
    } LVDS0_LANE0_NXT_EOL_01 @ 0x14B8;

    reg {
        name = "Lane 0 EOL synchronization code NE0_NXT_E configuration register for frame (N + 1) in OL_23 LVDS or HiSPi mode";
        desc = "LVDS0_LANE0_NXT_EOL_23 is a lane 0 EOL synchronization code configuration register for frame (N + 1) in LVDS or HiSPi mode.

Data sheet 9.3.6 LVDS0_LANE0_NXT_EOL_23 (offset 0x14BC, printed page 9-338, `hi3516av200--Hi3516AV200-Datasheet.txt` line 56881).";

        field {
            name = "lane0_nxt_eol_3";
            desc = "Lane 0 EOL synchronization code of frame 3 in LVDS or HiSPi mode This field is configurable only in WDR mode, and the configuration is invalid in linear mode.";
            sw = rw;
            hw = r;
            reset = 0x0;
        } lane0_nxt_eol_3[31:16];

        field {
            name = "lane0_nxt_eol_2";
            desc = "Lane 0 EOL synchronization code of frame 2 in LVDS or HiSPi mode This field is configurable only in WDR mode, and the configuration is invalid in linear mode.";
            sw = rw;
            hw = r;
            reset = 0x0;
        } lane0_nxt_eol_2[15:0];
    } LVDS0_LANE0_NXT_EOL_23 @ 0x14BC;

    reg {
        name = "Lane 1 SOF synchronization code NE1_NXT_S configuration register for frame (N + 1) in OF_01 LVDS or HiSPi mode";
        desc = "LVDS0_LANE1_NXT_SOF_01 is a lane 1 SOF synchronization code configuration register for frame (N + 1) in LVDS or HiSPi mode. Hi3516A V200 Professional HD IP Camera SoC

Data sheet 9.3.6 LVDS0_LANE1_NXT_SOF_01 (offset 0x14C0, printed page 9-339, `hi3516av200--Hi3516AV200-Datasheet.txt` line 56918).";

        field {
            name = "lane1_nxt_sof_1";
            desc = "Lane 1 SOF synchronization code of frame 1 in LVDS or HiSPi mode This field is configurable only in WDR mode, and the configuration is invalid in linear mode.";
            sw = rw;
            hw = r;
            reset = 0x0;
        } lane1_nxt_sof_1[31:16];

        field {
            name = "lane1_nxt_sof_0";
            desc = "Lane 1 SOF synchronization code of frame 0 in LVDS or HiSPi mode In WDR mode, the value is the SOF of frame 0. In linear mode, the value is the SOF.";
            sw = rw;
            hw = r;
            reset = 0x0;
        } lane1_nxt_sof_0[15:0];
    } LVDS0_LANE1_NXT_SOF_01 @ 0x14C0;

    reg {
        name = "Lane 1 SOF synchronization code NE1_NXT_S configuration register for frame (N + 1) in OF_23 LVDS or HiSPi mode";
        desc = "LVDS0_LANE1_NXT_SOF_23 is a lane 1 SOF synchronization code configuration register for frame (N + 1) in LVDS or HiSPi mode.

Data sheet 9.3.6 LVDS0_LANE1_NXT_SOF_23 (offset 0x14C4, printed page 9-339, `hi3516av200--Hi3516AV200-Datasheet.txt` line 56946).";

        field {
            name = "lane1_nxt_sof_3";
            desc = "Lane 1 SOF synchronization code of frame 3 in LVDS or HiSPi mode This field is configurable only in WDR mode, and the configuration is invalid in linear mode.";
            sw = rw;
            hw = r;
            reset = 0x0;
        } lane1_nxt_sof_3[31:16];

        field {
            name = "lane1_nxt_sof_2";
            desc = "Lane 1 SOF synchronization code of frame 2 in LVDS or HiSPi mode This field is configurable only in WDR mode, and the configuration is invalid in linear mode.";
            sw = rw;
            hw = r;
            reset = 0x0;
        } lane1_nxt_sof_2[15:0];
    } LVDS0_LANE1_NXT_SOF_23 @ 0x14C4;

    reg {
        name = "Lane 1 EOF synchronization code NE1_NXT_E configuration register for frame (N + 1) in OF_01 LVDS or HiSPi mode";
        desc = "LVDS0_LANE1_NXT_EOF_01 is a lane 1 EOF synchronization code configuration register for frame (N + 1) in LVDS or HiSPi mode. Hi3516A V200 Professional HD IP Camera SoC

Data sheet 9.3.6 LVDS0_LANE1_NXT_EOF_01 (offset 0x14C8, printed page 9-340, `hi3516av200--Hi3516AV200-Datasheet.txt` line 56983).";

        field {
            name = "lane1_nxt_eof_1";
            desc = "Lane 1 EOF synchronization code of frame 1 in LVDS or HiSPi mode This field is configurable only in WDR mode, and the configuration is invalid in linear mode.";
            sw = rw;
            hw = r;
            reset = 0x0;
        } lane1_nxt_eof_1[31:16];

        field {
            name = "lane1_nxt_eof_0";
            desc = "Lane 1 EOF synchronization code of frame 0 in LVDS or HiSPi mode In WDR mode, the value is the EOF of frame 0. In linear mode, the value is the EOF.";
            sw = rw;
            hw = r;
            reset = 0x0;
        } lane1_nxt_eof_0[15:0];
    } LVDS0_LANE1_NXT_EOF_01 @ 0x14C8;

    reg {
        name = "Lane 1 EOF synchronization code NE1_NXT_E configuration register for frame (N + 1) in OF_23 LVDS or HiSPi mode";
        desc = "LVDS0_LANE1_NXT_EOF_23 is a lane 1 EOF synchronization code configuration register for frame (N + 1) in LVDS or HiSPi mode.

Data sheet 9.3.6 LVDS0_LANE1_NXT_EOF_23 (offset 0x14CC, printed page 9-340, `hi3516av200--Hi3516AV200-Datasheet.txt` line 57011).";

        field {
            name = "lane1_nxt_eof_3";
            desc = "Lane 1 EOF synchronization code of frame 3 in LVDS or HiSPi mode This field is configurable only in WDR mode, and the configuration is invalid in linear mode.";
            sw = rw;
            hw = r;
            reset = 0x0;
        } lane1_nxt_eof_3[31:16];

        field {
            name = "lane1_nxt_eof_2";
            desc = "Lane 1 EOF synchronization code of frame 2 in LVDS or HiSPi mode This field is configurable only in WDR mode, and the configuration is invalid in linear mode.";
            sw = rw;
            hw = r;
            reset = 0x0;
        } lane1_nxt_eof_2[15:0];
    } LVDS0_LANE1_NXT_EOF_23 @ 0x14CC;

    reg {
        name = "Lane 1 SOL synchronization code NE1_NXT_S configuration register for frame (N + 1) in OL_01 LVDS or HiSPi mode";
        desc = "LVDS0_LANE1_NXT_SOL_01 is a lane 1 SOL synchronization code configuration register for frame (N + 1) in LVDS or HiSPi mode. Hi3516A V200 Professional HD IP Camera SoC

Data sheet 9.3.6 LVDS0_LANE1_NXT_SOL_01 (offset 0x14D0, printed page 9-341, `hi3516av200--Hi3516AV200-Datasheet.txt` line 57048).";

        field {
            name = "lane1_nxt_sol_1";
            desc = "Lane 1 SOL synchronization code of frame 1 in LVDS or HiSPi mode This field is configurable only in WDR mode, and the configuration is invalid in linear mode.";
            sw = rw;
            hw = r;
            reset = 0x0;
        } lane1_nxt_sol_1[31:16];

        field {
            name = "lane1_nxt_sol_0";
            desc = "Lane 1 SOL synchronization code of frame 0 in LVDS or HiSPi mode In WDR mode, the value is the SOL of frame 0. In linear mode, the value is the SOL.";
            sw = rw;
            hw = r;
            reset = 0x0;
        } lane1_nxt_sol_0[15:0];
    } LVDS0_LANE1_NXT_SOL_01 @ 0x14D0;

    reg {
        name = "Lane 1 SOL synchronization code NE1_NXT_S configuration register for frame (N + 1) in OL_23 LVDS or HiSPi mode";
        desc = "LVDS0_LANE1_NXT_SOL_23 is a lane 1 SOL synchronization code configuration register for frame (N + 1) in LVDS or HiSPi mode.

Data sheet 9.3.6 LVDS0_LANE1_NXT_SOL_23 (offset 0x14D4, printed page 9-341, `hi3516av200--Hi3516AV200-Datasheet.txt` line 57076).";

        field {
            name = "lane1_nxt_sol_3";
            desc = "Lane 1 SOL synchronization code of frame 3 in LVDS or HiSPi mode This field is configurable only in WDR mode, and the configuration is invalid in linear mode.";
            sw = rw;
            hw = r;
            reset = 0x0;
        } lane1_nxt_sol_3[31:16];

        field {
            name = "lane1_nxt_sol_2";
            desc = "Lane 1 SOL synchronization code of frame 2 in LVDS or HiSPi mode This field is configurable only in WDR mode, and the configuration is invalid in linear mode.";
            sw = rw;
            hw = r;
            reset = 0x0;
        } lane1_nxt_sol_2[15:0];
    } LVDS0_LANE1_NXT_SOL_23 @ 0x14D4;

    reg {
        name = "Lane 1 EOL synchronization code NE1_NXT_E configuration register for frame (N + 1) in OL_01 LVDS or HiSPi mode";
        desc = "LVDS0_LANE1_NXT_EOL_01 is a lane 1 EOL synchronization code configuration register for frame (N + 1) in LVDS or HiSPi mode. Hi3516A V200 Professional HD IP Camera SoC

Data sheet 9.3.6 LVDS0_LANE1_NXT_EOL_01 (offset 0x14D8, printed page 9-342, `hi3516av200--Hi3516AV200-Datasheet.txt` line 57113).";

        field {
            name = "lane1_nxt_eol_1";
            desc = "Lane 1 EOL synchronization code of frame 1 in LVDS or HiSPi mode This field is configurable only in WDR mode, and the configuration is invalid in linear mode.";
            sw = rw;
            hw = r;
            reset = 0x0;
        } lane1_nxt_eol_1[31:16];

        field {
            name = "lane1_nxt_eol_0";
            desc = "Lane 1 EOL synchronization code of frame 0 in LVDS or HiSPi mode In WDR mode, the value is the EOL of frame 0. In linear mode, the value is the EOL.";
            sw = rw;
            hw = r;
            reset = 0x0;
        } lane1_nxt_eol_0[15:0];
    } LVDS0_LANE1_NXT_EOL_01 @ 0x14D8;

    reg {
        name = "Lane 1 EOL synchronization code NE1_NXT_E configuration register for frame (N + 1) in OL_23 LVDS or HiSPi mode";
        desc = "LVDS0_LANE1_NXT_EOL_23 is a lane 1 EOL synchronization code configuration register for frame (N + 1) in LVDS or HiSPi mode.

Data sheet 9.3.6 LVDS0_LANE1_NXT_EOL_23 (offset 0x14DC, printed page 9-342, `hi3516av200--Hi3516AV200-Datasheet.txt` line 57141).";

        field {
            name = "lane1_nxt_eol_3";
            desc = "Lane 1 EOL synchronization code of frame 3 in LVDS or HiSPi mode This field is configurable only in WDR mode, and the configuration is invalid in linear mode.";
            sw = rw;
            hw = r;
            reset = 0x0;
        } lane1_nxt_eol_3[31:16];

        field {
            name = "lane1_nxt_eol_2";
            desc = "Lane 1 EOL synchronization code of frame 2 in LVDS or HiSPi mode This field is configurable only in WDR mode, and the configuration is invalid in linear mode.";
            sw = rw;
            hw = r;
            reset = 0x0;
        } lane1_nxt_eol_2[15:0];
    } LVDS0_LANE1_NXT_EOL_23 @ 0x14DC;

    reg {
        name = "Lane 2 SOF synchronization code NE2_NXT_S configuration register for frame (N + 1) in OF_01 LVDS or HiSPi mode";
        desc = "LVDS0_LANE2_NXT_SOF_01 is a lane 2 SOF synchronization code configuration register for frame (N + 1) in LVDS or HiSPi mode. Hi3516A V200 Professional HD IP Camera SoC

Data sheet 9.3.6 LVDS0_LANE2_NXT_SOF_01 (offset 0x14E0, printed page 9-343, `hi3516av200--Hi3516AV200-Datasheet.txt` line 57178).";

        field {
            name = "lane2_nxt_sof_1";
            desc = "Lane 2 SOF synchronization code of frame 1 in LVDS or HiSPi mode This field is configurable only in WDR mode, and the configuration is invalid in linear mode.";
            sw = rw;
            hw = r;
            reset = 0x0;
        } lane2_nxt_sof_1[31:16];

        field {
            name = "lane2_nxt_sof_0";
            desc = "Lane 2 SOF synchronization code of frame 0 in LVDS or HiSPi mode In WDR mode, the value is the SOF of frame 0. In linear mode, the value is the SOF.";
            sw = rw;
            hw = r;
            reset = 0x0;
        } lane2_nxt_sof_0[15:0];
    } LVDS0_LANE2_NXT_SOF_01 @ 0x14E0;

    reg {
        name = "Lane 2 SOF synchronization code NE2_NXT_S configuration register for frame (N + 1) in OF_23 LVDS or HiSPi mode";
        desc = "LVDS0_LANE2_NXT_SOF_23 is a lane 2 SOF synchronization code configuration register for frame (N + 1) in LVDS or HiSPi mode.

Data sheet 9.3.6 LVDS0_LANE2_NXT_SOF_23 (offset 0x14E4, printed page 9-343, `hi3516av200--Hi3516AV200-Datasheet.txt` line 57206).";

        field {
            name = "lane2_nxt_sof_3";
            desc = "Lane 2 SOF synchronization code of frame 3 in LVDS or HiSPi mode This field is configurable only in WDR mode, and the configuration is invalid in linear mode.";
            sw = rw;
            hw = r;
            reset = 0x0;
        } lane2_nxt_sof_3[31:16];

        field {
            name = "lane2_nxt_sof_2";
            desc = "Lane 2 SOF synchronization code of frame 2 in LVDS or HiSPi mode This field is configurable only in WDR mode, and the configuration is invalid in linear mode.";
            sw = rw;
            hw = r;
            reset = 0x0;
        } lane2_nxt_sof_2[15:0];
    } LVDS0_LANE2_NXT_SOF_23 @ 0x14E4;

    reg {
        name = "Lane 2 EOF synchronization code NE2_NXT_E configuration register for frame (N + 1) in OF_01 LVDS or HiSPi mode";
        desc = "LVDS0_LANE2_NXT_EOF_01 is a lane 2 EOF synchronization code configuration register for frame (N + 1) in LVDS or HiSPi mode. Hi3516A V200 Professional HD IP Camera SoC

Data sheet 9.3.6 LVDS0_LANE2_NXT_EOF_01 (offset 0x14E8, printed page 9-344, `hi3516av200--Hi3516AV200-Datasheet.txt` line 57243).";

        field {
            name = "lane2_nxt_eof_1";
            desc = "Lane 2 EOF synchronization code of frame 1 in LVDS or HiSPi mode This field is configurable only in WDR mode, and the configuration is invalid in linear mode.";
            sw = rw;
            hw = r;
            reset = 0x0;
        } lane2_nxt_eof_1[31:16];

        field {
            name = "lane2_nxt_eof_0";
            desc = "Lane 2 EOF synchronization code of frame 0 in LVDS or HiSPi mode In WDR mode, the value is the EOF of frame 0. In linear mode, the value is the EOF.";
            sw = rw;
            hw = r;
            reset = 0x0;
        } lane2_nxt_eof_0[15:0];
    } LVDS0_LANE2_NXT_EOF_01 @ 0x14E8;

    reg {
        name = "Lane 2 EOF synchronization code NE2_NXT_E configuration register for frame (N + 1) in OF_23 LVDS or HiSPi mode";
        desc = "LVDS0_LANE2_NXT_EOF_23 is a lane 2 EOF synchronization code configuration register for frame (N + 1) in LVDS or HiSPi mode.

Data sheet 9.3.6 LVDS0_LANE2_NXT_EOF_23 (offset 0x14EC, printed page 9-344, `hi3516av200--Hi3516AV200-Datasheet.txt` line 57271).";

        field {
            name = "lane2_nxt_eof_3";
            desc = "Lane 2 EOF synchronization code of frame 3 in LVDS or HiSPi mode This field is configurable only in WDR mode, and the configuration is invalid in linear mode.";
            sw = rw;
            hw = r;
            reset = 0x0;
        } lane2_nxt_eof_3[31:16];

        field {
            name = "lane2_nxt_eof_2";
            desc = "Lane 2 EOF synchronization code of frame 2 in LVDS or HiSPi mode This field is configurable only in WDR mode, and the configuration is invalid in linear mode.";
            sw = rw;
            hw = r;
            reset = 0x0;
        } lane2_nxt_eof_2[15:0];
    } LVDS0_LANE2_NXT_EOF_23 @ 0x14EC;

    reg {
        name = "Lane 2 SOL synchronization code NE2_NXT_S configuration register for frame (N + 1) in OL_01 LVDS or HiSPi mode";
        desc = "LVDS0_LANE2_NXT_SOL_01 is a lane 2 SOL synchronization code configuration register for frame (N + 1) in LVDS or HiSPi mode. Hi3516A V200 Professional HD IP Camera SoC

Data sheet 9.3.6 LVDS0_LANE2_NXT_SOL_01 (offset 0x14F0, printed page 9-345, `hi3516av200--Hi3516AV200-Datasheet.txt` line 57308).";

        field {
            name = "lane2_nxt_sol_1";
            desc = "Lane 2 SOL synchronization code of frame 1 in LVDS or HiSPi mode This field is configurable only in WDR mode, and the configuration is invalid in linear mode.";
            sw = rw;
            hw = r;
            reset = 0x0;
        } lane2_nxt_sol_1[31:16];

        field {
            name = "lane2_nxt_sol_0";
            desc = "Lane 2 SOL synchronization code of frame 0 in LVDS or HiSPi mode In WDR mode, the value is the SOL of frame 0. In linear mode, the value is the SOL.";
            sw = rw;
            hw = r;
            reset = 0x0;
        } lane2_nxt_sol_0[15:0];
    } LVDS0_LANE2_NXT_SOL_01 @ 0x14F0;

    reg {
        name = "Lane 2 SOL synchronization code NE2_NXT_S configuration register for frame (N + 1) in OL_23 LVDS or HiSPi mode";
        desc = "LVDS0_LANE2_NXT_SOL_23 is a lane 2 SOL synchronization code configuration register for frame (N + 1) in LVDS or HiSPi mode.

Data sheet 9.3.6 LVDS0_LANE2_NXT_SOL_23 (offset 0x14F4, printed page 9-345, `hi3516av200--Hi3516AV200-Datasheet.txt` line 57336).";

        field {
            name = "lane2_nxt_sol_3";
            desc = "Lane 2 SOL synchronization code of frame 3 in LVDS or HiSPi mode This field is configurable only in WDR mode, and the configuration is invalid in linear mode.";
            sw = rw;
            hw = r;
            reset = 0x0;
        } lane2_nxt_sol_3[31:16];

        field {
            name = "lane2_nxt_sol_2";
            desc = "Lane 2 SOL synchronization code of frame 2 in LVDS or HiSPi mode This field is configurable only in WDR mode, and the configuration is invalid in linear mode.";
            sw = rw;
            hw = r;
            reset = 0x0;
        } lane2_nxt_sol_2[15:0];
    } LVDS0_LANE2_NXT_SOL_23 @ 0x14F4;

    reg {
        name = "Lane 2 EOL synchronization code NE2_NXT_E configuration register for frame (N + 1) in OL_01 LVDS or HiSPi mode";
        desc = "LVDS0_LANE2_NXT_EOL_01 is a lane 2 EOL synchronization code configuration register for frame (N + 1) in LVDS or HiSPi mode. Hi3516A V200 Professional HD IP Camera SoC

Data sheet 9.3.6 LVDS0_LANE2_NXT_EOL_01 (offset 0x14F8, printed page 9-346, `hi3516av200--Hi3516AV200-Datasheet.txt` line 57373).";

        field {
            name = "lane2_nxt_eol_1";
            desc = "Lane 2 EOL synchronization code of frame 1 in LVDS or HiSPi mode This field is configurable only in WDR mode, and the configuration is invalid in linear mode.";
            sw = rw;
            hw = r;
            reset = 0x0;
        } lane2_nxt_eol_1[31:16];

        field {
            name = "lane2_nxt_eol_0";
            desc = "Lane 2 EOL synchronization code of frame 0 in LVDS or HiSPi mode In WDR mode, the value is the EOL of frame 0. In linear mode, the value is the EOL.";
            sw = rw;
            hw = r;
            reset = 0x0;
        } lane2_nxt_eol_0[15:0];
    } LVDS0_LANE2_NXT_EOL_01 @ 0x14F8;

    reg {
        name = "Lane 2 EOL synchronization code NE2_NXT_E configuration register for frame (N + 1) in OL_23 LVDS or HiSPi mode";
        desc = "LVDS0_LANE2_NXT_EOL_23 is a lane 2 EOL synchronization code configuration register for frame (N + 1) in LVDS or HiSPi mode.

Data sheet 9.3.6 LVDS0_LANE2_NXT_EOL_23 (offset 0x14FC, printed page 9-346, `hi3516av200--Hi3516AV200-Datasheet.txt` line 57401).";

        field {
            name = "lane2_nxt_eol_3";
            desc = "Lane 2 EOL synchronization code of frame 3 in LVDS or HiSPi mode This field is configurable only in WDR mode, and the configuration is invalid in linear mode.";
            sw = rw;
            hw = r;
            reset = 0x0;
        } lane2_nxt_eol_3[31:16];

        field {
            name = "lane2_nxt_eol_2";
            desc = "Lane 2 EOL synchronization code of frame 2 in LVDS or HiSPi mode This field is configurable only in WDR mode, and the configuration is invalid in linear mode.";
            sw = rw;
            hw = r;
            reset = 0x0;
        } lane2_nxt_eol_2[15:0];
    } LVDS0_LANE2_NXT_EOL_23 @ 0x14FC;

    reg {
        name = "Lane 3 SOF synchronization code NE3_NXT_S configuration register for frame (N + 1) in OF_01 LVDS or HiSPi mode";
        desc = "LVDS0_LANE3_NXT_SOF_01 is a lane 3 SOF synchronization code configuration register for frame (N + 1) in LVDS or HiSPi mode. Hi3516A V200 Professional HD IP Camera SoC

Data sheet 9.3.6 LVDS0_LANE3_NXT_SOF_01 (offset 0x1500, printed page 9-347, `hi3516av200--Hi3516AV200-Datasheet.txt` line 57438).";

        field {
            name = "lane3_nxt_sof_1";
            desc = "Lane 3 SOF synchronization code of frame 1 in LVDS or HiSPi mode This field is configurable only in WDR mode, and the configuration is invalid in linear mode.";
            sw = rw;
            hw = r;
            reset = 0x0;
        } lane3_nxt_sof_1[31:16];

        field {
            name = "lane3_nxt_sof_0";
            desc = "Lane 3 SOF synchronization code of frame 0 in LVDS or HiSPi mode In WDR mode, the value is the SOF of frame 0. In linear mode, the value is the SOF.";
            sw = rw;
            hw = r;
            reset = 0x0;
        } lane3_nxt_sof_0[15:0];
    } LVDS0_LANE3_NXT_SOF_01 @ 0x1500;

    reg {
        name = "Lane 3 SOF synchronization code NE3_NXT_S configuration register for frame (N + 1) in OF_23 LVDS or HiSPi mode";
        desc = "LVDS0_LANE3_NXT_SOF_23 is a lane 3 SOF synchronization code configuration register for frame (N + 1) in LVDS or HiSPi mode.

Data sheet 9.3.6 LVDS0_LANE3_NXT_SOF_23 (offset 0x1504, printed page 9-347, `hi3516av200--Hi3516AV200-Datasheet.txt` line 57466).";

        field {
            name = "lane3_nxt_sof_3";
            desc = "Lane 3 SOF synchronization code of frame 3 in LVDS or HiSPi mode This field is configurable only in WDR mode, and the configuration is invalid in linear mode.";
            sw = rw;
            hw = r;
            reset = 0x0;
        } lane3_nxt_sof_3[31:16];

        field {
            name = "lane3_nxt_sof_2";
            desc = "Lane 3 SOF synchronization code of frame 2 in LVDS or HiSPi mode This field is configurable only in WDR mode, and the configuration is invalid in linear mode.";
            sw = rw;
            hw = r;
            reset = 0x0;
        } lane3_nxt_sof_2[15:0];
    } LVDS0_LANE3_NXT_SOF_23 @ 0x1504;

    reg {
        name = "Lane 3 EOF synchronization code NE3_NXT_E configuration register for frame (N + 1) in OF_01 LVDS or HiSPi mode";
        desc = "LVDS0_LANE3_NXT_EOF_01 is a lane 3 EOF synchronization code configuration register for frame (N + 1) in LVDS or HiSPi mode. Hi3516A V200 Professional HD IP Camera SoC

Data sheet 9.3.6 LVDS0_LANE3_NXT_EOF_01 (offset 0x1508, printed page 9-348, `hi3516av200--Hi3516AV200-Datasheet.txt` line 57503).";

        field {
            name = "lane3_nxt_eof_1";
            desc = "Lane 3 EOF synchronization code of frame 1 in LVDS or HiSPi mode This field is configurable only in WDR mode, and the configuration is invalid in linear mode.";
            sw = rw;
            hw = r;
            reset = 0x0;
        } lane3_nxt_eof_1[31:16];

        field {
            name = "lane3_nxt_eof_0";
            desc = "Lane 3 EOF synchronization code of frame 0 in LVDS or HiSPi mode In WDR mode, the value is the EOF of frame 0. In linear mode, the value is the EOF.";
            sw = rw;
            hw = r;
            reset = 0x0;
        } lane3_nxt_eof_0[15:0];
    } LVDS0_LANE3_NXT_EOF_01 @ 0x1508;

    reg {
        name = "Lane 3 EOF synchronization code NE3_NXT_E configuration register for frame (N + 1) in OF_23 LVDS or HiSPi mode";
        desc = "LVDS0_LANE3_NXT_EOF_23 is a lane 3 EOF synchronization code configuration register for frame (N + 1) in LVDS or HiSPi mode.

Data sheet 9.3.6 LVDS0_LANE3_NXT_EOF_23 (offset 0x150C, printed page 9-348, `hi3516av200--Hi3516AV200-Datasheet.txt` line 57531).";

        field {
            name = "lane3_nxt_eof_3";
            desc = "Lane 3 EOF synchronization code of frame 3 in LVDS or HiSPi mode This field is configurable only in WDR mode, and the configuration is invalid in linear mode.";
            sw = rw;
            hw = r;
            reset = 0x0;
        } lane3_nxt_eof_3[31:16];

        field {
            name = "lane3_nxt_eof_2";
            desc = "Lane 3 EOF synchronization code of frame 2 in LVDS or HiSPi mode This field is configurable only in WDR mode, and the configuration is invalid in linear mode.";
            sw = rw;
            hw = r;
            reset = 0x0;
        } lane3_nxt_eof_2[15:0];
    } LVDS0_LANE3_NXT_EOF_23 @ 0x150C;

    reg {
        name = "Lane 3 SOL synchronization code NE3_NXT_S configuration register for frame (N + 1) in OL_01 LVDS or HiSPi mode";
        desc = "LVDS0_LANE3_NXT_SOL_01 is a lane 3 SOL synchronization code configuration register for frame (N + 1) in LVDS or HiSPi mode. Hi3516A V200 Professional HD IP Camera SoC

Data sheet 9.3.6 LVDS0_LANE3_NXT_SOL_01 (offset 0x1510, printed page 9-349, `hi3516av200--Hi3516AV200-Datasheet.txt` line 57568).";

        field {
            name = "lane3_nxt_sol_1";
            desc = "Lane 3 SOL synchronization code of frame 1 in LVDS or HiSPi mode This field is configurable only in WDR mode, and the configuration is invalid in linear mode.";
            sw = rw;
            hw = r;
            reset = 0x0;
        } lane3_nxt_sol_1[31:16];

        field {
            name = "lane3_nxt_sol_0";
            desc = "Lane 3 SOL synchronization code of frame 0 in LVDS or HiSPi mode In WDR mode, the value is the SOL of frame 0. In linear mode, the value is the SOL.";
            sw = rw;
            hw = r;
            reset = 0x0;
        } lane3_nxt_sol_0[15:0];
    } LVDS0_LANE3_NXT_SOL_01 @ 0x1510;

    reg {
        name = "Lane 3 SOL synchronization code NE3_NXT_S configuration register for frame (N + 1) in OL_23 LVDS or HiSPi mode";
        desc = "LVDS0_LANE3_NXT_SOL_23 is a lane 3 SOL synchronization code configuration register for frame (N + 1) in LVDS or HiSPi mode.

Data sheet 9.3.6 LVDS0_LANE3_NXT_SOL_23 (offset 0x1514, printed page 9-349, `hi3516av200--Hi3516AV200-Datasheet.txt` line 57596).";

        field {
            name = "lane3_nxt_sol_3";
            desc = "Lane 3 SOL synchronization code of frame 3 in LVDS or HiSPi mode This field is configurable only in WDR mode, and the configuration is invalid in linear mode.";
            sw = rw;
            hw = r;
            reset = 0x0;
        } lane3_nxt_sol_3[31:16];

        field {
            name = "lane3_nxt_sol_2";
            desc = "Lane 3 SOL synchronization code of frame 2 in LVDS or HiSPi mode This field is configurable only in WDR mode, and the configuration is invalid in linear mode.";
            sw = rw;
            hw = r;
            reset = 0x0;
        } lane3_nxt_sol_2[15:0];
    } LVDS0_LANE3_NXT_SOL_23 @ 0x1514;

    reg {
        name = "Lane 3 EOL synchronization code NE3_NXT_E configuration register for frame (N + 1) in OL_01 LVDS or HiSPi mode";
        desc = "LVDS0_LANE3_NXT_EOL_01 is a lane 3 EOL synchronization code configuration register for frame (N + 1) in LVDS or HiSPi mode. Hi3516A V200 Professional HD IP Camera SoC

Data sheet 9.3.6 LVDS0_LANE3_NXT_EOL_01 (offset 0x1518, printed page 9-350, `hi3516av200--Hi3516AV200-Datasheet.txt` line 57633).";

        field {
            name = "lane3_nxt_eol_1";
            desc = "Lane 3 EOL synchronization code of frame 1 in LVDS or HiSPi mode This field is configurable only in WDR mode, and the configuration is invalid in linear mode.";
            sw = rw;
            hw = r;
            reset = 0x0;
        } lane3_nxt_eol_1[31:16];

        field {
            name = "lane3_nxt_eol_0";
            desc = "Lane 3 EOL synchronization code of frame 0 in LVDS or HiSPi mode In WDR mode, the value is the EOL of frame 0. In linear mode, the value is the EOL.";
            sw = rw;
            hw = r;
            reset = 0x0;
        } lane3_nxt_eol_0[15:0];
    } LVDS0_LANE3_NXT_EOL_01 @ 0x1518;

    reg {
        name = "Lane 3 EOL synchronization code NE3_NXT_E configuration register for frame (N + 1) in OL_23 LVDS or HiSPi mode";
        desc = "LVDS0_LANE3_NXT_EOL_23 is a lane 3 EOL synchronization code configuration register for frame (N + 1) in LVDS or HiSPi mode.

Data sheet 9.3.6 LVDS0_LANE3_NXT_EOL_23 (offset 0x151C, printed page 9-350, `hi3516av200--Hi3516AV200-Datasheet.txt` line 57661).";

        field {
            name = "lane3_nxt_eol_3";
            desc = "Lane 3 EOL synchronization code of frame 3 in LVDS or HiSPi mode This field is configurable only in WDR mode, and the configuration is invalid in linear mode.";
            sw = rw;
            hw = r;
            reset = 0x0;
        } lane3_nxt_eol_3[31:16];

        field {
            name = "lane3_nxt_eol_2";
            desc = "Lane 3 EOL synchronization code of frame 2 in LVDS or HiSPi mode This field is configurable only in WDR mode, and the configuration is invalid in linear mode.";
            sw = rw;
            hw = r;
            reset = 0x0;
        } lane3_nxt_eol_2[15:0];
    } LVDS0_LANE3_NXT_EOL_23 @ 0x151C;

    reg {
        name = "Lane 4 SOF synchronization code NE4_NXT_S configuration register for frame (N + 1) in OF_01 LVDS or HiSPi mode";
        desc = "LVDS0_LANE4_NXT_SOF_01 is a lane 4 SOF synchronization code configuration register for frame (N + 1) in LVDS or HiSPi mode. Hi3516A V200 Professional HD IP Camera SoC

Data sheet 9.3.6 LVDS0_LANE4_NXT_SOF_01 (offset 0x1520, printed page 9-351, `hi3516av200--Hi3516AV200-Datasheet.txt` line 57698).";

        field {
            name = "lane4_nxt_sof_1";
            desc = "Lane 4 SOF synchronization code of frame 1 in LVDS or HiSPi mode This field is configurable only in WDR mode, and the configuration is invalid in linear mode.";
            sw = rw;
            hw = r;
            reset = 0x0;
        } lane4_nxt_sof_1[31:16];

        field {
            name = "lane4_nxt_sof_0";
            desc = "Lane 4 SOF synchronization code of frame 0 in LVDS or HiSPi mode In WDR mode, the value is the SOF of frame 0. In linear mode, the value is the SOF.";
            sw = rw;
            hw = r;
            reset = 0x0;
        } lane4_nxt_sof_0[15:0];
    } LVDS0_LANE4_NXT_SOF_01 @ 0x1520;

    reg {
        name = "Lane 4 SOF synchronization code NE4_NXT_S configuration register for frame (N + 1) in OF_23 LVDS or HiSPi mode";
        desc = "LVDS0_LANE4_NXT_SOF_23 is a lane 4 SOF synchronization code configuration register for frame (N + 1) in LVDS or HiSPi mode.

Data sheet 9.3.6 LVDS0_LANE4_NXT_SOF_23 (offset 0x1524, printed page 9-351, `hi3516av200--Hi3516AV200-Datasheet.txt` line 57726).";

        field {
            name = "lane4_nxt_sof_3";
            desc = "Lane 4 SOF synchronization code of frame 3 in LVDS or HiSPi mode This field is configurable only in WDR mode, and the configuration is invalid in linear mode.";
            sw = rw;
            hw = r;
            reset = 0x0;
        } lane4_nxt_sof_3[31:16];

        field {
            name = "lane4_nxt_sof_2";
            desc = "Lane 4 SOF synchronization code of frame 2 in LVDS or HiSPi mode This field is configurable only in WDR mode, and the configuration is invalid in linear mode.";
            sw = rw;
            hw = r;
            reset = 0x0;
        } lane4_nxt_sof_2[15:0];
    } LVDS0_LANE4_NXT_SOF_23 @ 0x1524;

    reg {
        name = "Lane 4 EOF synchronization code NE4_NXT_E configuration register for frame (N + 1) in OF_01 LVDS or HiSPi mode";
        desc = "LVDS0_LANE4_NXT_EOF_01 is a lane 4 EOF synchronization code configuration register for frame (N + 1) in LVDS or HiSPi mode. Hi3516A V200 Professional HD IP Camera SoC

Data sheet 9.3.6 LVDS0_LANE4_NXT_EOF_01 (offset 0x1528, printed page 9-352, `hi3516av200--Hi3516AV200-Datasheet.txt` line 57763).";

        field {
            name = "lane4_nxt_eof_1";
            desc = "Lane 4 EOF synchronization code of frame 1 in LVDS or HiSPi mode This field is configurable only in WDR mode, and the configuration is invalid in linear mode.";
            sw = rw;
            hw = r;
            reset = 0x0;
        } lane4_nxt_eof_1[31:16];

        field {
            name = "lane4_nxt_eof_0";
            desc = "Lane 4 EOF synchronization code of frame 0 in LVDS or HiSPi mode In WDR mode, the value is the EOF of frame 0. In linear mode, the value is the EOF.";
            sw = rw;
            hw = r;
            reset = 0x0;
        } lane4_nxt_eof_0[15:0];
    } LVDS0_LANE4_NXT_EOF_01 @ 0x1528;

    reg {
        name = "Lane 4 EOF synchronization code NE4_NXT_E configuration register for frame (N + 1) in OF_23 LVDS or HiSPi mode";
        desc = "LVDS0_LANE4_NXT_EOF_23 is a lane 4 EOF synchronization code configuration register for frame (N + 1) in LVDS or HiSPi mode.

Data sheet 9.3.6 LVDS0_LANE4_NXT_EOF_23 (offset 0x152C, printed page 9-352, `hi3516av200--Hi3516AV200-Datasheet.txt` line 57791).";

        field {
            name = "lane4_nxt_eof_3";
            desc = "Lane 4 EOF synchronization code of frame 3 in LVDS or HiSPi mode This field is configurable only in WDR mode, and the configuration is invalid in linear mode.";
            sw = rw;
            hw = r;
            reset = 0x0;
        } lane4_nxt_eof_3[31:16];

        field {
            name = "lane4_nxt_eof_2";
            desc = "Lane 4 EOF synchronization code of frame 2 in LVDS or HiSPi mode This field is configurable only in WDR mode, and the configuration is invalid in linear mode.";
            sw = rw;
            hw = r;
            reset = 0x0;
        } lane4_nxt_eof_2[15:0];
    } LVDS0_LANE4_NXT_EOF_23 @ 0x152C;

    reg {
        name = "Lane 4 SOL synchronization code NE4_NXT_S configuration register for frame (N + 1) in OL_01 LVDS or HiSPi mode";
        desc = "LVDS0_LANE4_NXT_SOL_01 is a lane 4 SOL synchronization code configuration register for frame (N + 1) in LVDS or HiSPi mode. Hi3516A V200 Professional HD IP Camera SoC

Data sheet 9.3.6 LVDS0_LANE4_NXT_SOL_01 (offset 0x1530, printed page 9-353, `hi3516av200--Hi3516AV200-Datasheet.txt` line 57828).";

        field {
            name = "lane4_nxt_sol_1";
            desc = "Lane 4 SOL synchronization code of frame 1 in LVDS or HiSPi mode This field is configurable only in WDR mode, and the configuration is invalid in linear mode.";
            sw = rw;
            hw = r;
            reset = 0x0;
        } lane4_nxt_sol_1[31:16];

        field {
            name = "lane4_nxt_sol_0";
            desc = "Lane 4 SOL synchronization code of frame 0 in LVDS or HiSPi mode In WDR mode, the value is the SOL of frame 0. In linear mode, the value is the SOL.";
            sw = rw;
            hw = r;
            reset = 0x0;
        } lane4_nxt_sol_0[15:0];
    } LVDS0_LANE4_NXT_SOL_01 @ 0x1530;

    reg {
        name = "Lane 4 SOL synchronization code NE4_NXT_S configuration register for frame (N + 1) in OL_23 LVDS or HiSPi mode";
        desc = "LVDS0_LANE4_NXT_SOL_23 is a lane 4 SOL synchronization code configuration register for frame (N + 1) in LVDS or HiSPi mode.

Data sheet 9.3.6 LVDS0_LANE4_NXT_SOL_23 (offset 0x1534, printed page 9-353, `hi3516av200--Hi3516AV200-Datasheet.txt` line 57856).";

        field {
            name = "lane4_nxt_sol_3";
            desc = "Lane 4 SOL synchronization code of frame 3 in LVDS or HiSPi mode This field is configurable only in WDR mode, and the configuration is invalid in linear mode.";
            sw = rw;
            hw = r;
            reset = 0x0;
        } lane4_nxt_sol_3[31:16];

        field {
            name = "lane4_nxt_sol_2";
            desc = "Lane 4 SOL synchronization code of frame 2 in LVDS or HiSPi mode This field is configurable only in WDR mode, and the configuration is invalid in linear mode.";
            sw = rw;
            hw = r;
            reset = 0x0;
        } lane4_nxt_sol_2[15:0];
    } LVDS0_LANE4_NXT_SOL_23 @ 0x1534;

    reg {
        name = "Lane 4 EOL synchronization code NE4_NXT_E configuration register for frame (N + 1) in OL_01 LVDS or HiSPi mode";
        desc = "LVDS0_LANE4_NXT_EOL_01 is a lane 4 EOL synchronization code configuration register for frame (N + 1) in LVDS or HiSPi mode. Hi3516A V200 Professional HD IP Camera SoC

Data sheet 9.3.6 LVDS0_LANE4_NXT_EOL_01 (offset 0x1538, printed page 9-354, `hi3516av200--Hi3516AV200-Datasheet.txt` line 57893).";

        field {
            name = "lane4_nxt_eol_1";
            desc = "Lane 4 EOL synchronization code of frame 1 in LVDS or HiSPi mode This field is configurable only in WDR mode, and the configuration is invalid in linear mode.";
            sw = rw;
            hw = r;
            reset = 0x0;
        } lane4_nxt_eol_1[31:16];

        field {
            name = "lane4_nxt_eol_0";
            desc = "Lane 4 EOL synchronization code of frame 0 in LVDS or HiSPi mode In WDR mode, the value is the EOL of frame 0. In linear mode, the value is the EOL.";
            sw = rw;
            hw = r;
            reset = 0x0;
        } lane4_nxt_eol_0[15:0];
    } LVDS0_LANE4_NXT_EOL_01 @ 0x1538;

    reg {
        name = "Lane 4 EOL synchronization code NE4_NXT_E configuration register for frame (N + 1) in OL_23 LVDS or HiSPi mode";
        desc = "LVDS0_LANE4_NXT_EOL_23 is a lane 4 EOL synchronization code configuration register for frame (N + 1) in LVDS or HiSPi mode.

Data sheet 9.3.6 LVDS0_LANE4_NXT_EOL_23 (offset 0x153C, printed page 9-354, `hi3516av200--Hi3516AV200-Datasheet.txt` line 57921).";

        field {
            name = "lane4_nxt_eol_3";
            desc = "Lane 4 EOL synchronization code of frame 3 in LVDS or HiSPi mode This field is configurable only in WDR mode, and the configuration is invalid in linear mode.";
            sw = rw;
            hw = r;
            reset = 0x0;
        } lane4_nxt_eol_3[31:16];

        field {
            name = "lane4_nxt_eol_2";
            desc = "Lane 4 EOL synchronization code of frame 2 in LVDS or HiSPi mode This field is configurable only in WDR mode, and the configuration is invalid in linear mode.";
            sw = rw;
            hw = r;
            reset = 0x0;
        } lane4_nxt_eol_2[15:0];
    } LVDS0_LANE4_NXT_EOL_23 @ 0x153C;

    reg {
        name = "Lane 5 SOF synchronization code NE5_NXT_S configuration register for frame (N + 1) in OF_01 LVDS or HiSPi mode";
        desc = "LVDS0_LANE5_NXT_SOF_01 is a lane 5 SOF synchronization code configuration register for frame (N + 1) in LVDS or HiSPi mode. Hi3516A V200 Professional HD IP Camera SoC

Data sheet 9.3.6 LVDS0_LANE5_NXT_SOF_01 (offset 0x1540, printed page 9-355, `hi3516av200--Hi3516AV200-Datasheet.txt` line 57958).";

        field {
            name = "lane5_nxt_sof_1";
            desc = "Lane 5 SOF synchronization code of frame 1 in LVDS or HiSPi mode This field is configurable only in WDR mode, and the configuration is invalid in linear mode.";
            sw = rw;
            hw = r;
            reset = 0x0;
        } lane5_nxt_sof_1[31:16];

        field {
            name = "lane5_nxt_sof_0";
            desc = "Lane 5 SOF synchronization code of frame 0 in LVDS or HiSPi mode In WDR mode, the value is the SOF of frame 0. In linear mode, the value is the SOF.";
            sw = rw;
            hw = r;
            reset = 0x0;
        } lane5_nxt_sof_0[15:0];
    } LVDS0_LANE5_NXT_SOF_01 @ 0x1540;

    reg {
        name = "Lane 5 SOF synchronization code NE5_NXT_S configuration register for frame (N + 1) in OF_23 LVDS or HiSPi mode";
        desc = "LVDS0_LANE5_NXT_SOF_23 is a lane 5 SOF synchronization code configuration register for frame (N + 1) in LVDS or HiSPi mode.

Data sheet 9.3.6 LVDS0_LANE5_NXT_SOF_23 (offset 0x1544, printed page 9-355, `hi3516av200--Hi3516AV200-Datasheet.txt` line 57986).";

        field {
            name = "lane5_nxt_sof_3";
            desc = "Lane 5 SOF synchronization code of frame 3 in LVDS or HiSPi mode This field is configurable only in WDR mode, and the configuration is invalid in linear mode.";
            sw = rw;
            hw = r;
            reset = 0x0;
        } lane5_nxt_sof_3[31:16];

        field {
            name = "lane5_nxt_sof_2";
            desc = "Lane 5 SOF synchronization code of frame 2 in LVDS or HiSPi mode This field is configurable only in WDR mode, and the configuration is invalid in linear mode.";
            sw = rw;
            hw = r;
            reset = 0x0;
        } lane5_nxt_sof_2[15:0];
    } LVDS0_LANE5_NXT_SOF_23 @ 0x1544;

    reg {
        name = "Lane 5 EOF synchronization code NE5_NXT_E configuration register for frame (N + 1) in OF_01 LVDS or HiSPi mode";
        desc = "LVDS0_LANE5_NXT_EOF_01 is a lane 5 EOF synchronization code configuration register for frame (N + 1) in LVDS or HiSPi mode. Hi3516A V200 Professional HD IP Camera SoC

Data sheet 9.3.6 LVDS0_LANE5_NXT_EOF_01 (offset 0x1548, printed page 9-356, `hi3516av200--Hi3516AV200-Datasheet.txt` line 58023).";

        field {
            name = "lane5_nxt_eof_1";
            desc = "Lane 5 EOF synchronization code of frame 1 in LVDS or HiSPi mode This field is configurable only in WDR mode, and the configuration is invalid in linear mode.";
            sw = rw;
            hw = r;
            reset = 0x0;
        } lane5_nxt_eof_1[31:16];

        field {
            name = "lane5_nxt_eof_0";
            desc = "Lane 5 EOF synchronization code of frame 0 in LVDS or HiSPi mode In WDR mode, the value is the EOF of frame 0. In linear mode, the value is the EOF.";
            sw = rw;
            hw = r;
            reset = 0x0;
        } lane5_nxt_eof_0[15:0];
    } LVDS0_LANE5_NXT_EOF_01 @ 0x1548;

    reg {
        name = "Lane 5 EOF synchronization code NE5_NXT_E configuration register for frame (N + 1) in OF_23 LVDS or HiSPi mode";
        desc = "LVDS0_LANE5_NXT_EOF_23 is a lane 5 EOF synchronization code configuration register for frame (N + 1) in LVDS or HiSPi mode.

Data sheet 9.3.6 LVDS0_LANE5_NXT_EOF_23 (offset 0x154C, printed page 9-356, `hi3516av200--Hi3516AV200-Datasheet.txt` line 58051).";

        field {
            name = "lane5_nxt_eof_3";
            desc = "Lane 5 EOF synchronization code of frame 3 in LVDS or HiSPi mode This field is configurable only in WDR mode, and the configuration is invalid in linear mode.";
            sw = rw;
            hw = r;
            reset = 0x0;
        } lane5_nxt_eof_3[31:16];

        field {
            name = "lane5_nxt_eof_2";
            desc = "Lane 5 EOF synchronization code of frame 2 in LVDS or HiSPi mode This field is configurable only in WDR mode, and the configuration is invalid in linear mode.";
            sw = rw;
            hw = r;
            reset = 0x0;
        } lane5_nxt_eof_2[15:0];
    } LVDS0_LANE5_NXT_EOF_23 @ 0x154C;

    reg {
        name = "Lane 5 SOL synchronization code NE5_NXT_S configuration register for frame (N + 1) in OL_01 LVDS or HiSPi mode";
        desc = "LVDS0_LANE5_NXT_SOL_01 is a lane 5 SOL synchronization code configuration register for frame (N + 1) in LVDS or HiSPi mode. Hi3516A V200 Professional HD IP Camera SoC

Data sheet 9.3.6 LVDS0_LANE5_NXT_SOL_01 (offset 0x1550, printed page 9-357, `hi3516av200--Hi3516AV200-Datasheet.txt` line 58088).";

        field {
            name = "lane5_nxt_sol_1";
            desc = "Lane 5 SOL synchronization code of frame 1 in LVDS or HiSPi mode This field is configurable only in WDR mode, and the configuration is invalid in linear mode.";
            sw = rw;
            hw = r;
            reset = 0x0;
        } lane5_nxt_sol_1[31:16];

        field {
            name = "lane5_nxt_sol_0";
            desc = "Lane 5 SOL synchronization code of frame 0 in LVDS or HiSPi mode In WDR mode, the value is the SOL of frame 0. In linear mode, the value is the SOL.";
            sw = rw;
            hw = r;
            reset = 0x0;
        } lane5_nxt_sol_0[15:0];
    } LVDS0_LANE5_NXT_SOL_01 @ 0x1550;

    reg {
        name = "Lane 5 SOL synchronization code NE5_NXT_S configuration register for frame (N + 1) in OL_23 LVDS or HiSPi mode";
        desc = "LVDS0_LANE5_NXT_SOL_23 is a lane 5 SOL synchronization code configuration register for frame (N + 1) in LVDS or HiSPi mode.

Data sheet 9.3.6 LVDS0_LANE5_NXT_SOL_23 (offset 0x1554, printed page 9-357, `hi3516av200--Hi3516AV200-Datasheet.txt` line 58116).";

        field {
            name = "lane5_nxt_sol_3";
            desc = "Lane 5 SOL synchronization code of frame 3 in LVDS or HiSPi mode This field is configurable only in WDR mode, and the configuration is invalid in linear mode.";
            sw = rw;
            hw = r;
            reset = 0x0;
        } lane5_nxt_sol_3[31:16];

        field {
            name = "lane5_nxt_sol_2";
            desc = "Lane 5 SOL synchronization code of frame 2 in LVDS or HiSPi mode This field is configurable only in WDR mode, and the configuration is invalid in linear mode.";
            sw = rw;
            hw = r;
            reset = 0x0;
        } lane5_nxt_sol_2[15:0];
    } LVDS0_LANE5_NXT_SOL_23 @ 0x1554;

    reg {
        name = "Lane 5 EOL synchronization code NE5_NXT_E configuration register for frame (N + 1) in OL_01 LVDS or HiSPi mode";
        desc = "LVDS0_LANE5_NXT_EOL_01 is a lane 5 EOL synchronization code configuration register for frame (N + 1) in LVDS or HiSPi mode. Hi3516A V200 Professional HD IP Camera SoC

Data sheet 9.3.6 LVDS0_LANE5_NXT_EOL_01 (offset 0x1558, printed page 9-358, `hi3516av200--Hi3516AV200-Datasheet.txt` line 58153).";

        field {
            name = "lane5_nxt_eol_1";
            desc = "Lane 5 EOL synchronization code of frame 1 in LVDS or HiSPi mode This field is configurable only in WDR mode, and the configuration is invalid in linear mode.";
            sw = rw;
            hw = r;
            reset = 0x0;
        } lane5_nxt_eol_1[31:16];

        field {
            name = "lane5_nxt_eol_0";
            desc = "Lane 5 EOL synchronization code of frame 0 in LVDS or HiSPi mode In WDR mode, the value is the EOL of frame 0. In linear mode, the value is the EOL.";
            sw = rw;
            hw = r;
            reset = 0x0;
        } lane5_nxt_eol_0[15:0];
    } LVDS0_LANE5_NXT_EOL_01 @ 0x1558;

    reg {
        name = "Lane 5 EOL synchronization code NE5_NXT_E configuration register for frame (N + 1) in OL_23 LVDS or HiSPi mode";
        desc = "LVDS0_LANE5_NXT_EOL_23 is a lane 5 EOL synchronization code configuration register for frame (N + 1) in LVDS or HiSPi mode.

Data sheet 9.3.6 LVDS0_LANE5_NXT_EOL_23 (offset 0x155C, printed page 9-358, `hi3516av200--Hi3516AV200-Datasheet.txt` line 58181).";

        field {
            name = "lane5_nxt_eol_3";
            desc = "Lane 5 EOL synchronization code of frame 3 in LVDS or HiSPi mode This field is configurable only in WDR mode, and the configuration is invalid in linear mode.";
            sw = rw;
            hw = r;
            reset = 0x0;
        } lane5_nxt_eol_3[31:16];

        field {
            name = "lane5_nxt_eol_2";
            desc = "Lane 5 EOL synchronization code of frame 2 in LVDS or HiSPi mode This field is configurable only in WDR mode, and the configuration is invalid in linear mode.";
            sw = rw;
            hw = r;
            reset = 0x0;
        } lane5_nxt_eol_2[15:0];
    } LVDS0_LANE5_NXT_EOL_23 @ 0x155C;

    reg {
        name = "Lane 6 SOF synchronization code NE6_NXT_S configuration register for frame (N + 1) in OF_01 LVDS or HiSPi mode";
        desc = "LVDS0_LANE6_NXT_SOF_01 is a lane 6 SOF synchronization code configuration register for frame (N + 1) in LVDS or HiSPi mode. Hi3516A V200 Professional HD IP Camera SoC

Data sheet 9.3.6 LVDS0_LANE6_NXT_SOF_01 (offset 0x1560, printed page 9-359, `hi3516av200--Hi3516AV200-Datasheet.txt` line 58218).";

        field {
            name = "lane6_nxt_sof_1";
            desc = "Lane 6 SOF synchronization code of frame 1 in LVDS or HiSPi mode This field is configurable only in WDR mode, and the configuration is invalid in linear mode.";
            sw = rw;
            hw = r;
            reset = 0x0;
        } lane6_nxt_sof_1[31:16];

        field {
            name = "lane6_nxt_sof_0";
            desc = "Lane 6 SOF synchronization code of frame 0 in LVDS or HiSPi mode In WDR mode, the value is the SOF of frame 0. In linear mode, the value is the SOF.";
            sw = rw;
            hw = r;
            reset = 0x0;
        } lane6_nxt_sof_0[15:0];
    } LVDS0_LANE6_NXT_SOF_01 @ 0x1560;

    reg {
        name = "Lane 6 SOF synchronization code NE6_NXT_S configuration register for frame (N + 1) in OF_23 LVDS or HiSPi mode";
        desc = "LVDS0_LANE6_NXT_SOF_23 is a lane 6 SOF synchronization code configuration register for frame (N + 1) in LVDS or HiSPi mode.

Data sheet 9.3.6 LVDS0_LANE6_NXT_SOF_23 (offset 0x1564, printed page 9-359, `hi3516av200--Hi3516AV200-Datasheet.txt` line 58246).";

        field {
            name = "lane6_nxt_sof_3";
            desc = "Lane 6 SOF synchronization code of frame 3 in LVDS or HiSPi mode This field is configurable only in WDR mode, and the configuration is invalid in linear mode.";
            sw = rw;
            hw = r;
            reset = 0x0;
        } lane6_nxt_sof_3[31:16];

        field {
            name = "lane6_nxt_sof_2";
            desc = "Lane 6 SOF synchronization code of frame 2 in LVDS or HiSPi mode This field is configurable only in WDR mode, and the configuration is invalid in linear mode.";
            sw = rw;
            hw = r;
            reset = 0x0;
        } lane6_nxt_sof_2[15:0];
    } LVDS0_LANE6_NXT_SOF_23 @ 0x1564;

    reg {
        name = "Lane 6 EOF synchronization code NE6_NXT_E configuration register for frame (N + 1) in OF_01 LVDS or HiSPi mode";
        desc = "LVDS0_LANE6_NXT_EOF_01 is a lane 6 EOF synchronization code configuration register for frame (N + 1) in LVDS or HiSPi mode. Hi3516A V200 Professional HD IP Camera SoC

Data sheet 9.3.6 LVDS0_LANE6_NXT_EOF_01 (offset 0x1568, printed page 9-360, `hi3516av200--Hi3516AV200-Datasheet.txt` line 58283).";

        field {
            name = "lane6_nxt_eof_1";
            desc = "Lane 6 EOF synchronization code of frame 1 in LVDS or HiSPi mode This field is configurable only in WDR mode, and the configuration is invalid in linear mode.";
            sw = rw;
            hw = r;
            reset = 0x0;
        } lane6_nxt_eof_1[31:16];

        field {
            name = "lane6_nxt_eof_0";
            desc = "Lane 6 EOF synchronization code of frame 0 in LVDS or HiSPi mode In WDR mode, the value is the EOF of frame 0. In linear mode, the value is the EOF.";
            sw = rw;
            hw = r;
            reset = 0x0;
        } lane6_nxt_eof_0[15:0];
    } LVDS0_LANE6_NXT_EOF_01 @ 0x1568;

    reg {
        name = "Lane 6 EOF synchronization code NE6_NXT_E configuration register for frame (N + 1) in OF_23 LVDS or HiSPi mode";
        desc = "LVDS0_LANE6_NXT_EOF_23 is a lane 6 EOF synchronization code configuration register for frame (N + 1) in LVDS or HiSPi mode.

Data sheet 9.3.6 LVDS0_LANE6_NXT_EOF_23 (offset 0x156C, printed page 9-360, `hi3516av200--Hi3516AV200-Datasheet.txt` line 58311).";

        field {
            name = "lane6_nxt_eof_3";
            desc = "Lane 6 EOF synchronization code of frame 3 in LVDS or HiSPi mode This field is configurable only in WDR mode, and the configuration is invalid in linear mode.";
            sw = rw;
            hw = r;
            reset = 0x0;
        } lane6_nxt_eof_3[31:16];

        field {
            name = "lane6_nxt_eof_2";
            desc = "Lane 6 EOF synchronization code of frame 2 in LVDS or HiSPi mode This field is configurable only in WDR mode, and the configuration is invalid in linear mode.";
            sw = rw;
            hw = r;
            reset = 0x0;
        } lane6_nxt_eof_2[15:0];
    } LVDS0_LANE6_NXT_EOF_23 @ 0x156C;

    reg {
        name = "Lane 6 SOL synchronization code NE6_NXT_S configuration register for frame (N + 1) in OL_01 LVDS or HiSPi mode";
        desc = "LVDS0_LANE6_NXT_SOL_01 is a lane 6 SOL synchronization code configuration register for frame (N + 1) in LVDS or HiSPi mode. Hi3516A V200 Professional HD IP Camera SoC

Data sheet 9.3.6 LVDS0_LANE6_NXT_SOL_01 (offset 0x1570, printed page 9-361, `hi3516av200--Hi3516AV200-Datasheet.txt` line 58348).";

        field {
            name = "lane6_nxt_sol_1";
            desc = "Lane 6 SOL synchronization code of frame 1 in LVDS or HiSPi mode This field is configurable only in WDR mode, and the configuration is invalid in linear mode.";
            sw = rw;
            hw = r;
            reset = 0x0;
        } lane6_nxt_sol_1[31:16];

        field {
            name = "lane6_nxt_sol_0";
            desc = "Lane 6 SOL synchronization code of frame 0 in LVDS or HiSPi mode In WDR mode, the value is the SOL of frame 0. In linear mode, the value is the SOL.";
            sw = rw;
            hw = r;
            reset = 0x0;
        } lane6_nxt_sol_0[15:0];
    } LVDS0_LANE6_NXT_SOL_01 @ 0x1570;

    reg {
        name = "Lane 6 SOL synchronization code NE6_NXT_S configuration register for frame (N + 1) in OL_23 LVDS or HiSPi mode";
        desc = "LVDS0_LANE6_NXT_SOL_23 is a lane 6 SOL synchronization code configuration register for frame (N + 1) in LVDS or HiSPi mode.

Data sheet 9.3.6 LVDS0_LANE6_NXT_SOL_23 (offset 0x1574, printed page 9-361, `hi3516av200--Hi3516AV200-Datasheet.txt` line 58376).";

        field {
            name = "lane6_nxt_sol_3";
            desc = "Lane 6 SOL synchronization code of frame 3 in LVDS or HiSPi mode This field is configurable only in WDR mode, and the configuration is invalid in linear mode.";
            sw = rw;
            hw = r;
            reset = 0x0;
        } lane6_nxt_sol_3[31:16];

        field {
            name = "lane6_nxt_sol_2";
            desc = "Lane 6 SOL synchronization code of frame 2 in LVDS or HiSPi mode This field is configurable only in WDR mode, and the configuration is invalid in linear mode.";
            sw = rw;
            hw = r;
            reset = 0x0;
        } lane6_nxt_sol_2[15:0];
    } LVDS0_LANE6_NXT_SOL_23 @ 0x1574;

    reg {
        name = "Lane 6 EOL synchronization code NE6_NXT_E configuration register for frame (N + 1) in OL_01 LVDS or HiSPi mode";
        desc = "LVDS0_LANE6_NXT_EOL_01 is a lane 6 EOL synchronization code configuration register for frame (N + 1) in LVDS or HiSPi mode. Hi3516A V200 Professional HD IP Camera SoC

Data sheet 9.3.6 LVDS0_LANE6_NXT_EOL_01 (offset 0x1578, printed page 9-362, `hi3516av200--Hi3516AV200-Datasheet.txt` line 58413).";

        field {
            name = "lane6_nxt_eol_1";
            desc = "Lane 6 EOL synchronization code of frame 1 in LVDS or HiSPi mode This field is configurable only in WDR mode, and the configuration is invalid in linear mode.";
            sw = rw;
            hw = r;
            reset = 0x0;
        } lane6_nxt_eol_1[31:16];

        field {
            name = "lane6_nxt_eol_0";
            desc = "Lane 6 EOL synchronization code of frame 0 in LVDS or HiSPi mode In WDR mode, the value is the EOL of frame 0. In linear mode, the value is the EOL.";
            sw = rw;
            hw = r;
            reset = 0x0;
        } lane6_nxt_eol_0[15:0];
    } LVDS0_LANE6_NXT_EOL_01 @ 0x1578;

    reg {
        name = "Lane 6 EOL synchronization code NE6_NXT_E configuration register for frame (N + 1) in OL_23 LVDS or HiSPi mode";
        desc = "LVDS0_LANE6_NXT_EOL_23 is a lane 6 EOL synchronization code configuration register for frame (N + 1) in LVDS or HiSPi mode.

Data sheet 9.3.6 LVDS0_LANE6_NXT_EOL_23 (offset 0x157C, printed page 9-362, `hi3516av200--Hi3516AV200-Datasheet.txt` line 58441).";

        field {
            name = "lane6_nxt_eol_3";
            desc = "Lane 6 EOL synchronization code of frame 3 in LVDS or HiSPi mode This field is configurable only in WDR mode, and the configuration is invalid in linear mode.";
            sw = rw;
            hw = r;
            reset = 0x0;
        } lane6_nxt_eol_3[31:16];

        field {
            name = "lane6_nxt_eol_2";
            desc = "Lane 6 EOL synchronization code of frame 2 in LVDS or HiSPi mode This field is configurable only in WDR mode, and the configuration is invalid in linear mode.";
            sw = rw;
            hw = r;
            reset = 0x0;
        } lane6_nxt_eol_2[15:0];
    } LVDS0_LANE6_NXT_EOL_23 @ 0x157C;

    reg {
        name = "Lane 7 SOF synchronization code NE7_NXT_S configuration register for frame (N + 1) in OF_01 LVDS or HiSPi mode";
        desc = "LVDS0_LANE7_NXT_SOF_01 is a lane 7 SOF synchronization code configuration register for frame (N + 1) in LVDS or HiSPi mode. Hi3516A V200 Professional HD IP Camera SoC

Data sheet 9.3.6 LVDS0_LANE7_NXT_SOF_01 (offset 0x1580, printed page 9-363, `hi3516av200--Hi3516AV200-Datasheet.txt` line 58478).";

        field {
            name = "lane7_nxt_sof_1";
            desc = "Lane 7 SOF synchronization code of frame 1 in LVDS or HiSPi mode This field is configurable only in WDR mode, and the configuration is invalid in linear mode.";
            sw = rw;
            hw = r;
            reset = 0x0;
        } lane7_nxt_sof_1[31:16];

        field {
            name = "lane7_nxt_sof_0";
            desc = "Lane 7 SOF synchronization code of frame 0 in LVDS or HiSPi mode In WDR mode, the value is the SOF of frame 0. In linear mode, the value is the SOF.";
            sw = rw;
            hw = r;
            reset = 0x0;
        } lane7_nxt_sof_0[15:0];
    } LVDS0_LANE7_NXT_SOF_01 @ 0x1580;

    reg {
        name = "Lane 7 SOF synchronization code NE7_NXT_S configuration register for frame (N + 1) in OF_23 LVDS or HiSPi mode";
        desc = "LVDS0_LANE7_NXT_SOF_23 is a lane 7 SOF synchronization code configuration register for frame (N + 1) in LVDS or HiSPi mode.

Data sheet 9.3.6 LVDS0_LANE7_NXT_SOF_23 (offset 0x1584, printed page 9-363, `hi3516av200--Hi3516AV200-Datasheet.txt` line 58506).";

        field {
            name = "lane7_nxt_sof_3";
            desc = "Lane 7 SOF synchronization code of frame 3 in LVDS or HiSPi mode This field is configurable only in WDR mode, and the configuration is invalid in linear mode.";
            sw = rw;
            hw = r;
            reset = 0x0;
        } lane7_nxt_sof_3[31:16];

        field {
            name = "lane7_nxt_sof_2";
            desc = "Lane 7 SOF synchronization code of frame 2 in LVDS or HiSPi mode This field is configurable only in WDR mode, and the configuration is invalid in linear mode.";
            sw = rw;
            hw = r;
            reset = 0x0;
        } lane7_nxt_sof_2[15:0];
    } LVDS0_LANE7_NXT_SOF_23 @ 0x1584;

    reg {
        name = "Lane 7 EOF synchronization code NE7_NXT_E configuration register for frame (N + 1) in OF_01 LVDS or HiSPi mode";
        desc = "LVDS0_LANE7_NXT_EOF_01 is a lane 7 EOF synchronization code configuration register for frame (N + 1) in LVDS or HiSPi mode. Hi3516A V200 Professional HD IP Camera SoC

Data sheet 9.3.6 LVDS0_LANE7_NXT_EOF_01 (offset 0x1588, printed page 9-364, `hi3516av200--Hi3516AV200-Datasheet.txt` line 58543).";

        field {
            name = "lane7_nxt_eof_1";
            desc = "Lane 7 EOF synchronization code of frame 1 in LVDS or HiSPi mode This field is configurable only in WDR mode, and the configuration is invalid in linear mode.";
            sw = rw;
            hw = r;
            reset = 0x0;
        } lane7_nxt_eof_1[31:16];

        field {
            name = "lane7_nxt_eof_0";
            desc = "Lane 7 EOF synchronization code of frame 0 in LVDS or HiSPi mode In WDR mode, the value is the EOF of frame 0. In linear mode, the value is the EOF.";
            sw = rw;
            hw = r;
            reset = 0x0;
        } lane7_nxt_eof_0[15:0];
    } LVDS0_LANE7_NXT_EOF_01 @ 0x1588;

    reg {
        name = "Lane 7 EOF synchronization code NE7_NXT_E configuration register for frame (N + 1) in OF_23 LVDS or HiSPi mode";
        desc = "LVDS0_LANE7_NXT_EOF_23 is a lane 7 EOF synchronization code configuration register for frame (N + 1) in LVDS or HiSPi mode.

Data sheet 9.3.6 LVDS0_LANE7_NXT_EOF_23 (offset 0x158C, printed page 9-364, `hi3516av200--Hi3516AV200-Datasheet.txt` line 58571).";

        field {
            name = "lane7_nxt_eof_3";
            desc = "Lane 7 EOF synchronization code of frame 3 in LVDS or HiSPi mode This field is configurable only in WDR mode, and the configuration is invalid in linear mode.";
            sw = rw;
            hw = r;
            reset = 0x0;
        } lane7_nxt_eof_3[31:16];

        field {
            name = "lane7_nxt_eof_2";
            desc = "Lane 7 EOF synchronization code of frame 2 in LVDS or HiSPi mode This field is configurable only in WDR mode, and the configuration is invalid in linear mode.";
            sw = rw;
            hw = r;
            reset = 0x0;
        } lane7_nxt_eof_2[15:0];
    } LVDS0_LANE7_NXT_EOF_23 @ 0x158C;

    reg {
        name = "Lane 7 SOL synchronization code NE7_NXT_S configuration register for frame (N + 1) in OL_01 LVDS or HiSPi mode";
        desc = "LVDS0_LANE7_NXT_SOL_01 is a lane 7 SOL synchronization code configuration register for frame (N + 1) in LVDS or HiSPi mode. Hi3516A V200 Professional HD IP Camera SoC

Data sheet 9.3.6 LVDS0_LANE7_NXT_SOL_01 (offset 0x1590, printed page 9-365, `hi3516av200--Hi3516AV200-Datasheet.txt` line 58608).";

        field {
            name = "lane7_nxt_sol_1";
            desc = "Lane 7 SOL synchronization code of frame 1 in LVDS or HiSPi mode This field is configurable only in WDR mode, and the configuration is invalid in linear mode.";
            sw = rw;
            hw = r;
            reset = 0x0;
        } lane7_nxt_sol_1[31:16];

        field {
            name = "lane7_nxt_sol_0";
            desc = "Lane 7 SOL synchronization code of frame 0 in LVDS or HiSPi mode In WDR mode, the value is the SOL of frame 0. In linear mode, the value is the SOL.";
            sw = rw;
            hw = r;
            reset = 0x0;
        } lane7_nxt_sol_0[15:0];
    } LVDS0_LANE7_NXT_SOL_01 @ 0x1590;

    reg {
        name = "Lane 7 SOL synchronization code NE7_NXT_S configuration register for frame (N + 1) in OL_23 LVDS or HiSPi mode";
        desc = "LVDS0_LANE7_NXT_SOL_23 is a lane 7 SOL synchronization code configuration register for frame (N + 1) in LVDS or HiSPi mode.

Data sheet 9.3.6 LVDS0_LANE7_NXT_SOL_23 (offset 0x1594, printed page 9-365, `hi3516av200--Hi3516AV200-Datasheet.txt` line 58636).";

        field {
            name = "lane7_nxt_sol_3";
            desc = "Lane 7 SOL synchronization code of frame 3 in LVDS or HiSPi mode This field is configurable only in WDR mode, and the configuration is invalid in linear mode.";
            sw = rw;
            hw = r;
            reset = 0x0;
        } lane7_nxt_sol_3[31:16];

        field {
            name = "lane7_nxt_sol_2";
            desc = "Lane 7 SOL synchronization code of frame 2 in LVDS or HiSPi mode This field is configurable only in WDR mode, and the configuration is invalid in linear mode.";
            sw = rw;
            hw = r;
            reset = 0x0;
        } lane7_nxt_sol_2[15:0];
    } LVDS0_LANE7_NXT_SOL_23 @ 0x1594;

    reg {
        name = "Lane 7 EOL synchronization code NE7_NXT_E configuration register for frame (N + 1) in OL_01 LVDS or HiSPi mode";
        desc = "LVDS0_LANE7_NXT_EOL_01 is a lane 7 EOL synchronization code configuration register for frame (N + 1) in LVDS or HiSPi mode. Hi3516A V200 Professional HD IP Camera SoC

Data sheet 9.3.6 LVDS0_LANE7_NXT_EOL_01 (offset 0x1598, printed page 9-366, `hi3516av200--Hi3516AV200-Datasheet.txt` line 58673).";

        field {
            name = "lane7_nxt_eol_1";
            desc = "Lane 7 EOL synchronization code of frame 1 in LVDS or HiSPi mode This field is configurable only in WDR mode, and the configuration is invalid in linear mode.";
            sw = rw;
            hw = r;
            reset = 0x0;
        } lane7_nxt_eol_1[31:16];

        field {
            name = "lane7_nxt_eol_0";
            desc = "Lane 7 EOL synchronization code of frame 0 in LVDS or HiSPi mode In WDR mode, the value is the EOL of frame 0. In linear mode, the value is the EOL.";
            sw = rw;
            hw = r;
            reset = 0x0;
        } lane7_nxt_eol_0[15:0];
    } LVDS0_LANE7_NXT_EOL_01 @ 0x1598;

    reg {
        name = "Lane 7 EOL synchronization code NE7_NXT_E configuration register for frame (N + 1) in OL_23 LVDS or HiSPi mode";
        desc = "LVDS0_LANE7_NXT_EOL_23 is a lane 7 EOL synchronization code configuration register for frame (N + 1) in LVDS or HiSPi mode.

Data sheet 9.3.6 LVDS0_LANE7_NXT_EOL_23 (offset 0x159C, printed page 9-366, `hi3516av200--Hi3516AV200-Datasheet.txt` line 58701).";

        field {
            name = "lane7_nxt_eol_3";
            desc = "Lane 7 EOL synchronization code of frame 3 in LVDS or HiSPi mode This field is configurable only in WDR mode, and the configuration is invalid in linear mode.";
            sw = rw;
            hw = r;
            reset = 0x0;
        } lane7_nxt_eol_3[31:16];

        field {
            name = "lane7_nxt_eol_2";
            desc = "Lane 7 EOL synchronization code of frame 2 in LVDS or HiSPi mode This field is configurable only in WDR mode, and the configuration is invalid in linear mode.";
            sw = rw;
            hw = r;
            reset = 0x0;
        } lane7_nxt_eol_2[15:0];
    } LVDS0_LANE7_NXT_EOL_23 @ 0x159C;

    reg {
        name = "Lane 8 SOF synchronization code NE8_NXT_S configuration register for frame (N + 1) in OF_01 LVDS or HiSPi mode";
        desc = "LVDS0_LANE8_NXT_SOF_01 is a lane 8 SOF synchronization code configuration register for frame (N + 1) in LVDS or HiSPi mode. Hi3516A V200 Professional HD IP Camera SoC

Data sheet 9.3.6 LVDS0_LANE8_NXT_SOF_01 (offset 0x15A0, printed page 9-367, `hi3516av200--Hi3516AV200-Datasheet.txt` line 58738).";

        field {
            name = "lane8_nxt_sof_1";
            desc = "Lane 8 SOF synchronization code of frame 1 in LVDS or HiSPi mode This field is configurable only in WDR mode, and the configuration is invalid in linear mode.";
            sw = rw;
            hw = r;
            reset = 0x0;
        } lane8_nxt_sof_1[31:16];

        field {
            name = "lane8_nxt_sof_0";
            desc = "Lane 8 SOF synchronization code of frame 0 in LVDS or HiSPi mode In WDR mode, the value is the SOF of frame 0. In linear mode, the value is the SOF.";
            sw = rw;
            hw = r;
            reset = 0x0;
        } lane8_nxt_sof_0[15:0];
    } LVDS0_LANE8_NXT_SOF_01 @ 0x15A0;

    reg {
        name = "Lane 8 SOF synchronization code NE8_NXT_S configuration register for frame (N + 1) in OF_23 LVDS or HiSPi mode";
        desc = "LVDS0_LANE8_NXT_SOF_23 is a lane 8 SOF synchronization code configuration register for frame (N + 1) in LVDS or HiSPi mode.

Data sheet 9.3.6 LVDS0_LANE8_NXT_SOF_23 (offset 0x15A4, printed page 9-367, `hi3516av200--Hi3516AV200-Datasheet.txt` line 58766).";

        field {
            name = "lane8_nxt_sof_3";
            desc = "Lane 8 SOF synchronization code of frame 3 in LVDS or HiSPi mode This field is configurable only in WDR mode, and the configuration is invalid in linear mode.";
            sw = rw;
            hw = r;
            reset = 0x0;
        } lane8_nxt_sof_3[31:16];

        field {
            name = "lane8_nxt_sof_2";
            desc = "Lane 8 SOF synchronization code of frame 2 in LVDS or HiSPi mode This field is configurable only in WDR mode, and the configuration is invalid in linear mode.";
            sw = rw;
            hw = r;
            reset = 0x0;
        } lane8_nxt_sof_2[15:0];
    } LVDS0_LANE8_NXT_SOF_23 @ 0x15A4;

    reg {
        name = "Lane 8 EOF synchronization code NE8_NXT_E configuration register for frame (N + 1) in OF_01 LVDS or HiSPi mode";
        desc = "LVDS0_LANE8_NXT_EOF_01 is a lane 8 EOF synchronization code configuration register for frame (N + 1) in LVDS or HiSPi mode. Hi3516A V200 Professional HD IP Camera SoC

Data sheet 9.3.6 LVDS0_LANE8_NXT_EOF_01 (offset 0x15A8, printed page 9-368, `hi3516av200--Hi3516AV200-Datasheet.txt` line 58803).";

        field {
            name = "lane8_nxt_eof_1";
            desc = "Lane 8 EOF synchronization code of frame 1 in LVDS or HiSPi mode This field is configurable only in WDR mode, and the configuration is invalid in linear mode.";
            sw = rw;
            hw = r;
            reset = 0x0;
        } lane8_nxt_eof_1[31:16];

        field {
            name = "lane8_nxt_eof_0";
            desc = "Lane 8 EOF synchronization code of frame 0 in LVDS or HiSPi mode In WDR mode, the value is the EOF of frame 0. In linear mode, the value is the EOF.";
            sw = rw;
            hw = r;
            reset = 0x0;
        } lane8_nxt_eof_0[15:0];
    } LVDS0_LANE8_NXT_EOF_01 @ 0x15A8;

    reg {
        name = "Lane 8 EOF synchronization code NE8_NXT_E configuration register for frame (N + 1) in OF_23 LVDS or HiSPi mode";
        desc = "LVDS0_LANE8_NXT_EOF_23 is a lane 8 EOF synchronization code configuration register for frame (N + 1) in LVDS or HiSPi mode.

Data sheet 9.3.6 LVDS0_LANE8_NXT_EOF_23 (offset 0x15AC, printed page 9-368, `hi3516av200--Hi3516AV200-Datasheet.txt` line 58831).";

        field {
            name = "lane8_nxt_eof_3";
            desc = "Lane 8 EOF synchronization code of frame 3 in LVDS or HiSPi mode This field is configurable only in WDR mode, and the configuration is invalid in linear mode.";
            sw = rw;
            hw = r;
            reset = 0x0;
        } lane8_nxt_eof_3[31:16];

        field {
            name = "lane8_nxt_eof_2";
            desc = "Lane 8 EOF synchronization code of frame 2 in LVDS or HiSPi mode This field is configurable only in WDR mode, and the configuration is invalid in linear mode.";
            sw = rw;
            hw = r;
            reset = 0x0;
        } lane8_nxt_eof_2[15:0];
    } LVDS0_LANE8_NXT_EOF_23 @ 0x15AC;

    reg {
        name = "Lane 8 SOL synchronization code NE8_NXT_S configuration register for frame (N + 1) in OL_01 LVDS or HiSPi mode";
        desc = "LVDS0_LANE8_NXT_SOL_01 is a lane 8 SOL synchronization code configuration register for frame (N + 1) in LVDS or HiSPi mode. Hi3516A V200 Professional HD IP Camera SoC

Data sheet 9.3.6 LVDS0_LANE8_NXT_SOL_01 (offset 0x15B0, printed page 9-369, `hi3516av200--Hi3516AV200-Datasheet.txt` line 58868).";

        field {
            name = "lane8_nxt_sol_1";
            desc = "Lane 8 SOL synchronization code of frame 1 in LVDS or HiSPi mode This field is configurable only in WDR mode, and the configuration is invalid in linear mode.";
            sw = rw;
            hw = r;
            reset = 0x0;
        } lane8_nxt_sol_1[31:16];

        field {
            name = "lane8_nxt_sol_0";
            desc = "Lane 8 SOL synchronization code of frame 0 in LVDS or HiSPi mode In WDR mode, the value is the SOL of frame 0. In linear mode, the value is the SOL.";
            sw = rw;
            hw = r;
            reset = 0x0;
        } lane8_nxt_sol_0[15:0];
    } LVDS0_LANE8_NXT_SOL_01 @ 0x15B0;

    reg {
        name = "Lane 8 SOL synchronization code NE8_NXT_S configuration register for frame (N + 1) in OL_23 LVDS or HiSPi mode";
        desc = "LVDS0_LANE8_NXT_SOL_23 is a lane 8 SOL synchronization code configuration register for frame (N + 1) in LVDS or HiSPi mode.

Data sheet 9.3.6 LVDS0_LANE8_NXT_SOL_23 (offset 0x15B4, printed page 9-369, `hi3516av200--Hi3516AV200-Datasheet.txt` line 58896).";

        field {
            name = "lane8_nxt_sol_3";
            desc = "Lane 8 SOL synchronization code of frame 3 in LVDS or HiSPi mode This field is configurable only in WDR mode, and the configuration is invalid in linear mode.";
            sw = rw;
            hw = r;
            reset = 0x0;
        } lane8_nxt_sol_3[31:16];

        field {
            name = "lane8_nxt_sol_2";
            desc = "Lane 8 SOL synchronization code of frame 2 in LVDS or HiSPi mode This field is configurable only in WDR mode, and the configuration is invalid in linear mode.";
            sw = rw;
            hw = r;
            reset = 0x0;
        } lane8_nxt_sol_2[15:0];
    } LVDS0_LANE8_NXT_SOL_23 @ 0x15B4;

    reg {
        name = "Lane 8 EOL synchronization code NE8_NXT_E configuration register for frame (N + 1) in OL_01 LVDS or HiSPi mode";
        desc = "LVDS0_LANE8_NXT_EOL_01 is a lane 8 EOL synchronization code configuration register for frame (N + 1) in LVDS or HiSPi mode. Hi3516A V200 Professional HD IP Camera SoC

Data sheet 9.3.6 LVDS0_LANE8_NXT_EOL_01 (offset 0x15B8, printed page 9-370, `hi3516av200--Hi3516AV200-Datasheet.txt` line 58933).";

        field {
            name = "lane8_nxt_eol_1";
            desc = "Lane 8 EOL synchronization code of frame 1 in LVDS or HiSPi mode This field is configurable only in WDR mode, and the configuration is invalid in linear mode.";
            sw = rw;
            hw = r;
            reset = 0x0;
        } lane8_nxt_eol_1[31:16];

        field {
            name = "lane8_nxt_eol_0";
            desc = "Lane 8 EOL synchronization code of frame 0 in LVDS or HiSPi mode In WDR mode, the value is the EOL of frame 0. In linear mode, the value is the EOL.";
            sw = rw;
            hw = r;
            reset = 0x0;
        } lane8_nxt_eol_0[15:0];
    } LVDS0_LANE8_NXT_EOL_01 @ 0x15B8;

    reg {
        name = "Lane 8 EOL synchronization code NE8_NXT_E configuration register for frame (N + 1) in OL_23 LVDS or HiSPi mode";
        desc = "LVDS0_LANE8_NXT_EOL_23 is a lane 8 EOL synchronization code configuration register for frame (N + 1) in LVDS or HiSPi mode.

Data sheet 9.3.6 LVDS0_LANE8_NXT_EOL_23 (offset 0x15BC, printed page 9-370, `hi3516av200--Hi3516AV200-Datasheet.txt` line 58961).";

        field {
            name = "lane8_nxt_eol_3";
            desc = "Lane 8 EOL synchronization code of frame 3 in LVDS or HiSPi mode This field is configurable only in WDR mode, and the configuration is invalid in linear mode.";
            sw = rw;
            hw = r;
            reset = 0x0;
        } lane8_nxt_eol_3[31:16];

        field {
            name = "lane8_nxt_eol_2";
            desc = "Lane 8 EOL synchronization code of frame 2 in LVDS or HiSPi mode This field is configurable only in WDR mode, and the configuration is invalid in linear mode.";
            sw = rw;
            hw = r;
            reset = 0x0;
        } lane8_nxt_eol_2[15:0];
    } LVDS0_LANE8_NXT_EOL_23 @ 0x15BC;

    reg {
        name = "Lane 9 SOF synchronization code NE9_NXT_S configuration register for frame (N + 1) in OF_01 LVDS or HiSPi mode";
        desc = "LVDS0_LANE9_NXT_SOF_01 is a lane 9 SOF synchronization code configuration register for frame (N + 1) in LVDS or HiSPi mode. Hi3516A V200 Professional HD IP Camera SoC

Data sheet 9.3.6 LVDS0_LANE9_NXT_SOF_01 (offset 0x15C0, printed page 9-371, `hi3516av200--Hi3516AV200-Datasheet.txt` line 58998).";

        field {
            name = "lane9_nxt_sof_1";
            desc = "Lane 9 SOF synchronization code of frame 1 in LVDS or HiSPi mode This field is configurable only in WDR mode, and the configuration is invalid in linear mode.";
            sw = rw;
            hw = r;
            reset = 0x0;
        } lane9_nxt_sof_1[31:16];

        field {
            name = "lane9_nxt_sof_0";
            desc = "Lane 9 SOF synchronization code of frame 0 in LVDS or HiSPi mode In WDR mode, the value is the SOF of frame 0. In linear mode, the value is the SOF.";
            sw = rw;
            hw = r;
            reset = 0x0;
        } lane9_nxt_sof_0[15:0];
    } LVDS0_LANE9_NXT_SOF_01 @ 0x15C0;

    reg {
        name = "Lane 9 SOF synchronization code NE9_NXT_S configuration register for frame (N + 1) in OF_23 LVDS or HiSPi mode";
        desc = "LVDS0_LANE9_NXT_SOF_23 is a lane 9 SOF synchronization code configuration register for frame (N + 1) in LVDS or HiSPi mode.

Data sheet 9.3.6 LVDS0_LANE9_NXT_SOF_23 (offset 0x15C4, printed page 9-371, `hi3516av200--Hi3516AV200-Datasheet.txt` line 59026).";

        field {
            name = "lane9_nxt_sof_3";
            desc = "Lane 9 SOF synchronization code of frame 3 in LVDS or HiSPi mode This field is configurable only in WDR mode, and the configuration is invalid in linear mode.";
            sw = rw;
            hw = r;
            reset = 0x0;
        } lane9_nxt_sof_3[31:16];

        field {
            name = "lane9_nxt_sof_2";
            desc = "Lane 9 SOF synchronization code of frame 2 in LVDS or HiSPi mode This field is configurable only in WDR mode, and the configuration is invalid in linear mode.";
            sw = rw;
            hw = r;
            reset = 0x0;
        } lane9_nxt_sof_2[15:0];
    } LVDS0_LANE9_NXT_SOF_23 @ 0x15C4;

    reg {
        name = "Lane 9 EOF synchronization code NE9_NXT_E configuration register for frame (N + 1) in OF_01 LVDS or HiSPi mode";
        desc = "LVDS0_LANE9_NXT_EOF_01 is a lane 9 EOF synchronization code configuration register for frame (N + 1) in LVDS or HiSPi mode. Hi3516A V200 Professional HD IP Camera SoC

Data sheet 9.3.6 LVDS0_LANE9_NXT_EOF_01 (offset 0x15C8, printed page 9-372, `hi3516av200--Hi3516AV200-Datasheet.txt` line 59063).";

        field {
            name = "lane9_nxt_eof_1";
            desc = "Lane 9 EOF synchronization code of frame 1 in LVDS or HiSPi mode This field is configurable only in WDR mode, and the configuration is invalid in linear mode.";
            sw = rw;
            hw = r;
            reset = 0x0;
        } lane9_nxt_eof_1[31:16];

        field {
            name = "lane9_nxt_eof_0";
            desc = "Lane 9 EOF synchronization code of frame 0 in LVDS or HiSPi mode In WDR mode, the value is the EOF of frame 0. In linear mode, the value is the EOF.";
            sw = rw;
            hw = r;
            reset = 0x0;
        } lane9_nxt_eof_0[15:0];
    } LVDS0_LANE9_NXT_EOF_01 @ 0x15C8;

    reg {
        name = "Lane 9 EOF synchronization code NE9_NXT_E configuration register for frame (N + 1) in OF_23 LVDS or HiSPi mode";
        desc = "LVDS0_LANE9_NXT_EOF_23 is a lane 9 EOF synchronization code configuration register for frame (N + 1) in LVDS or HiSPi mode.

Data sheet 9.3.6 LVDS0_LANE9_NXT_EOF_23 (offset 0x15CC, printed page 9-372, `hi3516av200--Hi3516AV200-Datasheet.txt` line 59091).";

        field {
            name = "lane9_nxt_eof_3";
            desc = "Lane 9 EOF synchronization code of frame 3 in LVDS or HiSPi mode This field is configurable only in WDR mode, and the configuration is invalid in linear mode.";
            sw = rw;
            hw = r;
            reset = 0x0;
        } lane9_nxt_eof_3[31:16];

        field {
            name = "lane9_nxt_eof_2";
            desc = "Lane 9 EOF synchronization code of frame 2 in LVDS or HiSPi mode This field is configurable only in WDR mode, and the configuration is invalid in linear mode.";
            sw = rw;
            hw = r;
            reset = 0x0;
        } lane9_nxt_eof_2[15:0];
    } LVDS0_LANE9_NXT_EOF_23 @ 0x15CC;

    reg {
        name = "Lane 9 SOL synchronization code NE9_NXT_S configuration register for frame (N + 1) in OL_01 LVDS or HiSPi mode";
        desc = "LVDS0_LANE9_NXT_SOL_01 is a lane 9 SOL synchronization code configuration register for frame (N + 1) in LVDS or HiSPi mode. Hi3516A V200 Professional HD IP Camera SoC

Data sheet 9.3.6 LVDS0_LANE9_NXT_SOL_01 (offset 0x15D0, printed page 9-373, `hi3516av200--Hi3516AV200-Datasheet.txt` line 59128).";

        field {
            name = "lane9_nxt_sol_1";
            desc = "Lane 9 SOL synchronization code of frame 1 in LVDS or HiSPi mode This field is configurable only in WDR mode, and the configuration is invalid in linear mode.";
            sw = rw;
            hw = r;
            reset = 0x0;
        } lane9_nxt_sol_1[31:16];

        field {
            name = "lane9_nxt_sol_0";
            desc = "Lane 9 SOL synchronization code of frame 0 in LVDS or HiSPi mode In WDR mode, the value is the SOL of frame 0. In linear mode, the value is the SOL.";
            sw = rw;
            hw = r;
            reset = 0x0;
        } lane9_nxt_sol_0[15:0];
    } LVDS0_LANE9_NXT_SOL_01 @ 0x15D0;

    reg {
        name = "Lane 9 SOL synchronization code NE9_NXT_S configuration register for frame (N + 1) in OL_23 LVDS or HiSPi mode";
        desc = "LVDS0_LANE9_NXT_SOL_23 is a lane 9 SOL synchronization code configuration register for frame (N + 1) in LVDS or HiSPi mode.

Data sheet 9.3.6 LVDS0_LANE9_NXT_SOL_23 (offset 0x15D4, printed page 9-373, `hi3516av200--Hi3516AV200-Datasheet.txt` line 59156).";

        field {
            name = "lane9_nxt_sol_3";
            desc = "Lane 9 SOL synchronization code of frame 3 in LVDS or HiSPi mode This field is configurable only in WDR mode, and the configuration is invalid in linear mode.";
            sw = rw;
            hw = r;
            reset = 0x0;
        } lane9_nxt_sol_3[31:16];

        field {
            name = "lane9_nxt_sol_2";
            desc = "Lane 9 SOL synchronization code of frame 2 in LVDS or HiSPi mode This field is configurable only in WDR mode, and the configuration is invalid in linear mode.";
            sw = rw;
            hw = r;
            reset = 0x0;
        } lane9_nxt_sol_2[15:0];
    } LVDS0_LANE9_NXT_SOL_23 @ 0x15D4;

    reg {
        name = "Lane 9 EOL synchronization code NE9_NXT_E configuration register for frame (N + 1) in OL_01 LVDS or HiSPi mode";
        desc = "LVDS0_LANE9_NXT_EOL_01 is a lane 9 EOL synchronization code configuration register for frame (N + 1) in LVDS or HiSPi mode. Hi3516A V200 Professional HD IP Camera SoC

Data sheet 9.3.6 LVDS0_LANE9_NXT_EOL_01 (offset 0x15D8, printed page 9-374, `hi3516av200--Hi3516AV200-Datasheet.txt` line 59193).";

        field {
            name = "lane9_nxt_eol_1";
            desc = "Lane 9 EOL synchronization code of frame 1 in LVDS or HiSPi mode This field is configurable only in WDR mode, and the configuration is invalid in linear mode.";
            sw = rw;
            hw = r;
            reset = 0x0;
        } lane9_nxt_eol_1[31:16];

        field {
            name = "lane9_nxt_eol_0";
            desc = "Lane 9 EOL synchronization code of frame 0 in LVDS or HiSPi mode In WDR mode, the value is the EOL of frame 0. In linear mode, the value is the EOL.";
            sw = rw;
            hw = r;
            reset = 0x0;
        } lane9_nxt_eol_0[15:0];
    } LVDS0_LANE9_NXT_EOL_01 @ 0x15D8;

    reg {
        name = "Lane 9 EOL synchronization code NE9_NXT_E configuration register for frame (N + 1) in OL_23 LVDS or HiSPi mode";
        desc = "LVDS0_LANE9_NXT_EOL_23 is a lane 9 EOL synchronization code configuration register for frame (N + 1) in LVDS or HiSPi mode.

Data sheet 9.3.6 LVDS0_LANE9_NXT_EOL_23 (offset 0x15DC, printed page 9-374, `hi3516av200--Hi3516AV200-Datasheet.txt` line 59221).";

        field {
            name = "lane9_nxt_eol_3";
            desc = "Lane 9 EOL synchronization code of frame 3 in LVDS or HiSPi mode This field is configurable only in WDR mode, and the configuration is invalid in linear mode.";
            sw = rw;
            hw = r;
            reset = 0x0;
        } lane9_nxt_eol_3[31:16];

        field {
            name = "lane9_nxt_eol_2";
            desc = "Lane 9 EOL synchronization code of frame 2 in LVDS or HiSPi mode This field is configurable only in WDR mode, and the configuration is invalid in linear mode.";
            sw = rw;
            hw = r;
            reset = 0x0;
        } lane9_nxt_eol_2[15:0];
    } LVDS0_LANE9_NXT_EOL_23 @ 0x15DC;

    reg {
        name = "Lane 10 SOF synchronization code NE10_NXT_ configuration register for frame (N + 1) in SOF_01 LVDS or HiSPi mode";
        desc = "LVDS0_LANE10_NXT_SOF_01 is a lane 10 SOF synchronization code configuration register for frame (N + 1) in LVDS or HiSPi mode. Hi3516A V200 Professional HD IP Camera SoC

Data sheet 9.3.6 LVDS0_LANE10_NXT_SOF_01 (offset 0x15E0, printed page 9-375, `hi3516av200--Hi3516AV200-Datasheet.txt` line 59258).";

        field {
            name = "lane10_nxt_sof_1";
            desc = "Lane 10 SOF synchronization code of frame 1 in LVDS or HiSPi mode This field is configurable only in WDR mode, and the configuration is invalid in linear mode.";
            sw = rw;
            hw = r;
            reset = 0x0;
        } lane10_nxt_sof_1[31:16];

        field {
            name = "lane10_nxt_sof_0";
            desc = "Lane 10 SOF synchronization code of frame 0 in LVDS or HiSPi mode In WDR mode, the value is the SOF of frame 0. In linear mode, the value is the SOF.";
            sw = rw;
            hw = r;
            reset = 0x0;
        } lane10_nxt_sof_0[15:0];
    } LVDS0_LANE10_NXT_SOF_01 @ 0x15E0;

    reg {
        name = "Lane 10 SOF synchronization code NE10_NXT_ configuration register for frame (N + 1) in SOF_23 LVDS or HiSPi mode";
        desc = "LVDS0_LANE10_NXT_SOF_23 is a lane 10 SOF synchronization code configuration register for frame (N + 1) in LVDS or HiSPi mode.

Data sheet 9.3.6 LVDS0_LANE10_NXT_SOF_23 (offset 0x15E4, printed page 9-375, `hi3516av200--Hi3516AV200-Datasheet.txt` line 59286).";

        field {
            name = "lane10_nxt_sof_3";
            desc = "Lane 10 SOF synchronization code of frame 3 in LVDS or HiSPi mode This field is configurable only in WDR mode, and the configuration is invalid in linear mode.";
            sw = rw;
            hw = r;
            reset = 0x0;
        } lane10_nxt_sof_3[31:16];

        field {
            name = "lane10_nxt_sof_2";
            desc = "Lane 10 SOF synchronization code of frame 2 in LVDS or HiSPi mode This field is configurable only in WDR mode, and the configuration is invalid in linear mode.";
            sw = rw;
            hw = r;
            reset = 0x0;
        } lane10_nxt_sof_2[15:0];
    } LVDS0_LANE10_NXT_SOF_23 @ 0x15E4;

    reg {
        name = "Lane 10 EOF synchronization code NE10_NXT_ configuration register for frame (N + 1) in EOF_01 LVDS or HiSPi mode";
        desc = "LVDS0_LANE10_NXT_EOF_01 is a lane 10 EOF synchronization code configuration register for frame (N + 1) in LVDS or HiSPi mode. Hi3516A V200 Professional HD IP Camera SoC

Data sheet 9.3.6 LVDS0_LANE10_NXT_EOF_01 (offset 0x15E8, printed page 9-376, `hi3516av200--Hi3516AV200-Datasheet.txt` line 59323).";

        field {
            name = "lane10_nxt_eof_1";
            desc = "Lane 10 EOF synchronization code of frame 1 in LVDS or HiSPi mode This field is configurable only in WDR mode, and the configuration is invalid in linear mode.";
            sw = rw;
            hw = r;
            reset = 0x0;
        } lane10_nxt_eof_1[31:16];

        field {
            name = "lane10_nxt_eof_0";
            desc = "Lane 10 EOF synchronization code of frame 0 in LVDS or HiSPi mode In WDR mode, the value is the EOF of frame 0. In linear mode, the value is the EOF.";
            sw = rw;
            hw = r;
            reset = 0x0;
        } lane10_nxt_eof_0[15:0];
    } LVDS0_LANE10_NXT_EOF_01 @ 0x15E8;

    reg {
        name = "Lane 10 EOF synchronization code NE10_NXT_ configuration register for frame (N + 1) in EOF_23 LVDS or HiSPi mode";
        desc = "LVDS0_LANE10_NXT_EOF_23 is a lane 10 EOF synchronization code configuration register for frame (N + 1) in LVDS or HiSPi mode.

Data sheet 9.3.6 LVDS0_LANE10_NXT_EOF_23 (offset 0x15EC, printed page 9-376, `hi3516av200--Hi3516AV200-Datasheet.txt` line 59351).";

        field {
            name = "lane10_nxt_eof_3";
            desc = "Lane 10 EOF synchronization code of frame 3 in LVDS or HiSPi mode This field is configurable only in WDR mode, and the configuration is invalid in linear mode.";
            sw = rw;
            hw = r;
            reset = 0x0;
        } lane10_nxt_eof_3[31:16];

        field {
            name = "lane10_nxt_eof_2";
            desc = "Lane 10 EOF synchronization code of frame 2 in LVDS or HiSPi mode This field is configurable only in WDR mode, and the configuration is invalid in linear mode.";
            sw = rw;
            hw = r;
            reset = 0x0;
        } lane10_nxt_eof_2[15:0];
    } LVDS0_LANE10_NXT_EOF_23 @ 0x15EC;

    reg {
        name = "Lane 10 SOL synchronization code NE10_NXT_ configuration register for frame (N + 1) in SOL_01 LVDS or HiSPi mode";
        desc = "LVDS0_LANE10_NXT_SOL_01 is a lane 10 SOL synchronization code configuration register for frame (N + 1) in LVDS or HiSPi mode. Hi3516A V200 Professional HD IP Camera SoC

Data sheet 9.3.6 LVDS0_LANE10_NXT_SOL_01 (offset 0x15F0, printed page 9-377, `hi3516av200--Hi3516AV200-Datasheet.txt` line 59388).";

        field {
            name = "lane10_nxt_sol_1";
            desc = "Lane 10 SOL synchronization code of frame 1 in LVDS or HiSPi mode This field is configurable only in WDR mode, and the configuration is invalid in linear mode.";
            sw = rw;
            hw = r;
            reset = 0x0;
        } lane10_nxt_sol_1[31:16];

        field {
            name = "lane10_nxt_sol_0";
            desc = "Lane 10 SOL synchronization code of frame 0 in LVDS or HiSPi mode In WDR mode, the value is the SOL of frame 0. In linear mode, the value is the SOL.";
            sw = rw;
            hw = r;
            reset = 0x0;
        } lane10_nxt_sol_0[15:0];
    } LVDS0_LANE10_NXT_SOL_01 @ 0x15F0;

    reg {
        name = "Lane 10 SOL synchronization code NE10_NXT_ configuration register for frame (N + 1) in SOL_23 LVDS or HiSPi mode";
        desc = "LVDS0_LANE10_NXT_SOL_23 is a lane 10 SOL synchronization code configuration register for frame (N + 1) in LVDS or HiSPi mode.

Data sheet 9.3.6 LVDS0_LANE10_NXT_SOL_23 (offset 0x15F4, printed page 9-377, `hi3516av200--Hi3516AV200-Datasheet.txt` line 59416).";

        field {
            name = "lane10_nxt_sol_3";
            desc = "Lane 10 SOL synchronization code of frame 3 in LVDS or HiSPi mode This field is configurable only in WDR mode, and the configuration is invalid in linear mode.";
            sw = rw;
            hw = r;
            reset = 0x0;
        } lane10_nxt_sol_3[31:16];

        field {
            name = "lane10_nxt_sol_2";
            desc = "Lane 10 SOL synchronization code of frame 2 in LVDS or HiSPi mode This field is configurable only in WDR mode, and the configuration is invalid in linear mode.";
            sw = rw;
            hw = r;
            reset = 0x0;
        } lane10_nxt_sol_2[15:0];
    } LVDS0_LANE10_NXT_SOL_23 @ 0x15F4;

    reg {
        name = "Lane 10 EOL synchronization code NE10_NXT_ configuration register for frame (N + 1) in EOL_01 LVDS or HiSPi mode";
        desc = "LVDS0_LANE10_NXT_EOL_01 is a lane 10 EOL synchronization code configuration register for frame (N + 1) in LVDS or HiSPi mode. Hi3516A V200 Professional HD IP Camera SoC

Data sheet 9.3.6 LVDS0_LANE10_NXT_EOL_01 (offset 0x15F8, printed page 9-378, `hi3516av200--Hi3516AV200-Datasheet.txt` line 59453).";

        field {
            name = "lane10_nxt_eol_1";
            desc = "Lane 10 EOL synchronization code of frame 1 in LVDS or HiSPi mode This field is configurable only in WDR mode, and the configuration is invalid in linear mode.";
            sw = rw;
            hw = r;
            reset = 0x0;
        } lane10_nxt_eol_1[31:16];

        field {
            name = "lane10_nxt_eol_0";
            desc = "Lane 10 EOL synchronization code of frame 0 in LVDS or HiSPi mode In WDR mode, the value is the EOL of frame 0. In linear mode, the value is the EOL.";
            sw = rw;
            hw = r;
            reset = 0x0;
        } lane10_nxt_eol_0[15:0];
    } LVDS0_LANE10_NXT_EOL_01 @ 0x15F8;

    reg {
        name = "Lane 10 EOL synchronization code NE10_NXT_ configuration register for frame (N + 1) in EOL_23 LVDS or HiSPi mode";
        desc = "LVDS0_LANE10_NXT_EOL_23 is a lane 10 EOL synchronization code configuration register for frame (N + 1) in LVDS or HiSPi mode.

Data sheet 9.3.6 LVDS0_LANE10_NXT_EOL_23 (offset 0x15FC, printed page 9-378, `hi3516av200--Hi3516AV200-Datasheet.txt` line 59481).";

        field {
            name = "lane10_nxt_eol_3";
            desc = "Lane 10 EOL synchronization code of frame 3 in LVDS or HiSPi mode This field is configurable only in WDR mode, and the configuration is invalid in linear mode.";
            sw = rw;
            hw = r;
            reset = 0x0;
        } lane10_nxt_eol_3[31:16];

        field {
            name = "lane10_nxt_eol_2";
            desc = "Lane 10 EOL synchronization code of frame 2 in LVDS or HiSPi mode This field is configurable only in WDR mode, and the configuration is invalid in linear mode.";
            sw = rw;
            hw = r;
            reset = 0x0;
        } lane10_nxt_eol_2[15:0];
    } LVDS0_LANE10_NXT_EOL_23 @ 0x15FC;

    reg {
        name = "Lane 11 SOF synchronization code NE11_NXT_ configuration register for frame (N + 1) in SOF_01 LVDS or HiSPi mode";
        desc = "LVDS0_LANE11_NXT_SOF_01 is a lane 11 SOF synchronization code configuration register for frame (N + 1) in LVDS or HiSPi mode. Hi3516A V200 Professional HD IP Camera SoC

Data sheet 9.3.6 LVDS0_LANE11_NXT_SOF_01 (offset 0x1600, printed page 9-379, `hi3516av200--Hi3516AV200-Datasheet.txt` line 59518).";

        field {
            name = "lane11_nxt_sof_1";
            desc = "Lane 11 SOF synchronization code of frame 1 in LVDS or HiSPi mode This field is configurable only in WDR mode, and the configuration is invalid in linear mode.";
            sw = rw;
            hw = r;
            reset = 0x0;
        } lane11_nxt_sof_1[31:16];

        field {
            name = "lane11_nxt_sof_0";
            desc = "Lane 11 SOF synchronization code of frame 0 in LVDS or HiSPi mode In WDR mode, the value is the SOF of frame 0. In linear mode, the value is the SOF.";
            sw = rw;
            hw = r;
            reset = 0x0;
        } lane11_nxt_sof_0[15:0];
    } LVDS0_LANE11_NXT_SOF_01 @ 0x1600;

    reg {
        name = "Lane 11 SOF synchronization code NE11_NXT_ configuration register for frame (N + 1) in SOF_23 LVDS or HiSPi mode";
        desc = "LVDS0_LANE11_NXT_SOF_23 is a lane 11 SOF synchronization code configuration register for frame (N + 1) in LVDS or HiSPi mode.

Data sheet 9.3.6 LVDS0_LANE11_NXT_SOF_23 (offset 0x1604, printed page 9-379, `hi3516av200--Hi3516AV200-Datasheet.txt` line 59546).";

        field {
            name = "lane11_nxt_sof_3";
            desc = "Lane 11 SOF synchronization code of frame 3 in LVDS or HiSPi mode This field is configurable only in WDR mode, and the configuration is invalid in linear mode.";
            sw = rw;
            hw = r;
            reset = 0x0;
        } lane11_nxt_sof_3[31:16];

        field {
            name = "lane11_nxt_sof_2";
            desc = "Lane 11 SOF synchronization code of frame 2 in LVDS or HiSPi mode This field is configurable only in WDR mode, and the configuration is invalid in linear mode.";
            sw = rw;
            hw = r;
            reset = 0x0;
        } lane11_nxt_sof_2[15:0];
    } LVDS0_LANE11_NXT_SOF_23 @ 0x1604;

    reg {
        name = "Lane 11 EOF synchronization code NE11_NXT_ configuration register for frame (N + 1) in EOF_01 LVDS or HiSPi mode";
        desc = "LVDS0_LANE11_NXT_EOF_01 is a lane 11 EOF synchronization code configuration register for frame (N + 1) in LVDS or HiSPi mode. Hi3516A V200 Professional HD IP Camera SoC

Data sheet 9.3.6 LVDS0_LANE11_NXT_EOF_01 (offset 0x1608, printed page 9-380, `hi3516av200--Hi3516AV200-Datasheet.txt` line 59583).";

        field {
            name = "lane11_nxt_eof_1";
            desc = "Lane 11 EOF synchronization code of frame 1 in LVDS or HiSPi mode This field is configurable only in WDR mode, and the configuration is invalid in linear mode.";
            sw = rw;
            hw = r;
            reset = 0x0;
        } lane11_nxt_eof_1[31:16];

        field {
            name = "lane11_nxt_eof_0";
            desc = "Lane 11 EOF synchronization code of frame 0 in LVDS or HiSPi mode In WDR mode, the value is the EOF of frame 0. In linear mode, the value is the EOF.";
            sw = rw;
            hw = r;
            reset = 0x0;
        } lane11_nxt_eof_0[15:0];
    } LVDS0_LANE11_NXT_EOF_01 @ 0x1608;

    reg {
        name = "Lane 11 EOF synchronization code NE11_NXT_ configuration register for frame (N + 1) in EOF_23 LVDS or HiSPi mode";
        desc = "LVDS0_LANE11_NXT_EOF_23 is a lane 11 EOF synchronization code configuration register for frame (N + 1) in LVDS or HiSPi mode.

Data sheet 9.3.6 LVDS0_LANE11_NXT_EOF_23 (offset 0x160C, printed page 9-380, `hi3516av200--Hi3516AV200-Datasheet.txt` line 59611).";

        field {
            name = "lane11_nxt_eof_3";
            desc = "Lane 11 EOF synchronization code of frame 3 in LVDS or HiSPi mode This field is configurable only in WDR mode, and the configuration is invalid in linear mode.";
            sw = rw;
            hw = r;
            reset = 0x0;
        } lane11_nxt_eof_3[31:16];

        field {
            name = "lane11_nxt_eof_2";
            desc = "Lane 11 EOF synchronization code of frame 2 in LVDS or HiSPi mode This field is configurable only in WDR mode, and the configuration is invalid in linear mode.";
            sw = rw;
            hw = r;
            reset = 0x0;
        } lane11_nxt_eof_2[15:0];
    } LVDS0_LANE11_NXT_EOF_23 @ 0x160C;

    reg {
        name = "Lane 11 SOL synchronization code NE11_NXT_ configuration register for frame (N + 1) in SOL_01 LVDS or HiSPi mode";
        desc = "LVDS0_LANE11_NXT_SOL_01 is a lane 11 SOL synchronization code configuration register for frame (N + 1) in LVDS or HiSPi mode. Hi3516A V200 Professional HD IP Camera SoC

Data sheet 9.3.6 LVDS0_LANE11_NXT_SOL_01 (offset 0x1610, printed page 9-381, `hi3516av200--Hi3516AV200-Datasheet.txt` line 59648).";

        field {
            name = "lane11_nxt_sol_1";
            desc = "Lane 11 SOL synchronization code of frame 1 in LVDS or HiSPi mode This field is configurable only in WDR mode, and the configuration is invalid in linear mode.";
            sw = rw;
            hw = r;
            reset = 0x0;
        } lane11_nxt_sol_1[31:16];

        field {
            name = "lane11_nxt_sol_0";
            desc = "Lane 11 SOL synchronization code of frame 0 in LVDS or HiSPi mode In WDR mode, the value is the SOL of frame 0. In linear mode, the value is the SOL.";
            sw = rw;
            hw = r;
            reset = 0x0;
        } lane11_nxt_sol_0[15:0];
    } LVDS0_LANE11_NXT_SOL_01 @ 0x1610;

    reg {
        name = "Lane 11 SOL synchronization code NE11_NXT_ configuration register for frame (N + 1) in SOL_23 LVDS or HiSPi mode";
        desc = "LVDS0_LANE11_NXT_SOL_23 is a lane 11 SOL synchronization code configuration register for frame (N + 1) in LVDS or HiSPi mode.

Data sheet 9.3.6 LVDS0_LANE11_NXT_SOL_23 (offset 0x1614, printed page 9-381, `hi3516av200--Hi3516AV200-Datasheet.txt` line 59676).";

        field {
            name = "lane11_nxt_sol_3";
            desc = "Lane 11 SOL synchronization code of frame 3 in LVDS or HiSPi mode This field is configurable only in WDR mode, and the configuration is invalid in linear mode.";
            sw = rw;
            hw = r;
            reset = 0x0;
        } lane11_nxt_sol_3[31:16];

        field {
            name = "lane11_nxt_sol_2";
            desc = "Lane 11 SOL synchronization code of frame 2 in LVDS or HiSPi mode This field is configurable only in WDR mode, and the configuration is invalid in linear mode.";
            sw = rw;
            hw = r;
            reset = 0x0;
        } lane11_nxt_sol_2[15:0];
    } LVDS0_LANE11_NXT_SOL_23 @ 0x1614;

    reg {
        name = "Lane 11 EOL synchronization code NE11_NXT_ configuration register for frame (N + 1) in EOL_01 LVDS or HiSPi mode";
        desc = "LVDS0_LANE11_NXT_EOL_01 is a lane 11 EOL synchronization code configuration register for frame (N + 1) in LVDS or HiSPi mode. Hi3516A V200 Professional HD IP Camera SoC

Data sheet 9.3.6 LVDS0_LANE11_NXT_EOL_01 (offset 0x1618, printed page 9-382, `hi3516av200--Hi3516AV200-Datasheet.txt` line 59713).";

        field {
            name = "lane11_nxt_eol_1";
            desc = "Lane 11 EOL synchronization code of frame 1 in LVDS or HiSPi mode This field is configurable only in WDR mode, and the configuration is invalid in linear mode.";
            sw = rw;
            hw = r;
            reset = 0x0;
        } lane11_nxt_eol_1[31:16];

        field {
            name = "lane11_nxt_eol_0";
            desc = "Lane 11 EOL synchronization code of frame 0 in LVDS or HiSPi mode In WDR mode, the value is the EOL of frame 0. In linear mode, the value is the EOL.";
            sw = rw;
            hw = r;
            reset = 0x0;
        } lane11_nxt_eol_0[15:0];
    } LVDS0_LANE11_NXT_EOL_01 @ 0x1618;

    reg {
        name = "Lane 11 EOL synchronization code NE11_NXT_ configuration register for frame (N + 1) in EOL_23 LVDS or HiSPi mode";
        desc = "LVDS0_LANE11_NXT_EOL_23 is a lane 11 EOL synchronization code configuration register for frame (N + 1) in LVDS or HiSPi mode.

Data sheet 9.3.6 LVDS0_LANE11_NXT_EOL_23 (offset 0x161C, printed page 9-382, `hi3516av200--Hi3516AV200-Datasheet.txt` line 59741).";

        field {
            name = "lane11_nxt_eol_3";
            desc = "Lane 11 EOL synchronization code of frame 3 in LVDS or HiSPi mode This field is configurable only in WDR mode, and the configuration is invalid in linear mode.";
            sw = rw;
            hw = r;
            reset = 0x0;
        } lane11_nxt_eol_3[31:16];

        field {
            name = "lane11_nxt_eol_2";
            desc = "Lane 11 EOL synchronization code of frame 2 in LVDS or HiSPi mode This field is configurable only in WDR mode, and the configuration is invalid in linear mode.";
            sw = rw;
            hw = r;
            reset = 0x0;
        } lane11_nxt_eol_2[15:0];
    } LVDS0_LANE11_NXT_EOL_23 @ 0x161C;

    reg {
        name = "LVDS DOL mode frame 0 LI register WORD0";
        desc = "LVDS0_LI_WORD0 is an LVDS DOL mode frame 0 LI register. Hi3516A V200 Professional HD IP Camera SoC

Data sheet 9.3.6 LVDS0_LI_WORD0 (offset 0x1620, printed page 9-383, `hi3516av200--Hi3516AV200-Datasheet.txt` line 59778).";

        field {
            name = "li_word0_1";
            desc = "LEF line information in DOL mode (for frame N + 1)";
            sw = rw;
            hw = r;
            reset = 0x211;
        } li_word0_1[31:16];

        field {
            name = "li_word0_0";
            desc = "LEF line information in DOL mode (for frame N)";
            sw = rw;
            hw = r;
            reset = 0x201;
        } li_word0_0[15:0];
    } LVDS0_LI_WORD0 @ 0x1620;

    reg {
        name = "LVDS DOL mode frame 1 LI register WORD1";
        desc = "LVDS0_LI_WORD1 is an LVDS DOL mode frame 1 LI register.

Data sheet 9.3.6 LVDS0_LI_WORD1 (offset 0x1624, printed page 9-383, `hi3516av200--Hi3516AV200-Datasheet.txt` line 59797).";

        field {
            name = "li_word1_1";
            desc = "SEF1 line information in DOL mode (for frame N + 1)";
            sw = rw;
            hw = r;
            reset = 0x212;
        } li_word1_1[31:16];

        field {
            name = "li_word1_0";
            desc = "SEF1 line information in DOL mode (for frame";
            sw = rw;
            hw = r;
            reset = 0x202;
        } li_word1_0[15:0];
    } LVDS0_LI_WORD1 @ 0x1624;

    reg {
        name = "LVDS DOL mode frame 2 LI register WORD2";
        desc = "LVDS0_LI_WORD2 is an LVDS DOL mode frame 2 LI register.

Data sheet 9.3.6 LVDS0_LI_WORD2 (offset 0x1628, printed page 9-383, `hi3516av200--Hi3516AV200-Datasheet.txt` line 59817).";

        field {
            name = "li_word2_1";
            desc = "SEF2 line information in DOL mode (for frame + 1)";
            sw = rw;
            hw = r;
            reset = 0x214;
        } li_word2_1[31:16];

        field {
            name = "li_word2_0";
            desc = "SEF2 line information in DOL mode (for frame";
            sw = rw;
            hw = r;
            reset = 0x204;
        } li_word2_0[15:0];
    } LVDS0_LI_WORD2 @ 0x1628;

    reg {
        name = "LVDS DOL mode frame 3 LI register WORD3";
        desc = "LVDS0_LI_WORD3 is an LVDS DOL mode frame 3 LI register.

Data sheet 9.3.6 LVDS0_LI_WORD3 (offset 0x162C, printed page 9-384, `hi3516av200--Hi3516AV200-Datasheet.txt` line 59842).";

        field {
            name = "li_word3_1";
            desc = "SEF3 line information in DOL mode (for frame + 1)";
            sw = rw;
            hw = r;
            reset = 0x218;
        } li_word3_1[31:16];

        field {
            name = "li_word3_0";
            desc = "SEF3 line information in DOL mode (for frame";
            sw = rw;
            hw = r;
            reset = 0x208;
        } li_word3_0[15:0];
    } LVDS0_LI_WORD3 @ 0x162C;

    reg {
        name = "LVDS0 lane IMGSIZE STATIS";
        desc = "[inferred] LVDS0 lane IMGSIZE STATIS. Array of 12 consecutive 32-bit words (header `LVDS0_LANE_IMGSIZE_STATIS[12]`). Not in the data sheet. Source: OpenIPC openhisilicon `kernel/mipi_rx/hi3519v101/mipi_reg.h` (GPL-3.0 repository, HiSilicon copyright; local copy sources/openhisilicon), union `U_LVDS_LANE_IMGSIZE_STATIS`, struct offset 0x1640 (GPL-3.0 repository, HiSilicon copyright; one header for Hi3519 V101 and Hi3516A V200). Reset value and access type unknown (modelled RW, no reset). Confidence: medium (vendor header for this chip family, not hardware verified).";

        field {
            name = "lane_imgheight";
            desc = "[inferred] Lane imgheight. (vendor header `hi3519v101/mipi_reg.h` field `lane_imgheight`; access and reset unknown, modelled RW)";
            sw = rw;
            hw = r;
        } lane_imgheight[31:16];

        field {
            name = "lane_imgwidth";
            desc = "[inferred] Lane imgwidth. (vendor header `hi3519v101/mipi_reg.h` field `lane_imgwidth`; access and reset unknown, modelled RW)";
            sw = rw;
            hw = r;
        } lane_imgwidth[15:0];
    } LVDS0_LANE_IMGSIZE_STATIS[12] @ 0x1640 += 0x4;

    reg {
        name = "LVDS LEF image size statistics register SIZE0_STAT IS";
        desc = "LVDS0_IMGSIZE0_STATIS is an LVDS LEF image size statistics register.

Data sheet 9.3.6 LVDS0_IMGSIZE0_STATIS (offset 0x1680, printed page 9-384, `hi3516av200--Hi3516AV200-Datasheet.txt` line 59862).";

        field {
            name = "lvds_imgheight0";
            desc = "Height of the image transferred by virtual channel 0 in LVDS or HiSPi mode";
            sw = r;
            hw = w;
            reset = 0x0;
        } lvds_imgheight0[31:16];

        field {
            name = "lvds_imgwidth0";
            desc = "Width of the image transferred by virtual channel 0 in LVDS or HiSPi mode";
            sw = r;
            hw = w;
            reset = 0x0;
        } lvds_imgwidth0[15:0];
    } LVDS0_IMGSIZE0_STATIS @ 0x1680;

    reg {
        name = "LVDS SEF1 image size statistics register SIZE1_STAT IS";
        desc = "LVDS0_IMGSIZE1_STATIS is an LVDS SEF1 image size statistics register. Hi3516A V200 Professional HD IP Camera SoC

Data sheet 9.3.6 LVDS0_IMGSIZE1_STATIS (offset 0x1684, printed page 9-385, `hi3516av200--Hi3516AV200-Datasheet.txt` line 59896).";

        field {
            name = "lvds_imgheight1";
            desc = "Height of the image transferred by virtual channel 1 in LVDS or HiSPi mode";
            sw = r;
            hw = w;
            reset = 0x0;
        } lvds_imgheight1[31:16];

        field {
            name = "lvds_imgwidth1";
            desc = "Width of the image transferred by virtual channel 1 in LVDS or HiSPi mode";
            sw = r;
            hw = w;
            reset = 0x0;
        } lvds_imgwidth1[15:0];
    } LVDS0_IMGSIZE1_STATIS @ 0x1684;

    reg {
        name = "LVDS SEF2 image size statistics register SIZE2_STAT IS";
        desc = "LVDS0_IMGSIZE2_STATIS is an LVDS SEF2 image size statistics register.

Data sheet 9.3.6 LVDS0_IMGSIZE2_STATIS (offset 0x1688, printed page 9-385, `hi3516av200--Hi3516AV200-Datasheet.txt` line 59919).";

        field {
            name = "lvds_imgheight2";
            desc = "Height of the image transferred by virtual channel 2 in LVDS or HiSPi mode";
            sw = r;
            hw = w;
            reset = 0x0;
        } lvds_imgheight2[31:16];

        field {
            name = "lvds_imgwidth2";
            desc = "Width of the image transferred by virtual channel 2 in LVDS or HiSPi mode";
            sw = r;
            hw = w;
            reset = 0x0;
        } lvds_imgwidth2[15:0];
    } LVDS0_IMGSIZE2_STATIS @ 0x1688;

    reg {
        name = "LVDS SEF3 image size statistics register SIZE3_STAT IS";
        desc = "LVDS0_IMGSIZE3_STATIS is an LVDS SEF3 image size statistics register. Hi3516A V200 Professional HD IP Camera SoC

Data sheet 9.3.6 LVDS0_IMGSIZE3_STATIS (offset 0x168C, printed page 9-386, `hi3516av200--Hi3516AV200-Datasheet.txt` line 59952).";

        field {
            name = "lvds_imgheight3";
            desc = "Height of the image transferred by virtual channel 3 in LVDS or HiSPi mode";
            sw = r;
            hw = w;
            reset = 0x0;
        } lvds_imgheight3[31:16];

        field {
            name = "lvds_imgwidth3";
            desc = "Width of the image transferred by virtual channel 3 in LVDS or HiSPi mode";
            sw = r;
            hw = w;
            reset = 0x0;
        } lvds_imgwidth3[15:0];
    } LVDS0_IMGSIZE3_STATIS @ 0x168C;

    reg {
        name = "LVDS read data raw interrupt status L_INT_RAW register";
        desc = "LVDS0_CTRL_INT_RAW is an LVDS read data raw interrupt status register.

Data sheet 9.3.6 LVDS0_CTRL_INT_RAW (offset 0x16F0, printed page 9-386, `hi3516av200--Hi3516AV200-Datasheet.txt` line 59975).";

        enum LVDS0_CTRL_INT_RAW_link2_rderr_raw_enum {
            NO_RAW_INTERRUPT = 0 { name = "No Raw Interrupt"; desc = "No raw interrupt is generated."; };
            RAW_INTERRUPT_GENERATED = 1 { name = "Raw Interrupt Generated"; desc = "A raw interrupt is generated."; };
        };

        field {
            name = "link2_rderr_raw";
            desc = "Link 2 read data error raw interrupt status";
            sw = rw;
            hw = w;
            onwrite = woclr;
            encode = LVDS0_CTRL_INT_RAW_link2_rderr_raw_enum;
            reset = 0x0;
        } link2_rderr_raw[26:26];

        enum LVDS0_CTRL_INT_RAW_link1_rderr_raw_enum {
            NO_RAW_INTERRUPT = 0 { name = "No Raw Interrupt"; desc = "No raw interrupt is generated."; };
            RAW_INTERRUPT_GENERATED = 1 { name = "Raw Interrupt Generated"; desc = "A raw interrupt is generated."; };
        };

        field {
            name = "link1_rderr_raw";
            desc = "Link 1 read data error raw interrupt status";
            sw = rw;
            hw = w;
            onwrite = woclr;
            encode = LVDS0_CTRL_INT_RAW_link1_rderr_raw_enum;
            reset = 0x0;
        } link1_rderr_raw[25:25];

        enum LVDS0_CTRL_INT_RAW_link0_rderr_raw_enum {
            NO_RAW_INTERRUPT = 0 { name = "No Raw Interrupt"; desc = "No raw interrupt is generated."; };
            RAW_INTERRUPT_GENERATED = 1 { name = "Raw Interrupt Generated"; desc = "A raw interrupt is generated."; };
        };

        field {
            name = "link0_rderr_raw";
            desc = "Link 0 read data error raw interrupt status";
            sw = rw;
            hw = w;
            onwrite = woclr;
            encode = LVDS0_CTRL_INT_RAW_link0_rderr_raw_enum;
            reset = 0x0;
        } link0_rderr_raw[24:24];

        enum LVDS0_CTRL_INT_RAW_lvds_stat_err_raw_enum {
            NO_RAW_INTERRUPT = 0 { name = "No Raw Interrupt"; desc = "No raw interrupt is generated."; };
            RAW_INTERRUPT_GENERATED = 1 { name = "Raw Interrupt Generated"; desc = "A raw interrupt is generated."; };
        };

        field {
            name = "lvds_stat_err_raw";
            desc = "LVDS status error raw interrupt status";
            sw = rw;
            hw = w;
            onwrite = woclr;
            encode = LVDS0_CTRL_INT_RAW_lvds_stat_err_raw_enum;
            reset = 0x0;
        } lvds_stat_err_raw[21:21];

        enum LVDS0_CTRL_INT_RAW_lane11_sync_err_raw_enum {
            NO_RAW_INTERRUPT = 0 { name = "No Raw Interrupt"; desc = "No raw interrupt is generated."; };
            RAW_INTERRUPT_GENERATED = 1 { name = "Raw Interrupt Generated"; desc = "A raw interrupt is generated."; };
        };

        field {
            name = "lane11_sync_err_raw";
            desc = "Lane 11 synchronization error raw interrupt status";
            sw = rw;
            hw = w;
            onwrite = woclr;
            encode = LVDS0_CTRL_INT_RAW_lane11_sync_err_raw_enum;
            reset = 0x0;
        } lane11_sync_err_raw[20:20];

        enum LVDS0_CTRL_INT_RAW_lane10_sync_err_raw_enum {
            NO_RAW_INTERRUPT = 0 { name = "No Raw Interrupt"; desc = "No raw interrupt is generated."; };
            RAW_INTERRUPT_GENERATED = 1 { name = "Raw Interrupt Generated"; desc = "A raw interrupt is generated."; };
        };

        field {
            name = "lane10_sync_err_raw";
            desc = "Lane 10 synchronization error raw interrupt status";
            sw = rw;
            hw = w;
            onwrite = woclr;
            encode = LVDS0_CTRL_INT_RAW_lane10_sync_err_raw_enum;
            reset = 0x0;
        } lane10_sync_err_raw[19:19];

        enum LVDS0_CTRL_INT_RAW_lane9_sync_err_raw_enum {
            NO_RAW_INTERRUPT = 0 { name = "No Raw Interrupt"; desc = "No raw interrupt is generated."; };
            RAW_INTERRUPT_GENERATED = 1 { name = "Raw Interrupt Generated"; desc = "A raw interrupt is generated."; };
        };

        field {
            name = "lane9_sync_err_raw";
            desc = "Lane 9 synchronization error raw interrupt status";
            sw = rw;
            hw = w;
            onwrite = woclr;
            encode = LVDS0_CTRL_INT_RAW_lane9_sync_err_raw_enum;
            reset = 0x0;
        } lane9_sync_err_raw[18:18];

        enum LVDS0_CTRL_INT_RAW_lane8_sync_err_raw_enum {
            NO_RAW_INTERRUPT = 0 { name = "No Raw Interrupt"; desc = "No raw interrupt is generated."; };
            RAW_INTERRUPT_GENERATED = 1 { name = "Raw Interrupt Generated"; desc = "A raw interrupt is generated."; };
        };

        field {
            name = "lane8_sync_err_raw";
            desc = "Lane 8 synchronization error raw interrupt status";
            sw = rw;
            hw = w;
            onwrite = woclr;
            encode = LVDS0_CTRL_INT_RAW_lane8_sync_err_raw_enum;
            reset = 0x0;
        } lane8_sync_err_raw[17:17];

        enum LVDS0_CTRL_INT_RAW_lane7_sync_err_raw_enum {
            NO_RAW_INTERRUPT = 0 { name = "No Raw Interrupt"; desc = "No raw interrupt is generated."; };
            RAW_INTERRUPT_GENERATED = 1 { name = "Raw Interrupt Generated"; desc = "A raw interrupt is generated."; };
        };

        field {
            name = "lane7_sync_err_raw";
            desc = "Lane 7 synchronization error raw interrupt status";
            sw = rw;
            hw = w;
            onwrite = woclr;
            encode = LVDS0_CTRL_INT_RAW_lane7_sync_err_raw_enum;
            reset = 0x0;
        } lane7_sync_err_raw[16:16];

        enum LVDS0_CTRL_INT_RAW_lane6_sync_err_raw_enum {
            NO_RAW_INTERRUPT = 0 { name = "No Raw Interrupt"; desc = "No raw interrupt is generated."; };
            RAW_INTERRUPT_GENERATED = 1 { name = "Raw Interrupt Generated"; desc = "A raw interrupt is generated."; };
        };

        field {
            name = "lane6_sync_err_raw";
            desc = "Lane 6 synchronization error raw interrupt status";
            sw = rw;
            hw = w;
            onwrite = woclr;
            encode = LVDS0_CTRL_INT_RAW_lane6_sync_err_raw_enum;
            reset = 0x0;
        } lane6_sync_err_raw[15:15];

        enum LVDS0_CTRL_INT_RAW_lane5_sync_err_raw_enum {
            NO_RAW_INTERRUPT = 0 { name = "No Raw Interrupt"; desc = "No raw interrupt is generated."; };
            RAW_INTERRUPT_GENERATED = 1 { name = "Raw Interrupt Generated"; desc = "A raw interrupt is generated."; };
        };

        field {
            name = "lane5_sync_err_raw";
            desc = "Lane 5 synchronization error raw interrupt status";
            sw = rw;
            hw = w;
            onwrite = woclr;
            encode = LVDS0_CTRL_INT_RAW_lane5_sync_err_raw_enum;
            reset = 0x0;
        } lane5_sync_err_raw[14:14];

        enum LVDS0_CTRL_INT_RAW_lane4_sync_err_raw_enum {
            NO_RAW_INTERRUPT = 0 { name = "No Raw Interrupt"; desc = "No raw interrupt is generated."; };
            RAW_INTERRUPT_GENERATED = 1 { name = "Raw Interrupt Generated"; desc = "A raw interrupt is generated."; };
        };

        field {
            name = "lane4_sync_err_raw";
            desc = "Lane 4 synchronization error raw interrupt status";
            sw = rw;
            hw = w;
            onwrite = woclr;
            encode = LVDS0_CTRL_INT_RAW_lane4_sync_err_raw_enum;
            reset = 0x0;
        } lane4_sync_err_raw[13:13];

        enum LVDS0_CTRL_INT_RAW_lane3_sync_err_raw_enum {
            NO_RAW_INTERRUPT = 0 { name = "No Raw Interrupt"; desc = "No raw interrupt is generated."; };
            RAW_INTERRUPT_GENERATED = 1 { name = "Raw Interrupt Generated"; desc = "A raw interrupt is generated."; };
        };

        field {
            name = "lane3_sync_err_raw";
            desc = "Lane 3 synchronization error raw interrupt status";
            sw = rw;
            hw = w;
            onwrite = woclr;
            encode = LVDS0_CTRL_INT_RAW_lane3_sync_err_raw_enum;
            reset = 0x0;
        } lane3_sync_err_raw[12:12];

        enum LVDS0_CTRL_INT_RAW_lane2_sync_err_raw_enum {
            NO_RAW_INTERRUPT = 0 { name = "No Raw Interrupt"; desc = "No raw interrupt is generated."; };
            RAW_INTERRUPT_GENERATED = 1 { name = "Raw Interrupt Generated"; desc = "A raw interrupt is generated."; };
        };

        field {
            name = "lane2_sync_err_raw";
            desc = "Lane 2 synchronization error raw interrupt status";
            sw = rw;
            hw = w;
            onwrite = woclr;
            encode = LVDS0_CTRL_INT_RAW_lane2_sync_err_raw_enum;
            reset = 0x0;
        } lane2_sync_err_raw[11:11];

        enum LVDS0_CTRL_INT_RAW_lane1_sync_err_raw_enum {
            NO_RAW_INTERRUPT = 0 { name = "No Raw Interrupt"; desc = "No raw interrupt is generated."; };
            RAW_INTERRUPT_GENERATED = 1 { name = "Raw Interrupt Generated"; desc = "A raw interrupt is generated."; };
        };

        field {
            name = "lane1_sync_err_raw";
            desc = "Lane 1 synchronization error raw interrupt status";
            sw = rw;
            hw = w;
            onwrite = woclr;
            encode = LVDS0_CTRL_INT_RAW_lane1_sync_err_raw_enum;
            reset = 0x0;
        } lane1_sync_err_raw[10:10];

        enum LVDS0_CTRL_INT_RAW_lane0_sync_err_raw_enum {
            NO_RAW_INTERRUPT = 0 { name = "No Raw Interrupt"; desc = "No raw interrupt is generated."; };
            RAW_INTERRUPT_GENERATED = 1 { name = "Raw Interrupt Generated"; desc = "A raw interrupt is generated."; };
        };

        field {
            name = "lane0_sync_err_raw";
            desc = "Lane 0 synchronization error raw interrupt status";
            sw = rw;
            hw = w;
            onwrite = woclr;
            encode = LVDS0_CTRL_INT_RAW_lane0_sync_err_raw_enum;
            reset = 0x0;
        } lane0_sync_err_raw[9:9];

        enum LVDS0_CTRL_INT_RAW_link2_hsync_err_raw_enum {
            NO_RAW_INTERRUPT = 0 { name = "No Raw Interrupt"; desc = "No raw interrupt is generated."; };
            RAW_INTERRUPT_GENERATED = 1 { name = "Raw Interrupt Generated"; desc = "A raw interrupt is generated."; };
        };

        field {
            name = "link2_hsync_err_raw";
            desc = "Link 2 HS error raw interrupt status";
            sw = rw;
            hw = w;
            onwrite = woclr;
            encode = LVDS0_CTRL_INT_RAW_link2_hsync_err_raw_enum;
            reset = 0x0;
        } link2_hsync_err_raw[8:8];

        enum LVDS0_CTRL_INT_RAW_link2_vsync_err_raw_enum {
            NO_RAW_INTERRUPT = 0 { name = "No Raw Interrupt"; desc = "No raw interrupt is generated."; };
            RAW_INTERRUPT_GENERATED = 1 { name = "Raw Interrupt Generated"; desc = "A raw interrupt is generated."; };
        };

        field {
            name = "link2_vsync_err_raw";
            desc = "Link 2 VS error raw interrupt status";
            sw = rw;
            hw = w;
            onwrite = woclr;
            encode = LVDS0_CTRL_INT_RAW_link2_vsync_err_raw_enum;
            reset = 0x0;
        } link2_vsync_err_raw[7:7];

        enum LVDS0_CTRL_INT_RAW_link2_wrerr_raw_enum {
            NO_RAW_INTERRUPT = 0 { name = "No Raw Interrupt"; desc = "No raw interrupt is generated."; };
            RAW_INTERRUPT_GENERATED = 1 { name = "Raw Interrupt Generated"; desc = "A raw interrupt is generated."; };
        };

        field {
            name = "link2_wrerr_raw";
            desc = "Link 2 write data error raw interrupt status";
            sw = rw;
            hw = w;
            onwrite = woclr;
            encode = LVDS0_CTRL_INT_RAW_link2_wrerr_raw_enum;
            reset = 0x0;
        } link2_wrerr_raw[6:6];

        enum LVDS0_CTRL_INT_RAW_link1_hsync_err_raw_enum {
            NO_RAW_INTERRUPT = 0 { name = "No Raw Interrupt"; desc = "No raw interrupt is generated."; };
            RAW_INTERRUPT_GENERATED = 1 { name = "Raw Interrupt Generated"; desc = "A raw interrupt is generated."; };
        };

        field {
            name = "link1_hsync_err_raw";
            desc = "Lane 1 HS error raw interrupt status";
            sw = rw;
            hw = w;
            onwrite = woclr;
            encode = LVDS0_CTRL_INT_RAW_link1_hsync_err_raw_enum;
            reset = 0x0;
        } link1_hsync_err_raw[5:5];

        enum LVDS0_CTRL_INT_RAW_link1_vsync_err_raw_enum {
            NO_RAW_INTERRUPT = 0 { name = "No Raw Interrupt"; desc = "No raw interrupt is generated."; };
            RAW_INTERRUPT_GENERATED = 1 { name = "Raw Interrupt Generated"; desc = "A raw interrupt is generated."; };
        };

        field {
            name = "link1_vsync_err_raw";
            desc = "Lane 1 VS error raw interrupt status";
            sw = rw;
            hw = w;
            onwrite = woclr;
            encode = LVDS0_CTRL_INT_RAW_link1_vsync_err_raw_enum;
            reset = 0x0;
        } link1_vsync_err_raw[4:4];

        enum LVDS0_CTRL_INT_RAW_link1_wrerr_raw_enum {
            NO_RAW_INTERRUPT = 0 { name = "No Raw Interrupt"; desc = "No raw interrupt is generated."; };
            RAW_INTERRUPT_GENERATED = 1 { name = "Raw Interrupt Generated"; desc = "A raw interrupt is generated."; };
        };

        field {
            name = "link1_wrerr_raw";
            desc = "Link 1 write data error raw interrupt status";
            sw = rw;
            hw = w;
            onwrite = woclr;
            encode = LVDS0_CTRL_INT_RAW_link1_wrerr_raw_enum;
            reset = 0x0;
        } link1_wrerr_raw[3:3];

        enum LVDS0_CTRL_INT_RAW_link0_hsync_err_raw_enum {
            NO_RAW_INTERRUPT = 0 { name = "No Raw Interrupt"; desc = "No raw interrupt is generated."; };
            RAW_INTERRUPT_GENERATED = 1 { name = "Raw Interrupt Generated"; desc = "A raw interrupt is generated."; };
        };

        field {
            name = "link0_hsync_err_raw";
            desc = "Lane 0 HS error raw interrupt status";
            sw = rw;
            hw = w;
            onwrite = woclr;
            encode = LVDS0_CTRL_INT_RAW_link0_hsync_err_raw_enum;
            reset = 0x0;
        } link0_hsync_err_raw[2:2];

        enum LVDS0_CTRL_INT_RAW_link0_vsync_err_raw_enum {
            NO_RAW_INTERRUPT = 0 { name = "No Raw Interrupt"; desc = "No raw interrupt is generated."; };
            RAW_INTERRUPT_GENERATED = 1 { name = "Raw Interrupt Generated"; desc = "A raw interrupt is generated."; };
        };

        field {
            name = "link0_vsync_err_raw";
            desc = "Lane 0 VS error raw interrupt status";
            sw = rw;
            hw = w;
            onwrite = woclr;
            encode = LVDS0_CTRL_INT_RAW_link0_vsync_err_raw_enum;
            reset = 0x0;
        } link0_vsync_err_raw[1:1];

        enum LVDS0_CTRL_INT_RAW_link0_wrerr_raw_enum {
            NO_RAW_INTERRUPT = 0 { name = "No Raw Interrupt"; desc = "No raw interrupt is generated."; };
            RAW_INTERRUPT_GENERATED = 1 { name = "Raw Interrupt Generated"; desc = "A raw interrupt is generated."; };
        };

        field {
            name = "link0_wrerr_raw";
            desc = "Link 0 write data error raw interrupt status";
            sw = rw;
            hw = w;
            onwrite = woclr;
            encode = LVDS0_CTRL_INT_RAW_link0_wrerr_raw_enum;
            reset = 0x0;
        } link0_wrerr_raw[0:0];
    } LVDS0_CTRL_INT_RAW @ 0x16F0;

    reg {
        name = "LVDS read data interrupt status register L_INT";
        desc = "LVDS0_CTRL_INT is an LVDS read data interrupt status register. Hi3516A V200 Professional HD IP Camera SoC

Data sheet 9.3.6 LVDS0_CTRL_INT (offset 0x16F4, printed page 9-389, `hi3516av200--Hi3516AV200-Datasheet.txt` line 60145).";

        enum LVDS0_CTRL_INT_link2_rderr_st_enum {
            NO_INTERRUPT_GENERATED = 0 { name = "No Interrupt Generated"; desc = "No interrupt is generated."; };
            INTERRUPT_GENERATED = 1 { name = "Interrupt Generated"; desc = "An interrupt is generated."; };
        };

        field {
            name = "link2_rderr_st";
            desc = "Link 2 read data error interrupt status";
            sw = r;
            hw = w;
            encode = LVDS0_CTRL_INT_link2_rderr_st_enum;
            reset = 0x0;
        } link2_rderr_st[26:26];

        enum LVDS0_CTRL_INT_link1_rderr_st_enum {
            NO_INTERRUPT_GENERATED = 0 { name = "No Interrupt Generated"; desc = "No interrupt is generated."; };
            INTERRUPT_GENERATED = 1 { name = "Interrupt Generated"; desc = "An interrupt is generated."; };
        };

        field {
            name = "link1_rderr_st";
            desc = "Link 1 read data error interrupt status";
            sw = r;
            hw = w;
            encode = LVDS0_CTRL_INT_link1_rderr_st_enum;
            reset = 0x0;
        } link1_rderr_st[25:25];

        enum LVDS0_CTRL_INT_link0_rderr_st_enum {
            NO_INTERRUPT_GENERATED = 0 { name = "No Interrupt Generated"; desc = "No interrupt is generated."; };
            INTERRUPT_GENERATED = 1 { name = "Interrupt Generated"; desc = "An interrupt is generated."; };
        };

        field {
            name = "link0_rderr_st";
            desc = "Link 0 read data error interrupt status";
            sw = r;
            hw = w;
            encode = LVDS0_CTRL_INT_link0_rderr_st_enum;
            reset = 0x0;
        } link0_rderr_st[24:24];

        enum LVDS0_CTRL_INT_lvds_stat_err_st_enum {
            NO_INTERRUPT_GENERATED = 0 { name = "No Interrupt Generated"; desc = "No interrupt is generated."; };
            INTERRUPT_GENERATED = 1 { name = "Interrupt Generated"; desc = "An interrupt is generated."; };
        };

        field {
            name = "lvds_stat_err_st";
            desc = "LVDS status error interrupt status";
            sw = r;
            hw = w;
            encode = LVDS0_CTRL_INT_lvds_stat_err_st_enum;
            reset = 0x0;
        } lvds_stat_err_st[21:21];

        enum LVDS0_CTRL_INT_lane11_sync_err_st_enum {
            NO_INTERRUPT_GENERATED = 0 { name = "No Interrupt Generated"; desc = "No interrupt is generated."; };
            INTERRUPT_GENERATED = 1 { name = "Interrupt Generated"; desc = "An interrupt is generated."; };
        };

        field {
            name = "lane11_sync_err_st";
            desc = "Lane 11 synchronization error interrupt status";
            sw = r;
            hw = w;
            encode = LVDS0_CTRL_INT_lane11_sync_err_st_enum;
            reset = 0x0;
        } lane11_sync_err_st[20:20];

        enum LVDS0_CTRL_INT_lane10_sync_err_st_enum {
            NO_INTERRUPT_GENERATED = 0 { name = "No Interrupt Generated"; desc = "No interrupt is generated."; };
            INTERRUPT_GENERATED = 1 { name = "Interrupt Generated"; desc = "An interrupt is generated."; };
        };

        field {
            name = "lane10_sync_err_st";
            desc = "Lane 10 synchronization error interrupt status";
            sw = r;
            hw = w;
            encode = LVDS0_CTRL_INT_lane10_sync_err_st_enum;
            reset = 0x0;
        } lane10_sync_err_st[19:19];

        enum LVDS0_CTRL_INT_lane9_sync_err_st_enum {
            NO_INTERRUPT_GENERATED = 0 { name = "No Interrupt Generated"; desc = "No interrupt is generated."; };
            INTERRUPT_GENERATED = 1 { name = "Interrupt Generated"; desc = "An interrupt is generated."; };
        };

        field {
            name = "lane9_sync_err_st";
            desc = "Lane 9 synchronization error interrupt status";
            sw = r;
            hw = w;
            encode = LVDS0_CTRL_INT_lane9_sync_err_st_enum;
            reset = 0x0;
        } lane9_sync_err_st[18:18];

        enum LVDS0_CTRL_INT_lane8_sync_err_st_enum {
            NO_INTERRUPT_GENERATED = 0 { name = "No Interrupt Generated"; desc = "No interrupt is generated."; };
            INTERRUPT_GENERATED = 1 { name = "Interrupt Generated"; desc = "An interrupt is generated."; };
        };

        field {
            name = "lane8_sync_err_st";
            desc = "Lane 8 synchronization error interrupt status";
            sw = r;
            hw = w;
            encode = LVDS0_CTRL_INT_lane8_sync_err_st_enum;
            reset = 0x0;
        } lane8_sync_err_st[17:17];

        enum LVDS0_CTRL_INT_lane7_sync_err_st_enum {
            NO_INTERRUPT_GENERATED = 0 { name = "No Interrupt Generated"; desc = "No interrupt is generated."; };
            INTERRUPT_GENERATED = 1 { name = "Interrupt Generated"; desc = "An interrupt is generated."; };
        };

        field {
            name = "lane7_sync_err_st";
            desc = "Lane 7 synchronization error interrupt status";
            sw = r;
            hw = w;
            encode = LVDS0_CTRL_INT_lane7_sync_err_st_enum;
            reset = 0x0;
        } lane7_sync_err_st[16:16];

        enum LVDS0_CTRL_INT_lane6_sync_err_st_enum {
            NO_INTERRUPT_GENERATED = 0 { name = "No Interrupt Generated"; desc = "No interrupt is generated."; };
            INTERRUPT_GENERATED = 1 { name = "Interrupt Generated"; desc = "An interrupt is generated."; };
        };

        field {
            name = "lane6_sync_err_st";
            desc = "Lane 6 synchronization error interrupt status";
            sw = r;
            hw = w;
            encode = LVDS0_CTRL_INT_lane6_sync_err_st_enum;
            reset = 0x0;
        } lane6_sync_err_st[15:15];

        enum LVDS0_CTRL_INT_lane5_sync_err_st_enum {
            NO_INTERRUPT_GENERATED = 0 { name = "No Interrupt Generated"; desc = "No interrupt is generated."; };
            INTERRUPT_GENERATED = 1 { name = "Interrupt Generated"; desc = "An interrupt is generated."; };
        };

        field {
            name = "lane5_sync_err_st";
            desc = "Lane 5 synchronization error interrupt status";
            sw = r;
            hw = w;
            encode = LVDS0_CTRL_INT_lane5_sync_err_st_enum;
            reset = 0x0;
        } lane5_sync_err_st[14:14];

        enum LVDS0_CTRL_INT_lane4_sync_err_st_enum {
            NO_INTERRUPT_GENERATED = 0 { name = "No Interrupt Generated"; desc = "No interrupt is generated."; };
            INTERRUPT_GENERATED = 1 { name = "Interrupt Generated"; desc = "An interrupt is generated."; };
        };

        field {
            name = "lane4_sync_err_st";
            desc = "Lane 4 synchronization error interrupt status";
            sw = r;
            hw = w;
            encode = LVDS0_CTRL_INT_lane4_sync_err_st_enum;
            reset = 0x0;
        } lane4_sync_err_st[13:13];

        enum LVDS0_CTRL_INT_lane3_sync_err_st_enum {
            NO_INTERRUPT_GENERATED = 0 { name = "No Interrupt Generated"; desc = "No interrupt is generated."; };
            INTERRUPT_GENERATED = 1 { name = "Interrupt Generated"; desc = "An interrupt is generated."; };
        };

        field {
            name = "lane3_sync_err_st";
            desc = "Lane 3 synchronization error interrupt status";
            sw = r;
            hw = w;
            encode = LVDS0_CTRL_INT_lane3_sync_err_st_enum;
            reset = 0x0;
        } lane3_sync_err_st[12:12];

        enum LVDS0_CTRL_INT_lane2_sync_err_st_enum {
            NO_INTERRUPT_GENERATED = 0 { name = "No Interrupt Generated"; desc = "No interrupt is generated."; };
            INTERRUPT_GENERATED = 1 { name = "Interrupt Generated"; desc = "An interrupt is generated."; };
        };

        field {
            name = "lane2_sync_err_st";
            desc = "Lane 2 synchronization error interrupt status";
            sw = r;
            hw = w;
            encode = LVDS0_CTRL_INT_lane2_sync_err_st_enum;
            reset = 0x0;
        } lane2_sync_err_st[11:11];

        enum LVDS0_CTRL_INT_lane1_sync_err_st_enum {
            NO_INTERRUPT_GENERATED = 0 { name = "No Interrupt Generated"; desc = "No interrupt is generated."; };
            INTERRUPT_GENERATED = 1 { name = "Interrupt Generated"; desc = "An interrupt is generated."; };
        };

        field {
            name = "lane1_sync_err_st";
            desc = "Lane 1 synchronization error interrupt status";
            sw = r;
            hw = w;
            encode = LVDS0_CTRL_INT_lane1_sync_err_st_enum;
            reset = 0x0;
        } lane1_sync_err_st[10:10];

        enum LVDS0_CTRL_INT_lane0_sync_err_st_enum {
            NO_INTERRUPT_GENERATED = 0 { name = "No Interrupt Generated"; desc = "No interrupt is generated."; };
            INTERRUPT_GENERATED = 1 { name = "Interrupt Generated"; desc = "An interrupt is generated."; };
        };

        field {
            name = "lane0_sync_err_st";
            desc = "Lane 0 synchronization error interrupt status";
            sw = r;
            hw = w;
            encode = LVDS0_CTRL_INT_lane0_sync_err_st_enum;
            reset = 0x0;
        } lane0_sync_err_st[9:9];

        enum LVDS0_CTRL_INT_link2_hsync_err_st_enum {
            NO_INTERRUPT_GENERATED = 0 { name = "No Interrupt Generated"; desc = "No interrupt is generated."; };
            INTERRUPT_GENERATED = 1 { name = "Interrupt Generated"; desc = "An interrupt is generated."; };
        };

        field {
            name = "link2_hsync_err_st";
            desc = "Link 2 HS error interrupt status";
            sw = r;
            hw = w;
            encode = LVDS0_CTRL_INT_link2_hsync_err_st_enum;
            reset = 0x0;
        } link2_hsync_err_st[8:8];

        enum LVDS0_CTRL_INT_link2_vsync_err_st_enum {
            NO_INTERRUPT_GENERATED = 0 { name = "No Interrupt Generated"; desc = "No interrupt is generated."; };
            INTERRUPT_GENERATED = 1 { name = "Interrupt Generated"; desc = "An interrupt is generated."; };
        };

        field {
            name = "link2_vsync_err_st";
            desc = "Link 2 VS error interrupt status";
            sw = r;
            hw = w;
            encode = LVDS0_CTRL_INT_link2_vsync_err_st_enum;
            reset = 0x0;
        } link2_vsync_err_st[7:7];

        enum LVDS0_CTRL_INT_link2_wrerr_st_enum {
            NO_INTERRUPT_GENERATED = 0 { name = "No Interrupt Generated"; desc = "No interrupt is generated."; };
            INTERRUPT_GENERATED = 1 { name = "Interrupt Generated"; desc = "An interrupt is generated."; };
        };

        field {
            name = "link2_wrerr_st";
            desc = "Link 2 write data error interrupt status";
            sw = r;
            hw = w;
            encode = LVDS0_CTRL_INT_link2_wrerr_st_enum;
            reset = 0x0;
        } link2_wrerr_st[6:6];

        enum LVDS0_CTRL_INT_link1_hsync_err_st_enum {
            NO_INTERRUPT_GENERATED = 0 { name = "No Interrupt Generated"; desc = "No interrupt is generated."; };
            INTERRUPT_GENERATED = 1 { name = "Interrupt Generated"; desc = "An interrupt is generated."; };
        };

        field {
            name = "link1_hsync_err_st";
            desc = "Link 1 HS error interrupt status";
            sw = r;
            hw = w;
            encode = LVDS0_CTRL_INT_link1_hsync_err_st_enum;
            reset = 0x0;
        } link1_hsync_err_st[5:5];

        enum LVDS0_CTRL_INT_link1_vsync_err_st_enum {
            NO_INTERRUPT_GENERATED = 0 { name = "No Interrupt Generated"; desc = "No interrupt is generated."; };
            INTERRUPT_GENERATED = 1 { name = "Interrupt Generated"; desc = "An interrupt is generated."; };
        };

        field {
            name = "link1_vsync_err_st";
            desc = "Link 1 VS error interrupt status";
            sw = r;
            hw = w;
            encode = LVDS0_CTRL_INT_link1_vsync_err_st_enum;
            reset = 0x0;
        } link1_vsync_err_st[4:4];

        enum LVDS0_CTRL_INT_link1_wrerr_st_enum {
            NO_INTERRUPT_GENERATED = 0 { name = "No Interrupt Generated"; desc = "No interrupt is generated."; };
            INTERRUPT_GENERATED = 1 { name = "Interrupt Generated"; desc = "An interrupt is generated."; };
        };

        field {
            name = "link1_wrerr_st";
            desc = "Link 1 write data error interrupt status";
            sw = r;
            hw = w;
            encode = LVDS0_CTRL_INT_link1_wrerr_st_enum;
            reset = 0x0;
        } link1_wrerr_st[3:3];

        enum LVDS0_CTRL_INT_link0_hsync_err_st_enum {
            NO_INTERRUPT_GENERATED = 0 { name = "No Interrupt Generated"; desc = "No interrupt is generated."; };
            INTERRUPT_GENERATED = 1 { name = "Interrupt Generated"; desc = "An interrupt is generated."; };
        };

        field {
            name = "link0_hsync_err_st";
            desc = "Link 0 HS error interrupt status";
            sw = r;
            hw = w;
            encode = LVDS0_CTRL_INT_link0_hsync_err_st_enum;
            reset = 0x0;
        } link0_hsync_err_st[2:2];

        enum LVDS0_CTRL_INT_link0_vsync_err_st_enum {
            NO_INTERRUPT_GENERATED = 0 { name = "No Interrupt Generated"; desc = "No interrupt is generated."; };
            INTERRUPT_GENERATED = 1 { name = "Interrupt Generated"; desc = "An interrupt is generated."; };
        };

        field {
            name = "link0_vsync_err_st";
            desc = "Link 0 VS error interrupt status";
            sw = r;
            hw = w;
            encode = LVDS0_CTRL_INT_link0_vsync_err_st_enum;
            reset = 0x0;
        } link0_vsync_err_st[1:1];

        enum LVDS0_CTRL_INT_link0_wrerr_st_enum {
            NO_INTERRUPT_GENERATED = 0 { name = "No Interrupt Generated"; desc = "No interrupt is generated."; };
            INTERRUPT_GENERATED = 1 { name = "Interrupt Generated"; desc = "An interrupt is generated."; };
        };

        field {
            name = "link0_wrerr_st";
            desc = "Link 0 write data error interrupt status";
            sw = r;
            hw = w;
            encode = LVDS0_CTRL_INT_link0_wrerr_st_enum;
            reset = 0x0;
        } link0_wrerr_st[0:0];
    } LVDS0_CTRL_INT @ 0x16F4;

    reg {
        name = "LVDS read data interrupt mask register L_INT_MSK";
        desc = "LVDS0_CTRL_INT_MSK is an LVDS read data interrupt mask register.

Data sheet 9.3.6 LVDS0_CTRL_INT_MSK (offset 0x16F8, printed page 9-391, `hi3516av200--Hi3516AV200-Datasheet.txt` line 60270).";

        enum LVDS0_CTRL_INT_MSK_link2_rderr_msk_enum {
            MASKED = 0 { name = "Masked"; desc = "masked"; };
            ENABLED = 1 { name = "Enabled"; desc = "enabled"; };
        };

        field {
            name = "link2_rderr_msk";
            desc = "Link 2 read data error interrupt enable";
            sw = rw;
            hw = r;
            encode = LVDS0_CTRL_INT_MSK_link2_rderr_msk_enum;
            reset = 0x0;
        } link2_rderr_msk[26:26];

        enum LVDS0_CTRL_INT_MSK_link1_rderr_msk_enum {
            MASKED = 0 { name = "Masked"; desc = "masked"; };
            ENABLED = 1 { name = "Enabled"; desc = "enabled"; };
        };

        field {
            name = "link1_rderr_msk";
            desc = "Link 1 read data error interrupt enable";
            sw = rw;
            hw = r;
            encode = LVDS0_CTRL_INT_MSK_link1_rderr_msk_enum;
            reset = 0x0;
        } link1_rderr_msk[25:25];

        enum LVDS0_CTRL_INT_MSK_link0_rderr_msk_enum {
            MASKED = 0 { name = "Masked"; desc = "masked"; };
            ENABLED = 1 { name = "Enabled"; desc = "enabled"; };
        };

        field {
            name = "link0_rderr_msk";
            desc = "Link 0 read data error interrupt enable";
            sw = rw;
            hw = r;
            encode = LVDS0_CTRL_INT_MSK_link0_rderr_msk_enum;
            reset = 0x0;
        } link0_rderr_msk[24:24];

        enum LVDS0_CTRL_INT_MSK_lvds_stat_err_st_msk_enum {
            MASKED = 0 { name = "Masked"; desc = "masked"; };
            ENABLED = 1 { name = "Enabled"; desc = "enabled"; };
        };

        field {
            name = "lvds_stat_err_st_msk";
            desc = "LVDS status error interrupt enable";
            sw = rw;
            hw = r;
            encode = LVDS0_CTRL_INT_MSK_lvds_stat_err_st_msk_enum;
            reset = 0x0;
        } lvds_stat_err_st_msk[21:21];

        enum LVDS0_CTRL_INT_MSK_lane11_sync_err_msk_enum {
            MASKED = 0 { name = "Masked"; desc = "masked"; };
            ENABLED = 1 { name = "Enabled"; desc = "enabled"; };
        };

        field {
            name = "lane11_sync_err_msk";
            desc = "Lane 11 synchronization error interrupt enable";
            sw = rw;
            hw = r;
            encode = LVDS0_CTRL_INT_MSK_lane11_sync_err_msk_enum;
            reset = 0x0;
        } lane11_sync_err_msk[20:20];

        enum LVDS0_CTRL_INT_MSK_lane10_sync_err_msk_enum {
            MASKED = 0 { name = "Masked"; desc = "masked"; };
            ENABLED = 1 { name = "Enabled"; desc = "enabled"; };
        };

        field {
            name = "lane10_sync_err_msk";
            desc = "Lane 10 synchronization error interrupt enable";
            sw = rw;
            hw = r;
            encode = LVDS0_CTRL_INT_MSK_lane10_sync_err_msk_enum;
            reset = 0x0;
        } lane10_sync_err_msk[19:19];

        enum LVDS0_CTRL_INT_MSK_lane9_sync_err_msk_enum {
            MASKED = 0 { name = "Masked"; desc = "masked"; };
            ENABLED = 1 { name = "Enabled"; desc = "enabled"; };
        };

        field {
            name = "lane9_sync_err_msk";
            desc = "Lane 9 synchronization error interrupt enable";
            sw = rw;
            hw = r;
            encode = LVDS0_CTRL_INT_MSK_lane9_sync_err_msk_enum;
            reset = 0x0;
        } lane9_sync_err_msk[18:18];

        enum LVDS0_CTRL_INT_MSK_lane8_sync_err_msk_enum {
            MASKED = 0 { name = "Masked"; desc = "masked"; };
            ENABLED = 1 { name = "Enabled"; desc = "enabled"; };
        };

        field {
            name = "lane8_sync_err_msk";
            desc = "Lane 8 synchronization error interrupt enable";
            sw = rw;
            hw = r;
            encode = LVDS0_CTRL_INT_MSK_lane8_sync_err_msk_enum;
            reset = 0x0;
        } lane8_sync_err_msk[17:17];

        enum LVDS0_CTRL_INT_MSK_lane7_sync_err_msk_enum {
            MASKED = 0 { name = "Masked"; desc = "masked"; };
            ENABLED = 1 { name = "Enabled"; desc = "enabled"; };
        };

        field {
            name = "lane7_sync_err_msk";
            desc = "Lane 7 synchronization error interrupt enable";
            sw = rw;
            hw = r;
            encode = LVDS0_CTRL_INT_MSK_lane7_sync_err_msk_enum;
            reset = 0x0;
        } lane7_sync_err_msk[16:16];

        enum LVDS0_CTRL_INT_MSK_lane6_sync_err_msk_enum {
            MASKED = 0 { name = "Masked"; desc = "masked"; };
            ENABLED = 1 { name = "Enabled"; desc = "enabled"; };
        };

        field {
            name = "lane6_sync_err_msk";
            desc = "Lane 6 synchronization error interrupt enable";
            sw = rw;
            hw = r;
            encode = LVDS0_CTRL_INT_MSK_lane6_sync_err_msk_enum;
            reset = 0x0;
        } lane6_sync_err_msk[15:15];

        enum LVDS0_CTRL_INT_MSK_lane5_sync_err_msk_enum {
            MASKED = 0 { name = "Masked"; desc = "masked"; };
            ENABLED = 1 { name = "Enabled"; desc = "enabled"; };
        };

        field {
            name = "lane5_sync_err_msk";
            desc = "Lane 5 synchronization error interrupt enable";
            sw = rw;
            hw = r;
            encode = LVDS0_CTRL_INT_MSK_lane5_sync_err_msk_enum;
            reset = 0x0;
        } lane5_sync_err_msk[14:14];

        enum LVDS0_CTRL_INT_MSK_lane4_sync_err_msk_enum {
            MASKED = 0 { name = "Masked"; desc = "masked"; };
            ENABLED = 1 { name = "Enabled"; desc = "enabled"; };
        };

        field {
            name = "lane4_sync_err_msk";
            desc = "Lane 4 synchronization error interrupt enable";
            sw = rw;
            hw = r;
            encode = LVDS0_CTRL_INT_MSK_lane4_sync_err_msk_enum;
            reset = 0x0;
        } lane4_sync_err_msk[13:13];

        enum LVDS0_CTRL_INT_MSK_lane3_sync_err_msk_enum {
            MASKED = 0 { name = "Masked"; desc = "masked"; };
            ENABLED = 1 { name = "Enabled"; desc = "enabled"; };
        };

        field {
            name = "lane3_sync_err_msk";
            desc = "Lane 3 synchronization error interrupt enable";
            sw = rw;
            hw = r;
            encode = LVDS0_CTRL_INT_MSK_lane3_sync_err_msk_enum;
            reset = 0x0;
        } lane3_sync_err_msk[12:12];

        enum LVDS0_CTRL_INT_MSK_lane2_sync_err_msk_enum {
            MASKED = 0 { name = "Masked"; desc = "masked"; };
            ENABLED = 1 { name = "Enabled"; desc = "enabled"; };
        };

        field {
            name = "lane2_sync_err_msk";
            desc = "Lane 2 synchronization error interrupt enable";
            sw = rw;
            hw = r;
            encode = LVDS0_CTRL_INT_MSK_lane2_sync_err_msk_enum;
            reset = 0x0;
        } lane2_sync_err_msk[11:11];

        enum LVDS0_CTRL_INT_MSK_lane1_sync_err_msk_enum {
            MASKED = 0 { name = "Masked"; desc = "masked"; };
            ENABLED = 1 { name = "Enabled"; desc = "enabled"; };
        };

        field {
            name = "lane1_sync_err_msk";
            desc = "Lane 1 synchronization error interrupt enable";
            sw = rw;
            hw = r;
            encode = LVDS0_CTRL_INT_MSK_lane1_sync_err_msk_enum;
            reset = 0x0;
        } lane1_sync_err_msk[10:10];

        enum LVDS0_CTRL_INT_MSK_lane0_sync_err_msk_enum {
            MASKED = 0 { name = "Masked"; desc = "masked"; };
            ENABLED = 1 { name = "Enabled"; desc = "enabled"; };
        };

        field {
            name = "lane0_sync_err_msk";
            desc = "Lane 0 synchronization error interrupt enable";
            sw = rw;
            hw = r;
            encode = LVDS0_CTRL_INT_MSK_lane0_sync_err_msk_enum;
            reset = 0x0;
        } lane0_sync_err_msk[9:9];

        enum LVDS0_CTRL_INT_MSK_link2_hsync_err_msk_enum {
            MASKED = 0 { name = "Masked"; desc = "masked"; };
            ENABLED = 1 { name = "Enabled"; desc = "enabled"; };
        };

        field {
            name = "link2_hsync_err_msk";
            desc = "Link 2 HS error interrupt enable";
            sw = rw;
            hw = r;
            encode = LVDS0_CTRL_INT_MSK_link2_hsync_err_msk_enum;
            reset = 0x0;
        } link2_hsync_err_msk[8:8];

        enum LVDS0_CTRL_INT_MSK_link2_vsync_err_msk_enum {
            MASKED = 0 { name = "Masked"; desc = "masked"; };
            ENABLED = 1 { name = "Enabled"; desc = "enabled"; };
        };

        field {
            name = "link2_vsync_err_msk";
            desc = "Link 2 VS error interrupt enable";
            sw = rw;
            hw = r;
            encode = LVDS0_CTRL_INT_MSK_link2_vsync_err_msk_enum;
            reset = 0x0;
        } link2_vsync_err_msk[7:7];

        enum LVDS0_CTRL_INT_MSK_link2_wrerr_msk_enum {
            MASKED = 0 { name = "Masked"; desc = "masked"; };
            ENABLED = 1 { name = "Enabled"; desc = "enabled"; };
        };

        field {
            name = "link2_wrerr_msk";
            desc = "Link 2 write data error interrupt enable";
            sw = rw;
            hw = r;
            encode = LVDS0_CTRL_INT_MSK_link2_wrerr_msk_enum;
            reset = 0x0;
        } link2_wrerr_msk[6:6];

        enum LVDS0_CTRL_INT_MSK_link1_hsync_err_msk_enum {
            MASKED = 0 { name = "Masked"; desc = "masked"; };
            ENABLED = 1 { name = "Enabled"; desc = "enabled"; };
        };

        field {
            name = "link1_hsync_err_msk";
            desc = "Link 1 HS error interrupt enable";
            sw = rw;
            hw = r;
            encode = LVDS0_CTRL_INT_MSK_link1_hsync_err_msk_enum;
            reset = 0x0;
        } link1_hsync_err_msk[5:5];

        enum LVDS0_CTRL_INT_MSK_link1_vsync_err_msk_enum {
            MASKED = 0 { name = "Masked"; desc = "masked"; };
            ENABLED = 1 { name = "Enabled"; desc = "enabled"; };
        };

        field {
            name = "link1_vsync_err_msk";
            desc = "Link 1 VS error interrupt enable";
            sw = rw;
            hw = r;
            encode = LVDS0_CTRL_INT_MSK_link1_vsync_err_msk_enum;
            reset = 0x0;
        } link1_vsync_err_msk[4:4];

        enum LVDS0_CTRL_INT_MSK_link1_wrerr_msk_enum {
            MASKED = 0 { name = "Masked"; desc = "masked"; };
            ENABLED = 1 { name = "Enabled"; desc = "enabled"; };
        };

        field {
            name = "link1_wrerr_msk";
            desc = "Link 1 write data error interrupt enable";
            sw = rw;
            hw = r;
            encode = LVDS0_CTRL_INT_MSK_link1_wrerr_msk_enum;
            reset = 0x0;
        } link1_wrerr_msk[3:3];

        enum LVDS0_CTRL_INT_MSK_link0_hsync_err_msk_enum {
            MASKED = 0 { name = "Masked"; desc = "masked"; };
            ENABLED = 1 { name = "Enabled"; desc = "enabled"; };
        };

        field {
            name = "link0_hsync_err_msk";
            desc = "Link 0 HS error interrupt enable";
            sw = rw;
            hw = r;
            encode = LVDS0_CTRL_INT_MSK_link0_hsync_err_msk_enum;
            reset = 0x0;
        } link0_hsync_err_msk[2:2];

        enum LVDS0_CTRL_INT_MSK_link0_vsync_err_msk_enum {
            MASKED = 0 { name = "Masked"; desc = "masked"; };
            ENABLED = 1 { name = "Enabled"; desc = "enabled"; };
        };

        field {
            name = "link0_vsync_err_msk";
            desc = "Link 0 VS error interrupt enable";
            sw = rw;
            hw = r;
            encode = LVDS0_CTRL_INT_MSK_link0_vsync_err_msk_enum;
            reset = 0x0;
        } link0_vsync_err_msk[1:1];

        enum LVDS0_CTRL_INT_MSK_link0_wrerr_msk_enum {
            MASKED = 0 { name = "Masked"; desc = "masked"; };
            ENABLED = 1 { name = "Enabled"; desc = "enabled"; };
        };

        field {
            name = "link0_wrerr_msk";
            desc = "Link 0 write data error interrupt enable";
            sw = rw;
            hw = r;
            encode = LVDS0_CTRL_INT_MSK_link0_wrerr_msk_enum;
            reset = 0x0;
        } link0_wrerr_msk[0:0];
    } LVDS0_CTRL_INT_MSK @ 0x16F8;

    reg {
        name = "Link 0 lane priority configuration register CHN0";
        desc = "LANE_ID0_CHN0 is a link 0 lane priority configuration register.

Data sheet 9.3.6 LANE_ID0_CHN0 (offset 0x1700, printed page 9-394, `hi3516av200--Hi3516AV200-Datasheet.txt` line 60444).";

        field {
            name = "lane3_id";
            desc = "Lane 3 channel ID Value range: 0-11 The field value indicates the ID of image sensor channel connected to lane 3.";
            sw = rw;
            hw = r;
            reset = 0x3;
        } lane3_id[15:12];

        field {
            name = "lane2_id";
            desc = "Lane 2 channel ID Value range: 0-11 The field value indicates the ID of image sensor channel connected to lane 2.";
            sw = rw;
            hw = r;
            reset = 0x2;
        } lane2_id[11:8];

        field {
            name = "lane1_id";
            desc = "Lane 1 channel ID Value range: 0-11 The field value indicates the ID of image sensor channel connected to lane 1.";
            sw = rw;
            hw = r;
            reset = 0x1;
        } lane1_id[7:4];

        field {
            name = "lane0_id";
            desc = "Lane 0 channel ID Value range: 0-11 The field value indicates the ID of image sensor channel connected to lane 0.";
            sw = rw;
            hw = r;
            reset = 0x0;
        } lane0_id[3:0];
    } LANE_ID0_CHN0 @ 0x1700;

    reg {
        name = "Link 1 lane priority configuration register CHN0";
        desc = "LANE_ID1_CHN0 is a link 1 lane priority configuration register. Hi3516A V200 Professional HD IP Camera SoC

Data sheet 9.3.6 LANE_ID1_CHN0 (offset 0x1704, printed page 9-395, `hi3516av200--Hi3516AV200-Datasheet.txt` line 60492).";

        field {
            name = "lane7_id";
            desc = "Lane 7 channel ID Value range: 0-11 The field value indicates the ID of image sensor channel connected to lane 7.";
            sw = rw;
            hw = r;
            reset = 0x7;
        } lane7_id[15:12];

        field {
            name = "lane6_id";
            desc = "Lane 6 channel ID Value range: 0-11 The field value indicates the ID of image sensor channel connected to lane 6.";
            sw = rw;
            hw = r;
            reset = 0x6;
        } lane6_id[11:8];

        field {
            name = "lane5_id";
            desc = "Lane 5 channel ID Value range: 0-11 The field value indicates the ID of image sensor channel connected to lane 5.";
            sw = rw;
            hw = r;
            reset = 0x5;
        } lane5_id[7:4];

        field {
            name = "lane4_id";
            desc = "Lane 4 channel ID Value range: 0-11 The field value indicates the ID of image sensor channel connected to lane 4.";
            sw = rw;
            hw = r;
            reset = 0x4;
        } lane4_id[3:0];
    } LANE_ID1_CHN0 @ 0x1704;

    reg {
        name = "Link 2 lane priority configuration register CHN0";
        desc = "LANE_ID2_CHN0 is a link 2 lane priority configuration register.

Data sheet 9.3.6 LANE_ID2_CHN0 (offset 0x1708, printed page 9-395, `hi3516av200--Hi3516AV200-Datasheet.txt` line 60530).";

        field {
            name = "lane11_id";
            desc = "Lane 11 channel ID Value range: 0-11 The field value indicates the ID of image sensor channel connected to lane 11.";
            sw = rw;
            hw = r;
            reset = 0xB;
        } lane11_id[15:12];

        field {
            name = "lane10_id";
            desc = "Lane 10 channel ID Value range: 0-11 The field value indicates the ID of image sensor channel connected to lane 10.";
            sw = rw;
            hw = r;
            reset = 0xA;
        } lane10_id[11:8];

        field {
            name = "lane9_id";
            desc = "Lane 9 channel ID Value range: 0-11 The field value indicates the ID of image sensor channel connected to lane 9.";
            sw = rw;
            hw = r;
            reset = 0x9;
        } lane9_id[7:4];

        field {
            name = "lane8_id";
            desc = "Lane 8 channel ID Value range: 0-11 The field value indicates the ID of image sensor channel connected to lane 8.";
            sw = rw;
            hw = r;
            reset = 0x8;
        } lane8_id[3:0];
    } LANE_ID2_CHN0 @ 0x1708;

    reg {
        name = "MIPI_ALIGN raw interrupt status register T_RAW";
        desc = "ALIGN0_INT_RAW is a MIPI_ALIGN raw interrupt status register.

Data sheet 9.3.6 ALIGN0_INT_RAW (offset 0x17F0, printed page 9-396, `hi3516av200--Hi3516AV200-Datasheet.txt` line 60579).";

        enum ALIGN0_INT_RAW_err_lane11_raw_enum {
            NO_RAW_INTERRUPT = 0 { name = "No Raw Interrupt"; desc = "No raw interrupt is generated."; };
            RAW_INTERRUPT_GENERATED = 1 { name = "Raw Interrupt Generated"; desc = "A raw interrupt is generated."; };
        };

        field {
            name = "err_lane11_raw";
            desc = "MIPI_ALIGN lane 11 raw interrupt status";
            sw = rw;
            hw = w;
            onwrite = woclr;
            encode = ALIGN0_INT_RAW_err_lane11_raw_enum;
            reset = 0x0;
        } err_lane11_raw[12:12];

        enum ALIGN0_INT_RAW_err_lane10_raw_enum {
            NO_RAW_INTERRUPT = 0 { name = "No Raw Interrupt"; desc = "No raw interrupt is generated."; };
            RAW_INTERRUPT_GENERATED = 1 { name = "Raw Interrupt Generated"; desc = "A raw interrupt is generated."; };
        };

        field {
            name = "err_lane10_raw";
            desc = "MIPI_ALIGN lane 10 raw interrupt status";
            sw = rw;
            hw = w;
            onwrite = woclr;
            encode = ALIGN0_INT_RAW_err_lane10_raw_enum;
            reset = 0x0;
        } err_lane10_raw[11:11];

        enum ALIGN0_INT_RAW_err_lane9_raw_enum {
            NO_RAW_INTERRUPT = 0 { name = "No Raw Interrupt"; desc = "No raw interrupt is generated."; };
            RAW_INTERRUPT_GENERATED = 1 { name = "Raw Interrupt Generated"; desc = "A raw interrupt is generated."; };
        };

        field {
            name = "err_lane9_raw";
            desc = "MIPI_ALIGN lane 9 raw interrupt status";
            sw = rw;
            hw = w;
            onwrite = woclr;
            encode = ALIGN0_INT_RAW_err_lane9_raw_enum;
            reset = 0x0;
        } err_lane9_raw[10:10];

        enum ALIGN0_INT_RAW_err_lane8_raw_enum {
            NO_RAW_INTERRUPT = 0 { name = "No Raw Interrupt"; desc = "No raw interrupt is generated."; };
            RAW_INTERRUPT_GENERATED = 1 { name = "Raw Interrupt Generated"; desc = "A raw interrupt is generated."; };
        };

        field {
            name = "err_lane8_raw";
            desc = "MIPI_ALIGN lane 8 raw interrupt status";
            sw = rw;
            hw = w;
            onwrite = woclr;
            encode = ALIGN0_INT_RAW_err_lane8_raw_enum;
            reset = 0x0;
        } err_lane8_raw[9:9];

        enum ALIGN0_INT_RAW_err_lane7_raw_enum {
            NO_RAW_INTERRUPT = 0 { name = "No Raw Interrupt"; desc = "No raw interrupt is generated."; };
            RAW_INTERRUPT_GENERATED = 1 { name = "Raw Interrupt Generated"; desc = "A raw interrupt is generated."; };
        };

        field {
            name = "err_lane7_raw";
            desc = "MIPI_ALIGN lane 7 raw interrupt status";
            sw = rw;
            hw = w;
            onwrite = woclr;
            encode = ALIGN0_INT_RAW_err_lane7_raw_enum;
            reset = 0x0;
        } err_lane7_raw[8:8];

        enum ALIGN0_INT_RAW_err_lane6_raw_enum {
            NO_RAW_INTERRUPT = 0 { name = "No Raw Interrupt"; desc = "No raw interrupt is generated."; };
            RAW_INTERRUPT_GENERATED = 1 { name = "Raw Interrupt Generated"; desc = "A raw interrupt is generated."; };
        };

        field {
            name = "err_lane6_raw";
            desc = "MIPI_ALIGN lane 6 raw interrupt status";
            sw = rw;
            hw = w;
            onwrite = woclr;
            encode = ALIGN0_INT_RAW_err_lane6_raw_enum;
            reset = 0x0;
        } err_lane6_raw[7:7];

        enum ALIGN0_INT_RAW_err_lane5_raw_enum {
            NO_RAW_INTERRUPT = 0 { name = "No Raw Interrupt"; desc = "No raw interrupt is generated."; };
            RAW_INTERRUPT_GENERATED = 1 { name = "Raw Interrupt Generated"; desc = "A raw interrupt is generated."; };
        };

        field {
            name = "err_lane5_raw";
            desc = "MIPI_ALIGN lane 5 raw interrupt status";
            sw = rw;
            hw = w;
            onwrite = woclr;
            encode = ALIGN0_INT_RAW_err_lane5_raw_enum;
            reset = 0x0;
        } err_lane5_raw[6:6];

        enum ALIGN0_INT_RAW_err_lane4_raw_enum {
            NO_RAW_INTERRUPT = 0 { name = "No Raw Interrupt"; desc = "No raw interrupt is generated."; };
            RAW_INTERRUPT_GENERATED = 1 { name = "Raw Interrupt Generated"; desc = "A raw interrupt is generated."; };
        };

        field {
            name = "err_lane4_raw";
            desc = "MIPI_ALIGN lane 4 raw interrupt status";
            sw = rw;
            hw = w;
            onwrite = woclr;
            encode = ALIGN0_INT_RAW_err_lane4_raw_enum;
            reset = 0x0;
        } err_lane4_raw[5:5];

        enum ALIGN0_INT_RAW_err_lane3_raw_enum {
            NO_RAW_INTERRUPT = 0 { name = "No Raw Interrupt"; desc = "No raw interrupt is generated."; };
            RAW_INTERRUPT_GENERATED = 1 { name = "Raw Interrupt Generated"; desc = "A raw interrupt is generated."; };
        };

        field {
            name = "err_lane3_raw";
            desc = "MIPI_ALIGN lane 3 raw interrupt status";
            sw = rw;
            hw = w;
            onwrite = woclr;
            encode = ALIGN0_INT_RAW_err_lane3_raw_enum;
            reset = 0x0;
        } err_lane3_raw[4:4];

        enum ALIGN0_INT_RAW_err_lane2_raw_enum {
            NO_RAW_INTERRUPT = 0 { name = "No Raw Interrupt"; desc = "No raw interrupt is generated."; };
            RAW_INTERRUPT_GENERATED = 1 { name = "Raw Interrupt Generated"; desc = "A raw interrupt is generated."; };
        };

        field {
            name = "err_lane2_raw";
            desc = "MIPI_ALIGN lane 2 raw interrupt status";
            sw = rw;
            hw = w;
            onwrite = woclr;
            encode = ALIGN0_INT_RAW_err_lane2_raw_enum;
            reset = 0x0;
        } err_lane2_raw[3:3];

        enum ALIGN0_INT_RAW_err_lane1_raw_enum {
            NO_RAW_INTERRUPT = 0 { name = "No Raw Interrupt"; desc = "No raw interrupt is generated."; };
            RAW_INTERRUPT_GENERATED = 1 { name = "Raw Interrupt Generated"; desc = "A raw interrupt is generated."; };
        };

        field {
            name = "err_lane1_raw";
            desc = "MIPI_ALIGN lane 1 raw interrupt status";
            sw = rw;
            hw = w;
            onwrite = woclr;
            encode = ALIGN0_INT_RAW_err_lane1_raw_enum;
            reset = 0x0;
        } err_lane1_raw[2:2];

        enum ALIGN0_INT_RAW_err_lane0_raw_enum {
            NO_RAW_INTERRUPT = 0 { name = "No Raw Interrupt"; desc = "No raw interrupt is generated."; };
            RAW_INTERRUPT_GENERATED = 1 { name = "Raw Interrupt Generated"; desc = "A raw interrupt is generated."; };
        };

        field {
            name = "err_lane0_raw";
            desc = "MIPI_ALIGN lane 0 raw interrupt status";
            sw = rw;
            hw = w;
            onwrite = woclr;
            encode = ALIGN0_INT_RAW_err_lane0_raw_enum;
            reset = 0x0;
        } err_lane0_raw[1:1];

        enum ALIGN0_INT_RAW_err_full_raw_enum {
            NO_RAW_INTERRUPT = 0 { name = "No Raw Interrupt"; desc = "No raw interrupt is generated."; };
            RAW_INTERRUPT_GENERATED = 1 { name = "Raw Interrupt Generated"; desc = "A raw interrupt is generated."; };
        };

        field {
            name = "err_full_raw";
            desc = "MIPI_ALIGN FIFO raw interrupt status";
            sw = rw;
            hw = w;
            onwrite = woclr;
            encode = ALIGN0_INT_RAW_err_full_raw_enum;
            reset = 0x0;
        } err_full_raw[0:0];
    } ALIGN0_INT_RAW @ 0x17F0;

    reg {
        name = "MIPI_ALIGN interrupt status register T";
        desc = "ALIGN0_INT is a MIPI_ALIGN interrupt status register. Hi3516A V200 Professional HD IP Camera SoC

Data sheet 9.3.6 ALIGN0_INT (offset 0x17F4, printed page 9-398, `hi3516av200--Hi3516AV200-Datasheet.txt` line 60663).";

        enum ALIGN0_INT_err_lane11_st_enum {
            NO_INTERRUPT_GENERATED = 0 { name = "No Interrupt Generated"; desc = "No interrupt is generated."; };
            INTERRUPT_GENERATED = 1 { name = "Interrupt Generated"; desc = "An interrupt is generated."; };
        };

        field {
            name = "err_lane11_st";
            desc = "MIPI_ALIGN lane 11 interrupt status";
            sw = r;
            hw = w;
            encode = ALIGN0_INT_err_lane11_st_enum;
            reset = 0x0;
        } err_lane11_st[12:12];

        enum ALIGN0_INT_err_lane10_st_enum {
            NO_INTERRUPT_GENERATED = 0 { name = "No Interrupt Generated"; desc = "No interrupt is generated."; };
            INTERRUPT_GENERATED = 1 { name = "Interrupt Generated"; desc = "An interrupt is generated."; };
        };

        field {
            name = "err_lane10_st";
            desc = "MIPI_ALIGN lane 10 interrupt status";
            sw = r;
            hw = w;
            encode = ALIGN0_INT_err_lane10_st_enum;
            reset = 0x0;
        } err_lane10_st[11:11];

        enum ALIGN0_INT_err_lane9_st_enum {
            NO_INTERRUPT_GENERATED = 0 { name = "No Interrupt Generated"; desc = "No interrupt is generated."; };
            INTERRUPT_GENERATED = 1 { name = "Interrupt Generated"; desc = "An interrupt is generated."; };
        };

        field {
            name = "err_lane9_st";
            desc = "MIPI_ALIGN lane 9 interrupt status";
            sw = r;
            hw = w;
            encode = ALIGN0_INT_err_lane9_st_enum;
            reset = 0x0;
        } err_lane9_st[10:10];

        enum ALIGN0_INT_err_lane8_st_enum {
            NO_INTERRUPT_GENERATED = 0 { name = "No Interrupt Generated"; desc = "No interrupt is generated."; };
            INTERRUPT_GENERATED = 1 { name = "Interrupt Generated"; desc = "An interrupt is generated."; };
        };

        field {
            name = "err_lane8_st";
            desc = "MIPI_ALIGN lane 8 interrupt status";
            sw = r;
            hw = w;
            encode = ALIGN0_INT_err_lane8_st_enum;
            reset = 0x0;
        } err_lane8_st[9:9];

        enum ALIGN0_INT_err_lane7_st_enum {
            NO_INTERRUPT_GENERATED = 0 { name = "No Interrupt Generated"; desc = "No interrupt is generated."; };
            INTERRUPT_GENERATED = 1 { name = "Interrupt Generated"; desc = "An interrupt is generated."; };
        };

        field {
            name = "err_lane7_st";
            desc = "MIPI_ALIGN lane 7 interrupt status";
            sw = r;
            hw = w;
            encode = ALIGN0_INT_err_lane7_st_enum;
            reset = 0x0;
        } err_lane7_st[8:8];

        enum ALIGN0_INT_err_lane6_st_enum {
            NO_INTERRUPT_GENERATED = 0 { name = "No Interrupt Generated"; desc = "No interrupt is generated."; };
            INTERRUPT_GENERATED = 1 { name = "Interrupt Generated"; desc = "An interrupt is generated."; };
        };

        field {
            name = "err_lane6_st";
            desc = "MIPI_ALIGN lane 6 interrupt status";
            sw = r;
            hw = w;
            encode = ALIGN0_INT_err_lane6_st_enum;
            reset = 0x0;
        } err_lane6_st[7:7];

        enum ALIGN0_INT_err_lane5_st_enum {
            NO_INTERRUPT_GENERATED = 0 { name = "No Interrupt Generated"; desc = "No interrupt is generated."; };
            INTERRUPT_GENERATED = 1 { name = "Interrupt Generated"; desc = "An interrupt is generated."; };
        };

        field {
            name = "err_lane5_st";
            desc = "MIPI_ALIGN lane 5 interrupt status";
            sw = r;
            hw = w;
            encode = ALIGN0_INT_err_lane5_st_enum;
            reset = 0x0;
        } err_lane5_st[6:6];

        enum ALIGN0_INT_err_lane4_st_enum {
            NO_INTERRUPT_GENERATED = 0 { name = "No Interrupt Generated"; desc = "No interrupt is generated."; };
            INTERRUPT_GENERATED = 1 { name = "Interrupt Generated"; desc = "An interrupt is generated."; };
        };

        field {
            name = "err_lane4_st";
            desc = "MIPI_ALIGN lane 4 interrupt status";
            sw = r;
            hw = w;
            encode = ALIGN0_INT_err_lane4_st_enum;
            reset = 0x0;
        } err_lane4_st[5:5];

        enum ALIGN0_INT_err_lane3_st_enum {
            NO_INTERRUPT_GENERATED = 0 { name = "No Interrupt Generated"; desc = "No interrupt is generated."; };
            INTERRUPT_GENERATED = 1 { name = "Interrupt Generated"; desc = "An interrupt is generated."; };
        };

        field {
            name = "err_lane3_st";
            desc = "MIPI_ALIGN lane 3 interrupt status";
            sw = r;
            hw = w;
            encode = ALIGN0_INT_err_lane3_st_enum;
            reset = 0x0;
        } err_lane3_st[4:4];

        enum ALIGN0_INT_err_lane2_st_enum {
            NO_INTERRUPT_GENERATED = 0 { name = "No Interrupt Generated"; desc = "No interrupt is generated."; };
            INTERRUPT_GENERATED = 1 { name = "Interrupt Generated"; desc = "An interrupt is generated."; };
        };

        field {
            name = "err_lane2_st";
            desc = "MIPI_ALIGN lane 2 interrupt status";
            sw = r;
            hw = w;
            encode = ALIGN0_INT_err_lane2_st_enum;
            reset = 0x0;
        } err_lane2_st[3:3];

        enum ALIGN0_INT_err_lane1_st_enum {
            NO_INTERRUPT_GENERATED = 0 { name = "No Interrupt Generated"; desc = "No interrupt is generated."; };
            INTERRUPT_GENERATED = 1 { name = "Interrupt Generated"; desc = "An interrupt is generated."; };
        };

        field {
            name = "err_lane1_st";
            desc = "MIPI_ALIGN lane 1 interrupt status";
            sw = r;
            hw = w;
            encode = ALIGN0_INT_err_lane1_st_enum;
            reset = 0x0;
        } err_lane1_st[2:2];

        enum ALIGN0_INT_err_lane0_st_enum {
            NO_INTERRUPT_GENERATED = 0 { name = "No Interrupt Generated"; desc = "No interrupt is generated."; };
            INTERRUPT_GENERATED = 1 { name = "Interrupt Generated"; desc = "An interrupt is generated."; };
        };

        field {
            name = "err_lane0_st";
            desc = "MIPI_ALIGN lane 0 interrupt status";
            sw = r;
            hw = w;
            encode = ALIGN0_INT_err_lane0_st_enum;
            reset = 0x0;
        } err_lane0_st[1:1];

        enum ALIGN0_INT_err_full_st_enum {
            NO_INTERRUPT_GENERATED = 0 { name = "No Interrupt Generated"; desc = "No interrupt is generated."; };
            INTERRUPT_GENERATED = 1 { name = "Interrupt Generated"; desc = "An interrupt is generated."; };
        };

        field {
            name = "err_full_st";
            desc = "MIPI_ALIGN FIFO interrupt status";
            sw = r;
            hw = w;
            encode = ALIGN0_INT_err_full_st_enum;
            reset = 0x0;
        } err_full_st[0:0];
    } ALIGN0_INT @ 0x17F4;

    reg {
        name = "MIPI_ALIGN interrupt mask register T_MSK";
        desc = "ALIGN0_INT_MSK is a MIPI_ALIGN interrupt mask register.

Data sheet 9.3.6 ALIGN0_INT_MSK (offset 0x17F8, printed page 9-399, `hi3516av200--Hi3516AV200-Datasheet.txt` line 60739).";

        enum ALIGN0_INT_MSK_err_lane11_mask_enum {
            MASKED = 0 { name = "Masked"; desc = "masked"; };
            ENABLED = 1 { name = "Enabled"; desc = "enabled"; };
        };

        field {
            name = "err_lane11_mask";
            desc = "MIPI_ALIGN lane 11 interrupt enable";
            sw = rw;
            hw = r;
            encode = ALIGN0_INT_MSK_err_lane11_mask_enum;
            reset = 0x0;
        } err_lane11_mask[12:12];

        enum ALIGN0_INT_MSK_err_lane10_mask_enum {
            MASKED = 0 { name = "Masked"; desc = "masked"; };
            ENABLED = 1 { name = "Enabled"; desc = "enabled"; };
        };

        field {
            name = "err_lane10_mask";
            desc = "MIPI_ALIGN lane 10 interrupt enable";
            sw = rw;
            hw = r;
            encode = ALIGN0_INT_MSK_err_lane10_mask_enum;
            reset = 0x0;
        } err_lane10_mask[11:11];

        enum ALIGN0_INT_MSK_err_lane9_mask_enum {
            MASKED = 0 { name = "Masked"; desc = "masked"; };
            ENABLED = 1 { name = "Enabled"; desc = "enabled"; };
        };

        field {
            name = "err_lane9_mask";
            desc = "MIPI_ALIGN lane 9 interrupt enable";
            sw = rw;
            hw = r;
            encode = ALIGN0_INT_MSK_err_lane9_mask_enum;
            reset = 0x0;
        } err_lane9_mask[10:10];

        enum ALIGN0_INT_MSK_err_lane8_mask_enum {
            MASKED = 0 { name = "Masked"; desc = "masked"; };
            ENABLED = 1 { name = "Enabled"; desc = "enabled"; };
        };

        field {
            name = "err_lane8_mask";
            desc = "MIPI_ALIGN lane 8 interrupt enable";
            sw = rw;
            hw = r;
            encode = ALIGN0_INT_MSK_err_lane8_mask_enum;
            reset = 0x0;
        } err_lane8_mask[9:9];

        enum ALIGN0_INT_MSK_err_lane7_mask_enum {
            MASKED = 0 { name = "Masked"; desc = "masked"; };
            ENABLED = 1 { name = "Enabled"; desc = "enabled"; };
        };

        field {
            name = "err_lane7_mask";
            desc = "MIPI_ALIGN lane 7 interrupt enable";
            sw = rw;
            hw = r;
            encode = ALIGN0_INT_MSK_err_lane7_mask_enum;
            reset = 0x0;
        } err_lane7_mask[8:8];

        enum ALIGN0_INT_MSK_err_lane6_mask_enum {
            MASKED = 0 { name = "Masked"; desc = "masked"; };
            ENABLED = 1 { name = "Enabled"; desc = "enabled"; };
        };

        field {
            name = "err_lane6_mask";
            desc = "MIPI_ALIGN lane 6 interrupt enable";
            sw = rw;
            hw = r;
            encode = ALIGN0_INT_MSK_err_lane6_mask_enum;
            reset = 0x0;
        } err_lane6_mask[7:7];

        enum ALIGN0_INT_MSK_err_lane5_mask_enum {
            MASKED = 0 { name = "Masked"; desc = "masked"; };
            ENABLED = 1 { name = "Enabled"; desc = "enabled"; };
        };

        field {
            name = "err_lane5_mask";
            desc = "MIPI_ALIGN lane 5 interrupt enable";
            sw = rw;
            hw = r;
            encode = ALIGN0_INT_MSK_err_lane5_mask_enum;
            reset = 0x0;
        } err_lane5_mask[6:6];

        enum ALIGN0_INT_MSK_err_lane4_mask_enum {
            MASKED = 0 { name = "Masked"; desc = "masked"; };
            ENABLED = 1 { name = "Enabled"; desc = "enabled"; };
        };

        field {
            name = "err_lane4_mask";
            desc = "MIPI_ALIGN lane 4 interrupt enable";
            sw = rw;
            hw = r;
            encode = ALIGN0_INT_MSK_err_lane4_mask_enum;
            reset = 0x0;
        } err_lane4_mask[5:5];

        enum ALIGN0_INT_MSK_err_lane3_mask_enum {
            MASKED = 0 { name = "Masked"; desc = "masked"; };
            ENABLED = 1 { name = "Enabled"; desc = "enabled"; };
        };

        field {
            name = "err_lane3_mask";
            desc = "MIPI_ALIGN lane 3 interrupt enable";
            sw = rw;
            hw = r;
            encode = ALIGN0_INT_MSK_err_lane3_mask_enum;
            reset = 0x0;
        } err_lane3_mask[4:4];

        enum ALIGN0_INT_MSK_err_lane2_mask_enum {
            MASKED = 0 { name = "Masked"; desc = "masked"; };
            ENABLED = 1 { name = "Enabled"; desc = "enabled"; };
        };

        field {
            name = "err_lane2_mask";
            desc = "MIPI_ALIGN lane 2 interrupt enable";
            sw = rw;
            hw = r;
            encode = ALIGN0_INT_MSK_err_lane2_mask_enum;
            reset = 0x0;
        } err_lane2_mask[3:3];

        enum ALIGN0_INT_MSK_err_lane1_mask_enum {
            MASKED = 0 { name = "Masked"; desc = "masked"; };
            ENABLED = 1 { name = "Enabled"; desc = "enabled"; };
        };

        field {
            name = "err_lane1_mask";
            desc = "MIPI_ALIGN lane 1 interrupt enable";
            sw = rw;
            hw = r;
            encode = ALIGN0_INT_MSK_err_lane1_mask_enum;
            reset = 0x0;
        } err_lane1_mask[2:2];

        enum ALIGN0_INT_MSK_err_lane0_mask_enum {
            MASKED = 0 { name = "Masked"; desc = "masked"; };
            ENABLED = 1 { name = "Enabled"; desc = "enabled"; };
        };

        field {
            name = "err_lane0_mask";
            desc = "MIPI_ALIGN lane 0 interrupt enable";
            sw = rw;
            hw = r;
            encode = ALIGN0_INT_MSK_err_lane0_mask_enum;
            reset = 0x0;
        } err_lane0_mask[1:1];

        enum ALIGN0_INT_MSK_err_full_mask_enum {
            MASKED = 0 { name = "Masked"; desc = "masked"; };
            ENABLED = 1 { name = "Enabled"; desc = "enabled"; };
        };

        field {
            name = "err_full_mask";
            desc = "MIPI_ALIGN FIFO interrupt enable";
            sw = rw;
            hw = r;
            encode = ALIGN0_INT_MSK_err_full_mask_enum;
            reset = 0x0;
        } err_full_mask[0:0];
    } ALIGN0_INT_MSK @ 0x17F8;

    reg {
        name = "MIPI 1 enabled data channel quantity ES_NUM register";
        desc = "MIPI1_LANES_NUM is a MIPI 1 enabled data channel quantity register.

Data sheet 9.3.6 MIPI1_LANES_NUM (offset 0x2004, printed page 9-401, `hi3516av200--Hi3516AV200-Datasheet.txt` line 60820).";

        enum MIPI1_LANES_NUM_mipi1_lane_num_enum {
            V_1 = 0 { name = "V 1"; desc = "1"; };
            V_2 = 1 { name = "V 2"; desc = "2"; };
            V_3 = 2 { name = "V 3"; desc = "3"; };
            V_4 = 3 { name = "V 4"; desc = "4"; };
            V_5 = 4 { name = "V 5"; desc = "5"; };
            V_6 = 5 { name = "V 6"; desc = "6"; };
            V_7 = 6 { name = "V 7"; desc = "7"; };
            V_8 = 7 { name = "V 8"; desc = "8"; };
        };

        field {
            name = "mipi1_lane_num";
            desc = "Number of enabled data channels";
            sw = rw;
            hw = r;
            encode = MIPI1_LANES_NUM_mipi1_lane_num_enum;
            reset = 0x3;
        } mipi1_lane_num[2:0];
    } MIPI1_LANES_NUM @ 0x2004;

    reg {
        name = "MIPI 1 global interrupt status register N_INT_ST";
        desc = "MIPI1_MAIN_INT_ST is a MIPI 1 global interrupt status register. Hi3516A V200 Professional HD IP Camera SoC

Data sheet 9.3.6 MIPI1_MAIN_INT_ST (offset 0x200C, printed page 9-402, `hi3516av200--Hi3516AV200-Datasheet.txt` line 60865).";

        field {
            name = "mipi1_status_int_line";
            desc = "Line interrupt status. This bit is set to 1 when any of the bit in the MIPI1_LINE_INTR_ST register is set to 1. This bit is cleared when it is read. To clear the reported interrupt, this bit and MIPI1_LINE_INTR_ST must be cleared.";
            sw = r;
            hw = w;
            reset = 0x0;
        } mipi1_status_int_line[18:18];

        field {
            name = "mipi1_status_int_pkt";
            desc = "Packet interrupt status. This bit is set to 1 when any of the bit in the MIPI1_PKT_INTR2_ST register is set to 1. This bit is cleared when it is read. To clear the reported interrupt, this bit and MIPI1_PKT_INTR2_ST must be cleared.";
            sw = r;
            hw = w;
            reset = 0x0;
        } mipi1_status_int_pkt[17:17];

        field {
            name = "mipi1_status_int_frame_fatal";
            desc = "Frame interrupt status. This bit is set to 1 when any of the bit in the MIPI1_FRAME_INTR_ST register is set to 1. This bit is cleared when it is read. To clear the reported interrupt, this bit and MIPI1_FRAME_INTR_ST must be cleared.";
            sw = r;
            hw = w;
            reset = 0x0;
        } mipi1_status_int_frame_fatal[2:2];

        field {
            name = "mipi1_status_int_pkt_fatal";
            desc = "Packet interrupt status. This bit is set to 1 when any of the bit in the MIPI1_PKT_INTR_ST register is set to 1. This bit is cleared when it is read. To clear the reported interrupt, this bit and MIPI1_PKT_INTR_ST must be cleared.";
            sw = r;
            hw = w;
            reset = 0x0;
        } mipi1_status_int_pkt_fatal[1:1];
    } MIPI1_MAIN_INT_ST @ 0x200C;

    reg {
        name = "MIPI 1 controller data ID 1 register";
        desc = "MIPI1_DI_1 is a MIPI 1 controller data ID 1 register. Hi3516A V200 Professional HD IP Camera SoC

Data sheet 9.3.6 MIPI1_DI_1 (offset 0x2010, printed page 9-403, `hi3516av200--Hi3516AV200-Datasheet.txt` line 60923).";

        field {
            name = "mipi1_di3_vc";
            desc = "Virtual channel ID of data with the ID 3";
            sw = rw;
            hw = r;
            reset = 0x0;
        } mipi1_di3_vc[31:30];

        enum MIPI1_DI_1_mipi1_di3_dt_enum {
            RAW8 = 0x2A { name = "Raw8"; desc = "RAW8"; };
            RAW10 = 0x2B { name = "Raw10"; desc = "RAW10"; };
            RAW12 = 0x2C { name = "Raw12"; desc = "RAW12"; };
            RAW14_OTHER_VALUES = 0x2D { name = "Raw14 Other Values"; desc = "RAW14 Other values: reserved"; };
        };

        field {
            name = "mipi1_di3_dt";
            desc = "Type of data with the ID 3";
            sw = rw;
            hw = r;
            encode = MIPI1_DI_1_mipi1_di3_dt_enum;
            reset = 0x0;
        } mipi1_di3_dt[29:24];

        field {
            name = "mipi1_di2_vc";
            desc = "Virtual channel ID of data with the ID 2";
            sw = rw;
            hw = r;
            reset = 0x0;
        } mipi1_di2_vc[23:22];

        enum MIPI1_DI_1_mipi1_di2_dt_enum {
            RAW8 = 0x2A { name = "Raw8"; desc = "RAW8"; };
            RAW10 = 0x2B { name = "Raw10"; desc = "RAW10"; };
            RAW12 = 0x2C { name = "Raw12"; desc = "RAW12"; };
            RAW14_OTHER_VALUES = 0x2D { name = "Raw14 Other Values"; desc = "RAW14 Other values: reserved"; };
        };

        field {
            name = "mipi1_di2_dt";
            desc = "Type of data with the ID 2";
            sw = rw;
            hw = r;
            encode = MIPI1_DI_1_mipi1_di2_dt_enum;
            reset = 0x0;
        } mipi1_di2_dt[21:16];

        field {
            name = "mipi1_di1_vc";
            desc = "Virtual channel ID of data with the ID 1";
            sw = rw;
            hw = r;
            reset = 0x0;
        } mipi1_di1_vc[15:14];

        enum MIPI1_DI_1_mipi1_di1_dt_enum {
            RAW8 = 0x2A { name = "Raw8"; desc = "RAW8"; };
            RAW10 = 0x2B { name = "Raw10"; desc = "RAW10"; };
            RAW12 = 0x2C { name = "Raw12"; desc = "RAW12"; };
            RAW14_OTHER_VALUES = 0x2D { name = "Raw14 Other Values"; desc = "RAW14 Other values: reserved"; };
        };

        field {
            name = "mipi1_di1_dt";
            desc = "Type of data with the ID 1";
            sw = rw;
            hw = r;
            encode = MIPI1_DI_1_mipi1_di1_dt_enum;
            reset = 0x0;
        } mipi1_di1_dt[13:8];

        field {
            name = "mipi1_di0_vc";
            desc = "Virtual channel ID of data with the ID 0";
            sw = rw;
            hw = r;
            reset = 0x0;
        } mipi1_di0_vc[7:6];

        enum MIPI1_DI_1_mipi1_di0_dt_enum {
            RAW8 = 0x2A { name = "Raw8"; desc = "RAW8"; };
            RAW10 = 0x2B { name = "Raw10"; desc = "RAW10"; };
            RAW12 = 0x2C { name = "Raw12"; desc = "RAW12"; };
            RAW14_OTHER_VALUES = 0x2D { name = "Raw14 Other Values"; desc = "RAW14 Other values: reserved"; };
        };

        field {
            name = "mipi1_di0_dt";
            desc = "Type of data with the ID 0";
            sw = rw;
            hw = r;
            encode = MIPI1_DI_1_mipi1_di0_dt_enum;
            reset = 0x0;
        } mipi1_di0_dt[5:0];
    } MIPI1_DI_1 @ 0x2010;

    reg {
        name = "MIPI 1 controller data ID 2 register";
        desc = "MIPI1_DI_2 is a MIPI 1 controller data ID 2 register.

Data sheet 9.3.6 MIPI1_DI_2 (offset 0x2014, printed page 9-404, `hi3516av200--Hi3516AV200-Datasheet.txt` line 60991).";

        field {
            name = "mipi1_di7_vc";
            desc = "Virtual channel ID of data with the ID 7";
            sw = rw;
            hw = r;
            reset = 0x0;
        } mipi1_di7_vc[31:30];

        enum MIPI1_DI_2_mipi1_di7_dt_enum {
            RAW8 = 0x2A { name = "Raw8"; desc = "RAW8"; };
            RAW10 = 0x2B { name = "Raw10"; desc = "RAW10"; };
            RAW12 = 0x2C { name = "Raw12"; desc = "RAW12"; };
            RAW14_OTHER_VALUES = 0x2D { name = "Raw14 Other Values"; desc = "RAW14 Other values: reserved"; };
        };

        field {
            name = "mipi1_di7_dt";
            desc = "Type of data with the ID 7";
            sw = rw;
            hw = r;
            encode = MIPI1_DI_2_mipi1_di7_dt_enum;
            reset = 0x0;
        } mipi1_di7_dt[29:24];

        field {
            name = "mipi1_di6_vc";
            desc = "Virtual channel ID of data with the ID 6";
            sw = rw;
            hw = r;
            reset = 0x0;
        } mipi1_di6_vc[23:22];

        enum MIPI1_DI_2_mipi1_di6_dt_enum {
            RAW8 = 0x2A { name = "Raw8"; desc = "RAW8"; };
            RAW10 = 0x2B { name = "Raw10"; desc = "RAW10"; };
            RAW12 = 0x2C { name = "Raw12"; desc = "RAW12"; };
            RAW14_OTHER_VALUES = 0x2D { name = "Raw14 Other Values"; desc = "RAW14 Other values: reserved"; };
        };

        field {
            name = "mipi1_di6_dt";
            desc = "Type of data with the ID 6";
            sw = rw;
            hw = r;
            encode = MIPI1_DI_2_mipi1_di6_dt_enum;
            reset = 0x0;
        } mipi1_di6_dt[21:16];

        field {
            name = "mipi1_di5_vc";
            desc = "Virtual channel ID of data with the ID 5";
            sw = rw;
            hw = r;
            reset = 0x0;
        } mipi1_di5_vc[15:14];

        enum MIPI1_DI_2_mipi1_di5_dt_enum {
            RAW8 = 0x2A { name = "Raw8"; desc = "RAW8"; };
            RAW10 = 0x2B { name = "Raw10"; desc = "RAW10"; };
            RAW12 = 0x2C { name = "Raw12"; desc = "RAW12"; };
            RAW14_OTHER_VALUES = 0x2D { name = "Raw14 Other Values"; desc = "RAW14 Other values: reserved"; };
        };

        field {
            name = "mipi1_di5_dt";
            desc = "Type of data with the ID 5";
            sw = rw;
            hw = r;
            encode = MIPI1_DI_2_mipi1_di5_dt_enum;
            reset = 0x0;
        } mipi1_di5_dt[13:8];

        field {
            name = "mipi1_di4_vc";
            desc = "Virtual channel ID of data with the ID 4";
            sw = rw;
            hw = r;
            reset = 0x0;
        } mipi1_di4_vc[7:6];

        enum MIPI1_DI_2_mipi1_di4_dt_enum {
            RAW8 = 0x2A { name = "Raw8"; desc = "RAW8"; };
            RAW10 = 0x2B { name = "Raw10"; desc = "RAW10"; };
            RAW12 = 0x2C { name = "Raw12"; desc = "RAW12"; };
            RAW14_OTHER_VALUES = 0x2D { name = "Raw14 Other Values"; desc = "RAW14 Other values: reserved"; };
        };

        field {
            name = "mipi1_di4_dt";
            desc = "Type of data with the ID 4";
            sw = rw;
            hw = r;
            encode = MIPI1_DI_2_mipi1_di4_dt_enum;
            reset = 0x0;
        } mipi1_di4_dt[5:0];
    } MIPI1_DI_2 @ 0x2014;

    reg {
        name = "MIPI 1 packet interrupt status register INTR_ST";
        desc = "MIPI1_PKT_INTR_ST is a MIPI 1 packet interrupt status register.

Data sheet 9.3.6 MIPI1_PKT_INTR_ST (offset 0x2060, printed page 9-405, `hi3516av200--Hi3516AV200-Datasheet.txt` line 61058).";

        enum MIPI1_PKT_INTR_ST_mipi1_err_ecc_double_enum {
            NO_ECC_ERROR = 0 { name = "No Ecc Error"; desc = "No ECC error occurs."; };
            ECC_ERRORS_OCCUR = 1 { name = "Ecc Errors Occur"; desc = "ECC errors occur."; };
        };

        field {
            name = "mipi1_err_ecc_double";
            desc = "Whether the header has at least two uncorrectable ECC errors. This bit is cleared when it is read.";
            sw = r;
            hw = w;
            onread = rclr;
            encode = MIPI1_PKT_INTR_ST_mipi1_err_ecc_double_enum;
            reset = 0x0;
        } mipi1_err_ecc_double[16:16];

        enum MIPI1_PKT_INTR_ST_mipi1_vc3_err_crc_enum {
            NO = 0 { name = "No"; desc = "no"; };
            YES = 1 { name = "Yes"; desc = "yes"; };
        };

        field {
            name = "mipi1_vc3_err_crc";
            desc = "Whether the VC 3 data has CRC errors. This bit is cleared when it is read.";
            sw = r;
            hw = w;
            onread = rclr;
            encode = MIPI1_PKT_INTR_ST_mipi1_vc3_err_crc_enum;
            reset = 0x0;
        } mipi1_vc3_err_crc[3:3];

        enum MIPI1_PKT_INTR_ST_mipi1_vc2_err_crc_enum {
            NO = 0 { name = "No"; desc = "no"; };
            YES = 1 { name = "Yes"; desc = "yes"; };
        };

        field {
            name = "mipi1_vc2_err_crc";
            desc = "Whether the VC 2 data has CRC errors. This bit is cleared when it is read.";
            sw = r;
            hw = w;
            onread = rclr;
            encode = MIPI1_PKT_INTR_ST_mipi1_vc2_err_crc_enum;
            reset = 0x0;
        } mipi1_vc2_err_crc[2:2];

        enum MIPI1_PKT_INTR_ST_mipi1_vc1_err_crc_enum {
            NO = 0 { name = "No"; desc = "no"; };
            YES = 1 { name = "Yes"; desc = "yes"; };
        };

        field {
            name = "mipi1_vc1_err_crc";
            desc = "Whether the VC 1 data has CRC errors. This bit is cleared when it is read.";
            sw = r;
            hw = w;
            onread = rclr;
            encode = MIPI1_PKT_INTR_ST_mipi1_vc1_err_crc_enum;
            reset = 0x0;
        } mipi1_vc1_err_crc[1:1];

        enum MIPI1_PKT_INTR_ST_mipi1_vc0_err_crc_enum {
            NO = 0 { name = "No"; desc = "no"; };
            YES = 1 { name = "Yes"; desc = "yes"; };
        };

        field {
            name = "mipi1_vc0_err_crc";
            desc = "Whether the VC 0 data has CRC errors. This bit is cleared when it is read.";
            sw = r;
            hw = w;
            onread = rclr;
            encode = MIPI1_PKT_INTR_ST_mipi1_vc0_err_crc_enum;
            reset = 0x0;
        } mipi1_vc0_err_crc[0:0];
    } MIPI1_PKT_INTR_ST @ 0x2060;

    reg {
        name = "MIPI 1 packet interrupt mask register INTR_MSK";
        desc = "MIPI1_PKT_INTR_MSK is a MIPI 1 packet interrupt mask register.

Data sheet 9.3.6 MIPI1_PKT_INTR_MSK (offset 0x2064, printed page 9-406, `hi3516av200--Hi3516AV200-Datasheet.txt` line 61120).";

        enum MIPI1_PKT_INTR_MSK_mipi1_mask_err_ecc_double_enum {
            MASKED = 0 { name = "Masked"; desc = "masked"; };
            ENABLED = 1 { name = "Enabled"; desc = "enabled"; };
        };

        field {
            name = "mipi1_mask_err_ecc_double";
            desc = "err_ecc_double interrupt mask";
            sw = rw;
            hw = r;
            encode = MIPI1_PKT_INTR_MSK_mipi1_mask_err_ecc_double_enum;
            reset = 0x0;
        } mipi1_mask_err_ecc_double[16:16];

        enum MIPI1_PKT_INTR_MSK_mipi1_mask_vc3_err_crc_enum {
            MASKED = 0 { name = "Masked"; desc = "masked"; };
            ENABLED = 1 { name = "Enabled"; desc = "enabled"; };
        };

        field {
            name = "mipi1_mask_vc3_err_crc";
            desc = "vc3_err_crc interrupt mask";
            sw = rw;
            hw = r;
            encode = MIPI1_PKT_INTR_MSK_mipi1_mask_vc3_err_crc_enum;
            reset = 0x0;
        } mipi1_mask_vc3_err_crc[3:3];

        enum MIPI1_PKT_INTR_MSK_mipi1_mask_vc2_err_crc_enum {
            MASKED = 0 { name = "Masked"; desc = "masked"; };
            ENABLED = 1 { name = "Enabled"; desc = "enabled"; };
        };

        field {
            name = "mipi1_mask_vc2_err_crc";
            desc = "vc2_err_crc interrupt mask";
            sw = rw;
            hw = r;
            encode = MIPI1_PKT_INTR_MSK_mipi1_mask_vc2_err_crc_enum;
            reset = 0x0;
        } mipi1_mask_vc2_err_crc[2:2];

        enum MIPI1_PKT_INTR_MSK_mipi1_mask_vc1_err_crc_enum {
            MASKED = 0 { name = "Masked"; desc = "masked"; };
            ENABLED = 1 { name = "Enabled"; desc = "enabled"; };
        };

        field {
            name = "mipi1_mask_vc1_err_crc";
            desc = "vc1_err_crc interrupt mask";
            sw = rw;
            hw = r;
            encode = MIPI1_PKT_INTR_MSK_mipi1_mask_vc1_err_crc_enum;
            reset = 0x0;
        } mipi1_mask_vc1_err_crc[1:1];

        enum MIPI1_PKT_INTR_MSK_mipi1_mask_vc0_err_crc_enum {
            MASKED = 0 { name = "Masked"; desc = "masked"; };
            ENABLED = 1 { name = "Enabled"; desc = "enabled"; };
        };

        field {
            name = "mipi1_mask_vc0_err_crc";
            desc = "vc0_err_crc interrupt mask";
            sw = rw;
            hw = r;
            encode = MIPI1_PKT_INTR_MSK_mipi1_mask_vc0_err_crc_enum;
            reset = 0x0;
        } mipi1_mask_vc0_err_crc[0:0];
    } MIPI1_PKT_INTR_MSK @ 0x2064;

    reg {
        name = "MIPI1 PKT INTR FORCE";
        desc = "[inferred] MIPI1 PKT INTR FORCE. Not in the data sheet. Source: OpenIPC openhisilicon `kernel/mipi_rx/hi3519v101/mipi_reg.h` (GPL-3.0 repository, HiSilicon copyright; local copy sources/openhisilicon), union `U_MIPI_PKT_INTR_FORCE`, struct offset 0x2068 (GPL-3.0 repository, HiSilicon copyright; one header for Hi3519 V101 and Hi3516A V200). Reset value and access type unknown (modelled RW, no reset). Confidence: medium (vendor header for this chip family, not hardware verified).";

        field {
            name = "force_err_ecc_double";
            desc = "[inferred] Force error ecc double. (vendor header `hi3519v101/mipi_reg.h` field `force_err_ecc_double`; access and reset unknown, modelled RW)";
            sw = rw;
            hw = r;
        } force_err_ecc_double[16:16];

        field {
            name = "force_vc3_err_crc";
            desc = "[inferred] Force vc3 error crc. (vendor header `hi3519v101/mipi_reg.h` field `force_vc3_err_crc`; access and reset unknown, modelled RW)";
            sw = rw;
            hw = r;
        } force_vc3_err_crc[3:3];

        field {
            name = "force_vc2_err_crc";
            desc = "[inferred] Force vc2 error crc. (vendor header `hi3519v101/mipi_reg.h` field `force_vc2_err_crc`; access and reset unknown, modelled RW)";
            sw = rw;
            hw = r;
        } force_vc2_err_crc[2:2];

        field {
            name = "force_vc1_err_crc";
            desc = "[inferred] Force vc1 error crc. (vendor header `hi3519v101/mipi_reg.h` field `force_vc1_err_crc`; access and reset unknown, modelled RW)";
            sw = rw;
            hw = r;
        } force_vc1_err_crc[1:1];

        field {
            name = "force_vc0_err_crc";
            desc = "[inferred] Force vc0 error crc. (vendor header `hi3519v101/mipi_reg.h` field `force_vc0_err_crc`; access and reset unknown, modelled RW)";
            sw = rw;
            hw = r;
        } force_vc0_err_crc[0:0];
    } MIPI1_PKT_INTR_FORCE @ 0x2068;

    reg {
        name = "MIPI 1 packet interrupt status register 2 INTR2_ST";
        desc = "MIPI1_PKT_INTR2_ST is a MIPI 1 packet interrupt status register 2.

Data sheet 9.3.6 MIPI1_PKT_INTR2_ST (offset 0x2070, printed page 9-407, `hi3516av200--Hi3516AV200-Datasheet.txt` line 61183).";

        enum MIPI1_PKT_INTR2_ST_mipi1_vc3_err_ecc_corrected_enum {
            NO = 0 { name = "No"; desc = "no"; };
            YES_ECC_ERRORS = 1 { name = "Yes Ecc Errors"; desc = "yes. The ECC errors have been corrected."; };
        };

        field {
            name = "mipi1_vc3_err_ecc_corrected";
            desc = "Whether the VC 3 channel has header errors. This bit is cleared when it is read.";
            sw = r;
            hw = w;
            onread = rclr;
            encode = MIPI1_PKT_INTR2_ST_mipi1_vc3_err_ecc_corrected_enum;
            reset = 0x0;
        } mipi1_vc3_err_ecc_corrected[19:19];

        enum MIPI1_PKT_INTR2_ST_mipi1_vc2_err_ecc_corrected_enum {
            NO = 0 { name = "No"; desc = "no"; };
            YES_ECC_ERRORS = 1 { name = "Yes Ecc Errors"; desc = "yes. The ECC errors have been corrected."; };
        };

        field {
            name = "mipi1_vc2_err_ecc_corrected";
            desc = "Whether the VC 2 channel has header errors. This bit is cleared when it is read.";
            sw = r;
            hw = w;
            onread = rclr;
            encode = MIPI1_PKT_INTR2_ST_mipi1_vc2_err_ecc_corrected_enum;
            reset = 0x0;
        } mipi1_vc2_err_ecc_corrected[18:18];

        enum MIPI1_PKT_INTR2_ST_mipi1_vc1_err_ecc_corrected_enum {
            NO = 0 { name = "No"; desc = "no"; };
            YES_ECC_ERRORS = 1 { name = "Yes Ecc Errors"; desc = "yes. The ECC errors have been corrected."; };
        };

        field {
            name = "mipi1_vc1_err_ecc_corrected";
            desc = "Whether the VC 1 channel has header errors. This bit is cleared when it is read.";
            sw = r;
            hw = w;
            onread = rclr;
            encode = MIPI1_PKT_INTR2_ST_mipi1_vc1_err_ecc_corrected_enum;
            reset = 0x0;
        } mipi1_vc1_err_ecc_corrected[17:17];

        enum MIPI1_PKT_INTR2_ST_mipi1_vc0_err_ecc_corrected_enum {
            NO = 0 { name = "No"; desc = "no"; };
            YES_ECC_ERRORS = 1 { name = "Yes Ecc Errors"; desc = "yes. The ECC errors have been corrected."; };
        };

        field {
            name = "mipi1_vc0_err_ecc_corrected";
            desc = "Whether the VC 0 channel has header errors. This bit is cleared when it is read.";
            sw = r;
            hw = w;
            onread = rclr;
            encode = MIPI1_PKT_INTR2_ST_mipi1_vc0_err_ecc_corrected_enum;
            reset = 0x0;
        } mipi1_vc0_err_ecc_corrected[16:16];

        enum MIPI1_PKT_INTR2_ST_mipi1_err_id_vc3_enum {
            SUPPORTED = 0 { name = "Supported"; desc = "supported"; };
            NOT_SUPPORTED = 1 { name = "Not Supported"; desc = "not supported"; };
        };

        field {
            name = "mipi1_err_id_vc3";
            desc = "Whether the VC 3 channel data type is supported. This bit is cleared when it is read.";
            sw = r;
            hw = w;
            onread = rclr;
            encode = MIPI1_PKT_INTR2_ST_mipi1_err_id_vc3_enum;
            reset = 0x0;
        } mipi1_err_id_vc3[3:3];

        enum MIPI1_PKT_INTR2_ST_mipi1_err_id_vc2_enum {
            SUPPORTED = 0 { name = "Supported"; desc = "supported"; };
            NOT_SUPPORTED = 1 { name = "Not Supported"; desc = "not supported"; };
        };

        field {
            name = "mipi1_err_id_vc2";
            desc = "Whether the VC 2 channel data type is supported. This bit is cleared when it is read.";
            sw = r;
            hw = w;
            onread = rclr;
            encode = MIPI1_PKT_INTR2_ST_mipi1_err_id_vc2_enum;
            reset = 0x0;
        } mipi1_err_id_vc2[2:2];

        enum MIPI1_PKT_INTR2_ST_mipi1_err_id_vc1_enum {
            SUPPORTED = 0 { name = "Supported"; desc = "supported"; };
            NOT_SUPPORTED = 1 { name = "Not Supported"; desc = "not supported"; };
        };

        field {
            name = "mipi1_err_id_vc1";
            desc = "Whether the VC 1 channel data type is supported. This bit is cleared when it is read.";
            sw = r;
            hw = w;
            onread = rclr;
            encode = MIPI1_PKT_INTR2_ST_mipi1_err_id_vc1_enum;
            reset = 0x0;
        } mipi1_err_id_vc1[1:1];

        enum MIPI1_PKT_INTR2_ST_mipi1_err_id_vc0_enum {
            SUPPORTED = 0 { name = "Supported"; desc = "supported"; };
            NOT_SUPPORTED = 1 { name = "Not Supported"; desc = "not supported"; };
        };

        field {
            name = "mipi1_err_id_vc0";
            desc = "Whether the VC 0 channel data type is supported. This bit is cleared when it is read.";
            sw = r;
            hw = w;
            onread = rclr;
            encode = MIPI1_PKT_INTR2_ST_mipi1_err_id_vc0_enum;
            reset = 0x0;
        } mipi1_err_id_vc0[0:0];
    } MIPI1_PKT_INTR2_ST @ 0x2070;

    reg {
        name = "MIPI 1 packet interrupt mask register 2 INTR2_MSK";
        desc = "MIPI1_PKT_INTR2_MSK is a MIPI 1 packet interrupt mask register 2. Hi3516A V200 Professional HD IP Camera SoC

Data sheet 9.3.6 MIPI1_PKT_INTR2_MSK (offset 0x2074, printed page 9-409, `hi3516av200--Hi3516AV200-Datasheet.txt` line 61270).";

        enum MIPI1_PKT_INTR2_MSK_mipi1_mask_vc3_err_ecc_corrected_enum {
            MASKED = 0 { name = "Masked"; desc = "masked"; };
            ENABLED = 1 { name = "Enabled"; desc = "enabled"; };
        };

        field {
            name = "mipi1_mask_vc3_err_ecc_corrected";
            desc = "mipi1_vc3_err_ecc_corrected interrupt mask";
            sw = rw;
            hw = r;
            encode = MIPI1_PKT_INTR2_MSK_mipi1_mask_vc3_err_ecc_corrected_enum;
            reset = 0x0;
        } mipi1_mask_vc3_err_ecc_corrected[19:19];

        enum MIPI1_PKT_INTR2_MSK_mipi1_mask_vc2_err_ecc_corrected_enum {
            MASKED = 0 { name = "Masked"; desc = "masked"; };
            ENABLED = 1 { name = "Enabled"; desc = "enabled"; };
        };

        field {
            name = "mipi1_mask_vc2_err_ecc_corrected";
            desc = "mipi1_vc2_err_ecc_corrected interrupt mask";
            sw = rw;
            hw = r;
            encode = MIPI1_PKT_INTR2_MSK_mipi1_mask_vc2_err_ecc_corrected_enum;
            reset = 0x0;
        } mipi1_mask_vc2_err_ecc_corrected[18:18];

        enum MIPI1_PKT_INTR2_MSK_mipi1_mask_vc1_err_ecc_corrected_enum {
            MASKED = 0 { name = "Masked"; desc = "masked"; };
            ENABLED = 1 { name = "Enabled"; desc = "enabled"; };
        };

        field {
            name = "mipi1_mask_vc1_err_ecc_corrected";
            desc = "mipi1_vc1_err_ecc_corrected interrupt mask";
            sw = rw;
            hw = r;
            encode = MIPI1_PKT_INTR2_MSK_mipi1_mask_vc1_err_ecc_corrected_enum;
            reset = 0x0;
        } mipi1_mask_vc1_err_ecc_corrected[17:17];

        enum MIPI1_PKT_INTR2_MSK_mipi1_mask_vc0_err_ecc_corrected_enum {
            MASKED = 0 { name = "Masked"; desc = "masked"; };
            ENABLED = 1 { name = "Enabled"; desc = "enabled"; };
        };

        field {
            name = "mipi1_mask_vc0_err_ecc_corrected";
            desc = "mipi1_vc0_err_ecc_corrected interrupt mask";
            sw = rw;
            hw = r;
            encode = MIPI1_PKT_INTR2_MSK_mipi1_mask_vc0_err_ecc_corrected_enum;
            reset = 0x0;
        } mipi1_mask_vc0_err_ecc_corrected[16:16];

        enum MIPI1_PKT_INTR2_MSK_mipi1_mask_err_id_vc3_enum {
            MASKED = 0 { name = "Masked"; desc = "masked"; };
            ENABLED = 1 { name = "Enabled"; desc = "enabled"; };
        };

        field {
            name = "mipi1_mask_err_id_vc3";
            desc = "mipi1_err_id_vc3 interrupt mask";
            sw = rw;
            hw = r;
            encode = MIPI1_PKT_INTR2_MSK_mipi1_mask_err_id_vc3_enum;
            reset = 0x0;
        } mipi1_mask_err_id_vc3[3:3];

        enum MIPI1_PKT_INTR2_MSK_mipi1_mask_err_id_vc2_enum {
            MASKED = 0 { name = "Masked"; desc = "masked"; };
            ENABLED = 1 { name = "Enabled"; desc = "enabled"; };
        };

        field {
            name = "mipi1_mask_err_id_vc2";
            desc = "mipi1_err_id_vc2 interrupt mask";
            sw = rw;
            hw = r;
            encode = MIPI1_PKT_INTR2_MSK_mipi1_mask_err_id_vc2_enum;
            reset = 0x0;
        } mipi1_mask_err_id_vc2[2:2];

        enum MIPI1_PKT_INTR2_MSK_mipi1_mask_err_id_vc1_enum {
            MASKED = 0 { name = "Masked"; desc = "masked"; };
            ENABLED = 1 { name = "Enabled"; desc = "enabled"; };
        };

        field {
            name = "mipi1_mask_err_id_vc1";
            desc = "mipi1_err_id_vc1 interrupt mask";
            sw = rw;
            hw = r;
            encode = MIPI1_PKT_INTR2_MSK_mipi1_mask_err_id_vc1_enum;
            reset = 0x0;
        } mipi1_mask_err_id_vc1[1:1];

        enum MIPI1_PKT_INTR2_MSK_mipi1_mask_err_id_vc0_enum {
            MASKED = 0 { name = "Masked"; desc = "masked"; };
            ENABLED = 1 { name = "Enabled"; desc = "enabled"; };
        };

        field {
            name = "mipi1_mask_err_id_vc0";
            desc = "mipi1_err_id_vc0 interrupt mask";
            sw = rw;
            hw = r;
            encode = MIPI1_PKT_INTR2_MSK_mipi1_mask_err_id_vc0_enum;
            reset = 0x0;
        } mipi1_mask_err_id_vc0[0:0];
    } MIPI1_PKT_INTR2_MSK @ 0x2074;

    reg {
        name = "MIPI1 PKT INTR2 FORCE";
        desc = "[inferred] MIPI1 PKT INTR2 FORCE. Not in the data sheet. Source: OpenIPC openhisilicon `kernel/mipi_rx/hi3519v101/mipi_reg.h` (GPL-3.0 repository, HiSilicon copyright; local copy sources/openhisilicon), union `U_MIPI_PKT_INTR2_FORCE`, struct offset 0x2078 (GPL-3.0 repository, HiSilicon copyright; one header for Hi3519 V101 and Hi3516A V200). Reset value and access type unknown (modelled RW, no reset). Confidence: medium (vendor header for this chip family, not hardware verified).";

        field {
            name = "force_vc3_err_ecc_corrected";
            desc = "[inferred] Force vc3 error ecc corrected. (vendor header `hi3519v101/mipi_reg.h` field `force_vc3_err_ecc_corrected`; access and reset unknown, modelled RW)";
            sw = rw;
            hw = r;
        } force_vc3_err_ecc_corrected[19:19];

        field {
            name = "force_vc2_err_ecc_corrected";
            desc = "[inferred] Force vc2 error ecc corrected. (vendor header `hi3519v101/mipi_reg.h` field `force_vc2_err_ecc_corrected`; access and reset unknown, modelled RW)";
            sw = rw;
            hw = r;
        } force_vc2_err_ecc_corrected[18:18];

        field {
            name = "force_vc1_err_ecc_corrected";
            desc = "[inferred] Force vc1 error ecc corrected. (vendor header `hi3519v101/mipi_reg.h` field `force_vc1_err_ecc_corrected`; access and reset unknown, modelled RW)";
            sw = rw;
            hw = r;
        } force_vc1_err_ecc_corrected[17:17];

        field {
            name = "force_vc0_err_ecc_corrected";
            desc = "[inferred] Force vc0 error ecc corrected. (vendor header `hi3519v101/mipi_reg.h` field `force_vc0_err_ecc_corrected`; access and reset unknown, modelled RW)";
            sw = rw;
            hw = r;
        } force_vc0_err_ecc_corrected[16:16];

        field {
            name = "force_err_id_vc3";
            desc = "[inferred] Force error id vc3. (vendor header `hi3519v101/mipi_reg.h` field `force_err_id_vc3`; access and reset unknown, modelled RW)";
            sw = rw;
            hw = r;
        } force_err_id_vc3[3:3];

        field {
            name = "force_err_id_vc2";
            desc = "[inferred] Force error id vc2. (vendor header `hi3519v101/mipi_reg.h` field `force_err_id_vc2`; access and reset unknown, modelled RW)";
            sw = rw;
            hw = r;
        } force_err_id_vc2[2:2];

        field {
            name = "force_err_id_vc1";
            desc = "[inferred] Force error id vc1. (vendor header `hi3519v101/mipi_reg.h` field `force_err_id_vc1`; access and reset unknown, modelled RW)";
            sw = rw;
            hw = r;
        } force_err_id_vc1[1:1];

        field {
            name = "force_err_id_vc0";
            desc = "[inferred] Force error id vc0. (vendor header `hi3519v101/mipi_reg.h` field `force_err_id_vc0`; access and reset unknown, modelled RW)";
            sw = rw;
            hw = r;
        } force_err_id_vc0[0:0];
    } MIPI1_PKT_INTR2_FORCE @ 0x2078;

    reg {
        name = "MIPI 1 frame interrupt status register ME_INTR_S T";
        desc = "MIPI1_FRAME_INTR_ST is a MIPI 1 frame interrupt status register.

Data sheet 9.3.6 MIPI1_FRAME_INTR_ST (offset 0x2080, printed page 9-410, `hi3516av200--Hi3516AV200-Datasheet.txt` line 61347).";

        enum MIPI1_FRAME_INTR_ST_mipi1_err_frame_data_vc3_enum {
            NO_CRC_ERROR = 0 { name = "No Crc Error"; desc = "No CRC error occurs."; };
            CRC_ERRORS_OCCUR = 1 { name = "Crc Errors Occur"; desc = "CRC errors occur."; };
        };

        field {
            name = "mipi1_err_frame_data_vc3";
            desc = "Whether the last frame of VC 3 channel data has at least one CRC error. This bit is cleared when it is read.";
            sw = r;
            hw = w;
            onread = rclr;
            encode = MIPI1_FRAME_INTR_ST_mipi1_err_frame_data_vc3_enum;
            reset = 0x0;
        } mipi1_err_frame_data_vc3[19:19];

        enum MIPI1_FRAME_INTR_ST_mipi1_err_frame_data_vc2_enum {
            NO_CRC_ERROR = 0 { name = "No Crc Error"; desc = "No CRC error occurs."; };
            CRC_ERRORS_OCCUR = 1 { name = "Crc Errors Occur"; desc = "CRC errors occur."; };
        };

        field {
            name = "mipi1_err_frame_data_vc2";
            desc = "Whether the last frame of VC 2 channel data has at least one CRC error. This bit is cleared when it is read.";
            sw = r;
            hw = w;
            onread = rclr;
            encode = MIPI1_FRAME_INTR_ST_mipi1_err_frame_data_vc2_enum;
            reset = 0x0;
        } mipi1_err_frame_data_vc2[18:18];

        enum MIPI1_FRAME_INTR_ST_mipi1_err_frame_data_vc1_enum {
            NO_CRC_ERROR = 0 { name = "No Crc Error"; desc = "No CRC error occurs."; };
            CRC_ERRORS_OCCUR = 1 { name = "Crc Errors Occur"; desc = "CRC errors occur."; };
        };

        field {
            name = "mipi1_err_frame_data_vc1";
            desc = "Whether the last frame of VC 1 channel data has at least one CRC error. This bit is cleared when it is read.";
            sw = r;
            hw = w;
            onread = rclr;
            encode = MIPI1_FRAME_INTR_ST_mipi1_err_frame_data_vc1_enum;
            reset = 0x0;
        } mipi1_err_frame_data_vc1[17:17];

        enum MIPI1_FRAME_INTR_ST_mipi1_err_frame_data_vc0_enum {
            NO_CRC_ERROR = 0 { name = "No Crc Error"; desc = "No CRC error occurs."; };
            CRC_ERRORS_OCCUR = 1 { name = "Crc Errors Occur"; desc = "CRC errors occur."; };
        };

        field {
            name = "mipi1_err_frame_data_vc0";
            desc = "Whether the last frame of VC 0 channel data has at least one CRC error. This bit is cleared when it is read.";
            sw = r;
            hw = w;
            onread = rclr;
            encode = MIPI1_FRAME_INTR_ST_mipi1_err_frame_data_vc0_enum;
            reset = 0x0;
        } mipi1_err_frame_data_vc0[16:16];

        enum MIPI1_FRAME_INTR_ST_mipi1_err_f_seq_vc3_enum {
            YES = 0 { name = "Yes"; desc = "yes"; };
            NO = 1 { name = "No"; desc = "no"; };
        };

        field {
            name = "mipi1_err_f_seq_vc3";
            desc = "Whether the VC 3 frame sequence is correct. This bit is cleared when it is read.";
            sw = r;
            hw = w;
            onread = rclr;
            encode = MIPI1_FRAME_INTR_ST_mipi1_err_f_seq_vc3_enum;
            reset = 0x0;
        } mipi1_err_f_seq_vc3[11:11];

        enum MIPI1_FRAME_INTR_ST_mipi1_err_f_seq_vc2_enum {
            YES = 0 { name = "Yes"; desc = "yes"; };
            NO = 1 { name = "No"; desc = "no"; };
        };

        field {
            name = "mipi1_err_f_seq_vc2";
            desc = "Whether the VC 2 frame sequence is correct. This bit is cleared when it is read.";
            sw = r;
            hw = w;
            onread = rclr;
            encode = MIPI1_FRAME_INTR_ST_mipi1_err_f_seq_vc2_enum;
            reset = 0x0;
        } mipi1_err_f_seq_vc2[10:10];

        enum MIPI1_FRAME_INTR_ST_mipi1_err_f_seq_vc1_enum {
            YES = 0 { name = "Yes"; desc = "yes"; };
            NO = 1 { name = "No"; desc = "no"; };
        };

        field {
            name = "mipi1_err_f_seq_vc1";
            desc = "Whether the VC 1 frame sequence is correct. This bit is cleared when it is read.";
            sw = r;
            hw = w;
            onread = rclr;
            encode = MIPI1_FRAME_INTR_ST_mipi1_err_f_seq_vc1_enum;
            reset = 0x0;
        } mipi1_err_f_seq_vc1[9:9];

        enum MIPI1_FRAME_INTR_ST_mipi1_err_f_seq_vc0_enum {
            YES = 0 { name = "Yes"; desc = "yes"; };
            NO = 1 { name = "No"; desc = "no"; };
        };

        field {
            name = "mipi1_err_f_seq_vc0";
            desc = "Whether the VC 0 frame sequence is correct. This bit is cleared when it is read.";
            sw = r;
            hw = w;
            onread = rclr;
            encode = MIPI1_FRAME_INTR_ST_mipi1_err_f_seq_vc0_enum;
            reset = 0x0;
        } mipi1_err_f_seq_vc0[8:8];

        enum MIPI1_FRAME_INTR_ST_mipi1_err_f_bndry_match_vc3_enum {
            YES = 0 { name = "Yes"; desc = "yes"; };
            NO = 1 { name = "No"; desc = "no"; };
        };

        field {
            name = "mipi1_err_f_bndry_match_vc3";
            desc = "Whether the SOF matches the EOF for the VC 3 channel. This bit is cleared when it is read.";
            sw = r;
            hw = w;
            onread = rclr;
            encode = MIPI1_FRAME_INTR_ST_mipi1_err_f_bndry_match_vc3_enum;
            reset = 0x0;
        } mipi1_err_f_bndry_match_vc3[3:3];

        enum MIPI1_FRAME_INTR_ST_mipi1_err_f_bndry_match_vc2_enum {
            YES = 0 { name = "Yes"; desc = "yes"; };
            NO = 1 { name = "No"; desc = "no"; };
        };

        field {
            name = "mipi1_err_f_bndry_match_vc2";
            desc = "Whether the SOF matches the EOF for the VC 2 channel. This bit is cleared when it is read.";
            sw = r;
            hw = w;
            onread = rclr;
            encode = MIPI1_FRAME_INTR_ST_mipi1_err_f_bndry_match_vc2_enum;
            reset = 0x0;
        } mipi1_err_f_bndry_match_vc2[2:2];

        enum MIPI1_FRAME_INTR_ST_mipi1_err_f_bndry_match_vc1_enum {
            YES = 0 { name = "Yes"; desc = "yes"; };
            NO = 1 { name = "No"; desc = "no"; };
        };

        field {
            name = "mipi1_err_f_bndry_match_vc1";
            desc = "Whether the SOF matches the EOF for the VC 1 channel. This bit is cleared when it is read.";
            sw = r;
            hw = w;
            onread = rclr;
            encode = MIPI1_FRAME_INTR_ST_mipi1_err_f_bndry_match_vc1_enum;
            reset = 0x0;
        } mipi1_err_f_bndry_match_vc1[1:1];

        enum MIPI1_FRAME_INTR_ST_mipi1_err_f_bndry_match_vc0_enum {
            YES = 0 { name = "Yes"; desc = "yes"; };
            NO = 1 { name = "No"; desc = "no"; };
        };

        field {
            name = "mipi1_err_f_bndry_match_vc0";
            desc = "Whether the SOF matches the EOF for the VC 0 channel. This bit is cleared when it is read.";
            sw = r;
            hw = w;
            onread = rclr;
            encode = MIPI1_FRAME_INTR_ST_mipi1_err_f_bndry_match_vc0_enum;
            reset = 0x0;
        } mipi1_err_f_bndry_match_vc0[0:0];
    } MIPI1_FRAME_INTR_ST @ 0x2080;

    reg {
        name = "MIPI 1 frame interrupt mask register ME_INTR_ MSK";
        desc = "MIPI1_FRAME_INTR_MSK is a MIPI 1 frame interrupt mask register.

Data sheet 9.3.6 MIPI1_FRAME_INTR_MSK (offset 0x2084, printed page 9-412, `hi3516av200--Hi3516AV200-Datasheet.txt` line 61465).";

        enum MIPI1_FRAME_INTR_MSK_mipi1_mask_err_frame_data_vc3_enum {
            MASKED = 0 { name = "Masked"; desc = "masked"; };
            ENABLED = 1 { name = "Enabled"; desc = "enabled"; };
        };

        field {
            name = "mipi1_mask_err_frame_data_vc3";
            desc = "mipi1_err_frame_data_vc3 interrupt mask";
            sw = rw;
            hw = r;
            encode = MIPI1_FRAME_INTR_MSK_mipi1_mask_err_frame_data_vc3_enum;
            reset = 0x0;
        } mipi1_mask_err_frame_data_vc3[19:19];

        enum MIPI1_FRAME_INTR_MSK_mipi1_mask_err_frame_data_vc2_enum {
            MASKED = 0 { name = "Masked"; desc = "masked"; };
            ENABLED = 1 { name = "Enabled"; desc = "enabled"; };
        };

        field {
            name = "mipi1_mask_err_frame_data_vc2";
            desc = "mipi1_err_frame_data_vc2 interrupt mask";
            sw = rw;
            hw = r;
            encode = MIPI1_FRAME_INTR_MSK_mipi1_mask_err_frame_data_vc2_enum;
            reset = 0x0;
        } mipi1_mask_err_frame_data_vc2[18:18];

        enum MIPI1_FRAME_INTR_MSK_mipi1_mask_err_frame_data_vc1_enum {
            MASKED = 0 { name = "Masked"; desc = "masked"; };
            ENABLED = 1 { name = "Enabled"; desc = "enabled"; };
        };

        field {
            name = "mipi1_mask_err_frame_data_vc1";
            desc = "mipi1_err_frame_data_vc1 interrupt mask";
            sw = rw;
            hw = r;
            encode = MIPI1_FRAME_INTR_MSK_mipi1_mask_err_frame_data_vc1_enum;
            reset = 0x0;
        } mipi1_mask_err_frame_data_vc1[17:17];

        enum MIPI1_FRAME_INTR_MSK_mipi1_mask_err_frame_data_vc0_enum {
            MASKED = 0 { name = "Masked"; desc = "masked"; };
            ENABLED = 1 { name = "Enabled"; desc = "enabled"; };
        };

        field {
            name = "mipi1_mask_err_frame_data_vc0";
            desc = "mipi1_err_frame_data_vc0 interrupt mask";
            sw = rw;
            hw = r;
            encode = MIPI1_FRAME_INTR_MSK_mipi1_mask_err_frame_data_vc0_enum;
            reset = 0x0;
        } mipi1_mask_err_frame_data_vc0[16:16];

        enum MIPI1_FRAME_INTR_MSK_mipi1_mask_err_f_seq_vc3_enum {
            MASKED = 0 { name = "Masked"; desc = "masked"; };
            ENABLED = 1 { name = "Enabled"; desc = "enabled"; };
        };

        field {
            name = "mipi1_mask_err_f_seq_vc3";
            desc = "mipi1_err_f_seq_vc3 interrupt mask";
            sw = rw;
            hw = r;
            encode = MIPI1_FRAME_INTR_MSK_mipi1_mask_err_f_seq_vc3_enum;
            reset = 0x0;
        } mipi1_mask_err_f_seq_vc3[11:11];

        enum MIPI1_FRAME_INTR_MSK_mipi1_mask_err_f_seq_vc2_enum {
            MASKED = 0 { name = "Masked"; desc = "masked"; };
            ENABLED = 1 { name = "Enabled"; desc = "enabled"; };
        };

        field {
            name = "mipi1_mask_err_f_seq_vc2";
            desc = "mipi1_err_f_seq_vc2 interrupt mask";
            sw = rw;
            hw = r;
            encode = MIPI1_FRAME_INTR_MSK_mipi1_mask_err_f_seq_vc2_enum;
            reset = 0x0;
        } mipi1_mask_err_f_seq_vc2[10:10];

        enum MIPI1_FRAME_INTR_MSK_mipi1_mask_err_f_seq_vc1_enum {
            MASKED = 0 { name = "Masked"; desc = "masked"; };
            ENABLED = 1 { name = "Enabled"; desc = "enabled"; };
        };

        field {
            name = "mipi1_mask_err_f_seq_vc1";
            desc = "mipi1_err_f_seq_vc1 interrupt mask";
            sw = rw;
            hw = r;
            encode = MIPI1_FRAME_INTR_MSK_mipi1_mask_err_f_seq_vc1_enum;
            reset = 0x0;
        } mipi1_mask_err_f_seq_vc1[9:9];

        enum MIPI1_FRAME_INTR_MSK_mipi1_mask_err_f_seq_vc0_enum {
            MASKED = 0 { name = "Masked"; desc = "masked"; };
            ENABLED = 1 { name = "Enabled"; desc = "enabled"; };
        };

        field {
            name = "mipi1_mask_err_f_seq_vc0";
            desc = "mipi1_err_f_seq_vc0 interrupt mask";
            sw = rw;
            hw = r;
            encode = MIPI1_FRAME_INTR_MSK_mipi1_mask_err_f_seq_vc0_enum;
            reset = 0x0;
        } mipi1_mask_err_f_seq_vc0[8:8];

        enum MIPI1_FRAME_INTR_MSK_mipi1_mask_err_f_bndry_match_vc3_enum {
            MASKED = 0 { name = "Masked"; desc = "masked"; };
            ENABLED = 1 { name = "Enabled"; desc = "enabled"; };
        };

        field {
            name = "mipi1_mask_err_f_bndry_match_vc3";
            desc = "mipi1_err_f_bndry_match_vc3 interrupt mask";
            sw = rw;
            hw = r;
            encode = MIPI1_FRAME_INTR_MSK_mipi1_mask_err_f_bndry_match_vc3_enum;
            reset = 0x0;
        } mipi1_mask_err_f_bndry_match_vc3[3:3];

        enum MIPI1_FRAME_INTR_MSK_mipi1_mask_err_f_bndry_match_vc2_enum {
            MASKED = 0 { name = "Masked"; desc = "masked"; };
            ENABLED = 1 { name = "Enabled"; desc = "enabled"; };
        };

        field {
            name = "mipi1_mask_err_f_bndry_match_vc2";
            desc = "mipi1_err_f_bndry_match_vc2 interrupt mask";
            sw = rw;
            hw = r;
            encode = MIPI1_FRAME_INTR_MSK_mipi1_mask_err_f_bndry_match_vc2_enum;
            reset = 0x0;
        } mipi1_mask_err_f_bndry_match_vc2[2:2];

        enum MIPI1_FRAME_INTR_MSK_mipi1_mask_err_f_bndry_match_vc1_enum {
            MASKED = 0 { name = "Masked"; desc = "masked"; };
            ENABLED = 1 { name = "Enabled"; desc = "enabled"; };
        };

        field {
            name = "mipi1_mask_err_f_bndry_match_vc1";
            desc = "mipi1_err_f_bndry_match_vc1 interrupt mask";
            sw = rw;
            hw = r;
            encode = MIPI1_FRAME_INTR_MSK_mipi1_mask_err_f_bndry_match_vc1_enum;
            reset = 0x0;
        } mipi1_mask_err_f_bndry_match_vc1[1:1];

        enum MIPI1_FRAME_INTR_MSK_mipi1_mask_err_f_bndry_match_vc0_enum {
            MASKED = 0 { name = "Masked"; desc = "masked"; };
            ENABLED = 1 { name = "Enabled"; desc = "enabled"; };
        };

        field {
            name = "mipi1_mask_err_f_bndry_match_vc0";
            desc = "mipi1_err_f_bndry_match_vc0 interrupt mask";
            sw = rw;
            hw = r;
            encode = MIPI1_FRAME_INTR_MSK_mipi1_mask_err_f_bndry_match_vc0_enum;
            reset = 0x0;
        } mipi1_mask_err_f_bndry_match_vc0[0:0];
    } MIPI1_FRAME_INTR_MSK @ 0x2084;

    reg {
        name = "MIPI1 FRAME INTR FORCE";
        desc = "[inferred] MIPI1 FRAME INTR FORCE. Not in the data sheet. Source: OpenIPC openhisilicon `kernel/mipi_rx/hi3519v101/mipi_reg.h` (GPL-3.0 repository, HiSilicon copyright; local copy sources/openhisilicon), union `U_MIPI_FRAME_INTR_FORCE`, struct offset 0x2088 (GPL-3.0 repository, HiSilicon copyright; one header for Hi3519 V101 and Hi3516A V200). Reset value and access type unknown (modelled RW, no reset). Confidence: medium (vendor header for this chip family, not hardware verified).";

        field {
            name = "force_err_frame_data_vc3";
            desc = "[inferred] Force error frame data vc3. (vendor header `hi3519v101/mipi_reg.h` field `force_err_frame_data_vc3`; access and reset unknown, modelled RW)";
            sw = rw;
            hw = r;
        } force_err_frame_data_vc3[19:19];

        field {
            name = "force_err_frame_data_vc2";
            desc = "[inferred] Force error frame data vc2. (vendor header `hi3519v101/mipi_reg.h` field `force_err_frame_data_vc2`; access and reset unknown, modelled RW)";
            sw = rw;
            hw = r;
        } force_err_frame_data_vc2[18:18];

        field {
            name = "force_err_frame_data_vc1";
            desc = "[inferred] Force error frame data vc1. (vendor header `hi3519v101/mipi_reg.h` field `force_err_frame_data_vc1`; access and reset unknown, modelled RW)";
            sw = rw;
            hw = r;
        } force_err_frame_data_vc1[17:17];

        field {
            name = "force_err_frame_data_vc0";
            desc = "[inferred] Force error frame data vc0. (vendor header `hi3519v101/mipi_reg.h` field `force_err_frame_data_vc0`; access and reset unknown, modelled RW)";
            sw = rw;
            hw = r;
        } force_err_frame_data_vc0[16:16];

        field {
            name = "force_err_f_seq_vc3";
            desc = "[inferred] Force error f seq vc3. (vendor header `hi3519v101/mipi_reg.h` field `force_err_f_seq_vc3`; access and reset unknown, modelled RW)";
            sw = rw;
            hw = r;
        } force_err_f_seq_vc3[11:11];

        field {
            name = "force_err_f_seq_vc2";
            desc = "[inferred] Force error f seq vc2. (vendor header `hi3519v101/mipi_reg.h` field `force_err_f_seq_vc2`; access and reset unknown, modelled RW)";
            sw = rw;
            hw = r;
        } force_err_f_seq_vc2[10:10];

        field {
            name = "force_err_f_seq_vc1";
            desc = "[inferred] Force error f seq vc1. (vendor header `hi3519v101/mipi_reg.h` field `force_err_f_seq_vc1`; access and reset unknown, modelled RW)";
            sw = rw;
            hw = r;
        } force_err_f_seq_vc1[9:9];

        field {
            name = "force_err_f_seq_vc0";
            desc = "[inferred] Force error f seq vc0. (vendor header `hi3519v101/mipi_reg.h` field `force_err_f_seq_vc0`; access and reset unknown, modelled RW)";
            sw = rw;
            hw = r;
        } force_err_f_seq_vc0[8:8];

        field {
            name = "force_err_f_bndry_match_vc3";
            desc = "[inferred] Force error f bndry match vc3. (vendor header `hi3519v101/mipi_reg.h` field `force_err_f_bndry_match_vc3`; access and reset unknown, modelled RW)";
            sw = rw;
            hw = r;
        } force_err_f_bndry_match_vc3[3:3];

        field {
            name = "force_err_f_bndry_match_vc2";
            desc = "[inferred] Force error f bndry match vc2. (vendor header `hi3519v101/mipi_reg.h` field `force_err_f_bndry_match_vc2`; access and reset unknown, modelled RW)";
            sw = rw;
            hw = r;
        } force_err_f_bndry_match_vc2[2:2];

        field {
            name = "force_err_f_bndry_match_vc1";
            desc = "[inferred] Force error f bndry match vc1. (vendor header `hi3519v101/mipi_reg.h` field `force_err_f_bndry_match_vc1`; access and reset unknown, modelled RW)";
            sw = rw;
            hw = r;
        } force_err_f_bndry_match_vc1[1:1];

        field {
            name = "force_err_f_bndry_match_vc0";
            desc = "[inferred] Force error f bndry match vc0. (vendor header `hi3519v101/mipi_reg.h` field `force_err_f_bndry_match_vc0`; access and reset unknown, modelled RW)";
            sw = rw;
            hw = r;
        } force_err_f_bndry_match_vc0[0:0];
    } MIPI1_FRAME_INTR_FORCE @ 0x2088;

    reg {
        name = "MIPI 1 line interrupt status register _INTR_ST";
        desc = "MIPI1_LINE_INTR_ST is a MIPI 1 line interrupt status register. Hi3516A V200 Professional HD IP Camera SoC

Data sheet 9.3.6 MIPI1_LINE_INTR_ST (offset 0x2090, printed page 9-414, `hi3516av200--Hi3516AV200-Datasheet.txt` line 61587).";

        field {
            name = "err_l_seq_di7";
            desc = "[inferred] Error l seq di7. (bits reserved in the data sheet; vendor header `hi3519v101/mipi_reg.h` field `err_l_seq_di7`; access and reset unknown, modelled RW)";
            sw = rw;
            hw = r;
        } err_l_seq_di7[23:23];

        field {
            name = "err_l_seq_di6";
            desc = "[inferred] Error l seq di6. (bits reserved in the data sheet; vendor header `hi3519v101/mipi_reg.h` field `err_l_seq_di6`; access and reset unknown, modelled RW)";
            sw = rw;
            hw = r;
        } err_l_seq_di6[22:22];

        field {
            name = "err_l_seq_di5";
            desc = "[inferred] Error l seq di5. (bits reserved in the data sheet; vendor header `hi3519v101/mipi_reg.h` field `err_l_seq_di5`; access and reset unknown, modelled RW)";
            sw = rw;
            hw = r;
        } err_l_seq_di5[21:21];

        field {
            name = "err_l_seq_di4";
            desc = "[inferred] Error l seq di4. (bits reserved in the data sheet; vendor header `hi3519v101/mipi_reg.h` field `err_l_seq_di4`; access and reset unknown, modelled RW)";
            sw = rw;
            hw = r;
        } err_l_seq_di4[20:20];

        enum MIPI1_LINE_INTR_ST_mipi1_err_l_seq_di_enum {
            YES = 0 { name = "Yes"; desc = "yes"; };
            NO = 1 { name = "No"; desc = "no"; };
        };

        field {
            name = "mipi1_err_l_seq_di";
            desc = "Whether the line sequence of VC 3 and DT 3 is correct. This bit is cleared when it is read.";
            sw = r;
            hw = w;
            onread = rclr;
            encode = MIPI1_LINE_INTR_ST_mipi1_err_l_seq_di_enum;
            reset = 0x0;
        } mipi1_err_l_seq_di[19:19];

        enum MIPI1_LINE_INTR_ST_mipi1_err_l_seq_di_2_enum {
            YES = 0 { name = "Yes"; desc = "yes"; };
            NO = 1 { name = "No"; desc = "no"; };
        };

        field {
            name = "mipi1_err_l_seq_di";
            desc = "Whether the line sequence of VC 2 and DT 2 is correct. This bit is cleared when it is read.";
            sw = r;
            hw = w;
            onread = rclr;
            encode = MIPI1_LINE_INTR_ST_mipi1_err_l_seq_di_2_enum;
            reset = 0x0;
        } mipi1_err_l_seq_di_2[18:18];

        enum MIPI1_LINE_INTR_ST_mipi1_err_l_seq_di_3_enum {
            YES = 0 { name = "Yes"; desc = "yes"; };
            NO = 1 { name = "No"; desc = "no"; };
        };

        field {
            name = "mipi1_err_l_seq_di";
            desc = "Whether the line sequence of VC 1 and DT 1 is correct. This bit is cleared when it is read.";
            sw = r;
            hw = w;
            onread = rclr;
            encode = MIPI1_LINE_INTR_ST_mipi1_err_l_seq_di_3_enum;
            reset = 0x0;
        } mipi1_err_l_seq_di_3[17:17];

        enum MIPI1_LINE_INTR_ST_mipi1_err_l_seq_di_4_enum {
            YES = 0 { name = "Yes"; desc = "yes"; };
            NO = 1 { name = "No"; desc = "no"; };
        };

        field {
            name = "mipi1_err_l_seq_di";
            desc = "Whether the line sequence of VC 0 and DT 0 is correct. This bit is cleared when it is read.";
            sw = r;
            hw = w;
            onread = rclr;
            encode = MIPI1_LINE_INTR_ST_mipi1_err_l_seq_di_4_enum;
            reset = 0x0;
        } mipi1_err_l_seq_di_4[16:16];

        field {
            name = "err_l_bndry_match_di7";
            desc = "[inferred] Error l bndry match di7. (bits reserved in the data sheet; vendor header `hi3519v101/mipi_reg.h` field `err_l_bndry_match_di7`; access and reset unknown, modelled RW)";
            sw = rw;
            hw = r;
        } err_l_bndry_match_di7[7:7];

        field {
            name = "err_l_bndry_match_di6";
            desc = "[inferred] Error l bndry match di6. (bits reserved in the data sheet; vendor header `hi3519v101/mipi_reg.h` field `err_l_bndry_match_di6`; access and reset unknown, modelled RW)";
            sw = rw;
            hw = r;
        } err_l_bndry_match_di6[6:6];

        field {
            name = "err_l_bndry_match_di5";
            desc = "[inferred] Error l bndry match di5. (bits reserved in the data sheet; vendor header `hi3519v101/mipi_reg.h` field `err_l_bndry_match_di5`; access and reset unknown, modelled RW)";
            sw = rw;
            hw = r;
        } err_l_bndry_match_di5[5:5];

        field {
            name = "err_l_bndry_match_di4";
            desc = "[inferred] Error l bndry match di4. (bits reserved in the data sheet; vendor header `hi3519v101/mipi_reg.h` field `err_l_bndry_match_di4`; access and reset unknown, modelled RW)";
            sw = rw;
            hw = r;
        } err_l_bndry_match_di4[4:4];

        enum MIPI1_LINE_INTR_ST_mipi1_err_l_bndry_match_di3_enum {
            YES = 0 { name = "Yes"; desc = "yes"; };
            NO = 1 { name = "No"; desc = "no"; };
        };

        field {
            name = "mipi1_err_l_bndry_match_di3";
            desc = "Whether the SOL matches the EOL for VC 3 and DT 3. This bit is cleared when it is read.";
            sw = r;
            hw = w;
            onread = rclr;
            encode = MIPI1_LINE_INTR_ST_mipi1_err_l_bndry_match_di3_enum;
            reset = 0x0;
        } mipi1_err_l_bndry_match_di3[3:3];

        enum MIPI1_LINE_INTR_ST_mipi1_err_l_bndry_match_di2_enum {
            YES = 0 { name = "Yes"; desc = "yes"; };
            NO = 1 { name = "No"; desc = "no"; };
        };

        field {
            name = "mipi1_err_l_bndry_match_di2";
            desc = "Whether the SOL matches the EOL for VC 2 and DT 2. This bit is cleared when it is read.";
            sw = r;
            hw = w;
            onread = rclr;
            encode = MIPI1_LINE_INTR_ST_mipi1_err_l_bndry_match_di2_enum;
            reset = 0x0;
        } mipi1_err_l_bndry_match_di2[2:2];

        enum MIPI1_LINE_INTR_ST_mipi1_err_l_bndry_match_di1_enum {
            YES = 0 { name = "Yes"; desc = "yes"; };
            NO = 1 { name = "No"; desc = "no"; };
        };

        field {
            name = "mipi1_err_l_bndry_match_di1";
            desc = "Whether the SOL matches the EOL for VC 1 and DT 1. This bit is cleared when it is read.";
            sw = r;
            hw = w;
            onread = rclr;
            encode = MIPI1_LINE_INTR_ST_mipi1_err_l_bndry_match_di1_enum;
            reset = 0x0;
        } mipi1_err_l_bndry_match_di1[1:1];

        enum MIPI1_LINE_INTR_ST_mipi1_err_l_bndry_match_di0_enum {
            YES = 0 { name = "Yes"; desc = "yes"; };
            NO = 1 { name = "No"; desc = "no"; };
        };

        field {
            name = "mipi1_err_l_bndry_match_di0";
            desc = "Whether the SOL matches the EOL for VC 0 and DT 0. This bit is cleared when it is read.";
            sw = r;
            hw = w;
            onread = rclr;
            encode = MIPI1_LINE_INTR_ST_mipi1_err_l_bndry_match_di0_enum;
            reset = 0x0;
        } mipi1_err_l_bndry_match_di0[0:0];
    } MIPI1_LINE_INTR_ST @ 0x2090;

    reg {
        name = "MIPI 1 line interrupt mask register _INTR_MSK";
        desc = "MIPI1_LINE_INTR_MSK is a MIPI 1 line interrupt mask register.

Data sheet 9.3.6 MIPI1_LINE_INTR_MSK (offset 0x2094, printed page 9-415, `hi3516av200--Hi3516AV200-Datasheet.txt` line 61664).";

        field {
            name = "mask_err_l_seq_di7";
            desc = "[inferred] Mask error l seq di7. (bits reserved in the data sheet; vendor header `hi3519v101/mipi_reg.h` field `mask_err_l_seq_di7`; access and reset unknown, modelled RW)";
            sw = rw;
            hw = r;
        } mask_err_l_seq_di7[23:23];

        field {
            name = "mask_err_l_seq_di6";
            desc = "[inferred] Mask error l seq di6. (bits reserved in the data sheet; vendor header `hi3519v101/mipi_reg.h` field `mask_err_l_seq_di6`; access and reset unknown, modelled RW)";
            sw = rw;
            hw = r;
        } mask_err_l_seq_di6[22:22];

        field {
            name = "mask_err_l_seq_di5";
            desc = "[inferred] Mask error l seq di5. (bits reserved in the data sheet; vendor header `hi3519v101/mipi_reg.h` field `mask_err_l_seq_di5`; access and reset unknown, modelled RW)";
            sw = rw;
            hw = r;
        } mask_err_l_seq_di5[21:21];

        field {
            name = "mask_err_l_seq_di4";
            desc = "[inferred] Mask error l seq di4. (bits reserved in the data sheet; vendor header `hi3519v101/mipi_reg.h` field `mask_err_l_seq_di4`; access and reset unknown, modelled RW)";
            sw = rw;
            hw = r;
        } mask_err_l_seq_di4[20:20];

        enum MIPI1_LINE_INTR_MSK_mipi1_mask_err_l_seq_di3_enum {
            MASKED = 0 { name = "Masked"; desc = "masked"; };
            ENABLED = 1 { name = "Enabled"; desc = "enabled"; };
        };

        field {
            name = "mipi1_mask_err_l_seq_di3";
            desc = "mipi1_err_l_seq_di3 interrupt mask";
            sw = rw;
            hw = r;
            encode = MIPI1_LINE_INTR_MSK_mipi1_mask_err_l_seq_di3_enum;
            reset = 0x0;
        } mipi1_mask_err_l_seq_di3[19:19];

        enum MIPI1_LINE_INTR_MSK_mipi1_mask_err_l_seq_di2_enum {
            MASKED = 0 { name = "Masked"; desc = "masked"; };
            ENABLED = 1 { name = "Enabled"; desc = "enabled"; };
        };

        field {
            name = "mipi1_mask_err_l_seq_di2";
            desc = "mipi1_err_l_seq_di2 interrupt mask";
            sw = rw;
            hw = r;
            encode = MIPI1_LINE_INTR_MSK_mipi1_mask_err_l_seq_di2_enum;
            reset = 0x0;
        } mipi1_mask_err_l_seq_di2[18:18];

        enum MIPI1_LINE_INTR_MSK_mipi1_mask_err_l_seq_di1_enum {
            MASKED = 0 { name = "Masked"; desc = "masked"; };
            ENABLED = 1 { name = "Enabled"; desc = "enabled"; };
        };

        field {
            name = "mipi1_mask_err_l_seq_di1";
            desc = "mipi1_err_l_seq_di1 interrupt mask";
            sw = rw;
            hw = r;
            encode = MIPI1_LINE_INTR_MSK_mipi1_mask_err_l_seq_di1_enum;
            reset = 0x0;
        } mipi1_mask_err_l_seq_di1[17:17];

        enum MIPI1_LINE_INTR_MSK_mipi1_mask_err_l_seq_di0_enum {
            MASKED = 0 { name = "Masked"; desc = "masked"; };
            ENABLED = 1 { name = "Enabled"; desc = "enabled"; };
        };

        field {
            name = "mipi1_mask_err_l_seq_di0";
            desc = "mipi1_err_l_seq_di0 interrupt mask";
            sw = rw;
            hw = r;
            encode = MIPI1_LINE_INTR_MSK_mipi1_mask_err_l_seq_di0_enum;
            reset = 0x0;
        } mipi1_mask_err_l_seq_di0[16:16];

        field {
            name = "mask_err_l_bndry_match_di7";
            desc = "[inferred] Mask error l bndry match di7. (bits reserved in the data sheet; vendor header `hi3519v101/mipi_reg.h` field `mask_err_l_bndry_match_di7`; access and reset unknown, modelled RW)";
            sw = rw;
            hw = r;
        } mask_err_l_bndry_match_di7[7:7];

        field {
            name = "mask_err_l_bndry_match_di6";
            desc = "[inferred] Mask error l bndry match di6. (bits reserved in the data sheet; vendor header `hi3519v101/mipi_reg.h` field `mask_err_l_bndry_match_di6`; access and reset unknown, modelled RW)";
            sw = rw;
            hw = r;
        } mask_err_l_bndry_match_di6[6:6];

        field {
            name = "mask_err_l_bndry_match_di5";
            desc = "[inferred] Mask error l bndry match di5. (bits reserved in the data sheet; vendor header `hi3519v101/mipi_reg.h` field `mask_err_l_bndry_match_di5`; access and reset unknown, modelled RW)";
            sw = rw;
            hw = r;
        } mask_err_l_bndry_match_di5[5:5];

        field {
            name = "mask_err_l_bndry_match_di4";
            desc = "[inferred] Mask error l bndry match di4. (bits reserved in the data sheet; vendor header `hi3519v101/mipi_reg.h` field `mask_err_l_bndry_match_di4`; access and reset unknown, modelled RW)";
            sw = rw;
            hw = r;
        } mask_err_l_bndry_match_di4[4:4];

        enum MIPI1_LINE_INTR_MSK_mipi1_mask_err_l_bndry_match_di3_enum {
            MASKED = 0 { name = "Masked"; desc = "masked"; };
            ENABLED = 1 { name = "Enabled"; desc = "enabled"; };
        };

        field {
            name = "mipi1_mask_err_l_bndry_match_di3";
            desc = "mipi1_err_l_bndry_match_di3 interrupt mask";
            sw = rw;
            hw = r;
            encode = MIPI1_LINE_INTR_MSK_mipi1_mask_err_l_bndry_match_di3_enum;
            reset = 0x0;
        } mipi1_mask_err_l_bndry_match_di3[3:3];

        enum MIPI1_LINE_INTR_MSK_mipi1_mask_err_l_bndry_match_di2_enum {
            MASKED = 0 { name = "Masked"; desc = "masked"; };
            ENABLED = 1 { name = "Enabled"; desc = "enabled"; };
        };

        field {
            name = "mipi1_mask_err_l_bndry_match_di2";
            desc = "mipi1_err_l_bndry_match_di2 interrupt mask";
            sw = rw;
            hw = r;
            encode = MIPI1_LINE_INTR_MSK_mipi1_mask_err_l_bndry_match_di2_enum;
            reset = 0x0;
        } mipi1_mask_err_l_bndry_match_di2[2:2];

        enum MIPI1_LINE_INTR_MSK_mipi1_mask_err_l_bndry_match_di1_enum {
            MASKED = 0 { name = "Masked"; desc = "masked"; };
            ENABLED = 1 { name = "Enabled"; desc = "enabled"; };
        };

        field {
            name = "mipi1_mask_err_l_bndry_match_di1";
            desc = "mipi1_err_l_bndry_match_di1 interrupt mask";
            sw = rw;
            hw = r;
            encode = MIPI1_LINE_INTR_MSK_mipi1_mask_err_l_bndry_match_di1_enum;
            reset = 0x0;
        } mipi1_mask_err_l_bndry_match_di1[1:1];

        enum MIPI1_LINE_INTR_MSK_mipi1_mask_err_l_bndry_match_di0_enum {
            MASKED = 0 { name = "Masked"; desc = "masked"; };
            ENABLED = 1 { name = "Enabled"; desc = "enabled"; };
        };

        field {
            name = "mipi1_mask_err_l_bndry_match_di0";
            desc = "mipi1_err_l_bndry_match_di0 interrupt mask";
            sw = rw;
            hw = r;
            encode = MIPI1_LINE_INTR_MSK_mipi1_mask_err_l_bndry_match_di0_enum;
            reset = 0x0;
        } mipi1_mask_err_l_bndry_match_di0[0:0];
    } MIPI1_LINE_INTR_MSK @ 0x2094;

    reg {
        name = "MIPI1 LINE INTR FORCE";
        desc = "[inferred] MIPI1 LINE INTR FORCE. Not in the data sheet. Source: OpenIPC openhisilicon `kernel/mipi_rx/hi3519v101/mipi_reg.h` (GPL-3.0 repository, HiSilicon copyright; local copy sources/openhisilicon), union `U_MIPI_LINE_INTR_FORCE`, struct offset 0x2098 (GPL-3.0 repository, HiSilicon copyright; one header for Hi3519 V101 and Hi3516A V200). Reset value and access type unknown (modelled RW, no reset). Confidence: medium (vendor header for this chip family, not hardware verified).";

        field {
            name = "force_err_l_seq_di7";
            desc = "[inferred] Force error l seq di7. (vendor header `hi3519v101/mipi_reg.h` field `force_err_l_seq_di7`; access and reset unknown, modelled RW)";
            sw = rw;
            hw = r;
        } force_err_l_seq_di7[23:23];

        field {
            name = "force_err_l_seq_di6";
            desc = "[inferred] Force error l seq di6. (vendor header `hi3519v101/mipi_reg.h` field `force_err_l_seq_di6`; access and reset unknown, modelled RW)";
            sw = rw;
            hw = r;
        } force_err_l_seq_di6[22:22];

        field {
            name = "force_err_l_seq_di5";
            desc = "[inferred] Force error l seq di5. (vendor header `hi3519v101/mipi_reg.h` field `force_err_l_seq_di5`; access and reset unknown, modelled RW)";
            sw = rw;
            hw = r;
        } force_err_l_seq_di5[21:21];

        field {
            name = "force_err_l_seq_di4";
            desc = "[inferred] Force error l seq di4. (vendor header `hi3519v101/mipi_reg.h` field `force_err_l_seq_di4`; access and reset unknown, modelled RW)";
            sw = rw;
            hw = r;
        } force_err_l_seq_di4[20:20];

        field {
            name = "force_err_l_seq_di3";
            desc = "[inferred] Force error l seq di3. (vendor header `hi3519v101/mipi_reg.h` field `force_err_l_seq_di3`; access and reset unknown, modelled RW)";
            sw = rw;
            hw = r;
        } force_err_l_seq_di3[19:19];

        field {
            name = "force_err_l_seq_di2";
            desc = "[inferred] Force error l seq di2. (vendor header `hi3519v101/mipi_reg.h` field `force_err_l_seq_di2`; access and reset unknown, modelled RW)";
            sw = rw;
            hw = r;
        } force_err_l_seq_di2[18:18];

        field {
            name = "force_err_l_seq_di1";
            desc = "[inferred] Force error l seq di1. (vendor header `hi3519v101/mipi_reg.h` field `force_err_l_seq_di1`; access and reset unknown, modelled RW)";
            sw = rw;
            hw = r;
        } force_err_l_seq_di1[17:17];

        field {
            name = "force_err_l_seq_di0";
            desc = "[inferred] Force error l seq di0. (vendor header `hi3519v101/mipi_reg.h` field `force_err_l_seq_di0`; access and reset unknown, modelled RW)";
            sw = rw;
            hw = r;
        } force_err_l_seq_di0[16:16];

        field {
            name = "force_err_l_bndry_match_di7";
            desc = "[inferred] Force error l bndry match di7. (vendor header `hi3519v101/mipi_reg.h` field `force_err_l_bndry_match_di7`; access and reset unknown, modelled RW)";
            sw = rw;
            hw = r;
        } force_err_l_bndry_match_di7[7:7];

        field {
            name = "force_err_l_bndry_match_di6";
            desc = "[inferred] Force error l bndry match di6. (vendor header `hi3519v101/mipi_reg.h` field `force_err_l_bndry_match_di6`; access and reset unknown, modelled RW)";
            sw = rw;
            hw = r;
        } force_err_l_bndry_match_di6[6:6];

        field {
            name = "force_err_l_bndry_match_di5";
            desc = "[inferred] Force error l bndry match di5. (vendor header `hi3519v101/mipi_reg.h` field `force_err_l_bndry_match_di5`; access and reset unknown, modelled RW)";
            sw = rw;
            hw = r;
        } force_err_l_bndry_match_di5[5:5];

        field {
            name = "force_err_l_bndry_match_di4";
            desc = "[inferred] Force error l bndry match di4. (vendor header `hi3519v101/mipi_reg.h` field `force_err_l_bndry_match_di4`; access and reset unknown, modelled RW)";
            sw = rw;
            hw = r;
        } force_err_l_bndry_match_di4[4:4];

        field {
            name = "force_err_l_bndry_match_di3";
            desc = "[inferred] Force error l bndry match di3. (vendor header `hi3519v101/mipi_reg.h` field `force_err_l_bndry_match_di3`; access and reset unknown, modelled RW)";
            sw = rw;
            hw = r;
        } force_err_l_bndry_match_di3[3:3];

        field {
            name = "force_err_l_bndry_match_di2";
            desc = "[inferred] Force error l bndry match di2. (vendor header `hi3519v101/mipi_reg.h` field `force_err_l_bndry_match_di2`; access and reset unknown, modelled RW)";
            sw = rw;
            hw = r;
        } force_err_l_bndry_match_di2[2:2];

        field {
            name = "force_err_l_bndry_match_di1";
            desc = "[inferred] Force error l bndry match di1. (vendor header `hi3519v101/mipi_reg.h` field `force_err_l_bndry_match_di1`; access and reset unknown, modelled RW)";
            sw = rw;
            hw = r;
        } force_err_l_bndry_match_di1[1:1];

        field {
            name = "force_err_l_bndry_match_di0";
            desc = "[inferred] Force error l bndry match di0. (vendor header `hi3519v101/mipi_reg.h` field `force_err_l_bndry_match_di0`; access and reset unknown, modelled RW)";
            sw = rw;
            hw = r;
        } force_err_l_bndry_match_di0[0:0];
    } MIPI1_LINE_INTR_FORCE @ 0x2098;

    reg {
        name = "MIPI 1 pixel bit width configuration RDEF_DT register for the user-defined data type";
        desc = "MIPI1_USERDEF_DT is a MIPI 1 pixel bit width configuration register for the user-defined data type.

Data sheet 9.3.6 MIPI1_USERDEF_DT (offset 0x2100, printed page 9-416, `hi3516av200--Hi3516AV200-Datasheet.txt` line 61743).";

        enum MIPI1_USERDEF_DT_mipi1_user_def3_dt_enum {
            V_8_BITS = 0 { name = "V 8 Bits"; desc = "8 bits"; };
            V_10_BITS = 1 { name = "V 10 Bits"; desc = "10 bits"; };
            V_12_BITS = 2 { name = "V 12 Bits"; desc = "12 bits"; };
            V_14_BITS = 3 { name = "V 14 Bits"; desc = "14 bits"; };
            V_16_BITS_OTHER = 4 { name = "V 16 Bits Other"; desc = "16 bits Other values: reserved"; };
        };

        field {
            name = "mipi1_user_def3_dt";
            desc = "Bit width of the transferred pixel when the data type is mipi1_user_def3";
            sw = rw;
            hw = r;
            encode = MIPI1_USERDEF_DT_mipi1_user_def3_dt_enum;
            reset = 0x0;
        } mipi1_user_def3_dt[14:12];

        enum MIPI1_USERDEF_DT_mipi1_user_def2_dt_enum {
            V_8_BITS = 0 { name = "V 8 Bits"; desc = "8 bits"; };
            V_10_BITS = 1 { name = "V 10 Bits"; desc = "10 bits"; };
            V_12_BITS = 2 { name = "V 12 Bits"; desc = "12 bits"; };
            V_14_BITS = 3 { name = "V 14 Bits"; desc = "14 bits"; };
            V_16_BITS_OTHER = 4 { name = "V 16 Bits Other"; desc = "16 bits Other values: reserved"; };
        };

        field {
            name = "mipi1_user_def2_dt";
            desc = "Bit width of the transferred pixel when the data type is mipi1_user_def2";
            sw = rw;
            hw = r;
            encode = MIPI1_USERDEF_DT_mipi1_user_def2_dt_enum;
            reset = 0x0;
        } mipi1_user_def2_dt[10:8];

        enum MIPI1_USERDEF_DT_mipi1_user_def1_dt_enum {
            V_8_BITS = 0 { name = "V 8 Bits"; desc = "8 bits"; };
            V_10_BITS = 1 { name = "V 10 Bits"; desc = "10 bits"; };
            V_12_BITS = 2 { name = "V 12 Bits"; desc = "12 bits"; };
            V_14_BITS = 3 { name = "V 14 Bits"; desc = "14 bits"; };
            V_16_BITS_OTHER = 4 { name = "V 16 Bits Other"; desc = "16 bits Other values: reserved"; };
        };

        field {
            name = "mipi1_user_def1_dt";
            desc = "Bit width of the transferred pixel when the data type is mipi1_user_def1";
            sw = rw;
            hw = r;
            encode = MIPI1_USERDEF_DT_mipi1_user_def1_dt_enum;
            reset = 0x0;
        } mipi1_user_def1_dt[6:4];

        enum MIPI1_USERDEF_DT_mipi1_user_def0_dt_enum {
            V_8_BITS = 0 { name = "V 8 Bits"; desc = "8 bits"; };
            V_10_BITS = 1 { name = "V 10 Bits"; desc = "10 bits"; };
            V_12_BITS = 2 { name = "V 12 Bits"; desc = "12 bits"; };
            V_14_BITS = 3 { name = "V 14 Bits"; desc = "14 bits"; };
            V_16_BITS_OTHER = 4 { name = "V 16 Bits Other"; desc = "16 bits Other values: reserved"; };
        };

        field {
            name = "mipi1_user_def0_dt";
            desc = "Bit width of the transferred pixel when the data type is mipi1_user_def0";
            sw = rw;
            hw = r;
            encode = MIPI1_USERDEF_DT_mipi1_user_def0_dt_enum;
            reset = 0x0;
        } mipi1_user_def0_dt[2:0];
    } MIPI1_USERDEF_DT @ 0x2100;

    reg {
        name = "MIPI 1 user-defined data type enable R_DEF configuration register";
        desc = "MIPI1_USER_DEF is a MIPI 1 user-defined data type enable configuration register. Hi3516A V200 Professional HD IP Camera SoC

Data sheet 9.3.6 MIPI1_USER_DEF (offset 0x2104, printed page 9-418, `hi3516av200--Hi3516AV200-Datasheet.txt` line 61828).";

        field {
            name = "mipi1_user_def3";
            desc = "User-defined data type 3 The value of this field is used for matching the type of the sensor output data. This field works with MIPI1_USERDEF_DT[mipi1_user_def3_dt].";
            sw = rw;
            hw = r;
            reset = 0x10;
        } mipi1_user_def3[29:24];

        field {
            name = "mipi1_user_def2";
            desc = "User-defined data type 2 The value of this field is used for matching the type of the sensor output data. This field works with MIPI1_USERDEF_DT[mipi1_user_def2_dt].";
            sw = rw;
            hw = r;
            reset = 0x36;
        } mipi1_user_def2[21:16];

        field {
            name = "mipi1_user_def1";
            desc = "User-defined data type 1 The value of this field is used for matching the type of the sensor output data. This field works with MIPI1_USERDEF_DT[mipi1_user_def1_dt].";
            sw = rw;
            hw = r;
            reset = 0x35;
        } mipi1_user_def1[13:8];

        field {
            name = "mipi1_user_def0";
            desc = "User-defined data type 0 The value of this field is used for matching the type of the sensor output data. This field works with MIPI1_USERDEF_DT[mipi1_user_def0_dt].";
            sw = rw;
            hw = r;
            reset = 0x34;
        } mipi1_user_def0[5:0];
    } MIPI1_USER_DEF @ 0x2104;

    reg {
        name = "MIPI 1 operating mode enable register L_MODE_H S";
        desc = "MIPI1_CTRL_MODE_HS is a MIPI 1 operating mode enable register. Hi3516A V200 Professional HD IP Camera SoC

Data sheet 9.3.6 MIPI1_CTRL_MODE_HS (offset 0x2108, printed page 9-419, `hi3516av200--Hi3516AV200-Datasheet.txt` line 61880).";

        enum MIPI1_CTRL_MODE_HS_mipi1_user_def_en_enum {
            DISABLED = 0 { name = "Disabled"; desc = "disabled"; };
            ENABLED = 1 { name = "Enabled"; desc = "enabled"; };
        };

        field {
            name = "mipi1_user_def_en";
            desc = "User-defined mode enable";
            sw = rw;
            hw = r;
            encode = MIPI1_CTRL_MODE_HS_mipi1_user_def_en_enum;
            reset = 0x0;
        } mipi1_user_def_en[8:8];
    } MIPI1_CTRL_MODE_HS @ 0x2108;

    reg {
        name = "MIPI 1 DOL mode frame identification _ID_CODE0 register 1";
        desc = "MIPI1_DOL_ID_CODE0 is MIPI 1 DOL mode frame identification register 0.

Data sheet 9.3.6 MIPI1_DOL_ID_CODE0 (offset 0x2200, printed page 9-419, `hi3516av200--Hi3516AV200-Datasheet.txt` line 61909).";

        field {
            name = "mipi1_id_code_reg";
            desc = "ID of SEF 1 frame N in MIPI DOL mode";
            sw = rw;
            hw = r;
            reset = 0x242;
        } mipi1_id_code_reg[31:16];

        field {
            name = "mipi1_id_code_reg";
            desc = "ID of LEF frame N in MIPI DOL mode";
            sw = rw;
            hw = r;
            reset = 0x241;
        } mipi1_id_code_reg_2[15:0];
    } MIPI1_DOL_ID_CODE0 @ 0x2200;

    reg {
        name = "MIPI 1 DOL mode frame identification _ID_CODE1 register 1";
        desc = "MIPI1_DOL_ID_CODE1 is MIPI 1 DOL mode frame identification register 1. Hi3516A V200 Professional HD IP Camera SoC

Data sheet 9.3.6 MIPI1_DOL_ID_CODE1 (offset 0x2204, printed page 9-420, `hi3516av200--Hi3516AV200-Datasheet.txt` line 61943).";

        field {
            name = "mipi1_id_code_reg";
            desc = "ID of LEF frame N + 1 in MIPI DOL mode";
            sw = rw;
            hw = r;
            reset = 0x251;
        } mipi1_id_code_reg[31:16];

        field {
            name = "mipi1_id_code_reg";
            desc = "ID of SEF 2 frame N in MIPI DOL mode";
            sw = rw;
            hw = r;
            reset = 0x244;
        } mipi1_id_code_reg_2[15:0];
    } MIPI1_DOL_ID_CODE1 @ 0x2204;

    reg {
        name = "MIPI 1 DOL mode frame identification _ID_CODE2 register 2";
        desc = "MIPI1_DOL_ID_CODE2 is MIPI 1 DOL mode frame identification register 2.

Data sheet 9.3.6 MIPI1_DOL_ID_CODE2 (offset 0x2208, printed page 9-420, `hi3516av200--Hi3516AV200-Datasheet.txt` line 61966).";

        field {
            name = "mipi1_id_code_reg";
            desc = "ID of SEF 2 frame + 1 in MIPI DOL mode";
            sw = rw;
            hw = r;
            reset = 0x254;
        } mipi1_id_code_reg[31:16];

        field {
            name = "mipi1_id_code_reg";
            desc = "ID of SEF 1 frame N + 1 in MIPI DOL mode";
            sw = rw;
            hw = r;
            reset = 0x252;
        } mipi1_id_code_reg_2[15:0];
    } MIPI1_DOL_ID_CODE2 @ 0x2208;

    reg {
        name = "MIPI1 CROP START CHN0";
        desc = "[inferred] MIPI1 CROP START CHN0. Not in the data sheet. Source: OpenIPC openhisilicon `kernel/mipi_rx/hi3519v101/mipi_reg.h` (GPL-3.0 repository, HiSilicon copyright; local copy sources/openhisilicon), union `U_MIPI_CROP_START_CHN0`, struct offset 0x2210 (GPL-3.0 repository, HiSilicon copyright; one header for Hi3519 V101 and Hi3516A V200). Reset value and access type unknown (modelled RW, no reset). Confidence: medium (vendor header for this chip family, not hardware verified).";

        field {
            name = "mipi_start_y_chn0";
            desc = "[inferred] Mipi start y chn0. (vendor header `hi3519v101/mipi_reg.h` field `mipi_start_y_chn0`; access and reset unknown, modelled RW)";
            sw = rw;
            hw = r;
        } mipi_start_y_chn0[31:16];

        field {
            name = "mipi_start_x_chn0";
            desc = "[inferred] Mipi start x chn0. (vendor header `hi3519v101/mipi_reg.h` field `mipi_start_x_chn0`; access and reset unknown, modelled RW)";
            sw = rw;
            hw = r;
        } mipi_start_x_chn0[15:0];
    } MIPI1_CROP_START_CHN0 @ 0x2210;

    reg {
        name = "MIPI1 CROP START CHN1";
        desc = "[inferred] MIPI1 CROP START CHN1. Not in the data sheet. Source: OpenIPC openhisilicon `kernel/mipi_rx/hi3519v101/mipi_reg.h` (GPL-3.0 repository, HiSilicon copyright; local copy sources/openhisilicon), union `U_MIPI_CROP_START_CHN1`, struct offset 0x2214 (GPL-3.0 repository, HiSilicon copyright; one header for Hi3519 V101 and Hi3516A V200). Reset value and access type unknown (modelled RW, no reset). Confidence: medium (vendor header for this chip family, not hardware verified).";

        field {
            name = "mipi_start_y_chn1";
            desc = "[inferred] Mipi start y chn1. (vendor header `hi3519v101/mipi_reg.h` field `mipi_start_y_chn1`; access and reset unknown, modelled RW)";
            sw = rw;
            hw = r;
        } mipi_start_y_chn1[31:16];

        field {
            name = "mipi_start_x_chn1";
            desc = "[inferred] Mipi start x chn1. (vendor header `hi3519v101/mipi_reg.h` field `mipi_start_x_chn1`; access and reset unknown, modelled RW)";
            sw = rw;
            hw = r;
        } mipi_start_x_chn1[15:0];
    } MIPI1_CROP_START_CHN1 @ 0x2214;

    reg {
        name = "MIPI1 CROP START CHN2";
        desc = "[inferred] MIPI1 CROP START CHN2. Not in the data sheet. Source: OpenIPC openhisilicon `kernel/mipi_rx/hi3519v101/mipi_reg.h` (GPL-3.0 repository, HiSilicon copyright; local copy sources/openhisilicon), union `U_MIPI_CROP_START_CHN2`, struct offset 0x2218 (GPL-3.0 repository, HiSilicon copyright; one header for Hi3519 V101 and Hi3516A V200). Reset value and access type unknown (modelled RW, no reset). Confidence: medium (vendor header for this chip family, not hardware verified).";

        field {
            name = "mipi_start_y_chn2";
            desc = "[inferred] Mipi start y chn2. (vendor header `hi3519v101/mipi_reg.h` field `mipi_start_y_chn2`; access and reset unknown, modelled RW)";
            sw = rw;
            hw = r;
        } mipi_start_y_chn2[31:16];

        field {
            name = "mipi_start_x_chn2";
            desc = "[inferred] Mipi start x chn2. (vendor header `hi3519v101/mipi_reg.h` field `mipi_start_x_chn2`; access and reset unknown, modelled RW)";
            sw = rw;
            hw = r;
        } mipi_start_x_chn2[15:0];
    } MIPI1_CROP_START_CHN2 @ 0x2218;

    reg {
        name = "MIPI1 CROP START CHN3";
        desc = "[inferred] MIPI1 CROP START CHN3. Not in the data sheet. Source: OpenIPC openhisilicon `kernel/mipi_rx/hi3519v101/mipi_reg.h` (GPL-3.0 repository, HiSilicon copyright; local copy sources/openhisilicon), union `U_MIPI_CROP_START_CHN3`, struct offset 0x221C (GPL-3.0 repository, HiSilicon copyright; one header for Hi3519 V101 and Hi3516A V200). Reset value and access type unknown (modelled RW, no reset). Confidence: medium (vendor header for this chip family, not hardware verified).";

        field {
            name = "mipi_start_y_chn3";
            desc = "[inferred] Mipi start y chn3. (vendor header `hi3519v101/mipi_reg.h` field `mipi_start_y_chn3`; access and reset unknown, modelled RW)";
            sw = rw;
            hw = r;
        } mipi_start_y_chn3[31:16];

        field {
            name = "mipi_start_x_chn3";
            desc = "[inferred] Mipi start x chn3. (vendor header `hi3519v101/mipi_reg.h` field `mipi_start_x_chn3`; access and reset unknown, modelled RW)";
            sw = rw;
            hw = r;
        } mipi_start_x_chn3[15:0];
    } MIPI1_CROP_START_CHN3 @ 0x221C;

    reg {
        name = "MIPI1 IMGSIZE";
        desc = "[inferred] MIPI1 IMGSIZE. Not in the data sheet. Source: OpenIPC openhisilicon `kernel/mipi_rx/hi3519v101/mipi_reg.h` (GPL-3.0 repository, HiSilicon copyright; local copy sources/openhisilicon), union `U_MIPI_IMGSIZE`, struct offset 0x2224 (GPL-3.0 repository, HiSilicon copyright; one header for Hi3519 V101 and Hi3516A V200). Reset value and access type unknown (modelled RW, no reset). Confidence: medium (vendor header for this chip family, not hardware verified).";

        field {
            name = "mipi_imgheight";
            desc = "[inferred] Mipi imgheight. (vendor header `hi3519v101/mipi_reg.h` field `mipi_imgheight`; access and reset unknown, modelled RW)";
            sw = rw;
            hw = r;
        } mipi_imgheight[31:16];

        field {
            name = "mipi_imgwidth";
            desc = "[inferred] Mipi imgwidth. (vendor header `hi3519v101/mipi_reg.h` field `mipi_imgwidth`; access and reset unknown, modelled RW)";
            sw = rw;
            hw = r;
        } mipi_imgwidth[15:0];
    } MIPI1_IMGSIZE @ 0x2224;

    reg {
        name = "MIPI 1 output operating mode enable L_MODE_PI register XEL";
        desc = "MIPI1_CTRL_MODE_PIXEL is a MIPI 1 output operating mode enable register. Hi3516A V200 Professional HD IP Camera SoC

Data sheet 9.3.6 MIPI1_CTRL_MODE_PIXEL (offset 0x2230, printed page 9-421, `hi3516av200--Hi3516AV200-Datasheet.txt` line 61999).";

        enum MIPI1_CTRL_MODE_PIXEL_mipi1_stagger_frm_num_enum {
            V_2_FRAME_HDR = 1 { name = "V 2 Frame Hdr"; desc = "2-frame HDR"; };
            V_3_FRAME_HDR = 2 { name = "V 3 Frame Hdr"; desc = "3-frame HDR"; };
            V_4_FRAME_HDR = 3 { name = "V 4 Frame Hdr"; desc = "4-frame HDR Other values: reserved"; };
        };

        field {
            name = "mipi1_stagger_frm_num";
            desc = "Number of frames in staggered HDR mode";
            sw = rw;
            hw = r;
            encode = MIPI1_CTRL_MODE_PIXEL_mipi1_stagger_frm_num_enum;
            reset = 0x0;
        } mipi1_stagger_frm_num[14:13];

        enum MIPI1_CTRL_MODE_PIXEL_mipi1_stagger_hdr_mode_enum {
            DISABLED = 0 { name = "Disabled"; desc = "disabled"; };
            ENABLED = 1 { name = "Enabled"; desc = "enabled"; };
        };

        field {
            name = "mipi1_stagger_hdr_mode";
            desc = "OmniVision staggered HDR mode enable";
            sw = rw;
            hw = r;
            encode = MIPI1_CTRL_MODE_PIXEL_mipi1_stagger_hdr_mode_enum;
            reset = 0x0;
        } mipi1_stagger_hdr_mode[12:12];

        enum MIPI1_CTRL_MODE_PIXEL_mipi1_mipi_dol_mode_enum {
            DISABLED = 0 { name = "Disabled"; desc = "disabled"; };
            ENABLED = 1 { name = "Enabled"; desc = "enabled"; };
        };

        field {
            name = "mipi1_mipi_dol_mode";
            desc = "MIPI DOL mode enable";
            sw = rw;
            hw = r;
            encode = MIPI1_CTRL_MODE_PIXEL_mipi1_mipi_dol_mode_enum;
            reset = 0x0;
        } mipi1_mipi_dol_mode[4:4];

        enum MIPI1_CTRL_MODE_PIXEL_mipi1_crop_en_enum {
            DISABLED = 0 { name = "Disabled"; desc = "disabled"; };
            ENABLED = 1 { name = "Enabled"; desc = "enabled"; };
        };

        field {
            name = "mipi1_crop_en";
            desc = "Cropping enable";
            sw = rw;
            hw = r;
            encode = MIPI1_CTRL_MODE_PIXEL_mipi1_crop_en_enum;
            reset = 0x0;
        } mipi1_crop_en[0:0];
    } MIPI1_CTRL_MODE_PIXEL @ 0x2230;

    reg {
        name = "MIPI 1 dummy line pixel value register MY_PIX_RE G";
        desc = "MIPI1_DUMMY_PIX_REG is a MIPI 1 dummy line pixel value register. Hi3516A V200 Professional HD IP Camera SoC

Data sheet 9.3.6 MIPI1_DUMMY_PIX_REG (offset 0x2240, printed page 9-422, `hi3516av200--Hi3516AV200-Datasheet.txt` line 62057).";

        field {
            name = "mipi1_dummy_pix_reg";
            desc = "Dummy line pixel value in staggered HDR mode";
            sw = rw;
            hw = r;
            reset = 0x0;
        } mipi1_dummy_pix_reg[15:0];
    } MIPI1_DUMMY_PIX_REG @ 0x2240;

    reg {
        name = "MIPI 1 VC 0 transferred image size IZE0_STATI register S";
        desc = "MIPI1_IMGSIZE0_STATIS is a MIPI 1 VC 0 transferred image size register.

Data sheet 9.3.6 MIPI1_IMGSIZE0_STATIS (offset 0x2250, printed page 9-422, `hi3516av200--Hi3516AV200-Datasheet.txt` line 62078).";

        field {
            name = "imgheight_statis_vc";
            desc = "Height of the previous frame of image transferred by virtual channel 0 in MIPI mode";
            sw = r;
            hw = w;
            reset = 0x0;
        } imgheight_statis_vc[31:16];

        field {
            name = "imgwidth_statis_vc";
            desc = "Width of the previous frame of image transferred by virtual channel 0 in MIPI mode";
            sw = r;
            hw = w;
            reset = 0x0;
        } imgwidth_statis_vc[15:0];
    } MIPI1_IMGSIZE0_STATIS @ 0x2250;

    reg {
        name = "MIPI 1 VC 1 transferred image size IZE1_STATI register S";
        desc = "MIPI1_IMGSIZE1_STATIS is a MIPI 1 VC 1 transferred image size register.

Data sheet 9.3.6 MIPI1_IMGSIZE1_STATIS (offset 0x2254, printed page 9-422, `hi3516av200--Hi3516AV200-Datasheet.txt` line 62101).";

        field {
            name = "mipi1_imgheight_statis_vc1";
            desc = "Height of the previous frame of image transferred by virtual channel 1 in MIPI mode";
            sw = r;
            hw = w;
            reset = 0x0;
        } mipi1_imgheight_statis_vc1[31:16];

        field {
            name = "mipi1_imgwidth_statis_vc1";
            desc = "mipi1_imgwidth_statis_vc1";
            sw = r;
            hw = w;
            reset = 0x0;
        } mipi1_imgwidth_statis_vc1[15:0];
    } MIPI1_IMGSIZE1_STATIS @ 0x2254;

    reg {
        name = "MIPI 1 VC 2 transferred image size IZE2_STATI register S";
        desc = "MIPI1_IMGSIZE2_STATIS is a MIPI 1 VC 2 transferred image size register.

Data sheet 9.3.6 MIPI1_IMGSIZE2_STATIS (offset 0x2258, printed page 9-423, `hi3516av200--Hi3516AV200-Datasheet.txt` line 62140).";

        field {
            name = "imgheight_statis_vc";
            desc = "Height of the previous frame of image transferred by virtual channel 2 in MIPI mode";
            sw = r;
            hw = w;
            reset = 0x0;
        } imgheight_statis_vc[31:16];

        field {
            name = "imgwidth_statis_vc";
            desc = "Width of the previous frame of image transferred by virtual channel 2 in MIPI mode";
            sw = r;
            hw = w;
            reset = 0x0;
        } imgwidth_statis_vc[15:0];
    } MIPI1_IMGSIZE2_STATIS @ 0x2258;

    reg {
        name = "MIPI 1 VC 3 transferred image size IZE3_STATI register S";
        desc = "MIPI1_IMGSIZE3_STATIS is a MIPI 1 VC 3 transferred image size register.

Data sheet 9.3.6 MIPI1_IMGSIZE3_STATIS (offset 0x225C, printed page 9-423, `hi3516av200--Hi3516AV200-Datasheet.txt` line 62163).";

        field {
            name = "imgheight_statis_vc";
            desc = "Height of the previous frame of image transferred by virtual channel 3 in MIPI mode";
            sw = r;
            hw = w;
            reset = 0x0;
        } imgheight_statis_vc[31:16];

        field {
            name = "imgwidth_statis_vc";
            desc = "Width of the previous frame of image transferred by virtual channel 3 in MIPI mode";
            sw = r;
            hw = w;
            reset = 0x0;
        } imgwidth_statis_vc[15:0];
    } MIPI1_IMGSIZE3_STATIS @ 0x225C;

    reg {
        name = "MIPI 1 read data error raw interrupt status L_INT_RAW register";
        desc = "MIPI1_CTRL_INT_RAW is a MIPI 1 read data error raw interrupt status register.

Data sheet 9.3.6 MIPI1_CTRL_INT_RAW (offset 0x22F0, printed page 9-424, `hi3516av200--Hi3516AV200-Datasheet.txt` line 62192).";

        enum MIPI1_CTRL_INT_RAW_mipi1_int_dfifo_rderr_raw_enum {
            NO_RAW_INTERRUPT = 0 { name = "No Raw Interrupt"; desc = "No raw interrupt is generated."; };
            RAW_INTERRUPT_GENERATED = 1 { name = "Raw Interrupt Generated"; desc = "A raw interrupt is generated."; };
        };

        field {
            name = "mipi1_int_dfifo_rderr_raw";
            desc = "MIPI 1 CTRL read data FIFO raw interrupt status";
            sw = rw;
            hw = w;
            onwrite = woclr;
            encode = MIPI1_CTRL_INT_RAW_mipi1_int_dfifo_rderr_raw_enum;
            reset = 0x0;
        } mipi1_int_dfifo_rderr_raw[17:17];

        enum MIPI1_CTRL_INT_RAW_mipi1_int_cfifo_rderr_raw_enum {
            NO_RAW_INTERRUPT = 0 { name = "No Raw Interrupt"; desc = "No raw interrupt is generated."; };
            RAW_INTERRUPT_GENERATED = 1 { name = "Raw Interrupt Generated"; desc = "A raw interrupt is generated."; };
        };

        field {
            name = "mipi1_int_cfifo_rderr_raw";
            desc = "MIPI 1 CTRL read command FIFO raw interrupt status";
            sw = rw;
            hw = w;
            onwrite = woclr;
            encode = MIPI1_CTRL_INT_RAW_mipi1_int_cfifo_rderr_raw_enum;
            reset = 0x0;
        } mipi1_int_cfifo_rderr_raw[16:16];

        enum MIPI1_CTRL_INT_RAW_mipi1_int_dfifo_wrerr_raw_enum {
            NO_RAW_INTERRUPT = 0 { name = "No Raw Interrupt"; desc = "No raw interrupt is generated."; };
            RAW_INTERRUPT_GENERATED = 1 { name = "Raw Interrupt Generated"; desc = "A raw interrupt is generated."; };
        };

        field {
            name = "mipi1_int_dfifo_wrerr_raw";
            desc = "MIPI 1 CTRL write data FIFO raw interrupt status";
            sw = rw;
            hw = w;
            onwrite = woclr;
            encode = MIPI1_CTRL_INT_RAW_mipi1_int_dfifo_wrerr_raw_enum;
            reset = 0x0;
        } mipi1_int_dfifo_wrerr_raw[1:1];

        enum MIPI1_CTRL_INT_RAW_mipi1_int_cfifo_wrerr_raw_enum {
            NO_RAW_INTERRUPT = 0 { name = "No Raw Interrupt"; desc = "No raw interrupt is generated."; };
            RAW_INTERRUPT_GENERATED = 1 { name = "Raw Interrupt Generated"; desc = "A raw interrupt is generated."; };
        };

        field {
            name = "mipi1_int_cfifo_wrerr_raw";
            desc = "MIPI 1 CTRL write command FIFO raw interrupt status";
            sw = rw;
            hw = w;
            onwrite = woclr;
            encode = MIPI1_CTRL_INT_RAW_mipi1_int_cfifo_wrerr_raw_enum;
            reset = 0x0;
        } mipi1_int_cfifo_wrerr_raw[0:0];
    } MIPI1_CTRL_INT_RAW @ 0x22F0;

    reg {
        name = "MIPI 1 read data error interrupt status L_INT register";
        desc = "MIPI1_CTRL_INT is a MIPI 1 read data error interrupt status register. Hi3516A V200 Professional HD IP Camera SoC

Data sheet 9.3.6 MIPI1_CTRL_INT (offset 0x22F4, printed page 9-425, `hi3516av200--Hi3516AV200-Datasheet.txt` line 62248).";

        enum MIPI1_CTRL_INT_mipi1_int_dfifo_rderr_st_enum {
            NO_INTERRUPT_GENERATED = 0 { name = "No Interrupt Generated"; desc = "No interrupt is generated."; };
            INTERRUPT_GENERATED = 1 { name = "Interrupt Generated"; desc = "An interrupt is generated."; };
        };

        field {
            name = "mipi1_int_dfifo_rderr_st";
            desc = "MIPI 1 CTRL read data FIFO interrupt status";
            sw = r;
            hw = w;
            encode = MIPI1_CTRL_INT_mipi1_int_dfifo_rderr_st_enum;
            reset = 0x0;
        } mipi1_int_dfifo_rderr_st[17:17];

        enum MIPI1_CTRL_INT_mipi1_int_cfifo_rderr_st_enum {
            NO_INTERRUPT_GENERATED = 0 { name = "No Interrupt Generated"; desc = "No interrupt is generated."; };
            INTERRUPT_GENERATED = 1 { name = "Interrupt Generated"; desc = "An interrupt is generated."; };
        };

        field {
            name = "mipi1_int_cfifo_rderr_st";
            desc = "MIPI 1 CTRL read command FIFO interrupt status";
            sw = r;
            hw = w;
            encode = MIPI1_CTRL_INT_mipi1_int_cfifo_rderr_st_enum;
            reset = 0x0;
        } mipi1_int_cfifo_rderr_st[16:16];

        enum MIPI1_CTRL_INT_mipi1_int_dfifo_wrerr_st_enum {
            NO_INTERRUPT_GENERATED = 0 { name = "No Interrupt Generated"; desc = "No interrupt is generated."; };
            INTERRUPT_GENERATED = 1 { name = "Interrupt Generated"; desc = "An interrupt is generated."; };
        };

        field {
            name = "mipi1_int_dfifo_wrerr_st";
            desc = "MIPI 1 CTRL write data FIFO interrupt status";
            sw = r;
            hw = w;
            encode = MIPI1_CTRL_INT_mipi1_int_dfifo_wrerr_st_enum;
            reset = 0x0;
        } mipi1_int_dfifo_wrerr_st[1:1];

        enum MIPI1_CTRL_INT_mipi1_int_cfifo_wrerr_st_enum {
            NO_INTERRUPT_GENERATED = 0 { name = "No Interrupt Generated"; desc = "No interrupt is generated."; };
            INTERRUPT_GENERATED = 1 { name = "Interrupt Generated"; desc = "An interrupt is generated."; };
        };

        field {
            name = "mipi1_int_cfifo_wrerr_st";
            desc = "MIPI 1 CTRL write command FIFO interrupt status";
            sw = r;
            hw = w;
            encode = MIPI1_CTRL_INT_mipi1_int_cfifo_wrerr_st_enum;
            reset = 0x0;
        } mipi1_int_cfifo_wrerr_st[0:0];
    } MIPI1_CTRL_INT @ 0x22F4;

    reg {
        name = "MIPI 1 read data error interrupt mask L_INT_MSK register";
        desc = "MIPI1_CTRL_INT_MSK is a MIPI 1 read data error interrupt mask register. Hi3516A V200 Professional HD IP Camera SoC

Data sheet 9.3.6 MIPI1_CTRL_INT_MSK (offset 0x22F8, printed page 9-426, `hi3516av200--Hi3516AV200-Datasheet.txt` line 62305).";

        enum MIPI1_CTRL_INT_MSK_mipi1_int_dfifo_rderr_msk_enum {
            MASKED = 0 { name = "Masked"; desc = "masked"; };
            ENABLED = 1 { name = "Enabled"; desc = "enabled"; };
        };

        field {
            name = "mipi1_int_dfifo_rderr_msk";
            desc = "MIPI 1 CTRL read data FIFO interrupt enable";
            sw = rw;
            hw = r;
            encode = MIPI1_CTRL_INT_MSK_mipi1_int_dfifo_rderr_msk_enum;
            reset = 0x0;
        } mipi1_int_dfifo_rderr_msk[17:17];

        enum MIPI1_CTRL_INT_MSK_mipi1_int_cfifo_rderr_msk_enum {
            MASKED = 0 { name = "Masked"; desc = "masked"; };
            ENABLED = 1 { name = "Enabled"; desc = "enabled"; };
        };

        field {
            name = "mipi1_int_cfifo_rderr_msk";
            desc = "MIPI 1 CTRL read command FIFO interrupt enable";
            sw = rw;
            hw = r;
            encode = MIPI1_CTRL_INT_MSK_mipi1_int_cfifo_rderr_msk_enum;
            reset = 0x0;
        } mipi1_int_cfifo_rderr_msk[16:16];

        enum MIPI1_CTRL_INT_MSK_mipi1_int_dfifo_wrerr_msk_enum {
            MASKED = 0 { name = "Masked"; desc = "masked"; };
            ENABLED = 1 { name = "Enabled"; desc = "enabled"; };
        };

        field {
            name = "mipi1_int_dfifo_wrerr_msk";
            desc = "MIPI 1 CTRL write data FIFO interrupt enable";
            sw = rw;
            hw = r;
            encode = MIPI1_CTRL_INT_MSK_mipi1_int_dfifo_wrerr_msk_enum;
            reset = 0x0;
        } mipi1_int_dfifo_wrerr_msk[1:1];

        enum MIPI1_CTRL_INT_MSK_mipi1_int_cfifo_wrerr_msk_enum {
            MASKED = 0 { name = "Masked"; desc = "masked"; };
            ENABLED = 1 { name = "Enabled"; desc = "enabled"; };
        };

        field {
            name = "mipi1_int_cfifo_wrerr_msk";
            desc = "MIPI 1 CTRL write command FIFO interrupt enable";
            sw = rw;
            hw = r;
            encode = MIPI1_CTRL_INT_MSK_mipi1_int_cfifo_wrerr_msk_enum;
            reset = 0x0;
        } mipi1_int_cfifo_wrerr_msk[0:0];
    } MIPI1_CTRL_INT_MSK @ 0x22F8;

    reg {
        name = "LVDS 1 WDR control register R";
        desc = "LVDS1_WDR is an LVDS 1 WDR control register. Hi3516A V200 Professional HD IP Camera SoC

Data sheet 9.3.6 LVDS1_WDR (offset 0x2300, printed page 9-427, `hi3516av200--Hi3516AV200-Datasheet.txt` line 62361).";

        field {
            name = "lvds1_wdr_id_shift";
            desc = "IMX136 frame ID flag shift. This field indicates the number of bits to be shifted rightwards to move the frame ID to bit 0.";
            sw = rw;
            hw = r;
            reset = 0x0;
        } lvds1_wdr_id_shift[15:12];

        enum LVDS1_WDR_lvds1_wdr_mode_enum {
            WDR_MODE_WITH = 0 { name = "Wdr Mode With"; desc = "WDR mode with the SOF-EOF flag. In this mode, the long exposure frame and short exposure frame have independent synchronization codes."; };
            HISPI_WDR_MODE = 2 { name = "Hispi Wdr Mode"; desc = "HiSPi WDR mode. In this mode, the long and short exposure frames share one SOF-EOF flag, and the first several lines of the short exposure frame are stuffed with 0x04."; };
            SONY_DOL_WDR = 4 { name = "Sony Dol Wdr"; desc = "SONY DOL WDR mode. In this mode, the synchronization code consists of four fields, the SAV-EAV flag is used, and the long exposure frame and short exposure frame have independent synchronization codes."; };
            SONY_DOL_WDR_2 = 5 { name = "Sony Dol Wdr 2"; desc = "SONY DOL WDR mode. In this mode, the synchronization code consists of four fields, the SAV-EAV flag is used, the long and short exposure frames share one group of synchronization codes, and there are blanking regions between the long exposure data and short exposure data."; };
            SONY_DOL_WDR_3 = 6 { name = "Sony Dol Wdr 3"; desc = "SONY DOL WDR mode. In this mode, the synchronization code consists of five fields. The fifth field indicates whether the frame is a long frame or a short frame."; };
            SONY_IMX136_FRAME = 8 { name = "Sony Imx136 Frame"; desc = "SONY IMX136 frame WDR mode. Do not enable WDR_EN in this mode."; };
            SHARP_LONG_SHORT = 9 { name = "Sharp Long Short"; desc = "Sharp long/short exposure 2-line alternating mode. The long frame is before the short frame."; };
            SHARP_LONG_SHORT_2 = 10 { name = "Sharp Long Short 2"; desc = "Sharp long/short exposure 2-line alternating mode. The long frame is after the short frame. Other values: reserved"; };
        };

        field {
            name = "lvds1_wdr_mode";
            desc = "LVDS WDR mode select";
            sw = rw;
            hw = r;
            encode = LVDS1_WDR_lvds1_wdr_mode_enum;
            reset = 0x0;
        } lvds1_wdr_mode[11:8];

        enum LVDS1_WDR_lvds1_wdr_num_enum {
            RESERVED = 0 { name = "Reserved"; desc = "reserved"; };
            V_2_FRAME_WDR = 1 { name = "V 2 Frame Wdr"; desc = "2-frame WDR"; };
            V_3_FRAME_WDR = 2 { name = "V 3 Frame Wdr"; desc = "3-frame WDR"; };
            V_4_FRAME_WDR = 3 { name = "V 4 Frame Wdr"; desc = "4-frame WDR"; };
        };

        field {
            name = "lvds1_wdr_num";
            desc = "WDR mode configuration";
            sw = rw;
            hw = r;
            encode = LVDS1_WDR_lvds1_wdr_num_enum;
            reset = 0x0;
        } lvds1_wdr_num[5:4];

        enum LVDS1_WDR_lvds1_wdr_en_enum {
            LINEAR_MODE = 0 { name = "Linear Mode"; desc = "linear mode"; };
            WDR_MODE = 1 { name = "Wdr Mode"; desc = "WDR mode"; };
        };

        field {
            name = "lvds1_wdr_en";
            desc = "WDR enable";
            sw = rw;
            hw = r;
            encode = LVDS1_WDR_lvds1_wdr_en_enum;
            reset = 0x0;
        } lvds1_wdr_en[0:0];
    } LVDS1_WDR @ 0x2300;

    reg {
        name = "LVDS1 DOLSCD HBLK";
        desc = "[inferred] LVDS1 DOLSCD HBLK. Not in the data sheet. Source: OpenIPC openhisilicon `kernel/mipi_rx/hi3519v101/mipi_reg.h` (GPL-3.0 repository, HiSilicon copyright; local copy sources/openhisilicon), union `U_LVDS_DOLSCD_HBLK`, struct offset 0x2304 (GPL-3.0 repository, HiSilicon copyright; one header for Hi3519 V101 and Hi3516A V200). Reset value and access type unknown (modelled RW, no reset). Confidence: medium (vendor header for this chip family, not hardware verified).";

        field {
            name = "dol_hblank2";
            desc = "[inferred] Dol hblank2. (vendor header `hi3519v101/mipi_reg.h` field `dol_hblank2`; access and reset unknown, modelled RW)";
            sw = rw;
            hw = r;
        } dol_hblank2[27:16];

        field {
            name = "dol_hblank1";
            desc = "[inferred] Dol hblank1. (vendor header `hi3519v101/mipi_reg.h` field `dol_hblank1`; access and reset unknown, modelled RW)";
            sw = rw;
            hw = r;
        } dol_hblank1[11:0];
    } LVDS1_DOLSCD_HBLK @ 0x2304;

    reg {
        name = "LVDS 1 fourth frame cropping register OP_START3";
        desc = "LVDS1_CROP_START3 is an LVDS 1 fourth frame cropping register.

Data sheet 9.3.6 LVDS1_CROP_START3 (offset 0x2308, printed page 9-428, `hi3516av200--Hi3516AV200-Datasheet.txt` line 62440).";

        field {
            name = "lvds_start_y3";
            desc = "[inferred] Lvds start y3. (bits reserved in the data sheet; vendor header `hi3519v101/mipi_reg.h` field `lvds_start_y3`; access and reset unknown, modelled RW)";
            sw = rw;
            hw = r;
        } lvds_start_y3[31:16];

        field {
            name = "lvds1_start_x3_lane";
            desc = "Width of the cropping start point for the fourth frame. The configured value is the start pixel to be cropped divided by the number of channels.";
            sw = rw;
            hw = r;
            reset = 0x0;
        } lvds1_start_x3_lane[15:0];
    } LVDS1_CROP_START3 @ 0x2308;

    reg {
        name = "LVDS 1 picture size register SIZE";
        desc = "LVDS1_IMGSIZE is an LVDS 1 image size register.

Data sheet 9.3.6 LVDS1_IMGSIZE (offset 0x230C, printed page 9-428, `hi3516av200--Hi3516AV200-Datasheet.txt` line 62464).";

        field {
            name = "lvds1_imgheight";
            desc = "Image height minus 1";
            sw = rw;
            hw = r;
            reset = 0x0;
        } lvds1_imgheight[31:16];

        field {
            name = "lvds1_imgwidth_lane";
            desc = "lvds1_imgwidth_lane";
            sw = rw;
            hw = r;
            reset = 0x0;
        } lvds1_imgwidth_lane[15:0];
    } LVDS1_IMGSIZE @ 0x230C;

    reg {
        name = "LVDS 1 control register L";
        desc = "LVDS1_CTRL is an LVDS 1 control register.

Data sheet 9.3.6 LVDS1_CTRL (offset 0x2310, printed page 9-429, `hi3516av200--Hi3516AV200-Datasheet.txt` line 62501).";

        enum LVDS1_CTRL_lvds1_split_mode_enum {
            PER_LANE_MODE = 0 { name = "Per Lane Mode"; desc = "per lane mode"; };
            SPLIT_2_LANE = 3 { name = "Split 2 Lane"; desc = "split-2 lane mode"; };
            SPLIT_4_LANE = 7 { name = "Split 4 Lane"; desc = "split-4 lane mode Other values: reserved"; };
        };

        field {
            name = "lvds1_split_mode";
            desc = "Transfer type for the synchronization code in LVDS or HiSPi mode";
            sw = rw;
            hw = r;
            encode = LVDS1_CTRL_lvds1_split_mode_enum;
            reset = 0x0;
        } lvds1_split_mode[18:16];

        enum LVDS1_CTRL_lvds1_crop_en_enum {
            DISABLED = 0 { name = "Disabled"; desc = "disabled"; };
            ENABLED = 1 { name = "Enabled"; desc = "enabled"; };
        };

        field {
            name = "lvds1_crop_en";
            desc = "Image cropping enable in LVDS or HiSPi mode";
            sw = rw;
            hw = r;
            encode = LVDS1_CTRL_lvds1_crop_en_enum;
            reset = 0x0;
        } lvds1_crop_en[12:12];

        enum LVDS1_CTRL_lvds1_code_big_endian_enum {
            LSB_LOWER_BITS = 0 { name = "Lsb Lower Bits"; desc = "LSB. The lower bits are transmitted first. The serial data sequence of the received synchronization code is bit 0, bit 1, …, bit 11."; };
            MSB_UPPER_BITS = 1 { name = "Msb Upper Bits"; desc = "MSB. The upper bits are transmitted first. The serial data sequence of the received synchronization code is bit 11, bit 10, …, bit 0."; };
        };

        field {
            name = "lvds1_code_big_endian";
            desc = "Serial bit transmission sequence for the synchronization code (sync_code) of the raw data to be transmitted in LVDS or HiSPi mode";
            sw = rw;
            hw = r;
            encode = LVDS1_CTRL_lvds1_code_big_endian_enum;
            reset = 0x1;
        } lvds1_code_big_endian[9:9];

        enum LVDS1_CTRL_lvds1_pix_big_endian_enum {
            LSB_LOWER_BITS = 0 { name = "Lsb Lower Bits"; desc = "LSB. The lower bits are transmitted first. The serial data sequence of the received valid pixels is bit 0, bit 1, …, bit 11."; };
            MSB_UPPER_BITS = 1 { name = "Msb Upper Bits"; desc = "MSB. The upper bits are transmitted first. The serial data sequence of the received valid pixels is bit 11, bit 10, …, bit 0."; };
        };

        field {
            name = "lvds1_pix_big_endian";
            desc = "Serial bit transmission sequence for the valid pixels of the raw data to be transmitted in LVDS or HiSPi mode";
            sw = rw;
            hw = r;
            encode = LVDS1_CTRL_lvds1_pix_big_endian_enum;
            reset = 0x1;
        } lvds1_pix_big_endian[8:8];

        enum LVDS1_CTRL_lvds1_raw_type_enum {
            V_8_BIT_RAW = 1 { name = "V 8 Bit Raw"; desc = "8-bit raw data"; };
            V_10_BIT_RAW = 2 { name = "V 10 Bit Raw"; desc = "10-bit raw data"; };
            V_12_BIT_RAW = 3 { name = "V 12 Bit Raw"; desc = "12-bit raw data"; };
            V_14_BIT_RAW = 4 { name = "V 14 Bit Raw"; desc = "14-bit raw data"; };
            V_16_BIT_RAW = 5 { name = "V 16 Bit Raw"; desc = "16-bit raw data Other values: reserved"; };
        };

        field {
            name = "lvds1_raw_type";
            desc = "Type of the raw data to be transmitted in LVDS or HiSPi mode";
            sw = rw;
            hw = r;
            encode = LVDS1_CTRL_lvds1_raw_type_enum;
            reset = 0x1;
        } lvds1_raw_type[6:4];

        enum LVDS1_CTRL_lvds1_sync_mode_enum {
            SOF_EOF_SOL = 0 { name = "Sof Eof Sol"; desc = "SOF/EOF/SOL/EOL mode. SOF specifies the start of the first line in the active region, EOF specifies the end of the last line in the active region, SOL and EOL specify the start and end of other lines in the active region respectively."; };
            SAV_EAV_MODE = 1 { name = "Sav Eav Mode"; desc = "SAV/EAV mode. SAV (Invalid) and EAV (Invalid) identify invalid data of the blanking region, whereas SAV (Valid) and EAV (Valid) identify pixel data of the active region."; };
        };

        field {
            name = "lvds1_sync_mode";
            desc = "Frame or line synchronization mode in LVDS mode";
            sw = rw;
            hw = r;
            encode = LVDS1_CTRL_lvds1_sync_mode_enum;
            reset = 0x0;
        } lvds1_sync_mode[0:0];
    } LVDS1_CTRL @ 0x2310;

    reg {
        name = "LVDS 1 first frame cropping register 0 OP_START0";
        desc = "LVDS1_CROP_START0 is an LVDS 1 first frame cropping register 0. Hi3516A V200 Professional HD IP Camera SoC

Data sheet 9.3.6 LVDS1_CROP_START0 (offset 0x2314, printed page 9-431, `hi3516av200--Hi3516AV200-Datasheet.txt` line 62596).";

        field {
            name = "lvds_start_y0";
            desc = "[inferred] Lvds start y0. (bits reserved in the data sheet; vendor header `hi3519v101/mipi_reg.h` field `lvds_start_y0`; access and reset unknown, modelled RW)";
            sw = rw;
            hw = r;
        } lvds_start_y0[31:16];

        field {
            name = "lvds1_start_x0_lane";
            desc = "Width of the cropping start point for the first frame. The configured value is the start pixel to be cropped divided by the number of channels.";
            sw = rw;
            hw = r;
            reset = 0x0;
        } lvds1_start_x0_lane[15:0];
    } LVDS1_CROP_START0 @ 0x2314;

    reg {
        name = "LVDS 1 second frame cropping register 1 OP_START1";
        desc = "LVDS1_CROP_START1 is an LVDS 1 second frame cropping register 1.

Data sheet 9.3.6 LVDS1_CROP_START1 (offset 0x2318, printed page 9-431, `hi3516av200--Hi3516AV200-Datasheet.txt` line 62619).";

        field {
            name = "lvds_start_y1";
            desc = "[inferred] Lvds start y1. (bits reserved in the data sheet; vendor header `hi3519v101/mipi_reg.h` field `lvds_start_y1`; access and reset unknown, modelled RW)";
            sw = rw;
            hw = r;
        } lvds_start_y1[31:16];

        field {
            name = "lvds1_start_x1_lane";
            desc = "Width of the cropping start point for the second frame. The configured value is the start pixel to be cropped divided by the number of channels.";
            sw = rw;
            hw = r;
            reset = 0x0;
        } lvds1_start_x1_lane[15:0];
    } LVDS1_CROP_START1 @ 0x2318;

    reg {
        name = "LVDS 1 third frame cropping register 2 OP_START2";
        desc = "LVDS1_CROP_START2 is an LVDS 1 third frame cropping register 2.

Data sheet 9.3.6 LVDS1_CROP_START2 (offset 0x231C, printed page 9-431, `hi3516av200--Hi3516AV200-Datasheet.txt` line 62642).";

        field {
            name = "lvds_start_y2";
            desc = "[inferred] Lvds start y2. (bits reserved in the data sheet; vendor header `hi3519v101/mipi_reg.h` field `lvds_start_y2`; access and reset unknown, modelled RW)";
            sw = rw;
            hw = r;
        } lvds_start_y2[31:16];

        field {
            name = "lvds1_start_x2_lane";
            desc = "lvds1_start_x2_lane";
            sw = rw;
            hw = r;
            reset = 0x0;
        } lvds1_start_x2_lane[15:0];
    } LVDS1_CROP_START2 @ 0x231C;

    reg {
        name = "Lane 0 SOF synchronization code NE0_SOF_0 configuration register in LVDS or HiSPi 1 mode";
        desc = "LVDS1_LANE0_SOF_01 is a lane 0 SOF synchronization code configuration register in LVDS or HiSPi mode.

Data sheet 9.3.6 LVDS1_LANE0_SOF_01 (offset 0x2320, printed page 9-432, `hi3516av200--Hi3516AV200-Datasheet.txt` line 62681).";

        field {
            name = "lvds1_lane0_sof_1";
            desc = "Lane 0 SOF synchronization code of frame 1 in LVDS or HiSPi mode This field is configurable only in WDR mode, and the configuration is invalid in linear mode.";
            sw = rw;
            hw = r;
            reset = 0x0;
        } lvds1_lane0_sof_1[31:16];

        field {
            name = "lvds1_lane0_sof_0";
            desc = "Lane 0 SOF synchronization code of frame 0 in LVDS or HiSPi mode In WDR mode, the value is the SOF of frame 0. In linear mode, the value is the SOF.";
            sw = rw;
            hw = r;
            reset = 0x0;
        } lvds1_lane0_sof_0[15:0];
    } LVDS1_LANE0_SOF_01 @ 0x2320;

    reg {
        name = "Lane 0 SOF synchronization code NE0_SOF_2 configuration register in LVDS or HiSPi 3 mode";
        desc = "LVDS1_LANE0_SOF_23 is a lane 0 SOF synchronization code configuration register in LVDS or HiSPi mode. Hi3516A V200 Professional HD IP Camera SoC

Data sheet 9.3.6 LVDS1_LANE0_SOF_23 (offset 0x2324, printed page 9-433, `hi3516av200--Hi3516AV200-Datasheet.txt` line 62719).";

        field {
            name = "lvds1_lane0_sof_3";
            desc = "Lane 0 SOF synchronization code of frame 3 in LVDS or HiSPi mode This field is configurable only in WDR mode, and the configuration is invalid in linear mode.";
            sw = rw;
            hw = r;
            reset = 0x0;
        } lvds1_lane0_sof_3[31:16];

        field {
            name = "lvds1_lane0_sof_2";
            desc = "Lane 0 SOF synchronization code of frame 2 in LVDS or HiSPi mode This field is configurable only in WDR mode, and the configuration is invalid in linear mode.";
            sw = rw;
            hw = r;
            reset = 0x0;
        } lvds1_lane0_sof_2[15:0];
    } LVDS1_LANE0_SOF_23 @ 0x2324;

    reg {
        name = "Lane 0 EOF synchronization code NE0_EOF_0 configuration register in LVDS or HiSPi 1 mode";
        desc = "LVDS1_LANE0_EOF_01 is a lane 0 EOF synchronization code configuration register in LVDS or HiSPi mode.

Data sheet 9.3.6 LVDS1_LANE0_EOF_01 (offset 0x2328, printed page 9-433, `hi3516av200--Hi3516AV200-Datasheet.txt` line 62747).";

        field {
            name = "lvds1_lane0_eof_1";
            desc = "Lane 0 EOF synchronization code of frame 1 in LVDS or HiSPi mode This field is configurable only in WDR mode, and the configuration is invalid in linear mode.";
            sw = rw;
            hw = r;
            reset = 0x0;
        } lvds1_lane0_eof_1[31:16];

        field {
            name = "lvds1_lane0_eof_0";
            desc = "Lane 0 EOF synchronization code of frame 0 in LVDS or HiSPi mode In WDR mode, the value is the EOF of frame 0. In linear mode, the value is the EOF.";
            sw = rw;
            hw = r;
            reset = 0x0;
        } lvds1_lane0_eof_0[15:0];
    } LVDS1_LANE0_EOF_01 @ 0x2328;

    reg {
        name = "Lane 0 EOF synchronization code NE0_EOF_2 configuration register in LVDS or HiSPi 3 mode";
        desc = "LVDS1_LANE0_EOF_23 is a lane 0 EOF synchronization code configuration register in LVDS or HiSPi mode. Hi3516A V200 Professional HD IP Camera SoC

Data sheet 9.3.6 LVDS1_LANE0_EOF_23 (offset 0x232C, printed page 9-434, `hi3516av200--Hi3516AV200-Datasheet.txt` line 62784).";

        field {
            name = "lvds1_lane0_eof_3";
            desc = "Lane 0 EOF synchronization code of frame 3 in LVDS or HiSPi mode This field is configurable only in WDR mode, and the configuration is invalid in linear mode.";
            sw = rw;
            hw = r;
            reset = 0x0;
        } lvds1_lane0_eof_3[31:16];

        field {
            name = "lvds1_lane0_eof_2";
            desc = "Lane 0 EOF synchronization code of frame 2 in LVDS or HiSPi mode This field is configurable only in WDR mode, and the configuration is invalid in linear mode.";
            sw = rw;
            hw = r;
            reset = 0x0;
        } lvds1_lane0_eof_2[15:0];
    } LVDS1_LANE0_EOF_23 @ 0x232C;

    reg {
        name = "Lane 0 SOL synchronization code NE0_SOL_0 configuration register in LVDS or HiSPi 1 mode";
        desc = "LVDS1_LANE0_SOL_01 is a lane 0 SOL synchronization code configuration register in LVDS or HiSPi mode.

Data sheet 9.3.6 LVDS1_LANE0_SOL_01 (offset 0x2330, printed page 9-434, `hi3516av200--Hi3516AV200-Datasheet.txt` line 62812).";

        field {
            name = "lvds1_lane0_sol_1";
            desc = "Lane 0 SOL synchronization code of frame 1 in LVDS or HiSPi mode This field is configurable only in WDR mode, and the configuration is invalid in linear mode.";
            sw = rw;
            hw = r;
            reset = 0x0;
        } lvds1_lane0_sol_1[31:16];

        field {
            name = "lvds1_lane0_sol_0";
            desc = "Lane 0 SOL synchronization code of frame 0 in LVDS or HiSPi mode In WDR mode, the value is the SOL of frame 0. In linear mode, the value is the SOL.";
            sw = rw;
            hw = r;
            reset = 0x0;
        } lvds1_lane0_sol_0[15:0];
    } LVDS1_LANE0_SOL_01 @ 0x2330;

    reg {
        name = "Lane 0 SOL synchronization code NE0_SOL_2 configuration register in LVDS or HiSPi 3 mode";
        desc = "LVDS1_LANE0_SOL_23 is a lane 0 SOL synchronization code configuration register in LVDS or HiSPi mode. Hi3516A V200 Professional HD IP Camera SoC

Data sheet 9.3.6 LVDS1_LANE0_SOL_23 (offset 0x2334, printed page 9-435, `hi3516av200--Hi3516AV200-Datasheet.txt` line 62849).";

        field {
            name = "lvds1_lane0_sol_3";
            desc = "Lane 0 SOL synchronization code of frame 3 in LVDS or HiSPi mode This field is configurable only in WDR mode, and the configuration is invalid in linear mode.";
            sw = rw;
            hw = r;
            reset = 0x0;
        } lvds1_lane0_sol_3[31:16];

        field {
            name = "lvds1_lane0_sol_2";
            desc = "Lane 0 SOL synchronization code of frame 2 in LVDS or HiSPi mode This field is configurable only in WDR mode, and the configuration is invalid in linear mode.";
            sw = rw;
            hw = r;
            reset = 0x0;
        } lvds1_lane0_sol_2[15:0];
    } LVDS1_LANE0_SOL_23 @ 0x2334;

    reg {
        name = "Lane 0 EOL synchronization code NE0_EOL_0 configuration register in LVDS or HiSPi 1 mode";
        desc = "LVDS1_LANE0_EOL_01 is a lane 0 EOL synchronization code configuration register in LVDS or HiSPi mode.

Data sheet 9.3.6 LVDS1_LANE0_EOL_01 (offset 0x2338, printed page 9-435, `hi3516av200--Hi3516AV200-Datasheet.txt` line 62877).";

        field {
            name = "lvds1_lane0_eol_1";
            desc = "Lane 0 EOL synchronization code of frame 1 in LVDS or HiSPi mode This field is configurable only in WDR mode, and the configuration is invalid in linear mode.";
            sw = rw;
            hw = r;
            reset = 0x0;
        } lvds1_lane0_eol_1[31:16];

        field {
            name = "lvds1_lane0_eol_0";
            desc = "Lane 0 EOL synchronization code of frame 0 in LVDS or HiSPi mode In WDR mode, the value is the EOL of frame 0. In linear mode, the value is the EOL.";
            sw = rw;
            hw = r;
            reset = 0x0;
        } lvds1_lane0_eol_0[15:0];
    } LVDS1_LANE0_EOL_01 @ 0x2338;

    reg {
        name = "Lane 0 EOL synchronization code NE0_EOL_2 configuration register in LVDS or HiSPi 3 mode";
        desc = "LVDS1_LANE0_EOL_23 is a lane 0 EOL synchronization code configuration register in LVDS or HiSPi mode. Hi3516A V200 Professional HD IP Camera SoC

Data sheet 9.3.6 LVDS1_LANE0_EOL_23 (offset 0x233C, printed page 9-436, `hi3516av200--Hi3516AV200-Datasheet.txt` line 62914).";

        field {
            name = "lvds1_lane0_eol_3";
            desc = "Lane 0 EOL synchronization code of frame 3 in LVDS or HiSPi mode This field is configurable only in WDR mode, and the configuration is invalid in linear mode.";
            sw = rw;
            hw = r;
            reset = 0x0;
        } lvds1_lane0_eol_3[31:16];

        field {
            name = "lvds1_lane0_eol_2";
            desc = "Lane 0 EOL synchronization code of frame 2 in LVDS or HiSPi mode This field is configurable only in WDR mode, and the configuration is invalid in linear mode.";
            sw = rw;
            hw = r;
            reset = 0x0;
        } lvds1_lane0_eol_2[15:0];
    } LVDS1_LANE0_EOL_23 @ 0x233C;

    reg {
        name = "Lane 1 SOF synchronization code NE1_SOF_0 configuration register in LVDS or HiSPi 1 mode";
        desc = "LVDS1_LANE1_SOF_01 is a lane 1 SOF synchronization code configuration register in LVDS or HiSPi mode.

Data sheet 9.3.6 LVDS1_LANE1_SOF_01 (offset 0x2340, printed page 9-436, `hi3516av200--Hi3516AV200-Datasheet.txt` line 62942).";

        field {
            name = "lvds1_lane1_sof_1";
            desc = "Lane 1 SOF synchronization code of frame 1 in LVDS or HiSPi mode This field is configurable only in WDR mode, and the configuration is invalid in linear mode.";
            sw = rw;
            hw = r;
            reset = 0x0;
        } lvds1_lane1_sof_1[31:16];

        field {
            name = "lvds1_lane1_sof_0";
            desc = "Lane 1 SOF synchronization code of frame 0 in LVDS or HiSPi mode In WDR mode, the value is the SOF of frame 0. In linear mode, the value is the SOF.";
            sw = rw;
            hw = r;
            reset = 0x0;
        } lvds1_lane1_sof_0[15:0];
    } LVDS1_LANE1_SOF_01 @ 0x2340;

    reg {
        name = "Lane 1 SOF synchronization code NE1_SOF_2 configuration register in LVDS or HiSPi 3 mode";
        desc = "LVDS1_LANE1_SOF_23 is a lane 1 SOF synchronization code configuration register in LVDS or HiSPi mode. Hi3516A V200 Professional HD IP Camera SoC

Data sheet 9.3.6 LVDS1_LANE1_SOF_23 (offset 0x2344, printed page 9-437, `hi3516av200--Hi3516AV200-Datasheet.txt` line 62979).";

        field {
            name = "lvds1_lane1_sof_3";
            desc = "Lane 1 SOF synchronization code of frame 3 in LVDS or HiSPi mode This field is configurable only in WDR mode, and the configuration is invalid in linear mode.";
            sw = rw;
            hw = r;
            reset = 0x0;
        } lvds1_lane1_sof_3[31:16];

        field {
            name = "lvds1_lane1_sof_2";
            desc = "Lane 1 SOF synchronization code of frame 2 in LVDS or HiSPi mode This field is configurable only in WDR mode, and the configuration is invalid in linear mode.";
            sw = rw;
            hw = r;
            reset = 0x0;
        } lvds1_lane1_sof_2[15:0];
    } LVDS1_LANE1_SOF_23 @ 0x2344;

    reg {
        name = "Lane 1 EOF synchronization code NE1_EOF_0 configuration register in LVDS or HiSPi 1 mode";
        desc = "LVDS1_LANE1_EOF_01 is a lane 1 EOF synchronization code configuration register in LVDS or HiSPi mode.

Data sheet 9.3.6 LVDS1_LANE1_EOF_01 (offset 0x2348, printed page 9-437, `hi3516av200--Hi3516AV200-Datasheet.txt` line 63007).";

        field {
            name = "lvds1_lane1_eof_1";
            desc = "Lane 1 EOF synchronization code of frame 1 in LVDS or HiSPi mode This field is configurable only in WDR mode, and the configuration is invalid in linear mode.";
            sw = rw;
            hw = r;
            reset = 0x0;
        } lvds1_lane1_eof_1[31:16];

        field {
            name = "lvds1_lane1_eof_0";
            desc = "Lane 1 EOF synchronization code of frame 0 in LVDS or HiSPi mode In WDR mode, the value is the EOF of frame 0. In linear mode, the value is the EOF.";
            sw = rw;
            hw = r;
            reset = 0x0;
        } lvds1_lane1_eof_0[15:0];
    } LVDS1_LANE1_EOF_01 @ 0x2348;

    reg {
        name = "Lane 1 EOF synchronization code NE1_EOF_2 configuration register in LVDS or HiSPi 3 mode";
        desc = "LVDS1_LANE1_EOF_23 is a lane 1 EOF synchronization code configuration register in LVDS or HiSPi mode. Hi3516A V200 Professional HD IP Camera SoC

Data sheet 9.3.6 LVDS1_LANE1_EOF_23 (offset 0x234C, printed page 9-438, `hi3516av200--Hi3516AV200-Datasheet.txt` line 63044).";

        field {
            name = "lvds1_lane1_eof_3";
            desc = "Lane 1 EOF synchronization code of frame 3 in LVDS or HiSPi mode This field is configurable only in WDR mode, and the configuration is invalid in linear mode.";
            sw = rw;
            hw = r;
            reset = 0x0;
        } lvds1_lane1_eof_3[31:16];

        field {
            name = "lvds1_lane1_eof_2";
            desc = "Lane 1 EOF synchronization code of frame 2 in LVDS or HiSPi mode This field is configurable only in WDR mode, and the configuration is invalid in linear mode.";
            sw = rw;
            hw = r;
            reset = 0x0;
        } lvds1_lane1_eof_2[15:0];
    } LVDS1_LANE1_EOF_23 @ 0x234C;

    reg {
        name = "Lane 1 SOL synchronization code NE1_SOL_0 configuration register in LVDS or HiSPi 1 mode";
        desc = "LVDS1_LANE1_SOL_01 is a lane 1 SOL synchronization code configuration register in LVDS or HiSPi mode.

Data sheet 9.3.6 LVDS1_LANE1_SOL_01 (offset 0x2350, printed page 9-438, `hi3516av200--Hi3516AV200-Datasheet.txt` line 63072).";

        field {
            name = "lvds1_lane1_sol_1";
            desc = "Lane 1 SOL synchronization code of frame 1 in LVDS or HiSPi mode This field is configurable only in WDR mode, and the configuration is invalid in linear mode.";
            sw = rw;
            hw = r;
            reset = 0x0;
        } lvds1_lane1_sol_1[31:16];

        field {
            name = "lvds1_lane1_sol_0";
            desc = "Lane 1 SOL synchronization code of frame 0 in LVDS or HiSPi mode In WDR mode, the value is the SOL of frame 0. In linear mode, the value is the SOL.";
            sw = rw;
            hw = r;
            reset = 0x0;
        } lvds1_lane1_sol_0[15:0];
    } LVDS1_LANE1_SOL_01 @ 0x2350;

    reg {
        name = "Lane 1 SOL synchronization code NE1_SOL_2 configuration register in LVDS or HiSPi 3 mode";
        desc = "LVDS1_LANE1_SOL_23 is a lane 1 SOL synchronization code configuration register in LVDS or HiSPi mode. Hi3516A V200 Professional HD IP Camera SoC

Data sheet 9.3.6 LVDS1_LANE1_SOL_23 (offset 0x2354, printed page 9-439, `hi3516av200--Hi3516AV200-Datasheet.txt` line 63109).";

        field {
            name = "lvds1_lane1_sol_3";
            desc = "Lane 1 SOL synchronization code of frame 3 in LVDS or HiSPi mode This field is configurable only in WDR mode, and the configuration is invalid in linear mode.";
            sw = rw;
            hw = r;
            reset = 0x0;
        } lvds1_lane1_sol_3[31:16];

        field {
            name = "lvds1_lane1_sol_2";
            desc = "Lane 1 SOL synchronization code of frame 2 in LVDS or HiSPi mode This field is configurable only in WDR mode, and the configuration is invalid in linear mode.";
            sw = rw;
            hw = r;
            reset = 0x0;
        } lvds1_lane1_sol_2[15:0];
    } LVDS1_LANE1_SOL_23 @ 0x2354;

    reg {
        name = "Lane 1 EOL synchronization code NE1_EOL_0 configuration register in LVDS or HiSPi 1 mode";
        desc = "LVDS1_LANE1_EOL_01 is a lane 1 EOL synchronization code configuration register in LVDS or HiSPi mode.

Data sheet 9.3.6 LVDS1_LANE1_EOL_01 (offset 0x2358, printed page 9-439, `hi3516av200--Hi3516AV200-Datasheet.txt` line 63137).";

        field {
            name = "lvds1_lane1_eol_1";
            desc = "Lane 1 EOL synchronization code of frame 1 in LVDS or HiSPi mode This field is configurable only in WDR mode, and the configuration is invalid in linear mode.";
            sw = rw;
            hw = r;
            reset = 0x0;
        } lvds1_lane1_eol_1[31:16];

        field {
            name = "lvds1_lane1_eol_0";
            desc = "Lane 1 EOL synchronization code of frame 0 in LVDS or HiSPi mode In WDR mode, the value is the EOL of frame 0. In linear mode, the value is the EOL.";
            sw = rw;
            hw = r;
            reset = 0x0;
        } lvds1_lane1_eol_0[15:0];
    } LVDS1_LANE1_EOL_01 @ 0x2358;

    reg {
        name = "Lane 1 EOL synchronization code NE1_EOL_2 configuration register in LVDS or HiSPi 3 mode";
        desc = "LVDS1_LANE1_EOL_23 is a lane 1 EOL synchronization code configuration register in LVDS or HiSPi mode. Hi3516A V200 Professional HD IP Camera SoC

Data sheet 9.3.6 LVDS1_LANE1_EOL_23 (offset 0x235C, printed page 9-440, `hi3516av200--Hi3516AV200-Datasheet.txt` line 63174).";

        field {
            name = "lvds1_lane1_eol_3";
            desc = "Lane 1 EOL synchronization code of frame 3 in LVDS or HiSPi mode This field is configurable only in WDR mode, and the configuration is invalid in linear mode.";
            sw = rw;
            hw = r;
            reset = 0x0;
        } lvds1_lane1_eol_3[31:16];

        field {
            name = "lvds1_lane1_eol_2";
            desc = "Lane 1 EOL synchronization code of frame 2 in LVDS or HiSPi mode This field is configurable only in WDR mode, and the configuration is invalid in linear mode.";
            sw = rw;
            hw = r;
            reset = 0x0;
        } lvds1_lane1_eol_2[15:0];
    } LVDS1_LANE1_EOL_23 @ 0x235C;

    reg {
        name = "Lane 2 SOF synchronization code NE2_SOF_0 configuration register in LVDS or HiSPi 1 mode";
        desc = "LVDS1_LANE2_SOF_01 is a lane 2 SOF synchronization code configuration register in LVDS or HiSPi mode.

Data sheet 9.3.6 LVDS1_LANE2_SOF_01 (offset 0x2360, printed page 9-440, `hi3516av200--Hi3516AV200-Datasheet.txt` line 63202).";

        field {
            name = "lvds1_lane2_sof_1";
            desc = "Lane 2 SOF synchronization code of frame 1 in LVDS or HiSPi mode This field is configurable only in WDR mode, and the configuration is invalid in linear mode.";
            sw = rw;
            hw = r;
            reset = 0x0;
        } lvds1_lane2_sof_1[31:16];

        field {
            name = "lvds1_lane2_sof_0";
            desc = "Lane 2 SOF synchronization code of frame 0 in LVDS or HiSPi mode In WDR mode, the value is the SOF of frame 0. In linear mode, the value is the SOF.";
            sw = rw;
            hw = r;
            reset = 0x0;
        } lvds1_lane2_sof_0[15:0];
    } LVDS1_LANE2_SOF_01 @ 0x2360;

    reg {
        name = "Lane 2 SOF synchronization code NE2_SOF_2 configuration register in LVDS or HiSPi 3 mode";
        desc = "LVDS1_LANE2_SOF_23 is a lane 2 SOF synchronization code configuration register in LVDS or HiSPi mode. Hi3516A V200 Professional HD IP Camera SoC

Data sheet 9.3.6 LVDS1_LANE2_SOF_23 (offset 0x2364, printed page 9-441, `hi3516av200--Hi3516AV200-Datasheet.txt` line 63239).";

        field {
            name = "lvds1_lane2_sof_3";
            desc = "Lane 2 SOF synchronization code of frame 3 in LVDS or HiSPi mode This field is configurable only in WDR mode, and the configuration is invalid in linear mode.";
            sw = rw;
            hw = r;
            reset = 0x0;
        } lvds1_lane2_sof_3[31:16];

        field {
            name = "lvds1_lane2_sof_2";
            desc = "Lane 2 SOF synchronization code of frame 2 in LVDS or HiSPi mode This field is configurable only in WDR mode, and the configuration is invalid in linear mode.";
            sw = rw;
            hw = r;
            reset = 0x0;
        } lvds1_lane2_sof_2[15:0];
    } LVDS1_LANE2_SOF_23 @ 0x2364;

    reg {
        name = "Lane 2 EOF synchronization code NE2_EOF_0 configuration register in LVDS or HiSPi 1 mode";
        desc = "LVDS1_LANE2_EOF_01 is a lane 2 EOF synchronization code configuration register in LVDS or HiSPi mode.

Data sheet 9.3.6 LVDS1_LANE2_EOF_01 (offset 0x2368, printed page 9-441, `hi3516av200--Hi3516AV200-Datasheet.txt` line 63267).";

        field {
            name = "lvds1_lane2_eof_1";
            desc = "Lane 2 EOF synchronization code of frame 1 in LVDS or HiSPi mode This field is configurable only in WDR mode, and the configuration is invalid in linear mode.";
            sw = rw;
            hw = r;
            reset = 0x0;
        } lvds1_lane2_eof_1[31:16];

        field {
            name = "lvds1_lane2_eof_0";
            desc = "Lane 2 EOF synchronization code of frame 0 in LVDS or HiSPi mode In WDR mode, the value is the EOF of frame 0. In linear mode, the value is the EOF.";
            sw = rw;
            hw = r;
            reset = 0x0;
        } lvds1_lane2_eof_0[15:0];
    } LVDS1_LANE2_EOF_01 @ 0x2368;

    reg {
        name = "Lane 2 EOF synchronization code NE2_EOF_2 configuration register in LVDS or HiSPi 3 mode";
        desc = "LVDS1_LANE2_EOF_23 is a lane 2 EOF synchronization code configuration register in LVDS or HiSPi mode. Hi3516A V200 Professional HD IP Camera SoC

Data sheet 9.3.6 LVDS1_LANE2_EOF_23 (offset 0x236C, printed page 9-442, `hi3516av200--Hi3516AV200-Datasheet.txt` line 63304).";

        field {
            name = "lvds1_lane2_eof_3";
            desc = "Lane 2 EOF synchronization code of frame 3 in LVDS or HiSPi mode This field is configurable only in WDR mode, and the configuration is invalid in linear mode.";
            sw = rw;
            hw = r;
            reset = 0x0;
        } lvds1_lane2_eof_3[31:16];

        field {
            name = "lvds1_lane2_eof_2";
            desc = "Lane 2 EOF synchronization code of frame 2 in LVDS or HiSPi mode This field is configurable only in WDR mode, and the configuration is invalid in linear mode.";
            sw = rw;
            hw = r;
            reset = 0x0;
        } lvds1_lane2_eof_2[15:0];
    } LVDS1_LANE2_EOF_23 @ 0x236C;

    reg {
        name = "Lane 2 SOL synchronization code NE2_SOL_0 configuration register in LVDS or HiSPi 1 mode";
        desc = "LVDS1_LANE2_SOL_01 is a lane 2 SOL synchronization code configuration register in LVDS or HiSPi mode.

Data sheet 9.3.6 LVDS1_LANE2_SOL_01 (offset 0x2370, printed page 9-442, `hi3516av200--Hi3516AV200-Datasheet.txt` line 63332).";

        field {
            name = "lvds1_lane2_sol_1";
            desc = "Lane 2 SOL synchronization code of frame 1 in LVDS or HiSPi mode This field is configurable only in WDR mode, and the configuration is invalid in linear mode.";
            sw = rw;
            hw = r;
            reset = 0x0;
        } lvds1_lane2_sol_1[31:16];

        field {
            name = "lvds1_lane2_sol_0";
            desc = "Lane 2 SOL synchronization code of frame 0 in LVDS or HiSPi mode In WDR mode, the value is the SOL of frame 0. In linear mode, the value is the SOL.";
            sw = rw;
            hw = r;
            reset = 0x0;
        } lvds1_lane2_sol_0[15:0];
    } LVDS1_LANE2_SOL_01 @ 0x2370;

    reg {
        name = "Lane 2 SOL synchronization code NE2_SOL_2 configuration register in LVDS or HiSPi 3 mode";
        desc = "LVDS1_LANE2_SOL_23 is a lane 2 SOL synchronization code configuration register in LVDS or HiSPi mode. Hi3516A V200 Professional HD IP Camera SoC

Data sheet 9.3.6 LVDS1_LANE2_SOL_23 (offset 0x2374, printed page 9-443, `hi3516av200--Hi3516AV200-Datasheet.txt` line 63369).";

        field {
            name = "lvds1_lane2_sol_3";
            desc = "Lane 2 SOL synchronization code of frame 3 in LVDS or HiSPi mode This field is configurable only in WDR mode, and the configuration is invalid in linear mode.";
            sw = rw;
            hw = r;
            reset = 0x0;
        } lvds1_lane2_sol_3[31:16];

        field {
            name = "lvds1_lane2_sol_2";
            desc = "Lane 2 SOL synchronization code of frame 2 in LVDS or HiSPi mode This field is configurable only in WDR mode, and the configuration is invalid in linear mode.";
            sw = rw;
            hw = r;
            reset = 0x0;
        } lvds1_lane2_sol_2[15:0];
    } LVDS1_LANE2_SOL_23 @ 0x2374;

    reg {
        name = "Lane 2 EOL synchronization code NE2_EOL_0 configuration register in LVDS or HiSPi 1 mode";
        desc = "LVDS1_LANE2_EOL_01 is a lane 2 EOL synchronization code configuration register in LVDS or HiSPi mode.

Data sheet 9.3.6 LVDS1_LANE2_EOL_01 (offset 0x2378, printed page 9-443, `hi3516av200--Hi3516AV200-Datasheet.txt` line 63397).";

        field {
            name = "lvds1_lane2_eol_1";
            desc = "Lane 2 EOL synchronization code of frame 1 in LVDS or HiSPi mode This field is configurable only in WDR mode, and the configuration is invalid in linear mode.";
            sw = rw;
            hw = r;
            reset = 0x0;
        } lvds1_lane2_eol_1[31:16];

        field {
            name = "lvds1_lane2_eol_0";
            desc = "Lane 2 EOL synchronization code of frame 0 in LVDS or HiSPi mode In WDR mode, the value is the EOL of frame 0. In linear mode, the value is the EOL.";
            sw = rw;
            hw = r;
            reset = 0x0;
        } lvds1_lane2_eol_0[15:0];
    } LVDS1_LANE2_EOL_01 @ 0x2378;

    reg {
        name = "Lane 2 EOL synchronization code NE2_EOL_2 configuration register in LVDS or HiSPi 3 mode";
        desc = "LVDS1_LANE2_EOL_23 is a lane 2 EOL synchronization code configuration register in LVDS or HiSPi mode. Hi3516A V200 Professional HD IP Camera SoC

Data sheet 9.3.6 LVDS1_LANE2_EOL_23 (offset 0x237C, printed page 9-444, `hi3516av200--Hi3516AV200-Datasheet.txt` line 63434).";

        field {
            name = "lvds1_lane2_eol_3";
            desc = "Lane 2 EOL synchronization code of frame 3 in LVDS or HiSPi mode This field is configurable only in WDR mode, and the configuration is invalid in linear mode.";
            sw = rw;
            hw = r;
            reset = 0x0;
        } lvds1_lane2_eol_3[31:16];

        field {
            name = "lvds1_lane2_eol_2";
            desc = "Lane 2 EOL synchronization code of frame 2 in LVDS or HiSPi mode This field is configurable only in WDR mode, and the configuration is invalid in linear mode.";
            sw = rw;
            hw = r;
            reset = 0x0;
        } lvds1_lane2_eol_2[15:0];
    } LVDS1_LANE2_EOL_23 @ 0x237C;

    reg {
        name = "Lane 3 SOF synchronization code NE3_SOF_0 configuration register in LVDS or HiSPi 1 mode";
        desc = "LVDS1_LANE3_SOF_01 is a lane 3 SOF synchronization code configuration register in LVDS or HiSPi mode.

Data sheet 9.3.6 LVDS1_LANE3_SOF_01 (offset 0x2380, printed page 9-444, `hi3516av200--Hi3516AV200-Datasheet.txt` line 63462).";

        field {
            name = "lvds1_lane3_sof_1";
            desc = "Lane 3 SOF synchronization code of frame 1 in LVDS or HiSPi mode This field is configurable only in WDR mode, and the configuration is invalid in linear mode.";
            sw = rw;
            hw = r;
            reset = 0x0;
        } lvds1_lane3_sof_1[31:16];

        field {
            name = "lvds1_lane3_sof_0";
            desc = "Lane 3 SOF synchronization code of frame 0 in LVDS or HiSPi mode In WDR mode, the value is the SOF of frame 0. In linear mode, the value is the SOF.";
            sw = rw;
            hw = r;
            reset = 0x0;
        } lvds1_lane3_sof_0[15:0];
    } LVDS1_LANE3_SOF_01 @ 0x2380;

    reg {
        name = "Lane 3 SOF synchronization code NE3_SOF_2 configuration register in LVDS or HiSPi 3 mode";
        desc = "LVDS1_LANE3_SOF_23 is a lane 3 SOF synchronization code configuration register in LVDS or HiSPi mode. Hi3516A V200 Professional HD IP Camera SoC

Data sheet 9.3.6 LVDS1_LANE3_SOF_23 (offset 0x2384, printed page 9-445, `hi3516av200--Hi3516AV200-Datasheet.txt` line 63499).";

        field {
            name = "lvds1_lane3_sof_3";
            desc = "Lane 3 SOF synchronization code of frame 3 in LVDS or HiSPi mode This field is configurable only in WDR mode, and the configuration is invalid in linear mode.";
            sw = rw;
            hw = r;
            reset = 0x0;
        } lvds1_lane3_sof_3[31:16];

        field {
            name = "lvds1_lane3_sof_2";
            desc = "Lane 3 SOF synchronization code of frame 2 in LVDS or HiSPi mode This field is configurable only in WDR mode, and the configuration is invalid in linear mode.";
            sw = rw;
            hw = r;
            reset = 0x0;
        } lvds1_lane3_sof_2[15:0];
    } LVDS1_LANE3_SOF_23 @ 0x2384;

    reg {
        name = "Lane 3 EOF synchronization code NE3_EOF_0 configuration register in LVDS or HiSPi 1 mode";
        desc = "LVDS1_LANE3_EOF_01 is a lane 3 EOF synchronization code configuration register in LVDS or HiSPi mode.

Data sheet 9.3.6 LVDS1_LANE3_EOF_01 (offset 0x2388, printed page 9-445, `hi3516av200--Hi3516AV200-Datasheet.txt` line 63527).";

        field {
            name = "lvds1_lane3_eof_1";
            desc = "Lane 3 EOF synchronization code of frame 1 in LVDS or HiSPi mode This field is configurable only in WDR mode, and the configuration is invalid in linear mode.";
            sw = rw;
            hw = r;
            reset = 0x0;
        } lvds1_lane3_eof_1[31:16];

        field {
            name = "lvds1_lane3_eof_0";
            desc = "Lane 3 EOF synchronization code of frame 0 in LVDS or HiSPi mode In WDR mode, the value is the EOF of frame 0. In linear mode, the value is the EOF.";
            sw = rw;
            hw = r;
            reset = 0x0;
        } lvds1_lane3_eof_0[15:0];
    } LVDS1_LANE3_EOF_01 @ 0x2388;

    reg {
        name = "Lane 3 EOF synchronization code NE3_EOF_2 configuration register in LVDS or HiSPi 3 mode";
        desc = "LVDS1_LANE3_EOF_23 is a lane 3 EOF synchronization code configuration register in LVDS or HiSPi mode. Hi3516A V200 Professional HD IP Camera SoC

Data sheet 9.3.6 LVDS1_LANE3_EOF_23 (offset 0x238C, printed page 9-446, `hi3516av200--Hi3516AV200-Datasheet.txt` line 63564).";

        field {
            name = "lvds1_lane3_eof_3";
            desc = "Lane 3 EOF synchronization code of frame 3 in LVDS or HiSPi mode This field is configurable only in WDR mode, and the configuration is invalid in linear mode.";
            sw = rw;
            hw = r;
            reset = 0x0;
        } lvds1_lane3_eof_3[31:16];

        field {
            name = "lvds1_lane3_eof_2";
            desc = "Lane 3 EOF synchronization code of frame 2 in LVDS or HiSPi mode This field is configurable only in WDR mode, and the configuration is invalid in linear mode.";
            sw = rw;
            hw = r;
            reset = 0x0;
        } lvds1_lane3_eof_2[15:0];
    } LVDS1_LANE3_EOF_23 @ 0x238C;

    reg {
        name = "Lane 3 SOL synchronization code NE3_SOL_0 configuration register in LVDS or HiSPi 1 mode";
        desc = "LVDS1_LANE3_SOL_01 is a lane 3 SOL synchronization code configuration register in LVDS or HiSPi mode.

Data sheet 9.3.6 LVDS1_LANE3_SOL_01 (offset 0x2390, printed page 9-446, `hi3516av200--Hi3516AV200-Datasheet.txt` line 63592).";

        field {
            name = "lvds1_lane3_sol_1";
            desc = "Lane 3 SOL synchronization code of frame 1 in LVDS or HiSPi mode This field is configurable only in WDR mode, and the configuration is invalid in linear mode.";
            sw = rw;
            hw = r;
            reset = 0x0;
        } lvds1_lane3_sol_1[31:16];

        field {
            name = "lvds1_lane3_sol_0";
            desc = "Lane 3 SOL synchronization code of frame 0 in LVDS or HiSPi mode In WDR mode, the value is the SOL of frame 0. In linear mode, the value is the SOL.";
            sw = rw;
            hw = r;
            reset = 0x0;
        } lvds1_lane3_sol_0[15:0];
    } LVDS1_LANE3_SOL_01 @ 0x2390;

    reg {
        name = "Lane 3 SOL synchronization code NE3_SOL_2 configuration register in LVDS or HiSPi 3 mode";
        desc = "LVDS1_LANE3_SOL_23 is a lane 3 SOL synchronization code configuration register in LVDS or HiSPi mode. Hi3516A V200 Professional HD IP Camera SoC

Data sheet 9.3.6 LVDS1_LANE3_SOL_23 (offset 0x2394, printed page 9-447, `hi3516av200--Hi3516AV200-Datasheet.txt` line 63629).";

        field {
            name = "lvds1_lane3_sol_3";
            desc = "Lane 3 SOL synchronization code of frame 3 in LVDS or HiSPi mode This field is configurable only in WDR mode, and the configuration is invalid in linear mode.";
            sw = rw;
            hw = r;
            reset = 0x0;
        } lvds1_lane3_sol_3[31:16];

        field {
            name = "lvds1_lane3_sol_2";
            desc = "Lane 3 SOL synchronization code of frame 2 in LVDS or HiSPi mode This field is configurable only in WDR mode, and the configuration is invalid in linear mode.";
            sw = rw;
            hw = r;
            reset = 0x0;
        } lvds1_lane3_sol_2[15:0];
    } LVDS1_LANE3_SOL_23 @ 0x2394;

    reg {
        name = "Lane 3 EOL synchronization code NE3_EOL_0 configuration register in LVDS or HiSPi 1 mode";
        desc = "LVDS1_LANE3_EOL_01 is a lane 3 EOL synchronization code configuration register in LVDS or HiSPi mode.

Data sheet 9.3.6 LVDS1_LANE3_EOL_01 (offset 0x2398, printed page 9-447, `hi3516av200--Hi3516AV200-Datasheet.txt` line 63657).";

        field {
            name = "lvds1_lane3_eol_1";
            desc = "Lane 3 EOL synchronization code of frame 1 in LVDS or HiSPi mode This field is configurable only in WDR mode, and the configuration is invalid in linear mode.";
            sw = rw;
            hw = r;
            reset = 0x0;
        } lvds1_lane3_eol_1[31:16];

        field {
            name = "lvds1_lane3_eol_0";
            desc = "Lane 3 EOL synchronization code of frame 0 in LVDS or HiSPi mode In WDR mode, the value is the EOL of frame 0. In linear mode, the value is the EOL.";
            sw = rw;
            hw = r;
            reset = 0x0;
        } lvds1_lane3_eol_0[15:0];
    } LVDS1_LANE3_EOL_01 @ 0x2398;

    reg {
        name = "Lane 3 EOL synchronization code NE3_EOL_2 configuration register in LVDS or HiSPi 3 mode";
        desc = "LVDS1_LANE3_EOL_23 is a lane 3 EOL synchronization code configuration register in LVDS or HiSPi mode. Hi3516A V200 Professional HD IP Camera SoC

Data sheet 9.3.6 LVDS1_LANE3_EOL_23 (offset 0x239C, printed page 9-448, `hi3516av200--Hi3516AV200-Datasheet.txt` line 63694).";

        field {
            name = "lvds1_lane3_eol_3";
            desc = "Lane 3 EOL synchronization code of frame 3 in LVDS or HiSPi mode This field is configurable only in WDR mode, and the configuration is invalid in linear mode.";
            sw = rw;
            hw = r;
            reset = 0x0;
        } lvds1_lane3_eol_3[31:16];

        field {
            name = "lvds1_lane3_eol_2";
            desc = "Lane 3 EOL synchronization code of frame 2 in LVDS or HiSPi mode This field is configurable only in WDR mode, and the configuration is invalid in linear mode.";
            sw = rw;
            hw = r;
            reset = 0x0;
        } lvds1_lane3_eol_2[15:0];
    } LVDS1_LANE3_EOL_23 @ 0x239C;

    reg {
        name = "LVDS1 LANE4 SOF 01";
        desc = "[inferred] LVDS1 LANE4 SOF 01. Not in the data sheet. Source: OpenIPC openhisilicon `kernel/mipi_rx/hi3519v101/mipi_reg.h` (GPL-3.0 repository, HiSilicon copyright; local copy sources/openhisilicon), union `U_LVDS_LANE_SOF_01`, struct offset 0x23A0 (GPL-3.0 repository, HiSilicon copyright; one header for Hi3519 V101 and Hi3516A V200). Reset value and access type unknown (modelled RW, no reset). Confidence: medium (vendor header for this chip family, not hardware verified).";

        field {
            name = "lane_sof_1";
            desc = "[inferred] Lane sof 1. (vendor header `hi3519v101/mipi_reg.h` field `lane_sof_1`; access and reset unknown, modelled RW)";
            sw = rw;
            hw = r;
        } lane_sof_1[31:16];

        field {
            name = "lane_sof_0";
            desc = "[inferred] Lane sof 0. (vendor header `hi3519v101/mipi_reg.h` field `lane_sof_0`; access and reset unknown, modelled RW)";
            sw = rw;
            hw = r;
        } lane_sof_0[15:0];
    } LVDS1_LANE4_SOF_01 @ 0x23A0;

    reg {
        name = "LVDS1 LANE4 SOF 23";
        desc = "[inferred] LVDS1 LANE4 SOF 23. Not in the data sheet. Source: OpenIPC openhisilicon `kernel/mipi_rx/hi3519v101/mipi_reg.h` (GPL-3.0 repository, HiSilicon copyright; local copy sources/openhisilicon), union `U_LVDS_LANE_SOF_23`, struct offset 0x23A4 (GPL-3.0 repository, HiSilicon copyright; one header for Hi3519 V101 and Hi3516A V200). Reset value and access type unknown (modelled RW, no reset). Confidence: medium (vendor header for this chip family, not hardware verified).";

        field {
            name = "lane_sof_3";
            desc = "[inferred] Lane sof 3. (vendor header `hi3519v101/mipi_reg.h` field `lane_sof_3`; access and reset unknown, modelled RW)";
            sw = rw;
            hw = r;
        } lane_sof_3[31:16];

        field {
            name = "lane_sof_2";
            desc = "[inferred] Lane sof 2. (vendor header `hi3519v101/mipi_reg.h` field `lane_sof_2`; access and reset unknown, modelled RW)";
            sw = rw;
            hw = r;
        } lane_sof_2[15:0];
    } LVDS1_LANE4_SOF_23 @ 0x23A4;

    reg {
        name = "LVDS1 LANE4 EOF 01";
        desc = "[inferred] LVDS1 LANE4 EOF 01. Not in the data sheet. Source: OpenIPC openhisilicon `kernel/mipi_rx/hi3519v101/mipi_reg.h` (GPL-3.0 repository, HiSilicon copyright; local copy sources/openhisilicon), union `U_LVDS_LANE_EOF_01`, struct offset 0x23A8 (GPL-3.0 repository, HiSilicon copyright; one header for Hi3519 V101 and Hi3516A V200). Reset value and access type unknown (modelled RW, no reset). Confidence: medium (vendor header for this chip family, not hardware verified).";

        field {
            name = "lane_eof_1";
            desc = "[inferred] Lane eof 1. (vendor header `hi3519v101/mipi_reg.h` field `lane_eof_1`; access and reset unknown, modelled RW)";
            sw = rw;
            hw = r;
        } lane_eof_1[31:16];

        field {
            name = "lane_eof_0";
            desc = "[inferred] Lane eof 0. (vendor header `hi3519v101/mipi_reg.h` field `lane_eof_0`; access and reset unknown, modelled RW)";
            sw = rw;
            hw = r;
        } lane_eof_0[15:0];
    } LVDS1_LANE4_EOF_01 @ 0x23A8;

    reg {
        name = "LVDS1 LANE4 EOF 23";
        desc = "[inferred] LVDS1 LANE4 EOF 23. Not in the data sheet. Source: OpenIPC openhisilicon `kernel/mipi_rx/hi3519v101/mipi_reg.h` (GPL-3.0 repository, HiSilicon copyright; local copy sources/openhisilicon), union `U_LVDS_LANE_EOF_23`, struct offset 0x23AC (GPL-3.0 repository, HiSilicon copyright; one header for Hi3519 V101 and Hi3516A V200). Reset value and access type unknown (modelled RW, no reset). Confidence: medium (vendor header for this chip family, not hardware verified).";

        field {
            name = "lane_eof_3";
            desc = "[inferred] Lane eof 3. (vendor header `hi3519v101/mipi_reg.h` field `lane_eof_3`; access and reset unknown, modelled RW)";
            sw = rw;
            hw = r;
        } lane_eof_3[31:16];

        field {
            name = "lane_eof_2";
            desc = "[inferred] Lane eof 2. (vendor header `hi3519v101/mipi_reg.h` field `lane_eof_2`; access and reset unknown, modelled RW)";
            sw = rw;
            hw = r;
        } lane_eof_2[15:0];
    } LVDS1_LANE4_EOF_23 @ 0x23AC;

    reg {
        name = "LVDS1 LANE4 SOL 01";
        desc = "[inferred] LVDS1 LANE4 SOL 01. Not in the data sheet. Source: OpenIPC openhisilicon `kernel/mipi_rx/hi3519v101/mipi_reg.h` (GPL-3.0 repository, HiSilicon copyright; local copy sources/openhisilicon), union `U_LVDS_LANE_SOL_01`, struct offset 0x23B0 (GPL-3.0 repository, HiSilicon copyright; one header for Hi3519 V101 and Hi3516A V200). Reset value and access type unknown (modelled RW, no reset). Confidence: medium (vendor header for this chip family, not hardware verified).";

        field {
            name = "lane_sol_1";
            desc = "[inferred] Lane sol 1. (vendor header `hi3519v101/mipi_reg.h` field `lane_sol_1`; access and reset unknown, modelled RW)";
            sw = rw;
            hw = r;
        } lane_sol_1[31:16];

        field {
            name = "lane_sol_0";
            desc = "[inferred] Lane sol 0. (vendor header `hi3519v101/mipi_reg.h` field `lane_sol_0`; access and reset unknown, modelled RW)";
            sw = rw;
            hw = r;
        } lane_sol_0[15:0];
    } LVDS1_LANE4_SOL_01 @ 0x23B0;

    reg {
        name = "LVDS1 LANE4 SOL 23";
        desc = "[inferred] LVDS1 LANE4 SOL 23. Not in the data sheet. Source: OpenIPC openhisilicon `kernel/mipi_rx/hi3519v101/mipi_reg.h` (GPL-3.0 repository, HiSilicon copyright; local copy sources/openhisilicon), union `U_LVDS_LANE_SOL_23`, struct offset 0x23B4 (GPL-3.0 repository, HiSilicon copyright; one header for Hi3519 V101 and Hi3516A V200). Reset value and access type unknown (modelled RW, no reset). Confidence: medium (vendor header for this chip family, not hardware verified).";

        field {
            name = "lane_sol_3";
            desc = "[inferred] Lane sol 3. (vendor header `hi3519v101/mipi_reg.h` field `lane_sol_3`; access and reset unknown, modelled RW)";
            sw = rw;
            hw = r;
        } lane_sol_3[31:16];

        field {
            name = "lane_sol_2";
            desc = "[inferred] Lane sol 2. (vendor header `hi3519v101/mipi_reg.h` field `lane_sol_2`; access and reset unknown, modelled RW)";
            sw = rw;
            hw = r;
        } lane_sol_2[15:0];
    } LVDS1_LANE4_SOL_23 @ 0x23B4;

    reg {
        name = "LVDS1 LANE4 EOL 01";
        desc = "[inferred] LVDS1 LANE4 EOL 01. Not in the data sheet. Source: OpenIPC openhisilicon `kernel/mipi_rx/hi3519v101/mipi_reg.h` (GPL-3.0 repository, HiSilicon copyright; local copy sources/openhisilicon), union `U_LVDS_LANE_EOL_01`, struct offset 0x23B8 (GPL-3.0 repository, HiSilicon copyright; one header for Hi3519 V101 and Hi3516A V200). Reset value and access type unknown (modelled RW, no reset). Confidence: medium (vendor header for this chip family, not hardware verified).";

        field {
            name = "lane_eol_1";
            desc = "[inferred] Lane eol 1. (vendor header `hi3519v101/mipi_reg.h` field `lane_eol_1`; access and reset unknown, modelled RW)";
            sw = rw;
            hw = r;
        } lane_eol_1[31:16];

        field {
            name = "lane_eol_0";
            desc = "[inferred] Lane eol 0. (vendor header `hi3519v101/mipi_reg.h` field `lane_eol_0`; access and reset unknown, modelled RW)";
            sw = rw;
            hw = r;
        } lane_eol_0[15:0];
    } LVDS1_LANE4_EOL_01 @ 0x23B8;

    reg {
        name = "LVDS1 LANE4 EOL 23";
        desc = "[inferred] LVDS1 LANE4 EOL 23. Not in the data sheet. Source: OpenIPC openhisilicon `kernel/mipi_rx/hi3519v101/mipi_reg.h` (GPL-3.0 repository, HiSilicon copyright; local copy sources/openhisilicon), union `U_LVDS_LANE_EOL_23`, struct offset 0x23BC (GPL-3.0 repository, HiSilicon copyright; one header for Hi3519 V101 and Hi3516A V200). Reset value and access type unknown (modelled RW, no reset). Confidence: medium (vendor header for this chip family, not hardware verified).";

        field {
            name = "lane_eol_3";
            desc = "[inferred] Lane eol 3. (vendor header `hi3519v101/mipi_reg.h` field `lane_eol_3`; access and reset unknown, modelled RW)";
            sw = rw;
            hw = r;
        } lane_eol_3[31:16];

        field {
            name = "lane_eol_2";
            desc = "[inferred] Lane eol 2. (vendor header `hi3519v101/mipi_reg.h` field `lane_eol_2`; access and reset unknown, modelled RW)";
            sw = rw;
            hw = r;
        } lane_eol_2[15:0];
    } LVDS1_LANE4_EOL_23 @ 0x23BC;

    reg {
        name = "LVDS1 LANE5 SOF 01";
        desc = "[inferred] LVDS1 LANE5 SOF 01. Not in the data sheet. Source: OpenIPC openhisilicon `kernel/mipi_rx/hi3519v101/mipi_reg.h` (GPL-3.0 repository, HiSilicon copyright; local copy sources/openhisilicon), union `U_LVDS_LANE_SOF_01`, struct offset 0x23C0 (GPL-3.0 repository, HiSilicon copyright; one header for Hi3519 V101 and Hi3516A V200). Reset value and access type unknown (modelled RW, no reset). Confidence: medium (vendor header for this chip family, not hardware verified).";

        field {
            name = "lane_sof_1";
            desc = "[inferred] Lane sof 1. (vendor header `hi3519v101/mipi_reg.h` field `lane_sof_1`; access and reset unknown, modelled RW)";
            sw = rw;
            hw = r;
        } lane_sof_1[31:16];

        field {
            name = "lane_sof_0";
            desc = "[inferred] Lane sof 0. (vendor header `hi3519v101/mipi_reg.h` field `lane_sof_0`; access and reset unknown, modelled RW)";
            sw = rw;
            hw = r;
        } lane_sof_0[15:0];
    } LVDS1_LANE5_SOF_01 @ 0x23C0;

    reg {
        name = "LVDS1 LANE5 SOF 23";
        desc = "[inferred] LVDS1 LANE5 SOF 23. Not in the data sheet. Source: OpenIPC openhisilicon `kernel/mipi_rx/hi3519v101/mipi_reg.h` (GPL-3.0 repository, HiSilicon copyright; local copy sources/openhisilicon), union `U_LVDS_LANE_SOF_23`, struct offset 0x23C4 (GPL-3.0 repository, HiSilicon copyright; one header for Hi3519 V101 and Hi3516A V200). Reset value and access type unknown (modelled RW, no reset). Confidence: medium (vendor header for this chip family, not hardware verified).";

        field {
            name = "lane_sof_3";
            desc = "[inferred] Lane sof 3. (vendor header `hi3519v101/mipi_reg.h` field `lane_sof_3`; access and reset unknown, modelled RW)";
            sw = rw;
            hw = r;
        } lane_sof_3[31:16];

        field {
            name = "lane_sof_2";
            desc = "[inferred] Lane sof 2. (vendor header `hi3519v101/mipi_reg.h` field `lane_sof_2`; access and reset unknown, modelled RW)";
            sw = rw;
            hw = r;
        } lane_sof_2[15:0];
    } LVDS1_LANE5_SOF_23 @ 0x23C4;

    reg {
        name = "LVDS1 LANE5 EOF 01";
        desc = "[inferred] LVDS1 LANE5 EOF 01. Not in the data sheet. Source: OpenIPC openhisilicon `kernel/mipi_rx/hi3519v101/mipi_reg.h` (GPL-3.0 repository, HiSilicon copyright; local copy sources/openhisilicon), union `U_LVDS_LANE_EOF_01`, struct offset 0x23C8 (GPL-3.0 repository, HiSilicon copyright; one header for Hi3519 V101 and Hi3516A V200). Reset value and access type unknown (modelled RW, no reset). Confidence: medium (vendor header for this chip family, not hardware verified).";

        field {
            name = "lane_eof_1";
            desc = "[inferred] Lane eof 1. (vendor header `hi3519v101/mipi_reg.h` field `lane_eof_1`; access and reset unknown, modelled RW)";
            sw = rw;
            hw = r;
        } lane_eof_1[31:16];

        field {
            name = "lane_eof_0";
            desc = "[inferred] Lane eof 0. (vendor header `hi3519v101/mipi_reg.h` field `lane_eof_0`; access and reset unknown, modelled RW)";
            sw = rw;
            hw = r;
        } lane_eof_0[15:0];
    } LVDS1_LANE5_EOF_01 @ 0x23C8;

    reg {
        name = "LVDS1 LANE5 EOF 23";
        desc = "[inferred] LVDS1 LANE5 EOF 23. Not in the data sheet. Source: OpenIPC openhisilicon `kernel/mipi_rx/hi3519v101/mipi_reg.h` (GPL-3.0 repository, HiSilicon copyright; local copy sources/openhisilicon), union `U_LVDS_LANE_EOF_23`, struct offset 0x23CC (GPL-3.0 repository, HiSilicon copyright; one header for Hi3519 V101 and Hi3516A V200). Reset value and access type unknown (modelled RW, no reset). Confidence: medium (vendor header for this chip family, not hardware verified).";

        field {
            name = "lane_eof_3";
            desc = "[inferred] Lane eof 3. (vendor header `hi3519v101/mipi_reg.h` field `lane_eof_3`; access and reset unknown, modelled RW)";
            sw = rw;
            hw = r;
        } lane_eof_3[31:16];

        field {
            name = "lane_eof_2";
            desc = "[inferred] Lane eof 2. (vendor header `hi3519v101/mipi_reg.h` field `lane_eof_2`; access and reset unknown, modelled RW)";
            sw = rw;
            hw = r;
        } lane_eof_2[15:0];
    } LVDS1_LANE5_EOF_23 @ 0x23CC;

    reg {
        name = "LVDS1 LANE5 SOL 01";
        desc = "[inferred] LVDS1 LANE5 SOL 01. Not in the data sheet. Source: OpenIPC openhisilicon `kernel/mipi_rx/hi3519v101/mipi_reg.h` (GPL-3.0 repository, HiSilicon copyright; local copy sources/openhisilicon), union `U_LVDS_LANE_SOL_01`, struct offset 0x23D0 (GPL-3.0 repository, HiSilicon copyright; one header for Hi3519 V101 and Hi3516A V200). Reset value and access type unknown (modelled RW, no reset). Confidence: medium (vendor header for this chip family, not hardware verified).";

        field {
            name = "lane_sol_1";
            desc = "[inferred] Lane sol 1. (vendor header `hi3519v101/mipi_reg.h` field `lane_sol_1`; access and reset unknown, modelled RW)";
            sw = rw;
            hw = r;
        } lane_sol_1[31:16];

        field {
            name = "lane_sol_0";
            desc = "[inferred] Lane sol 0. (vendor header `hi3519v101/mipi_reg.h` field `lane_sol_0`; access and reset unknown, modelled RW)";
            sw = rw;
            hw = r;
        } lane_sol_0[15:0];
    } LVDS1_LANE5_SOL_01 @ 0x23D0;

    reg {
        name = "LVDS1 LANE5 SOL 23";
        desc = "[inferred] LVDS1 LANE5 SOL 23. Not in the data sheet. Source: OpenIPC openhisilicon `kernel/mipi_rx/hi3519v101/mipi_reg.h` (GPL-3.0 repository, HiSilicon copyright; local copy sources/openhisilicon), union `U_LVDS_LANE_SOL_23`, struct offset 0x23D4 (GPL-3.0 repository, HiSilicon copyright; one header for Hi3519 V101 and Hi3516A V200). Reset value and access type unknown (modelled RW, no reset). Confidence: medium (vendor header for this chip family, not hardware verified).";

        field {
            name = "lane_sol_3";
            desc = "[inferred] Lane sol 3. (vendor header `hi3519v101/mipi_reg.h` field `lane_sol_3`; access and reset unknown, modelled RW)";
            sw = rw;
            hw = r;
        } lane_sol_3[31:16];

        field {
            name = "lane_sol_2";
            desc = "[inferred] Lane sol 2. (vendor header `hi3519v101/mipi_reg.h` field `lane_sol_2`; access and reset unknown, modelled RW)";
            sw = rw;
            hw = r;
        } lane_sol_2[15:0];
    } LVDS1_LANE5_SOL_23 @ 0x23D4;

    reg {
        name = "LVDS1 LANE5 EOL 01";
        desc = "[inferred] LVDS1 LANE5 EOL 01. Not in the data sheet. Source: OpenIPC openhisilicon `kernel/mipi_rx/hi3519v101/mipi_reg.h` (GPL-3.0 repository, HiSilicon copyright; local copy sources/openhisilicon), union `U_LVDS_LANE_EOL_01`, struct offset 0x23D8 (GPL-3.0 repository, HiSilicon copyright; one header for Hi3519 V101 and Hi3516A V200). Reset value and access type unknown (modelled RW, no reset). Confidence: medium (vendor header for this chip family, not hardware verified).";

        field {
            name = "lane_eol_1";
            desc = "[inferred] Lane eol 1. (vendor header `hi3519v101/mipi_reg.h` field `lane_eol_1`; access and reset unknown, modelled RW)";
            sw = rw;
            hw = r;
        } lane_eol_1[31:16];

        field {
            name = "lane_eol_0";
            desc = "[inferred] Lane eol 0. (vendor header `hi3519v101/mipi_reg.h` field `lane_eol_0`; access and reset unknown, modelled RW)";
            sw = rw;
            hw = r;
        } lane_eol_0[15:0];
    } LVDS1_LANE5_EOL_01 @ 0x23D8;

    reg {
        name = "LVDS1 LANE5 EOL 23";
        desc = "[inferred] LVDS1 LANE5 EOL 23. Not in the data sheet. Source: OpenIPC openhisilicon `kernel/mipi_rx/hi3519v101/mipi_reg.h` (GPL-3.0 repository, HiSilicon copyright; local copy sources/openhisilicon), union `U_LVDS_LANE_EOL_23`, struct offset 0x23DC (GPL-3.0 repository, HiSilicon copyright; one header for Hi3519 V101 and Hi3516A V200). Reset value and access type unknown (modelled RW, no reset). Confidence: medium (vendor header for this chip family, not hardware verified).";

        field {
            name = "lane_eol_3";
            desc = "[inferred] Lane eol 3. (vendor header `hi3519v101/mipi_reg.h` field `lane_eol_3`; access and reset unknown, modelled RW)";
            sw = rw;
            hw = r;
        } lane_eol_3[31:16];

        field {
            name = "lane_eol_2";
            desc = "[inferred] Lane eol 2. (vendor header `hi3519v101/mipi_reg.h` field `lane_eol_2`; access and reset unknown, modelled RW)";
            sw = rw;
            hw = r;
        } lane_eol_2[15:0];
    } LVDS1_LANE5_EOL_23 @ 0x23DC;

    reg {
        name = "LVDS1 LANE6 SOF 01";
        desc = "[inferred] LVDS1 LANE6 SOF 01. Not in the data sheet. Source: OpenIPC openhisilicon `kernel/mipi_rx/hi3519v101/mipi_reg.h` (GPL-3.0 repository, HiSilicon copyright; local copy sources/openhisilicon), union `U_LVDS_LANE_SOF_01`, struct offset 0x23E0 (GPL-3.0 repository, HiSilicon copyright; one header for Hi3519 V101 and Hi3516A V200). Reset value and access type unknown (modelled RW, no reset). Confidence: medium (vendor header for this chip family, not hardware verified).";

        field {
            name = "lane_sof_1";
            desc = "[inferred] Lane sof 1. (vendor header `hi3519v101/mipi_reg.h` field `lane_sof_1`; access and reset unknown, modelled RW)";
            sw = rw;
            hw = r;
        } lane_sof_1[31:16];

        field {
            name = "lane_sof_0";
            desc = "[inferred] Lane sof 0. (vendor header `hi3519v101/mipi_reg.h` field `lane_sof_0`; access and reset unknown, modelled RW)";
            sw = rw;
            hw = r;
        } lane_sof_0[15:0];
    } LVDS1_LANE6_SOF_01 @ 0x23E0;

    reg {
        name = "LVDS1 LANE6 SOF 23";
        desc = "[inferred] LVDS1 LANE6 SOF 23. Not in the data sheet. Source: OpenIPC openhisilicon `kernel/mipi_rx/hi3519v101/mipi_reg.h` (GPL-3.0 repository, HiSilicon copyright; local copy sources/openhisilicon), union `U_LVDS_LANE_SOF_23`, struct offset 0x23E4 (GPL-3.0 repository, HiSilicon copyright; one header for Hi3519 V101 and Hi3516A V200). Reset value and access type unknown (modelled RW, no reset). Confidence: medium (vendor header for this chip family, not hardware verified).";

        field {
            name = "lane_sof_3";
            desc = "[inferred] Lane sof 3. (vendor header `hi3519v101/mipi_reg.h` field `lane_sof_3`; access and reset unknown, modelled RW)";
            sw = rw;
            hw = r;
        } lane_sof_3[31:16];

        field {
            name = "lane_sof_2";
            desc = "[inferred] Lane sof 2. (vendor header `hi3519v101/mipi_reg.h` field `lane_sof_2`; access and reset unknown, modelled RW)";
            sw = rw;
            hw = r;
        } lane_sof_2[15:0];
    } LVDS1_LANE6_SOF_23 @ 0x23E4;

    reg {
        name = "LVDS1 LANE6 EOF 01";
        desc = "[inferred] LVDS1 LANE6 EOF 01. Not in the data sheet. Source: OpenIPC openhisilicon `kernel/mipi_rx/hi3519v101/mipi_reg.h` (GPL-3.0 repository, HiSilicon copyright; local copy sources/openhisilicon), union `U_LVDS_LANE_EOF_01`, struct offset 0x23E8 (GPL-3.0 repository, HiSilicon copyright; one header for Hi3519 V101 and Hi3516A V200). Reset value and access type unknown (modelled RW, no reset). Confidence: medium (vendor header for this chip family, not hardware verified).";

        field {
            name = "lane_eof_1";
            desc = "[inferred] Lane eof 1. (vendor header `hi3519v101/mipi_reg.h` field `lane_eof_1`; access and reset unknown, modelled RW)";
            sw = rw;
            hw = r;
        } lane_eof_1[31:16];

        field {
            name = "lane_eof_0";
            desc = "[inferred] Lane eof 0. (vendor header `hi3519v101/mipi_reg.h` field `lane_eof_0`; access and reset unknown, modelled RW)";
            sw = rw;
            hw = r;
        } lane_eof_0[15:0];
    } LVDS1_LANE6_EOF_01 @ 0x23E8;

    reg {
        name = "LVDS1 LANE6 EOF 23";
        desc = "[inferred] LVDS1 LANE6 EOF 23. Not in the data sheet. Source: OpenIPC openhisilicon `kernel/mipi_rx/hi3519v101/mipi_reg.h` (GPL-3.0 repository, HiSilicon copyright; local copy sources/openhisilicon), union `U_LVDS_LANE_EOF_23`, struct offset 0x23EC (GPL-3.0 repository, HiSilicon copyright; one header for Hi3519 V101 and Hi3516A V200). Reset value and access type unknown (modelled RW, no reset). Confidence: medium (vendor header for this chip family, not hardware verified).";

        field {
            name = "lane_eof_3";
            desc = "[inferred] Lane eof 3. (vendor header `hi3519v101/mipi_reg.h` field `lane_eof_3`; access and reset unknown, modelled RW)";
            sw = rw;
            hw = r;
        } lane_eof_3[31:16];

        field {
            name = "lane_eof_2";
            desc = "[inferred] Lane eof 2. (vendor header `hi3519v101/mipi_reg.h` field `lane_eof_2`; access and reset unknown, modelled RW)";
            sw = rw;
            hw = r;
        } lane_eof_2[15:0];
    } LVDS1_LANE6_EOF_23 @ 0x23EC;

    reg {
        name = "LVDS1 LANE6 SOL 01";
        desc = "[inferred] LVDS1 LANE6 SOL 01. Not in the data sheet. Source: OpenIPC openhisilicon `kernel/mipi_rx/hi3519v101/mipi_reg.h` (GPL-3.0 repository, HiSilicon copyright; local copy sources/openhisilicon), union `U_LVDS_LANE_SOL_01`, struct offset 0x23F0 (GPL-3.0 repository, HiSilicon copyright; one header for Hi3519 V101 and Hi3516A V200). Reset value and access type unknown (modelled RW, no reset). Confidence: medium (vendor header for this chip family, not hardware verified).";

        field {
            name = "lane_sol_1";
            desc = "[inferred] Lane sol 1. (vendor header `hi3519v101/mipi_reg.h` field `lane_sol_1`; access and reset unknown, modelled RW)";
            sw = rw;
            hw = r;
        } lane_sol_1[31:16];

        field {
            name = "lane_sol_0";
            desc = "[inferred] Lane sol 0. (vendor header `hi3519v101/mipi_reg.h` field `lane_sol_0`; access and reset unknown, modelled RW)";
            sw = rw;
            hw = r;
        } lane_sol_0[15:0];
    } LVDS1_LANE6_SOL_01 @ 0x23F0;

    reg {
        name = "LVDS1 LANE6 SOL 23";
        desc = "[inferred] LVDS1 LANE6 SOL 23. Not in the data sheet. Source: OpenIPC openhisilicon `kernel/mipi_rx/hi3519v101/mipi_reg.h` (GPL-3.0 repository, HiSilicon copyright; local copy sources/openhisilicon), union `U_LVDS_LANE_SOL_23`, struct offset 0x23F4 (GPL-3.0 repository, HiSilicon copyright; one header for Hi3519 V101 and Hi3516A V200). Reset value and access type unknown (modelled RW, no reset). Confidence: medium (vendor header for this chip family, not hardware verified).";

        field {
            name = "lane_sol_3";
            desc = "[inferred] Lane sol 3. (vendor header `hi3519v101/mipi_reg.h` field `lane_sol_3`; access and reset unknown, modelled RW)";
            sw = rw;
            hw = r;
        } lane_sol_3[31:16];

        field {
            name = "lane_sol_2";
            desc = "[inferred] Lane sol 2. (vendor header `hi3519v101/mipi_reg.h` field `lane_sol_2`; access and reset unknown, modelled RW)";
            sw = rw;
            hw = r;
        } lane_sol_2[15:0];
    } LVDS1_LANE6_SOL_23 @ 0x23F4;

    reg {
        name = "LVDS1 LANE6 EOL 01";
        desc = "[inferred] LVDS1 LANE6 EOL 01. Not in the data sheet. Source: OpenIPC openhisilicon `kernel/mipi_rx/hi3519v101/mipi_reg.h` (GPL-3.0 repository, HiSilicon copyright; local copy sources/openhisilicon), union `U_LVDS_LANE_EOL_01`, struct offset 0x23F8 (GPL-3.0 repository, HiSilicon copyright; one header for Hi3519 V101 and Hi3516A V200). Reset value and access type unknown (modelled RW, no reset). Confidence: medium (vendor header for this chip family, not hardware verified).";

        field {
            name = "lane_eol_1";
            desc = "[inferred] Lane eol 1. (vendor header `hi3519v101/mipi_reg.h` field `lane_eol_1`; access and reset unknown, modelled RW)";
            sw = rw;
            hw = r;
        } lane_eol_1[31:16];

        field {
            name = "lane_eol_0";
            desc = "[inferred] Lane eol 0. (vendor header `hi3519v101/mipi_reg.h` field `lane_eol_0`; access and reset unknown, modelled RW)";
            sw = rw;
            hw = r;
        } lane_eol_0[15:0];
    } LVDS1_LANE6_EOL_01 @ 0x23F8;

    reg {
        name = "LVDS1 LANE6 EOL 23";
        desc = "[inferred] LVDS1 LANE6 EOL 23. Not in the data sheet. Source: OpenIPC openhisilicon `kernel/mipi_rx/hi3519v101/mipi_reg.h` (GPL-3.0 repository, HiSilicon copyright; local copy sources/openhisilicon), union `U_LVDS_LANE_EOL_23`, struct offset 0x23FC (GPL-3.0 repository, HiSilicon copyright; one header for Hi3519 V101 and Hi3516A V200). Reset value and access type unknown (modelled RW, no reset). Confidence: medium (vendor header for this chip family, not hardware verified).";

        field {
            name = "lane_eol_3";
            desc = "[inferred] Lane eol 3. (vendor header `hi3519v101/mipi_reg.h` field `lane_eol_3`; access and reset unknown, modelled RW)";
            sw = rw;
            hw = r;
        } lane_eol_3[31:16];

        field {
            name = "lane_eol_2";
            desc = "[inferred] Lane eol 2. (vendor header `hi3519v101/mipi_reg.h` field `lane_eol_2`; access and reset unknown, modelled RW)";
            sw = rw;
            hw = r;
        } lane_eol_2[15:0];
    } LVDS1_LANE6_EOL_23 @ 0x23FC;

    reg {
        name = "LVDS1 LANE7 SOF 01";
        desc = "[inferred] LVDS1 LANE7 SOF 01. Not in the data sheet. Source: OpenIPC openhisilicon `kernel/mipi_rx/hi3519v101/mipi_reg.h` (GPL-3.0 repository, HiSilicon copyright; local copy sources/openhisilicon), union `U_LVDS_LANE_SOF_01`, struct offset 0x2400 (GPL-3.0 repository, HiSilicon copyright; one header for Hi3519 V101 and Hi3516A V200). Reset value and access type unknown (modelled RW, no reset). Confidence: medium (vendor header for this chip family, not hardware verified).";

        field {
            name = "lane_sof_1";
            desc = "[inferred] Lane sof 1. (vendor header `hi3519v101/mipi_reg.h` field `lane_sof_1`; access and reset unknown, modelled RW)";
            sw = rw;
            hw = r;
        } lane_sof_1[31:16];

        field {
            name = "lane_sof_0";
            desc = "[inferred] Lane sof 0. (vendor header `hi3519v101/mipi_reg.h` field `lane_sof_0`; access and reset unknown, modelled RW)";
            sw = rw;
            hw = r;
        } lane_sof_0[15:0];
    } LVDS1_LANE7_SOF_01 @ 0x2400;

    reg {
        name = "LVDS1 LANE7 SOF 23";
        desc = "[inferred] LVDS1 LANE7 SOF 23. Not in the data sheet. Source: OpenIPC openhisilicon `kernel/mipi_rx/hi3519v101/mipi_reg.h` (GPL-3.0 repository, HiSilicon copyright; local copy sources/openhisilicon), union `U_LVDS_LANE_SOF_23`, struct offset 0x2404 (GPL-3.0 repository, HiSilicon copyright; one header for Hi3519 V101 and Hi3516A V200). Reset value and access type unknown (modelled RW, no reset). Confidence: medium (vendor header for this chip family, not hardware verified).";

        field {
            name = "lane_sof_3";
            desc = "[inferred] Lane sof 3. (vendor header `hi3519v101/mipi_reg.h` field `lane_sof_3`; access and reset unknown, modelled RW)";
            sw = rw;
            hw = r;
        } lane_sof_3[31:16];

        field {
            name = "lane_sof_2";
            desc = "[inferred] Lane sof 2. (vendor header `hi3519v101/mipi_reg.h` field `lane_sof_2`; access and reset unknown, modelled RW)";
            sw = rw;
            hw = r;
        } lane_sof_2[15:0];
    } LVDS1_LANE7_SOF_23 @ 0x2404;

    reg {
        name = "LVDS1 LANE7 EOF 01";
        desc = "[inferred] LVDS1 LANE7 EOF 01. Not in the data sheet. Source: OpenIPC openhisilicon `kernel/mipi_rx/hi3519v101/mipi_reg.h` (GPL-3.0 repository, HiSilicon copyright; local copy sources/openhisilicon), union `U_LVDS_LANE_EOF_01`, struct offset 0x2408 (GPL-3.0 repository, HiSilicon copyright; one header for Hi3519 V101 and Hi3516A V200). Reset value and access type unknown (modelled RW, no reset). Confidence: medium (vendor header for this chip family, not hardware verified).";

        field {
            name = "lane_eof_1";
            desc = "[inferred] Lane eof 1. (vendor header `hi3519v101/mipi_reg.h` field `lane_eof_1`; access and reset unknown, modelled RW)";
            sw = rw;
            hw = r;
        } lane_eof_1[31:16];

        field {
            name = "lane_eof_0";
            desc = "[inferred] Lane eof 0. (vendor header `hi3519v101/mipi_reg.h` field `lane_eof_0`; access and reset unknown, modelled RW)";
            sw = rw;
            hw = r;
        } lane_eof_0[15:0];
    } LVDS1_LANE7_EOF_01 @ 0x2408;

    reg {
        name = "LVDS1 LANE7 EOF 23";
        desc = "[inferred] LVDS1 LANE7 EOF 23. Not in the data sheet. Source: OpenIPC openhisilicon `kernel/mipi_rx/hi3519v101/mipi_reg.h` (GPL-3.0 repository, HiSilicon copyright; local copy sources/openhisilicon), union `U_LVDS_LANE_EOF_23`, struct offset 0x240C (GPL-3.0 repository, HiSilicon copyright; one header for Hi3519 V101 and Hi3516A V200). Reset value and access type unknown (modelled RW, no reset). Confidence: medium (vendor header for this chip family, not hardware verified).";

        field {
            name = "lane_eof_3";
            desc = "[inferred] Lane eof 3. (vendor header `hi3519v101/mipi_reg.h` field `lane_eof_3`; access and reset unknown, modelled RW)";
            sw = rw;
            hw = r;
        } lane_eof_3[31:16];

        field {
            name = "lane_eof_2";
            desc = "[inferred] Lane eof 2. (vendor header `hi3519v101/mipi_reg.h` field `lane_eof_2`; access and reset unknown, modelled RW)";
            sw = rw;
            hw = r;
        } lane_eof_2[15:0];
    } LVDS1_LANE7_EOF_23 @ 0x240C;

    reg {
        name = "LVDS1 LANE7 SOL 01";
        desc = "[inferred] LVDS1 LANE7 SOL 01. Not in the data sheet. Source: OpenIPC openhisilicon `kernel/mipi_rx/hi3519v101/mipi_reg.h` (GPL-3.0 repository, HiSilicon copyright; local copy sources/openhisilicon), union `U_LVDS_LANE_SOL_01`, struct offset 0x2410 (GPL-3.0 repository, HiSilicon copyright; one header for Hi3519 V101 and Hi3516A V200). Reset value and access type unknown (modelled RW, no reset). Confidence: medium (vendor header for this chip family, not hardware verified).";

        field {
            name = "lane_sol_1";
            desc = "[inferred] Lane sol 1. (vendor header `hi3519v101/mipi_reg.h` field `lane_sol_1`; access and reset unknown, modelled RW)";
            sw = rw;
            hw = r;
        } lane_sol_1[31:16];

        field {
            name = "lane_sol_0";
            desc = "[inferred] Lane sol 0. (vendor header `hi3519v101/mipi_reg.h` field `lane_sol_0`; access and reset unknown, modelled RW)";
            sw = rw;
            hw = r;
        } lane_sol_0[15:0];
    } LVDS1_LANE7_SOL_01 @ 0x2410;

    reg {
        name = "LVDS1 LANE7 SOL 23";
        desc = "[inferred] LVDS1 LANE7 SOL 23. Not in the data sheet. Source: OpenIPC openhisilicon `kernel/mipi_rx/hi3519v101/mipi_reg.h` (GPL-3.0 repository, HiSilicon copyright; local copy sources/openhisilicon), union `U_LVDS_LANE_SOL_23`, struct offset 0x2414 (GPL-3.0 repository, HiSilicon copyright; one header for Hi3519 V101 and Hi3516A V200). Reset value and access type unknown (modelled RW, no reset). Confidence: medium (vendor header for this chip family, not hardware verified).";

        field {
            name = "lane_sol_3";
            desc = "[inferred] Lane sol 3. (vendor header `hi3519v101/mipi_reg.h` field `lane_sol_3`; access and reset unknown, modelled RW)";
            sw = rw;
            hw = r;
        } lane_sol_3[31:16];

        field {
            name = "lane_sol_2";
            desc = "[inferred] Lane sol 2. (vendor header `hi3519v101/mipi_reg.h` field `lane_sol_2`; access and reset unknown, modelled RW)";
            sw = rw;
            hw = r;
        } lane_sol_2[15:0];
    } LVDS1_LANE7_SOL_23 @ 0x2414;

    reg {
        name = "LVDS1 LANE7 EOL 01";
        desc = "[inferred] LVDS1 LANE7 EOL 01. Not in the data sheet. Source: OpenIPC openhisilicon `kernel/mipi_rx/hi3519v101/mipi_reg.h` (GPL-3.0 repository, HiSilicon copyright; local copy sources/openhisilicon), union `U_LVDS_LANE_EOL_01`, struct offset 0x2418 (GPL-3.0 repository, HiSilicon copyright; one header for Hi3519 V101 and Hi3516A V200). Reset value and access type unknown (modelled RW, no reset). Confidence: medium (vendor header for this chip family, not hardware verified).";

        field {
            name = "lane_eol_1";
            desc = "[inferred] Lane eol 1. (vendor header `hi3519v101/mipi_reg.h` field `lane_eol_1`; access and reset unknown, modelled RW)";
            sw = rw;
            hw = r;
        } lane_eol_1[31:16];

        field {
            name = "lane_eol_0";
            desc = "[inferred] Lane eol 0. (vendor header `hi3519v101/mipi_reg.h` field `lane_eol_0`; access and reset unknown, modelled RW)";
            sw = rw;
            hw = r;
        } lane_eol_0[15:0];
    } LVDS1_LANE7_EOL_01 @ 0x2418;

    reg {
        name = "LVDS1 LANE7 EOL 23";
        desc = "[inferred] LVDS1 LANE7 EOL 23. Not in the data sheet. Source: OpenIPC openhisilicon `kernel/mipi_rx/hi3519v101/mipi_reg.h` (GPL-3.0 repository, HiSilicon copyright; local copy sources/openhisilicon), union `U_LVDS_LANE_EOL_23`, struct offset 0x241C (GPL-3.0 repository, HiSilicon copyright; one header for Hi3519 V101 and Hi3516A V200). Reset value and access type unknown (modelled RW, no reset). Confidence: medium (vendor header for this chip family, not hardware verified).";

        field {
            name = "lane_eol_3";
            desc = "[inferred] Lane eol 3. (vendor header `hi3519v101/mipi_reg.h` field `lane_eol_3`; access and reset unknown, modelled RW)";
            sw = rw;
            hw = r;
        } lane_eol_3[31:16];

        field {
            name = "lane_eol_2";
            desc = "[inferred] Lane eol 2. (vendor header `hi3519v101/mipi_reg.h` field `lane_eol_2`; access and reset unknown, modelled RW)";
            sw = rw;
            hw = r;
        } lane_eol_2[15:0];
    } LVDS1_LANE7_EOL_23 @ 0x241C;

    reg {
        name = "LVDS1 LANE8 SOF 01";
        desc = "[inferred] LVDS1 LANE8 SOF 01. Not in the data sheet. Source: OpenIPC openhisilicon `kernel/mipi_rx/hi3519v101/mipi_reg.h` (GPL-3.0 repository, HiSilicon copyright; local copy sources/openhisilicon), union `U_LVDS_LANE_SOF_01`, struct offset 0x2420 (GPL-3.0 repository, HiSilicon copyright; one header for Hi3519 V101 and Hi3516A V200). Reset value and access type unknown (modelled RW, no reset). Confidence: medium (vendor header for this chip family, not hardware verified).";

        field {
            name = "lane_sof_1";
            desc = "[inferred] Lane sof 1. (vendor header `hi3519v101/mipi_reg.h` field `lane_sof_1`; access and reset unknown, modelled RW)";
            sw = rw;
            hw = r;
        } lane_sof_1[31:16];

        field {
            name = "lane_sof_0";
            desc = "[inferred] Lane sof 0. (vendor header `hi3519v101/mipi_reg.h` field `lane_sof_0`; access and reset unknown, modelled RW)";
            sw = rw;
            hw = r;
        } lane_sof_0[15:0];
    } LVDS1_LANE8_SOF_01 @ 0x2420;

    reg {
        name = "LVDS1 LANE8 SOF 23";
        desc = "[inferred] LVDS1 LANE8 SOF 23. Not in the data sheet. Source: OpenIPC openhisilicon `kernel/mipi_rx/hi3519v101/mipi_reg.h` (GPL-3.0 repository, HiSilicon copyright; local copy sources/openhisilicon), union `U_LVDS_LANE_SOF_23`, struct offset 0x2424 (GPL-3.0 repository, HiSilicon copyright; one header for Hi3519 V101 and Hi3516A V200). Reset value and access type unknown (modelled RW, no reset). Confidence: medium (vendor header for this chip family, not hardware verified).";

        field {
            name = "lane_sof_3";
            desc = "[inferred] Lane sof 3. (vendor header `hi3519v101/mipi_reg.h` field `lane_sof_3`; access and reset unknown, modelled RW)";
            sw = rw;
            hw = r;
        } lane_sof_3[31:16];

        field {
            name = "lane_sof_2";
            desc = "[inferred] Lane sof 2. (vendor header `hi3519v101/mipi_reg.h` field `lane_sof_2`; access and reset unknown, modelled RW)";
            sw = rw;
            hw = r;
        } lane_sof_2[15:0];
    } LVDS1_LANE8_SOF_23 @ 0x2424;

    reg {
        name = "LVDS1 LANE8 EOF 01";
        desc = "[inferred] LVDS1 LANE8 EOF 01. Not in the data sheet. Source: OpenIPC openhisilicon `kernel/mipi_rx/hi3519v101/mipi_reg.h` (GPL-3.0 repository, HiSilicon copyright; local copy sources/openhisilicon), union `U_LVDS_LANE_EOF_01`, struct offset 0x2428 (GPL-3.0 repository, HiSilicon copyright; one header for Hi3519 V101 and Hi3516A V200). Reset value and access type unknown (modelled RW, no reset). Confidence: medium (vendor header for this chip family, not hardware verified).";

        field {
            name = "lane_eof_1";
            desc = "[inferred] Lane eof 1. (vendor header `hi3519v101/mipi_reg.h` field `lane_eof_1`; access and reset unknown, modelled RW)";
            sw = rw;
            hw = r;
        } lane_eof_1[31:16];

        field {
            name = "lane_eof_0";
            desc = "[inferred] Lane eof 0. (vendor header `hi3519v101/mipi_reg.h` field `lane_eof_0`; access and reset unknown, modelled RW)";
            sw = rw;
            hw = r;
        } lane_eof_0[15:0];
    } LVDS1_LANE8_EOF_01 @ 0x2428;

    reg {
        name = "LVDS1 LANE8 EOF 23";
        desc = "[inferred] LVDS1 LANE8 EOF 23. Not in the data sheet. Source: OpenIPC openhisilicon `kernel/mipi_rx/hi3519v101/mipi_reg.h` (GPL-3.0 repository, HiSilicon copyright; local copy sources/openhisilicon), union `U_LVDS_LANE_EOF_23`, struct offset 0x242C (GPL-3.0 repository, HiSilicon copyright; one header for Hi3519 V101 and Hi3516A V200). Reset value and access type unknown (modelled RW, no reset). Confidence: medium (vendor header for this chip family, not hardware verified).";

        field {
            name = "lane_eof_3";
            desc = "[inferred] Lane eof 3. (vendor header `hi3519v101/mipi_reg.h` field `lane_eof_3`; access and reset unknown, modelled RW)";
            sw = rw;
            hw = r;
        } lane_eof_3[31:16];

        field {
            name = "lane_eof_2";
            desc = "[inferred] Lane eof 2. (vendor header `hi3519v101/mipi_reg.h` field `lane_eof_2`; access and reset unknown, modelled RW)";
            sw = rw;
            hw = r;
        } lane_eof_2[15:0];
    } LVDS1_LANE8_EOF_23 @ 0x242C;

    reg {
        name = "LVDS1 LANE8 SOL 01";
        desc = "[inferred] LVDS1 LANE8 SOL 01. Not in the data sheet. Source: OpenIPC openhisilicon `kernel/mipi_rx/hi3519v101/mipi_reg.h` (GPL-3.0 repository, HiSilicon copyright; local copy sources/openhisilicon), union `U_LVDS_LANE_SOL_01`, struct offset 0x2430 (GPL-3.0 repository, HiSilicon copyright; one header for Hi3519 V101 and Hi3516A V200). Reset value and access type unknown (modelled RW, no reset). Confidence: medium (vendor header for this chip family, not hardware verified).";

        field {
            name = "lane_sol_1";
            desc = "[inferred] Lane sol 1. (vendor header `hi3519v101/mipi_reg.h` field `lane_sol_1`; access and reset unknown, modelled RW)";
            sw = rw;
            hw = r;
        } lane_sol_1[31:16];

        field {
            name = "lane_sol_0";
            desc = "[inferred] Lane sol 0. (vendor header `hi3519v101/mipi_reg.h` field `lane_sol_0`; access and reset unknown, modelled RW)";
            sw = rw;
            hw = r;
        } lane_sol_0[15:0];
    } LVDS1_LANE8_SOL_01 @ 0x2430;

    reg {
        name = "LVDS1 LANE8 SOL 23";
        desc = "[inferred] LVDS1 LANE8 SOL 23. Not in the data sheet. Source: OpenIPC openhisilicon `kernel/mipi_rx/hi3519v101/mipi_reg.h` (GPL-3.0 repository, HiSilicon copyright; local copy sources/openhisilicon), union `U_LVDS_LANE_SOL_23`, struct offset 0x2434 (GPL-3.0 repository, HiSilicon copyright; one header for Hi3519 V101 and Hi3516A V200). Reset value and access type unknown (modelled RW, no reset). Confidence: medium (vendor header for this chip family, not hardware verified).";

        field {
            name = "lane_sol_3";
            desc = "[inferred] Lane sol 3. (vendor header `hi3519v101/mipi_reg.h` field `lane_sol_3`; access and reset unknown, modelled RW)";
            sw = rw;
            hw = r;
        } lane_sol_3[31:16];

        field {
            name = "lane_sol_2";
            desc = "[inferred] Lane sol 2. (vendor header `hi3519v101/mipi_reg.h` field `lane_sol_2`; access and reset unknown, modelled RW)";
            sw = rw;
            hw = r;
        } lane_sol_2[15:0];
    } LVDS1_LANE8_SOL_23 @ 0x2434;

    reg {
        name = "LVDS1 LANE8 EOL 01";
        desc = "[inferred] LVDS1 LANE8 EOL 01. Not in the data sheet. Source: OpenIPC openhisilicon `kernel/mipi_rx/hi3519v101/mipi_reg.h` (GPL-3.0 repository, HiSilicon copyright; local copy sources/openhisilicon), union `U_LVDS_LANE_EOL_01`, struct offset 0x2438 (GPL-3.0 repository, HiSilicon copyright; one header for Hi3519 V101 and Hi3516A V200). Reset value and access type unknown (modelled RW, no reset). Confidence: medium (vendor header for this chip family, not hardware verified).";

        field {
            name = "lane_eol_1";
            desc = "[inferred] Lane eol 1. (vendor header `hi3519v101/mipi_reg.h` field `lane_eol_1`; access and reset unknown, modelled RW)";
            sw = rw;
            hw = r;
        } lane_eol_1[31:16];

        field {
            name = "lane_eol_0";
            desc = "[inferred] Lane eol 0. (vendor header `hi3519v101/mipi_reg.h` field `lane_eol_0`; access and reset unknown, modelled RW)";
            sw = rw;
            hw = r;
        } lane_eol_0[15:0];
    } LVDS1_LANE8_EOL_01 @ 0x2438;

    reg {
        name = "LVDS1 LANE8 EOL 23";
        desc = "[inferred] LVDS1 LANE8 EOL 23. Not in the data sheet. Source: OpenIPC openhisilicon `kernel/mipi_rx/hi3519v101/mipi_reg.h` (GPL-3.0 repository, HiSilicon copyright; local copy sources/openhisilicon), union `U_LVDS_LANE_EOL_23`, struct offset 0x243C (GPL-3.0 repository, HiSilicon copyright; one header for Hi3519 V101 and Hi3516A V200). Reset value and access type unknown (modelled RW, no reset). Confidence: medium (vendor header for this chip family, not hardware verified).";

        field {
            name = "lane_eol_3";
            desc = "[inferred] Lane eol 3. (vendor header `hi3519v101/mipi_reg.h` field `lane_eol_3`; access and reset unknown, modelled RW)";
            sw = rw;
            hw = r;
        } lane_eol_3[31:16];

        field {
            name = "lane_eol_2";
            desc = "[inferred] Lane eol 2. (vendor header `hi3519v101/mipi_reg.h` field `lane_eol_2`; access and reset unknown, modelled RW)";
            sw = rw;
            hw = r;
        } lane_eol_2[15:0];
    } LVDS1_LANE8_EOL_23 @ 0x243C;

    reg {
        name = "LVDS1 LANE9 SOF 01";
        desc = "[inferred] LVDS1 LANE9 SOF 01. Not in the data sheet. Source: OpenIPC openhisilicon `kernel/mipi_rx/hi3519v101/mipi_reg.h` (GPL-3.0 repository, HiSilicon copyright; local copy sources/openhisilicon), union `U_LVDS_LANE_SOF_01`, struct offset 0x2440 (GPL-3.0 repository, HiSilicon copyright; one header for Hi3519 V101 and Hi3516A V200). Reset value and access type unknown (modelled RW, no reset). Confidence: medium (vendor header for this chip family, not hardware verified).";

        field {
            name = "lane_sof_1";
            desc = "[inferred] Lane sof 1. (vendor header `hi3519v101/mipi_reg.h` field `lane_sof_1`; access and reset unknown, modelled RW)";
            sw = rw;
            hw = r;
        } lane_sof_1[31:16];

        field {
            name = "lane_sof_0";
            desc = "[inferred] Lane sof 0. (vendor header `hi3519v101/mipi_reg.h` field `lane_sof_0`; access and reset unknown, modelled RW)";
            sw = rw;
            hw = r;
        } lane_sof_0[15:0];
    } LVDS1_LANE9_SOF_01 @ 0x2440;

    reg {
        name = "LVDS1 LANE9 SOF 23";
        desc = "[inferred] LVDS1 LANE9 SOF 23. Not in the data sheet. Source: OpenIPC openhisilicon `kernel/mipi_rx/hi3519v101/mipi_reg.h` (GPL-3.0 repository, HiSilicon copyright; local copy sources/openhisilicon), union `U_LVDS_LANE_SOF_23`, struct offset 0x2444 (GPL-3.0 repository, HiSilicon copyright; one header for Hi3519 V101 and Hi3516A V200). Reset value and access type unknown (modelled RW, no reset). Confidence: medium (vendor header for this chip family, not hardware verified).";

        field {
            name = "lane_sof_3";
            desc = "[inferred] Lane sof 3. (vendor header `hi3519v101/mipi_reg.h` field `lane_sof_3`; access and reset unknown, modelled RW)";
            sw = rw;
            hw = r;
        } lane_sof_3[31:16];

        field {
            name = "lane_sof_2";
            desc = "[inferred] Lane sof 2. (vendor header `hi3519v101/mipi_reg.h` field `lane_sof_2`; access and reset unknown, modelled RW)";
            sw = rw;
            hw = r;
        } lane_sof_2[15:0];
    } LVDS1_LANE9_SOF_23 @ 0x2444;

    reg {
        name = "LVDS1 LANE9 EOF 01";
        desc = "[inferred] LVDS1 LANE9 EOF 01. Not in the data sheet. Source: OpenIPC openhisilicon `kernel/mipi_rx/hi3519v101/mipi_reg.h` (GPL-3.0 repository, HiSilicon copyright; local copy sources/openhisilicon), union `U_LVDS_LANE_EOF_01`, struct offset 0x2448 (GPL-3.0 repository, HiSilicon copyright; one header for Hi3519 V101 and Hi3516A V200). Reset value and access type unknown (modelled RW, no reset). Confidence: medium (vendor header for this chip family, not hardware verified).";

        field {
            name = "lane_eof_1";
            desc = "[inferred] Lane eof 1. (vendor header `hi3519v101/mipi_reg.h` field `lane_eof_1`; access and reset unknown, modelled RW)";
            sw = rw;
            hw = r;
        } lane_eof_1[31:16];

        field {
            name = "lane_eof_0";
            desc = "[inferred] Lane eof 0. (vendor header `hi3519v101/mipi_reg.h` field `lane_eof_0`; access and reset unknown, modelled RW)";
            sw = rw;
            hw = r;
        } lane_eof_0[15:0];
    } LVDS1_LANE9_EOF_01 @ 0x2448;

    reg {
        name = "LVDS1 LANE9 EOF 23";
        desc = "[inferred] LVDS1 LANE9 EOF 23. Not in the data sheet. Source: OpenIPC openhisilicon `kernel/mipi_rx/hi3519v101/mipi_reg.h` (GPL-3.0 repository, HiSilicon copyright; local copy sources/openhisilicon), union `U_LVDS_LANE_EOF_23`, struct offset 0x244C (GPL-3.0 repository, HiSilicon copyright; one header for Hi3519 V101 and Hi3516A V200). Reset value and access type unknown (modelled RW, no reset). Confidence: medium (vendor header for this chip family, not hardware verified).";

        field {
            name = "lane_eof_3";
            desc = "[inferred] Lane eof 3. (vendor header `hi3519v101/mipi_reg.h` field `lane_eof_3`; access and reset unknown, modelled RW)";
            sw = rw;
            hw = r;
        } lane_eof_3[31:16];

        field {
            name = "lane_eof_2";
            desc = "[inferred] Lane eof 2. (vendor header `hi3519v101/mipi_reg.h` field `lane_eof_2`; access and reset unknown, modelled RW)";
            sw = rw;
            hw = r;
        } lane_eof_2[15:0];
    } LVDS1_LANE9_EOF_23 @ 0x244C;

    reg {
        name = "LVDS1 LANE9 SOL 01";
        desc = "[inferred] LVDS1 LANE9 SOL 01. Not in the data sheet. Source: OpenIPC openhisilicon `kernel/mipi_rx/hi3519v101/mipi_reg.h` (GPL-3.0 repository, HiSilicon copyright; local copy sources/openhisilicon), union `U_LVDS_LANE_SOL_01`, struct offset 0x2450 (GPL-3.0 repository, HiSilicon copyright; one header for Hi3519 V101 and Hi3516A V200). Reset value and access type unknown (modelled RW, no reset). Confidence: medium (vendor header for this chip family, not hardware verified).";

        field {
            name = "lane_sol_1";
            desc = "[inferred] Lane sol 1. (vendor header `hi3519v101/mipi_reg.h` field `lane_sol_1`; access and reset unknown, modelled RW)";
            sw = rw;
            hw = r;
        } lane_sol_1[31:16];

        field {
            name = "lane_sol_0";
            desc = "[inferred] Lane sol 0. (vendor header `hi3519v101/mipi_reg.h` field `lane_sol_0`; access and reset unknown, modelled RW)";
            sw = rw;
            hw = r;
        } lane_sol_0[15:0];
    } LVDS1_LANE9_SOL_01 @ 0x2450;

    reg {
        name = "LVDS1 LANE9 SOL 23";
        desc = "[inferred] LVDS1 LANE9 SOL 23. Not in the data sheet. Source: OpenIPC openhisilicon `kernel/mipi_rx/hi3519v101/mipi_reg.h` (GPL-3.0 repository, HiSilicon copyright; local copy sources/openhisilicon), union `U_LVDS_LANE_SOL_23`, struct offset 0x2454 (GPL-3.0 repository, HiSilicon copyright; one header for Hi3519 V101 and Hi3516A V200). Reset value and access type unknown (modelled RW, no reset). Confidence: medium (vendor header for this chip family, not hardware verified).";

        field {
            name = "lane_sol_3";
            desc = "[inferred] Lane sol 3. (vendor header `hi3519v101/mipi_reg.h` field `lane_sol_3`; access and reset unknown, modelled RW)";
            sw = rw;
            hw = r;
        } lane_sol_3[31:16];

        field {
            name = "lane_sol_2";
            desc = "[inferred] Lane sol 2. (vendor header `hi3519v101/mipi_reg.h` field `lane_sol_2`; access and reset unknown, modelled RW)";
            sw = rw;
            hw = r;
        } lane_sol_2[15:0];
    } LVDS1_LANE9_SOL_23 @ 0x2454;

    reg {
        name = "LVDS1 LANE9 EOL 01";
        desc = "[inferred] LVDS1 LANE9 EOL 01. Not in the data sheet. Source: OpenIPC openhisilicon `kernel/mipi_rx/hi3519v101/mipi_reg.h` (GPL-3.0 repository, HiSilicon copyright; local copy sources/openhisilicon), union `U_LVDS_LANE_EOL_01`, struct offset 0x2458 (GPL-3.0 repository, HiSilicon copyright; one header for Hi3519 V101 and Hi3516A V200). Reset value and access type unknown (modelled RW, no reset). Confidence: medium (vendor header for this chip family, not hardware verified).";

        field {
            name = "lane_eol_1";
            desc = "[inferred] Lane eol 1. (vendor header `hi3519v101/mipi_reg.h` field `lane_eol_1`; access and reset unknown, modelled RW)";
            sw = rw;
            hw = r;
        } lane_eol_1[31:16];

        field {
            name = "lane_eol_0";
            desc = "[inferred] Lane eol 0. (vendor header `hi3519v101/mipi_reg.h` field `lane_eol_0`; access and reset unknown, modelled RW)";
            sw = rw;
            hw = r;
        } lane_eol_0[15:0];
    } LVDS1_LANE9_EOL_01 @ 0x2458;

    reg {
        name = "LVDS1 LANE9 EOL 23";
        desc = "[inferred] LVDS1 LANE9 EOL 23. Not in the data sheet. Source: OpenIPC openhisilicon `kernel/mipi_rx/hi3519v101/mipi_reg.h` (GPL-3.0 repository, HiSilicon copyright; local copy sources/openhisilicon), union `U_LVDS_LANE_EOL_23`, struct offset 0x245C (GPL-3.0 repository, HiSilicon copyright; one header for Hi3519 V101 and Hi3516A V200). Reset value and access type unknown (modelled RW, no reset). Confidence: medium (vendor header for this chip family, not hardware verified).";

        field {
            name = "lane_eol_3";
            desc = "[inferred] Lane eol 3. (vendor header `hi3519v101/mipi_reg.h` field `lane_eol_3`; access and reset unknown, modelled RW)";
            sw = rw;
            hw = r;
        } lane_eol_3[31:16];

        field {
            name = "lane_eol_2";
            desc = "[inferred] Lane eol 2. (vendor header `hi3519v101/mipi_reg.h` field `lane_eol_2`; access and reset unknown, modelled RW)";
            sw = rw;
            hw = r;
        } lane_eol_2[15:0];
    } LVDS1_LANE9_EOL_23 @ 0x245C;

    reg {
        name = "LVDS1 LANE10 SOF 01";
        desc = "[inferred] LVDS1 LANE10 SOF 01. Not in the data sheet. Source: OpenIPC openhisilicon `kernel/mipi_rx/hi3519v101/mipi_reg.h` (GPL-3.0 repository, HiSilicon copyright; local copy sources/openhisilicon), union `U_LVDS_LANE_SOF_01`, struct offset 0x2460 (GPL-3.0 repository, HiSilicon copyright; one header for Hi3519 V101 and Hi3516A V200). Reset value and access type unknown (modelled RW, no reset). Confidence: medium (vendor header for this chip family, not hardware verified).";

        field {
            name = "lane_sof_1";
            desc = "[inferred] Lane sof 1. (vendor header `hi3519v101/mipi_reg.h` field `lane_sof_1`; access and reset unknown, modelled RW)";
            sw = rw;
            hw = r;
        } lane_sof_1[31:16];

        field {
            name = "lane_sof_0";
            desc = "[inferred] Lane sof 0. (vendor header `hi3519v101/mipi_reg.h` field `lane_sof_0`; access and reset unknown, modelled RW)";
            sw = rw;
            hw = r;
        } lane_sof_0[15:0];
    } LVDS1_LANE10_SOF_01 @ 0x2460;

    reg {
        name = "LVDS1 LANE10 SOF 23";
        desc = "[inferred] LVDS1 LANE10 SOF 23. Not in the data sheet. Source: OpenIPC openhisilicon `kernel/mipi_rx/hi3519v101/mipi_reg.h` (GPL-3.0 repository, HiSilicon copyright; local copy sources/openhisilicon), union `U_LVDS_LANE_SOF_23`, struct offset 0x2464 (GPL-3.0 repository, HiSilicon copyright; one header for Hi3519 V101 and Hi3516A V200). Reset value and access type unknown (modelled RW, no reset). Confidence: medium (vendor header for this chip family, not hardware verified).";

        field {
            name = "lane_sof_3";
            desc = "[inferred] Lane sof 3. (vendor header `hi3519v101/mipi_reg.h` field `lane_sof_3`; access and reset unknown, modelled RW)";
            sw = rw;
            hw = r;
        } lane_sof_3[31:16];

        field {
            name = "lane_sof_2";
            desc = "[inferred] Lane sof 2. (vendor header `hi3519v101/mipi_reg.h` field `lane_sof_2`; access and reset unknown, modelled RW)";
            sw = rw;
            hw = r;
        } lane_sof_2[15:0];
    } LVDS1_LANE10_SOF_23 @ 0x2464;

    reg {
        name = "LVDS1 LANE10 EOF 01";
        desc = "[inferred] LVDS1 LANE10 EOF 01. Not in the data sheet. Source: OpenIPC openhisilicon `kernel/mipi_rx/hi3519v101/mipi_reg.h` (GPL-3.0 repository, HiSilicon copyright; local copy sources/openhisilicon), union `U_LVDS_LANE_EOF_01`, struct offset 0x2468 (GPL-3.0 repository, HiSilicon copyright; one header for Hi3519 V101 and Hi3516A V200). Reset value and access type unknown (modelled RW, no reset). Confidence: medium (vendor header for this chip family, not hardware verified).";

        field {
            name = "lane_eof_1";
            desc = "[inferred] Lane eof 1. (vendor header `hi3519v101/mipi_reg.h` field `lane_eof_1`; access and reset unknown, modelled RW)";
            sw = rw;
            hw = r;
        } lane_eof_1[31:16];

        field {
            name = "lane_eof_0";
            desc = "[inferred] Lane eof 0. (vendor header `hi3519v101/mipi_reg.h` field `lane_eof_0`; access and reset unknown, modelled RW)";
            sw = rw;
            hw = r;
        } lane_eof_0[15:0];
    } LVDS1_LANE10_EOF_01 @ 0x2468;

    reg {
        name = "LVDS1 LANE10 EOF 23";
        desc = "[inferred] LVDS1 LANE10 EOF 23. Not in the data sheet. Source: OpenIPC openhisilicon `kernel/mipi_rx/hi3519v101/mipi_reg.h` (GPL-3.0 repository, HiSilicon copyright; local copy sources/openhisilicon), union `U_LVDS_LANE_EOF_23`, struct offset 0x246C (GPL-3.0 repository, HiSilicon copyright; one header for Hi3519 V101 and Hi3516A V200). Reset value and access type unknown (modelled RW, no reset). Confidence: medium (vendor header for this chip family, not hardware verified).";

        field {
            name = "lane_eof_3";
            desc = "[inferred] Lane eof 3. (vendor header `hi3519v101/mipi_reg.h` field `lane_eof_3`; access and reset unknown, modelled RW)";
            sw = rw;
            hw = r;
        } lane_eof_3[31:16];

        field {
            name = "lane_eof_2";
            desc = "[inferred] Lane eof 2. (vendor header `hi3519v101/mipi_reg.h` field `lane_eof_2`; access and reset unknown, modelled RW)";
            sw = rw;
            hw = r;
        } lane_eof_2[15:0];
    } LVDS1_LANE10_EOF_23 @ 0x246C;

    reg {
        name = "LVDS1 LANE10 SOL 01";
        desc = "[inferred] LVDS1 LANE10 SOL 01. Not in the data sheet. Source: OpenIPC openhisilicon `kernel/mipi_rx/hi3519v101/mipi_reg.h` (GPL-3.0 repository, HiSilicon copyright; local copy sources/openhisilicon), union `U_LVDS_LANE_SOL_01`, struct offset 0x2470 (GPL-3.0 repository, HiSilicon copyright; one header for Hi3519 V101 and Hi3516A V200). Reset value and access type unknown (modelled RW, no reset). Confidence: medium (vendor header for this chip family, not hardware verified).";

        field {
            name = "lane_sol_1";
            desc = "[inferred] Lane sol 1. (vendor header `hi3519v101/mipi_reg.h` field `lane_sol_1`; access and reset unknown, modelled RW)";
            sw = rw;
            hw = r;
        } lane_sol_1[31:16];

        field {
            name = "lane_sol_0";
            desc = "[inferred] Lane sol 0. (vendor header `hi3519v101/mipi_reg.h` field `lane_sol_0`; access and reset unknown, modelled RW)";
            sw = rw;
            hw = r;
        } lane_sol_0[15:0];
    } LVDS1_LANE10_SOL_01 @ 0x2470;

    reg {
        name = "LVDS1 LANE10 SOL 23";
        desc = "[inferred] LVDS1 LANE10 SOL 23. Not in the data sheet. Source: OpenIPC openhisilicon `kernel/mipi_rx/hi3519v101/mipi_reg.h` (GPL-3.0 repository, HiSilicon copyright; local copy sources/openhisilicon), union `U_LVDS_LANE_SOL_23`, struct offset 0x2474 (GPL-3.0 repository, HiSilicon copyright; one header for Hi3519 V101 and Hi3516A V200). Reset value and access type unknown (modelled RW, no reset). Confidence: medium (vendor header for this chip family, not hardware verified).";

        field {
            name = "lane_sol_3";
            desc = "[inferred] Lane sol 3. (vendor header `hi3519v101/mipi_reg.h` field `lane_sol_3`; access and reset unknown, modelled RW)";
            sw = rw;
            hw = r;
        } lane_sol_3[31:16];

        field {
            name = "lane_sol_2";
            desc = "[inferred] Lane sol 2. (vendor header `hi3519v101/mipi_reg.h` field `lane_sol_2`; access and reset unknown, modelled RW)";
            sw = rw;
            hw = r;
        } lane_sol_2[15:0];
    } LVDS1_LANE10_SOL_23 @ 0x2474;

    reg {
        name = "LVDS1 LANE10 EOL 01";
        desc = "[inferred] LVDS1 LANE10 EOL 01. Not in the data sheet. Source: OpenIPC openhisilicon `kernel/mipi_rx/hi3519v101/mipi_reg.h` (GPL-3.0 repository, HiSilicon copyright; local copy sources/openhisilicon), union `U_LVDS_LANE_EOL_01`, struct offset 0x2478 (GPL-3.0 repository, HiSilicon copyright; one header for Hi3519 V101 and Hi3516A V200). Reset value and access type unknown (modelled RW, no reset). Confidence: medium (vendor header for this chip family, not hardware verified).";

        field {
            name = "lane_eol_1";
            desc = "[inferred] Lane eol 1. (vendor header `hi3519v101/mipi_reg.h` field `lane_eol_1`; access and reset unknown, modelled RW)";
            sw = rw;
            hw = r;
        } lane_eol_1[31:16];

        field {
            name = "lane_eol_0";
            desc = "[inferred] Lane eol 0. (vendor header `hi3519v101/mipi_reg.h` field `lane_eol_0`; access and reset unknown, modelled RW)";
            sw = rw;
            hw = r;
        } lane_eol_0[15:0];
    } LVDS1_LANE10_EOL_01 @ 0x2478;

    reg {
        name = "LVDS1 LANE10 EOL 23";
        desc = "[inferred] LVDS1 LANE10 EOL 23. Not in the data sheet. Source: OpenIPC openhisilicon `kernel/mipi_rx/hi3519v101/mipi_reg.h` (GPL-3.0 repository, HiSilicon copyright; local copy sources/openhisilicon), union `U_LVDS_LANE_EOL_23`, struct offset 0x247C (GPL-3.0 repository, HiSilicon copyright; one header for Hi3519 V101 and Hi3516A V200). Reset value and access type unknown (modelled RW, no reset). Confidence: medium (vendor header for this chip family, not hardware verified).";

        field {
            name = "lane_eol_3";
            desc = "[inferred] Lane eol 3. (vendor header `hi3519v101/mipi_reg.h` field `lane_eol_3`; access and reset unknown, modelled RW)";
            sw = rw;
            hw = r;
        } lane_eol_3[31:16];

        field {
            name = "lane_eol_2";
            desc = "[inferred] Lane eol 2. (vendor header `hi3519v101/mipi_reg.h` field `lane_eol_2`; access and reset unknown, modelled RW)";
            sw = rw;
            hw = r;
        } lane_eol_2[15:0];
    } LVDS1_LANE10_EOL_23 @ 0x247C;

    reg {
        name = "LVDS1 LANE11 SOF 01";
        desc = "[inferred] LVDS1 LANE11 SOF 01. Not in the data sheet. Source: OpenIPC openhisilicon `kernel/mipi_rx/hi3519v101/mipi_reg.h` (GPL-3.0 repository, HiSilicon copyright; local copy sources/openhisilicon), union `U_LVDS_LANE_SOF_01`, struct offset 0x2480 (GPL-3.0 repository, HiSilicon copyright; one header for Hi3519 V101 and Hi3516A V200). Reset value and access type unknown (modelled RW, no reset). Confidence: medium (vendor header for this chip family, not hardware verified).";

        field {
            name = "lane_sof_1";
            desc = "[inferred] Lane sof 1. (vendor header `hi3519v101/mipi_reg.h` field `lane_sof_1`; access and reset unknown, modelled RW)";
            sw = rw;
            hw = r;
        } lane_sof_1[31:16];

        field {
            name = "lane_sof_0";
            desc = "[inferred] Lane sof 0. (vendor header `hi3519v101/mipi_reg.h` field `lane_sof_0`; access and reset unknown, modelled RW)";
            sw = rw;
            hw = r;
        } lane_sof_0[15:0];
    } LVDS1_LANE11_SOF_01 @ 0x2480;

    reg {
        name = "LVDS1 LANE11 SOF 23";
        desc = "[inferred] LVDS1 LANE11 SOF 23. Not in the data sheet. Source: OpenIPC openhisilicon `kernel/mipi_rx/hi3519v101/mipi_reg.h` (GPL-3.0 repository, HiSilicon copyright; local copy sources/openhisilicon), union `U_LVDS_LANE_SOF_23`, struct offset 0x2484 (GPL-3.0 repository, HiSilicon copyright; one header for Hi3519 V101 and Hi3516A V200). Reset value and access type unknown (modelled RW, no reset). Confidence: medium (vendor header for this chip family, not hardware verified).";

        field {
            name = "lane_sof_3";
            desc = "[inferred] Lane sof 3. (vendor header `hi3519v101/mipi_reg.h` field `lane_sof_3`; access and reset unknown, modelled RW)";
            sw = rw;
            hw = r;
        } lane_sof_3[31:16];

        field {
            name = "lane_sof_2";
            desc = "[inferred] Lane sof 2. (vendor header `hi3519v101/mipi_reg.h` field `lane_sof_2`; access and reset unknown, modelled RW)";
            sw = rw;
            hw = r;
        } lane_sof_2[15:0];
    } LVDS1_LANE11_SOF_23 @ 0x2484;

    reg {
        name = "LVDS1 LANE11 EOF 01";
        desc = "[inferred] LVDS1 LANE11 EOF 01. Not in the data sheet. Source: OpenIPC openhisilicon `kernel/mipi_rx/hi3519v101/mipi_reg.h` (GPL-3.0 repository, HiSilicon copyright; local copy sources/openhisilicon), union `U_LVDS_LANE_EOF_01`, struct offset 0x2488 (GPL-3.0 repository, HiSilicon copyright; one header for Hi3519 V101 and Hi3516A V200). Reset value and access type unknown (modelled RW, no reset). Confidence: medium (vendor header for this chip family, not hardware verified).";

        field {
            name = "lane_eof_1";
            desc = "[inferred] Lane eof 1. (vendor header `hi3519v101/mipi_reg.h` field `lane_eof_1`; access and reset unknown, modelled RW)";
            sw = rw;
            hw = r;
        } lane_eof_1[31:16];

        field {
            name = "lane_eof_0";
            desc = "[inferred] Lane eof 0. (vendor header `hi3519v101/mipi_reg.h` field `lane_eof_0`; access and reset unknown, modelled RW)";
            sw = rw;
            hw = r;
        } lane_eof_0[15:0];
    } LVDS1_LANE11_EOF_01 @ 0x2488;

    reg {
        name = "LVDS1 LANE11 EOF 23";
        desc = "[inferred] LVDS1 LANE11 EOF 23. Not in the data sheet. Source: OpenIPC openhisilicon `kernel/mipi_rx/hi3519v101/mipi_reg.h` (GPL-3.0 repository, HiSilicon copyright; local copy sources/openhisilicon), union `U_LVDS_LANE_EOF_23`, struct offset 0x248C (GPL-3.0 repository, HiSilicon copyright; one header for Hi3519 V101 and Hi3516A V200). Reset value and access type unknown (modelled RW, no reset). Confidence: medium (vendor header for this chip family, not hardware verified).";

        field {
            name = "lane_eof_3";
            desc = "[inferred] Lane eof 3. (vendor header `hi3519v101/mipi_reg.h` field `lane_eof_3`; access and reset unknown, modelled RW)";
            sw = rw;
            hw = r;
        } lane_eof_3[31:16];

        field {
            name = "lane_eof_2";
            desc = "[inferred] Lane eof 2. (vendor header `hi3519v101/mipi_reg.h` field `lane_eof_2`; access and reset unknown, modelled RW)";
            sw = rw;
            hw = r;
        } lane_eof_2[15:0];
    } LVDS1_LANE11_EOF_23 @ 0x248C;

    reg {
        name = "LVDS1 LANE11 SOL 01";
        desc = "[inferred] LVDS1 LANE11 SOL 01. Not in the data sheet. Source: OpenIPC openhisilicon `kernel/mipi_rx/hi3519v101/mipi_reg.h` (GPL-3.0 repository, HiSilicon copyright; local copy sources/openhisilicon), union `U_LVDS_LANE_SOL_01`, struct offset 0x2490 (GPL-3.0 repository, HiSilicon copyright; one header for Hi3519 V101 and Hi3516A V200). Reset value and access type unknown (modelled RW, no reset). Confidence: medium (vendor header for this chip family, not hardware verified).";

        field {
            name = "lane_sol_1";
            desc = "[inferred] Lane sol 1. (vendor header `hi3519v101/mipi_reg.h` field `lane_sol_1`; access and reset unknown, modelled RW)";
            sw = rw;
            hw = r;
        } lane_sol_1[31:16];

        field {
            name = "lane_sol_0";
            desc = "[inferred] Lane sol 0. (vendor header `hi3519v101/mipi_reg.h` field `lane_sol_0`; access and reset unknown, modelled RW)";
            sw = rw;
            hw = r;
        } lane_sol_0[15:0];
    } LVDS1_LANE11_SOL_01 @ 0x2490;

    reg {
        name = "LVDS1 LANE11 SOL 23";
        desc = "[inferred] LVDS1 LANE11 SOL 23. Not in the data sheet. Source: OpenIPC openhisilicon `kernel/mipi_rx/hi3519v101/mipi_reg.h` (GPL-3.0 repository, HiSilicon copyright; local copy sources/openhisilicon), union `U_LVDS_LANE_SOL_23`, struct offset 0x2494 (GPL-3.0 repository, HiSilicon copyright; one header for Hi3519 V101 and Hi3516A V200). Reset value and access type unknown (modelled RW, no reset). Confidence: medium (vendor header for this chip family, not hardware verified).";

        field {
            name = "lane_sol_3";
            desc = "[inferred] Lane sol 3. (vendor header `hi3519v101/mipi_reg.h` field `lane_sol_3`; access and reset unknown, modelled RW)";
            sw = rw;
            hw = r;
        } lane_sol_3[31:16];

        field {
            name = "lane_sol_2";
            desc = "[inferred] Lane sol 2. (vendor header `hi3519v101/mipi_reg.h` field `lane_sol_2`; access and reset unknown, modelled RW)";
            sw = rw;
            hw = r;
        } lane_sol_2[15:0];
    } LVDS1_LANE11_SOL_23 @ 0x2494;

    reg {
        name = "LVDS1 LANE11 EOL 01";
        desc = "[inferred] LVDS1 LANE11 EOL 01. Not in the data sheet. Source: OpenIPC openhisilicon `kernel/mipi_rx/hi3519v101/mipi_reg.h` (GPL-3.0 repository, HiSilicon copyright; local copy sources/openhisilicon), union `U_LVDS_LANE_EOL_01`, struct offset 0x2498 (GPL-3.0 repository, HiSilicon copyright; one header for Hi3519 V101 and Hi3516A V200). Reset value and access type unknown (modelled RW, no reset). Confidence: medium (vendor header for this chip family, not hardware verified).";

        field {
            name = "lane_eol_1";
            desc = "[inferred] Lane eol 1. (vendor header `hi3519v101/mipi_reg.h` field `lane_eol_1`; access and reset unknown, modelled RW)";
            sw = rw;
            hw = r;
        } lane_eol_1[31:16];

        field {
            name = "lane_eol_0";
            desc = "[inferred] Lane eol 0. (vendor header `hi3519v101/mipi_reg.h` field `lane_eol_0`; access and reset unknown, modelled RW)";
            sw = rw;
            hw = r;
        } lane_eol_0[15:0];
    } LVDS1_LANE11_EOL_01 @ 0x2498;

    reg {
        name = "LVDS1 LANE11 EOL 23";
        desc = "[inferred] LVDS1 LANE11 EOL 23. Not in the data sheet. Source: OpenIPC openhisilicon `kernel/mipi_rx/hi3519v101/mipi_reg.h` (GPL-3.0 repository, HiSilicon copyright; local copy sources/openhisilicon), union `U_LVDS_LANE_EOL_23`, struct offset 0x249C (GPL-3.0 repository, HiSilicon copyright; one header for Hi3519 V101 and Hi3516A V200). Reset value and access type unknown (modelled RW, no reset). Confidence: medium (vendor header for this chip family, not hardware verified).";

        field {
            name = "lane_eol_3";
            desc = "[inferred] Lane eol 3. (vendor header `hi3519v101/mipi_reg.h` field `lane_eol_3`; access and reset unknown, modelled RW)";
            sw = rw;
            hw = r;
        } lane_eol_3[31:16];

        field {
            name = "lane_eol_2";
            desc = "[inferred] Lane eol 2. (vendor header `hi3519v101/mipi_reg.h` field `lane_eol_2`; access and reset unknown, modelled RW)";
            sw = rw;
            hw = r;
        } lane_eol_2[15:0];
    } LVDS1_LANE11_EOL_23 @ 0x249C;

    reg {
        name = "Lane 0 SOF synchronization code NE0_NXT_S configuration register for frame (N + 1) in OF_01 LVDS or HiSPi mode";
        desc = "LVDS1_LANE0_NXT_SOF_01 is a lane 0 SOF synchronization code configuration register for frame (N + 1) in LVDS or HiSPi mode.

Data sheet 9.3.6 LVDS1_LANE0_NXT_SOF_01 (offset 0x24A0, printed page 9-448, `hi3516av200--Hi3516AV200-Datasheet.txt` line 63722).";

        field {
            name = "lvds1_lane0_nxt_sof_1";
            desc = "Lane 0 SOF synchronization code of frame 1 in LVDS or HiSPi mode This field is configurable only in WDR mode, and the configuration is invalid in linear mode.";
            sw = rw;
            hw = r;
            reset = 0x0;
        } lvds1_lane0_nxt_sof_1[31:16];

        field {
            name = "lvds1_lane0_nxt_sof_0";
            desc = "Lane 0 SOF synchronization code of frame 0 in LVDS or HiSPi mode In WDR mode, the value is the SOF of frame 0. In linear mode, the value is the SOF.";
            sw = rw;
            hw = r;
            reset = 0x0;
        } lvds1_lane0_nxt_sof_0[15:0];
    } LVDS1_LANE0_NXT_SOF_01 @ 0x24A0;

    reg {
        name = "Lane 0 SOF synchronization code NE0_NXT_S configuration register for frame (N + 1) in OF_23 LVDS or HiSPi mode";
        desc = "LVDS1_LANE0_NXT_SOF_23 is a lane 0 SOF synchronization code configuration register for frame (N + 1) in LVDS or HiSPi mode. Hi3516A V200 Professional HD IP Camera SoC

Data sheet 9.3.6 LVDS1_LANE0_NXT_SOF_23 (offset 0x24A4, printed page 9-449, `hi3516av200--Hi3516AV200-Datasheet.txt` line 63760).";

        field {
            name = "lvds1_lane0_nxt_sof_3";
            desc = "Lane 0 SOF synchronization code of frame 3 in LVDS or HiSPi mode This field is configurable only in WDR mode, and the configuration is invalid in linear mode.";
            sw = rw;
            hw = r;
            reset = 0x0;
        } lvds1_lane0_nxt_sof_3[31:16];

        field {
            name = "lvds1_lane0_nxt_sof_2";
            desc = "Lane 0 SOF synchronization code of frame 2 in LVDS or HiSPi mode This field is configurable only in WDR mode, and the configuration is invalid in linear mode.";
            sw = rw;
            hw = r;
            reset = 0x0;
        } lvds1_lane0_nxt_sof_2[15:0];
    } LVDS1_LANE0_NXT_SOF_23 @ 0x24A4;

    reg {
        name = "Lane 0 EOF synchronization code NE0_NXT_E configuration register for frame (N + 1) in OF_01 LVDS or HiSPi mode";
        desc = "LVDS1_LANE0_NXT_EOF_01 is a lane 0 EOF synchronization code configuration register for frame (N + 1) in LVDS or HiSPi mode.

Data sheet 9.3.6 LVDS1_LANE0_NXT_EOF_01 (offset 0x24A8, printed page 9-449, `hi3516av200--Hi3516AV200-Datasheet.txt` line 63788).";

        field {
            name = "lvds1_lane0_nxt_eof_1";
            desc = "Lane 0 EOF synchronization code of frame 1 in LVDS or HiSPi mode This field is configurable only in WDR mode, and the configuration is invalid in linear mode.";
            sw = rw;
            hw = r;
            reset = 0x0;
        } lvds1_lane0_nxt_eof_1[31:16];

        field {
            name = "lvds1_lane0_nxt_eof_0";
            desc = "Lane 0 EOF synchronization code of frame 0 in LVDS or HiSPi mode In WDR mode, the value is the EOF of frame 0. In linear mode, the value is the EOF.";
            sw = rw;
            hw = r;
            reset = 0x0;
        } lvds1_lane0_nxt_eof_0[15:0];
    } LVDS1_LANE0_NXT_EOF_01 @ 0x24A8;

    reg {
        name = "Lane 0 EOF synchronization code NE0_NXT_E configuration register for frame (N + 1) in OF_23 LVDS or HiSPi mode";
        desc = "LVDS1_LANE0_NXT_EOF_23 is a lane 0 EOF synchronization code configuration register for frame (N + 1) in LVDS or HiSPi mode. Hi3516A V200 Professional HD IP Camera SoC

Data sheet 9.3.6 LVDS1_LANE0_NXT_EOF_23 (offset 0x24AC, printed page 9-450, `hi3516av200--Hi3516AV200-Datasheet.txt` line 63826).";

        field {
            name = "lvds1_lane0_nxt_eof_3";
            desc = "Lane 0 EOF synchronization code of frame 3 in LVDS or HiSPi mode This field is configurable only in WDR mode, and the configuration is invalid in linear mode.";
            sw = rw;
            hw = r;
            reset = 0x0;
        } lvds1_lane0_nxt_eof_3[31:16];

        field {
            name = "lvds1_lane0_nxt_eof_2";
            desc = "Lane 0 EOF synchronization code of frame 2 in LVDS or HiSPi mode This field is configurable only in WDR mode, and the configuration is invalid in linear mode.";
            sw = rw;
            hw = r;
            reset = 0x0;
        } lvds1_lane0_nxt_eof_2[15:0];
    } LVDS1_LANE0_NXT_EOF_23 @ 0x24AC;

    reg {
        name = "Lane 0 SOL synchronization code NE0_NXT_S configuration register for frame (N + 1) in OL_01 LVDS or HiSPi mode";
        desc = "LVDS1_LANE0_NXT_SOL_01 is a lane 0 SOL synchronization code configuration register for frame (N + 1) in LVDS or HiSPi mode.

Data sheet 9.3.6 LVDS1_LANE0_NXT_SOL_01 (offset 0x24B0, printed page 9-450, `hi3516av200--Hi3516AV200-Datasheet.txt` line 63854).";

        field {
            name = "lvds1_lane0_nxt_sol_1";
            desc = "Lane 0 SOL synchronization code of frame 1 in LVDS or HiSPi mode This field is configurable only in WDR mode, and the configuration is invalid in linear mode.";
            sw = rw;
            hw = r;
            reset = 0x0;
        } lvds1_lane0_nxt_sol_1[31:16];

        field {
            name = "lvds1_lane0_nxt_sol_0";
            desc = "Lane 0 SOL synchronization code of frame 0 in LVDS or HiSPi mode In WDR mode, the value is the SOL of frame 0. In linear mode, the value is the SOL.";
            sw = rw;
            hw = r;
            reset = 0x0;
        } lvds1_lane0_nxt_sol_0[15:0];
    } LVDS1_LANE0_NXT_SOL_01 @ 0x24B0;

    reg {
        name = "Lane 0 SOL synchronization code NE0_NXT_S configuration register for frame (N + 1) in OL_23 LVDS or HiSPi mode";
        desc = "LVDS1_LANE0_NXT_SOL_23 is a lane 0 SOL synchronization code configuration register for frame (N + 1) in LVDS or HiSPi mode. Hi3516A V200 Professional HD IP Camera SoC

Data sheet 9.3.6 LVDS1_LANE0_NXT_SOL_23 (offset 0x24B4, printed page 9-451, `hi3516av200--Hi3516AV200-Datasheet.txt` line 63892).";

        field {
            name = "lvds1_lane0_nxt_sol_3";
            desc = "Lane 0 SOL synchronization code of frame 3 in LVDS or HiSPi mode This field is configurable only in WDR mode, and the configuration is invalid in linear mode.";
            sw = rw;
            hw = r;
            reset = 0x0;
        } lvds1_lane0_nxt_sol_3[31:16];

        field {
            name = "lvds1_lane0_nxt_sol_2";
            desc = "Lane 0 SOL synchronization code of frame 2 in LVDS or HiSPi mode This field is configurable only in WDR mode, and the configuration is invalid in linear mode.";
            sw = rw;
            hw = r;
            reset = 0x0;
        } lvds1_lane0_nxt_sol_2[15:0];
    } LVDS1_LANE0_NXT_SOL_23 @ 0x24B4;

    reg {
        name = "Lane 0 EOL synchronization code NE0_NXT_E configuration register for frame (N + 1) in OL_01 LVDS or HiSPi mode";
        desc = "LVDS1_LANE0_NXT_EOL_01 is a lane 0 EOL synchronization code configuration register for frame (N + 1) in LVDS or HiSPi mode.

Data sheet 9.3.6 LVDS1_LANE0_NXT_EOL_01 (offset 0x24B8, printed page 9-451, `hi3516av200--Hi3516AV200-Datasheet.txt` line 63920).";

        field {
            name = "lvds1_lane0_nxt_eol_1";
            desc = "Lane 0 EOL synchronization code of frame 1 in LVDS or HiSPi mode This field is configurable only in WDR mode, and the configuration is invalid in linear mode.";
            sw = rw;
            hw = r;
            reset = 0x0;
        } lvds1_lane0_nxt_eol_1[31:16];

        field {
            name = "lvds1_lane0_nxt_eol_0";
            desc = "Lane 0 EOL synchronization code of frame 0 in LVDS or HiSPi mode In WDR mode, the value is the EOL of frame 0. In linear mode, the value is the EOL.";
            sw = rw;
            hw = r;
            reset = 0x0;
        } lvds1_lane0_nxt_eol_0[15:0];
    } LVDS1_LANE0_NXT_EOL_01 @ 0x24B8;

    reg {
        name = "Lane 0 EOL synchronization code NE0_NXT_E configuration register for frame (N + 1) in OL_23 LVDS or HiSPi mode";
        desc = "LVDS1_LANE0_NXT_EOL_23 is a lane 0 EOL synchronization code configuration register for frame (N + 1) in LVDS or HiSPi mode. Hi3516A V200 Professional HD IP Camera SoC

Data sheet 9.3.6 LVDS1_LANE0_NXT_EOL_23 (offset 0x24BC, printed page 9-452, `hi3516av200--Hi3516AV200-Datasheet.txt` line 63958).";

        field {
            name = "lvds1_lane0_nxt_eol_3";
            desc = "Lane 0 EOL synchronization code of frame 3 in LVDS or HiSPi mode This field is configurable only in WDR mode, and the configuration is invalid in linear mode.";
            sw = rw;
            hw = r;
            reset = 0x0;
        } lvds1_lane0_nxt_eol_3[31:16];

        field {
            name = "lvds1_lane0_nxt_eol_2";
            desc = "Lane 0 EOL synchronization code of frame 2 in LVDS or HiSPi mode This field is configurable only in WDR mode, and the configuration is invalid in linear mode.";
            sw = rw;
            hw = r;
            reset = 0x0;
        } lvds1_lane0_nxt_eol_2[15:0];
    } LVDS1_LANE0_NXT_EOL_23 @ 0x24BC;

    reg {
        name = "Lane 1 SOF synchronization code NE1_NXT_S configuration register for frame (N + 1) in OF_01 LVDS or HiSPi mode";
        desc = "LVDS1_LANE1_NXT_SOF_01 is a lane 1 SOF synchronization code configuration register for frame (N + 1) in LVDS or HiSPi mode.

Data sheet 9.3.6 LVDS1_LANE1_NXT_SOF_01 (offset 0x24C0, printed page 9-452, `hi3516av200--Hi3516AV200-Datasheet.txt` line 63986).";

        field {
            name = "lvds1_lane1_nxt_sof_1";
            desc = "Lane 1 SOF synchronization code of frame 1 in LVDS or HiSPi mode This field is configurable only in WDR mode, and the configuration is invalid in linear mode.";
            sw = rw;
            hw = r;
            reset = 0x0;
        } lvds1_lane1_nxt_sof_1[31:16];

        field {
            name = "lvds1_lane1_nxt_sof_0";
            desc = "Lane 1 SOF synchronization code of frame 0 in LVDS or HiSPi mode In WDR mode, the value is the SOF of frame 0. In linear mode, the value is the SOF.";
            sw = rw;
            hw = r;
            reset = 0x0;
        } lvds1_lane1_nxt_sof_0[15:0];
    } LVDS1_LANE1_NXT_SOF_01 @ 0x24C0;

    reg {
        name = "Lane 1 SOF synchronization code NE1_NXT_S configuration register for frame (N + 1) in OF_23 LVDS or HiSPi mode";
        desc = "LVDS1_LANE1_NXT_SOF_23 is a lane 1 SOF synchronization code configuration register for frame (N + 1) in LVDS or HiSPi mode. Hi3516A V200 Professional HD IP Camera SoC

Data sheet 9.3.6 LVDS1_LANE1_NXT_SOF_23 (offset 0x24C4, printed page 9-453, `hi3516av200--Hi3516AV200-Datasheet.txt` line 64024).";

        field {
            name = "lvds1_lane1_nxt_sof_3";
            desc = "Lane 1 SOF synchronization code of frame 3 in LVDS or HiSPi mode This field is configurable only in WDR mode, and the configuration is invalid in linear mode.";
            sw = rw;
            hw = r;
            reset = 0x0;
        } lvds1_lane1_nxt_sof_3[31:16];

        field {
            name = "lvds1_lane1_nxt_sof_2";
            desc = "Lane 1 SOF synchronization code of frame 2 in LVDS or HiSPi mode This field is configurable only in WDR mode, and the configuration is invalid in linear mode.";
            sw = rw;
            hw = r;
            reset = 0x0;
        } lvds1_lane1_nxt_sof_2[15:0];
    } LVDS1_LANE1_NXT_SOF_23 @ 0x24C4;

    reg {
        name = "Lane 1 EOF synchronization code NE1_NXT_E configuration register for frame (N + 1) in OF_01 LVDS or HiSPi mode";
        desc = "LVDS1_LANE1_NXT_EOF_01 is a lane 1 EOF synchronization code configuration register for frame (N + 1) in LVDS or HiSPi mode.

Data sheet 9.3.6 LVDS1_LANE1_NXT_EOF_01 (offset 0x24C8, printed page 9-453, `hi3516av200--Hi3516AV200-Datasheet.txt` line 64052).";

        field {
            name = "lvds1_lane1_nxt_eof_1";
            desc = "Lane 1 EOF synchronization code of frame 1 in LVDS or HiSPi mode This field is configurable only in WDR mode, and the configuration is invalid in linear mode.";
            sw = rw;
            hw = r;
            reset = 0x0;
        } lvds1_lane1_nxt_eof_1[31:16];

        field {
            name = "lvds1_lane1_nxt_eof_0";
            desc = "Lane 1 EOF synchronization code of frame 0 in LVDS or HiSPi mode In WDR mode, the value is the EOF of frame 0. In linear mode, the value is the EOF.";
            sw = rw;
            hw = r;
            reset = 0x0;
        } lvds1_lane1_nxt_eof_0[15:0];
    } LVDS1_LANE1_NXT_EOF_01 @ 0x24C8;

    reg {
        name = "Lane 1 EOF synchronization code NE1_NXT_E configuration register for frame (N + 1) in OF_23 LVDS or HiSPi mode";
        desc = "LVDS1_LANE1_NXT_EOF_23 is a lane 1 EOF synchronization code configuration register for frame (N + 1) in LVDS or HiSPi mode. Hi3516A V200 Professional HD IP Camera SoC

Data sheet 9.3.6 LVDS1_LANE1_NXT_EOF_23 (offset 0x24CC, printed page 9-454, `hi3516av200--Hi3516AV200-Datasheet.txt` line 64090).";

        field {
            name = "lvds1_lane1_nxt_eof_3";
            desc = "Lane 1 EOF synchronization code of frame 3 in LVDS or HiSPi mode This field is configurable only in WDR mode, and the configuration is invalid in linear mode.";
            sw = rw;
            hw = r;
            reset = 0x0;
        } lvds1_lane1_nxt_eof_3[31:16];

        field {
            name = "lvds1_lane1_nxt_eof_2";
            desc = "Lane 1 EOF synchronization code of frame 2 in LVDS or HiSPi mode This field is configurable only in WDR mode, and the configuration is invalid in linear mode.";
            sw = rw;
            hw = r;
            reset = 0x0;
        } lvds1_lane1_nxt_eof_2[15:0];
    } LVDS1_LANE1_NXT_EOF_23 @ 0x24CC;

    reg {
        name = "Lane 1 SOL synchronization code NE1_NXT_S configuration register for frame (N + 1) in OL_01 LVDS or HiSPi mode";
        desc = "LVDS1_LANE1_NXT_SOL_01 is a lane 1 SOL synchronization code configuration register for frame (N + 1) in LVDS or HiSPi mode.

Data sheet 9.3.6 LVDS1_LANE1_NXT_SOL_01 (offset 0x24D0, printed page 9-454, `hi3516av200--Hi3516AV200-Datasheet.txt` line 64118).";

        field {
            name = "lvds1_lane1_nxt_sol_1";
            desc = "Lane 1 SOL synchronization code of frame 1 in LVDS or HiSPi mode This field is configurable only in WDR mode, and the configuration is invalid in linear mode.";
            sw = rw;
            hw = r;
            reset = 0x0;
        } lvds1_lane1_nxt_sol_1[31:16];

        field {
            name = "lvds1_lane1_nxt_sol_0";
            desc = "Lane 1 SOL synchronization code of frame 0 in LVDS or HiSPi mode In WDR mode, the value is the SOL of frame 0. In linear mode, the value is the SOL.";
            sw = rw;
            hw = r;
            reset = 0x0;
        } lvds1_lane1_nxt_sol_0[15:0];
    } LVDS1_LANE1_NXT_SOL_01 @ 0x24D0;

    reg {
        name = "Lane 1 SOL synchronization code NE1_NXT_S configuration register for frame (N + 1) in OL_23 LVDS or HiSPi mode";
        desc = "LVDS1_LANE1_NXT_SOL_23 is a lane 1 SOL synchronization code configuration register for frame (N + 1) in LVDS or HiSPi mode. Hi3516A V200 Professional HD IP Camera SoC

Data sheet 9.3.6 LVDS1_LANE1_NXT_SOL_23 (offset 0x24D4, printed page 9-455, `hi3516av200--Hi3516AV200-Datasheet.txt` line 64156).";

        field {
            name = "lvds1_lane1_nxt_sol_3";
            desc = "Lane 1 SOL synchronization code of frame 3 in LVDS or HiSPi mode This field is configurable only in WDR mode, and the configuration is invalid in linear mode.";
            sw = rw;
            hw = r;
            reset = 0x0;
        } lvds1_lane1_nxt_sol_3[31:16];

        field {
            name = "lvds1_lane1_nxt_sol_2";
            desc = "Lane 1 SOL synchronization code of frame 2 in LVDS or HiSPi mode This field is configurable only in WDR mode, and the configuration is invalid in linear mode.";
            sw = rw;
            hw = r;
            reset = 0x0;
        } lvds1_lane1_nxt_sol_2[15:0];
    } LVDS1_LANE1_NXT_SOL_23 @ 0x24D4;

    reg {
        name = "Lane 1 EOL synchronization code NE1_NXT_E configuration register for frame (N + 1) in OL_01 LVDS or HiSPi mode";
        desc = "LVDS1_LANE1_NXT_EOL_01 is a lane 1 EOL synchronization code configuration register for frame (N + 1) in LVDS or HiSPi mode.

Data sheet 9.3.6 LVDS1_LANE1_NXT_EOL_01 (offset 0x24D8, printed page 9-455, `hi3516av200--Hi3516AV200-Datasheet.txt` line 64184).";

        field {
            name = "lvds1_lane1_nxt_eol_1";
            desc = "Lane 1 EOL synchronization code of frame 1 in LVDS or HiSPi mode This field is configurable only in WDR mode, and the configuration is invalid in linear mode.";
            sw = rw;
            hw = r;
            reset = 0x0;
        } lvds1_lane1_nxt_eol_1[31:16];

        field {
            name = "lvds1_lane1_nxt_eol_0";
            desc = "Lane 1 EOL synchronization code of frame 0 in LVDS or HiSPi mode In WDR mode, the value is the EOL of frame 0. In linear mode, the value is the EOL.";
            sw = rw;
            hw = r;
            reset = 0x0;
        } lvds1_lane1_nxt_eol_0[15:0];
    } LVDS1_LANE1_NXT_EOL_01 @ 0x24D8;

    reg {
        name = "Lane 1 EOL synchronization code NE1_NXT_E configuration register for frame (N + 1) in OL_23 LVDS or HiSPi mode";
        desc = "LVDS1_LANE1_NXT_EOL_23 is a lane 1 EOL synchronization code configuration register for frame (N + 1) in LVDS or HiSPi mode. Hi3516A V200 Professional HD IP Camera SoC

Data sheet 9.3.6 LVDS1_LANE1_NXT_EOL_23 (offset 0x24DC, printed page 9-456, `hi3516av200--Hi3516AV200-Datasheet.txt` line 64222).";

        field {
            name = "lvds1_lane1_nxt_eol_3";
            desc = "Lane 1 EOL synchronization code of frame 3 in LVDS or HiSPi mode This field is configurable only in WDR mode, and the configuration is invalid in linear mode.";
            sw = rw;
            hw = r;
            reset = 0x0;
        } lvds1_lane1_nxt_eol_3[31:16];

        field {
            name = "lvds1_lane1_nxt_eol_2";
            desc = "Lane 1 EOL synchronization code of frame 2 in LVDS or HiSPi mode This field is configurable only in WDR mode, and the configuration is invalid in linear mode.";
            sw = rw;
            hw = r;
            reset = 0x0;
        } lvds1_lane1_nxt_eol_2[15:0];
    } LVDS1_LANE1_NXT_EOL_23 @ 0x24DC;

    reg {
        name = "Lane 2 SOF synchronization code NE2_NXT_S configuration register for frame (N + 1) in OF_01 LVDS or HiSPi mode";
        desc = "LVDS1_LANE2_NXT_SOF_01 is a lane 2 SOF synchronization code configuration register for frame (N + 1) in LVDS or HiSPi mode.

Data sheet 9.3.6 LVDS1_LANE2_NXT_SOF_01 (offset 0x24E0, printed page 9-456, `hi3516av200--Hi3516AV200-Datasheet.txt` line 64250).";

        field {
            name = "lvds1_lane2_nxt_sof_1";
            desc = "Lane 2 SOF synchronization code of frame 1 in LVDS or HiSPi mode This field is configurable only in WDR mode, and the configuration is invalid in linear mode.";
            sw = rw;
            hw = r;
            reset = 0x0;
        } lvds1_lane2_nxt_sof_1[31:16];

        field {
            name = "lvds1_lane2_nxt_sof_0";
            desc = "Lane 2 SOF synchronization code of frame 0 in LVDS or HiSPi mode In WDR mode, the value is the SOF of frame 0. In linear mode, the value is the SOF.";
            sw = rw;
            hw = r;
            reset = 0x0;
        } lvds1_lane2_nxt_sof_0[15:0];
    } LVDS1_LANE2_NXT_SOF_01 @ 0x24E0;

    reg {
        name = "Lane 2 SOF synchronization code NE2_NXT_S configuration register for frame (N + 1) in OF_23 LVDS or HiSPi mode";
        desc = "LVDS1_LANE2_NXT_SOF_23 is a lane 2 SOF synchronization code configuration register for frame (N + 1) in LVDS or HiSPi mode. Hi3516A V200 Professional HD IP Camera SoC

Data sheet 9.3.6 LVDS1_LANE2_NXT_SOF_23 (offset 0x24E4, printed page 9-457, `hi3516av200--Hi3516AV200-Datasheet.txt` line 64288).";

        field {
            name = "lvds1_lane2_nxt_sof_3";
            desc = "Lane 2 SOF synchronization code of frame 3 in LVDS or HiSPi mode This field is configurable only in WDR mode, and the configuration is invalid in linear mode.";
            sw = rw;
            hw = r;
            reset = 0x0;
        } lvds1_lane2_nxt_sof_3[31:16];

        field {
            name = "lvds1_lane2_nxt_sof_2";
            desc = "Lane 2 SOF synchronization code of frame 2 in LVDS or HiSPi mode This field is configurable only in WDR mode, and the configuration is invalid in linear mode.";
            sw = rw;
            hw = r;
            reset = 0x0;
        } lvds1_lane2_nxt_sof_2[15:0];
    } LVDS1_LANE2_NXT_SOF_23 @ 0x24E4;

    reg {
        name = "Lane 2 EOF synchronization code NE2_NXT_E configuration register for frame (N + 1) in OF_01 LVDS or HiSPi mode";
        desc = "LVDS1_LANE2_NXT_EOF_01 is a lane 2 EOF synchronization code configuration register for frame (N + 1) in LVDS or HiSPi mode.

Data sheet 9.3.6 LVDS1_LANE2_NXT_EOF_01 (offset 0x24E8, printed page 9-457, `hi3516av200--Hi3516AV200-Datasheet.txt` line 64316).";

        field {
            name = "lvds1_lane2_nxt_eof_1";
            desc = "Lane 2 EOF synchronization code of frame 1 in LVDS or HiSPi mode This field is configurable only in WDR mode, and the configuration is invalid in linear mode.";
            sw = rw;
            hw = r;
            reset = 0x0;
        } lvds1_lane2_nxt_eof_1[31:16];

        field {
            name = "lvds1_lane2_nxt_eof_0";
            desc = "Lane 2 EOF synchronization code of frame 0 in LVDS or HiSPi mode In WDR mode, the value is the EOF of frame 0. In linear mode, the value is the EOF.";
            sw = rw;
            hw = r;
            reset = 0x0;
        } lvds1_lane2_nxt_eof_0[15:0];
    } LVDS1_LANE2_NXT_EOF_01 @ 0x24E8;

    reg {
        name = "Lane 2 EOF synchronization code NE2_NXT_E configuration register for frame (N + 1) in OF_23 LVDS or HiSPi mode";
        desc = "LVDS1_LANE2_NXT_EOF_23 is a lane 2 EOF synchronization code configuration register for frame (N + 1) in LVDS or HiSPi mode. Hi3516A V200 Professional HD IP Camera SoC

Data sheet 9.3.6 LVDS1_LANE2_NXT_EOF_23 (offset 0x24EC, printed page 9-458, `hi3516av200--Hi3516AV200-Datasheet.txt` line 64354).";

        field {
            name = "lvds1_lane2_nxt_eof_3";
            desc = "Lane 2 EOF synchronization code of frame 3 in LVDS or HiSPi mode This field is configurable only in WDR mode, and the configuration is invalid in linear mode.";
            sw = rw;
            hw = r;
            reset = 0x0;
        } lvds1_lane2_nxt_eof_3[31:16];

        field {
            name = "lvds1_lane2_nxt_eof_2";
            desc = "Lane 2 EOF synchronization code of frame 2 in LVDS or HiSPi mode This field is configurable only in WDR mode, and the configuration is invalid in linear mode.";
            sw = rw;
            hw = r;
            reset = 0x0;
        } lvds1_lane2_nxt_eof_2[15:0];
    } LVDS1_LANE2_NXT_EOF_23 @ 0x24EC;

    reg {
        name = "Lane 2 SOL synchronization code NE2_NXT_S configuration register for frame (N + 1) in OL_01 LVDS or HiSPi mode";
        desc = "LVDS1_LANE2_NXT_SOL_01 is a lane 2 SOL synchronization code configuration register for frame (N + 1) in LVDS or HiSPi mode.

Data sheet 9.3.6 LVDS1_LANE2_NXT_SOL_01 (offset 0x24F0, printed page 9-458, `hi3516av200--Hi3516AV200-Datasheet.txt` line 64382).";

        field {
            name = "lvds1_lane2_nxt_sol_1";
            desc = "Lane 2 SOL synchronization code of frame 1 in LVDS or HiSPi mode This field is configurable only in WDR mode, and the configuration is invalid in linear mode.";
            sw = rw;
            hw = r;
            reset = 0x0;
        } lvds1_lane2_nxt_sol_1[31:16];

        field {
            name = "lvds1_lane2_nxt_sol_0";
            desc = "Lane 2 SOL synchronization code of frame 0 in LVDS or HiSPi mode In WDR mode, the value is the SOL of frame 0. In linear mode, the value is the SOL.";
            sw = rw;
            hw = r;
            reset = 0x0;
        } lvds1_lane2_nxt_sol_0[15:0];
    } LVDS1_LANE2_NXT_SOL_01 @ 0x24F0;

    reg {
        name = "Lane 2 SOL synchronization code NE2_NXT_S configuration register for frame (N + 1) in OL_23 LVDS or HiSPi mode";
        desc = "LVDS1_LANE2_NXT_SOL_23 is a lane 2 SOL synchronization code configuration register for frame (N + 1) in LVDS or HiSPi mode. Hi3516A V200 Professional HD IP Camera SoC

Data sheet 9.3.6 LVDS1_LANE2_NXT_SOL_23 (offset 0x24F4, printed page 9-459, `hi3516av200--Hi3516AV200-Datasheet.txt` line 64420).";

        field {
            name = "lvds1_lane2_nxt_sol_3";
            desc = "Lane 2 SOL synchronization code of frame 3 in LVDS or HiSPi mode This field is configurable only in WDR mode, and the configuration is invalid in linear mode.";
            sw = rw;
            hw = r;
            reset = 0x0;
        } lvds1_lane2_nxt_sol_3[31:16];

        field {
            name = "lvds1_lane2_nxt_sol_2";
            desc = "Lane 2 SOL synchronization code of frame 2 in LVDS or HiSPi mode This field is configurable only in WDR mode, and the configuration is invalid in linear mode.";
            sw = rw;
            hw = r;
            reset = 0x0;
        } lvds1_lane2_nxt_sol_2[15:0];
    } LVDS1_LANE2_NXT_SOL_23 @ 0x24F4;

    reg {
        name = "Lane 2 EOL synchronization code NE2_NXT_E configuration register for frame (N + 1) in OL_01 LVDS or HiSPi mode";
        desc = "LVDS1_LANE2_NXT_EOL_01 is a lane 2 EOL synchronization code configuration register for frame (N + 1) in LVDS or HiSPi mode.

Data sheet 9.3.6 LVDS1_LANE2_NXT_EOL_01 (offset 0x24F8, printed page 9-459, `hi3516av200--Hi3516AV200-Datasheet.txt` line 64448).";

        field {
            name = "lvds1_lane2_nxt_eol_1";
            desc = "Lane 2 EOL synchronization code of frame 1 in LVDS or HiSPi mode This field is configurable only in WDR mode, and the configuration is invalid in linear mode.";
            sw = rw;
            hw = r;
            reset = 0x0;
        } lvds1_lane2_nxt_eol_1[31:16];

        field {
            name = "lvds1_lane2_nxt_eol_0";
            desc = "Lane 2 EOL synchronization code of frame 0 in LVDS or HiSPi mode In WDR mode, the value is the EOL of frame 0. In linear mode, the value is the EOL.";
            sw = rw;
            hw = r;
            reset = 0x0;
        } lvds1_lane2_nxt_eol_0[15:0];
    } LVDS1_LANE2_NXT_EOL_01 @ 0x24F8;

    reg {
        name = "Lane 2 EOL synchronization code NE2_NXT_E configuration register for frame (N + 1) in OL_23 LVDS or HiSPi mode";
        desc = "LVDS1_LANE2_NXT_EOL_23 is a lane 2 EOL synchronization code configuration register for frame (N + 1) in LVDS or HiSPi mode. Hi3516A V200 Professional HD IP Camera SoC

Data sheet 9.3.6 LVDS1_LANE2_NXT_EOL_23 (offset 0x24FC, printed page 9-460, `hi3516av200--Hi3516AV200-Datasheet.txt` line 64486).";

        field {
            name = "lvds1_lane2_nxt_eol_3";
            desc = "Lane 2 EOL synchronization code of frame 3 in LVDS or HiSPi mode This field is configurable only in WDR mode, and the configuration is invalid in linear mode.";
            sw = rw;
            hw = r;
            reset = 0x0;
        } lvds1_lane2_nxt_eol_3[31:16];

        field {
            name = "lvds1_lane2_nxt_eol_2";
            desc = "Lane 2 EOL synchronization code of frame 2 in LVDS or HiSPi mode This field is configurable only in WDR mode, and the configuration is invalid in linear mode.";
            sw = rw;
            hw = r;
            reset = 0x0;
        } lvds1_lane2_nxt_eol_2[15:0];
    } LVDS1_LANE2_NXT_EOL_23 @ 0x24FC;

    reg {
        name = "Lane 3 SOF synchronization code NE3_NXT_S configuration register for frame (N + 1) in OF_01 LVDS or HiSPi mode";
        desc = "LVDS1_LANE3_NXT_SOF_01 is a lane 3 SOF synchronization code configuration register for frame (N + 1) in LVDS or HiSPi mode.

Data sheet 9.3.6 LVDS1_LANE3_NXT_SOF_01 (offset 0x2500, printed page 9-460, `hi3516av200--Hi3516AV200-Datasheet.txt` line 64514).";

        field {
            name = "lvds1_lane3_nxt_sof_1";
            desc = "Lane 3 SOF synchronization code of frame 1 in LVDS or HiSPi mode This field is configurable only in WDR mode, and the configuration is invalid in linear mode.";
            sw = rw;
            hw = r;
            reset = 0x0;
        } lvds1_lane3_nxt_sof_1[31:16];

        field {
            name = "lvds1_lane3_nxt_sof_0";
            desc = "Lane 3 SOF synchronization code of frame 0 in LVDS or HiSPi mode In WDR mode, the value is the SOF of frame 0. In linear mode, the value is the SOF.";
            sw = rw;
            hw = r;
            reset = 0x0;
        } lvds1_lane3_nxt_sof_0[15:0];
    } LVDS1_LANE3_NXT_SOF_01 @ 0x2500;

    reg {
        name = "Lane 3 SOF synchronization code NE3_NXT_S configuration register for frame (N + 1) in OF_23 LVDS or HiSPi mode";
        desc = "LVDS1_LANE3_NXT_SOF_23 is a lane 3 SOF synchronization code configuration register for frame (N + 1) in LVDS or HiSPi mode. Hi3516A V200 Professional HD IP Camera SoC

Data sheet 9.3.6 LVDS1_LANE3_NXT_SOF_23 (offset 0x2504, printed page 9-461, `hi3516av200--Hi3516AV200-Datasheet.txt` line 64552).";

        field {
            name = "lvds1_lane3_nxt_sof_3";
            desc = "Lane 3 SOF synchronization code of frame 3 in LVDS or HiSPi mode This field is configurable only in WDR mode, and the configuration is invalid in linear mode.";
            sw = rw;
            hw = r;
            reset = 0x0;
        } lvds1_lane3_nxt_sof_3[31:16];

        field {
            name = "lvds1_lane3_nxt_sof_2";
            desc = "Lane 3 SOF synchronization code of frame 2 in LVDS or HiSPi mode This field is configurable only in WDR mode, and the configuration is invalid in linear mode.";
            sw = rw;
            hw = r;
            reset = 0x0;
        } lvds1_lane3_nxt_sof_2[15:0];
    } LVDS1_LANE3_NXT_SOF_23 @ 0x2504;

    reg {
        name = "Lane 3 EOF synchronization code NE3_NXT_E configuration register for frame (N + 1) in OF_01 LVDS or HiSPi mode";
        desc = "LVDS1_LANE3_NXT_EOF_01 is a lane 3 EOF synchronization code configuration register for frame (N + 1) in LVDS or HiSPi mode.

Data sheet 9.3.6 LVDS1_LANE3_NXT_EOF_01 (offset 0x2508, printed page 9-461, `hi3516av200--Hi3516AV200-Datasheet.txt` line 64580).";

        field {
            name = "lvds1_lane3_nxt_eof_1";
            desc = "Lane 3 EOF synchronization code of frame 1 in LVDS or HiSPi mode This field is configurable only in WDR mode, and the configuration is invalid in linear mode.";
            sw = rw;
            hw = r;
            reset = 0x0;
        } lvds1_lane3_nxt_eof_1[31:16];

        field {
            name = "lvds1_lane3_nxt_eof_0";
            desc = "Lane 3 EOF synchronization code of frame 0 in LVDS or HiSPi mode In WDR mode, the value is the EOF of frame 0. In linear mode, the value is the EOF.";
            sw = rw;
            hw = r;
            reset = 0x0;
        } lvds1_lane3_nxt_eof_0[15:0];
    } LVDS1_LANE3_NXT_EOF_01 @ 0x2508;

    reg {
        name = "Lane 3 EOF synchronization code NE3_NXT_E configuration register for frame (N + 1) in OF_23 LVDS or HiSPi mode";
        desc = "LVDS1_LANE3_NXT_EOF_23 is a lane 3 EOF synchronization code configuration register for frame (N + 1) in LVDS or HiSPi mode. Hi3516A V200 Professional HD IP Camera SoC

Data sheet 9.3.6 LVDS1_LANE3_NXT_EOF_23 (offset 0x250C, printed page 9-462, `hi3516av200--Hi3516AV200-Datasheet.txt` line 64618).";

        field {
            name = "lvds1_lane3_nxt_eof_3";
            desc = "Lane 2 EOF synchronization code of frame 3 in LVDS or HiSPi mode This field is configurable only in WDR mode, and the configuration is invalid in linear mode.";
            sw = rw;
            hw = r;
            reset = 0x0;
        } lvds1_lane3_nxt_eof_3[31:16];

        field {
            name = "lvds1_lane3_nxt_eof_2";
            desc = "Lane 2 EOF synchronization code of frame 2 in LVDS or HiSPi mode This field is configurable only in WDR mode, and the configuration is invalid in linear mode.";
            sw = rw;
            hw = r;
            reset = 0x0;
        } lvds1_lane3_nxt_eof_2[15:0];
    } LVDS1_LANE3_NXT_EOF_23 @ 0x250C;

    reg {
        name = "Lane 3 SOL synchronization code NE3_NXT_S configuration register for frame (N + 1) in OL_01 LVDS or HiSPi mode";
        desc = "LVDS1_LANE3_NXT_SOL_01 is a lane 3 SOL synchronization code configuration register for frame (N + 1) in LVDS or HiSPi mode.

Data sheet 9.3.6 LVDS1_LANE3_NXT_SOL_01 (offset 0x2510, printed page 9-462, `hi3516av200--Hi3516AV200-Datasheet.txt` line 64646).";

        field {
            name = "lvds1_lane3_nxt_sol_1";
            desc = "Lane 3 SOL synchronization code of frame 1 in LVDS or HiSPi mode This field is configurable only in WDR mode, and the configuration is invalid in linear mode.";
            sw = rw;
            hw = r;
            reset = 0x0;
        } lvds1_lane3_nxt_sol_1[31:16];

        field {
            name = "lvds1_lane3_nxt_sol_0";
            desc = "Lane 3 SOL synchronization code of frame 0 in LVDS or HiSPi mode In WDR mode, the value is the SOL of frame 0. In linear mode, the value is the SOL.";
            sw = rw;
            hw = r;
            reset = 0x0;
        } lvds1_lane3_nxt_sol_0[15:0];
    } LVDS1_LANE3_NXT_SOL_01 @ 0x2510;

    reg {
        name = "Lane 3 SOL synchronization code NE3_NXT_S configuration register for frame (N + 1) in OL_23 LVDS or HiSPi mode";
        desc = "LVDS1_LANE3_NXT_SOL_23 is a lane 3 SOL synchronization code configuration register for frame (N + 1) in LVDS or HiSPi mode. Hi3516A V200 Professional HD IP Camera SoC

Data sheet 9.3.6 LVDS1_LANE3_NXT_SOL_23 (offset 0x2514, printed page 9-463, `hi3516av200--Hi3516AV200-Datasheet.txt` line 64684).";

        field {
            name = "lvds1_lane3_nxt_sol_3";
            desc = "Lane 3 SOL synchronization code of frame 3 in LVDS or HiSPi mode This field is configurable only in WDR mode, and the configuration is invalid in linear mode.";
            sw = rw;
            hw = r;
            reset = 0x0;
        } lvds1_lane3_nxt_sol_3[31:16];

        field {
            name = "lvds1_lane3_nxt_sol_2";
            desc = "Lane 3 SOL synchronization code of frame 2 in LVDS or HiSPi mode This field is configurable only in WDR mode, and the configuration is invalid in linear mode.";
            sw = rw;
            hw = r;
            reset = 0x0;
        } lvds1_lane3_nxt_sol_2[15:0];
    } LVDS1_LANE3_NXT_SOL_23 @ 0x2514;

    reg {
        name = "Lane 3 EOL synchronization code NE3_NXT_E configuration register for frame (N + 1) in OL_01 LVDS or HiSPi mode";
        desc = "LVDS1_LANE3_NXT_EOL_01 is a lane 3 EOL synchronization code configuration register for frame (N + 1) in LVDS or HiSPi mode.

Data sheet 9.3.6 LVDS1_LANE3_NXT_EOL_01 (offset 0x2518, printed page 9-463, `hi3516av200--Hi3516AV200-Datasheet.txt` line 64712).";

        field {
            name = "lvds1_lane3_nxt_eol_1";
            desc = "Lane 3 EOL synchronization code of frame 1 in LVDS or HiSPi mode This field is configurable only in WDR mode, and the configuration is invalid in linear mode.";
            sw = rw;
            hw = r;
            reset = 0x0;
        } lvds1_lane3_nxt_eol_1[31:16];

        field {
            name = "lvds1_lane3_nxt_eol_0";
            desc = "Lane 3 EOL synchronization code of frame 0 in LVDS or HiSPi mode In WDR mode, the value is the EOL of frame 0. In linear mode, the value is the EOL.";
            sw = rw;
            hw = r;
            reset = 0x0;
        } lvds1_lane3_nxt_eol_0[15:0];
    } LVDS1_LANE3_NXT_EOL_01 @ 0x2518;

    reg {
        name = "Lane 3 EOL synchronization code NE3_NXT_E configuration register for frame (N + 1) in OL_23 LVDS or HiSPi mode";
        desc = "LVDS1_LANE3_NXT_EOL_23 is a lane 3 EOL synchronization code configuration register for frame (N + 1) in LVDS or HiSPi mode. Hi3516A V200 Professional HD IP Camera SoC

Data sheet 9.3.6 LVDS1_LANE3_NXT_EOL_23 (offset 0x251C, printed page 9-464, `hi3516av200--Hi3516AV200-Datasheet.txt` line 64750).";

        field {
            name = "lvds1_lane3_nxt_eol_3";
            desc = "Lane 3 EOL synchronization code of frame 3 in LVDS or HiSPi mode This field is configurable only in WDR mode, and the configuration is invalid in linear mode.";
            sw = rw;
            hw = r;
            reset = 0x0;
        } lvds1_lane3_nxt_eol_3[31:16];

        field {
            name = "lvds1_lane3_nxt_eol_2";
            desc = "Lane 3 EOL synchronization code of frame 2 in LVDS or HiSPi mode This field is configurable only in WDR mode, and the configuration is invalid in linear mode.";
            sw = rw;
            hw = r;
            reset = 0x0;
        } lvds1_lane3_nxt_eol_2[15:0];
    } LVDS1_LANE3_NXT_EOL_23 @ 0x251C;

    reg {
        name = "LVDS1 LANE4 NXT SOF 01";
        desc = "[inferred] LVDS1 LANE4 NXT SOF 01. Not in the data sheet. Source: OpenIPC openhisilicon `kernel/mipi_rx/hi3519v101/mipi_reg.h` (GPL-3.0 repository, HiSilicon copyright; local copy sources/openhisilicon), union `U_LVDS_LANE_SOF_01`, struct offset 0x2520 (GPL-3.0 repository, HiSilicon copyright; one header for Hi3519 V101 and Hi3516A V200). Reset value and access type unknown (modelled RW, no reset). Confidence: medium (vendor header for this chip family, not hardware verified).";

        field {
            name = "lane_sof_1";
            desc = "[inferred] Lane sof 1. (vendor header `hi3519v101/mipi_reg.h` field `lane_sof_1`; access and reset unknown, modelled RW)";
            sw = rw;
            hw = r;
        } lane_sof_1[31:16];

        field {
            name = "lane_sof_0";
            desc = "[inferred] Lane sof 0. (vendor header `hi3519v101/mipi_reg.h` field `lane_sof_0`; access and reset unknown, modelled RW)";
            sw = rw;
            hw = r;
        } lane_sof_0[15:0];
    } LVDS1_LANE4_NXT_SOF_01 @ 0x2520;

    reg {
        name = "LVDS1 LANE4 NXT SOF 23";
        desc = "[inferred] LVDS1 LANE4 NXT SOF 23. Not in the data sheet. Source: OpenIPC openhisilicon `kernel/mipi_rx/hi3519v101/mipi_reg.h` (GPL-3.0 repository, HiSilicon copyright; local copy sources/openhisilicon), union `U_LVDS_LANE_SOF_23`, struct offset 0x2524 (GPL-3.0 repository, HiSilicon copyright; one header for Hi3519 V101 and Hi3516A V200). Reset value and access type unknown (modelled RW, no reset). Confidence: medium (vendor header for this chip family, not hardware verified).";

        field {
            name = "lane_sof_3";
            desc = "[inferred] Lane sof 3. (vendor header `hi3519v101/mipi_reg.h` field `lane_sof_3`; access and reset unknown, modelled RW)";
            sw = rw;
            hw = r;
        } lane_sof_3[31:16];

        field {
            name = "lane_sof_2";
            desc = "[inferred] Lane sof 2. (vendor header `hi3519v101/mipi_reg.h` field `lane_sof_2`; access and reset unknown, modelled RW)";
            sw = rw;
            hw = r;
        } lane_sof_2[15:0];
    } LVDS1_LANE4_NXT_SOF_23 @ 0x2524;

    reg {
        name = "LVDS1 LANE4 NXT EOF 01";
        desc = "[inferred] LVDS1 LANE4 NXT EOF 01. Not in the data sheet. Source: OpenIPC openhisilicon `kernel/mipi_rx/hi3519v101/mipi_reg.h` (GPL-3.0 repository, HiSilicon copyright; local copy sources/openhisilicon), union `U_LVDS_LANE_EOF_01`, struct offset 0x2528 (GPL-3.0 repository, HiSilicon copyright; one header for Hi3519 V101 and Hi3516A V200). Reset value and access type unknown (modelled RW, no reset). Confidence: medium (vendor header for this chip family, not hardware verified).";

        field {
            name = "lane_eof_1";
            desc = "[inferred] Lane eof 1. (vendor header `hi3519v101/mipi_reg.h` field `lane_eof_1`; access and reset unknown, modelled RW)";
            sw = rw;
            hw = r;
        } lane_eof_1[31:16];

        field {
            name = "lane_eof_0";
            desc = "[inferred] Lane eof 0. (vendor header `hi3519v101/mipi_reg.h` field `lane_eof_0`; access and reset unknown, modelled RW)";
            sw = rw;
            hw = r;
        } lane_eof_0[15:0];
    } LVDS1_LANE4_NXT_EOF_01 @ 0x2528;

    reg {
        name = "LVDS1 LANE4 NXT EOF 23";
        desc = "[inferred] LVDS1 LANE4 NXT EOF 23. Not in the data sheet. Source: OpenIPC openhisilicon `kernel/mipi_rx/hi3519v101/mipi_reg.h` (GPL-3.0 repository, HiSilicon copyright; local copy sources/openhisilicon), union `U_LVDS_LANE_EOF_23`, struct offset 0x252C (GPL-3.0 repository, HiSilicon copyright; one header for Hi3519 V101 and Hi3516A V200). Reset value and access type unknown (modelled RW, no reset). Confidence: medium (vendor header for this chip family, not hardware verified).";

        field {
            name = "lane_eof_3";
            desc = "[inferred] Lane eof 3. (vendor header `hi3519v101/mipi_reg.h` field `lane_eof_3`; access and reset unknown, modelled RW)";
            sw = rw;
            hw = r;
        } lane_eof_3[31:16];

        field {
            name = "lane_eof_2";
            desc = "[inferred] Lane eof 2. (vendor header `hi3519v101/mipi_reg.h` field `lane_eof_2`; access and reset unknown, modelled RW)";
            sw = rw;
            hw = r;
        } lane_eof_2[15:0];
    } LVDS1_LANE4_NXT_EOF_23 @ 0x252C;

    reg {
        name = "LVDS1 LANE4 NXT SOL 01";
        desc = "[inferred] LVDS1 LANE4 NXT SOL 01. Not in the data sheet. Source: OpenIPC openhisilicon `kernel/mipi_rx/hi3519v101/mipi_reg.h` (GPL-3.0 repository, HiSilicon copyright; local copy sources/openhisilicon), union `U_LVDS_LANE_SOL_01`, struct offset 0x2530 (GPL-3.0 repository, HiSilicon copyright; one header for Hi3519 V101 and Hi3516A V200). Reset value and access type unknown (modelled RW, no reset). Confidence: medium (vendor header for this chip family, not hardware verified).";

        field {
            name = "lane_sol_1";
            desc = "[inferred] Lane sol 1. (vendor header `hi3519v101/mipi_reg.h` field `lane_sol_1`; access and reset unknown, modelled RW)";
            sw = rw;
            hw = r;
        } lane_sol_1[31:16];

        field {
            name = "lane_sol_0";
            desc = "[inferred] Lane sol 0. (vendor header `hi3519v101/mipi_reg.h` field `lane_sol_0`; access and reset unknown, modelled RW)";
            sw = rw;
            hw = r;
        } lane_sol_0[15:0];
    } LVDS1_LANE4_NXT_SOL_01 @ 0x2530;

    reg {
        name = "LVDS1 LANE4 NXT SOL 23";
        desc = "[inferred] LVDS1 LANE4 NXT SOL 23. Not in the data sheet. Source: OpenIPC openhisilicon `kernel/mipi_rx/hi3519v101/mipi_reg.h` (GPL-3.0 repository, HiSilicon copyright; local copy sources/openhisilicon), union `U_LVDS_LANE_SOL_23`, struct offset 0x2534 (GPL-3.0 repository, HiSilicon copyright; one header for Hi3519 V101 and Hi3516A V200). Reset value and access type unknown (modelled RW, no reset). Confidence: medium (vendor header for this chip family, not hardware verified).";

        field {
            name = "lane_sol_3";
            desc = "[inferred] Lane sol 3. (vendor header `hi3519v101/mipi_reg.h` field `lane_sol_3`; access and reset unknown, modelled RW)";
            sw = rw;
            hw = r;
        } lane_sol_3[31:16];

        field {
            name = "lane_sol_2";
            desc = "[inferred] Lane sol 2. (vendor header `hi3519v101/mipi_reg.h` field `lane_sol_2`; access and reset unknown, modelled RW)";
            sw = rw;
            hw = r;
        } lane_sol_2[15:0];
    } LVDS1_LANE4_NXT_SOL_23 @ 0x2534;

    reg {
        name = "LVDS1 LANE4 NXT EOL 01";
        desc = "[inferred] LVDS1 LANE4 NXT EOL 01. Not in the data sheet. Source: OpenIPC openhisilicon `kernel/mipi_rx/hi3519v101/mipi_reg.h` (GPL-3.0 repository, HiSilicon copyright; local copy sources/openhisilicon), union `U_LVDS_LANE_EOL_01`, struct offset 0x2538 (GPL-3.0 repository, HiSilicon copyright; one header for Hi3519 V101 and Hi3516A V200). Reset value and access type unknown (modelled RW, no reset). Confidence: medium (vendor header for this chip family, not hardware verified).";

        field {
            name = "lane_eol_1";
            desc = "[inferred] Lane eol 1. (vendor header `hi3519v101/mipi_reg.h` field `lane_eol_1`; access and reset unknown, modelled RW)";
            sw = rw;
            hw = r;
        } lane_eol_1[31:16];

        field {
            name = "lane_eol_0";
            desc = "[inferred] Lane eol 0. (vendor header `hi3519v101/mipi_reg.h` field `lane_eol_0`; access and reset unknown, modelled RW)";
            sw = rw;
            hw = r;
        } lane_eol_0[15:0];
    } LVDS1_LANE4_NXT_EOL_01 @ 0x2538;

    reg {
        name = "LVDS1 LANE4 NXT EOL 23";
        desc = "[inferred] LVDS1 LANE4 NXT EOL 23. Not in the data sheet. Source: OpenIPC openhisilicon `kernel/mipi_rx/hi3519v101/mipi_reg.h` (GPL-3.0 repository, HiSilicon copyright; local copy sources/openhisilicon), union `U_LVDS_LANE_EOL_23`, struct offset 0x253C (GPL-3.0 repository, HiSilicon copyright; one header for Hi3519 V101 and Hi3516A V200). Reset value and access type unknown (modelled RW, no reset). Confidence: medium (vendor header for this chip family, not hardware verified).";

        field {
            name = "lane_eol_3";
            desc = "[inferred] Lane eol 3. (vendor header `hi3519v101/mipi_reg.h` field `lane_eol_3`; access and reset unknown, modelled RW)";
            sw = rw;
            hw = r;
        } lane_eol_3[31:16];

        field {
            name = "lane_eol_2";
            desc = "[inferred] Lane eol 2. (vendor header `hi3519v101/mipi_reg.h` field `lane_eol_2`; access and reset unknown, modelled RW)";
            sw = rw;
            hw = r;
        } lane_eol_2[15:0];
    } LVDS1_LANE4_NXT_EOL_23 @ 0x253C;

    reg {
        name = "LVDS1 LANE5 NXT SOF 01";
        desc = "[inferred] LVDS1 LANE5 NXT SOF 01. Not in the data sheet. Source: OpenIPC openhisilicon `kernel/mipi_rx/hi3519v101/mipi_reg.h` (GPL-3.0 repository, HiSilicon copyright; local copy sources/openhisilicon), union `U_LVDS_LANE_SOF_01`, struct offset 0x2540 (GPL-3.0 repository, HiSilicon copyright; one header for Hi3519 V101 and Hi3516A V200). Reset value and access type unknown (modelled RW, no reset). Confidence: medium (vendor header for this chip family, not hardware verified).";

        field {
            name = "lane_sof_1";
            desc = "[inferred] Lane sof 1. (vendor header `hi3519v101/mipi_reg.h` field `lane_sof_1`; access and reset unknown, modelled RW)";
            sw = rw;
            hw = r;
        } lane_sof_1[31:16];

        field {
            name = "lane_sof_0";
            desc = "[inferred] Lane sof 0. (vendor header `hi3519v101/mipi_reg.h` field `lane_sof_0`; access and reset unknown, modelled RW)";
            sw = rw;
            hw = r;
        } lane_sof_0[15:0];
    } LVDS1_LANE5_NXT_SOF_01 @ 0x2540;

    reg {
        name = "LVDS1 LANE5 NXT SOF 23";
        desc = "[inferred] LVDS1 LANE5 NXT SOF 23. Not in the data sheet. Source: OpenIPC openhisilicon `kernel/mipi_rx/hi3519v101/mipi_reg.h` (GPL-3.0 repository, HiSilicon copyright; local copy sources/openhisilicon), union `U_LVDS_LANE_SOF_23`, struct offset 0x2544 (GPL-3.0 repository, HiSilicon copyright; one header for Hi3519 V101 and Hi3516A V200). Reset value and access type unknown (modelled RW, no reset). Confidence: medium (vendor header for this chip family, not hardware verified).";

        field {
            name = "lane_sof_3";
            desc = "[inferred] Lane sof 3. (vendor header `hi3519v101/mipi_reg.h` field `lane_sof_3`; access and reset unknown, modelled RW)";
            sw = rw;
            hw = r;
        } lane_sof_3[31:16];

        field {
            name = "lane_sof_2";
            desc = "[inferred] Lane sof 2. (vendor header `hi3519v101/mipi_reg.h` field `lane_sof_2`; access and reset unknown, modelled RW)";
            sw = rw;
            hw = r;
        } lane_sof_2[15:0];
    } LVDS1_LANE5_NXT_SOF_23 @ 0x2544;

    reg {
        name = "LVDS1 LANE5 NXT EOF 01";
        desc = "[inferred] LVDS1 LANE5 NXT EOF 01. Not in the data sheet. Source: OpenIPC openhisilicon `kernel/mipi_rx/hi3519v101/mipi_reg.h` (GPL-3.0 repository, HiSilicon copyright; local copy sources/openhisilicon), union `U_LVDS_LANE_EOF_01`, struct offset 0x2548 (GPL-3.0 repository, HiSilicon copyright; one header for Hi3519 V101 and Hi3516A V200). Reset value and access type unknown (modelled RW, no reset). Confidence: medium (vendor header for this chip family, not hardware verified).";

        field {
            name = "lane_eof_1";
            desc = "[inferred] Lane eof 1. (vendor header `hi3519v101/mipi_reg.h` field `lane_eof_1`; access and reset unknown, modelled RW)";
            sw = rw;
            hw = r;
        } lane_eof_1[31:16];

        field {
            name = "lane_eof_0";
            desc = "[inferred] Lane eof 0. (vendor header `hi3519v101/mipi_reg.h` field `lane_eof_0`; access and reset unknown, modelled RW)";
            sw = rw;
            hw = r;
        } lane_eof_0[15:0];
    } LVDS1_LANE5_NXT_EOF_01 @ 0x2548;

    reg {
        name = "LVDS1 LANE5 NXT EOF 23";
        desc = "[inferred] LVDS1 LANE5 NXT EOF 23. Not in the data sheet. Source: OpenIPC openhisilicon `kernel/mipi_rx/hi3519v101/mipi_reg.h` (GPL-3.0 repository, HiSilicon copyright; local copy sources/openhisilicon), union `U_LVDS_LANE_EOF_23`, struct offset 0x254C (GPL-3.0 repository, HiSilicon copyright; one header for Hi3519 V101 and Hi3516A V200). Reset value and access type unknown (modelled RW, no reset). Confidence: medium (vendor header for this chip family, not hardware verified).";

        field {
            name = "lane_eof_3";
            desc = "[inferred] Lane eof 3. (vendor header `hi3519v101/mipi_reg.h` field `lane_eof_3`; access and reset unknown, modelled RW)";
            sw = rw;
            hw = r;
        } lane_eof_3[31:16];

        field {
            name = "lane_eof_2";
            desc = "[inferred] Lane eof 2. (vendor header `hi3519v101/mipi_reg.h` field `lane_eof_2`; access and reset unknown, modelled RW)";
            sw = rw;
            hw = r;
        } lane_eof_2[15:0];
    } LVDS1_LANE5_NXT_EOF_23 @ 0x254C;

    reg {
        name = "LVDS1 LANE5 NXT SOL 01";
        desc = "[inferred] LVDS1 LANE5 NXT SOL 01. Not in the data sheet. Source: OpenIPC openhisilicon `kernel/mipi_rx/hi3519v101/mipi_reg.h` (GPL-3.0 repository, HiSilicon copyright; local copy sources/openhisilicon), union `U_LVDS_LANE_SOL_01`, struct offset 0x2550 (GPL-3.0 repository, HiSilicon copyright; one header for Hi3519 V101 and Hi3516A V200). Reset value and access type unknown (modelled RW, no reset). Confidence: medium (vendor header for this chip family, not hardware verified).";

        field {
            name = "lane_sol_1";
            desc = "[inferred] Lane sol 1. (vendor header `hi3519v101/mipi_reg.h` field `lane_sol_1`; access and reset unknown, modelled RW)";
            sw = rw;
            hw = r;
        } lane_sol_1[31:16];

        field {
            name = "lane_sol_0";
            desc = "[inferred] Lane sol 0. (vendor header `hi3519v101/mipi_reg.h` field `lane_sol_0`; access and reset unknown, modelled RW)";
            sw = rw;
            hw = r;
        } lane_sol_0[15:0];
    } LVDS1_LANE5_NXT_SOL_01 @ 0x2550;

    reg {
        name = "LVDS1 LANE5 NXT SOL 23";
        desc = "[inferred] LVDS1 LANE5 NXT SOL 23. Not in the data sheet. Source: OpenIPC openhisilicon `kernel/mipi_rx/hi3519v101/mipi_reg.h` (GPL-3.0 repository, HiSilicon copyright; local copy sources/openhisilicon), union `U_LVDS_LANE_SOL_23`, struct offset 0x2554 (GPL-3.0 repository, HiSilicon copyright; one header for Hi3519 V101 and Hi3516A V200). Reset value and access type unknown (modelled RW, no reset). Confidence: medium (vendor header for this chip family, not hardware verified).";

        field {
            name = "lane_sol_3";
            desc = "[inferred] Lane sol 3. (vendor header `hi3519v101/mipi_reg.h` field `lane_sol_3`; access and reset unknown, modelled RW)";
            sw = rw;
            hw = r;
        } lane_sol_3[31:16];

        field {
            name = "lane_sol_2";
            desc = "[inferred] Lane sol 2. (vendor header `hi3519v101/mipi_reg.h` field `lane_sol_2`; access and reset unknown, modelled RW)";
            sw = rw;
            hw = r;
        } lane_sol_2[15:0];
    } LVDS1_LANE5_NXT_SOL_23 @ 0x2554;

    reg {
        name = "LVDS1 LANE5 NXT EOL 01";
        desc = "[inferred] LVDS1 LANE5 NXT EOL 01. Not in the data sheet. Source: OpenIPC openhisilicon `kernel/mipi_rx/hi3519v101/mipi_reg.h` (GPL-3.0 repository, HiSilicon copyright; local copy sources/openhisilicon), union `U_LVDS_LANE_EOL_01`, struct offset 0x2558 (GPL-3.0 repository, HiSilicon copyright; one header for Hi3519 V101 and Hi3516A V200). Reset value and access type unknown (modelled RW, no reset). Confidence: medium (vendor header for this chip family, not hardware verified).";

        field {
            name = "lane_eol_1";
            desc = "[inferred] Lane eol 1. (vendor header `hi3519v101/mipi_reg.h` field `lane_eol_1`; access and reset unknown, modelled RW)";
            sw = rw;
            hw = r;
        } lane_eol_1[31:16];

        field {
            name = "lane_eol_0";
            desc = "[inferred] Lane eol 0. (vendor header `hi3519v101/mipi_reg.h` field `lane_eol_0`; access and reset unknown, modelled RW)";
            sw = rw;
            hw = r;
        } lane_eol_0[15:0];
    } LVDS1_LANE5_NXT_EOL_01 @ 0x2558;

    reg {
        name = "LVDS1 LANE5 NXT EOL 23";
        desc = "[inferred] LVDS1 LANE5 NXT EOL 23. Not in the data sheet. Source: OpenIPC openhisilicon `kernel/mipi_rx/hi3519v101/mipi_reg.h` (GPL-3.0 repository, HiSilicon copyright; local copy sources/openhisilicon), union `U_LVDS_LANE_EOL_23`, struct offset 0x255C (GPL-3.0 repository, HiSilicon copyright; one header for Hi3519 V101 and Hi3516A V200). Reset value and access type unknown (modelled RW, no reset). Confidence: medium (vendor header for this chip family, not hardware verified).";

        field {
            name = "lane_eol_3";
            desc = "[inferred] Lane eol 3. (vendor header `hi3519v101/mipi_reg.h` field `lane_eol_3`; access and reset unknown, modelled RW)";
            sw = rw;
            hw = r;
        } lane_eol_3[31:16];

        field {
            name = "lane_eol_2";
            desc = "[inferred] Lane eol 2. (vendor header `hi3519v101/mipi_reg.h` field `lane_eol_2`; access and reset unknown, modelled RW)";
            sw = rw;
            hw = r;
        } lane_eol_2[15:0];
    } LVDS1_LANE5_NXT_EOL_23 @ 0x255C;

    reg {
        name = "LVDS1 LANE6 NXT SOF 01";
        desc = "[inferred] LVDS1 LANE6 NXT SOF 01. Not in the data sheet. Source: OpenIPC openhisilicon `kernel/mipi_rx/hi3519v101/mipi_reg.h` (GPL-3.0 repository, HiSilicon copyright; local copy sources/openhisilicon), union `U_LVDS_LANE_SOF_01`, struct offset 0x2560 (GPL-3.0 repository, HiSilicon copyright; one header for Hi3519 V101 and Hi3516A V200). Reset value and access type unknown (modelled RW, no reset). Confidence: medium (vendor header for this chip family, not hardware verified).";

        field {
            name = "lane_sof_1";
            desc = "[inferred] Lane sof 1. (vendor header `hi3519v101/mipi_reg.h` field `lane_sof_1`; access and reset unknown, modelled RW)";
            sw = rw;
            hw = r;
        } lane_sof_1[31:16];

        field {
            name = "lane_sof_0";
            desc = "[inferred] Lane sof 0. (vendor header `hi3519v101/mipi_reg.h` field `lane_sof_0`; access and reset unknown, modelled RW)";
            sw = rw;
            hw = r;
        } lane_sof_0[15:0];
    } LVDS1_LANE6_NXT_SOF_01 @ 0x2560;

    reg {
        name = "LVDS1 LANE6 NXT SOF 23";
        desc = "[inferred] LVDS1 LANE6 NXT SOF 23. Not in the data sheet. Source: OpenIPC openhisilicon `kernel/mipi_rx/hi3519v101/mipi_reg.h` (GPL-3.0 repository, HiSilicon copyright; local copy sources/openhisilicon), union `U_LVDS_LANE_SOF_23`, struct offset 0x2564 (GPL-3.0 repository, HiSilicon copyright; one header for Hi3519 V101 and Hi3516A V200). Reset value and access type unknown (modelled RW, no reset). Confidence: medium (vendor header for this chip family, not hardware verified).";

        field {
            name = "lane_sof_3";
            desc = "[inferred] Lane sof 3. (vendor header `hi3519v101/mipi_reg.h` field `lane_sof_3`; access and reset unknown, modelled RW)";
            sw = rw;
            hw = r;
        } lane_sof_3[31:16];

        field {
            name = "lane_sof_2";
            desc = "[inferred] Lane sof 2. (vendor header `hi3519v101/mipi_reg.h` field `lane_sof_2`; access and reset unknown, modelled RW)";
            sw = rw;
            hw = r;
        } lane_sof_2[15:0];
    } LVDS1_LANE6_NXT_SOF_23 @ 0x2564;

    reg {
        name = "LVDS1 LANE6 NXT EOF 01";
        desc = "[inferred] LVDS1 LANE6 NXT EOF 01. Not in the data sheet. Source: OpenIPC openhisilicon `kernel/mipi_rx/hi3519v101/mipi_reg.h` (GPL-3.0 repository, HiSilicon copyright; local copy sources/openhisilicon), union `U_LVDS_LANE_EOF_01`, struct offset 0x2568 (GPL-3.0 repository, HiSilicon copyright; one header for Hi3519 V101 and Hi3516A V200). Reset value and access type unknown (modelled RW, no reset). Confidence: medium (vendor header for this chip family, not hardware verified).";

        field {
            name = "lane_eof_1";
            desc = "[inferred] Lane eof 1. (vendor header `hi3519v101/mipi_reg.h` field `lane_eof_1`; access and reset unknown, modelled RW)";
            sw = rw;
            hw = r;
        } lane_eof_1[31:16];

        field {
            name = "lane_eof_0";
            desc = "[inferred] Lane eof 0. (vendor header `hi3519v101/mipi_reg.h` field `lane_eof_0`; access and reset unknown, modelled RW)";
            sw = rw;
            hw = r;
        } lane_eof_0[15:0];
    } LVDS1_LANE6_NXT_EOF_01 @ 0x2568;

    reg {
        name = "LVDS1 LANE6 NXT EOF 23";
        desc = "[inferred] LVDS1 LANE6 NXT EOF 23. Not in the data sheet. Source: OpenIPC openhisilicon `kernel/mipi_rx/hi3519v101/mipi_reg.h` (GPL-3.0 repository, HiSilicon copyright; local copy sources/openhisilicon), union `U_LVDS_LANE_EOF_23`, struct offset 0x256C (GPL-3.0 repository, HiSilicon copyright; one header for Hi3519 V101 and Hi3516A V200). Reset value and access type unknown (modelled RW, no reset). Confidence: medium (vendor header for this chip family, not hardware verified).";

        field {
            name = "lane_eof_3";
            desc = "[inferred] Lane eof 3. (vendor header `hi3519v101/mipi_reg.h` field `lane_eof_3`; access and reset unknown, modelled RW)";
            sw = rw;
            hw = r;
        } lane_eof_3[31:16];

        field {
            name = "lane_eof_2";
            desc = "[inferred] Lane eof 2. (vendor header `hi3519v101/mipi_reg.h` field `lane_eof_2`; access and reset unknown, modelled RW)";
            sw = rw;
            hw = r;
        } lane_eof_2[15:0];
    } LVDS1_LANE6_NXT_EOF_23 @ 0x256C;

    reg {
        name = "LVDS1 LANE6 NXT SOL 01";
        desc = "[inferred] LVDS1 LANE6 NXT SOL 01. Not in the data sheet. Source: OpenIPC openhisilicon `kernel/mipi_rx/hi3519v101/mipi_reg.h` (GPL-3.0 repository, HiSilicon copyright; local copy sources/openhisilicon), union `U_LVDS_LANE_SOL_01`, struct offset 0x2570 (GPL-3.0 repository, HiSilicon copyright; one header for Hi3519 V101 and Hi3516A V200). Reset value and access type unknown (modelled RW, no reset). Confidence: medium (vendor header for this chip family, not hardware verified).";

        field {
            name = "lane_sol_1";
            desc = "[inferred] Lane sol 1. (vendor header `hi3519v101/mipi_reg.h` field `lane_sol_1`; access and reset unknown, modelled RW)";
            sw = rw;
            hw = r;
        } lane_sol_1[31:16];

        field {
            name = "lane_sol_0";
            desc = "[inferred] Lane sol 0. (vendor header `hi3519v101/mipi_reg.h` field `lane_sol_0`; access and reset unknown, modelled RW)";
            sw = rw;
            hw = r;
        } lane_sol_0[15:0];
    } LVDS1_LANE6_NXT_SOL_01 @ 0x2570;

    reg {
        name = "LVDS1 LANE6 NXT SOL 23";
        desc = "[inferred] LVDS1 LANE6 NXT SOL 23. Not in the data sheet. Source: OpenIPC openhisilicon `kernel/mipi_rx/hi3519v101/mipi_reg.h` (GPL-3.0 repository, HiSilicon copyright; local copy sources/openhisilicon), union `U_LVDS_LANE_SOL_23`, struct offset 0x2574 (GPL-3.0 repository, HiSilicon copyright; one header for Hi3519 V101 and Hi3516A V200). Reset value and access type unknown (modelled RW, no reset). Confidence: medium (vendor header for this chip family, not hardware verified).";

        field {
            name = "lane_sol_3";
            desc = "[inferred] Lane sol 3. (vendor header `hi3519v101/mipi_reg.h` field `lane_sol_3`; access and reset unknown, modelled RW)";
            sw = rw;
            hw = r;
        } lane_sol_3[31:16];

        field {
            name = "lane_sol_2";
            desc = "[inferred] Lane sol 2. (vendor header `hi3519v101/mipi_reg.h` field `lane_sol_2`; access and reset unknown, modelled RW)";
            sw = rw;
            hw = r;
        } lane_sol_2[15:0];
    } LVDS1_LANE6_NXT_SOL_23 @ 0x2574;

    reg {
        name = "LVDS1 LANE6 NXT EOL 01";
        desc = "[inferred] LVDS1 LANE6 NXT EOL 01. Not in the data sheet. Source: OpenIPC openhisilicon `kernel/mipi_rx/hi3519v101/mipi_reg.h` (GPL-3.0 repository, HiSilicon copyright; local copy sources/openhisilicon), union `U_LVDS_LANE_EOL_01`, struct offset 0x2578 (GPL-3.0 repository, HiSilicon copyright; one header for Hi3519 V101 and Hi3516A V200). Reset value and access type unknown (modelled RW, no reset). Confidence: medium (vendor header for this chip family, not hardware verified).";

        field {
            name = "lane_eol_1";
            desc = "[inferred] Lane eol 1. (vendor header `hi3519v101/mipi_reg.h` field `lane_eol_1`; access and reset unknown, modelled RW)";
            sw = rw;
            hw = r;
        } lane_eol_1[31:16];

        field {
            name = "lane_eol_0";
            desc = "[inferred] Lane eol 0. (vendor header `hi3519v101/mipi_reg.h` field `lane_eol_0`; access and reset unknown, modelled RW)";
            sw = rw;
            hw = r;
        } lane_eol_0[15:0];
    } LVDS1_LANE6_NXT_EOL_01 @ 0x2578;

    reg {
        name = "LVDS1 LANE6 NXT EOL 23";
        desc = "[inferred] LVDS1 LANE6 NXT EOL 23. Not in the data sheet. Source: OpenIPC openhisilicon `kernel/mipi_rx/hi3519v101/mipi_reg.h` (GPL-3.0 repository, HiSilicon copyright; local copy sources/openhisilicon), union `U_LVDS_LANE_EOL_23`, struct offset 0x257C (GPL-3.0 repository, HiSilicon copyright; one header for Hi3519 V101 and Hi3516A V200). Reset value and access type unknown (modelled RW, no reset). Confidence: medium (vendor header for this chip family, not hardware verified).";

        field {
            name = "lane_eol_3";
            desc = "[inferred] Lane eol 3. (vendor header `hi3519v101/mipi_reg.h` field `lane_eol_3`; access and reset unknown, modelled RW)";
            sw = rw;
            hw = r;
        } lane_eol_3[31:16];

        field {
            name = "lane_eol_2";
            desc = "[inferred] Lane eol 2. (vendor header `hi3519v101/mipi_reg.h` field `lane_eol_2`; access and reset unknown, modelled RW)";
            sw = rw;
            hw = r;
        } lane_eol_2[15:0];
    } LVDS1_LANE6_NXT_EOL_23 @ 0x257C;

    reg {
        name = "LVDS1 LANE7 NXT SOF 01";
        desc = "[inferred] LVDS1 LANE7 NXT SOF 01. Not in the data sheet. Source: OpenIPC openhisilicon `kernel/mipi_rx/hi3519v101/mipi_reg.h` (GPL-3.0 repository, HiSilicon copyright; local copy sources/openhisilicon), union `U_LVDS_LANE_SOF_01`, struct offset 0x2580 (GPL-3.0 repository, HiSilicon copyright; one header for Hi3519 V101 and Hi3516A V200). Reset value and access type unknown (modelled RW, no reset). Confidence: medium (vendor header for this chip family, not hardware verified).";

        field {
            name = "lane_sof_1";
            desc = "[inferred] Lane sof 1. (vendor header `hi3519v101/mipi_reg.h` field `lane_sof_1`; access and reset unknown, modelled RW)";
            sw = rw;
            hw = r;
        } lane_sof_1[31:16];

        field {
            name = "lane_sof_0";
            desc = "[inferred] Lane sof 0. (vendor header `hi3519v101/mipi_reg.h` field `lane_sof_0`; access and reset unknown, modelled RW)";
            sw = rw;
            hw = r;
        } lane_sof_0[15:0];
    } LVDS1_LANE7_NXT_SOF_01 @ 0x2580;

    reg {
        name = "LVDS1 LANE7 NXT SOF 23";
        desc = "[inferred] LVDS1 LANE7 NXT SOF 23. Not in the data sheet. Source: OpenIPC openhisilicon `kernel/mipi_rx/hi3519v101/mipi_reg.h` (GPL-3.0 repository, HiSilicon copyright; local copy sources/openhisilicon), union `U_LVDS_LANE_SOF_23`, struct offset 0x2584 (GPL-3.0 repository, HiSilicon copyright; one header for Hi3519 V101 and Hi3516A V200). Reset value and access type unknown (modelled RW, no reset). Confidence: medium (vendor header for this chip family, not hardware verified).";

        field {
            name = "lane_sof_3";
            desc = "[inferred] Lane sof 3. (vendor header `hi3519v101/mipi_reg.h` field `lane_sof_3`; access and reset unknown, modelled RW)";
            sw = rw;
            hw = r;
        } lane_sof_3[31:16];

        field {
            name = "lane_sof_2";
            desc = "[inferred] Lane sof 2. (vendor header `hi3519v101/mipi_reg.h` field `lane_sof_2`; access and reset unknown, modelled RW)";
            sw = rw;
            hw = r;
        } lane_sof_2[15:0];
    } LVDS1_LANE7_NXT_SOF_23 @ 0x2584;

    reg {
        name = "LVDS1 LANE7 NXT EOF 01";
        desc = "[inferred] LVDS1 LANE7 NXT EOF 01. Not in the data sheet. Source: OpenIPC openhisilicon `kernel/mipi_rx/hi3519v101/mipi_reg.h` (GPL-3.0 repository, HiSilicon copyright; local copy sources/openhisilicon), union `U_LVDS_LANE_EOF_01`, struct offset 0x2588 (GPL-3.0 repository, HiSilicon copyright; one header for Hi3519 V101 and Hi3516A V200). Reset value and access type unknown (modelled RW, no reset). Confidence: medium (vendor header for this chip family, not hardware verified).";

        field {
            name = "lane_eof_1";
            desc = "[inferred] Lane eof 1. (vendor header `hi3519v101/mipi_reg.h` field `lane_eof_1`; access and reset unknown, modelled RW)";
            sw = rw;
            hw = r;
        } lane_eof_1[31:16];

        field {
            name = "lane_eof_0";
            desc = "[inferred] Lane eof 0. (vendor header `hi3519v101/mipi_reg.h` field `lane_eof_0`; access and reset unknown, modelled RW)";
            sw = rw;
            hw = r;
        } lane_eof_0[15:0];
    } LVDS1_LANE7_NXT_EOF_01 @ 0x2588;

    reg {
        name = "LVDS1 LANE7 NXT EOF 23";
        desc = "[inferred] LVDS1 LANE7 NXT EOF 23. Not in the data sheet. Source: OpenIPC openhisilicon `kernel/mipi_rx/hi3519v101/mipi_reg.h` (GPL-3.0 repository, HiSilicon copyright; local copy sources/openhisilicon), union `U_LVDS_LANE_EOF_23`, struct offset 0x258C (GPL-3.0 repository, HiSilicon copyright; one header for Hi3519 V101 and Hi3516A V200). Reset value and access type unknown (modelled RW, no reset). Confidence: medium (vendor header for this chip family, not hardware verified).";

        field {
            name = "lane_eof_3";
            desc = "[inferred] Lane eof 3. (vendor header `hi3519v101/mipi_reg.h` field `lane_eof_3`; access and reset unknown, modelled RW)";
            sw = rw;
            hw = r;
        } lane_eof_3[31:16];

        field {
            name = "lane_eof_2";
            desc = "[inferred] Lane eof 2. (vendor header `hi3519v101/mipi_reg.h` field `lane_eof_2`; access and reset unknown, modelled RW)";
            sw = rw;
            hw = r;
        } lane_eof_2[15:0];
    } LVDS1_LANE7_NXT_EOF_23 @ 0x258C;

    reg {
        name = "LVDS1 LANE7 NXT SOL 01";
        desc = "[inferred] LVDS1 LANE7 NXT SOL 01. Not in the data sheet. Source: OpenIPC openhisilicon `kernel/mipi_rx/hi3519v101/mipi_reg.h` (GPL-3.0 repository, HiSilicon copyright; local copy sources/openhisilicon), union `U_LVDS_LANE_SOL_01`, struct offset 0x2590 (GPL-3.0 repository, HiSilicon copyright; one header for Hi3519 V101 and Hi3516A V200). Reset value and access type unknown (modelled RW, no reset). Confidence: medium (vendor header for this chip family, not hardware verified).";

        field {
            name = "lane_sol_1";
            desc = "[inferred] Lane sol 1. (vendor header `hi3519v101/mipi_reg.h` field `lane_sol_1`; access and reset unknown, modelled RW)";
            sw = rw;
            hw = r;
        } lane_sol_1[31:16];

        field {
            name = "lane_sol_0";
            desc = "[inferred] Lane sol 0. (vendor header `hi3519v101/mipi_reg.h` field `lane_sol_0`; access and reset unknown, modelled RW)";
            sw = rw;
            hw = r;
        } lane_sol_0[15:0];
    } LVDS1_LANE7_NXT_SOL_01 @ 0x2590;

    reg {
        name = "LVDS1 LANE7 NXT SOL 23";
        desc = "[inferred] LVDS1 LANE7 NXT SOL 23. Not in the data sheet. Source: OpenIPC openhisilicon `kernel/mipi_rx/hi3519v101/mipi_reg.h` (GPL-3.0 repository, HiSilicon copyright; local copy sources/openhisilicon), union `U_LVDS_LANE_SOL_23`, struct offset 0x2594 (GPL-3.0 repository, HiSilicon copyright; one header for Hi3519 V101 and Hi3516A V200). Reset value and access type unknown (modelled RW, no reset). Confidence: medium (vendor header for this chip family, not hardware verified).";

        field {
            name = "lane_sol_3";
            desc = "[inferred] Lane sol 3. (vendor header `hi3519v101/mipi_reg.h` field `lane_sol_3`; access and reset unknown, modelled RW)";
            sw = rw;
            hw = r;
        } lane_sol_3[31:16];

        field {
            name = "lane_sol_2";
            desc = "[inferred] Lane sol 2. (vendor header `hi3519v101/mipi_reg.h` field `lane_sol_2`; access and reset unknown, modelled RW)";
            sw = rw;
            hw = r;
        } lane_sol_2[15:0];
    } LVDS1_LANE7_NXT_SOL_23 @ 0x2594;

    reg {
        name = "LVDS1 LANE7 NXT EOL 01";
        desc = "[inferred] LVDS1 LANE7 NXT EOL 01. Not in the data sheet. Source: OpenIPC openhisilicon `kernel/mipi_rx/hi3519v101/mipi_reg.h` (GPL-3.0 repository, HiSilicon copyright; local copy sources/openhisilicon), union `U_LVDS_LANE_EOL_01`, struct offset 0x2598 (GPL-3.0 repository, HiSilicon copyright; one header for Hi3519 V101 and Hi3516A V200). Reset value and access type unknown (modelled RW, no reset). Confidence: medium (vendor header for this chip family, not hardware verified).";

        field {
            name = "lane_eol_1";
            desc = "[inferred] Lane eol 1. (vendor header `hi3519v101/mipi_reg.h` field `lane_eol_1`; access and reset unknown, modelled RW)";
            sw = rw;
            hw = r;
        } lane_eol_1[31:16];

        field {
            name = "lane_eol_0";
            desc = "[inferred] Lane eol 0. (vendor header `hi3519v101/mipi_reg.h` field `lane_eol_0`; access and reset unknown, modelled RW)";
            sw = rw;
            hw = r;
        } lane_eol_0[15:0];
    } LVDS1_LANE7_NXT_EOL_01 @ 0x2598;

    reg {
        name = "LVDS1 LANE7 NXT EOL 23";
        desc = "[inferred] LVDS1 LANE7 NXT EOL 23. Not in the data sheet. Source: OpenIPC openhisilicon `kernel/mipi_rx/hi3519v101/mipi_reg.h` (GPL-3.0 repository, HiSilicon copyright; local copy sources/openhisilicon), union `U_LVDS_LANE_EOL_23`, struct offset 0x259C (GPL-3.0 repository, HiSilicon copyright; one header for Hi3519 V101 and Hi3516A V200). Reset value and access type unknown (modelled RW, no reset). Confidence: medium (vendor header for this chip family, not hardware verified).";

        field {
            name = "lane_eol_3";
            desc = "[inferred] Lane eol 3. (vendor header `hi3519v101/mipi_reg.h` field `lane_eol_3`; access and reset unknown, modelled RW)";
            sw = rw;
            hw = r;
        } lane_eol_3[31:16];

        field {
            name = "lane_eol_2";
            desc = "[inferred] Lane eol 2. (vendor header `hi3519v101/mipi_reg.h` field `lane_eol_2`; access and reset unknown, modelled RW)";
            sw = rw;
            hw = r;
        } lane_eol_2[15:0];
    } LVDS1_LANE7_NXT_EOL_23 @ 0x259C;

    reg {
        name = "LVDS1 LANE8 NXT SOF 01";
        desc = "[inferred] LVDS1 LANE8 NXT SOF 01. Not in the data sheet. Source: OpenIPC openhisilicon `kernel/mipi_rx/hi3519v101/mipi_reg.h` (GPL-3.0 repository, HiSilicon copyright; local copy sources/openhisilicon), union `U_LVDS_LANE_SOF_01`, struct offset 0x25A0 (GPL-3.0 repository, HiSilicon copyright; one header for Hi3519 V101 and Hi3516A V200). Reset value and access type unknown (modelled RW, no reset). Confidence: medium (vendor header for this chip family, not hardware verified).";

        field {
            name = "lane_sof_1";
            desc = "[inferred] Lane sof 1. (vendor header `hi3519v101/mipi_reg.h` field `lane_sof_1`; access and reset unknown, modelled RW)";
            sw = rw;
            hw = r;
        } lane_sof_1[31:16];

        field {
            name = "lane_sof_0";
            desc = "[inferred] Lane sof 0. (vendor header `hi3519v101/mipi_reg.h` field `lane_sof_0`; access and reset unknown, modelled RW)";
            sw = rw;
            hw = r;
        } lane_sof_0[15:0];
    } LVDS1_LANE8_NXT_SOF_01 @ 0x25A0;

    reg {
        name = "LVDS1 LANE8 NXT SOF 23";
        desc = "[inferred] LVDS1 LANE8 NXT SOF 23. Not in the data sheet. Source: OpenIPC openhisilicon `kernel/mipi_rx/hi3519v101/mipi_reg.h` (GPL-3.0 repository, HiSilicon copyright; local copy sources/openhisilicon), union `U_LVDS_LANE_SOF_23`, struct offset 0x25A4 (GPL-3.0 repository, HiSilicon copyright; one header for Hi3519 V101 and Hi3516A V200). Reset value and access type unknown (modelled RW, no reset). Confidence: medium (vendor header for this chip family, not hardware verified).";

        field {
            name = "lane_sof_3";
            desc = "[inferred] Lane sof 3. (vendor header `hi3519v101/mipi_reg.h` field `lane_sof_3`; access and reset unknown, modelled RW)";
            sw = rw;
            hw = r;
        } lane_sof_3[31:16];

        field {
            name = "lane_sof_2";
            desc = "[inferred] Lane sof 2. (vendor header `hi3519v101/mipi_reg.h` field `lane_sof_2`; access and reset unknown, modelled RW)";
            sw = rw;
            hw = r;
        } lane_sof_2[15:0];
    } LVDS1_LANE8_NXT_SOF_23 @ 0x25A4;

    reg {
        name = "LVDS1 LANE8 NXT EOF 01";
        desc = "[inferred] LVDS1 LANE8 NXT EOF 01. Not in the data sheet. Source: OpenIPC openhisilicon `kernel/mipi_rx/hi3519v101/mipi_reg.h` (GPL-3.0 repository, HiSilicon copyright; local copy sources/openhisilicon), union `U_LVDS_LANE_EOF_01`, struct offset 0x25A8 (GPL-3.0 repository, HiSilicon copyright; one header for Hi3519 V101 and Hi3516A V200). Reset value and access type unknown (modelled RW, no reset). Confidence: medium (vendor header for this chip family, not hardware verified).";

        field {
            name = "lane_eof_1";
            desc = "[inferred] Lane eof 1. (vendor header `hi3519v101/mipi_reg.h` field `lane_eof_1`; access and reset unknown, modelled RW)";
            sw = rw;
            hw = r;
        } lane_eof_1[31:16];

        field {
            name = "lane_eof_0";
            desc = "[inferred] Lane eof 0. (vendor header `hi3519v101/mipi_reg.h` field `lane_eof_0`; access and reset unknown, modelled RW)";
            sw = rw;
            hw = r;
        } lane_eof_0[15:0];
    } LVDS1_LANE8_NXT_EOF_01 @ 0x25A8;

    reg {
        name = "LVDS1 LANE8 NXT EOF 23";
        desc = "[inferred] LVDS1 LANE8 NXT EOF 23. Not in the data sheet. Source: OpenIPC openhisilicon `kernel/mipi_rx/hi3519v101/mipi_reg.h` (GPL-3.0 repository, HiSilicon copyright; local copy sources/openhisilicon), union `U_LVDS_LANE_EOF_23`, struct offset 0x25AC (GPL-3.0 repository, HiSilicon copyright; one header for Hi3519 V101 and Hi3516A V200). Reset value and access type unknown (modelled RW, no reset). Confidence: medium (vendor header for this chip family, not hardware verified).";

        field {
            name = "lane_eof_3";
            desc = "[inferred] Lane eof 3. (vendor header `hi3519v101/mipi_reg.h` field `lane_eof_3`; access and reset unknown, modelled RW)";
            sw = rw;
            hw = r;
        } lane_eof_3[31:16];

        field {
            name = "lane_eof_2";
            desc = "[inferred] Lane eof 2. (vendor header `hi3519v101/mipi_reg.h` field `lane_eof_2`; access and reset unknown, modelled RW)";
            sw = rw;
            hw = r;
        } lane_eof_2[15:0];
    } LVDS1_LANE8_NXT_EOF_23 @ 0x25AC;

    reg {
        name = "LVDS1 LANE8 NXT SOL 01";
        desc = "[inferred] LVDS1 LANE8 NXT SOL 01. Not in the data sheet. Source: OpenIPC openhisilicon `kernel/mipi_rx/hi3519v101/mipi_reg.h` (GPL-3.0 repository, HiSilicon copyright; local copy sources/openhisilicon), union `U_LVDS_LANE_SOL_01`, struct offset 0x25B0 (GPL-3.0 repository, HiSilicon copyright; one header for Hi3519 V101 and Hi3516A V200). Reset value and access type unknown (modelled RW, no reset). Confidence: medium (vendor header for this chip family, not hardware verified).";

        field {
            name = "lane_sol_1";
            desc = "[inferred] Lane sol 1. (vendor header `hi3519v101/mipi_reg.h` field `lane_sol_1`; access and reset unknown, modelled RW)";
            sw = rw;
            hw = r;
        } lane_sol_1[31:16];

        field {
            name = "lane_sol_0";
            desc = "[inferred] Lane sol 0. (vendor header `hi3519v101/mipi_reg.h` field `lane_sol_0`; access and reset unknown, modelled RW)";
            sw = rw;
            hw = r;
        } lane_sol_0[15:0];
    } LVDS1_LANE8_NXT_SOL_01 @ 0x25B0;

    reg {
        name = "LVDS1 LANE8 NXT SOL 23";
        desc = "[inferred] LVDS1 LANE8 NXT SOL 23. Not in the data sheet. Source: OpenIPC openhisilicon `kernel/mipi_rx/hi3519v101/mipi_reg.h` (GPL-3.0 repository, HiSilicon copyright; local copy sources/openhisilicon), union `U_LVDS_LANE_SOL_23`, struct offset 0x25B4 (GPL-3.0 repository, HiSilicon copyright; one header for Hi3519 V101 and Hi3516A V200). Reset value and access type unknown (modelled RW, no reset). Confidence: medium (vendor header for this chip family, not hardware verified).";

        field {
            name = "lane_sol_3";
            desc = "[inferred] Lane sol 3. (vendor header `hi3519v101/mipi_reg.h` field `lane_sol_3`; access and reset unknown, modelled RW)";
            sw = rw;
            hw = r;
        } lane_sol_3[31:16];

        field {
            name = "lane_sol_2";
            desc = "[inferred] Lane sol 2. (vendor header `hi3519v101/mipi_reg.h` field `lane_sol_2`; access and reset unknown, modelled RW)";
            sw = rw;
            hw = r;
        } lane_sol_2[15:0];
    } LVDS1_LANE8_NXT_SOL_23 @ 0x25B4;

    reg {
        name = "LVDS1 LANE8 NXT EOL 01";
        desc = "[inferred] LVDS1 LANE8 NXT EOL 01. Not in the data sheet. Source: OpenIPC openhisilicon `kernel/mipi_rx/hi3519v101/mipi_reg.h` (GPL-3.0 repository, HiSilicon copyright; local copy sources/openhisilicon), union `U_LVDS_LANE_EOL_01`, struct offset 0x25B8 (GPL-3.0 repository, HiSilicon copyright; one header for Hi3519 V101 and Hi3516A V200). Reset value and access type unknown (modelled RW, no reset). Confidence: medium (vendor header for this chip family, not hardware verified).";

        field {
            name = "lane_eol_1";
            desc = "[inferred] Lane eol 1. (vendor header `hi3519v101/mipi_reg.h` field `lane_eol_1`; access and reset unknown, modelled RW)";
            sw = rw;
            hw = r;
        } lane_eol_1[31:16];

        field {
            name = "lane_eol_0";
            desc = "[inferred] Lane eol 0. (vendor header `hi3519v101/mipi_reg.h` field `lane_eol_0`; access and reset unknown, modelled RW)";
            sw = rw;
            hw = r;
        } lane_eol_0[15:0];
    } LVDS1_LANE8_NXT_EOL_01 @ 0x25B8;

    reg {
        name = "LVDS1 LANE8 NXT EOL 23";
        desc = "[inferred] LVDS1 LANE8 NXT EOL 23. Not in the data sheet. Source: OpenIPC openhisilicon `kernel/mipi_rx/hi3519v101/mipi_reg.h` (GPL-3.0 repository, HiSilicon copyright; local copy sources/openhisilicon), union `U_LVDS_LANE_EOL_23`, struct offset 0x25BC (GPL-3.0 repository, HiSilicon copyright; one header for Hi3519 V101 and Hi3516A V200). Reset value and access type unknown (modelled RW, no reset). Confidence: medium (vendor header for this chip family, not hardware verified).";

        field {
            name = "lane_eol_3";
            desc = "[inferred] Lane eol 3. (vendor header `hi3519v101/mipi_reg.h` field `lane_eol_3`; access and reset unknown, modelled RW)";
            sw = rw;
            hw = r;
        } lane_eol_3[31:16];

        field {
            name = "lane_eol_2";
            desc = "[inferred] Lane eol 2. (vendor header `hi3519v101/mipi_reg.h` field `lane_eol_2`; access and reset unknown, modelled RW)";
            sw = rw;
            hw = r;
        } lane_eol_2[15:0];
    } LVDS1_LANE8_NXT_EOL_23 @ 0x25BC;

    reg {
        name = "LVDS1 LANE9 NXT SOF 01";
        desc = "[inferred] LVDS1 LANE9 NXT SOF 01. Not in the data sheet. Source: OpenIPC openhisilicon `kernel/mipi_rx/hi3519v101/mipi_reg.h` (GPL-3.0 repository, HiSilicon copyright; local copy sources/openhisilicon), union `U_LVDS_LANE_SOF_01`, struct offset 0x25C0 (GPL-3.0 repository, HiSilicon copyright; one header for Hi3519 V101 and Hi3516A V200). Reset value and access type unknown (modelled RW, no reset). Confidence: medium (vendor header for this chip family, not hardware verified).";

        field {
            name = "lane_sof_1";
            desc = "[inferred] Lane sof 1. (vendor header `hi3519v101/mipi_reg.h` field `lane_sof_1`; access and reset unknown, modelled RW)";
            sw = rw;
            hw = r;
        } lane_sof_1[31:16];

        field {
            name = "lane_sof_0";
            desc = "[inferred] Lane sof 0. (vendor header `hi3519v101/mipi_reg.h` field `lane_sof_0`; access and reset unknown, modelled RW)";
            sw = rw;
            hw = r;
        } lane_sof_0[15:0];
    } LVDS1_LANE9_NXT_SOF_01 @ 0x25C0;

    reg {
        name = "LVDS1 LANE9 NXT SOF 23";
        desc = "[inferred] LVDS1 LANE9 NXT SOF 23. Not in the data sheet. Source: OpenIPC openhisilicon `kernel/mipi_rx/hi3519v101/mipi_reg.h` (GPL-3.0 repository, HiSilicon copyright; local copy sources/openhisilicon), union `U_LVDS_LANE_SOF_23`, struct offset 0x25C4 (GPL-3.0 repository, HiSilicon copyright; one header for Hi3519 V101 and Hi3516A V200). Reset value and access type unknown (modelled RW, no reset). Confidence: medium (vendor header for this chip family, not hardware verified).";

        field {
            name = "lane_sof_3";
            desc = "[inferred] Lane sof 3. (vendor header `hi3519v101/mipi_reg.h` field `lane_sof_3`; access and reset unknown, modelled RW)";
            sw = rw;
            hw = r;
        } lane_sof_3[31:16];

        field {
            name = "lane_sof_2";
            desc = "[inferred] Lane sof 2. (vendor header `hi3519v101/mipi_reg.h` field `lane_sof_2`; access and reset unknown, modelled RW)";
            sw = rw;
            hw = r;
        } lane_sof_2[15:0];
    } LVDS1_LANE9_NXT_SOF_23 @ 0x25C4;

    reg {
        name = "LVDS1 LANE9 NXT EOF 01";
        desc = "[inferred] LVDS1 LANE9 NXT EOF 01. Not in the data sheet. Source: OpenIPC openhisilicon `kernel/mipi_rx/hi3519v101/mipi_reg.h` (GPL-3.0 repository, HiSilicon copyright; local copy sources/openhisilicon), union `U_LVDS_LANE_EOF_01`, struct offset 0x25C8 (GPL-3.0 repository, HiSilicon copyright; one header for Hi3519 V101 and Hi3516A V200). Reset value and access type unknown (modelled RW, no reset). Confidence: medium (vendor header for this chip family, not hardware verified).";

        field {
            name = "lane_eof_1";
            desc = "[inferred] Lane eof 1. (vendor header `hi3519v101/mipi_reg.h` field `lane_eof_1`; access and reset unknown, modelled RW)";
            sw = rw;
            hw = r;
        } lane_eof_1[31:16];

        field {
            name = "lane_eof_0";
            desc = "[inferred] Lane eof 0. (vendor header `hi3519v101/mipi_reg.h` field `lane_eof_0`; access and reset unknown, modelled RW)";
            sw = rw;
            hw = r;
        } lane_eof_0[15:0];
    } LVDS1_LANE9_NXT_EOF_01 @ 0x25C8;

    reg {
        name = "LVDS1 LANE9 NXT EOF 23";
        desc = "[inferred] LVDS1 LANE9 NXT EOF 23. Not in the data sheet. Source: OpenIPC openhisilicon `kernel/mipi_rx/hi3519v101/mipi_reg.h` (GPL-3.0 repository, HiSilicon copyright; local copy sources/openhisilicon), union `U_LVDS_LANE_EOF_23`, struct offset 0x25CC (GPL-3.0 repository, HiSilicon copyright; one header for Hi3519 V101 and Hi3516A V200). Reset value and access type unknown (modelled RW, no reset). Confidence: medium (vendor header for this chip family, not hardware verified).";

        field {
            name = "lane_eof_3";
            desc = "[inferred] Lane eof 3. (vendor header `hi3519v101/mipi_reg.h` field `lane_eof_3`; access and reset unknown, modelled RW)";
            sw = rw;
            hw = r;
        } lane_eof_3[31:16];

        field {
            name = "lane_eof_2";
            desc = "[inferred] Lane eof 2. (vendor header `hi3519v101/mipi_reg.h` field `lane_eof_2`; access and reset unknown, modelled RW)";
            sw = rw;
            hw = r;
        } lane_eof_2[15:0];
    } LVDS1_LANE9_NXT_EOF_23 @ 0x25CC;

    reg {
        name = "LVDS1 LANE9 NXT SOL 01";
        desc = "[inferred] LVDS1 LANE9 NXT SOL 01. Not in the data sheet. Source: OpenIPC openhisilicon `kernel/mipi_rx/hi3519v101/mipi_reg.h` (GPL-3.0 repository, HiSilicon copyright; local copy sources/openhisilicon), union `U_LVDS_LANE_SOL_01`, struct offset 0x25D0 (GPL-3.0 repository, HiSilicon copyright; one header for Hi3519 V101 and Hi3516A V200). Reset value and access type unknown (modelled RW, no reset). Confidence: medium (vendor header for this chip family, not hardware verified).";

        field {
            name = "lane_sol_1";
            desc = "[inferred] Lane sol 1. (vendor header `hi3519v101/mipi_reg.h` field `lane_sol_1`; access and reset unknown, modelled RW)";
            sw = rw;
            hw = r;
        } lane_sol_1[31:16];

        field {
            name = "lane_sol_0";
            desc = "[inferred] Lane sol 0. (vendor header `hi3519v101/mipi_reg.h` field `lane_sol_0`; access and reset unknown, modelled RW)";
            sw = rw;
            hw = r;
        } lane_sol_0[15:0];
    } LVDS1_LANE9_NXT_SOL_01 @ 0x25D0;

    reg {
        name = "LVDS1 LANE9 NXT SOL 23";
        desc = "[inferred] LVDS1 LANE9 NXT SOL 23. Not in the data sheet. Source: OpenIPC openhisilicon `kernel/mipi_rx/hi3519v101/mipi_reg.h` (GPL-3.0 repository, HiSilicon copyright; local copy sources/openhisilicon), union `U_LVDS_LANE_SOL_23`, struct offset 0x25D4 (GPL-3.0 repository, HiSilicon copyright; one header for Hi3519 V101 and Hi3516A V200). Reset value and access type unknown (modelled RW, no reset). Confidence: medium (vendor header for this chip family, not hardware verified).";

        field {
            name = "lane_sol_3";
            desc = "[inferred] Lane sol 3. (vendor header `hi3519v101/mipi_reg.h` field `lane_sol_3`; access and reset unknown, modelled RW)";
            sw = rw;
            hw = r;
        } lane_sol_3[31:16];

        field {
            name = "lane_sol_2";
            desc = "[inferred] Lane sol 2. (vendor header `hi3519v101/mipi_reg.h` field `lane_sol_2`; access and reset unknown, modelled RW)";
            sw = rw;
            hw = r;
        } lane_sol_2[15:0];
    } LVDS1_LANE9_NXT_SOL_23 @ 0x25D4;

    reg {
        name = "LVDS1 LANE9 NXT EOL 01";
        desc = "[inferred] LVDS1 LANE9 NXT EOL 01. Not in the data sheet. Source: OpenIPC openhisilicon `kernel/mipi_rx/hi3519v101/mipi_reg.h` (GPL-3.0 repository, HiSilicon copyright; local copy sources/openhisilicon), union `U_LVDS_LANE_EOL_01`, struct offset 0x25D8 (GPL-3.0 repository, HiSilicon copyright; one header for Hi3519 V101 and Hi3516A V200). Reset value and access type unknown (modelled RW, no reset). Confidence: medium (vendor header for this chip family, not hardware verified).";

        field {
            name = "lane_eol_1";
            desc = "[inferred] Lane eol 1. (vendor header `hi3519v101/mipi_reg.h` field `lane_eol_1`; access and reset unknown, modelled RW)";
            sw = rw;
            hw = r;
        } lane_eol_1[31:16];

        field {
            name = "lane_eol_0";
            desc = "[inferred] Lane eol 0. (vendor header `hi3519v101/mipi_reg.h` field `lane_eol_0`; access and reset unknown, modelled RW)";
            sw = rw;
            hw = r;
        } lane_eol_0[15:0];
    } LVDS1_LANE9_NXT_EOL_01 @ 0x25D8;

    reg {
        name = "LVDS1 LANE9 NXT EOL 23";
        desc = "[inferred] LVDS1 LANE9 NXT EOL 23. Not in the data sheet. Source: OpenIPC openhisilicon `kernel/mipi_rx/hi3519v101/mipi_reg.h` (GPL-3.0 repository, HiSilicon copyright; local copy sources/openhisilicon), union `U_LVDS_LANE_EOL_23`, struct offset 0x25DC (GPL-3.0 repository, HiSilicon copyright; one header for Hi3519 V101 and Hi3516A V200). Reset value and access type unknown (modelled RW, no reset). Confidence: medium (vendor header for this chip family, not hardware verified).";

        field {
            name = "lane_eol_3";
            desc = "[inferred] Lane eol 3. (vendor header `hi3519v101/mipi_reg.h` field `lane_eol_3`; access and reset unknown, modelled RW)";
            sw = rw;
            hw = r;
        } lane_eol_3[31:16];

        field {
            name = "lane_eol_2";
            desc = "[inferred] Lane eol 2. (vendor header `hi3519v101/mipi_reg.h` field `lane_eol_2`; access and reset unknown, modelled RW)";
            sw = rw;
            hw = r;
        } lane_eol_2[15:0];
    } LVDS1_LANE9_NXT_EOL_23 @ 0x25DC;

    reg {
        name = "LVDS1 LANE10 NXT SOF 01";
        desc = "[inferred] LVDS1 LANE10 NXT SOF 01. Not in the data sheet. Source: OpenIPC openhisilicon `kernel/mipi_rx/hi3519v101/mipi_reg.h` (GPL-3.0 repository, HiSilicon copyright; local copy sources/openhisilicon), union `U_LVDS_LANE_SOF_01`, struct offset 0x25E0 (GPL-3.0 repository, HiSilicon copyright; one header for Hi3519 V101 and Hi3516A V200). Reset value and access type unknown (modelled RW, no reset). Confidence: medium (vendor header for this chip family, not hardware verified).";

        field {
            name = "lane_sof_1";
            desc = "[inferred] Lane sof 1. (vendor header `hi3519v101/mipi_reg.h` field `lane_sof_1`; access and reset unknown, modelled RW)";
            sw = rw;
            hw = r;
        } lane_sof_1[31:16];

        field {
            name = "lane_sof_0";
            desc = "[inferred] Lane sof 0. (vendor header `hi3519v101/mipi_reg.h` field `lane_sof_0`; access and reset unknown, modelled RW)";
            sw = rw;
            hw = r;
        } lane_sof_0[15:0];
    } LVDS1_LANE10_NXT_SOF_01 @ 0x25E0;

    reg {
        name = "LVDS1 LANE10 NXT SOF 23";
        desc = "[inferred] LVDS1 LANE10 NXT SOF 23. Not in the data sheet. Source: OpenIPC openhisilicon `kernel/mipi_rx/hi3519v101/mipi_reg.h` (GPL-3.0 repository, HiSilicon copyright; local copy sources/openhisilicon), union `U_LVDS_LANE_SOF_23`, struct offset 0x25E4 (GPL-3.0 repository, HiSilicon copyright; one header for Hi3519 V101 and Hi3516A V200). Reset value and access type unknown (modelled RW, no reset). Confidence: medium (vendor header for this chip family, not hardware verified).";

        field {
            name = "lane_sof_3";
            desc = "[inferred] Lane sof 3. (vendor header `hi3519v101/mipi_reg.h` field `lane_sof_3`; access and reset unknown, modelled RW)";
            sw = rw;
            hw = r;
        } lane_sof_3[31:16];

        field {
            name = "lane_sof_2";
            desc = "[inferred] Lane sof 2. (vendor header `hi3519v101/mipi_reg.h` field `lane_sof_2`; access and reset unknown, modelled RW)";
            sw = rw;
            hw = r;
        } lane_sof_2[15:0];
    } LVDS1_LANE10_NXT_SOF_23 @ 0x25E4;

    reg {
        name = "LVDS1 LANE10 NXT EOF 01";
        desc = "[inferred] LVDS1 LANE10 NXT EOF 01. Not in the data sheet. Source: OpenIPC openhisilicon `kernel/mipi_rx/hi3519v101/mipi_reg.h` (GPL-3.0 repository, HiSilicon copyright; local copy sources/openhisilicon), union `U_LVDS_LANE_EOF_01`, struct offset 0x25E8 (GPL-3.0 repository, HiSilicon copyright; one header for Hi3519 V101 and Hi3516A V200). Reset value and access type unknown (modelled RW, no reset). Confidence: medium (vendor header for this chip family, not hardware verified).";

        field {
            name = "lane_eof_1";
            desc = "[inferred] Lane eof 1. (vendor header `hi3519v101/mipi_reg.h` field `lane_eof_1`; access and reset unknown, modelled RW)";
            sw = rw;
            hw = r;
        } lane_eof_1[31:16];

        field {
            name = "lane_eof_0";
            desc = "[inferred] Lane eof 0. (vendor header `hi3519v101/mipi_reg.h` field `lane_eof_0`; access and reset unknown, modelled RW)";
            sw = rw;
            hw = r;
        } lane_eof_0[15:0];
    } LVDS1_LANE10_NXT_EOF_01 @ 0x25E8;

    reg {
        name = "LVDS1 LANE10 NXT EOF 23";
        desc = "[inferred] LVDS1 LANE10 NXT EOF 23. Not in the data sheet. Source: OpenIPC openhisilicon `kernel/mipi_rx/hi3519v101/mipi_reg.h` (GPL-3.0 repository, HiSilicon copyright; local copy sources/openhisilicon), union `U_LVDS_LANE_EOF_23`, struct offset 0x25EC (GPL-3.0 repository, HiSilicon copyright; one header for Hi3519 V101 and Hi3516A V200). Reset value and access type unknown (modelled RW, no reset). Confidence: medium (vendor header for this chip family, not hardware verified).";

        field {
            name = "lane_eof_3";
            desc = "[inferred] Lane eof 3. (vendor header `hi3519v101/mipi_reg.h` field `lane_eof_3`; access and reset unknown, modelled RW)";
            sw = rw;
            hw = r;
        } lane_eof_3[31:16];

        field {
            name = "lane_eof_2";
            desc = "[inferred] Lane eof 2. (vendor header `hi3519v101/mipi_reg.h` field `lane_eof_2`; access and reset unknown, modelled RW)";
            sw = rw;
            hw = r;
        } lane_eof_2[15:0];
    } LVDS1_LANE10_NXT_EOF_23 @ 0x25EC;

    reg {
        name = "LVDS1 LANE10 NXT SOL 01";
        desc = "[inferred] LVDS1 LANE10 NXT SOL 01. Not in the data sheet. Source: OpenIPC openhisilicon `kernel/mipi_rx/hi3519v101/mipi_reg.h` (GPL-3.0 repository, HiSilicon copyright; local copy sources/openhisilicon), union `U_LVDS_LANE_SOL_01`, struct offset 0x25F0 (GPL-3.0 repository, HiSilicon copyright; one header for Hi3519 V101 and Hi3516A V200). Reset value and access type unknown (modelled RW, no reset). Confidence: medium (vendor header for this chip family, not hardware verified).";

        field {
            name = "lane_sol_1";
            desc = "[inferred] Lane sol 1. (vendor header `hi3519v101/mipi_reg.h` field `lane_sol_1`; access and reset unknown, modelled RW)";
            sw = rw;
            hw = r;
        } lane_sol_1[31:16];

        field {
            name = "lane_sol_0";
            desc = "[inferred] Lane sol 0. (vendor header `hi3519v101/mipi_reg.h` field `lane_sol_0`; access and reset unknown, modelled RW)";
            sw = rw;
            hw = r;
        } lane_sol_0[15:0];
    } LVDS1_LANE10_NXT_SOL_01 @ 0x25F0;

    reg {
        name = "LVDS1 LANE10 NXT SOL 23";
        desc = "[inferred] LVDS1 LANE10 NXT SOL 23. Not in the data sheet. Source: OpenIPC openhisilicon `kernel/mipi_rx/hi3519v101/mipi_reg.h` (GPL-3.0 repository, HiSilicon copyright; local copy sources/openhisilicon), union `U_LVDS_LANE_SOL_23`, struct offset 0x25F4 (GPL-3.0 repository, HiSilicon copyright; one header for Hi3519 V101 and Hi3516A V200). Reset value and access type unknown (modelled RW, no reset). Confidence: medium (vendor header for this chip family, not hardware verified).";

        field {
            name = "lane_sol_3";
            desc = "[inferred] Lane sol 3. (vendor header `hi3519v101/mipi_reg.h` field `lane_sol_3`; access and reset unknown, modelled RW)";
            sw = rw;
            hw = r;
        } lane_sol_3[31:16];

        field {
            name = "lane_sol_2";
            desc = "[inferred] Lane sol 2. (vendor header `hi3519v101/mipi_reg.h` field `lane_sol_2`; access and reset unknown, modelled RW)";
            sw = rw;
            hw = r;
        } lane_sol_2[15:0];
    } LVDS1_LANE10_NXT_SOL_23 @ 0x25F4;

    reg {
        name = "LVDS1 LANE10 NXT EOL 01";
        desc = "[inferred] LVDS1 LANE10 NXT EOL 01. Not in the data sheet. Source: OpenIPC openhisilicon `kernel/mipi_rx/hi3519v101/mipi_reg.h` (GPL-3.0 repository, HiSilicon copyright; local copy sources/openhisilicon), union `U_LVDS_LANE_EOL_01`, struct offset 0x25F8 (GPL-3.0 repository, HiSilicon copyright; one header for Hi3519 V101 and Hi3516A V200). Reset value and access type unknown (modelled RW, no reset). Confidence: medium (vendor header for this chip family, not hardware verified).";

        field {
            name = "lane_eol_1";
            desc = "[inferred] Lane eol 1. (vendor header `hi3519v101/mipi_reg.h` field `lane_eol_1`; access and reset unknown, modelled RW)";
            sw = rw;
            hw = r;
        } lane_eol_1[31:16];

        field {
            name = "lane_eol_0";
            desc = "[inferred] Lane eol 0. (vendor header `hi3519v101/mipi_reg.h` field `lane_eol_0`; access and reset unknown, modelled RW)";
            sw = rw;
            hw = r;
        } lane_eol_0[15:0];
    } LVDS1_LANE10_NXT_EOL_01 @ 0x25F8;

    reg {
        name = "LVDS1 LANE10 NXT EOL 23";
        desc = "[inferred] LVDS1 LANE10 NXT EOL 23. Not in the data sheet. Source: OpenIPC openhisilicon `kernel/mipi_rx/hi3519v101/mipi_reg.h` (GPL-3.0 repository, HiSilicon copyright; local copy sources/openhisilicon), union `U_LVDS_LANE_EOL_23`, struct offset 0x25FC (GPL-3.0 repository, HiSilicon copyright; one header for Hi3519 V101 and Hi3516A V200). Reset value and access type unknown (modelled RW, no reset). Confidence: medium (vendor header for this chip family, not hardware verified).";

        field {
            name = "lane_eol_3";
            desc = "[inferred] Lane eol 3. (vendor header `hi3519v101/mipi_reg.h` field `lane_eol_3`; access and reset unknown, modelled RW)";
            sw = rw;
            hw = r;
        } lane_eol_3[31:16];

        field {
            name = "lane_eol_2";
            desc = "[inferred] Lane eol 2. (vendor header `hi3519v101/mipi_reg.h` field `lane_eol_2`; access and reset unknown, modelled RW)";
            sw = rw;
            hw = r;
        } lane_eol_2[15:0];
    } LVDS1_LANE10_NXT_EOL_23 @ 0x25FC;

    reg {
        name = "LVDS1 LANE11 NXT SOF 01";
        desc = "[inferred] LVDS1 LANE11 NXT SOF 01. Not in the data sheet. Source: OpenIPC openhisilicon `kernel/mipi_rx/hi3519v101/mipi_reg.h` (GPL-3.0 repository, HiSilicon copyright; local copy sources/openhisilicon), union `U_LVDS_LANE_SOF_01`, struct offset 0x2600 (GPL-3.0 repository, HiSilicon copyright; one header for Hi3519 V101 and Hi3516A V200). Reset value and access type unknown (modelled RW, no reset). Confidence: medium (vendor header for this chip family, not hardware verified).";

        field {
            name = "lane_sof_1";
            desc = "[inferred] Lane sof 1. (vendor header `hi3519v101/mipi_reg.h` field `lane_sof_1`; access and reset unknown, modelled RW)";
            sw = rw;
            hw = r;
        } lane_sof_1[31:16];

        field {
            name = "lane_sof_0";
            desc = "[inferred] Lane sof 0. (vendor header `hi3519v101/mipi_reg.h` field `lane_sof_0`; access and reset unknown, modelled RW)";
            sw = rw;
            hw = r;
        } lane_sof_0[15:0];
    } LVDS1_LANE11_NXT_SOF_01 @ 0x2600;

    reg {
        name = "LVDS1 LANE11 NXT SOF 23";
        desc = "[inferred] LVDS1 LANE11 NXT SOF 23. Not in the data sheet. Source: OpenIPC openhisilicon `kernel/mipi_rx/hi3519v101/mipi_reg.h` (GPL-3.0 repository, HiSilicon copyright; local copy sources/openhisilicon), union `U_LVDS_LANE_SOF_23`, struct offset 0x2604 (GPL-3.0 repository, HiSilicon copyright; one header for Hi3519 V101 and Hi3516A V200). Reset value and access type unknown (modelled RW, no reset). Confidence: medium (vendor header for this chip family, not hardware verified).";

        field {
            name = "lane_sof_3";
            desc = "[inferred] Lane sof 3. (vendor header `hi3519v101/mipi_reg.h` field `lane_sof_3`; access and reset unknown, modelled RW)";
            sw = rw;
            hw = r;
        } lane_sof_3[31:16];

        field {
            name = "lane_sof_2";
            desc = "[inferred] Lane sof 2. (vendor header `hi3519v101/mipi_reg.h` field `lane_sof_2`; access and reset unknown, modelled RW)";
            sw = rw;
            hw = r;
        } lane_sof_2[15:0];
    } LVDS1_LANE11_NXT_SOF_23 @ 0x2604;

    reg {
        name = "LVDS1 LANE11 NXT EOF 01";
        desc = "[inferred] LVDS1 LANE11 NXT EOF 01. Not in the data sheet. Source: OpenIPC openhisilicon `kernel/mipi_rx/hi3519v101/mipi_reg.h` (GPL-3.0 repository, HiSilicon copyright; local copy sources/openhisilicon), union `U_LVDS_LANE_EOF_01`, struct offset 0x2608 (GPL-3.0 repository, HiSilicon copyright; one header for Hi3519 V101 and Hi3516A V200). Reset value and access type unknown (modelled RW, no reset). Confidence: medium (vendor header for this chip family, not hardware verified).";

        field {
            name = "lane_eof_1";
            desc = "[inferred] Lane eof 1. (vendor header `hi3519v101/mipi_reg.h` field `lane_eof_1`; access and reset unknown, modelled RW)";
            sw = rw;
            hw = r;
        } lane_eof_1[31:16];

        field {
            name = "lane_eof_0";
            desc = "[inferred] Lane eof 0. (vendor header `hi3519v101/mipi_reg.h` field `lane_eof_0`; access and reset unknown, modelled RW)";
            sw = rw;
            hw = r;
        } lane_eof_0[15:0];
    } LVDS1_LANE11_NXT_EOF_01 @ 0x2608;

    reg {
        name = "LVDS1 LANE11 NXT EOF 23";
        desc = "[inferred] LVDS1 LANE11 NXT EOF 23. Not in the data sheet. Source: OpenIPC openhisilicon `kernel/mipi_rx/hi3519v101/mipi_reg.h` (GPL-3.0 repository, HiSilicon copyright; local copy sources/openhisilicon), union `U_LVDS_LANE_EOF_23`, struct offset 0x260C (GPL-3.0 repository, HiSilicon copyright; one header for Hi3519 V101 and Hi3516A V200). Reset value and access type unknown (modelled RW, no reset). Confidence: medium (vendor header for this chip family, not hardware verified).";

        field {
            name = "lane_eof_3";
            desc = "[inferred] Lane eof 3. (vendor header `hi3519v101/mipi_reg.h` field `lane_eof_3`; access and reset unknown, modelled RW)";
            sw = rw;
            hw = r;
        } lane_eof_3[31:16];

        field {
            name = "lane_eof_2";
            desc = "[inferred] Lane eof 2. (vendor header `hi3519v101/mipi_reg.h` field `lane_eof_2`; access and reset unknown, modelled RW)";
            sw = rw;
            hw = r;
        } lane_eof_2[15:0];
    } LVDS1_LANE11_NXT_EOF_23 @ 0x260C;

    reg {
        name = "LVDS1 LANE11 NXT SOL 01";
        desc = "[inferred] LVDS1 LANE11 NXT SOL 01. Not in the data sheet. Source: OpenIPC openhisilicon `kernel/mipi_rx/hi3519v101/mipi_reg.h` (GPL-3.0 repository, HiSilicon copyright; local copy sources/openhisilicon), union `U_LVDS_LANE_SOL_01`, struct offset 0x2610 (GPL-3.0 repository, HiSilicon copyright; one header for Hi3519 V101 and Hi3516A V200). Reset value and access type unknown (modelled RW, no reset). Confidence: medium (vendor header for this chip family, not hardware verified).";

        field {
            name = "lane_sol_1";
            desc = "[inferred] Lane sol 1. (vendor header `hi3519v101/mipi_reg.h` field `lane_sol_1`; access and reset unknown, modelled RW)";
            sw = rw;
            hw = r;
        } lane_sol_1[31:16];

        field {
            name = "lane_sol_0";
            desc = "[inferred] Lane sol 0. (vendor header `hi3519v101/mipi_reg.h` field `lane_sol_0`; access and reset unknown, modelled RW)";
            sw = rw;
            hw = r;
        } lane_sol_0[15:0];
    } LVDS1_LANE11_NXT_SOL_01 @ 0x2610;

    reg {
        name = "LVDS1 LANE11 NXT SOL 23";
        desc = "[inferred] LVDS1 LANE11 NXT SOL 23. Not in the data sheet. Source: OpenIPC openhisilicon `kernel/mipi_rx/hi3519v101/mipi_reg.h` (GPL-3.0 repository, HiSilicon copyright; local copy sources/openhisilicon), union `U_LVDS_LANE_SOL_23`, struct offset 0x2614 (GPL-3.0 repository, HiSilicon copyright; one header for Hi3519 V101 and Hi3516A V200). Reset value and access type unknown (modelled RW, no reset). Confidence: medium (vendor header for this chip family, not hardware verified).";

        field {
            name = "lane_sol_3";
            desc = "[inferred] Lane sol 3. (vendor header `hi3519v101/mipi_reg.h` field `lane_sol_3`; access and reset unknown, modelled RW)";
            sw = rw;
            hw = r;
        } lane_sol_3[31:16];

        field {
            name = "lane_sol_2";
            desc = "[inferred] Lane sol 2. (vendor header `hi3519v101/mipi_reg.h` field `lane_sol_2`; access and reset unknown, modelled RW)";
            sw = rw;
            hw = r;
        } lane_sol_2[15:0];
    } LVDS1_LANE11_NXT_SOL_23 @ 0x2614;

    reg {
        name = "LVDS1 LANE11 NXT EOL 01";
        desc = "[inferred] LVDS1 LANE11 NXT EOL 01. Not in the data sheet. Source: OpenIPC openhisilicon `kernel/mipi_rx/hi3519v101/mipi_reg.h` (GPL-3.0 repository, HiSilicon copyright; local copy sources/openhisilicon), union `U_LVDS_LANE_EOL_01`, struct offset 0x2618 (GPL-3.0 repository, HiSilicon copyright; one header for Hi3519 V101 and Hi3516A V200). Reset value and access type unknown (modelled RW, no reset). Confidence: medium (vendor header for this chip family, not hardware verified).";

        field {
            name = "lane_eol_1";
            desc = "[inferred] Lane eol 1. (vendor header `hi3519v101/mipi_reg.h` field `lane_eol_1`; access and reset unknown, modelled RW)";
            sw = rw;
            hw = r;
        } lane_eol_1[31:16];

        field {
            name = "lane_eol_0";
            desc = "[inferred] Lane eol 0. (vendor header `hi3519v101/mipi_reg.h` field `lane_eol_0`; access and reset unknown, modelled RW)";
            sw = rw;
            hw = r;
        } lane_eol_0[15:0];
    } LVDS1_LANE11_NXT_EOL_01 @ 0x2618;

    reg {
        name = "LVDS1 LANE11 NXT EOL 23";
        desc = "[inferred] LVDS1 LANE11 NXT EOL 23. Not in the data sheet. Source: OpenIPC openhisilicon `kernel/mipi_rx/hi3519v101/mipi_reg.h` (GPL-3.0 repository, HiSilicon copyright; local copy sources/openhisilicon), union `U_LVDS_LANE_EOL_23`, struct offset 0x261C (GPL-3.0 repository, HiSilicon copyright; one header for Hi3519 V101 and Hi3516A V200). Reset value and access type unknown (modelled RW, no reset). Confidence: medium (vendor header for this chip family, not hardware verified).";

        field {
            name = "lane_eol_3";
            desc = "[inferred] Lane eol 3. (vendor header `hi3519v101/mipi_reg.h` field `lane_eol_3`; access and reset unknown, modelled RW)";
            sw = rw;
            hw = r;
        } lane_eol_3[31:16];

        field {
            name = "lane_eol_2";
            desc = "[inferred] Lane eol 2. (vendor header `hi3519v101/mipi_reg.h` field `lane_eol_2`; access and reset unknown, modelled RW)";
            sw = rw;
            hw = r;
        } lane_eol_2[15:0];
    } LVDS1_LANE11_NXT_EOL_23 @ 0x261C;

    reg {
        name = "LVDS DOL mode frame 0 LI register WORD0";
        desc = "LVDS1_LI_WORD0 is an LVDS DOL mode frame 0 LI register.

Data sheet 9.3.6 LVDS1_LI_WORD0 (offset 0x2620, printed page 9-464, `hi3516av200--Hi3516AV200-Datasheet.txt` line 64777).";

        field {
            name = "lvds1_li_word0_1";
            desc = "LEF line information in DOL mode (for frame N + 1)";
            sw = rw;
            hw = r;
            reset = 0x211;
        } lvds1_li_word0_1[31:16];

        field {
            name = "lvds1_li_word0_0";
            desc = "LEF line information in DOL mode (for frame N)";
            sw = rw;
            hw = r;
            reset = 0x201;
        } lvds1_li_word0_0[15:0];
    } LVDS1_LI_WORD0 @ 0x2620;

    reg {
        name = "LVDS DOL mode frame 1 LI register WORD1";
        desc = "LVDS1_LI_WORD1 is an LVDS DOL mode frame 1 LI register. Hi3516A V200 Professional HD IP Camera SoC

Data sheet 9.3.6 LVDS1_LI_WORD1 (offset 0x2624, printed page 9-465, `hi3516av200--Hi3516AV200-Datasheet.txt` line 64807).";

        field {
            name = "lvds1_li_word1_1";
            desc = "SEF 1 line information in DOL mode (for frame N + 1)";
            sw = rw;
            hw = r;
            reset = 0x212;
        } lvds1_li_word1_1[31:16];

        field {
            name = "lvds1_li_word1_0";
            desc = "SEF 1 line information in DOL mode (for frame N)";
            sw = rw;
            hw = r;
            reset = 0x202;
        } lvds1_li_word1_0[15:0];
    } LVDS1_LI_WORD1 @ 0x2624;

    reg {
        name = "LVDS DOL mode frame 2 LI register WORD2";
        desc = "LVDS1_LI_WORD2 is an LVDS DOL mode frame 2 LI register.

Data sheet 9.3.6 LVDS1_LI_WORD2 (offset 0x2628, printed page 9-465, `hi3516av200--Hi3516AV200-Datasheet.txt` line 64826).";

        field {
            name = "lvds1_li_word2_1";
            desc = "SEF 2 line information in DOL mode (for frame N + 1)";
            sw = rw;
            hw = r;
            reset = 0x214;
        } lvds1_li_word2_1[31:16];

        field {
            name = "lvds1_li_word2_0";
            desc = "SEF 2 line information in DOL mode (for frame";
            sw = rw;
            hw = r;
            reset = 0x204;
        } lvds1_li_word2_0[15:0];
    } LVDS1_LI_WORD2 @ 0x2628;

    reg {
        name = "LVDS DOL mode frame 3 LI register WORD3";
        desc = "LVDS1_LI_WORD3 is an LVDS DOL mode frame 3 LI register.

Data sheet 9.3.6 LVDS1_LI_WORD3 (offset 0x262C, printed page 9-465, `hi3516av200--Hi3516AV200-Datasheet.txt` line 64846).";

        field {
            name = "lvds1_li_word3_1";
            desc = "SEF 3 line information in DOL mode (for frame + 1)";
            sw = rw;
            hw = r;
            reset = 0x218;
        } lvds1_li_word3_1[31:16];

        field {
            name = "lvds1_li_word3_0";
            desc = "SEF 3 line information in DOL mode (for frame";
            sw = rw;
            hw = r;
            reset = 0x208;
        } lvds1_li_word3_0[15:0];
    } LVDS1_LI_WORD3 @ 0x262C;

    reg {
        name = "LVDS1 lane IMGSIZE STATIS";
        desc = "[inferred] LVDS1 lane IMGSIZE STATIS. Array of 12 consecutive 32-bit words (header `LVDS1_LANE_IMGSIZE_STATIS[12]`). Not in the data sheet. Source: OpenIPC openhisilicon `kernel/mipi_rx/hi3519v101/mipi_reg.h` (GPL-3.0 repository, HiSilicon copyright; local copy sources/openhisilicon), union `U_LVDS_LANE_IMGSIZE_STATIS`, struct offset 0x2640 (GPL-3.0 repository, HiSilicon copyright; one header for Hi3519 V101 and Hi3516A V200). Reset value and access type unknown (modelled RW, no reset). Confidence: medium (vendor header for this chip family, not hardware verified).";

        field {
            name = "lane_imgheight";
            desc = "[inferred] Lane imgheight. (vendor header `hi3519v101/mipi_reg.h` field `lane_imgheight`; access and reset unknown, modelled RW)";
            sw = rw;
            hw = r;
        } lane_imgheight[31:16];

        field {
            name = "lane_imgwidth";
            desc = "[inferred] Lane imgwidth. (vendor header `hi3519v101/mipi_reg.h` field `lane_imgwidth`; access and reset unknown, modelled RW)";
            sw = rw;
            hw = r;
        } lane_imgwidth[15:0];
    } LVDS1_LANE_IMGSIZE_STATIS[12] @ 0x2640 += 0x4;

    reg {
        name = "LVDS 1 CTRL read data sequence NE_ORDER selection register 2 S2";
        desc = "LVDS1_LANE_ORDERS2 is LVDS 1 CTRL read data sequence selection register 2.

Data sheet 9.3.6 LVDS1_LANE_ORDERS2 (offset 0x2678, printed page 9-466, `hi3516av200--Hi3516AV200-Datasheet.txt` line 64871).";

        field {
            name = "LVDS_LANE11";
            desc = "LVDS_LANE11 data ID";
            sw = rw;
            hw = r;
            reset = 0x3;
        } LVDS_LANE11[15:12];

        field {
            name = "LVDS_LANE10";
            desc = "LVDS_LANE10 data ID";
            sw = rw;
            hw = r;
            reset = 0x2;
        } LVDS_LANE10[11:8];

        field {
            name = "LVDS_LANE9";
            desc = "LVDS_LANE9 data ID";
            sw = rw;
            hw = r;
            reset = 0x1;
        } LVDS_LANE9[7:4];

        field {
            name = "LVDS_LANE8";
            desc = "LVDS_LANE8 data ID";
            sw = rw;
            hw = r;
            reset = 0x0;
        } LVDS_LANE8[3:0];
    } LVDS1_LANE_ORDERS2 @ 0x2678;

    reg {
        name = "LVDS 1 LEF image size statistics register SIZE0_STAT IS";
        desc = "LVDS1_IMGSIZE0_STATIS is an LVDS 1 LEF image size statistics register.

Data sheet 9.3.6 LVDS1_IMGSIZE0_STATIS (offset 0x2680, printed page 9-466, `hi3516av200--Hi3516AV200-Datasheet.txt` line 64904).";

        field {
            name = "lvds1_imgheight0";
            desc = "Height of the image transferred by virtual channel 0 in LVDS or HiSPi mode";
            sw = r;
            hw = w;
            reset = 0x0;
        } lvds1_imgheight0[31:16];

        field {
            name = "lvds1_imgwidth0";
            desc = "Width of the image transferred by virtual channel 0 in LVDS or HiSPi mode";
            sw = r;
            hw = w;
            reset = 0x0;
        } lvds1_imgwidth0[15:0];
    } LVDS1_IMGSIZE0_STATIS @ 0x2680;

    reg {
        name = "LVDS 1 SEF 1 image size statistics SIZE1_STAT register IS";
        desc = "LVDS1_IMGSIZE1_STATIS is an LVDS 1 SEF 1 image size statistics register. Hi3516A V200 Professional HD IP Camera SoC

Data sheet 9.3.6 LVDS1_IMGSIZE1_STATIS (offset 0x2684, printed page 9-467, `hi3516av200--Hi3516AV200-Datasheet.txt` line 64937).";

        field {
            name = "lvds1_imgheight1";
            desc = "Height of the image transferred by virtual channel 1 in LVDS or HiSPi mode";
            sw = r;
            hw = w;
            reset = 0x0;
        } lvds1_imgheight1[31:16];

        field {
            name = "lvds1_imgwidth1";
            desc = "Width of the image transferred by virtual channel 1 in LVDS or HiSPi mode";
            sw = r;
            hw = w;
            reset = 0x0;
        } lvds1_imgwidth1[15:0];
    } LVDS1_IMGSIZE1_STATIS @ 0x2684;

    reg {
        name = "LVDS 1 SEF 2 image size statistics SIZE2_STAT register IS";
        desc = "LVDS1_IMGSIZE2_STATIS is an LVDS 1 SEF 2 image size statistics register.

Data sheet 9.3.6 LVDS1_IMGSIZE2_STATIS (offset 0x2688, printed page 9-467, `hi3516av200--Hi3516AV200-Datasheet.txt` line 64960).";

        field {
            name = "lvds1_imgheight2";
            desc = "Height of the image transferred by virtual channel 2 in LVDS or HiSPi mode";
            sw = r;
            hw = w;
            reset = 0x0;
        } lvds1_imgheight2[31:16];

        field {
            name = "lvds1_imgwidth2";
            desc = "Width of the image transferred by virtual channel 2 in LVDS or HiSPi mode";
            sw = r;
            hw = w;
            reset = 0x0;
        } lvds1_imgwidth2[15:0];
    } LVDS1_IMGSIZE2_STATIS @ 0x2688;

    reg {
        name = "LVDS 1 SEF 3 image size statistics SIZE3_STAT register IS";
        desc = "LVDS1_IMGSIZE3_STATIS is an LVDS 1 SEF 3 image size statistics register. Hi3516A V200 Professional HD IP Camera SoC

Data sheet 9.3.6 LVDS1_IMGSIZE3_STATIS (offset 0x268C, printed page 9-468, `hi3516av200--Hi3516AV200-Datasheet.txt` line 64993).";

        field {
            name = "lvds1_imgheight3";
            desc = "Height of the image transferred by virtual channel 3 in LVDS or HiSPi mode";
            sw = r;
            hw = w;
            reset = 0x0;
        } lvds1_imgheight3[31:16];

        field {
            name = "lvds1_imgwidth3";
            desc = "Width of the image transferred by virtual channel 3 in LVDS or HiSPi mode";
            sw = r;
            hw = w;
            reset = 0x0;
        } lvds1_imgwidth3[15:0];
    } LVDS1_IMGSIZE3_STATIS @ 0x268C;

    reg {
        name = "LVDS 1 read data raw interrupt status L_INT_RAW register";
        desc = "LVDS1_CTRL_INT_RAW is an LVDS 1 read data raw interrupt status register.

Data sheet 9.3.6 LVDS1_CTRL_INT_RAW (offset 0x26F0, printed page 9-468, `hi3516av200--Hi3516AV200-Datasheet.txt` line 65016).";

        field {
            name = "link2_rderr_raw";
            desc = "[inferred] Link2 rderr raw. (bits reserved in the data sheet; vendor header `hi3519v101/mipi_reg.h` field `link2_rderr_raw`; access and reset unknown, modelled RW)";
            sw = rw;
            hw = r;
        } link2_rderr_raw[26:26];

        field {
            name = "link1_rderr_raw";
            desc = "[inferred] Link1 rderr raw. (bits reserved in the data sheet; vendor header `hi3519v101/mipi_reg.h` field `link1_rderr_raw`; access and reset unknown, modelled RW)";
            sw = rw;
            hw = r;
        } link1_rderr_raw[25:25];

        enum LVDS1_CTRL_INT_RAW_lvds1_link0_rderr_raw_enum {
            NO_RAW_INTERRUPT = 0 { name = "No Raw Interrupt"; desc = "No raw interrupt is generated."; };
            RAW_INTERRUPT_GENERATED = 1 { name = "Raw Interrupt Generated"; desc = "A raw interrupt is generated."; };
        };

        field {
            name = "lvds1_link0_rderr_raw";
            desc = "Link 0 read data error raw interrupt status";
            sw = rw;
            hw = w;
            onwrite = woclr;
            encode = LVDS1_CTRL_INT_RAW_lvds1_link0_rderr_raw_enum;
            reset = 0x0;
        } lvds1_link0_rderr_raw[24:24];

        enum LVDS1_CTRL_INT_RAW_lvds1_lvds_stat_err_raw_enum {
            NO_RAW_INTERRUPT = 0 { name = "No Raw Interrupt"; desc = "No raw interrupt is generated."; };
            RAW_INTERRUPT_GENERATED = 1 { name = "Raw Interrupt Generated"; desc = "A raw interrupt is generated."; };
        };

        field {
            name = "lvds1_lvds_stat_err_raw";
            desc = "LVDS status error raw interrupt status";
            sw = rw;
            hw = w;
            onwrite = woclr;
            encode = LVDS1_CTRL_INT_RAW_lvds1_lvds_stat_err_raw_enum;
            reset = 0x0;
        } lvds1_lvds_stat_err_raw[21:21];

        field {
            name = "lane11_sync_err_raw";
            desc = "[inferred] Lane11 sync error raw. (bits reserved in the data sheet; vendor header `hi3519v101/mipi_reg.h` field `lane11_sync_err_raw`; access and reset unknown, modelled RW)";
            sw = rw;
            hw = r;
        } lane11_sync_err_raw[20:20];

        field {
            name = "lane10_sync_err_raw";
            desc = "[inferred] Lane10 sync error raw. (bits reserved in the data sheet; vendor header `hi3519v101/mipi_reg.h` field `lane10_sync_err_raw`; access and reset unknown, modelled RW)";
            sw = rw;
            hw = r;
        } lane10_sync_err_raw[19:19];

        field {
            name = "lane9_sync_err_raw";
            desc = "[inferred] Lane9 sync error raw. (bits reserved in the data sheet; vendor header `hi3519v101/mipi_reg.h` field `lane9_sync_err_raw`; access and reset unknown, modelled RW)";
            sw = rw;
            hw = r;
        } lane9_sync_err_raw[18:18];

        field {
            name = "lane8_sync_err_raw";
            desc = "[inferred] Lane8 sync error raw. (bits reserved in the data sheet; vendor header `hi3519v101/mipi_reg.h` field `lane8_sync_err_raw`; access and reset unknown, modelled RW)";
            sw = rw;
            hw = r;
        } lane8_sync_err_raw[17:17];

        field {
            name = "lane7_sync_err_raw";
            desc = "[inferred] Lane7 sync error raw. (bits reserved in the data sheet; vendor header `hi3519v101/mipi_reg.h` field `lane7_sync_err_raw`; access and reset unknown, modelled RW)";
            sw = rw;
            hw = r;
        } lane7_sync_err_raw[16:16];

        field {
            name = "lane6_sync_err_raw";
            desc = "[inferred] Lane6 sync error raw. (bits reserved in the data sheet; vendor header `hi3519v101/mipi_reg.h` field `lane6_sync_err_raw`; access and reset unknown, modelled RW)";
            sw = rw;
            hw = r;
        } lane6_sync_err_raw[15:15];

        field {
            name = "lane5_sync_err_raw";
            desc = "[inferred] Lane5 sync error raw. (bits reserved in the data sheet; vendor header `hi3519v101/mipi_reg.h` field `lane5_sync_err_raw`; access and reset unknown, modelled RW)";
            sw = rw;
            hw = r;
        } lane5_sync_err_raw[14:14];

        field {
            name = "lane4_sync_err_raw";
            desc = "[inferred] Lane4 sync error raw. (bits reserved in the data sheet; vendor header `hi3519v101/mipi_reg.h` field `lane4_sync_err_raw`; access and reset unknown, modelled RW)";
            sw = rw;
            hw = r;
        } lane4_sync_err_raw[13:13];

        enum LVDS1_CTRL_INT_RAW_lvds1_lane3_sync_err_raw_enum {
            NO_RAW_INTERRUPT = 0 { name = "No Raw Interrupt"; desc = "No raw interrupt is generated."; };
            RAW_INTERRUPT_GENERATED = 1 { name = "Raw Interrupt Generated"; desc = "A raw interrupt is generated."; };
        };

        field {
            name = "lvds1_lane3_sync_err_raw";
            desc = "Lane 3 synchronization error raw interrupt status";
            sw = rw;
            hw = w;
            onwrite = woclr;
            encode = LVDS1_CTRL_INT_RAW_lvds1_lane3_sync_err_raw_enum;
            reset = 0x0;
        } lvds1_lane3_sync_err_raw[12:12];

        enum LVDS1_CTRL_INT_RAW_lvds1_lane2_sync_err_raw_enum {
            NO_RAW_INTERRUPT = 0 { name = "No Raw Interrupt"; desc = "No raw interrupt is generated."; };
            RAW_INTERRUPT_GENERATED = 1 { name = "Raw Interrupt Generated"; desc = "A raw interrupt is generated."; };
        };

        field {
            name = "lvds1_lane2_sync_err_raw";
            desc = "Lane 2 synchronization error raw interrupt status";
            sw = rw;
            hw = w;
            onwrite = woclr;
            encode = LVDS1_CTRL_INT_RAW_lvds1_lane2_sync_err_raw_enum;
            reset = 0x0;
        } lvds1_lane2_sync_err_raw[11:11];

        enum LVDS1_CTRL_INT_RAW_lvds1_lane1_sync_err_raw_enum {
            NO_RAW_INTERRUPT = 0 { name = "No Raw Interrupt"; desc = "No raw interrupt is generated."; };
            RAW_INTERRUPT_GENERATED = 1 { name = "Raw Interrupt Generated"; desc = "A raw interrupt is generated."; };
        };

        field {
            name = "lvds1_lane1_sync_err_raw";
            desc = "Lane 1 synchronization error raw interrupt status";
            sw = rw;
            hw = w;
            onwrite = woclr;
            encode = LVDS1_CTRL_INT_RAW_lvds1_lane1_sync_err_raw_enum;
            reset = 0x0;
        } lvds1_lane1_sync_err_raw[10:10];

        enum LVDS1_CTRL_INT_RAW_lvds1_lane0_sync_err_raw_enum {
            NO_RAW_INTERRUPT = 0 { name = "No Raw Interrupt"; desc = "No raw interrupt is generated."; };
            RAW_INTERRUPT_GENERATED = 1 { name = "Raw Interrupt Generated"; desc = "A raw interrupt is generated."; };
        };

        field {
            name = "lvds1_lane0_sync_err_raw";
            desc = "Lane 0 synchronization error raw interrupt status";
            sw = rw;
            hw = w;
            onwrite = woclr;
            encode = LVDS1_CTRL_INT_RAW_lvds1_lane0_sync_err_raw_enum;
            reset = 0x0;
        } lvds1_lane0_sync_err_raw[9:9];

        field {
            name = "link2_hsync_err_raw";
            desc = "[inferred] Link2 horizontal sync error raw. (bits reserved in the data sheet; vendor header `hi3519v101/mipi_reg.h` field `link2_hsync_err_raw`; access and reset unknown, modelled RW)";
            sw = rw;
            hw = r;
        } link2_hsync_err_raw[8:8];

        field {
            name = "link2_vsync_err_raw";
            desc = "[inferred] Link2 vertical sync error raw. (bits reserved in the data sheet; vendor header `hi3519v101/mipi_reg.h` field `link2_vsync_err_raw`; access and reset unknown, modelled RW)";
            sw = rw;
            hw = r;
        } link2_vsync_err_raw[7:7];

        field {
            name = "link2_wrerr_raw";
            desc = "[inferred] Link2 wrerr raw. (bits reserved in the data sheet; vendor header `hi3519v101/mipi_reg.h` field `link2_wrerr_raw`; access and reset unknown, modelled RW)";
            sw = rw;
            hw = r;
        } link2_wrerr_raw[6:6];

        field {
            name = "link1_hsync_err_raw";
            desc = "[inferred] Link1 horizontal sync error raw. (bits reserved in the data sheet; vendor header `hi3519v101/mipi_reg.h` field `link1_hsync_err_raw`; access and reset unknown, modelled RW)";
            sw = rw;
            hw = r;
        } link1_hsync_err_raw[5:5];

        field {
            name = "link1_vsync_err_raw";
            desc = "[inferred] Link1 vertical sync error raw. (bits reserved in the data sheet; vendor header `hi3519v101/mipi_reg.h` field `link1_vsync_err_raw`; access and reset unknown, modelled RW)";
            sw = rw;
            hw = r;
        } link1_vsync_err_raw[4:4];

        field {
            name = "link1_wrerr_raw";
            desc = "[inferred] Link1 wrerr raw. (bits reserved in the data sheet; vendor header `hi3519v101/mipi_reg.h` field `link1_wrerr_raw`; access and reset unknown, modelled RW)";
            sw = rw;
            hw = r;
        } link1_wrerr_raw[3:3];

        enum LVDS1_CTRL_INT_RAW_lvds1_link0_hsync_err_raw_enum {
            NO_RAW_INTERRUPT = 0 { name = "No Raw Interrupt"; desc = "No raw interrupt is generated."; };
            RAW_INTERRUPT_GENERATED = 1 { name = "Raw Interrupt Generated"; desc = "A raw interrupt is generated."; };
        };

        field {
            name = "lvds1_link0_hsync_err_raw";
            desc = "Link 0 HS error raw interrupt status";
            sw = rw;
            hw = w;
            onwrite = woclr;
            encode = LVDS1_CTRL_INT_RAW_lvds1_link0_hsync_err_raw_enum;
            reset = 0x0;
        } lvds1_link0_hsync_err_raw[2:2];

        enum LVDS1_CTRL_INT_RAW_lvds1_link0_vsync_err_raw_enum {
            NO_RAW_INTERRUPT = 0 { name = "No Raw Interrupt"; desc = "No raw interrupt is generated."; };
            RAW_INTERRUPT_GENERATED = 1 { name = "Raw Interrupt Generated"; desc = "A raw interrupt is generated."; };
        };

        field {
            name = "lvds1_link0_vsync_err_raw";
            desc = "Link 0 VS error raw interrupt status";
            sw = rw;
            hw = w;
            onwrite = woclr;
            encode = LVDS1_CTRL_INT_RAW_lvds1_link0_vsync_err_raw_enum;
            reset = 0x0;
        } lvds1_link0_vsync_err_raw[1:1];

        enum LVDS1_CTRL_INT_RAW_lvds1_link0_wrerr_raw_enum {
            NO_RAW_INTERRUPT = 0 { name = "No Raw Interrupt"; desc = "No raw interrupt is generated."; };
            RAW_INTERRUPT_GENERATED = 1 { name = "Raw Interrupt Generated"; desc = "A raw interrupt is generated."; };
        };

        field {
            name = "lvds1_link0_wrerr_raw";
            desc = "Link 0 write data error raw interrupt status";
            sw = rw;
            hw = w;
            onwrite = woclr;
            encode = LVDS1_CTRL_INT_RAW_lvds1_link0_wrerr_raw_enum;
            reset = 0x0;
        } lvds1_link0_wrerr_raw[0:0];
    } LVDS1_CTRL_INT_RAW @ 0x26F0;

    reg {
        name = "LVDS 1 read data interrupt status register L_INT";
        desc = "LVDS1_CTRL_INT is an LVDS 1 read data interrupt status register. Hi3516A V200 Professional HD IP Camera SoC

Data sheet 9.3.6 LVDS1_CTRL_INT (offset 0x26F4, printed page 9-470, `hi3516av200--Hi3516AV200-Datasheet.txt` line 65110).";

        field {
            name = "link2_rderr_st";
            desc = "[inferred] Link2 rderr st. (bits reserved in the data sheet; vendor header `hi3519v101/mipi_reg.h` field `link2_rderr_st`; access and reset unknown, modelled RW)";
            sw = rw;
            hw = r;
        } link2_rderr_st[26:26];

        field {
            name = "link1_rderr_st";
            desc = "[inferred] Link1 rderr st. (bits reserved in the data sheet; vendor header `hi3519v101/mipi_reg.h` field `link1_rderr_st`; access and reset unknown, modelled RW)";
            sw = rw;
            hw = r;
        } link1_rderr_st[25:25];

        enum LVDS1_CTRL_INT_lvds1_link0_rderr_st_enum {
            NO_INTERRUPT_GENERATED = 0 { name = "No Interrupt Generated"; desc = "No interrupt is generated."; };
            INTERRUPT_GENERATED = 1 { name = "Interrupt Generated"; desc = "An interrupt is generated."; };
        };

        field {
            name = "lvds1_link0_rderr_st";
            desc = "Link 0 read data error interrupt status";
            sw = r;
            hw = w;
            encode = LVDS1_CTRL_INT_lvds1_link0_rderr_st_enum;
            reset = 0x0;
        } lvds1_link0_rderr_st[24:24];

        enum LVDS1_CTRL_INT_lvds1_lvds_stat_err_st_enum {
            NO_INTERRUPT_GENERATED = 0 { name = "No Interrupt Generated"; desc = "No interrupt is generated."; };
            INTERRUPT_GENERATED = 1 { name = "Interrupt Generated"; desc = "An interrupt is generated."; };
        };

        field {
            name = "lvds1_lvds_stat_err_st";
            desc = "LVDS status error interrupt status";
            sw = r;
            hw = w;
            encode = LVDS1_CTRL_INT_lvds1_lvds_stat_err_st_enum;
            reset = 0x0;
        } lvds1_lvds_stat_err_st[21:21];

        field {
            name = "lane11_sync_err_st";
            desc = "[inferred] Lane11 sync error st. (bits reserved in the data sheet; vendor header `hi3519v101/mipi_reg.h` field `lane11_sync_err_st`; access and reset unknown, modelled RW)";
            sw = rw;
            hw = r;
        } lane11_sync_err_st[20:20];

        field {
            name = "lane10_sync_err_st";
            desc = "[inferred] Lane10 sync error st. (bits reserved in the data sheet; vendor header `hi3519v101/mipi_reg.h` field `lane10_sync_err_st`; access and reset unknown, modelled RW)";
            sw = rw;
            hw = r;
        } lane10_sync_err_st[19:19];

        field {
            name = "lane9_sync_err_st";
            desc = "[inferred] Lane9 sync error st. (bits reserved in the data sheet; vendor header `hi3519v101/mipi_reg.h` field `lane9_sync_err_st`; access and reset unknown, modelled RW)";
            sw = rw;
            hw = r;
        } lane9_sync_err_st[18:18];

        field {
            name = "lane8_sync_err_st";
            desc = "[inferred] Lane8 sync error st. (bits reserved in the data sheet; vendor header `hi3519v101/mipi_reg.h` field `lane8_sync_err_st`; access and reset unknown, modelled RW)";
            sw = rw;
            hw = r;
        } lane8_sync_err_st[17:17];

        field {
            name = "lane7_sync_err_st";
            desc = "[inferred] Lane7 sync error st. (bits reserved in the data sheet; vendor header `hi3519v101/mipi_reg.h` field `lane7_sync_err_st`; access and reset unknown, modelled RW)";
            sw = rw;
            hw = r;
        } lane7_sync_err_st[16:16];

        field {
            name = "lane6_sync_err_st";
            desc = "[inferred] Lane6 sync error st. (bits reserved in the data sheet; vendor header `hi3519v101/mipi_reg.h` field `lane6_sync_err_st`; access and reset unknown, modelled RW)";
            sw = rw;
            hw = r;
        } lane6_sync_err_st[15:15];

        field {
            name = "lane5_sync_err_st";
            desc = "[inferred] Lane5 sync error st. (bits reserved in the data sheet; vendor header `hi3519v101/mipi_reg.h` field `lane5_sync_err_st`; access and reset unknown, modelled RW)";
            sw = rw;
            hw = r;
        } lane5_sync_err_st[14:14];

        field {
            name = "lane4_sync_err_st";
            desc = "[inferred] Lane4 sync error st. (bits reserved in the data sheet; vendor header `hi3519v101/mipi_reg.h` field `lane4_sync_err_st`; access and reset unknown, modelled RW)";
            sw = rw;
            hw = r;
        } lane4_sync_err_st[13:13];

        enum LVDS1_CTRL_INT_lvds1_lane3_sync_err_st_enum {
            NO_INTERRUPT_GENERATED = 0 { name = "No Interrupt Generated"; desc = "No interrupt is generated."; };
            INTERRUPT_GENERATED = 1 { name = "Interrupt Generated"; desc = "An interrupt is generated."; };
        };

        field {
            name = "lvds1_lane3_sync_err_st";
            desc = "Lane 3 synchronization error interrupt status";
            sw = r;
            hw = w;
            encode = LVDS1_CTRL_INT_lvds1_lane3_sync_err_st_enum;
            reset = 0x0;
        } lvds1_lane3_sync_err_st[12:12];

        enum LVDS1_CTRL_INT_lvds1_lane2_sync_err_st_enum {
            NO_INTERRUPT_GENERATED = 0 { name = "No Interrupt Generated"; desc = "No interrupt is generated."; };
            INTERRUPT_GENERATED = 1 { name = "Interrupt Generated"; desc = "An interrupt is generated."; };
        };

        field {
            name = "lvds1_lane2_sync_err_st";
            desc = "Lane 2 synchronization error interrupt status";
            sw = r;
            hw = w;
            encode = LVDS1_CTRL_INT_lvds1_lane2_sync_err_st_enum;
            reset = 0x0;
        } lvds1_lane2_sync_err_st[11:11];

        enum LVDS1_CTRL_INT_lvds1_lane1_sync_err_st_enum {
            NO_INTERRUPT_GENERATED = 0 { name = "No Interrupt Generated"; desc = "No interrupt is generated."; };
            INTERRUPT_GENERATED = 1 { name = "Interrupt Generated"; desc = "An interrupt is generated."; };
        };

        field {
            name = "lvds1_lane1_sync_err_st";
            desc = "Lane 1 synchronization error interrupt status";
            sw = r;
            hw = w;
            encode = LVDS1_CTRL_INT_lvds1_lane1_sync_err_st_enum;
            reset = 0x0;
        } lvds1_lane1_sync_err_st[10:10];

        enum LVDS1_CTRL_INT_lvds1_lane0_sync_err_st_enum {
            NO_INTERRUPT_GENERATED = 0 { name = "No Interrupt Generated"; desc = "No interrupt is generated."; };
            INTERRUPT_GENERATED = 1 { name = "Interrupt Generated"; desc = "An interrupt is generated."; };
        };

        field {
            name = "lvds1_lane0_sync_err_st";
            desc = "Lane 0 synchronization error interrupt status";
            sw = r;
            hw = w;
            encode = LVDS1_CTRL_INT_lvds1_lane0_sync_err_st_enum;
            reset = 0x0;
        } lvds1_lane0_sync_err_st[9:9];

        field {
            name = "link2_hsync_err_st";
            desc = "[inferred] Link2 horizontal sync error st. (bits reserved in the data sheet; vendor header `hi3519v101/mipi_reg.h` field `link2_hsync_err_st`; access and reset unknown, modelled RW)";
            sw = rw;
            hw = r;
        } link2_hsync_err_st[8:8];

        field {
            name = "link2_vsync_err_st";
            desc = "[inferred] Link2 vertical sync error st. (bits reserved in the data sheet; vendor header `hi3519v101/mipi_reg.h` field `link2_vsync_err_st`; access and reset unknown, modelled RW)";
            sw = rw;
            hw = r;
        } link2_vsync_err_st[7:7];

        field {
            name = "link2_wrerr_st";
            desc = "[inferred] Link2 wrerr st. (bits reserved in the data sheet; vendor header `hi3519v101/mipi_reg.h` field `link2_wrerr_st`; access and reset unknown, modelled RW)";
            sw = rw;
            hw = r;
        } link2_wrerr_st[6:6];

        field {
            name = "link1_hsync_err_st";
            desc = "[inferred] Link1 horizontal sync error st. (bits reserved in the data sheet; vendor header `hi3519v101/mipi_reg.h` field `link1_hsync_err_st`; access and reset unknown, modelled RW)";
            sw = rw;
            hw = r;
        } link1_hsync_err_st[5:5];

        field {
            name = "link1_vsync_err_st";
            desc = "[inferred] Link1 vertical sync error st. (bits reserved in the data sheet; vendor header `hi3519v101/mipi_reg.h` field `link1_vsync_err_st`; access and reset unknown, modelled RW)";
            sw = rw;
            hw = r;
        } link1_vsync_err_st[4:4];

        field {
            name = "link1_wrerr_st";
            desc = "[inferred] Link1 wrerr st. (bits reserved in the data sheet; vendor header `hi3519v101/mipi_reg.h` field `link1_wrerr_st`; access and reset unknown, modelled RW)";
            sw = rw;
            hw = r;
        } link1_wrerr_st[3:3];

        enum LVDS1_CTRL_INT_lvds1_link0_hsync_err_st_enum {
            NO_INTERRUPT_GENERATED = 0 { name = "No Interrupt Generated"; desc = "No interrupt is generated."; };
            INTERRUPT_GENERATED = 1 { name = "Interrupt Generated"; desc = "An interrupt is generated."; };
        };

        field {
            name = "lvds1_link0_hsync_err_st";
            desc = "Link 0 HS error interrupt status";
            sw = r;
            hw = w;
            encode = LVDS1_CTRL_INT_lvds1_link0_hsync_err_st_enum;
            reset = 0x0;
        } lvds1_link0_hsync_err_st[2:2];

        enum LVDS1_CTRL_INT_lvds1_link0_vsync_err_st_enum {
            NO_INTERRUPT_GENERATED = 0 { name = "No Interrupt Generated"; desc = "No interrupt is generated."; };
            INTERRUPT_GENERATED = 1 { name = "Interrupt Generated"; desc = "An interrupt is generated."; };
        };

        field {
            name = "lvds1_link0_vsync_err_st";
            desc = "Link 0 VS error interrupt status";
            sw = r;
            hw = w;
            encode = LVDS1_CTRL_INT_lvds1_link0_vsync_err_st_enum;
            reset = 0x0;
        } lvds1_link0_vsync_err_st[1:1];

        enum LVDS1_CTRL_INT_lvds1_link0_wrerr_st_enum {
            NO_INTERRUPT_GENERATED = 0 { name = "No Interrupt Generated"; desc = "No interrupt is generated."; };
            INTERRUPT_GENERATED = 1 { name = "Interrupt Generated"; desc = "An interrupt is generated."; };
        };

        field {
            name = "lvds1_link0_wrerr_st";
            desc = "Link 0 write data error interrupt status";
            sw = r;
            hw = w;
            encode = LVDS1_CTRL_INT_lvds1_link0_wrerr_st_enum;
            reset = 0x0;
        } lvds1_link0_wrerr_st[0:0];
    } LVDS1_CTRL_INT @ 0x26F4;

    reg {
        name = "LVDS 1 read data interrupt mask register L_INT_MSK";
        desc = "LVDS1_CTRL_INT_MSK is an LVDS 1 read data interrupt mask register.

Data sheet 9.3.6 LVDS1_CTRL_INT_MSK (offset 0x26F8, printed page 9-471, `hi3516av200--Hi3516AV200-Datasheet.txt` line 65196).";

        field {
            name = "link2_rderr_msk";
            desc = "[inferred] Link2 rderr mask. (bits reserved in the data sheet; vendor header `hi3519v101/mipi_reg.h` field `link2_rderr_msk`; access and reset unknown, modelled RW)";
            sw = rw;
            hw = r;
        } link2_rderr_msk[26:26];

        field {
            name = "link1_rderr_msk";
            desc = "[inferred] Link1 rderr mask. (bits reserved in the data sheet; vendor header `hi3519v101/mipi_reg.h` field `link1_rderr_msk`; access and reset unknown, modelled RW)";
            sw = rw;
            hw = r;
        } link1_rderr_msk[25:25];

        enum LVDS1_CTRL_INT_MSK_lvds1_link0_rderr_msk_enum {
            MASKED = 0 { name = "Masked"; desc = "masked"; };
            ENABLED = 1 { name = "Enabled"; desc = "enabled"; };
        };

        field {
            name = "lvds1_link0_rderr_msk";
            desc = "Link 0 read data error interrupt enable";
            sw = rw;
            hw = r;
            encode = LVDS1_CTRL_INT_MSK_lvds1_link0_rderr_msk_enum;
            reset = 0x0;
        } lvds1_link0_rderr_msk[24:24];

        enum LVDS1_CTRL_INT_MSK_lvds1_lvds_stat_err_st_msk_enum {
            MASKED = 0 { name = "Masked"; desc = "masked"; };
            ENABLED = 1 { name = "Enabled"; desc = "enabled"; };
        };

        field {
            name = "lvds1_lvds_stat_err_st_msk";
            desc = "LVDS status error interrupt enable";
            sw = rw;
            hw = r;
            encode = LVDS1_CTRL_INT_MSK_lvds1_lvds_stat_err_st_msk_enum;
            reset = 0x0;
        } lvds1_lvds_stat_err_st_msk[21:21];

        field {
            name = "lane11_sync_err_msk";
            desc = "[inferred] Lane11 sync error mask. (bits reserved in the data sheet; vendor header `hi3519v101/mipi_reg.h` field `lane11_sync_err_msk`; access and reset unknown, modelled RW)";
            sw = rw;
            hw = r;
        } lane11_sync_err_msk[20:20];

        field {
            name = "lane10_sync_err_msk";
            desc = "[inferred] Lane10 sync error mask. (bits reserved in the data sheet; vendor header `hi3519v101/mipi_reg.h` field `lane10_sync_err_msk`; access and reset unknown, modelled RW)";
            sw = rw;
            hw = r;
        } lane10_sync_err_msk[19:19];

        field {
            name = "lane9_sync_err_msk";
            desc = "[inferred] Lane9 sync error mask. (bits reserved in the data sheet; vendor header `hi3519v101/mipi_reg.h` field `lane9_sync_err_msk`; access and reset unknown, modelled RW)";
            sw = rw;
            hw = r;
        } lane9_sync_err_msk[18:18];

        field {
            name = "lane8_sync_err_msk";
            desc = "[inferred] Lane8 sync error mask. (bits reserved in the data sheet; vendor header `hi3519v101/mipi_reg.h` field `lane8_sync_err_msk`; access and reset unknown, modelled RW)";
            sw = rw;
            hw = r;
        } lane8_sync_err_msk[17:17];

        field {
            name = "lane7_sync_err_msk";
            desc = "[inferred] Lane7 sync error mask. (bits reserved in the data sheet; vendor header `hi3519v101/mipi_reg.h` field `lane7_sync_err_msk`; access and reset unknown, modelled RW)";
            sw = rw;
            hw = r;
        } lane7_sync_err_msk[16:16];

        field {
            name = "lane6_sync_err_msk";
            desc = "[inferred] Lane6 sync error mask. (bits reserved in the data sheet; vendor header `hi3519v101/mipi_reg.h` field `lane6_sync_err_msk`; access and reset unknown, modelled RW)";
            sw = rw;
            hw = r;
        } lane6_sync_err_msk[15:15];

        field {
            name = "lane5_sync_err_msk";
            desc = "[inferred] Lane5 sync error mask. (bits reserved in the data sheet; vendor header `hi3519v101/mipi_reg.h` field `lane5_sync_err_msk`; access and reset unknown, modelled RW)";
            sw = rw;
            hw = r;
        } lane5_sync_err_msk[14:14];

        field {
            name = "lane4_sync_err_msk";
            desc = "[inferred] Lane4 sync error mask. (bits reserved in the data sheet; vendor header `hi3519v101/mipi_reg.h` field `lane4_sync_err_msk`; access and reset unknown, modelled RW)";
            sw = rw;
            hw = r;
        } lane4_sync_err_msk[13:13];

        enum LVDS1_CTRL_INT_MSK_lvds1_lane3_sync_err_msk_enum {
            MASKED = 0 { name = "Masked"; desc = "masked"; };
            ENABLED = 1 { name = "Enabled"; desc = "enabled"; };
        };

        field {
            name = "lvds1_lane3_sync_err_msk";
            desc = "Lane 3 synchronization error interrupt enable";
            sw = rw;
            hw = r;
            encode = LVDS1_CTRL_INT_MSK_lvds1_lane3_sync_err_msk_enum;
            reset = 0x0;
        } lvds1_lane3_sync_err_msk[12:12];

        enum LVDS1_CTRL_INT_MSK_lvds1_lane2_sync_err_msk_enum {
            MASKED = 0 { name = "Masked"; desc = "masked"; };
            ENABLED = 1 { name = "Enabled"; desc = "enabled"; };
        };

        field {
            name = "lvds1_lane2_sync_err_msk";
            desc = "Lane 2 synchronization error interrupt enable";
            sw = rw;
            hw = r;
            encode = LVDS1_CTRL_INT_MSK_lvds1_lane2_sync_err_msk_enum;
            reset = 0x0;
        } lvds1_lane2_sync_err_msk[11:11];

        enum LVDS1_CTRL_INT_MSK_lvds1_lane1_sync_err_msk_enum {
            MASKED = 0 { name = "Masked"; desc = "masked"; };
            ENABLED = 1 { name = "Enabled"; desc = "enabled"; };
        };

        field {
            name = "lvds1_lane1_sync_err_msk";
            desc = "Lane 1 synchronization error interrupt enable";
            sw = rw;
            hw = r;
            encode = LVDS1_CTRL_INT_MSK_lvds1_lane1_sync_err_msk_enum;
            reset = 0x0;
        } lvds1_lane1_sync_err_msk[10:10];

        enum LVDS1_CTRL_INT_MSK_lvds1_lane0_sync_err_msk_enum {
            MASKED = 0 { name = "Masked"; desc = "masked"; };
            ENABLED = 1 { name = "Enabled"; desc = "enabled"; };
        };

        field {
            name = "lvds1_lane0_sync_err_msk";
            desc = "Lane 0 synchronization error interrupt enable";
            sw = rw;
            hw = r;
            encode = LVDS1_CTRL_INT_MSK_lvds1_lane0_sync_err_msk_enum;
            reset = 0x0;
        } lvds1_lane0_sync_err_msk[9:9];

        field {
            name = "link2_hsync_err_msk";
            desc = "[inferred] Link2 horizontal sync error mask. (bits reserved in the data sheet; vendor header `hi3519v101/mipi_reg.h` field `link2_hsync_err_msk`; access and reset unknown, modelled RW)";
            sw = rw;
            hw = r;
        } link2_hsync_err_msk[8:8];

        field {
            name = "link2_vsync_err_msk";
            desc = "[inferred] Link2 vertical sync error mask. (bits reserved in the data sheet; vendor header `hi3519v101/mipi_reg.h` field `link2_vsync_err_msk`; access and reset unknown, modelled RW)";
            sw = rw;
            hw = r;
        } link2_vsync_err_msk[7:7];

        field {
            name = "link2_wrerr_msk";
            desc = "[inferred] Link2 wrerr mask. (bits reserved in the data sheet; vendor header `hi3519v101/mipi_reg.h` field `link2_wrerr_msk`; access and reset unknown, modelled RW)";
            sw = rw;
            hw = r;
        } link2_wrerr_msk[6:6];

        field {
            name = "link1_hsync_err_msk";
            desc = "[inferred] Link1 horizontal sync error mask. (bits reserved in the data sheet; vendor header `hi3519v101/mipi_reg.h` field `link1_hsync_err_msk`; access and reset unknown, modelled RW)";
            sw = rw;
            hw = r;
        } link1_hsync_err_msk[5:5];

        field {
            name = "link1_vsync_err_msk";
            desc = "[inferred] Link1 vertical sync error mask. (bits reserved in the data sheet; vendor header `hi3519v101/mipi_reg.h` field `link1_vsync_err_msk`; access and reset unknown, modelled RW)";
            sw = rw;
            hw = r;
        } link1_vsync_err_msk[4:4];

        field {
            name = "link1_wrerr_msk";
            desc = "[inferred] Link1 wrerr mask. (bits reserved in the data sheet; vendor header `hi3519v101/mipi_reg.h` field `link1_wrerr_msk`; access and reset unknown, modelled RW)";
            sw = rw;
            hw = r;
        } link1_wrerr_msk[3:3];

        enum LVDS1_CTRL_INT_MSK_lvds1_link0_hsync_err_msk_enum {
            MASKED = 0 { name = "Masked"; desc = "masked"; };
            ENABLED = 1 { name = "Enabled"; desc = "enabled"; };
        };

        field {
            name = "lvds1_link0_hsync_err_msk";
            desc = "Link 0 HS error interrupt enable";
            sw = rw;
            hw = r;
            encode = LVDS1_CTRL_INT_MSK_lvds1_link0_hsync_err_msk_enum;
            reset = 0x0;
        } lvds1_link0_hsync_err_msk[2:2];

        enum LVDS1_CTRL_INT_MSK_lvds1_link0_vsync_err_msk_enum {
            MASKED = 0 { name = "Masked"; desc = "masked"; };
            ENABLED = 1 { name = "Enabled"; desc = "enabled"; };
        };

        field {
            name = "lvds1_link0_vsync_err_msk";
            desc = "Link 0 VS error interrupt enable";
            sw = rw;
            hw = r;
            encode = LVDS1_CTRL_INT_MSK_lvds1_link0_vsync_err_msk_enum;
            reset = 0x0;
        } lvds1_link0_vsync_err_msk[1:1];

        enum LVDS1_CTRL_INT_MSK_lvds1_link0_wrerr_msk_enum {
            MASKED = 0 { name = "Masked"; desc = "masked"; };
            ENABLED = 1 { name = "Enabled"; desc = "enabled"; };
        };

        field {
            name = "lvds1_link0_wrerr_msk";
            desc = "Link 0 write data error interrupt enable";
            sw = rw;
            hw = r;
            encode = LVDS1_CTRL_INT_MSK_lvds1_link0_wrerr_msk_enum;
            reset = 0x0;
        } lvds1_link0_wrerr_msk[0:0];
    } LVDS1_CTRL_INT_MSK @ 0x26F8;

    reg {
        name = "Link 0 lane priority configuration register CHN1";
        desc = "LANE_ID0_CHN1 is a link 0 lane priority configuration register.

Data sheet 9.3.6 LANE_ID0_CHN1 (offset 0x2700, printed page 9-472, `hi3516av200--Hi3516AV200-Datasheet.txt` line 65282).";

        field {
            name = "lvds1_lane3_id";
            desc = "Lane 3 channel ID, range from 0 to 11 The field value indicates the ID of image sensor channel connected to lane 3.";
            sw = rw;
            hw = r;
            reset = 0x3;
        } lvds1_lane3_id[15:12];

        field {
            name = "lvds1_lane2_id";
            desc = "Lane 2 channel ID, range from 0 to 11 The field value indicates the ID of image sensor channel connected to lane 2.";
            sw = rw;
            hw = r;
            reset = 0x2;
        } lvds1_lane2_id[11:8];

        field {
            name = "lvds1_lane1_id";
            desc = "Lane 1 channel ID, range from 0 to 11 The field value indicates the ID of image sensor channel connected to lane 1.";
            sw = rw;
            hw = r;
            reset = 0x1;
        } lvds1_lane1_id[7:4];

        field {
            name = "lvds1_lane0_id";
            desc = "Lane 0 channel ID, range from 0 to 11 The field value indicates the ID of image sensor channel connected to lane 0.";
            sw = rw;
            hw = r;
            reset = 0x0;
        } lvds1_lane0_id[3:0];
    } LANE_ID0_CHN1 @ 0x2700;

    reg {
        name = "Lane ID1 CHN1 1";
        desc = "[inferred] Lane ID1 CHN1 1. Not in the data sheet. Source: OpenIPC openhisilicon `kernel/mipi_rx/hi3519v101/mipi_reg.h` (GPL-3.0 repository, HiSilicon copyright; local copy sources/openhisilicon), union `U_LANE_ID_CHN`, struct offset 0x2704 (GPL-3.0 repository, HiSilicon copyright; one header for Hi3519 V101 and Hi3516A V200). Reset value and access type unknown (modelled RW, no reset). Confidence: medium (vendor header for this chip family, not hardware verified).";

        field {
            name = "lane3_id";
            desc = "[inferred] Lane3 id. (vendor header `hi3519v101/mipi_reg.h` field `lane3_id`; access and reset unknown, modelled RW)";
            sw = rw;
            hw = r;
        } lane3_id[15:12];

        field {
            name = "lane2_id";
            desc = "[inferred] Lane2 id. (vendor header `hi3519v101/mipi_reg.h` field `lane2_id`; access and reset unknown, modelled RW)";
            sw = rw;
            hw = r;
        } lane2_id[11:8];

        field {
            name = "lane1_id";
            desc = "[inferred] Lane1 id. (vendor header `hi3519v101/mipi_reg.h` field `lane1_id`; access and reset unknown, modelled RW)";
            sw = rw;
            hw = r;
        } lane1_id[7:4];

        field {
            name = "lane0_id";
            desc = "[inferred] Lane0 id. (vendor header `hi3519v101/mipi_reg.h` field `lane0_id`; access and reset unknown, modelled RW)";
            sw = rw;
            hw = r;
        } lane0_id[3:0];
    } LANE_ID1_CHN1_1 @ 0x2704;

    reg {
        name = "Lane ID1 CHN1 2";
        desc = "[inferred] Lane ID1 CHN1 2. Not in the data sheet. Source: OpenIPC openhisilicon `kernel/mipi_rx/hi3519v101/mipi_reg.h` (GPL-3.0 repository, HiSilicon copyright; local copy sources/openhisilicon), union `U_LANE_ID_CHN`, struct offset 0x2708 (GPL-3.0 repository, HiSilicon copyright; one header for Hi3519 V101 and Hi3516A V200). Reset value and access type unknown (modelled RW, no reset). Confidence: medium (vendor header for this chip family, not hardware verified).";

        field {
            name = "lane3_id";
            desc = "[inferred] Lane3 id. (vendor header `hi3519v101/mipi_reg.h` field `lane3_id`; access and reset unknown, modelled RW)";
            sw = rw;
            hw = r;
        } lane3_id[15:12];

        field {
            name = "lane2_id";
            desc = "[inferred] Lane2 id. (vendor header `hi3519v101/mipi_reg.h` field `lane2_id`; access and reset unknown, modelled RW)";
            sw = rw;
            hw = r;
        } lane2_id[11:8];

        field {
            name = "lane1_id";
            desc = "[inferred] Lane1 id. (vendor header `hi3519v101/mipi_reg.h` field `lane1_id`; access and reset unknown, modelled RW)";
            sw = rw;
            hw = r;
        } lane1_id[7:4];

        field {
            name = "lane0_id";
            desc = "[inferred] Lane0 id. (vendor header `hi3519v101/mipi_reg.h` field `lane0_id`; access and reset unknown, modelled RW)";
            sw = rw;
            hw = r;
        } lane0_id[3:0];
    } LANE_ID1_CHN1_2 @ 0x2708;

    reg {
        name = "MIPI_ALIGN raw interrupt status register T_RAW";
        desc = "ALIGN1_INT_RAW is a MIPI_ALIGN raw interrupt status register.

Data sheet 9.3.6 ALIGN1_INT_RAW (offset 0x27F0, printed page 9-473, `hi3516av200--Hi3516AV200-Datasheet.txt` line 65323).";

        field {
            name = "err_lane11_raw";
            desc = "[inferred] Error lane11 raw. (bits reserved in the data sheet; vendor header `hi3519v101/mipi_reg.h` field `err_lane11_raw`; access and reset unknown, modelled RW)";
            sw = rw;
            hw = r;
        } err_lane11_raw[12:12];

        field {
            name = "err_lane10_raw";
            desc = "[inferred] Error lane10 raw. (bits reserved in the data sheet; vendor header `hi3519v101/mipi_reg.h` field `err_lane10_raw`; access and reset unknown, modelled RW)";
            sw = rw;
            hw = r;
        } err_lane10_raw[11:11];

        field {
            name = "err_lane9_raw";
            desc = "[inferred] Error lane9 raw. (bits reserved in the data sheet; vendor header `hi3519v101/mipi_reg.h` field `err_lane9_raw`; access and reset unknown, modelled RW)";
            sw = rw;
            hw = r;
        } err_lane9_raw[10:10];

        field {
            name = "err_lane8_raw";
            desc = "[inferred] Error lane8 raw. (bits reserved in the data sheet; vendor header `hi3519v101/mipi_reg.h` field `err_lane8_raw`; access and reset unknown, modelled RW)";
            sw = rw;
            hw = r;
        } err_lane8_raw[9:9];

        field {
            name = "err_lane7_raw";
            desc = "[inferred] Error lane7 raw. (bits reserved in the data sheet; vendor header `hi3519v101/mipi_reg.h` field `err_lane7_raw`; access and reset unknown, modelled RW)";
            sw = rw;
            hw = r;
        } err_lane7_raw[8:8];

        field {
            name = "err_lane6_raw";
            desc = "[inferred] Error lane6 raw. (bits reserved in the data sheet; vendor header `hi3519v101/mipi_reg.h` field `err_lane6_raw`; access and reset unknown, modelled RW)";
            sw = rw;
            hw = r;
        } err_lane6_raw[7:7];

        field {
            name = "err_lane5_raw";
            desc = "[inferred] Error lane5 raw. (bits reserved in the data sheet; vendor header `hi3519v101/mipi_reg.h` field `err_lane5_raw`; access and reset unknown, modelled RW)";
            sw = rw;
            hw = r;
        } err_lane5_raw[6:6];

        field {
            name = "err_lane4_raw";
            desc = "[inferred] Error lane4 raw. (bits reserved in the data sheet; vendor header `hi3519v101/mipi_reg.h` field `err_lane4_raw`; access and reset unknown, modelled RW)";
            sw = rw;
            hw = r;
        } err_lane4_raw[5:5];

        enum ALIGN1_INT_RAW_align1_err_lane3_raw_enum {
            NO_RAW_INTERRUPT = 0 { name = "No Raw Interrupt"; desc = "No raw interrupt is generated."; };
            RAW_INTERRUPT_GENERATED = 1 { name = "Raw Interrupt Generated"; desc = "A raw interrupt is generated."; };
        };

        field {
            name = "align1_err_lane3_raw";
            desc = "MIPI_ALIGN lane 3 raw interrupt status";
            sw = rw;
            hw = w;
            onwrite = woclr;
            encode = ALIGN1_INT_RAW_align1_err_lane3_raw_enum;
            reset = 0x0;
        } align1_err_lane3_raw[4:4];

        enum ALIGN1_INT_RAW_align1_err_lane2_raw_enum {
            NO_RAW_INTERRUPT = 0 { name = "No Raw Interrupt"; desc = "No raw interrupt is generated."; };
            RAW_INTERRUPT_GENERATED = 1 { name = "Raw Interrupt Generated"; desc = "A raw interrupt is generated."; };
        };

        field {
            name = "align1_err_lane2_raw";
            desc = "MIPI_ALIGN lane 2 raw interrupt status";
            sw = rw;
            hw = w;
            onwrite = woclr;
            encode = ALIGN1_INT_RAW_align1_err_lane2_raw_enum;
            reset = 0x0;
        } align1_err_lane2_raw[3:3];

        enum ALIGN1_INT_RAW_align1_err_lane1_raw_enum {
            NO_RAW_INTERRUPT = 0 { name = "No Raw Interrupt"; desc = "No raw interrupt is generated."; };
            RAW_INTERRUPT_GENERATED = 1 { name = "Raw Interrupt Generated"; desc = "A raw interrupt is generated."; };
        };

        field {
            name = "align1_err_lane1_raw";
            desc = "MIPI_ALIGN lane 1 raw interrupt status";
            sw = rw;
            hw = w;
            onwrite = woclr;
            encode = ALIGN1_INT_RAW_align1_err_lane1_raw_enum;
            reset = 0x0;
        } align1_err_lane1_raw[2:2];

        enum ALIGN1_INT_RAW_align1_err_lane0_raw_enum {
            NO_RAW_INTERRUPT = 0 { name = "No Raw Interrupt"; desc = "No raw interrupt is generated."; };
            RAW_INTERRUPT_GENERATED = 1 { name = "Raw Interrupt Generated"; desc = "A raw interrupt is generated."; };
        };

        field {
            name = "align1_err_lane0_raw";
            desc = "MIPI_ALIGN lane 0 raw interrupt status";
            sw = rw;
            hw = w;
            onwrite = woclr;
            encode = ALIGN1_INT_RAW_align1_err_lane0_raw_enum;
            reset = 0x0;
        } align1_err_lane0_raw[1:1];

        enum ALIGN1_INT_RAW_align1_err_full_raw_enum {
            NO_RAW_INTERRUPT = 0 { name = "No Raw Interrupt"; desc = "No raw interrupt is generated."; };
            RAW_INTERRUPT_GENERATED = 1 { name = "Raw Interrupt Generated"; desc = "A raw interrupt is generated."; };
        };

        field {
            name = "align1_err_full_raw";
            desc = "MIPI_ALIGN FIFO raw interrupt status";
            sw = rw;
            hw = w;
            onwrite = woclr;
            encode = ALIGN1_INT_RAW_align1_err_full_raw_enum;
            reset = 0x0;
        } align1_err_full_raw[0:0];
    } ALIGN1_INT_RAW @ 0x27F0;

    reg {
        name = "MIPI_ALIGN interrupt status register T";
        desc = "ALIGN1_INT is a MIPI_ALIGN interrupt status register.

Data sheet 9.3.6 ALIGN1_INT (offset 0x27F4, printed page 9-474, `hi3516av200--Hi3516AV200-Datasheet.txt` line 65383).";

        field {
            name = "err_lane11_st";
            desc = "[inferred] Error lane11 st. (bits reserved in the data sheet; vendor header `hi3519v101/mipi_reg.h` field `err_lane11_st`; access and reset unknown, modelled RW)";
            sw = rw;
            hw = r;
        } err_lane11_st[12:12];

        field {
            name = "err_lane10_st";
            desc = "[inferred] Error lane10 st. (bits reserved in the data sheet; vendor header `hi3519v101/mipi_reg.h` field `err_lane10_st`; access and reset unknown, modelled RW)";
            sw = rw;
            hw = r;
        } err_lane10_st[11:11];

        field {
            name = "err_lane9_st";
            desc = "[inferred] Error lane9 st. (bits reserved in the data sheet; vendor header `hi3519v101/mipi_reg.h` field `err_lane9_st`; access and reset unknown, modelled RW)";
            sw = rw;
            hw = r;
        } err_lane9_st[10:10];

        field {
            name = "err_lane8_st";
            desc = "[inferred] Error lane8 st. (bits reserved in the data sheet; vendor header `hi3519v101/mipi_reg.h` field `err_lane8_st`; access and reset unknown, modelled RW)";
            sw = rw;
            hw = r;
        } err_lane8_st[9:9];

        field {
            name = "err_lane7_st";
            desc = "[inferred] Error lane7 st. (bits reserved in the data sheet; vendor header `hi3519v101/mipi_reg.h` field `err_lane7_st`; access and reset unknown, modelled RW)";
            sw = rw;
            hw = r;
        } err_lane7_st[8:8];

        field {
            name = "err_lane6_st";
            desc = "[inferred] Error lane6 st. (bits reserved in the data sheet; vendor header `hi3519v101/mipi_reg.h` field `err_lane6_st`; access and reset unknown, modelled RW)";
            sw = rw;
            hw = r;
        } err_lane6_st[7:7];

        field {
            name = "err_lane5_st";
            desc = "[inferred] Error lane5 st. (bits reserved in the data sheet; vendor header `hi3519v101/mipi_reg.h` field `err_lane5_st`; access and reset unknown, modelled RW)";
            sw = rw;
            hw = r;
        } err_lane5_st[6:6];

        field {
            name = "err_lane4_st";
            desc = "[inferred] Error lane4 st. (bits reserved in the data sheet; vendor header `hi3519v101/mipi_reg.h` field `err_lane4_st`; access and reset unknown, modelled RW)";
            sw = rw;
            hw = r;
        } err_lane4_st[5:5];

        enum ALIGN1_INT_align1_err_lane3_st_enum {
            NO_INTERRUPT_GENERATED = 0 { name = "No Interrupt Generated"; desc = "No interrupt is generated."; };
            INTERRUPT_GENERATED = 1 { name = "Interrupt Generated"; desc = "An interrupt is generated."; };
        };

        field {
            name = "align1_err_lane3_st";
            desc = "MIPI_ALIGN lane 3 interrupt status";
            sw = r;
            hw = w;
            encode = ALIGN1_INT_align1_err_lane3_st_enum;
            reset = 0x0;
        } align1_err_lane3_st[4:4];

        enum ALIGN1_INT_align1_err_lane2_st_enum {
            NO_INTERRUPT_GENERATED = 0 { name = "No Interrupt Generated"; desc = "No interrupt is generated."; };
            INTERRUPT_GENERATED = 1 { name = "Interrupt Generated"; desc = "An interrupt is generated."; };
        };

        field {
            name = "align1_err_lane2_st";
            desc = "MIPI_ALIGN lane 2 interrupt status";
            sw = r;
            hw = w;
            encode = ALIGN1_INT_align1_err_lane2_st_enum;
            reset = 0x0;
        } align1_err_lane2_st[3:3];

        enum ALIGN1_INT_align1_err_lane1_st_enum {
            NO_INTERRUPT_GENERATED = 0 { name = "No Interrupt Generated"; desc = "No interrupt is generated."; };
            INTERRUPT_GENERATED = 1 { name = "Interrupt Generated"; desc = "An interrupt is generated."; };
        };

        field {
            name = "align1_err_lane1_st";
            desc = "MIPI_ALIGN lane 1 interrupt status";
            sw = r;
            hw = w;
            encode = ALIGN1_INT_align1_err_lane1_st_enum;
            reset = 0x0;
        } align1_err_lane1_st[2:2];

        enum ALIGN1_INT_align1_err_lane0_st_enum {
            NO_INTERRUPT_GENERATED = 0 { name = "No Interrupt Generated"; desc = "No interrupt is generated."; };
            INTERRUPT_GENERATED = 1 { name = "Interrupt Generated"; desc = "An interrupt is generated."; };
        };

        field {
            name = "align1_err_lane0_st";
            desc = "MIPI_ALIGN lane 0 interrupt status";
            sw = r;
            hw = w;
            encode = ALIGN1_INT_align1_err_lane0_st_enum;
            reset = 0x0;
        } align1_err_lane0_st[1:1];

        enum ALIGN1_INT_align1_err_full_st_enum {
            NO_INTERRUPT_GENERATED = 0 { name = "No Interrupt Generated"; desc = "No interrupt is generated."; };
            INTERRUPT_GENERATED = 1 { name = "Interrupt Generated"; desc = "An interrupt is generated."; };
        };

        field {
            name = "align1_err_full_st";
            desc = "MIPI_ALIGN FIFO interrupt status";
            sw = r;
            hw = w;
            encode = ALIGN1_INT_align1_err_full_st_enum;
            reset = 0x0;
        } align1_err_full_st[0:0];
    } ALIGN1_INT @ 0x27F4;

    reg {
        name = "MIPI_ALIGN interrupt mask register T_MSK";
        desc = "ALIGN1_INT_MSK is a MIPI_ALIGN interrupt mask register.

Data sheet 9.3.6 ALIGN1_INT_MSK (offset 0x27F8, printed page 9-475, `hi3516av200--Hi3516AV200-Datasheet.txt` line 65434).";

        field {
            name = "err_lane11_mask";
            desc = "[inferred] Error lane11 mask. (bits reserved in the data sheet; vendor header `hi3519v101/mipi_reg.h` field `err_lane11_mask`; access and reset unknown, modelled RW)";
            sw = rw;
            hw = r;
        } err_lane11_mask[12:12];

        field {
            name = "err_lane10_mask";
            desc = "[inferred] Error lane10 mask. (bits reserved in the data sheet; vendor header `hi3519v101/mipi_reg.h` field `err_lane10_mask`; access and reset unknown, modelled RW)";
            sw = rw;
            hw = r;
        } err_lane10_mask[11:11];

        field {
            name = "err_lane9_mask";
            desc = "[inferred] Error lane9 mask. (bits reserved in the data sheet; vendor header `hi3519v101/mipi_reg.h` field `err_lane9_mask`; access and reset unknown, modelled RW)";
            sw = rw;
            hw = r;
        } err_lane9_mask[10:10];

        field {
            name = "err_lane8_mask";
            desc = "[inferred] Error lane8 mask. (bits reserved in the data sheet; vendor header `hi3519v101/mipi_reg.h` field `err_lane8_mask`; access and reset unknown, modelled RW)";
            sw = rw;
            hw = r;
        } err_lane8_mask[9:9];

        field {
            name = "err_lane7_mask";
            desc = "[inferred] Error lane7 mask. (bits reserved in the data sheet; vendor header `hi3519v101/mipi_reg.h` field `err_lane7_mask`; access and reset unknown, modelled RW)";
            sw = rw;
            hw = r;
        } err_lane7_mask[8:8];

        field {
            name = "err_lane6_mask";
            desc = "[inferred] Error lane6 mask. (bits reserved in the data sheet; vendor header `hi3519v101/mipi_reg.h` field `err_lane6_mask`; access and reset unknown, modelled RW)";
            sw = rw;
            hw = r;
        } err_lane6_mask[7:7];

        field {
            name = "err_lane5_mask";
            desc = "[inferred] Error lane5 mask. (bits reserved in the data sheet; vendor header `hi3519v101/mipi_reg.h` field `err_lane5_mask`; access and reset unknown, modelled RW)";
            sw = rw;
            hw = r;
        } err_lane5_mask[6:6];

        field {
            name = "err_lane4_mask";
            desc = "[inferred] Error lane4 mask. (bits reserved in the data sheet; vendor header `hi3519v101/mipi_reg.h` field `err_lane4_mask`; access and reset unknown, modelled RW)";
            sw = rw;
            hw = r;
        } err_lane4_mask[5:5];

        enum ALIGN1_INT_MSK_align1_err_lane3_mask_enum {
            MASKED = 0 { name = "Masked"; desc = "masked"; };
            ENABLED = 1 { name = "Enabled"; desc = "enabled"; };
        };

        field {
            name = "align1_err_lane3_mask";
            desc = "MIPI_ALIGN lane 3 interrupt enable";
            sw = rw;
            hw = r;
            encode = ALIGN1_INT_MSK_align1_err_lane3_mask_enum;
            reset = 0x0;
        } align1_err_lane3_mask[4:4];

        enum ALIGN1_INT_MSK_align1_err_lane2_mask_enum {
            MASKED = 0 { name = "Masked"; desc = "masked"; };
            ENABLED = 1 { name = "Enabled"; desc = "enabled"; };
        };

        field {
            name = "align1_err_lane2_mask";
            desc = "MIPI_ALIGN lane 2 interrupt enable";
            sw = rw;
            hw = r;
            encode = ALIGN1_INT_MSK_align1_err_lane2_mask_enum;
            reset = 0x0;
        } align1_err_lane2_mask[3:3];

        enum ALIGN1_INT_MSK_align1_err_lane1_mask_enum {
            MASKED = 0 { name = "Masked"; desc = "masked"; };
            ENABLED = 1 { name = "Enabled"; desc = "enabled"; };
        };

        field {
            name = "align1_err_lane1_mask";
            desc = "MIPI_ALIGN lane 1 interrupt enable";
            sw = rw;
            hw = r;
            encode = ALIGN1_INT_MSK_align1_err_lane1_mask_enum;
            reset = 0x0;
        } align1_err_lane1_mask[2:2];

        enum ALIGN1_INT_MSK_align1_err_lane0_mask_enum {
            MASKED = 0 { name = "Masked"; desc = "masked"; };
            ENABLED = 1 { name = "Enabled"; desc = "enabled"; };
        };

        field {
            name = "align1_err_lane0_mask";
            desc = "MIPI_ALIGN lane 0 interrupt enable";
            sw = rw;
            hw = r;
            encode = ALIGN1_INT_MSK_align1_err_lane0_mask_enum;
            reset = 0x0;
        } align1_err_lane0_mask[1:1];

        enum ALIGN1_INT_MSK_align1_err_full_mask_enum {
            MASKED = 0 { name = "Masked"; desc = "masked"; };
            ENABLED = 1 { name = "Enabled"; desc = "enabled"; };
        };

        field {
            name = "align1_err_full_mask";
            desc = "MIPI_ALIGN FIFO interrupt enable";
            sw = rw;
            hw = r;
            encode = ALIGN1_INT_MSK_align1_err_full_mask_enum;
            reset = 0x0;
        } align1_err_full_mask[0:0];
    } ALIGN1_INT_MSK @ 0x27F8;
};

`endif
