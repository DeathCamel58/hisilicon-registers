`ifndef HISI_WDG_SP805_RDL
`define HISI_WDG_SP805_RDL

regfile eHISI_WDG_SP805 {
    name = "Watchdog Registers";
    desc = "
    The watchdog is based on the [`ARM SP805`](https://developer.arm.com/documentation/ddi0270/b/) device: a 32-bit down counter clocked by WDOGCLK (the bus clock or
    the reference clock selected by the system controller / CRG, chip dependent) that raises an interrupt when it reaches 0 and, if `resen` is set and the interrupt is not
    cleared before the counter reaches 0 a second time, drives the reset output (the chip reset, and on most SoCs the WDG_RSTN pin). The registers are write-protected
    by WDG_LOCK (write 0x1ACCE551 to unlock).

    The register map (WDG_LOAD .. WDG_LOCK) and every reset value are identical in all data sheets checked (Hi3511/Hi3512, Hi3515, Hi3516/Hi3516C/Hi3518 V100, Hi3516A/D V100,
    Hi3520/Hi3520D V100, Hi3518E V20X/Hi3516C V200, Hi3516A V200, Hi3519 V101, Hi3516C V300/Hi3516E V100, Hi3516A V300). `WDG_SP805_RESET_G1` (chip `defines.rdl`) gives
    WDG_INTCLR the documented reset 0 (Hi3516A V300, Hi3518E V20X); the other data sheets print none for the write-only register. `WDG_SP805_PRIMECELL_ID` adds the
    PeriphID/PCellID registers read on Hi3520D hardware; the data sheets do not list them, nor the SP805 integration test registers (WDOGITCR/WDOGITOP, 0xF00/0xF04).

    !!! NOTE
        Although this seems to mostly match the `ARM SP805`, the documentation seems to be missing registers that IP block should have.

    ## Instances per SoC

    | SoC | Instances | Base address | Interrupt |
    |-----|-----------|--------------|-----------|
    | Hi3511 / Hi3512 | WDG | 0x101E1000 | VIC 0 |
    | Hi3515 / Hi3520 V100 | WDG | 0x20040000 | VIC 0 |
    | Hi3516C V100 / Hi3518 V100 / Hi3518E V20X / Hi3516C V200 | WDG | 0x20040000 | VIC 1 |
    | Hi3516 V100 / Hi3516A / Hi3516D V100 | WDG | 0x20040000 | GIC 34 |
    | Hi3520D V100 | WDG | 0x20040000 | GIC 34 |
    | Hi3516A V200 / Hi3519 V101 | WDG | 0x12080000 | GIC 32 |
    | Hi3516C V300 / Hi3516E V100 | WDG | 0x12080000 | VIC 1 |
    | Hi3516A V300 | WDG0, WDG1 | 0x12050000, 0x12051000 | GIC 32 (WDG0), 108 (WDG1) |
    ";

    /* Fields */

    reg {
        name = "Initial Count Value Register";

        field {
            name = "wdg_load";
            desc = "Initial count value of the watchdog counter.";
                    reset = 0xFFFFFFFF;
        } wdg_load[31:0];

    } WDG_LOAD @ 0x000;

    reg {
        name = "Current Count Value Register";
        desc = "It is used to read the current count value of the internal counter of the watchdog.";

        field {
            name = "wdogvalue";
            desc = "Current count value of the watchdog counter.";
            counter;
            decrvalue = 1;
            sw = r;
            hw = w;
            reset = 0xFFFFFFFF;
        } wdogvalue[31:0];

    } WDG_VALUE @ 0x004;

    reg {
        name = "Watchdog Control Register";
        desc = "It is used to enable or disable the watchdog and control the interrupt and reset functions of the watchdog.";

        enum enabled_enum {
            DISABLED = 0x0 { desc = "Disabled"; };
            ENABLED  = 0x1 { desc = "Enabled"; };
        };

        field {
            name = "inten";
            desc = "Output enable of the watchdog interrupt signal. 0: the counter stops and the watchdog is disabled. 1: the counter, the interrupt and the watchdog are enabled.";
            encode = enabled_enum;
            reset = 0x0;
        } inten[0:0];

        field {
            name = "resen";
            desc = "Output enable of the watchdog reset signal.";
            encode = enabled_enum;
            reset = 0x0;
        } resen[1:1];

    } WDG_CONTROL @ 0x008;

    reg {
        name = "Interrupt Clear Register";
        desc = "Used to clear watchdog interrupts so the watchdog can reload an initial value for counting. This register is write-only. When a value is written to this register, the watchdog interrupts are cleared. No written value is recorded in this register and no default reset value is defined.";

        field {
            name = "wdg_intclr";
            desc = "Writing any value to this register clears the watchdog interrupts and enables the watchdog to reload an initial count value from WDG_LOAD to restart counting. ";
            sw = w;
            hw = r;
`ifdef WDG_SP805_RESET_G1
            reset = 0x0;
`endif
        } wdg_intclr[31:0];

    } WDG_INTCLR @ 0x00C;

    reg {
        name = "Raw Interrupt Status Register";
        desc = "It shows the raw interrupt status of the watchdog.";

        enum wdogris_enum {
            NO_INTERRUPT = 0x0 { desc = "No Interrupt"; };
            INTERRUPT    = 0x1 { desc = "Interrupt"; };
        };

        field {
            name = "wdogris";
            desc = "Status of the raw interrupts of the watchdog. When the count value reaches 0, this bit is set to 1.";
            encode = wdogris_enum;
            sw = r;
            hw = w;
            reset = 0x0;
        } wdogris[0:0];

    } WDG_RIS @ 0x010;

    reg {
        name = "Masked Interrupt Status Register";
        desc = "It shows the masked interrupt status of the watchdog.";

        enum wdogmis_enum {
            NO_INTERRUPT = 0x0 { desc = "No Interrupt; Or Interrupt is Masked"; };
            INTERRUPT    = 0x1 { desc = "Interrupt"; };
        };

        field {
            name = "wdogmis";
            desc = "Status of the masked interrupts of the watchdog.";
            encode = wdogmis_enum;
            sw = r;
            hw = w;
            reset = 0x0;
        } wdogmis[0:0];

    } WDG_MIS @ 0x014;

    reg {
        name = "Lock Register";
        desc = "Used to control the write and read permissions for the watchdog registers.";

        field {
            name = "wdg_lock";
            desc = "
            Writing 0x1ACCE551 to this register enables the write permission for all the registers.

            Writing other values disables the write permission for all the registers.

            When this register is read, the lock status rather than the written value of this register is returned.

            * `0x0`: The write permission is available (unlocked).
            * `0x1`: The write permission is unavailable (locked).
            ";
            reset = 0x0;
        } wdg_lock[31:0];

    } WDG_LOCK @ 0xC00;

`ifdef WDG_SP805_PRIMECELL_ID
    reg {
        name = "Peripheral identification register 0";
        desc = "Part number [7:0] = 0x05. Read-only. Not in the data sheet (the data sheet lists only the registers up to WDG_LOCK); value read on hardware 2026-11-08 (Hi3520D V100, stock U-Boot prompt after a cold boot). Read together the four PERIPHID bytes give 0x00141805 and the four PCELLID bytes give 0xB105F00D, the standard ARM SP805 identification (the PrimeCell ID is 0xB105F00D).";

        field {
            name = "id";
            desc = "Identification byte.";
            sw = r;
            hw = w;
            reset = 0x05;
        } id[7:0];
    } WDG_PERIPHID0 @ 0xFE0;

    reg {
        name = "Peripheral identification register 1";
        desc = "Designer [3:0] = 0x8 (ARM), part number [11:8] = 0x8. Read-only. Not in the data sheet (the data sheet lists only the registers up to WDG_LOCK); value read on hardware 2026-11-08 (Hi3520D V100, stock U-Boot prompt after a cold boot). Read together the four PERIPHID bytes give 0x00141805 and the four PCELLID bytes give 0xB105F00D, the standard ARM SP805 identification (the PrimeCell ID is 0xB105F00D).";

        field {
            name = "id";
            desc = "Identification byte.";
            sw = r;
            hw = w;
            reset = 0x18;
        } id[7:0];
    } WDG_PERIPHID1 @ 0xFE4;

    reg {
        name = "Peripheral identification register 2";
        desc = "Revision [7:4] = 0x1, designer [3:0] = 0x4. Read-only. Not in the data sheet (the data sheet lists only the registers up to WDG_LOCK); value read on hardware 2026-11-08 (Hi3520D V100, stock U-Boot prompt after a cold boot). Read together the four PERIPHID bytes give 0x00141805 and the four PCELLID bytes give 0xB105F00D, the standard ARM SP805 identification (the PrimeCell ID is 0xB105F00D).";

        field {
            name = "id";
            desc = "Identification byte.";
            sw = r;
            hw = w;
            reset = 0x14;
        } id[7:0];
    } WDG_PERIPHID2 @ 0xFE8;

    reg {
        name = "Peripheral identification register 3";
        desc = "Configuration = 0x00. Read-only. Not in the data sheet (the data sheet lists only the registers up to WDG_LOCK); value read on hardware 2026-11-08 (Hi3520D V100, stock U-Boot prompt after a cold boot). Read together the four PERIPHID bytes give 0x00141805 and the four PCELLID bytes give 0xB105F00D, the standard ARM SP805 identification (the PrimeCell ID is 0xB105F00D).";

        field {
            name = "id";
            desc = "Identification byte.";
            sw = r;
            hw = w;
            reset = 0x00;
        } id[7:0];
    } WDG_PERIPHID3 @ 0xFEC;

    reg {
        name = "PrimeCell identification register 0";
        desc = "PrimeCell ID [7:0] = 0x0D. Read-only. Not in the data sheet (the data sheet lists only the registers up to WDG_LOCK); value read on hardware 2026-11-08 (Hi3520D V100, stock U-Boot prompt after a cold boot). Read together the four PERIPHID bytes give 0x00141805 and the four PCELLID bytes give 0xB105F00D, the standard ARM SP805 identification (the PrimeCell ID is 0xB105F00D).";

        field {
            name = "id";
            desc = "Identification byte.";
            sw = r;
            hw = w;
            reset = 0x0D;
        } id[7:0];
    } WDG_PCELLID0 @ 0xFF0;

    reg {
        name = "PrimeCell identification register 1";
        desc = "PrimeCell ID [15:8] = 0xF0. Read-only. Not in the data sheet (the data sheet lists only the registers up to WDG_LOCK); value read on hardware 2026-11-08 (Hi3520D V100, stock U-Boot prompt after a cold boot). Read together the four PERIPHID bytes give 0x00141805 and the four PCELLID bytes give 0xB105F00D, the standard ARM SP805 identification (the PrimeCell ID is 0xB105F00D).";

        field {
            name = "id";
            desc = "Identification byte.";
            sw = r;
            hw = w;
            reset = 0xF0;
        } id[7:0];
    } WDG_PCELLID1 @ 0xFF4;

    reg {
        name = "PrimeCell identification register 2";
        desc = "PrimeCell ID [23:16] = 0x05. Read-only. Not in the data sheet (the data sheet lists only the registers up to WDG_LOCK); value read on hardware 2026-11-08 (Hi3520D V100, stock U-Boot prompt after a cold boot). Read together the four PERIPHID bytes give 0x00141805 and the four PCELLID bytes give 0xB105F00D, the standard ARM SP805 identification (the PrimeCell ID is 0xB105F00D).";

        field {
            name = "id";
            desc = "Identification byte.";
            sw = r;
            hw = w;
            reset = 0x05;
        } id[7:0];
    } WDG_PCELLID2 @ 0xFF8;

    reg {
        name = "PrimeCell identification register 3";
        desc = "PrimeCell ID [31:24] = 0xB1. Read-only. Not in the data sheet (the data sheet lists only the registers up to WDG_LOCK); value read on hardware 2026-11-08 (Hi3520D V100, stock U-Boot prompt after a cold boot). Read together the four PERIPHID bytes give 0x00141805 and the four PCELLID bytes give 0xB105F00D, the standard ARM SP805 identification (the PrimeCell ID is 0xB105F00D).";

        field {
            name = "id";
            desc = "Identification byte.";
            sw = r;
            hw = w;
            reset = 0xB1;
        } id[7:0];
    } WDG_PCELLID3 @ 0xFFC;

`endif

};
`endif
