`ifndef HISI_IVE_RDL
`define HISI_IVE_RDL

// Shared by every chip with the 7-register IVE control block. Verified word for word against the Hi3516C V100 (data sheet issue 00B02, chapter 9, base 0x205E_0000, VIC 21),
// Hi3518A/C V100 (issue 01, chapter 9, 0x205E_0000, VIC 21), Hi3518E V100 (issue 03, chapter 9, 0x205E_0000) and Hi3516 V100 (Chinese issue 00B60, chapter 11, base 0x2013_0000)
// data sheets: identical offsets, bit ranges, access types and resets. The newer generation (Hi3516A/D, Hi3516AV200, Hi3516CV300, Hi3519V101, Hi3518EV200/Hi3516CV200) keeps the same
// seven registers (same names and offsets, bit tables not published) and adds the counters/clock-gating registers at 0x30-0x6C of the register summary; those are modelled below
// under `IVE_EXT_REGS` (define it in the chip's defines.rdl) as whole-register fields because no data sheet gives their bit layout.

regfile eHISI_IVE {
    name = "HiSilicon intelligent video engine";
    desc = "
    HiSilicon Intelligent Video Engine (IVE) (Hi3520D: base 0x205E0000, GIC interrupt ID 77; per-chip bases and interrupts in the table below): a hardware accelerator for image operators (DMA, 3x3 filter, YUV to RGB CSC, Sobel/Scharr gradients, canny magnitude and direction, erode, dilate, threshold, AND/OR/subtract of two images, integral image, histogram). It runs from a linked list of task nodes in DDR read over the AXI master (64-bit); the APB slave (32-bit) only holds the 7 control and status registers below (start, interrupt enable/raw/status, link-table start address, working status, completed task id). The node layout (Figure 10-1) and the operator parameters live in the linked list in memory, not in registers, so they are not modelled here. Registers are from Hi3520D/Hi3515A/Hi3515C data sheet issue 07, chapter 10 (`datasheet.txt` lines 31529-32830), checked against the original Chinese edition (issue 02, `hi3520dv100--Hi3520D-Hi3515A-Hi3515C-original.txt` lines 34320-34620) and identical in the Hi3516C/Hi3518/Hi3518E/Hi3516 V100 data sheets (see the file header). Clock and reset: PERI_CRG (IVE bits). Not hardware verified.

    | SoC | Base | Interrupt | Register description in the data sheet |
    |-----|------|-----------|-----------------------------------------|
    | Hi3516C V100, Hi3518A/C V100, Hi3518E V100 | 0x205E0000 | VIC 21 | 7 registers, bit tables |
    | Hi3516 V100 | 0x20130000 | not in its interrupt table | 7 registers, bit tables |
    | Hi3520D / Hi3515A / Hi3515C | 0x205E0000 | GIC 77 | 7 registers, bit tables |
    | Hi3516A / Hi3516D V100 | 0x206A0000 | GIC 77 | 7 + 9 summary-only registers |
    | Hi3518E V20X / Hi3516C V200 | 0x206A0000 | VIC 21 | 7 + 12 summary-only registers |
    | Hi3516A V200, Hi3519 V101 | 0x11040000 | GIC 71 | 7 + 9 summary-only registers |
    | Hi3516C V300 / Hi3516E V100 | 0x11230000 | VIC 21 | 7 + 9 summary-only registers (the EV100 edition's contents page prints 0x1104_0000, the memory map and table caption 0x1123_0000) |
    | Hi3516A V300 | 0x11230000 | GIC 69 | no register summary in the data sheet; registers inferred |

    Hi3511, Hi3515 and Hi3520 V100 have no IVE.

    VENDOR MODULES (2026-11-11, docs/rdl-campaign/ive-vendor.md; static analysis of hi3520D_ive.ko, hi3518_ive.ko, hi3516a_ive.ko, hi3518e_ive.ko, hi3519v101_ive.ko, hi3516cv300_ive.ko, open_ive.ko, nothing executed): the vendor driver touches only the 7 data-sheet registers plus a handful of the 0x30-0x6C block, so the data-sheet control path is confirmed on all chips with a module (INT_EN written 2 on the older generation Hi3520D/Hi3518 and 6 on the newer one, INT_RW cleared with 3 or 7, LIST_POINTER then START, IVE_TASK_ID read in the interrupt handler). Newer generation additions found in the code and modelled under IVE_EXT_REGS: bit 2 (timeout interrupt) in INT_EN/INT_RW/INT_STATUS, the overtime threshold at 0x60, clock gating bit 0 at 0x34, and two utilization counters at 0x84/0x88 that no data sheet lists. The Hi3516A V300 module also writes 0x54 (AXI outstanding), 0x8C and 0x90 (memory speed), modelled under IVE_AV300_REGS. Registers the vendor code never touches (0x30, 0x40-0x50, 0x64-0x6C) keep their data-sheet-summary-only descriptions.
    ";

    reg {
        name = "Start register";
        desc = "IVE_START is a start register.

Data sheet 10.5 IVE_START (offset 0x0, printed page 10-25, `datasheet.txt` line 32587).";

        field {
            name = "ive_start";
            desc = "ive_start";
            sw = w;
            hw = r;
            reset = 0x0;
        } ive_start[0:0];
    } IVE_START @ 0x0;

    reg {
        name = "Interrupt enable register";
        desc = "INT_EN is an interrupt enable register.

Data sheet 10.5 INT_EN (offset 0x4, printed page 10-26, `datasheet.txt` line 32620).";

        enum INT_EN_list_int_en_enum {
            DISABLED = 0 { name = "Disabled"; desc = "disabled"; };
            ENABLED = 1 { name = "Enabled"; desc = "enabled"; };
        };

        field {
            name = "list_int_en";
            desc = "Link table interrupt enable.";
            sw = rw;
            hw = r;
            encode = INT_EN_list_int_en_enum;
            reset = 0x0;
        } list_int_en[1:1];

        enum INT_EN_node_int_en_enum {
            DISABLED = 0 { name = "Disabled"; desc = "disabled"; };
            ENABLED = 1 { name = "Enabled"; desc = "enabled"; };
        };

        field {
            name = "node_int_en";
            desc = "Node interrupt enable.";
            sw = rw;
            hw = r;
            encode = INT_EN_node_int_en_enum;
            reset = 0x0;
        } node_int_en[0:0];

`ifdef IVE_EXT_REGS

        field {
            name = "timeout_int_en";
            desc = "Timeout (overtime) interrupt enable, newer IVE generation only. Not in any data sheet bit table. The vendor modules for Hi3516A/D, Hi3518E V200, Hi3516A V200/Hi3519, Hi3516C V300/Hi3516E V100 and Hi3516A V300 write INT_EN = 6 (this bit and list_int_en) in IVE_DRV_EnInt; the older generation writes 2. Source: vendor module hi3516a_ive.ko, hi3518e_ive.ko, hi3519v101_ive.ko, hi3516cv300_ive.ko, open_ive.ko (IVE_DRV_EnInt / drv_ive_en_int), confidence MEDIUM (bit meaning from the name of the consumer IVE_DRV_IsIveTimeoutInt), not verified on hardware.";
            sw = rw;
            hw = r;
        } timeout_int_en[2:2];
`endif
    } INT_EN @ 0x4;

    reg {
        name = "Raw interrupt register";
        desc = "INT_RW is a raw interrupt register.

Data sheet 10.5 INT_RW (offset 0x8, printed page 10-26, `datasheet.txt` line 32651).";

        enum INT_RW_list_int_rw_enum {
            NO_INTERRUPT_GENERATED = 0 { name = "No Interrupt Generated"; desc = "No interrupt is generated."; };
            INTERRUPT_GENERATED = 1 { name = "Interrupt Generated"; desc = "An interrupt is generated."; };
        };

        field {
            name = "list_int_rw";
            desc = "Link table raw interrupt. After reading an interrupt through INT_STATUS, the software writes INT_RW to clear the interrupt.";
            sw = rw;
            hw = r;
            encode = INT_RW_list_int_rw_enum;
            reset = 0x0;
        } list_int_rw[1:1];

        enum INT_RW_node_int_rw_enum {
            NO_INTERRUPT_GENERATED = 0 { name = "No Interrupt Generated"; desc = "No interrupt is generated."; };
            INTERRUPT_GENERATED = 1 { name = "Interrupt Generated"; desc = "An interrupt is generated."; };
        };

        field {
            name = "node_int_rw";
            desc = "Node raw interrupt. After reading an interrupt through INT_STATUS, the software writes INT_RW to clear the interrupt.";
            sw = rw;
            hw = r;
            encode = INT_RW_node_int_rw_enum;
            reset = 0x0;
        } node_int_rw[0:0];

`ifdef IVE_EXT_REGS

        field {
            name = "timeout_int_rw";
            desc = "Timeout interrupt raw bit, newer generation only (not in any data sheet bit table); the vendor interrupt handler clears all interrupts by writing 7 here (older generation: 3), IVE_DRV_ClearInt. Source: vendor module hi3516a_ive.ko, hi3518e_ive.ko, hi3519v101_ive.ko, hi3516cv300_ive.ko, open_ive.ko, confidence MEDIUM, not verified on hardware.";
            sw = rw;
            hw = r;
        } timeout_int_rw[2:2];
`endif
    } INT_RW @ 0x8;

    reg {
        name = "Interrupt status register";
        desc = "INT_STATUS is an interrupt status register.

Data sheet 10.5 INT_STATUS (offset 0xC, printed page 10-27, `datasheet.txt` line 32698).";

        enum INT_STATUS_list_int_status_enum {
            NO_INTERRUPT_GENERATED = 0 { name = "No Interrupt Generated"; desc = "No interrupt is generated."; };
            INTERRUPT_GENERATED = 1 { name = "Interrupt Generated"; desc = "An interrupt is generated."; };
        };

        field {
            name = "list_int_status";
            desc = "Link table interrupt status. The software determines whether a linked list interrupt is generated by reading this bit.";
            sw = r;
            hw = w;
            encode = INT_STATUS_list_int_status_enum;
            reset = 0x0;
        } list_int_status[1:1];

        enum INT_STATUS_node_int_status_enum {
            NO_INTERRUPT_GENERATED = 0 { name = "No Interrupt Generated"; desc = "No interrupt is generated."; };
            INTERRUPT_GENERATED = 1 { name = "Interrupt Generated"; desc = "An interrupt is generated."; };
        };

        field {
            name = "node_int_status";
            desc = "Node interrupt status. The software determines whether a node interrupt is generated by reading this bit.";
            sw = r;
            hw = w;
            encode = INT_STATUS_node_int_status_enum;
            reset = 0x0;
        } node_int_status[0:0];

`ifdef IVE_EXT_REGS

        field {
            name = "timeout_int_status";
            desc = "Timeout interrupt status, newer generation only (not in any data sheet bit table). IVE_DRV_IsIveTimeoutInt tests (value & 4) and IVE_DRV_IsIveListInt tests bit 1 (list_int_status) of the word IVE_DRV_GetIntStatus read from 0xC. Source: vendor module hi3516a_ive.ko, hi3518e_ive.ko, hi3519v101_ive.ko, hi3516cv300_ive.ko, open_ive.ko, confidence HIGH for the bit position, MEDIUM for the meaning, not verified on hardware.";
            sw = r;
            hw = w;
        } timeout_int_status[2:2];
`endif
    } INT_STATUS @ 0xC;

    reg {
        name = "Link table start address register";
        desc = "LIST_POINTER is a linked list start address register.

Data sheet 10.5 LIST_POINTER (offset 0x10, printed page 10-28, `datasheet.txt` line 32744).";

        field {
            name = "link_table_header_addr";
            desc = "Address of the first node in the linked list.";
            sw = rw;
            hw = r;
            reset = 0x0;
        } link_table_header_addr[31:0];
    } LIST_POINTER @ 0x10;

    reg {
        name = "IVE working status register";
        desc = "IVE_STATUS is an IVE working status register.

Data sheet 10.5 IVE_STATUS (offset 0x14, printed page 10-28, `datasheet.txt` line 32764).";

        enum IVE_STATUS_ive_working_status_enum {
            IDLE = 0 { name = "Idle"; desc = "idle"; };
            BUSY = 1 { name = "Busy"; desc = "busy"; };
        };

        field {
            name = "ive_working_status";
            desc = "Current working status of the IVE.";
            sw = r;
            hw = w;
            encode = IVE_STATUS_ive_working_status_enum;
            reset = 0x0;
        } ive_working_status[0:0];
    } IVE_STATUS @ 0x14;

    reg {
        name = "Completed task ID register";
        desc = "IVE_TASK_ID is a completed task ID register.

Data sheet 10.5 IVE_TASK_ID (offset 0x18, printed page 10-29, `datasheet.txt` line 32803).";

        field {
            name = "ive_task_id";
            desc = "ID of a task that was just completed. If task IDs are incremental, all tasks before a specified task have been completed.";
            sw = r;
            hw = w;
            reset = 0x0;
        } ive_task_id[15:0];
    } IVE_TASK_ID @ 0x18;

`ifdef IVE_EXT_REGS
    // Registers of the newer IVE generation (Hi3518E V20X/Hi3516C V200 data sheet 8.4 Table 8-1, `hi3518ev200--Hi3518EV20X-Hi3516CV200-Datasheet.txt` lines 49690-49735). Scripted audit 2026-11-11
    // (docs/rdl-campaign/ive.md): the Hi3516A/D (issue 08), Hi3516A V200, Hi3519 V101 and Hi3516C V300/Hi3516E V100 summaries list the 16 registers 0x30-0x6C without INT_DONE_CNT/INT_RD_CNT/INT_WR_CNT
    // (0x48/0x4C/0x50, only in the Hi3518E V20X/Hi3516C V200 table, gated by IVE_INT_CNT_REGS); the Hi3516A V300 user guide has NO IVE register summary at all, so its 0x30-0x6C registers are
    // inferred from the neighbor generation (confidence LOW). Only the summary (offset, name, one-line description) is published; no bit tables, no reset values, so each is a whole 32-bit field of unknown layout.
    reg {
        name = "Cycles consumed by the preceding node";
        desc = "NODE_CLK_VALUE: register for the number of cycles consumed by the preceding node (data sheet summary only; bit layout and reset not published).";
        field { name = "node_clk_value"; desc = "Number of clock cycles consumed by the preceding node (layout not published)."; sw = r; hw = w; } node_clk_value[31:0];
    } NODE_CLK_VALUE @ 0x30;

    reg {
        name = "Internal clock gating";
        desc = "CLK_GT_EN: clock gating of the IVE internal modules (data sheet summary only; bit layout and reset not published). Vendor-derived: IVE_DRV_EnIveClkGt (drv_ive_en_clk_gt) sets bit 0 by read-modify-write at init; no other bit is touched. Source: vendor module hi3516a_ive.ko, hi3518e_ive.ko, hi3519v101_ive.ko, hi3516cv300_ive.ko, hi3521a_ive.ko, open_ive.ko, confidence HIGH, not verified on hardware.";
        field { name = "clk_gt_en"; desc = "Clock gating enables of the IVE internal modules (layout not published)."; sw = rw; hw = r; } clk_gt_en[31:0];
    } CLK_GT_EN @ 0x34;

    reg {
        name = "Processed node count";
        desc = "NODE_DONE_CNT: register for the number of processed nodes (data sheet summary only).";
        field { name = "node_done_cnt"; desc = "Number of processed nodes (layout not published)."; sw = r; hw = w; } node_done_cnt[31:0];
    } NODE_DONE_CNT @ 0x40;

    reg {
        name = "Processed linked list count";
        desc = "LIST_DONE_CNT: register for the number of processed linked lists (data sheet summary only).";
        field { name = "list_done_cnt"; desc = "Number of processed linked lists (layout not published)."; sw = r; hw = w; } list_done_cnt[31:0];
    } LIST_DONE_CNT @ 0x44;

`ifdef IVE_INT_CNT_REGS
    reg {
        name = "Node interrupts reported by the current linked list";
        desc = "INT_DONE_CNT: count register for the node interrupts reported by the current linked list (listed only in the Hi3518E V20X/Hi3516C V200 data sheet summary, so instantiated only there under `IVE_INT_CNT_REGS`; the Hi3516A/D, Hi3516A V200, Hi3519, Hi3516C V300/Hi3516E V100 and Hi3516A V300 data sheets omit it, existence there unknown).";
        field { name = "int_done_cnt"; desc = "Node interrupts reported by the current linked list (layout not published)."; sw = r; hw = w; } int_done_cnt[31:0];
    } INT_DONE_CNT @ 0x48;

    reg {
        name = "Interrupts read by the current linked list";
        desc = "INT_RD_CNT: count register for the interrupts that have been successfully read by the current linked list (listed only in the Hi3518E V20X/Hi3516C V200 data sheet summary, so instantiated only there under `IVE_INT_CNT_REGS`; the Hi3516A/D, Hi3516A V200, Hi3519, Hi3516C V300/Hi3516E V100 and Hi3516A V300 data sheets omit it, existence there unknown).";
        field { name = "int_rd_cnt"; desc = "Interrupts read by the current linked list (layout not published)."; sw = r; hw = w; } int_rd_cnt[31:0];
    } INT_RD_CNT @ 0x4C;

    reg {
        name = "Interrupts cleared by the current linked list";
        desc = "INT_WR_CNT: count register for the interrupts that have been cleared by writing the current linked list (listed only in the Hi3518E V20X/Hi3516C V200 data sheet summary, so instantiated only there under `IVE_INT_CNT_REGS`; the Hi3516A/D, Hi3516A V200, Hi3519, Hi3516C V300/Hi3516E V100 and Hi3516A V300 data sheets omit it, existence there unknown).";
        field { name = "int_wr_cnt"; desc = "Interrupts cleared by the current linked list (layout not published)."; sw = r; hw = w; } int_wr_cnt[31:0];
    } INT_WR_CNT @ 0x50;
`endif

    reg {
        name = "AXI outstanding configuration";
        desc = "AXI_INFO: read and write outstanding number register (data sheet summary only; bit layout and reset not published). Vendor-derived: only the Hi3516A V300 module touches it (drv_ive_set_outstanding): bits [3:0] set to 7 and bits [11:8] set to 0xF by two read-modify-writes. The other modules never write it. Source: vendor module open_ive.ko, confidence MEDIUM (field meaning by the function name), not verified on hardware.";
        field { name = "axi_info"; desc = "AXI read/write outstanding numbers (layout not published)."; sw = rw; hw = r; } axi_info[31:0];
    } AXI_INFO @ 0x54;

    reg {
        name = "Overtime interrupt threshold";
        desc = "IVE_OVER_TIME_THR: overtime interrupt threshold register (data sheet summary only; bit layout and reset not published). Vendor-derived: IVE_DRV_WriteTimeOutRegs writes the whole word once at init (after enabling the interrupts): 0x0DB58580 (230000000) in hi3516a_ive.ko, 0x0CCCCB60 (214747000) in hi3518e_ive.ko; the same call is in hi3519v101_ive.ko, hi3516cv300_ive.ko and open_ive.ko. Source: vendor module those modules, confidence HIGH, not verified on hardware.";
        field { name = "ive_over_time_thr"; desc = "Operator overtime interrupt threshold in clock cycles (layout not published)."; sw = rw; hw = r; } ive_over_time_thr[31:0];
    } IVE_OVER_TIME_THR @ 0x60;

    reg {
        name = "Operator working cycle counter";
        desc = "IVE_OVER_TIME_CNT: register for the dynamic counting number of the operator working cycles (data sheet summary only).";
        field { name = "ive_over_time_cnt"; desc = "Running count of the operator working cycles (layout not published)."; sw = r; hw = w; } ive_over_time_cnt[31:0];
    } IVE_OVER_TIME_CNT @ 0x64;

    reg {
        name = "Cycles consumed by the preceding linked list";
        desc = "CHAIN_STAT_CLK_VALUE: register for the number of cycles consumed by the preceding linked list (data sheet summary only).";
        field { name = "chain_stat_clk_value"; desc = "Clock cycles consumed by the preceding linked list (layout not published)."; sw = r; hw = w; } chain_stat_clk_value[31:0];
    } CHAIN_STAT_CLK_VALUE @ 0x68;

    reg {
        name = "Current linked list cycle counter";
        desc = "CHAIN_CYCLE_CNT: register for the counting number of the current linked list cycles (data sheet summary only).";
        field { name = "chain_cycle_cnt"; desc = "Running count of the current linked list cycles (layout not published)."; sw = r; hw = w; } chain_cycle_cnt[31:0];
    } CHAIN_CYCLE_CNT @ 0x6C;

    reg {
        name = "IVE utilization busy counter";
        desc = "Not in any data sheet. Vendor-derived: IVE_DRV_GetUtili (drv_ive_get_utili, the 'IVE UTILI INFO' proc page) reads this word as the numerator and UTILI_TOTAL_CNT (0x88) as the divisor and computes a percentage (value * 100 / total); a guard on bit 1 of the word at offset 0 and on the divisor avoids division by zero. Read only. Source: vendor module hi3518e_ive.ko, hi3519v101_ive.ko, hi3516cv300_ive.ko, open_ive.ko (hi3516a_ive.ko and hi3521a_ive.ko have the function as a stub returning 0), confidence MEDIUM (roles inferred from the arithmetic and the proc text), not verified on hardware.";

        field {
            name = "utili_busy_cnt";
            desc = "Busy-cycle count used as the numerator of the utilization percentage (inferred, MEDIUM).";
            sw = r;
            hw = w;
        } utili_busy_cnt[31:0];
    } UTILI_BUSY_CNT @ 0x84;

    reg {
        name = "IVE utilization total counter";
        desc = "Not in any data sheet. Vendor-derived: divisor of the utilization computation in IVE_DRV_GetUtili (see UTILI_BUSY_CNT at 0x84). Read only. Source: vendor module hi3518e_ive.ko, hi3519v101_ive.ko, hi3516cv300_ive.ko, open_ive.ko, confidence MEDIUM, not verified on hardware.";

        field {
            name = "utili_total_cnt";
            desc = "Total-cycle count used as the divisor of the utilization percentage (inferred, MEDIUM).";
            sw = r;
            hw = w;
        } utili_total_cnt[31:0];
    } UTILI_TOTAL_CNT @ 0x88;

`ifdef IVE_AV300_REGS
    reg {
        name = "UNK_008C";
        desc = "Written by drv_ive_set_base_addr with its argument (a single word, probably an address; the caller was not followed). Access observed: written. Hi3516A V300 only (the older modules never write 0x8C). Unknown purpose, vendor-observed only, confidence LOW, not verified on hardware.";

        field {
            name = "value";
            desc = "32 bit value, single field (bit layout not observed). Unknown purpose, vendor-observed only, confidence LOW, not verified on hardware.";
            sw = w;
            hw = r;
        } value[31:0];
    } UNK_008C @ 0x8C;

    reg {
        name = "UNK_0090";
        desc = "Named after drv_ive_set_mem_speed (memory speed configuration), which performs twelve read-modify-writes on this register, each setting one 2 or 3 bit field: [25:23] = 3, [22:21] = 1, [20:19] = 1, [18:16] = 3, [15:14] = 1, [13:12] = 1, [11:10] = 0, [9:8] = 1, [7:6] = 1, [5:4] = 1, [3:2] = 2, [1:0] = 1 (assembled 0x01AB5159 if the other bits start at 0). Access observed: read-modify-write. Hi3516A V300 only. Field meanings unknown. Unknown purpose, vendor-observed only, confidence LOW, not verified on hardware.";

        field { name = "f_25_23_unk"; desc = "Written with 3. Unknown purpose, vendor-observed only, confidence LOW, not verified on hardware."; sw = rw; hw = r; } f_25_23_unk[25:23];
        field { name = "f_22_21_unk"; desc = "Written with 1. Unknown purpose, vendor-observed only, confidence LOW, not verified on hardware."; sw = rw; hw = r; } f_22_21_unk[22:21];
        field { name = "f_20_19_unk"; desc = "Written with 1. Unknown purpose, vendor-observed only, confidence LOW, not verified on hardware."; sw = rw; hw = r; } f_20_19_unk[20:19];
        field { name = "f_18_16_unk"; desc = "Written with 3. Unknown purpose, vendor-observed only, confidence LOW, not verified on hardware."; sw = rw; hw = r; } f_18_16_unk[18:16];
        field { name = "f_15_14_unk"; desc = "Written with 1. Unknown purpose, vendor-observed only, confidence LOW, not verified on hardware."; sw = rw; hw = r; } f_15_14_unk[15:14];
        field { name = "f_13_12_unk"; desc = "Written with 1. Unknown purpose, vendor-observed only, confidence LOW, not verified on hardware."; sw = rw; hw = r; } f_13_12_unk[13:12];
        field { name = "f_11_10_unk"; desc = "Cleared to 0. Unknown purpose, vendor-observed only, confidence LOW, not verified on hardware."; sw = rw; hw = r; } f_11_10_unk[11:10];
        field { name = "f_9_8_unk"; desc = "Written with 1. Unknown purpose, vendor-observed only, confidence LOW, not verified on hardware."; sw = rw; hw = r; } f_9_8_unk[9:8];
        field { name = "f_7_6_unk"; desc = "Written with 1. Unknown purpose, vendor-observed only, confidence LOW, not verified on hardware."; sw = rw; hw = r; } f_7_6_unk[7:6];
        field { name = "f_5_4_unk"; desc = "Written with 1. Unknown purpose, vendor-observed only, confidence LOW, not verified on hardware."; sw = rw; hw = r; } f_5_4_unk[5:4];
        field { name = "f_3_2_unk"; desc = "Written with 2. Unknown purpose, vendor-observed only, confidence LOW, not verified on hardware."; sw = rw; hw = r; } f_3_2_unk[3:2];
        field { name = "f_1_0_unk"; desc = "Written with 1. Unknown purpose, vendor-observed only, confidence LOW, not verified on hardware."; sw = rw; hw = r; } f_1_0_unk[1:0];
    } UNK_0090 @ 0x90;
`endif
`endif

};

`endif
