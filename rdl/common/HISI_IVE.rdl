`ifndef HISI_IVE_RDL
`define HISI_IVE_RDL


regfile eHISI_IVE {
    name = "HiSilicon intelligent video engine";
    desc = "
    HiSilicon Intelligent Video Engine (IVE) at 0x205E0000, GIC interrupt ID 77: a hardware accelerator for image operators (DMA, 3x3 filter, YUV to RGB CSC, Sobel/Scharr gradients, canny magnitude and direction, erode, dilate, threshold, AND/OR/subtract of two images, integral image, histogram). It runs from a linked list of task nodes in DDR read over the AXI master (64-bit); the APB slave (32-bit) only holds the 7 control and status registers below (start, interrupt enable/raw/status, link-table start address, working status, completed task id). The node layout (Figure 10-1) and the operator parameters live in the linked list in memory, not in registers, so they are not modelled here. Registers are from Hi3520D/Hi3515A/Hi3515C data sheet issue 07, chapter 10 (`datasheet.txt` lines 31529-32830). Clock and reset: PERI_CRG (IVE bits). Not hardware verified.
    ";

    reg {
        name = "Start register";
        desc = "IVE_START is a start register.

Data sheet 10.5 IVE_START (offset 0x0, printed page 10-25, `datasheet.txt` line 32587).";

        field {
            name = "ive_start";
            desc = "ive_start";
            sw = w;
            hw = r;
            reset = 0x0;
        } ive_start[0:0];
    } IVE_START @ 0x0;

    reg {
        name = "Interrupt enable register";
        desc = "INT_EN is an interrupt enable register.

Data sheet 10.5 INT_EN (offset 0x4, printed page 10-26, `datasheet.txt` line 32620).";

        enum INT_EN_list_int_en_enum {
            DISABLED = 0 { name = "Disabled"; desc = "disabled"; };
            ENABLED = 1 { name = "Enabled"; desc = "enabled"; };
        };

        field {
            name = "list_int_en";
            desc = "Link table interrupt enable.";
            sw = rw;
            hw = r;
            encode = INT_EN_list_int_en_enum;
            reset = 0x0;
        } list_int_en[1:1];

        enum INT_EN_node_int_en_enum {
            DISABLED = 0 { name = "Disabled"; desc = "disabled"; };
            ENABLED = 1 { name = "Enabled"; desc = "enabled"; };
        };

        field {
            name = "node_int_en";
            desc = "Node interrupt enable.";
            sw = rw;
            hw = r;
            encode = INT_EN_node_int_en_enum;
            reset = 0x0;
        } node_int_en[0:0];
    } INT_EN @ 0x4;

    reg {
        name = "Raw interrupt register";
        desc = "INT_RW is a raw interrupt register.

Data sheet 10.5 INT_RW (offset 0x8, printed page 10-26, `datasheet.txt` line 32651).";

        enum INT_RW_list_int_rw_enum {
            NO_INTERRUPT_GENERATED = 0 { name = "No Interrupt Generated"; desc = "No interrupt is generated."; };
            INTERRUPT_GENERATED = 1 { name = "Interrupt Generated"; desc = "An interrupt is generated."; };
        };

        field {
            name = "list_int_rw";
            desc = "Link table raw interrupt. After reading an interrupt through INT_STATUS, the software writes INT_RW to clear the interrupt.";
            sw = rw;
            hw = r;
            encode = INT_RW_list_int_rw_enum;
            reset = 0x0;
        } list_int_rw[1:1];

        enum INT_RW_node_int_rw_enum {
            NO_INTERRUPT_GENERATED = 0 { name = "No Interrupt Generated"; desc = "No interrupt is generated."; };
            INTERRUPT_GENERATED = 1 { name = "Interrupt Generated"; desc = "An interrupt is generated."; };
        };

        field {
            name = "node_int_rw";
            desc = "Node raw interrupt. After reading an interrupt through INT_STATUS, the software writes INT_RW to clear the interrupt.";
            sw = rw;
            hw = r;
            encode = INT_RW_node_int_rw_enum;
            reset = 0x0;
        } node_int_rw[0:0];
    } INT_RW @ 0x8;

    reg {
        name = "Interrupt status register";
        desc = "INT_STATUS is an interrupt status register.

Data sheet 10.5 INT_STATUS (offset 0xC, printed page 10-27, `datasheet.txt` line 32698).";

        enum INT_STATUS_list_int_status_enum {
            NO_INTERRUPT_GENERATED = 0 { name = "No Interrupt Generated"; desc = "No interrupt is generated."; };
            INTERRUPT_GENERATED = 1 { name = "Interrupt Generated"; desc = "An interrupt is generated."; };
        };

        field {
            name = "list_int_status";
            desc = "Link table interrupt status. The software determines whether a linked list interrupt is generated by reading this bit.";
            sw = r;
            hw = w;
            encode = INT_STATUS_list_int_status_enum;
            reset = 0x0;
        } list_int_status[1:1];

        enum INT_STATUS_node_int_status_enum {
            NO_INTERRUPT_GENERATED = 0 { name = "No Interrupt Generated"; desc = "No interrupt is generated."; };
            INTERRUPT_GENERATED = 1 { name = "Interrupt Generated"; desc = "An interrupt is generated."; };
        };

        field {
            name = "node_int_status";
            desc = "Node interrupt status. The software determines whether a node interrupt is generated by reading this bit.";
            sw = r;
            hw = w;
            encode = INT_STATUS_node_int_status_enum;
            reset = 0x0;
        } node_int_status[0:0];
    } INT_STATUS @ 0xC;

    reg {
        name = "Link table start address register";
        desc = "LIST_POINTER is a linked list start address register.

Data sheet 10.5 LIST_POINTER (offset 0x10, printed page 10-28, `datasheet.txt` line 32744).";

        field {
            name = "link_table_header_addr";
            desc = "Address of the first node in the linked list.";
            sw = rw;
            hw = r;
            reset = 0x0;
        } link_table_header_addr[31:0];
    } LIST_POINTER @ 0x10;

    reg {
        name = "IVE working status register";
        desc = "IVE_STATUS is an IVE working status register.

Data sheet 10.5 IVE_STATUS (offset 0x14, printed page 10-28, `datasheet.txt` line 32764).";

        enum IVE_STATUS_ive_working_status_enum {
            IDLE = 0 { name = "Idle"; desc = "idle"; };
            BUSY = 1 { name = "Busy"; desc = "busy"; };
        };

        field {
            name = "ive_working_status";
            desc = "Current working status of the IVE.";
            sw = r;
            hw = w;
            encode = IVE_STATUS_ive_working_status_enum;
            reset = 0x0;
        } ive_working_status[0:0];
    } IVE_STATUS @ 0x14;

    reg {
        name = "Completed task ID register";
        desc = "IVE_TASK_ID is a completed task ID register.

Data sheet 10.5 IVE_TASK_ID (offset 0x18, printed page 10-29, `datasheet.txt` line 32803).";

        field {
            name = "ive_task_id";
            desc = "ID of a task that was just completed. If task IDs are incremental, all tasks before a specified task have been completed.";
            sw = r;
            hw = w;
            reset = 0x0;
        } ive_task_id[15:0];
    } IVE_TASK_ID @ 0x18;

};

`endif
