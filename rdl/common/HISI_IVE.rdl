`ifndef HISI_IVE_RDL
`define HISI_IVE_RDL

// Shared by every chip with the 7-register IVE control block. Verified word for word against the Hi3516C V100 (data sheet issue 00B02, chapter 9, base 0x205E_0000, VIC 21),
// Hi3518A/C V100 (issue 01, chapter 9, 0x205E_0000, VIC 21), Hi3518E V100 (issue 03, chapter 9, 0x205E_0000) and Hi3516 V100 (Chinese issue 00B60, chapter 11, base 0x2013_0000)
// data sheets: identical offsets, bit ranges, access types and resets. The newer generation (Hi3516A/D, Hi3516AV200, Hi3516CV300, Hi3519V101, Hi3518EV200/Hi3516CV200) keeps the same
// seven registers (same names and offsets, bit tables not published) and adds the counters/clock-gating registers at 0x30-0x6C of the register summary; those are modelled below
// under `IVE_EXT_REGS` (define it in the chip's defines.rdl) as whole-register fields because no data sheet gives their bit layout.

regfile eHISI_IVE {
    name = "HiSilicon intelligent video engine";
    desc = "
    HiSilicon Intelligent Video Engine (IVE) (Hi3520D: base 0x205E0000, GIC interrupt ID 77; per-chip bases and interrupts in the table below): a hardware accelerator for image operators (DMA, 3x3 filter, YUV to RGB CSC, Sobel/Scharr gradients, canny magnitude and direction, erode, dilate, threshold, AND/OR/subtract of two images, integral image, histogram). It runs from a linked list of task nodes in DDR read over the AXI master (64-bit); the APB slave (32-bit) only holds the 7 control and status registers below (start, interrupt enable/raw/status, link-table start address, working status, completed task id). The node layout (Figure 10-1) and the operator parameters live in the linked list in memory, not in registers, so they are not modelled here. Registers are from Hi3520D/Hi3515A/Hi3515C data sheet issue 07, chapter 10 (`datasheet.txt` lines 31529-32830), checked against the original Chinese edition (issue 02, `hi3520dv100--Hi3520D-Hi3515A-Hi3515C-original.txt` lines 34320-34620) and identical in the Hi3516C/Hi3518/Hi3518E/Hi3516 V100 data sheets (see the file header). Clock and reset: PERI_CRG (IVE bits). Not hardware verified.

    | SoC | Base | Interrupt | Register description in the data sheet |
    |-----|------|-----------|-----------------------------------------|
    | Hi3516C V100, Hi3518A/C V100, Hi3518E V100 | 0x205E0000 | VIC 21 | 7 registers, bit tables |
    | Hi3516 V100 | 0x20130000 | not in its interrupt table | 7 registers, bit tables |
    | Hi3520D / Hi3515A / Hi3515C | 0x205E0000 | GIC 77 | 7 registers, bit tables |
    | Hi3516A / Hi3516D V100 | 0x206A0000 | GIC 77 | 7 + 9 summary-only registers |
    | Hi3518E V20X / Hi3516C V200 | 0x206A0000 | VIC 21 | 7 + 12 summary-only registers |
    | Hi3516A V200, Hi3519 V101 | 0x11040000 | GIC 71 | 7 + 9 summary-only registers |
    | Hi3516C V300 / Hi3516E V100 | 0x11230000 | VIC 21 | 7 + 9 summary-only registers (the EV100 edition's contents page prints 0x1104_0000, the memory map and table caption 0x1123_0000) |
    | Hi3516A V300 | 0x11230000 | GIC 69 | no register summary in the data sheet; registers inferred |

    Hi3511, Hi3515 and Hi3520 V100 have no IVE.
    ";

    reg {
        name = "Start register";
        desc = "IVE_START is a start register.

Data sheet 10.5 IVE_START (offset 0x0, printed page 10-25, `datasheet.txt` line 32587).";

        field {
            name = "ive_start";
            desc = "ive_start";
            sw = w;
            hw = r;
            reset = 0x0;
        } ive_start[0:0];
    } IVE_START @ 0x0;

    reg {
        name = "Interrupt enable register";
        desc = "INT_EN is an interrupt enable register.

Data sheet 10.5 INT_EN (offset 0x4, printed page 10-26, `datasheet.txt` line 32620).";

        enum INT_EN_list_int_en_enum {
            DISABLED = 0 { name = "Disabled"; desc = "disabled"; };
            ENABLED = 1 { name = "Enabled"; desc = "enabled"; };
        };

        field {
            name = "list_int_en";
            desc = "Link table interrupt enable.";
            sw = rw;
            hw = r;
            encode = INT_EN_list_int_en_enum;
            reset = 0x0;
        } list_int_en[1:1];

        enum INT_EN_node_int_en_enum {
            DISABLED = 0 { name = "Disabled"; desc = "disabled"; };
            ENABLED = 1 { name = "Enabled"; desc = "enabled"; };
        };

        field {
            name = "node_int_en";
            desc = "Node interrupt enable.";
            sw = rw;
            hw = r;
            encode = INT_EN_node_int_en_enum;
            reset = 0x0;
        } node_int_en[0:0];
    } INT_EN @ 0x4;

    reg {
        name = "Raw interrupt register";
        desc = "INT_RW is a raw interrupt register.

Data sheet 10.5 INT_RW (offset 0x8, printed page 10-26, `datasheet.txt` line 32651).";

        enum INT_RW_list_int_rw_enum {
            NO_INTERRUPT_GENERATED = 0 { name = "No Interrupt Generated"; desc = "No interrupt is generated."; };
            INTERRUPT_GENERATED = 1 { name = "Interrupt Generated"; desc = "An interrupt is generated."; };
        };

        field {
            name = "list_int_rw";
            desc = "Link table raw interrupt. After reading an interrupt through INT_STATUS, the software writes INT_RW to clear the interrupt.";
            sw = rw;
            hw = r;
            encode = INT_RW_list_int_rw_enum;
            reset = 0x0;
        } list_int_rw[1:1];

        enum INT_RW_node_int_rw_enum {
            NO_INTERRUPT_GENERATED = 0 { name = "No Interrupt Generated"; desc = "No interrupt is generated."; };
            INTERRUPT_GENERATED = 1 { name = "Interrupt Generated"; desc = "An interrupt is generated."; };
        };

        field {
            name = "node_int_rw";
            desc = "Node raw interrupt. After reading an interrupt through INT_STATUS, the software writes INT_RW to clear the interrupt.";
            sw = rw;
            hw = r;
            encode = INT_RW_node_int_rw_enum;
            reset = 0x0;
        } node_int_rw[0:0];
    } INT_RW @ 0x8;

    reg {
        name = "Interrupt status register";
        desc = "INT_STATUS is an interrupt status register.

Data sheet 10.5 INT_STATUS (offset 0xC, printed page 10-27, `datasheet.txt` line 32698).";

        enum INT_STATUS_list_int_status_enum {
            NO_INTERRUPT_GENERATED = 0 { name = "No Interrupt Generated"; desc = "No interrupt is generated."; };
            INTERRUPT_GENERATED = 1 { name = "Interrupt Generated"; desc = "An interrupt is generated."; };
        };

        field {
            name = "list_int_status";
            desc = "Link table interrupt status. The software determines whether a linked list interrupt is generated by reading this bit.";
            sw = r;
            hw = w;
            encode = INT_STATUS_list_int_status_enum;
            reset = 0x0;
        } list_int_status[1:1];

        enum INT_STATUS_node_int_status_enum {
            NO_INTERRUPT_GENERATED = 0 { name = "No Interrupt Generated"; desc = "No interrupt is generated."; };
            INTERRUPT_GENERATED = 1 { name = "Interrupt Generated"; desc = "An interrupt is generated."; };
        };

        field {
            name = "node_int_status";
            desc = "Node interrupt status. The software determines whether a node interrupt is generated by reading this bit.";
            sw = r;
            hw = w;
            encode = INT_STATUS_node_int_status_enum;
            reset = 0x0;
        } node_int_status[0:0];
    } INT_STATUS @ 0xC;

    reg {
        name = "Link table start address register";
        desc = "LIST_POINTER is a linked list start address register.

Data sheet 10.5 LIST_POINTER (offset 0x10, printed page 10-28, `datasheet.txt` line 32744).";

        field {
            name = "link_table_header_addr";
            desc = "Address of the first node in the linked list.";
            sw = rw;
            hw = r;
            reset = 0x0;
        } link_table_header_addr[31:0];
    } LIST_POINTER @ 0x10;

    reg {
        name = "IVE working status register";
        desc = "IVE_STATUS is an IVE working status register.

Data sheet 10.5 IVE_STATUS (offset 0x14, printed page 10-28, `datasheet.txt` line 32764).";

        enum IVE_STATUS_ive_working_status_enum {
            IDLE = 0 { name = "Idle"; desc = "idle"; };
            BUSY = 1 { name = "Busy"; desc = "busy"; };
        };

        field {
            name = "ive_working_status";
            desc = "Current working status of the IVE.";
            sw = r;
            hw = w;
            encode = IVE_STATUS_ive_working_status_enum;
            reset = 0x0;
        } ive_working_status[0:0];
    } IVE_STATUS @ 0x14;

    reg {
        name = "Completed task ID register";
        desc = "IVE_TASK_ID is a completed task ID register.

Data sheet 10.5 IVE_TASK_ID (offset 0x18, printed page 10-29, `datasheet.txt` line 32803).";

        field {
            name = "ive_task_id";
            desc = "ID of a task that was just completed. If task IDs are incremental, all tasks before a specified task have been completed.";
            sw = r;
            hw = w;
            reset = 0x0;
        } ive_task_id[15:0];
    } IVE_TASK_ID @ 0x18;

`ifdef IVE_EXT_REGS
    // Registers of the newer IVE generation (Hi3518E V20X/Hi3516C V200 data sheet 8.4 Table 8-1, `hi3518ev200--Hi3518EV20X-Hi3516CV200-Datasheet.txt` lines 49690-49735). Scripted audit 2026-11-11
    // (docs/rdl-campaign/ive.md): the Hi3516A/D (issue 08), Hi3516A V200, Hi3519 V101 and Hi3516C V300/Hi3516E V100 summaries list the 16 registers 0x30-0x6C without INT_DONE_CNT/INT_RD_CNT/INT_WR_CNT
    // (0x48/0x4C/0x50, only in the Hi3518E V20X/Hi3516C V200 table, gated by IVE_INT_CNT_REGS); the Hi3516A V300 user guide has NO IVE register summary at all, so its 0x30-0x6C registers are
    // inferred from the neighbor generation (confidence LOW). Only the summary (offset, name, one-line description) is published; no bit tables, no reset values, so each is a whole 32-bit field of unknown layout.
    reg {
        name = "Cycles consumed by the preceding node";
        desc = "NODE_CLK_VALUE: register for the number of cycles consumed by the preceding node (data sheet summary only; bit layout and reset not published).";
        field { name = "node_clk_value"; desc = "Number of clock cycles consumed by the preceding node (layout not published)."; sw = r; hw = w; } node_clk_value[31:0];
    } NODE_CLK_VALUE @ 0x30;

    reg {
        name = "Internal clock gating";
        desc = "CLK_GT_EN: clock gating of the IVE internal modules (data sheet summary only; bit layout and reset not published).";
        field { name = "clk_gt_en"; desc = "Clock gating enables of the IVE internal modules (layout not published)."; sw = rw; hw = r; } clk_gt_en[31:0];
    } CLK_GT_EN @ 0x34;

    reg {
        name = "Processed node count";
        desc = "NODE_DONE_CNT: register for the number of processed nodes (data sheet summary only).";
        field { name = "node_done_cnt"; desc = "Number of processed nodes (layout not published)."; sw = r; hw = w; } node_done_cnt[31:0];
    } NODE_DONE_CNT @ 0x40;

    reg {
        name = "Processed linked list count";
        desc = "LIST_DONE_CNT: register for the number of processed linked lists (data sheet summary only).";
        field { name = "list_done_cnt"; desc = "Number of processed linked lists (layout not published)."; sw = r; hw = w; } list_done_cnt[31:0];
    } LIST_DONE_CNT @ 0x44;

`ifdef IVE_INT_CNT_REGS
    reg {
        name = "Node interrupts reported by the current linked list";
        desc = "INT_DONE_CNT: count register for the node interrupts reported by the current linked list (listed only in the Hi3518E V20X/Hi3516C V200 data sheet summary, so instantiated only there under `IVE_INT_CNT_REGS`; the Hi3516A/D, Hi3516A V200, Hi3519, Hi3516C V300/Hi3516E V100 and Hi3516A V300 data sheets omit it, existence there unknown).";
        field { name = "int_done_cnt"; desc = "Node interrupts reported by the current linked list (layout not published)."; sw = r; hw = w; } int_done_cnt[31:0];
    } INT_DONE_CNT @ 0x48;

    reg {
        name = "Interrupts read by the current linked list";
        desc = "INT_RD_CNT: count register for the interrupts that have been successfully read by the current linked list (listed only in the Hi3518E V20X/Hi3516C V200 data sheet summary, so instantiated only there under `IVE_INT_CNT_REGS`; the Hi3516A/D, Hi3516A V200, Hi3519, Hi3516C V300/Hi3516E V100 and Hi3516A V300 data sheets omit it, existence there unknown).";
        field { name = "int_rd_cnt"; desc = "Interrupts read by the current linked list (layout not published)."; sw = r; hw = w; } int_rd_cnt[31:0];
    } INT_RD_CNT @ 0x4C;

    reg {
        name = "Interrupts cleared by the current linked list";
        desc = "INT_WR_CNT: count register for the interrupts that have been cleared by writing the current linked list (listed only in the Hi3518E V20X/Hi3516C V200 data sheet summary, so instantiated only there under `IVE_INT_CNT_REGS`; the Hi3516A/D, Hi3516A V200, Hi3519, Hi3516C V300/Hi3516E V100 and Hi3516A V300 data sheets omit it, existence there unknown).";
        field { name = "int_wr_cnt"; desc = "Interrupts cleared by the current linked list (layout not published)."; sw = r; hw = w; } int_wr_cnt[31:0];
    } INT_WR_CNT @ 0x50;
`endif

    reg {
        name = "AXI outstanding configuration";
        desc = "AXI_INFO: read and write outstanding number register (data sheet summary only; bit layout and reset not published).";
        field { name = "axi_info"; desc = "AXI read/write outstanding numbers (layout not published)."; sw = rw; hw = r; } axi_info[31:0];
    } AXI_INFO @ 0x54;

    reg {
        name = "Overtime interrupt threshold";
        desc = "IVE_OVER_TIME_THR: overtime interrupt threshold register (data sheet summary only; bit layout and reset not published).";
        field { name = "ive_over_time_thr"; desc = "Operator overtime interrupt threshold in clock cycles (layout not published)."; sw = rw; hw = r; } ive_over_time_thr[31:0];
    } IVE_OVER_TIME_THR @ 0x60;

    reg {
        name = "Operator working cycle counter";
        desc = "IVE_OVER_TIME_CNT: register for the dynamic counting number of the operator working cycles (data sheet summary only).";
        field { name = "ive_over_time_cnt"; desc = "Running count of the operator working cycles (layout not published)."; sw = r; hw = w; } ive_over_time_cnt[31:0];
    } IVE_OVER_TIME_CNT @ 0x64;

    reg {
        name = "Cycles consumed by the preceding linked list";
        desc = "CHAIN_STAT_CLK_VALUE: register for the number of cycles consumed by the preceding linked list (data sheet summary only).";
        field { name = "chain_stat_clk_value"; desc = "Clock cycles consumed by the preceding linked list (layout not published)."; sw = r; hw = w; } chain_stat_clk_value[31:0];
    } CHAIN_STAT_CLK_VALUE @ 0x68;

    reg {
        name = "Current linked list cycle counter";
        desc = "CHAIN_CYCLE_CNT: register for the counting number of the current linked list cycles (data sheet summary only).";
        field { name = "chain_cycle_cnt"; desc = "Running count of the current linked list cycles (layout not published)."; sw = r; hw = w; } chain_cycle_cnt[31:0];
    } CHAIN_CYCLE_CNT @ 0x6C;
`endif

};

`endif
