`ifndef HISI_MIPI_RX_AV100_RDL
`define HISI_MIPI_RX_AV100_RDL


regfile eHISI_MIPI_RX_AV100 {
    name = "MIPI RX (sensor serial interface receiver, Hi3516A/D V100)";
    desc = "
    MIPI RX (combo PHY + controller for MIPI D-PHY CSI-2, LVDS / sub-LVDS / HiSPI and CMOS parallel sensors, feeding the VICAP) of the Hi3516A V100 / Hi3516D V100 at 0x20680000. Two links (link 0 at 0x1000, link 1 at 0x1400, each with interrupt, lane, PHY, MIPI data-ID / packet-error, FSM registers and per-lane LVDS sync codes at +0x80); 38 of the 42 registers of the Hi3518E V20X `eHISI_MIPI_RX` are identical by offset, fields and reset (that block lacks LVDS_WDR_MODE 0x10, MIPI_RSTN 0x1034 and link 1, and has MIPI_USERDEF_DT/USER_DEF/CROPSTART/CTRL_MODE at 0x18-0x24 which this chip's data sheet does not list). The vendor header adds PHY_MODE/POWER/DLY, the lane 2/3 sync codes, the PHY status set at 0x1200/0x1600 and MIPI_IMGSIZE_CHN0/1 at 0x800. Non-hardware-verified transcription.

    Generated 2026-11-10 by build/rdl-audit/video-rdl-scratch/gen_blocks.py: mechanical transcription of the data sheet register tables (ds_extract2 + description extraction from the PDF) merged with the vendor header; not hardware verified.

    Register sources: 64 registers from the data sheet (hi3516av100--Hi3516A-Hi3516D-Datasheet.txt, section 10.3.6); 71 registers and 50 fields from OpenIPC openhisilicon `kernel/mipi_rx/hi3516av100/mipi_reg.h` (GPL-3.0 repository, HiSilicon copyright; local copy sources/openhisilicon) (GPL-3.0 repository, HiSilicon copyright; byte-identical to the hi3516cv200 file), each marked `[inferred]` in its desc (names from the header, meanings inferred from the names, reset/access unknown). 4 field names that the data-sheet text extraction garbled (two column cells run together) were taken from the header. Name differences, data sheet kept: 0x4 name DS MIPI_CTRL_MODE / header MIPI_CTRL_PARAM; 0x1014 LANE_ID_LINK0 header field lane0_id [2:0] overlaps DS fields differently; 0x1014 LANE_ID_LINK0 header field lane1_id [6:4] overlaps DS fields differently; 0x1014 LANE_ID_LINK0 header field lane2_id [10:8] overlaps DS fields differently; 0x1014 LANE_ID_LINK0 header field lane3_id [14:12] overlaps DS fields differently; 0x1030 name DS MIPI_LANES_NUM / header MIPI_LANES_NUM_LINK0; 0x1030 MIPI_LANES_NUM [1:0] DS  / header mipi_lane_num; 0x1034 name DS MIPI_RSTN / header MIPI_RSTN_LINK0; 0x1038 name DS MIPI_DI_1 / header MIPI_DI_1_LINK0; 0x103C name DS MIPI_DI_2 / header MIPI_DI_2_LINK0; 0x1040 name DS MIPI_INTR1_RAW / header MIPI_INTR1_RAW_LINK0; 0x1044 name DS MIPI_INTR2_RAW / header MIPI_INTR2_RAW_LINK0; 0x1044 MIPI_INTR2_RAW [8:8] data-sheet text `ctedintr_vc0_ecc_corrected` garbled, header name intr_vc0_ecc_corrected used; 0x1044 MIPI_INTR2_RAW [9:9] data-sheet text `ctedintr_vc1_ecc_correctedintr_vc0_ecc_corre` garbled, header name intr_vc1_ecc_corrected used; 0x1044 MIPI_INTR2_RAW [10:10] data-sheet text `ctedintr_vc2_ecc_correctedintr_vc1_ecc_corre` garbled, header name intr_vc2_ecc_corrected used; 0x1044 MIPI_INTR2_RAW [11:11] data-sheet text `intr_vc3_ecc_correctedintr_vc2_ecc_corre` garbled, header name intr_vc3_ecc_corrected used; 0x1048 name DS MIPI_INTR1_MASK / header MIPI_INTR1_MASK_LINK0; 0x104C name DS MIPI_INTR2_MASK / header MIPI_INTR2_MASK_LINK0; 0x1060 name DS MIPI_TIMEOUT / header MIPI_TIMEOUT_LINK0; 0x1064 name DS MIPI_FSM_PARAM / header MIPI_FSM_PARAM_LINK0; 0x1064 MIPI_FSM_PARAM [13:8] DS cyc_data_hs_trail / header cyc_data_hs0; 0x1068 name DS MIPI_FSM_CKEN / header MIPI_FSM_CKEN_LINK0; 0x1414 LANE_ID_LINK1 header field lane0_id [2:0] overlaps DS fields differently; 0x1414 LANE_ID_LINK1 header field lane1_id [6:4] overlaps DS fields differently; 0x1414 LANE_ID_LINK1 header field lane2_id [10:8] overlaps DS fields differently; 0x1414 LANE_ID_LINK1 header field lane3_id [14:12] overlaps DS fields differently; 0x1428 PHY_CFG_LINK1 [3:0] DS rg_en_d / header phy_rg_en_d; 0x1428 PHY_CFG_LINK1 [4:4] DS rg_en_clk / header phy_rg_en_clk; 0x1428 PHY_CFG_LINK1 [8:8] DS rg_en_cmos / header phy_rg_en_cmos; 0x1428 PHY_CFG_LINK1 [12:12] DS rg_en_lp / header phy_rg_en_lp; 0x1428 PHY_CFG_LINK1 [19:16] DS da_ulpb / header phy_da_ulpb; 0x1428 PHY_CFG_LINK1 [20:20] DS da_ulpb_ck / header phy_da_ulpb_ck; 0x1428 PHY_CFG_LINK1 [25:24] DS rg_it_lp / header phy_rg_it_lp; 0x1428 PHY_CFG_LINK1 [27:26] DS rg_it_ck / header phy_rg_it_ck; 0x1428 PHY_CFG_LINK1 [29:28] DS rg_it_dt / header phy_rg_it_dt; 0x1428 PHY_CFG_LINK1 [30:30] DS rg_sa_en / header phy_rg_sa_en.";

    reg {
        name = "MIPI configuration enable register";
        desc = "MIPI_START is an MIPI configuration enable register. Huawei Proprietary and Confidential Hi3516A/Hi3516D Professional HD IP Camera SoC

Data sheet 10.3.6 MIPI_START (offset 0x0, printed page 10-281, `hi3516av100--Hi3516A-Hi3516D-Datasheet.txt` line 74566).";

        enum MIPI_START_mipi_start_enum {
            DISABLED = 0 { name = "Disabled"; desc = "disabled"; };
            ENABLED_APB_CLOCK = 1 { name = "Enabled Apb Clock"; desc = "enabled the APB clock domain configuration signal and convert it into the MIPI working clock domain output."; };
        };

        field {
            name = "mipi_start";
            desc = "Configuration enable.";
            sw = rw;
            hw = r;
            encode = MIPI_START_mipi_start_enum;
            reset = 0x0;
        } mipi_start[0:0];
    } MIPI_START @ 0x0;

    reg {
        name = "MIPI controller configuration register";
        desc = "MIPI_CTRL_MODE is an MIPI controller configuration register.

Data sheet 10.3.6 MIPI_CTRL_MODE (offset 0x4, printed page 10-281, `hi3516av100--Hi3516A-Hi3516D-Datasheet.txt` line 74596).";

        enum MIPI_CTRL_MODE_mipi_mem_ck_gt_enum {
            DISABLED = 0 { name = "Disabled"; desc = "disabled"; };
            ENABLED = 1 { name = "Enabled"; desc = "enabled"; };
        };

        field {
            name = "mipi_mem_ck_gt";
            desc = "MIPI memory clock gating enable.";
            sw = rw;
            hw = r;
            encode = MIPI_CTRL_MODE_mipi_mem_ck_gt_enum;
            reset = 0x0;
        } mipi_mem_ck_gt[0:0];
    } MIPI_CTRL_MODE @ 0x4;

    reg {
        name = "MIPI image size register";
        desc = "LVDS_IMGSIZE is an MIPI image size register.

Data sheet 10.3.6 LVDS_IMGSIZE (offset 0xC, printed page 10-282, `hi3516av100--Hi3516A-Hi3516D-Datasheet.txt` line 74630).";

        field {
            name = "lvds_imgheight";
            desc = "Image height. The value is the actual image height minus 1, and the value range is [0, 8191].";
            sw = rw;
            hw = r;
            reset = 0x0;
        } lvds_imgheight[28:16];

        field {
            name = "lvds_imgwidth";
            desc = "Image width. The value is the actual image width minus 1, and the value range is [0, 8191].";
            sw = rw;
            hw = r;
            reset = 0x0;
        } lvds_imgwidth[12:0];
    } LVDS_IMGSIZE @ 0xC;

    reg {
        name = "Sensor WDR mode configuration register";
        desc = "LVDS_WDR_MODE is a sensor WDR mode configuration register.

Data sheet 10.3.6 LVDS_WDR_MODE (offset 0x10, printed page 10-282, `hi3516av100--Hi3516A-Hi3516D-Datasheet.txt` line 74659).";

        enum LVDS_WDR_MODE_wdr_mode_enum {
            NORMAL_WDR_MODE = 0 { name = "Normal Wdr Mode"; desc = "normal WDR mode"; };
            SONY_DOL_WDR = 1 { name = "Sony Dol Wdr"; desc = "SONY DOL WDR mode. For images of the same exposure length, the current frame has a different synchronization code from the next frame."; };
        };

        field {
            name = "wdr_mode";
            desc = "WDR mode configuration. This signal is valid only if lvds_wdr_en is enabled and lvds_sync_mode is set to 1.";
            sw = r;
            hw = w;
            encode = LVDS_WDR_MODE_wdr_mode_enum;
            reset = 0x0;
        } wdr_mode[8:8];

        field {
            name = "lvds_wdr_num";
            desc = "WDR mode configuration. 01: two-frame WDR Other: reserved";
            sw = rw;
            hw = r;
            reset = 0x0;
        } lvds_wdr_num[5:4];

        enum LVDS_WDR_MODE_lvds_wdr_en_enum {
            LINEAR_MODE = 0 { name = "Linear Mode"; desc = "linear mode"; };
            WDR_MODE = 1 { name = "Wdr Mode"; desc = "WDR mode"; };
        };

        field {
            name = "lvds_wdr_en";
            desc = "WDR enable.";
            sw = rw;
            hw = r;
            encode = LVDS_WDR_MODE_lvds_wdr_en_enum;
            reset = 0x0;
        } lvds_wdr_en[0:0];
    } LVDS_WDR_MODE @ 0x10;

    reg {
        name = "LVDS operating mode configuration E register";
        desc = "LVDS_CTRL_MODE is an LVDS operating mode configuration register.

Data sheet 10.3.6 LVDS_CTRL_MODE (offset 0x14, printed page 10-283, `hi3516av100--Hi3516A-Hi3516D-Datasheet.txt` line 74709).";

        enum LVDS_CTRL_MODE_lvds_link_seq_enum {
            SYNCHRONOUS_TRANSMISSION_MODE = 0 { name = "Synchronous Transmission Mode"; desc = "synchronous transmission mode for two links of the normal sensor"; };
            ASYNCHRONOUS_TRANSMISSION_MODE = 1 { name = "Asynchronous Transmission Mode"; desc = "asynchronous transmission mode for two links of the Panasonic sensor"; };
        };

        field {
            name = "lvds_link_seq";
            desc = "Sequence of two links in LVDS mode.";
            sw = rw;
            hw = r;
            encode = LVDS_CTRL_MODE_lvds_link_seq_enum;
            reset = 0x0;
        } lvds_link_seq[12:12];

        enum LVDS_CTRL_MODE_lvds_code_big_endian_enum {
            LSB_LEAST_SIGNIFICANT = 0 { name = "Lsb Least Significant"; desc = "LSB. Least significant bits are transmitted first. Use RAW12 as an example. The serial data sequence of the synchronization code (sync_code) received is bit 0, bit 1, …, bit 11."; };
            MSB_MOST_SIGNIFICANT = 1 { name = "Msb Most Significant"; desc = "MSB. Most significant bits are transmitted first. Use RAW12 as an example. The serial data sequence of the synchronization code (sync_code) received is bit 11, bit 10, …, bit 0."; };
        };

        field {
            name = "lvds_code_big_endian";
            desc = "Serial bit transmission sequence for the synchronization code (sync_code) of raw data to be transmitted in LVDS or HiSPI mode.";
            sw = rw;
            hw = r;
            encode = LVDS_CTRL_MODE_lvds_code_big_endian_enum;
            reset = 0x1;
        } lvds_code_big_endian[9:9];

        enum LVDS_CTRL_MODE_lvds_pix_big_endian_enum {
            LSB_LEAST_SIGNIFICANT = 0 { name = "Lsb Least Significant"; desc = "LSB. Least significant bits are transmitted first. Use RAW12 as an example. The serial data sequence of the valid pixels received is bit 0, bit 1, …, bit 11."; };
            MSB_MOST_SIGNIFICANT = 1 { name = "Msb Most Significant"; desc = "MSB. Most significant bits are transmitted first. Use RAW12 as an example. The serial data sequence of the valid pixels received is bit 11, bit 10, …, bit 0."; };
        };

        field {
            name = "lvds_pix_big_endian";
            desc = "Serial bit transmission sequence for the valid pixels of raw data to be transmitted in LVDS or HiSPI mode.";
            sw = rw;
            hw = r;
            encode = LVDS_CTRL_MODE_lvds_pix_big_endian_enum;
            reset = 0x1;
        } lvds_pix_big_endian[8:8];

        enum LVDS_CTRL_MODE_lvds_raw_type_enum {
            RESERVED = 0 { name = "Reserved"; desc = "reserved"; };
            RAW_10_BIT = 1 { name = "Raw 10 Bit"; desc = "raw 10 bit"; };
            RAW_12_BITS = 2 { name = "Raw 12 Bits"; desc = "raw 12 bits"; };
            RAW_14_BITS = 3 { name = "Raw 14 Bits"; desc = "raw 14 bits"; };
        };

        field {
            name = "lvds_raw_type";
            desc = "Type of raw data to be transmitted in LVDS or HiSPI mode.";
            sw = rw;
            hw = r;
            encode = LVDS_CTRL_MODE_lvds_raw_type_enum;
            reset = 0x1;
        } lvds_raw_type[5:4];

        enum LVDS_CTRL_MODE_lvds_sync_mode_enum {
            SOF_EOF_SOL = 0 { name = "Sof Eof Sol"; desc = "SOF, EOF, SOL, or EOL mode"; };
            SAV_EAV_MODE = 1 { name = "Sav Eav Mode"; desc = "SAV-EAV mode SAV-EAV mode is widely applied in SONY/OmniVision sensors. In this mode, set InValid SAV/EAV in LINKm_LANEn_SOF_xx or LINKm_LANEn_EOF_xx, and set Valid SAV/EAV in LINKm_LANEn_SOL_xx or LINKm_LANEn_SOL_xx. Here, m is 0 or 1, and n is 0, 1, 2, or 3. In HiSPI mode, this field must be set to 0."; };
        };

        field {
            name = "lvds_sync_mode";
            desc = "Frame or line synchronization mode in LVDS mode.";
            sw = rw;
            hw = r;
            encode = LVDS_CTRL_MODE_lvds_sync_mode_enum;
            reset = 0x0;
        } lvds_sync_mode[0:0];
    } LVDS_CTRL_MODE @ 0x14;

    reg {
        name = "MIPI IMGSIZE CHN0";
        desc = "[inferred] MIPI IMGSIZE CHN0. Not in the data sheet. Source: OpenIPC openhisilicon `kernel/mipi_rx/hi3516av100/mipi_reg.h` (GPL-3.0 repository, HiSilicon copyright; local copy sources/openhisilicon), union `U_MIPI_IMGSIZE_CHN0`, struct offset 0x800 (GPL-3.0 repository, HiSilicon copyright; byte-identical to the hi3516cv200 file). Reset value and access type unknown (modelled RW, no reset). Confidence: medium (vendor header for this chip family, not hardware verified).";

        field {
            name = "imgheight_statis_vc0";
            desc = "[inferred] Imgheight statis vc0. (vendor header `hi3516av100/mipi_reg.h` field `imgheight_statis_vc0`; access and reset unknown, modelled RW)";
            sw = rw;
            hw = r;
        } imgheight_statis_vc0[28:16];

        field {
            name = "imgwidth_statis_vc0";
            desc = "[inferred] Imgwidth statis vc0. (vendor header `hi3516av100/mipi_reg.h` field `imgwidth_statis_vc0`; access and reset unknown, modelled RW)";
            sw = rw;
            hw = r;
        } imgwidth_statis_vc0[12:0];
    } MIPI_IMGSIZE_CHN0 @ 0x800;

    reg {
        name = "MIPI IMGSIZE CHN1";
        desc = "[inferred] MIPI IMGSIZE CHN1. Not in the data sheet. Source: OpenIPC openhisilicon `kernel/mipi_rx/hi3516av100/mipi_reg.h` (GPL-3.0 repository, HiSilicon copyright; local copy sources/openhisilicon), union `U_MIPI_IMGSIZE_CHN1`, struct offset 0x804 (GPL-3.0 repository, HiSilicon copyright; byte-identical to the hi3516cv200 file). Reset value and access type unknown (modelled RW, no reset). Confidence: medium (vendor header for this chip family, not hardware verified).";

        field {
            name = "imgheight_statis_vc1";
            desc = "[inferred] Imgheight statis vc1. (vendor header `hi3516av100/mipi_reg.h` field `imgheight_statis_vc1`; access and reset unknown, modelled RW)";
            sw = rw;
            hw = r;
        } imgheight_statis_vc1[28:16];

        field {
            name = "imgwidth_statis_vc1";
            desc = "[inferred] Imgwidth statis vc1. (vendor header `hi3516av100/mipi_reg.h` field `imgwidth_statis_vc1`; access and reset unknown, modelled RW)";
            sw = rw;
            hw = r;
        } imgwidth_statis_vc1[12:0];
    } MIPI_IMGSIZE_CHN1 @ 0x804;

    reg {
        name = "Link 0 interrupt status register";
        desc = "INT_STAT_LINK0 is a link 0 interrupt status register. Huawei Proprietary and Confidential Hi3516A/Hi3516D Professional HD IP Camera SoC

Data sheet 10.3.6 INT_STAT_LINK0 (offset 0x1000, printed page 10-285, `hi3516av100--Hi3516A-Hi3516D-Datasheet.txt` line 74795).";

        enum INT_STAT_LINK0_vsync_err_stat_enum {
            NO_INTERRUPT_GENERATED = 0 { name = "No Interrupt Generated"; desc = "No interrupt is generated."; };
            INTERRUPT_GENERATED = 1 { name = "Interrupt Generated"; desc = "An interrupt is generated."; };
        };

        field {
            name = "vsync_err_stat";
            desc = "SOF or EOF signal async interrupt status for each lane on link 0.";
            sw = r;
            hw = w;
            encode = INT_STAT_LINK0_vsync_err_stat_enum;
            reset = 0x0;
        } vsync_err_stat[21:21];

        enum INT_STAT_LINK0_hsync_err_stat_enum {
            NO_INTERRUPT_GENERATED = 0 { name = "No Interrupt Generated"; desc = "No interrupt is generated."; };
            INTERRUPT_GENERATED = 1 { name = "Interrupt Generated"; desc = "An interrupt is generated."; };
        };

        field {
            name = "hsync_err_stat";
            desc = "SOL or EOL signal async interrupt status for each lane on link 0.";
            sw = r;
            hw = w;
            encode = INT_STAT_LINK0_hsync_err_stat_enum;
            reset = 0x0;
        } hsync_err_stat[20:20];

        enum INT_STAT_LINK0_lane3_sync_err_stat_enum {
            NO_INTERRUPT_GENERATED = 0 { name = "No Interrupt Generated"; desc = "No interrupt is generated."; };
            INTERRUPT_GENERATED = 1 { name = "Interrupt Generated"; desc = "An interrupt is generated."; };
        };

        field {
            name = "lane3_sync_err_stat";
            desc = "EOL or EOF signal detection failure interrupt status for lane 3 on link 0 in LVDS mode.";
            sw = r;
            hw = w;
            encode = INT_STAT_LINK0_lane3_sync_err_stat_enum;
            reset = 0x0;
        } lane3_sync_err_stat[19:19];

        enum INT_STAT_LINK0_lane2_sync_err_stat_enum {
            NO_INTERRUPT_GENERATED = 0 { name = "No Interrupt Generated"; desc = "No interrupt is generated."; };
            INTERRUPT_GENERATED = 1 { name = "Interrupt Generated"; desc = "An interrupt is generated."; };
        };

        field {
            name = "lane2_sync_err_stat";
            desc = "EOL or EOF signal detection failure interrupt status for lane 2 on link 0 in LVDS mode.";
            sw = r;
            hw = w;
            encode = INT_STAT_LINK0_lane2_sync_err_stat_enum;
            reset = 0x0;
        } lane2_sync_err_stat[18:18];

        enum INT_STAT_LINK0_lane1_sync_err_stat_enum {
            NO_INTERRUPT_GENERATED = 0 { name = "No Interrupt Generated"; desc = "No interrupt is generated."; };
            INTERRUPT_GENERATED = 1 { name = "Interrupt Generated"; desc = "An interrupt is generated."; };
        };

        field {
            name = "lane1_sync_err_stat";
            desc = "EOL or EOF signal detection failure interrupt status for lane 1 on link 0 in LVDS mode.";
            sw = r;
            hw = w;
            encode = INT_STAT_LINK0_lane1_sync_err_stat_enum;
            reset = 0x0;
        } lane1_sync_err_stat[17:17];

        enum INT_STAT_LINK0_lane0_sync_err_stat_enum {
            NO_INTERRUPT_GENERATED = 0 { name = "No Interrupt Generated"; desc = "No interrupt is generated."; };
            INTERRUPT_GENERATED = 1 { name = "Interrupt Generated"; desc = "An interrupt is generated."; };
        };

        field {
            name = "lane0_sync_err_stat";
            desc = "EOL or EOF signal detection failure interrupt status for lane 0 on link 0 in LVDS mode.";
            sw = r;
            hw = w;
            encode = INT_STAT_LINK0_lane0_sync_err_stat_enum;
            reset = 0x0;
        } lane0_sync_err_stat[16:16];

        enum INT_STAT_LINK0_timeout_d3_stat_enum {
            NO_INTERRUPT_GENERATED = 0 { name = "No Interrupt Generated"; desc = "No interrupt is generated."; };
            INTERRUPT_GENERATED = 1 { name = "Interrupt Generated"; desc = "An interrupt is generated."; };
        };

        field {
            name = "timeout_d3_stat";
            desc = "FSM timeout interrupt status for data lane 3 on link 0 in MIPI mode.";
            sw = r;
            hw = w;
            encode = INT_STAT_LINK0_timeout_d3_stat_enum;
            reset = 0x0;
        } timeout_d3_stat[12:12];

        enum INT_STAT_LINK0_timeout_d2_stat_enum {
            NO_INTERRUPT_GENERATED = 0 { name = "No Interrupt Generated"; desc = "No interrupt is generated."; };
            INTERRUPT_GENERATED = 1 { name = "Interrupt Generated"; desc = "An interrupt is generated."; };
        };

        field {
            name = "timeout_d2_stat";
            desc = "FSM timeout interrupt status for data lane 2 on link 0 in MIPI mode.";
            sw = r;
            hw = w;
            encode = INT_STAT_LINK0_timeout_d2_stat_enum;
            reset = 0x0;
        } timeout_d2_stat[11:11];

        enum INT_STAT_LINK0_timeout_d1_stat_enum {
            NO_INTERRUPT_GENERATED = 0 { name = "No Interrupt Generated"; desc = "No interrupt is generated."; };
            INTERRUPT_GENERATED = 1 { name = "Interrupt Generated"; desc = "An interrupt is generated."; };
        };

        field {
            name = "timeout_d1_stat";
            desc = "FSM timeout interrupt status for data lane 1 on link 0 in MIPI mode.";
            sw = r;
            hw = w;
            encode = INT_STAT_LINK0_timeout_d1_stat_enum;
            reset = 0x0;
        } timeout_d1_stat[10:10];

        enum INT_STAT_LINK0_timeout_d0_stat_enum {
            NO_INTERRUPT_GENERATED = 0 { name = "No Interrupt Generated"; desc = "No interrupt is generated."; };
            INTERRUPT_GENERATED = 1 { name = "Interrupt Generated"; desc = "An interrupt is generated."; };
        };

        field {
            name = "timeout_d0_stat";
            desc = "FSM timeout interrupt status for data lane 0 on link 0 in MIPI mode.";
            sw = r;
            hw = w;
            encode = INT_STAT_LINK0_timeout_d0_stat_enum;
            reset = 0x0;
        } timeout_d0_stat[9:9];

        enum INT_STAT_LINK0_timeout_ck_stat_enum {
            NO_INTERRUPT_GENERATED = 0 { name = "No Interrupt Generated"; desc = "No interrupt is generated."; };
            INTERRUPT_GENERATED = 1 { name = "Interrupt Generated"; desc = "An interrupt is generated."; };
        };

        field {
            name = "timeout_ck_stat";
            desc = "FSM timeout interrupt status for the clock lane on link 0 in MIPI mode.";
            sw = r;
            hw = w;
            encode = INT_STAT_LINK0_timeout_ck_stat_enum;
            reset = 0x0;
        } timeout_ck_stat[8:8];

        enum INT_STAT_LINK0_escape_d3_stat_enum {
            NO_INTERRUPT_GENERATED = 0 { name = "No Interrupt Generated"; desc = "No interrupt is generated."; };
            INTERRUPT_GENERATED = 1 { name = "Interrupt Generated"; desc = "An interrupt is generated."; };
        };

        field {
            name = "escape_d3_stat";
            desc = "Escape sequence interrupt status for data lane 3 on link 0 in MIPI mode.";
            sw = r;
            hw = w;
            encode = INT_STAT_LINK0_escape_d3_stat_enum;
            reset = 0x0;
        } escape_d3_stat[4:4];

        enum INT_STAT_LINK0_escape_d2_stat_enum {
            NO_INTERRUPT_GENERATED = 0 { name = "No Interrupt Generated"; desc = "No interrupt is generated."; };
            INTERRUPT_GENERATED = 1 { name = "Interrupt Generated"; desc = "An interrupt is generated."; };
        };

        field {
            name = "escape_d2_stat";
            desc = "Escape sequence interrupt status for data lane 2 on link 0 in MIPI mode.";
            sw = r;
            hw = w;
            encode = INT_STAT_LINK0_escape_d2_stat_enum;
            reset = 0x0;
        } escape_d2_stat[3:3];

        enum INT_STAT_LINK0_escape_d1_stat_enum {
            NO_INTERRUPT_GENERATED = 0 { name = "No Interrupt Generated"; desc = "No interrupt is generated."; };
            INTERRUPT_GENERATED = 1 { name = "Interrupt Generated"; desc = "An interrupt is generated."; };
        };

        field {
            name = "escape_d1_stat";
            desc = "Escape sequence interrupt status for data lane 1 on link 0 in MIPI mode.";
            sw = r;
            hw = w;
            encode = INT_STAT_LINK0_escape_d1_stat_enum;
            reset = 0x0;
        } escape_d1_stat[2:2];

        enum INT_STAT_LINK0_escape_d0_stat_enum {
            NO_INTERRUPT_GENERATED = 0 { name = "No Interrupt Generated"; desc = "No interrupt is generated."; };
            INTERRUPT_GENERATED = 1 { name = "Interrupt Generated"; desc = "An interrupt is generated."; };
        };

        field {
            name = "escape_d0_stat";
            desc = "Escape sequence interrupt status for data lane 0 on link 0 in MIPI mode.";
            sw = r;
            hw = w;
            encode = INT_STAT_LINK0_escape_d0_stat_enum;
            reset = 0x0;
        } escape_d0_stat[1:1];

        enum INT_STAT_LINK0_escape_ck_stat_enum {
            NO_INTERRUPT_GENERATED = 0 { name = "No Interrupt Generated"; desc = "No interrupt is generated."; };
            INTERRUPT_GENERATED = 1 { name = "Interrupt Generated"; desc = "An interrupt is generated."; };
        };

        field {
            name = "escape_ck_stat";
            desc = "Escape sequence interrupt status for the clock lane on link 0 in MIPI mode.";
            sw = r;
            hw = w;
            encode = INT_STAT_LINK0_escape_ck_stat_enum;
            reset = 0x0;
        } escape_ck_stat[0:0];
    } INT_STAT_LINK0 @ 0x1000;

    reg {
        name = "Link 0 interrupt mask register";
        desc = "INT_MASK_LINK0 is a link 0 interrupt mask register.

Data sheet 10.3.6 INT_MASK_LINK0 (offset 0x1004, printed page 10-287, `hi3516av100--Hi3516A-Hi3516D-Datasheet.txt` line 74913).";

        enum INT_MASK_LINK0_vsync_err_mask_enum {
            NOT_MASKED = 0 { name = "Not Masked"; desc = "not masked"; };
            MASKED = 1 { name = "Masked"; desc = "masked"; };
        };

        field {
            name = "vsync_err_mask";
            desc = "SOF or EOF signal async interrupt mask for each lane on link 0.";
            sw = rw;
            hw = r;
            encode = INT_MASK_LINK0_vsync_err_mask_enum;
            reset = 0x0;
        } vsync_err_mask[21:21];

        enum INT_MASK_LINK0_hsync_err_mask_enum {
            NOT_MASKED = 0 { name = "Not Masked"; desc = "not masked"; };
            MASKED = 1 { name = "Masked"; desc = "masked"; };
        };

        field {
            name = "hsync_err_mask";
            desc = "SOL or EOL signal async interrupt mask for each lane on link 0.";
            sw = rw;
            hw = r;
            encode = INT_MASK_LINK0_hsync_err_mask_enum;
            reset = 0x0;
        } hsync_err_mask[20:20];

        enum INT_MASK_LINK0_lane3_sync_err_mask_enum {
            NOT_MASKED = 0 { name = "Not Masked"; desc = "not masked"; };
            MASKED = 1 { name = "Masked"; desc = "masked"; };
        };

        field {
            name = "lane3_sync_err_mask";
            desc = "EOL or EOF signal detection failure interrupt mask for lane 3 on link 0.";
            sw = rw;
            hw = r;
            encode = INT_MASK_LINK0_lane3_sync_err_mask_enum;
            reset = 0x0;
        } lane3_sync_err_mask[19:19];

        enum INT_MASK_LINK0_lane2_sync_err_mask_enum {
            NOT_MASKED = 0 { name = "Not Masked"; desc = "not masked"; };
            MASKED = 1 { name = "Masked"; desc = "masked"; };
        };

        field {
            name = "lane2_sync_err_mask";
            desc = "EOL or EOF signal detection failure interrupt mask for lane 2 on link 0.";
            sw = rw;
            hw = r;
            encode = INT_MASK_LINK0_lane2_sync_err_mask_enum;
            reset = 0x0;
        } lane2_sync_err_mask[18:18];

        enum INT_MASK_LINK0_lane1_sync_err_mask_enum {
            NOT_MASKED = 0 { name = "Not Masked"; desc = "not masked"; };
            MASKED = 1 { name = "Masked"; desc = "masked"; };
        };

        field {
            name = "lane1_sync_err_mask";
            desc = "EOL or EOF signal detection failure interrupt mask for lane 1 on link 0.";
            sw = rw;
            hw = r;
            encode = INT_MASK_LINK0_lane1_sync_err_mask_enum;
            reset = 0x0;
        } lane1_sync_err_mask[17:17];

        enum INT_MASK_LINK0_lane0_sync_err_mask_enum {
            NOT_MASKED = 0 { name = "Not Masked"; desc = "not masked"; };
            MASKED = 1 { name = "Masked"; desc = "masked"; };
        };

        field {
            name = "lane0_sync_err_mask";
            desc = "EOL or EOF signal detection failure interrupt mask for lane 0 on link 0.";
            sw = rw;
            hw = r;
            encode = INT_MASK_LINK0_lane0_sync_err_mask_enum;
            reset = 0x0;
        } lane0_sync_err_mask[16:16];

        enum INT_MASK_LINK0_timeout_d3_mask_enum {
            NOT_MASKED = 0 { name = "Not Masked"; desc = "not masked"; };
            MASKED = 1 { name = "Masked"; desc = "masked"; };
        };

        field {
            name = "timeout_d3_mask";
            desc = "FSM timeout interrupt mask for data lane 3 on link 0.";
            sw = rw;
            hw = r;
            encode = INT_MASK_LINK0_timeout_d3_mask_enum;
            reset = 0x0;
        } timeout_d3_mask[12:12];

        enum INT_MASK_LINK0_timeout_d2_mask_enum {
            NOT_MASKED = 0 { name = "Not Masked"; desc = "not masked"; };
            MASKED = 1 { name = "Masked"; desc = "masked"; };
        };

        field {
            name = "timeout_d2_mask";
            desc = "FSM timeout interrupt mask for data lane 2 on link 0.";
            sw = rw;
            hw = r;
            encode = INT_MASK_LINK0_timeout_d2_mask_enum;
            reset = 0x0;
        } timeout_d2_mask[11:11];

        enum INT_MASK_LINK0_timeout_d1_mask_enum {
            NOT_MASKED = 0 { name = "Not Masked"; desc = "not masked"; };
            MASKED = 1 { name = "Masked"; desc = "masked"; };
        };

        field {
            name = "timeout_d1_mask";
            desc = "FSM timeout interrupt mash for data lane 1 on link 0.";
            sw = rw;
            hw = r;
            encode = INT_MASK_LINK0_timeout_d1_mask_enum;
            reset = 0x0;
        } timeout_d1_mask[10:10];

        enum INT_MASK_LINK0_timeout_d0_mask_enum {
            NOT_MASKED = 0 { name = "Not Masked"; desc = "not masked"; };
            MASKED = 1 { name = "Masked"; desc = "masked"; };
        };

        field {
            name = "timeout_d0_mask";
            desc = "FSM timeout interrupt mask for data lane 0 on link 0.";
            sw = rw;
            hw = r;
            encode = INT_MASK_LINK0_timeout_d0_mask_enum;
            reset = 0x0;
        } timeout_d0_mask[9:9];

        enum INT_MASK_LINK0_timeout_ck_mask_enum {
            NOT_MASKED = 0 { name = "Not Masked"; desc = "not masked"; };
            MASKED = 1 { name = "Masked"; desc = "masked"; };
        };

        field {
            name = "timeout_ck_mask";
            desc = "FSM timeout interrupt mask for the clock lane on link 0.";
            sw = rw;
            hw = r;
            encode = INT_MASK_LINK0_timeout_ck_mask_enum;
            reset = 0x0;
        } timeout_ck_mask[8:8];

        enum INT_MASK_LINK0_escape_d3_mask_enum {
            NOT_MASKED = 0 { name = "Not Masked"; desc = "not masked"; };
            MASKED = 1 { name = "Masked"; desc = "masked"; };
        };

        field {
            name = "escape_d3_mask";
            desc = "Escape interrupt mask for data lane 3 on link 0.";
            sw = rw;
            hw = r;
            encode = INT_MASK_LINK0_escape_d3_mask_enum;
            reset = 0x0;
        } escape_d3_mask[4:4];

        enum INT_MASK_LINK0_escape_d2_mask_enum {
            NOT_MASKED = 0 { name = "Not Masked"; desc = "not masked"; };
            MASKED = 1 { name = "Masked"; desc = "masked"; };
        };

        field {
            name = "escape_d2_mask";
            desc = "Escape interrupt mask for data lane 2 on link 0.";
            sw = rw;
            hw = r;
            encode = INT_MASK_LINK0_escape_d2_mask_enum;
            reset = 0x0;
        } escape_d2_mask[3:3];

        enum INT_MASK_LINK0_escape_d1_mask_enum {
            NOT_MASKED = 0 { name = "Not Masked"; desc = "not masked"; };
            MASKED = 1 { name = "Masked"; desc = "masked"; };
        };

        field {
            name = "escape_d1_mask";
            desc = "Escape interrupt mask for data lane 1 on link 0.";
            sw = rw;
            hw = r;
            encode = INT_MASK_LINK0_escape_d1_mask_enum;
            reset = 0x0;
        } escape_d1_mask[2:2];

        enum INT_MASK_LINK0_escape_d0_mask_enum {
            NOT_MASKED = 0 { name = "Not Masked"; desc = "not masked"; };
            MASKED = 1 { name = "Masked"; desc = "masked"; };
        };

        field {
            name = "escape_d0_mask";
            desc = "Escape interrupt mask for data lane 0 on link 0.";
            sw = rw;
            hw = r;
            encode = INT_MASK_LINK0_escape_d0_mask_enum;
            reset = 0x0;
        } escape_d0_mask[1:1];

        enum INT_MASK_LINK0_escape_ck_mask_enum {
            NOT_MASKED = 0 { name = "Not Masked"; desc = "not masked"; };
            MASKED = 1 { name = "Masked"; desc = "masked"; };
        };

        field {
            name = "escape_ck_mask";
            desc = "Escape interrupt mask for the clock lane on link 0.";
            sw = rw;
            hw = r;
            encode = INT_MASK_LINK0_escape_ck_mask_enum;
            reset = 0x0;
        } escape_ck_mask[0:0];
    } INT_MASK_LINK0 @ 0x1004;

    reg {
        name = "Link 0 raw interrupt status register";
        desc = "INT_RAW_LINK0 is a link 0 raw interrupt status register. Huawei Proprietary and Confidential Hi3516A/Hi3516D Professional HD IP Camera SoC

Data sheet 10.3.6 INT_RAW_LINK0 (offset 0x1008, printed page 10-289, `hi3516av100--Hi3516A-Hi3516D-Datasheet.txt` line 75014).";

        enum INT_RAW_LINK0_vsync_err_raw_enum {
            NO_RAW_INTERRUPT = 0 { name = "No Raw Interrupt"; desc = "No raw interrupt is generated."; };
            RAW_INTERRUPT_GENERATED = 1 { name = "Raw Interrupt Generated"; desc = "A raw interrupt is generated."; };
        };

        field {
            name = "vsync_err_raw";
            desc = "Raw SOF or EOF signal async interrupt status for each lane on link 0.";
            sw = r;
            hw = w;
            encode = INT_RAW_LINK0_vsync_err_raw_enum;
            reset = 0x0;
        } vsync_err_raw[21:21];

        enum INT_RAW_LINK0_hsync_err_raw_enum {
            NO_RAW_INTERRUPT = 0 { name = "No Raw Interrupt"; desc = "No raw interrupt is generated."; };
            RAW_INTERRUPT_GENERATED = 1 { name = "Raw Interrupt Generated"; desc = "A raw interrupt is generated."; };
        };

        field {
            name = "hsync_err_raw";
            desc = "Raw SOL or EOL signal async interrupt status for each lane on link 0.";
            sw = r;
            hw = w;
            encode = INT_RAW_LINK0_hsync_err_raw_enum;
            reset = 0x0;
        } hsync_err_raw[20:20];

        enum INT_RAW_LINK0_lane3_sync_err_raw_enum {
            NO_RAW_INTERRUPT = 0 { name = "No Raw Interrupt"; desc = "No raw interrupt is generated."; };
            RAW_INTERRUPT_GENERATED = 1 { name = "Raw Interrupt Generated"; desc = "A raw interrupt is generated."; };
        };

        field {
            name = "lane3_sync_err_raw";
            desc = "Raw EOL or EOF signal detection failure interrupt status for lane 3 on link 0.";
            sw = r;
            hw = w;
            encode = INT_RAW_LINK0_lane3_sync_err_raw_enum;
            reset = 0x0;
        } lane3_sync_err_raw[19:19];

        enum INT_RAW_LINK0_lane2_sync_err_raw_enum {
            NO_RAW_INTERRUPT = 0 { name = "No Raw Interrupt"; desc = "No raw interrupt is generated."; };
            RAW_INTERRUPT_GENERATED = 1 { name = "Raw Interrupt Generated"; desc = "A raw interrupt is generated."; };
        };

        field {
            name = "lane2_sync_err_raw";
            desc = "Raw EOL or EOF signal detection failure interrupt status for lane 2 on link 0.";
            sw = r;
            hw = w;
            encode = INT_RAW_LINK0_lane2_sync_err_raw_enum;
            reset = 0x0;
        } lane2_sync_err_raw[18:18];

        enum INT_RAW_LINK0_lane1_sync_err_raw_enum {
            NO_RAW_INTERRUPT = 0 { name = "No Raw Interrupt"; desc = "No raw interrupt is generated."; };
            RAW_INTERRUPT_GENERATED = 1 { name = "Raw Interrupt Generated"; desc = "A raw interrupt is generated."; };
        };

        field {
            name = "lane1_sync_err_raw";
            desc = "Raw EOL or EOF signal detection failure interrupt status for lane 1 on link 0.";
            sw = r;
            hw = w;
            encode = INT_RAW_LINK0_lane1_sync_err_raw_enum;
            reset = 0x0;
        } lane1_sync_err_raw[17:17];

        enum INT_RAW_LINK0_lane0_sync_err_raw_enum {
            NO_RAW_INTERRUPT = 0 { name = "No Raw Interrupt"; desc = "No raw interrupt is generated."; };
            RAW_INTERRUPT_GENERATED = 1 { name = "Raw Interrupt Generated"; desc = "A raw interrupt is generated."; };
        };

        field {
            name = "lane0_sync_err_raw";
            desc = "Raw EOL or EOF signal detection failure interrupt status for lane 0 on link 0.";
            sw = r;
            hw = w;
            encode = INT_RAW_LINK0_lane0_sync_err_raw_enum;
            reset = 0x0;
        } lane0_sync_err_raw[16:16];

        enum INT_RAW_LINK0_timeout_d3_raw_enum {
            NO_RAW_INTERRUPT = 0 { name = "No Raw Interrupt"; desc = "No raw interrupt is generated."; };
            RAW_INTERRUPT_GENERATED = 1 { name = "Raw Interrupt Generated"; desc = "A raw interrupt is generated."; };
        };

        field {
            name = "timeout_d3_raw";
            desc = "Raw FSM timeout interrupt status for data lane 3 on link 0.";
            sw = r;
            hw = w;
            encode = INT_RAW_LINK0_timeout_d3_raw_enum;
            reset = 0x0;
        } timeout_d3_raw[12:12];

        enum INT_RAW_LINK0_timeout_d2_raw_enum {
            NO_RAW_INTERRUPT = 0 { name = "No Raw Interrupt"; desc = "No raw interrupt is generated."; };
            RAW_INTERRUPT_GENERATED = 1 { name = "Raw Interrupt Generated"; desc = "A raw interrupt is generated."; };
        };

        field {
            name = "timeout_d2_raw";
            desc = "Raw FSM timeout interrupt status for data lane 2 on link 0.";
            sw = r;
            hw = w;
            encode = INT_RAW_LINK0_timeout_d2_raw_enum;
            reset = 0x0;
        } timeout_d2_raw[11:11];

        enum INT_RAW_LINK0_timeout_d1_raw_enum {
            NO_RAW_INTERRUPT = 0 { name = "No Raw Interrupt"; desc = "No raw interrupt is generated."; };
            RAW_INTERRUPT_GENERATED = 1 { name = "Raw Interrupt Generated"; desc = "A raw interrupt is generated."; };
        };

        field {
            name = "timeout_d1_raw";
            desc = "Raw FSM timeout interrupt status for data lane 1 on link 0.";
            sw = r;
            hw = w;
            encode = INT_RAW_LINK0_timeout_d1_raw_enum;
            reset = 0x0;
        } timeout_d1_raw[10:10];

        enum INT_RAW_LINK0_timeout_d0_raw_enum {
            NO_RAW_INTERRUPT = 0 { name = "No Raw Interrupt"; desc = "No raw interrupt is generated."; };
            RAW_INTERRUPT_GENERATED = 1 { name = "Raw Interrupt Generated"; desc = "A raw interrupt is generated."; };
        };

        field {
            name = "timeout_d0_raw";
            desc = "Raw FSM timeout interrupt status for data lane 0 on link 0.";
            sw = r;
            hw = w;
            encode = INT_RAW_LINK0_timeout_d0_raw_enum;
            reset = 0x0;
        } timeout_d0_raw[9:9];

        enum INT_RAW_LINK0_timeout_ck_raw_enum {
            NO_RAW_INTERRUPT = 0 { name = "No Raw Interrupt"; desc = "No raw interrupt is generated."; };
            RAW_INTERRUPT_GENERATED = 1 { name = "Raw Interrupt Generated"; desc = "A raw interrupt is generated."; };
        };

        field {
            name = "timeout_ck_raw";
            desc = "Raw FSM timeout interrupt status for the clock lane on link 0.";
            sw = r;
            hw = w;
            encode = INT_RAW_LINK0_timeout_ck_raw_enum;
            reset = 0x0;
        } timeout_ck_raw[8:8];

        enum INT_RAW_LINK0_escape_d3_raw_enum {
            NO_RAW_INTERRUPT = 0 { name = "No Raw Interrupt"; desc = "No raw interrupt is generated."; };
            RAW_INTERRUPT_GENERATED = 1 { name = "Raw Interrupt Generated"; desc = "A raw interrupt is generated."; };
        };

        field {
            name = "escape_d3_raw";
            desc = "Raw escape sequence interrupt status for data lane 3 on link 0.";
            sw = r;
            hw = w;
            encode = INT_RAW_LINK0_escape_d3_raw_enum;
            reset = 0x0;
        } escape_d3_raw[4:4];

        enum INT_RAW_LINK0_escape_d2_raw_enum {
            NO_RAW_INTERRUPT = 0 { name = "No Raw Interrupt"; desc = "No raw interrupt is generated."; };
            RAW_INTERRUPT_GENERATED = 1 { name = "Raw Interrupt Generated"; desc = "A raw interrupt is generated."; };
        };

        field {
            name = "escape_d2_raw";
            desc = "Raw escape sequence interrupt status for data lane 2 on link 0.";
            sw = r;
            hw = w;
            encode = INT_RAW_LINK0_escape_d2_raw_enum;
            reset = 0x0;
        } escape_d2_raw[3:3];

        enum INT_RAW_LINK0_escape_d1_raw_enum {
            NO_RAW_INTERRUPT = 0 { name = "No Raw Interrupt"; desc = "No raw interrupt is generated."; };
            RAW_INTERRUPT_GENERATED = 1 { name = "Raw Interrupt Generated"; desc = "A raw interrupt is generated."; };
        };

        field {
            name = "escape_d1_raw";
            desc = "Raw escape sequence interrupt status for data lane 1 on link 0.";
            sw = r;
            hw = w;
            encode = INT_RAW_LINK0_escape_d1_raw_enum;
            reset = 0x0;
        } escape_d1_raw[2:2];

        enum INT_RAW_LINK0_escape_d0_raw_enum {
            NO_RAW_INTERRUPT = 0 { name = "No Raw Interrupt"; desc = "No raw interrupt is generated."; };
            RAW_INTERRUPT_GENERATED = 1 { name = "Raw Interrupt Generated"; desc = "A raw interrupt is generated."; };
        };

        field {
            name = "escape_d0_raw";
            desc = "Raw escape sequence interrupt status for data lane 0 on link 0.";
            sw = r;
            hw = w;
            encode = INT_RAW_LINK0_escape_d0_raw_enum;
            reset = 0x0;
        } escape_d0_raw[1:1];

        enum INT_RAW_LINK0_escape_ck_raw_enum {
            NO_RAW_INTERRUPT = 0 { name = "No Raw Interrupt"; desc = "No raw interrupt is generated."; };
            RAW_INTERRUPT_GENERATED = 1 { name = "Raw Interrupt Generated"; desc = "A raw interrupt is generated."; };
        };

        field {
            name = "escape_ck_raw";
            desc = "Raw escape sequence interrupt status for the clock lane on link 0.";
            sw = r;
            hw = w;
            encode = INT_RAW_LINK0_escape_ck_raw_enum;
            reset = 0x0;
        } escape_ck_raw[0:0];
    } INT_RAW_LINK0 @ 0x1008;

    reg {
        name = "Link 0 interrupt clear register";
        desc = "INT_CLR_LINK0 is a link 0 interrupt clear register. Huawei Proprietary and Confidential Hi3516A/Hi3516D Professional HD IP Camera SoC

Data sheet 10.3.6 INT_CLR_LINK0 (offset 0x100C, printed page 10-291, `hi3516av100--Hi3516A-Hi3516D-Datasheet.txt` line 75121).";

        field {
            name = "vsync_err_clr";
            desc = "SOF or EOF signal async interrupt clear for each lane on link 0. Writing 1 clears this interrupt.";
            sw = rw;
            hw = r;
            reset = 0x0;
        } vsync_err_clr[21:21];

        field {
            name = "hsync_err_clr";
            desc = "SOL or EOL signal async interrupt clear for each lane on link 0. Writing 1 clears this interrupt.";
            sw = rw;
            hw = r;
            reset = 0x0;
        } hsync_err_clr[20:20];

        field {
            name = "lane3_sync_err_clr";
            desc = "EOL or EOF signal detection failure interrupt clear for lane 3 on link 0. Writing 1 clears this interrupt.";
            sw = rw;
            hw = r;
            reset = 0x0;
        } lane3_sync_err_clr[19:19];

        field {
            name = "lane2_sync_err_clr";
            desc = "EOL or EOF signal detection failure interrupt clear for lane 2 on link 0. Writing 1 clears this interrupt.";
            sw = rw;
            hw = r;
            reset = 0x0;
        } lane2_sync_err_clr[18:18];

        field {
            name = "lane1_sync_err_clr";
            desc = "EOL or EOF signal detection failure interrupt clear for lane 1 on link 0. Writing 1 clears this interrupt.";
            sw = rw;
            hw = r;
            reset = 0x0;
        } lane1_sync_err_clr[17:17];

        field {
            name = "lane0_sync_err_clr";
            desc = "EOL or EOF signal detection failure interrupt clear for lane 0 on link 0. Writing 1 clears this interrupt.";
            sw = rw;
            hw = r;
            reset = 0x0;
        } lane0_sync_err_clr[16:16];

        field {
            name = "timeout_d3_clr";
            desc = "FSM timeout interrupt clear for data lane 3 on link 0. Writing 1 clears this interrupt.";
            sw = rw;
            hw = r;
            reset = 0x0;
        } timeout_d3_clr[12:12];

        field {
            name = "timeout_d2_clr";
            desc = "FSM timeout interrupt clear for data lane 2 on link 0. Writing 1 clears this interrupt.";
            sw = rw;
            hw = r;
            reset = 0x0;
        } timeout_d2_clr[11:11];

        field {
            name = "timeout_d1_clr";
            desc = "FSM timeout interrupt clear for data lane 1 on link 0. Writing 1 clears this interrupt.";
            sw = rw;
            hw = r;
            reset = 0x0;
        } timeout_d1_clr[10:10];

        field {
            name = "timeout_d0_clr";
            desc = "FSM timeout interrupt clear for data lane 0 on link 0. Writing 1 clears this interrupt.";
            sw = rw;
            hw = r;
            reset = 0x0;
        } timeout_d0_clr[9:9];

        field {
            name = "timeout_ck_clr";
            desc = "FSM timeout interrupt clear for the clock lane on link 0. Writing 1 clears this interrupt.";
            sw = rw;
            hw = r;
            reset = 0x0;
        } timeout_ck_clr[8:8];

        field {
            name = "escape_d3_clr";
            desc = "Escape interrupt clear for data lane 3 on link 0. Writing 1 clears this interrupt.";
            sw = rw;
            hw = r;
            reset = 0x0;
        } escape_d3_clr[4:4];

        field {
            name = "escape_d2_clr";
            desc = "Escape interrupt clear for data lane 2 on link 0. Writing 1 clears this interrupt.";
            sw = rw;
            hw = r;
            reset = 0x0;
        } escape_d2_clr[3:3];

        field {
            name = "escape_d1_clr";
            desc = "Escape interrupt clear for data lane 1 on link 0. Writing 1 clears this interrupt.";
            sw = rw;
            hw = r;
            reset = 0x0;
        } escape_d1_clr[2:2];

        field {
            name = "escape_d0_clr";
            desc = "Escape interrupt clear for data lane 0 on link 0. Writing 1 clears this interrupt.";
            sw = rw;
            hw = r;
            reset = 0x0;
        } escape_d0_clr[1:1];

        field {
            name = "escape_ck_clr";
            desc = "Escape interrupt clear for the clock lane on link 0. Writing 1 clears this interrupt.";
            sw = rw;
            hw = r;
            reset = 0x0;
        } escape_ck_clr[0:0];
    } INT_CLR_LINK0 @ 0x100C;

    reg {
        name = "Link 0 lane enable configuration register";
        desc = "LANE_EN_LINK0 is a link 0 lane enable configuration register.

Data sheet 10.3.6 LANE_EN_LINK0 (offset 0x1010, printed page 10-292, `hi3516av100--Hi3516A-Hi3516D-Datasheet.txt` line 75207).";

        enum LANE_EN_LINK0_lane3_en_enum {
            DISABLED = 0 { name = "Disabled"; desc = "disabled"; };
            ENABLED = 1 { name = "Enabled"; desc = "enabled"; };
        };

        field {
            name = "lane3_en";
            desc = "Lane 3 enable for link 0.";
            sw = rw;
            hw = r;
            encode = LANE_EN_LINK0_lane3_en_enum;
            reset = 0x0;
        } lane3_en[12:12];

        enum LANE_EN_LINK0_lane2_en_enum {
            DISABLED = 0 { name = "Disabled"; desc = "disabled"; };
            ENABLED = 1 { name = "Enabled"; desc = "enabled"; };
        };

        field {
            name = "lane2_en";
            desc = "Lane 2 enable for link 0.";
            sw = rw;
            hw = r;
            encode = LANE_EN_LINK0_lane2_en_enum;
            reset = 0x0;
        } lane2_en[8:8];

        enum LANE_EN_LINK0_lane1_en_enum {
            DISABLED = 0 { name = "Disabled"; desc = "disabled"; };
            ENABLED = 1 { name = "Enabled"; desc = "enabled"; };
        };

        field {
            name = "lane1_en";
            desc = "Lane 1 enable for link 0.";
            sw = rw;
            hw = r;
            encode = LANE_EN_LINK0_lane1_en_enum;
            reset = 0x0;
        } lane1_en[4:4];

        enum LANE_EN_LINK0_lane0_en_enum {
            DISABLED = 0 { name = "Disabled"; desc = "disabled"; };
            ENABLED = 1 { name = "Enabled"; desc = "enabled"; };
        };

        field {
            name = "lane0_en";
            desc = "Lane 0 enable for link 0.";
            sw = rw;
            hw = r;
            encode = LANE_EN_LINK0_lane0_en_enum;
            reset = 0x0;
        } lane0_en[0:0];
    } LANE_EN_LINK0 @ 0x1010;

    reg {
        name = "Link 0 lane priority configuration register";
        desc = "LANE_ID_LINK0 is a link 0 lane priority configuration register.

Data sheet 10.3.6 LANE_ID_LINK0 (offset 0x1014, printed page 10-293, `hi3516av100--Hi3516A-Hi3516D-Datasheet.txt` line 75254).";

        field {
            name = "lane3_id";
            desc = "Lane 3 priority for link 0. The value ranges from 0 to 3.";
            sw = rw;
            hw = r;
            reset = 0x3;
        } lane3_id[13:12];

        field {
            name = "lane2_id";
            desc = "Lane 2 priority for link 0. The value ranges from 0 to 3.";
            sw = rw;
            hw = r;
            reset = 0x2;
        } lane2_id[9:8];

        field {
            name = "lane1_id";
            desc = "Lane 1 priority for link 0. The value ranges from 0 to 3.";
            sw = rw;
            hw = r;
            reset = 0x1;
        } lane1_id[5:4];

        field {
            name = "lane0_id";
            desc = "Lane 0 priority for link 0. The value ranges from 0 to 3.";
            sw = rw;
            hw = r;
            reset = 0x0;
        } lane0_id[1:0];
    } LANE_ID_LINK0 @ 0x1014;

    reg {
        name = "PHY mode LINK0";
        desc = "[inferred] PHY mode LINK0. Not in the data sheet. Source: OpenIPC openhisilicon `kernel/mipi_rx/hi3516av100/mipi_reg.h` (GPL-3.0 repository, HiSilicon copyright; local copy sources/openhisilicon), union `U_PHY_MODE_LINK`, struct offset 0x1018 (GPL-3.0 repository, HiSilicon copyright; byte-identical to the hi3516cv200 file). Reset value and access type unknown (modelled RW, no reset). Confidence: medium (vendor header for this chip family, not hardware verified).";

        field {
            name = "phy_offset";
            desc = "[inferred] PHY offset. (vendor header `hi3516av100/mipi_reg.h` field `phy_offset`; access and reset unknown, modelled RW)";
            sw = rw;
            hw = r;
        } phy_offset[21:20];

        field {
            name = "phy_frsck";
            desc = "[inferred] PHY frsck. (vendor header `hi3516av100/mipi_reg.h` field `phy_frsck`; access and reset unknown, modelled RW)";
            sw = rw;
            hw = r;
        } phy_frsck[9:9];

        field {
            name = "phy_frpck";
            desc = "[inferred] PHY frpck. (vendor header `hi3516av100/mipi_reg.h` field `phy_frpck`; access and reset unknown, modelled RW)";
            sw = rw;
            hw = r;
        } phy_frpck[8:8];

        field {
            name = "phy_btsel";
            desc = "[inferred] PHY btsel. (vendor header `hi3516av100/mipi_reg.h` field `phy_btsel`; access and reset unknown, modelled RW)";
            sw = rw;
            hw = r;
        } phy_btsel[6:5];

        field {
            name = "phy_sbsel";
            desc = "[inferred] PHY sbsel. (vendor header `hi3516av100/mipi_reg.h` field `phy_sbsel`; access and reset unknown, modelled RW)";
            sw = rw;
            hw = r;
        } phy_sbsel[4:4];

        field {
            name = "phy_ifimode";
            desc = "[inferred] PHY ifimode. (vendor header `hi3516av100/mipi_reg.h` field `phy_ifimode`; access and reset unknown, modelled RW)";
            sw = rw;
            hw = r;
        } phy_ifimode[2:0];
    } PHY_MODE_LINK0 @ 0x1018;

    reg {
        name = "PHY POWER LINK0";
        desc = "[inferred] PHY POWER LINK0. Not in the data sheet. Source: OpenIPC openhisilicon `kernel/mipi_rx/hi3516av100/mipi_reg.h` (GPL-3.0 repository, HiSilicon copyright; local copy sources/openhisilicon), union `U_PHY_POWER_LINK`, struct offset 0x101C (GPL-3.0 repository, HiSilicon copyright; byte-identical to the hi3516cv200 file). Reset value and access type unknown (modelled RW, no reset). Confidence: medium (vendor header for this chip family, not hardware verified).";

        field {
            name = "phy_rstn";
            desc = "[inferred] PHY rstn. (vendor header `hi3516av100/mipi_reg.h` field `phy_rstn`; access and reset unknown, modelled RW)";
            sw = rw;
            hw = r;
        } phy_rstn[4:4];

        field {
            name = "phy_pwdn";
            desc = "[inferred] PHY pwdn. (vendor header `hi3516av100/mipi_reg.h` field `phy_pwdn`; access and reset unknown, modelled RW)";
            sw = rw;
            hw = r;
        } phy_pwdn[0:0];
    } PHY_POWER_LINK0 @ 0x101C;

    reg {
        name = "PHY delay LINK0";
        desc = "[inferred] PHY delay LINK0. Not in the data sheet. Source: OpenIPC openhisilicon `kernel/mipi_rx/hi3516av100/mipi_reg.h` (GPL-3.0 repository, HiSilicon copyright; local copy sources/openhisilicon), union `U_PHY_DLY_LINK`, struct offset 0x1020 (GPL-3.0 repository, HiSilicon copyright; byte-identical to the hi3516cv200 file). Reset value and access type unknown (modelled RW, no reset). Confidence: medium (vendor header for this chip family, not hardware verified).";

        field {
            name = "phy_dlyd3";
            desc = "[inferred] PHY dlyd3. (vendor header `hi3516av100/mipi_reg.h` field `phy_dlyd3`; access and reset unknown, modelled RW)";
            sw = rw;
            hw = r;
        } phy_dlyd3[18:16];

        field {
            name = "phy_dlyd2";
            desc = "[inferred] PHY dlyd2. (vendor header `hi3516av100/mipi_reg.h` field `phy_dlyd2`; access and reset unknown, modelled RW)";
            sw = rw;
            hw = r;
        } phy_dlyd2[14:12];

        field {
            name = "phy_dlyd1";
            desc = "[inferred] PHY dlyd1. (vendor header `hi3516av100/mipi_reg.h` field `phy_dlyd1`; access and reset unknown, modelled RW)";
            sw = rw;
            hw = r;
        } phy_dlyd1[10:8];

        field {
            name = "phy_dlyd0";
            desc = "[inferred] PHY dlyd0. (vendor header `hi3516av100/mipi_reg.h` field `phy_dlyd0`; access and reset unknown, modelled RW)";
            sw = rw;
            hw = r;
        } phy_dlyd0[6:4];

        field {
            name = "phy_dlyck";
            desc = "[inferred] PHY dlyck. (vendor header `hi3516av100/mipi_reg.h` field `phy_dlyck`; access and reset unknown, modelled RW)";
            sw = rw;
            hw = r;
        } phy_dlyck[2:0];
    } PHY_DLY_LINK0 @ 0x1020;

    reg {
        name = "Link 0 PHY channel enable register";
        desc = "PHY_EN_LINK0 is a link 0 PHY channel enable register. Huawei Proprietary and Confidential Hi3516A/Hi3516D Professional HD IP Camera SoC

Data sheet 10.3.6 PHY_EN_LINK0 (offset 0x1024, printed page 10-294, `hi3516av100--Hi3516A-Hi3516D-Datasheet.txt` line 75291).";

        enum PHY_EN_LINK0_phy_te_d3en_enum {
            DISABLED = 0 { name = "Disabled"; desc = "disabled"; };
            ENABLED = 1 { name = "Enabled"; desc = "enabled"; };
        };

        field {
            name = "phy_te_d3en";
            desc = "Termination enable for data lane 3 on link 0.";
            sw = rw;
            hw = r;
            encode = PHY_EN_LINK0_phy_te_d3en_enum;
            reset = 0x0;
        } phy_te_d3en[23:23];

        enum PHY_EN_LINK0_phy_te_d2en_enum {
            DISABLED = 0 { name = "Disabled"; desc = "disabled"; };
            ENABLED = 1 { name = "Enabled"; desc = "enabled"; };
        };

        field {
            name = "phy_te_d2en";
            desc = "Termination enable for data lane 2 on link 0.";
            sw = rw;
            hw = r;
            encode = PHY_EN_LINK0_phy_te_d2en_enum;
            reset = 0x0;
        } phy_te_d2en[22:22];

        enum PHY_EN_LINK0_phy_te_d1en_enum {
            DISABLED = 0 { name = "Disabled"; desc = "disabled"; };
            ENABLED = 1 { name = "Enabled"; desc = "enabled"; };
        };

        field {
            name = "phy_te_d1en";
            desc = "Termination enable for data lane 1 on link 0.";
            sw = rw;
            hw = r;
            encode = PHY_EN_LINK0_phy_te_d1en_enum;
            reset = 0x0;
        } phy_te_d1en[21:21];

        enum PHY_EN_LINK0_phy_te_d0en_enum {
            DISABLED = 0 { name = "Disabled"; desc = "disabled"; };
            ENABLED = 1 { name = "Enabled"; desc = "enabled"; };
        };

        field {
            name = "phy_te_d0en";
            desc = "Termination enable for data lane 0 on link 0.";
            sw = rw;
            hw = r;
            encode = PHY_EN_LINK0_phy_te_d0en_enum;
            reset = 0x0;
        } phy_te_d0en[20:20];

        enum PHY_EN_LINK0_phy_te_cken_enum {
            DISABLED = 0 { name = "Disabled"; desc = "disabled"; };
            ENABLED = 1 { name = "Enabled"; desc = "enabled"; };
        };

        field {
            name = "phy_te_cken";
            desc = "Termination enable for the clock lane on link 0.";
            sw = rw;
            hw = r;
            encode = PHY_EN_LINK0_phy_te_cken_enum;
            reset = 0x0;
        } phy_te_cken[16:16];

        enum PHY_EN_LINK0_phy_hs_d3en_enum {
            DISABLED = 0 { name = "Disabled"; desc = "disabled"; };
            ENABLED = 1 { name = "Enabled"; desc = "enabled"; };
        };

        field {
            name = "phy_hs_d3en";
            desc = "High-speed mode enable for data lane 3 on link 0.";
            sw = rw;
            hw = r;
            encode = PHY_EN_LINK0_phy_hs_d3en_enum;
            reset = 0x0;
        } phy_hs_d3en[15:15];

        enum PHY_EN_LINK0_phy_hs_d2en_enum {
            DISABLED = 0 { name = "Disabled"; desc = "disabled"; };
            ENABLED = 1 { name = "Enabled"; desc = "enabled"; };
        };

        field {
            name = "phy_hs_d2en";
            desc = "High-speed mode enable for data lane 2 on link 0.";
            sw = rw;
            hw = r;
            encode = PHY_EN_LINK0_phy_hs_d2en_enum;
            reset = 0x0;
        } phy_hs_d2en[14:14];

        enum PHY_EN_LINK0_phy_hs_d1en_enum {
            DISABLED = 0 { name = "Disabled"; desc = "disabled"; };
            ENABLED = 1 { name = "Enabled"; desc = "enabled"; };
        };

        field {
            name = "phy_hs_d1en";
            desc = "High-speed mode enable for data lane 1 on link 0.";
            sw = rw;
            hw = r;
            encode = PHY_EN_LINK0_phy_hs_d1en_enum;
            reset = 0x0;
        } phy_hs_d1en[13:13];

        enum PHY_EN_LINK0_phy_hs_d0en_enum {
            DISABLED = 0 { name = "Disabled"; desc = "disabled"; };
            ENABLED = 1 { name = "Enabled"; desc = "enabled"; };
        };

        field {
            name = "phy_hs_d0en";
            desc = "High-speed mode enable for data lane 0 on link 0.";
            sw = rw;
            hw = r;
            encode = PHY_EN_LINK0_phy_hs_d0en_enum;
            reset = 0x0;
        } phy_hs_d0en[12:12];

        enum PHY_EN_LINK0_phy_hs_cken_enum {
            DISABLED = 0 { name = "Disabled"; desc = "disabled"; };
            ENABLED = 1 { name = "Enabled"; desc = "enabled"; };
        };

        field {
            name = "phy_hs_cken";
            desc = "High-speed mode enable for the clock lane on link 0.";
            sw = rw;
            hw = r;
            encode = PHY_EN_LINK0_phy_hs_cken_enum;
            reset = 0x0;
        } phy_hs_cken[8:8];

        field {
            name = "phy_lp_d3en";
            desc = "[inferred] PHY low-power d3en. (bits reserved in the data sheet; vendor header `hi3516av100/mipi_reg.h` field `phy_lp_d3en`; access and reset unknown, modelled RW)";
            sw = rw;
            hw = r;
        } phy_lp_d3en[7:7];

        field {
            name = "phy_lp_d2en";
            desc = "[inferred] PHY low-power d2en. (bits reserved in the data sheet; vendor header `hi3516av100/mipi_reg.h` field `phy_lp_d2en`; access and reset unknown, modelled RW)";
            sw = rw;
            hw = r;
        } phy_lp_d2en[6:6];

        field {
            name = "phy_lp_d1en";
            desc = "[inferred] PHY low-power d1en. (bits reserved in the data sheet; vendor header `hi3516av100/mipi_reg.h` field `phy_lp_d1en`; access and reset unknown, modelled RW)";
            sw = rw;
            hw = r;
        } phy_lp_d1en[5:5];

        field {
            name = "phy_lp_d0en";
            desc = "[inferred] PHY low-power d0en. (bits reserved in the data sheet; vendor header `hi3516av100/mipi_reg.h` field `phy_lp_d0en`; access and reset unknown, modelled RW)";
            sw = rw;
            hw = r;
        } phy_lp_d0en[4:4];

        field {
            name = "phy_lp_cken";
            desc = "[inferred] PHY low-power cken. (bits reserved in the data sheet; vendor header `hi3516av100/mipi_reg.h` field `phy_lp_cken`; access and reset unknown, modelled RW)";
            sw = rw;
            hw = r;
        } phy_lp_cken[0:0];
    } PHY_EN_LINK0 @ 0x1024;

    reg {
        name = "Link 0 PHY mode configuration register";
        desc = "PHY_CFG_LINK0 is a link 0 PHY mode configuration register.

Data sheet 10.3.6 PHY_CFG_LINK0 (offset 0x1028, printed page 10-295, `hi3516av100--Hi3516A-Hi3516D-Datasheet.txt` line 75363).";

        field {
            name = "phy_rg_sa_en";
            desc = "SA enable (function tuning).";
            sw = rw;
            hw = r;
            reset = 0x1;
        } phy_rg_sa_en[30:30];

        field {
            name = "phy_rg_it_dt";
            desc = "High-speed mode current adjustment for data channels.";
            sw = rw;
            hw = r;
            reset = 0x2;
        } phy_rg_it_dt[29:28];

        field {
            name = "phy_rg_it_ck";
            desc = "High-speed mode current adjustment for the clock channel.";
            sw = rw;
            hw = r;
            reset = 0x2;
        } phy_rg_it_ck[27:26];

        field {
            name = "phy_rg_it_lp";
            desc = "Low-power mode current adjustment.";
            sw = rw;
            hw = r;
            reset = 0x2;
        } phy_rg_it_lp[25:24];

        enum PHY_CFG_LINK0_phy_da_ulpb_ck_enum {
            ENABLE_F = 0 { name = "Enable F"; desc = "enable"; };
            DISABLE = 1 { name = "Disable"; desc = "disable"; };
        };

        field {
            name = "phy_da_ulpb_ck";
            desc = "Ultra-low-power mode enable for the clock lane.";
            sw = rw;
            hw = r;
            encode = PHY_CFG_LINK0_phy_da_ulpb_ck_enum;
            reset = 0x1;
        } phy_da_ulpb_ck[20:20];

        enum PHY_CFG_LINK0_phy_da_ulpb_enum {
            ENABLE_F = 0 { name = "Enable F"; desc = "enable"; };
            DISABLE = 1 { name = "Disable"; desc = "disable"; };
        };

        field {
            name = "phy_da_ulpb";
            desc = "Ultra-low-power mode enable for data lanes. Each bit corresponds to one data lane. Bit[16] corresponds to data lane 0. Bit[17] corresponds to data lane 1. Bit[18] corresponds to data lane 2. Bit[19] corresponds to data lane 3";
            sw = rw;
            hw = r;
            encode = PHY_CFG_LINK0_phy_da_ulpb_enum;
            reset = 0xF;
        } phy_da_ulpb[19:16];

        enum PHY_CFG_LINK0_phy_rg_en_lp_enum {
            DISABLED = 0 { name = "Disabled"; desc = "disabled"; };
            ENABLED = 1 { name = "Enabled"; desc = "enabled"; };
        };

        field {
            name = "phy_rg_en_lp";
            desc = "LP mode enable. In LVDS mode, the common mode voltage may trigger an internal LP-related circuit. Therefore, this signal must be disabled in LVDS mode.";
            sw = rw;
            hw = r;
            encode = PHY_CFG_LINK0_phy_rg_en_lp_enum;
            reset = 0x0;
        } phy_rg_en_lp[12:12];

        enum PHY_CFG_LINK0_phy_rg_en_cmos_enum {
            DISABLED = 0 { name = "Disabled"; desc = "disabled"; };
            ENABLED = 1 { name = "Enabled"; desc = "enabled"; };
        };

        field {
            name = "phy_rg_en_cmos";
            desc = "CMOS mode enable.";
            sw = rw;
            hw = r;
            encode = PHY_CFG_LINK0_phy_rg_en_cmos_enum;
            reset = 0x0;
        } phy_rg_en_cmos[8:8];

        enum PHY_CFG_LINK0_phy_rg_en_clk_enum {
            DISABLED = 0 { name = "Disabled"; desc = "disabled"; };
            ENABLED = 1 { name = "Enabled"; desc = "enabled"; };
        };

        field {
            name = "phy_rg_en_clk";
            desc = "Clock lane enable.";
            sw = rw;
            hw = r;
            encode = PHY_CFG_LINK0_phy_rg_en_clk_enum;
            reset = 0x0;
        } phy_rg_en_clk[4:4];

        enum PHY_CFG_LINK0_phy_rg_en_d_enum {
            DISABLED = 0 { name = "Disabled"; desc = "disabled"; };
            ENABLED = 1 { name = "Enabled"; desc = "enabled"; };
        };

        field {
            name = "phy_rg_en_d";
            desc = "Data lane enable.";
            sw = rw;
            hw = r;
            encode = PHY_CFG_LINK0_phy_rg_en_d_enum;
            reset = 0x0;
        } phy_rg_en_d[3:0];
    } PHY_CFG_LINK0 @ 0x1028;

    reg {
        name = "MIPI data channel quantity register";
        desc = "MIPI_LANES_NUM is an MIPI data channel quantity register. Huawei Proprietary and Confidential Hi3516A/Hi3516D Professional HD IP Camera SoC

Data sheet 10.3.6 MIPI_LANES_NUM (offset 0x1030, printed page 10-297, `hi3516av100--Hi3516A-Hi3516D-Datasheet.txt` line 75442).";

        enum MIPI_LANES_NUM_field_1_0_enum {
            ONE_DATA_CHANNEL = 0 { name = "One Data Channel"; desc = "one data channel"; };
            TWO_DATA_CHANNELS = 1 { name = "Two Data Channels"; desc = "two data channels"; };
            THREE_DATA_CHANNELS = 2 { name = "Three Data Channels"; desc = "three data channels"; };
            FOUR_DATA_CHANNELS = 3 { name = "Four Data Channels"; desc = "four data channels"; };
        };

        field {
            name = "field_1_0";
            desc = "Number of enabled data channels.";
            sw = rw;
            hw = r;
            encode = MIPI_LANES_NUM_field_1_0_enum;
            reset = 0x0;
        } field_1_0[1:0];
    } MIPI_LANES_NUM @ 0x1030;

    reg {
        name = "MIPI controller reset control register";
        desc = "MIPI_RSTN is an MIPI controller reset control register.

Data sheet 10.3.6 MIPI_RSTN (offset 0x1034, printed page 10-297, `hi3516av100--Hi3516A-Hi3516D-Datasheet.txt` line 75472).";

        enum MIPI_RSTN_csi2_rstn_enum {
            RESET_F = 0 { name = "Reset F"; desc = "reset"; };
            DEASSERT_RESET = 1 { name = "Deassert Reset"; desc = "deassert the reset"; };
        };

        field {
            name = "csi2_rstn";
            desc = "CSI2 controller reset control.";
            sw = rw;
            hw = r;
            encode = MIPI_RSTN_csi2_rstn_enum;
            reset = 0x0;
        } csi2_rstn[0:0];
    } MIPI_RSTN @ 0x1034;

    reg {
        name = "MIPI controller data ID 1 register";
        desc = "MIPI_DI_1 is an MIPI controller data ID 1 register. Huawei Proprietary and Confidential Hi3516A/Hi3516D Professional HD IP Camera SoC

Data sheet 10.3.6 MIPI_DI_1 (offset 0x1038, printed page 10-298, `hi3516av100--Hi3516A-Hi3516D-Datasheet.txt` line 75506).";

        field {
            name = "di3_vc";
            desc = "Virtual channel of data ID 3.";
            sw = rw;
            hw = r;
            reset = 0x0;
        } di3_vc[31:30];

        enum MIPI_DI_1_di3_dt_enum {
            RAW10 = 0x2B { name = "Raw10"; desc = "RAW10"; };
            RAW12 = 0x2C { name = "Raw12"; desc = "RAW12"; };
            RAW14_OTHER_VALUES = 0x2D { name = "Raw14 Other Values"; desc = "RAW14 Other values: reserved"; };
        };

        field {
            name = "di3_dt";
            desc = "Data type of data ID 3.";
            sw = rw;
            hw = r;
            encode = MIPI_DI_1_di3_dt_enum;
            reset = 0x0;
        } di3_dt[29:24];

        field {
            name = "di2_vc";
            desc = "Virtual channel of data ID 2.";
            sw = rw;
            hw = r;
            reset = 0x0;
        } di2_vc[23:22];

        enum MIPI_DI_1_di2_dt_enum {
            RAW10 = 0x2B { name = "Raw10"; desc = "RAW10"; };
            RAW12 = 0x2C { name = "Raw12"; desc = "RAW12"; };
            RAW14_OTHER_VALUES = 0x2D { name = "Raw14 Other Values"; desc = "RAW14 Other values: reserved"; };
        };

        field {
            name = "di2_dt";
            desc = "Data type of data ID 2.";
            sw = rw;
            hw = r;
            encode = MIPI_DI_1_di2_dt_enum;
            reset = 0x0;
        } di2_dt[21:16];

        field {
            name = "di1_vc";
            desc = "Virtual channel of data ID 1.";
            sw = rw;
            hw = r;
            reset = 0x0;
        } di1_vc[15:14];

        enum MIPI_DI_1_di1_dt_enum {
            RAW10 = 0x2B { name = "Raw10"; desc = "RAW10"; };
            RAW12 = 0x2C { name = "Raw12"; desc = "RAW12"; };
            RAW14_OTHER_VALUES = 0x2D { name = "Raw14 Other Values"; desc = "RAW14 Other values: reserved"; };
        };

        field {
            name = "di1_dt";
            desc = "Data type of data ID 1.";
            sw = rw;
            hw = r;
            encode = MIPI_DI_1_di1_dt_enum;
            reset = 0x0;
        } di1_dt[13:8];

        field {
            name = "di0_vc";
            desc = "Virtual channel of data ID 0.";
            sw = rw;
            hw = r;
            reset = 0x0;
        } di0_vc[7:6];

        enum MIPI_DI_1_di0_dt_enum {
            RAW10 = 0x2B { name = "Raw10"; desc = "RAW10"; };
            RAW12 = 0x2C { name = "Raw12"; desc = "RAW12"; };
            RAW14_OTHER_VALUES = 0x2D { name = "Raw14 Other Values"; desc = "RAW14 Other values: reserved"; };
        };

        field {
            name = "di0_dt";
            desc = "Data type of data ID 0.";
            sw = rw;
            hw = r;
            encode = MIPI_DI_1_di0_dt_enum;
            reset = 0x0;
        } di0_dt[5:0];
    } MIPI_DI_1 @ 0x1038;

    reg {
        name = "MIPI controller data ID 2 register";
        desc = "MIPI_DI_2 is an MIPI controller data ID 2 register. Huawei Proprietary and Confidential Hi3516A/Hi3516D Professional HD IP Camera SoC

Data sheet 10.3.6 MIPI_DI_2 (offset 0x103C, printed page 10-299, `hi3516av100--Hi3516A-Hi3516D-Datasheet.txt` line 75558).";

        field {
            name = "di7_vc";
            desc = "Virtual channel of data ID 7.";
            sw = rw;
            hw = r;
            reset = 0x0;
        } di7_vc[31:30];

        enum MIPI_DI_2_di7_dt_enum {
            RAW10 = 0x2B { name = "Raw10"; desc = "RAW10"; };
            RAW12 = 0x2C { name = "Raw12"; desc = "RAW12"; };
            RAW14_OTHER_VALUES = 0x2D { name = "Raw14 Other Values"; desc = "RAW14 Other values: reserved"; };
        };

        field {
            name = "di7_dt";
            desc = "Data type of data ID 7.";
            sw = rw;
            hw = r;
            encode = MIPI_DI_2_di7_dt_enum;
            reset = 0x0;
        } di7_dt[29:24];

        field {
            name = "di6_vc";
            desc = "Virtual channel of data ID 6.";
            sw = rw;
            hw = r;
            reset = 0x0;
        } di6_vc[23:22];

        enum MIPI_DI_2_di6_dt_enum {
            RAW10 = 0x2B { name = "Raw10"; desc = "RAW10"; };
            RAW12 = 0x2C { name = "Raw12"; desc = "RAW12"; };
            RAW14_OTHER_VALUES = 0x2D { name = "Raw14 Other Values"; desc = "RAW14 Other values: reserved"; };
        };

        field {
            name = "di6_dt";
            desc = "Data type of data ID 6.";
            sw = rw;
            hw = r;
            encode = MIPI_DI_2_di6_dt_enum;
            reset = 0x0;
        } di6_dt[21:16];

        field {
            name = "di5_vc";
            desc = "Virtual channel of data ID 5.";
            sw = rw;
            hw = r;
            reset = 0x0;
        } di5_vc[15:14];

        enum MIPI_DI_2_di5_dt_enum {
            RAW10 = 0x2B { name = "Raw10"; desc = "RAW10"; };
            RAW12 = 0x2C { name = "Raw12"; desc = "RAW12"; };
            RAW14_OTHER_VALUES = 0x2D { name = "Raw14 Other Values"; desc = "RAW14 Other values: reserved"; };
        };

        field {
            name = "di5_dt";
            desc = "Data type of data type 5.";
            sw = rw;
            hw = r;
            encode = MIPI_DI_2_di5_dt_enum;
            reset = 0x0;
        } di5_dt[13:8];

        field {
            name = "di4_vc";
            desc = "Virtual channel of data ID 4.";
            sw = rw;
            hw = r;
            reset = 0x0;
        } di4_vc[7:6];

        enum MIPI_DI_2_di4_dt_enum {
            RAW10 = 0x2B { name = "Raw10"; desc = "RAW10"; };
            RAW12 = 0x2C { name = "Raw12"; desc = "RAW12"; };
            RAW14_OTHER_VALUES = 0x2D { name = "Raw14 Other Values"; desc = "RAW14 Other values: reserved"; };
        };

        field {
            name = "di4_dt";
            desc = "Data type of data type 4.";
            sw = rw;
            hw = r;
            encode = MIPI_DI_2_di4_dt_enum;
            reset = 0x0;
        } di4_dt[5:0];
    } MIPI_DI_2 @ 0x103C;

    reg {
        name = "MIPI raw interrupt 1 register";
        desc = "MIPI_INTR1_RAW is an MIPI raw interrupt 1 register. Huawei Proprietary and Confidential Hi3516A/Hi3516D Professional HD IP Camera SoC

Data sheet 10.3.6 MIPI_INTR1_RAW (offset 0x1040, printed page 10-300, `hi3516av100--Hi3516A-Hi3516D-Datasheet.txt` line 75610).";

        field {
            name = "intr_ecc_double";
            desc = "The header has at least two errors, which cannot be fixed by ECC. This field is cleared on a read.";
            sw = r;
            hw = w;
            onread = rclr;
            reset = 0x0;
        } intr_ecc_double[28:28];

        field {
            name = "intr_crc_vc3";
            desc = "VC3 data CRC error. This field is cleared on a read.";
            sw = r;
            hw = w;
            onread = rclr;
            reset = 0x0;
        } intr_crc_vc3[27:27];

        field {
            name = "intr_crc_vc2";
            desc = "VC2 data CRC error. This field is cleared on a read.";
            sw = r;
            hw = w;
            onread = rclr;
            reset = 0x0;
        } intr_crc_vc2[26:26];

        field {
            name = "intr_crc_vc1";
            desc = "VC1 data CRC error. This field is cleared on a read.";
            sw = r;
            hw = w;
            onread = rclr;
            reset = 0x0;
        } intr_crc_vc1[25:25];

        field {
            name = "intr_crc_vc0";
            desc = "VC0 data CRC error. This field is cleared on a read.";
            sw = r;
            hw = w;
            onread = rclr;
            reset = 0x0;
        } intr_crc_vc0[24:24];

        field {
            name = "intr_l_seq_di3";
            desc = "VC3 and DT3 line sequence error. This field is cleared on a read.";
            sw = r;
            hw = w;
            onread = rclr;
            reset = 0x0;
        } intr_l_seq_di3[23:23];

        field {
            name = "intr_l_seq_di2";
            desc = "VC2 and DT2 line sequence error. This field is cleared on a read.";
            sw = r;
            hw = w;
            onread = rclr;
            reset = 0x0;
        } intr_l_seq_di2[22:22];

        field {
            name = "intr_l_seq_di1";
            desc = "VC1 and DT1 line sequence error. This field is cleared on a read.";
            sw = r;
            hw = w;
            onread = rclr;
            reset = 0x0;
        } intr_l_seq_di1[21:21];

        field {
            name = "intr_l_seq_di0";
            desc = "VC0 and DT0 line sequence error. This field is cleared on a read.";
            sw = r;
            hw = w;
            onread = rclr;
            reset = 0x0;
        } intr_l_seq_di0[20:20];

        field {
            name = "intr_l_bndy_di3";
            desc = "SOL and EOL mismatch for VC3 and DT3. This field is cleared on a read.";
            sw = r;
            hw = w;
            onread = rclr;
            reset = 0x0;
        } intr_l_bndy_di3[19:19];

        field {
            name = "intr_l_bndy_di2";
            desc = "SOL and EOL mismatch for VC2 and DT2. This field is cleared on a read.";
            sw = r;
            hw = w;
            onread = rclr;
            reset = 0x0;
        } intr_l_bndy_di2[18:18];

        field {
            name = "intr_l_bndy_di1";
            desc = "SOL and EOL mismatch for VC1 and DT1. This field is cleared on a read.";
            sw = r;
            hw = w;
            onread = rclr;
            reset = 0x0;
        } intr_l_bndy_di1[17:17];

        field {
            name = "intr_l_bndy_di0";
            desc = "SOL and EOL mismatch for VC0 and DT0. This field is cleared on a read.";
            sw = r;
            hw = w;
            onread = rclr;
            reset = 0x0;
        } intr_l_bndy_di0[16:16];

        field {
            name = "intr_f_crc_vc3";
            desc = "In the last frame of data, VC3 channel data has at least one CRC error. This field is cleared on a read.";
            sw = r;
            hw = w;
            onread = rclr;
            reset = 0x0;
        } intr_f_crc_vc3[15:15];

        field {
            name = "intr_f_crc_vc2";
            desc = "In the last frame of data, VC2 channel data has at least one CRC error. This field is cleared on a read.";
            sw = r;
            hw = w;
            onread = rclr;
            reset = 0x0;
        } intr_f_crc_vc2[14:14];

        field {
            name = "intr_f_crc_vc1";
            desc = "In the last frame of data, VC1 channel data has at least one CRC error. This field is cleared on a read.";
            sw = r;
            hw = w;
            onread = rclr;
            reset = 0x0;
        } intr_f_crc_vc1[13:13];

        field {
            name = "intr_f_crc_vc0";
            desc = "In the last frame of data, VC0 channel data has at least one CRC error. This field is cleared on a read.";
            sw = r;
            hw = w;
            onread = rclr;
            reset = 0x0;
        } intr_f_crc_vc0[12:12];

        field {
            name = "intr_f_seq_vc3";
            desc = "VC3 frame sequence error. This field is cleared on a read.";
            sw = r;
            hw = w;
            onread = rclr;
            reset = 0x0;
        } intr_f_seq_vc3[11:11];

        field {
            name = "intr_f_seq_vc2";
            desc = "VC2 frame sequence error. This field is cleared on a read.";
            sw = r;
            hw = w;
            onread = rclr;
            reset = 0x0;
        } intr_f_seq_vc2[10:10];

        field {
            name = "intr_f_seq_vc1";
            desc = "VC1 frame sequence error. This field is cleared on a read.";
            sw = r;
            hw = w;
            onread = rclr;
            reset = 0x0;
        } intr_f_seq_vc1[9:9];

        field {
            name = "intr_f_seq_vc0";
            desc = "VC0 frame sequence error. This field is cleared on a read.";
            sw = r;
            hw = w;
            onread = rclr;
            reset = 0x0;
        } intr_f_seq_vc0[8:8];

        field {
            name = "intr_f_bndry_vc3";
            desc = "SOF and EOF mismatch for VC3. This field is cleared on a read.";
            sw = r;
            hw = w;
            onread = rclr;
            reset = 0x0;
        } intr_f_bndry_vc3[7:7];

        field {
            name = "intr_f_bndry_vc2";
            desc = "SOF and EOF mismatch for VC2. This field is cleared on a read.";
            sw = r;
            hw = w;
            onread = rclr;
            reset = 0x0;
        } intr_f_bndry_vc2[6:6];

        field {
            name = "intr_f_bndry_vc1";
            desc = "SOF and EOF mismatch for VC1. This field is cleared on a read.";
            sw = r;
            hw = w;
            onread = rclr;
            reset = 0x0;
        } intr_f_bndry_vc1[5:5];

        field {
            name = "intr_f_bndry_vc0";
            desc = "SOF and EOF mismatch for VC0. This field is cleared on a read.";
            sw = r;
            hw = w;
            onread = rclr;
            reset = 0x0;
        } intr_f_bndry_vc0[4:4];
    } MIPI_INTR1_RAW @ 0x1040;

    reg {
        name = "MIPI raw interrupt 2 register";
        desc = "MIPI_INTR2_RAW is an MIPI raw interrupt 2 register.

Data sheet 10.3.6 MIPI_INTR2_RAW (offset 0x1044, printed page 10-301, `hi3516av100--Hi3516A-Hi3516D-Datasheet.txt` line 75696).";

        field {
            name = "intr_l_seq_di7";
            desc = "VC 7 and DT 7 line sequence error. This field is cleared on a read.";
            sw = r;
            hw = w;
            onread = rclr;
            reset = 0x0;
        } intr_l_seq_di7[23:23];

        field {
            name = "intr_l_seq_di6";
            desc = "VC 6 and DT 6 line sequence error. This field is cleared on a read.";
            sw = r;
            hw = w;
            onread = rclr;
            reset = 0x0;
        } intr_l_seq_di6[22:22];

        field {
            name = "intr_l_seq_di5";
            desc = "VC 5 and DT 5 line sequence error. This field is cleared on a read.";
            sw = r;
            hw = w;
            onread = rclr;
            reset = 0x0;
        } intr_l_seq_di5[21:21];

        field {
            name = "intr_l_seq_di4";
            desc = "VC 4 and DT 4 line sequence error. This field is cleared on a read.";
            sw = r;
            hw = w;
            onread = rclr;
            reset = 0x0;
        } intr_l_seq_di4[20:20];

        field {
            name = "intr_l_bndry_di7";
            desc = "SOL and EOL mismatch for VC 7 and DT 7. This field is cleared on a read.";
            sw = r;
            hw = w;
            onread = rclr;
            reset = 0x0;
        } intr_l_bndry_di7[19:19];

        field {
            name = "intr_l_bndry_di6";
            desc = "SOL and EOL mismatch for VC 6 and DT 6. This field is cleared on a read.";
            sw = r;
            hw = w;
            onread = rclr;
            reset = 0x0;
        } intr_l_bndry_di6[18:18];

        field {
            name = "intr_l_bndry_di5";
            desc = "SOL and EOL mismatch for VC 5 and DT 5. This field is cleared on a read.";
            sw = r;
            hw = w;
            onread = rclr;
            reset = 0x0;
        } intr_l_bndry_di5[17:17];

        field {
            name = "intr_l_bndry_di4";
            desc = "SOL and EOL mismatch for VC 4 and DT 4. This field is cleared on a read.";
            sw = r;
            hw = w;
            onread = rclr;
            reset = 0x0;
        } intr_l_bndry_di4[16:16];

        field {
            name = "intr_err_id_vc3";
            desc = "VC3 channel data type is not supported. This field is cleared on a read.";
            sw = r;
            hw = w;
            onread = rclr;
            reset = 0x0;
        } intr_err_id_vc3[15:15];

        field {
            name = "intr_err_id_vc2";
            desc = "VC2 channel data type is not supported. This field is cleared on a read.";
            sw = r;
            hw = w;
            onread = rclr;
            reset = 0x0;
        } intr_err_id_vc2[14:14];

        field {
            name = "intr_err_id_vc1";
            desc = "VC1 channel data type is not supported. This field is cleared on a read.";
            sw = r;
            hw = w;
            onread = rclr;
            reset = 0x0;
        } intr_err_id_vc1[13:13];

        field {
            name = "intr_err_id_vc0";
            desc = "VC0 channel data type is not supported. This field is cleared on a read.";
            sw = r;
            hw = w;
            onread = rclr;
            reset = 0x0;
        } intr_err_id_vc0[12:12];

        field {
            name = "intr_vc3_ecc_corrected";
            desc = "VC3 channel header error, fixed by ECC. This field is cleared on a read.";
            sw = r;
            hw = w;
            onread = rclr;
            reset = 0x0;
        } intr_vc3_ecc_corrected[11:11];

        field {
            name = "intr_vc2_ecc_corrected";
            desc = "VC2 channel header error, fixed by ECC. This field is cleared on a read.";
            sw = r;
            hw = w;
            onread = rclr;
            reset = 0x0;
        } intr_vc2_ecc_corrected[10:10];

        field {
            name = "intr_vc1_ecc_corrected";
            desc = "VC1 channel header error, fixed by ECC. This field is cleared on a read.";
            sw = r;
            hw = w;
            onread = rclr;
            reset = 0x0;
        } intr_vc1_ecc_corrected[9:9];

        field {
            name = "intr_vc0_ecc_corrected";
            desc = "VC0 channel header error, fixed by ECC. This field is cleared on a read.";
            sw = r;
            hw = w;
            onread = rclr;
            reset = 0x0;
        } intr_vc0_ecc_corrected[8:8];
    } MIPI_INTR2_RAW @ 0x1044;

    reg {
        name = "MIPI interrupt 1 mask register";
        desc = "MIPI_INTR1_MASK is an MIPI interrupt 1 mask register. Huawei Proprietary and Confidential Hi3516A/Hi3516D Professional HD IP Camera SoC

Data sheet 10.3.6 MIPI_INTR1_MASK (offset 0x1048, printed page 10-303, `hi3516av100--Hi3516A-Hi3516D-Datasheet.txt` line 75789).";

        enum MIPI_INTR1_MASK_mask_ecc_double_enum {
            NOT_MASKED = 0 { name = "Not Masked"; desc = "not masked"; };
            MASKED = 1 { name = "Masked"; desc = "masked"; };
        };

        field {
            name = "mask_ecc_double";
            desc = "Ecc_double interrupt mask, corresponding to the relevant bit in the MIPI_INTR1_RAW register.";
            sw = rw;
            hw = r;
            encode = MIPI_INTR1_MASK_mask_ecc_double_enum;
            reset = 0x0;
        } mask_ecc_double[28:28];

        enum MIPI_INTR1_MASK_mask_crc_vc3_enum {
            NOT_MASKED = 0 { name = "Not Masked"; desc = "not masked"; };
            MASKED = 1 { name = "Masked"; desc = "masked"; };
        };

        field {
            name = "mask_crc_vc3";
            desc = "Crc_vc3 interrupt mask.";
            sw = rw;
            hw = r;
            encode = MIPI_INTR1_MASK_mask_crc_vc3_enum;
            reset = 0x0;
        } mask_crc_vc3[27:27];

        enum MIPI_INTR1_MASK_mask_crc_vc2_enum {
            NOT_MASKED = 0 { name = "Not Masked"; desc = "not masked"; };
            MASKED = 1 { name = "Masked"; desc = "masked"; };
        };

        field {
            name = "mask_crc_vc2";
            desc = "Crc_vc2 interrupt mask.";
            sw = rw;
            hw = r;
            encode = MIPI_INTR1_MASK_mask_crc_vc2_enum;
            reset = 0x0;
        } mask_crc_vc2[26:26];

        enum MIPI_INTR1_MASK_mask_crc_vc1_enum {
            NOT_MASKED = 0 { name = "Not Masked"; desc = "not masked"; };
            MASKED = 1 { name = "Masked"; desc = "masked"; };
        };

        field {
            name = "mask_crc_vc1";
            desc = "Crc_vc1 interrupt mask.";
            sw = rw;
            hw = r;
            encode = MIPI_INTR1_MASK_mask_crc_vc1_enum;
            reset = 0x0;
        } mask_crc_vc1[25:25];

        enum MIPI_INTR1_MASK_mask_crc_vc0_enum {
            NOT_MASKED = 0 { name = "Not Masked"; desc = "not masked"; };
            MASKED = 1 { name = "Masked"; desc = "masked"; };
        };

        field {
            name = "mask_crc_vc0";
            desc = "Crc_vc0 interrupt mask.";
            sw = rw;
            hw = r;
            encode = MIPI_INTR1_MASK_mask_crc_vc0_enum;
            reset = 0x0;
        } mask_crc_vc0[24:24];

        enum MIPI_INTR1_MASK_mask_l_seq_di3_enum {
            NOT_MASKED = 0 { name = "Not Masked"; desc = "not masked"; };
            MASKED = 1 { name = "Masked"; desc = "masked"; };
        };

        field {
            name = "mask_l_seq_di3";
            desc = "L_seq_di3 interrupt mask.";
            sw = rw;
            hw = r;
            encode = MIPI_INTR1_MASK_mask_l_seq_di3_enum;
            reset = 0x0;
        } mask_l_seq_di3[23:23];

        enum MIPI_INTR1_MASK_mask_l_seq_di2_enum {
            NOT_MASKED = 0 { name = "Not Masked"; desc = "not masked"; };
            MASKED = 1 { name = "Masked"; desc = "masked"; };
        };

        field {
            name = "mask_l_seq_di2";
            desc = "L_seq_di2 interrupt mask.";
            sw = rw;
            hw = r;
            encode = MIPI_INTR1_MASK_mask_l_seq_di2_enum;
            reset = 0x0;
        } mask_l_seq_di2[22:22];

        enum MIPI_INTR1_MASK_mask_l_seq_di1_enum {
            NOT_MASKED = 0 { name = "Not Masked"; desc = "not masked"; };
            MASKED = 1 { name = "Masked"; desc = "masked"; };
        };

        field {
            name = "mask_l_seq_di1";
            desc = "L_seq_di1 interrupt mask.";
            sw = rw;
            hw = r;
            encode = MIPI_INTR1_MASK_mask_l_seq_di1_enum;
            reset = 0x0;
        } mask_l_seq_di1[21:21];

        enum MIPI_INTR1_MASK_mask_l_seq_di0_enum {
            NOT_MASKED = 0 { name = "Not Masked"; desc = "not masked"; };
            MASKED = 1 { name = "Masked"; desc = "masked"; };
        };

        field {
            name = "mask_l_seq_di0";
            desc = "L_seq_di0 interrupt mask.";
            sw = rw;
            hw = r;
            encode = MIPI_INTR1_MASK_mask_l_seq_di0_enum;
            reset = 0x0;
        } mask_l_seq_di0[20:20];

        enum MIPI_INTR1_MASK_mask_l_bndy_di3_enum {
            NOT_MASKED = 0 { name = "Not Masked"; desc = "not masked"; };
            MASKED = 1 { name = "Masked"; desc = "masked"; };
        };

        field {
            name = "mask_l_bndy_di3";
            desc = "L_bndy_di3 interrupt mask.";
            sw = rw;
            hw = r;
            encode = MIPI_INTR1_MASK_mask_l_bndy_di3_enum;
            reset = 0x0;
        } mask_l_bndy_di3[19:19];

        enum MIPI_INTR1_MASK_mask_l_bndy_di2_enum {
            NOT_MASKED = 0 { name = "Not Masked"; desc = "not masked"; };
            MASKED = 1 { name = "Masked"; desc = "masked"; };
        };

        field {
            name = "mask_l_bndy_di2";
            desc = "L_bndy_di2 interrupt mask.";
            sw = rw;
            hw = r;
            encode = MIPI_INTR1_MASK_mask_l_bndy_di2_enum;
            reset = 0x0;
        } mask_l_bndy_di2[18:18];

        enum MIPI_INTR1_MASK_mask_l_bndy_di1_enum {
            NOT_MASKED = 0 { name = "Not Masked"; desc = "not masked"; };
            MASKED = 1 { name = "Masked"; desc = "masked"; };
        };

        field {
            name = "mask_l_bndy_di1";
            desc = "L_bndy_di1 interrupt mask.";
            sw = rw;
            hw = r;
            encode = MIPI_INTR1_MASK_mask_l_bndy_di1_enum;
            reset = 0x0;
        } mask_l_bndy_di1[17:17];

        enum MIPI_INTR1_MASK_mask_l_bndy_di0_enum {
            NOT_MASKED = 0 { name = "Not Masked"; desc = "not masked"; };
            MASKED = 1 { name = "Masked"; desc = "masked"; };
        };

        field {
            name = "mask_l_bndy_di0";
            desc = "L_bndy_di0 interrupt mask.";
            sw = rw;
            hw = r;
            encode = MIPI_INTR1_MASK_mask_l_bndy_di0_enum;
            reset = 0x0;
        } mask_l_bndy_di0[16:16];

        enum MIPI_INTR1_MASK_mask_f_crc_vc3_enum {
            NOT_MASKED = 0 { name = "Not Masked"; desc = "not masked"; };
            MASKED = 1 { name = "Masked"; desc = "masked"; };
        };

        field {
            name = "mask_f_crc_vc3";
            desc = "F_crc_vc3 interrupt mask.";
            sw = rw;
            hw = r;
            encode = MIPI_INTR1_MASK_mask_f_crc_vc3_enum;
            reset = 0x0;
        } mask_f_crc_vc3[15:15];

        enum MIPI_INTR1_MASK_mask_f_crc_vc2_enum {
            NOT_MASKED = 0 { name = "Not Masked"; desc = "not masked"; };
            MASKED = 1 { name = "Masked"; desc = "masked"; };
        };

        field {
            name = "mask_f_crc_vc2";
            desc = "F_crc_vc2 interrupt mask.";
            sw = rw;
            hw = r;
            encode = MIPI_INTR1_MASK_mask_f_crc_vc2_enum;
            reset = 0x0;
        } mask_f_crc_vc2[14:14];

        enum MIPI_INTR1_MASK_mask_f_crc_vc1_enum {
            NOT_MASKED = 0 { name = "Not Masked"; desc = "not masked"; };
            MASKED = 1 { name = "Masked"; desc = "masked"; };
        };

        field {
            name = "mask_f_crc_vc1";
            desc = "F_crc_vc1 interrupt mask.";
            sw = rw;
            hw = r;
            encode = MIPI_INTR1_MASK_mask_f_crc_vc1_enum;
            reset = 0x0;
        } mask_f_crc_vc1[13:13];

        enum MIPI_INTR1_MASK_mask_f_crc_vc0_enum {
            NOT_MASKED = 0 { name = "Not Masked"; desc = "not masked"; };
            MASKED = 1 { name = "Masked"; desc = "masked"; };
        };

        field {
            name = "mask_f_crc_vc0";
            desc = "F_crc_vc0 interrupt mask.";
            sw = rw;
            hw = r;
            encode = MIPI_INTR1_MASK_mask_f_crc_vc0_enum;
            reset = 0x0;
        } mask_f_crc_vc0[12:12];

        enum MIPI_INTR1_MASK_mask_f_seq_vc3_enum {
            NOT_MASKED = 0 { name = "Not Masked"; desc = "not masked"; };
            MASKED = 1 { name = "Masked"; desc = "masked"; };
        };

        field {
            name = "mask_f_seq_vc3";
            desc = "F_seq_vc3 interrupt mask.";
            sw = rw;
            hw = r;
            encode = MIPI_INTR1_MASK_mask_f_seq_vc3_enum;
            reset = 0x0;
        } mask_f_seq_vc3[11:11];

        enum MIPI_INTR1_MASK_mask_f_seq_vc2_enum {
            NOT_MASKED = 0 { name = "Not Masked"; desc = "not masked"; };
            MASKED = 1 { name = "Masked"; desc = "masked"; };
        };

        field {
            name = "mask_f_seq_vc2";
            desc = "F_seq_vc2 interrupt mask.";
            sw = rw;
            hw = r;
            encode = MIPI_INTR1_MASK_mask_f_seq_vc2_enum;
            reset = 0x0;
        } mask_f_seq_vc2[10:10];

        enum MIPI_INTR1_MASK_mask_f_seq_vc1_enum {
            NOT_MASKED = 0 { name = "Not Masked"; desc = "not masked"; };
            MASKED = 1 { name = "Masked"; desc = "masked"; };
        };

        field {
            name = "mask_f_seq_vc1";
            desc = "F_seq_vc1 interrupt mask.";
            sw = rw;
            hw = r;
            encode = MIPI_INTR1_MASK_mask_f_seq_vc1_enum;
            reset = 0x0;
        } mask_f_seq_vc1[9:9];

        enum MIPI_INTR1_MASK_mask_f_seq_vc0_enum {
            NOT_MASKED = 0 { name = "Not Masked"; desc = "not masked"; };
            MASKED = 1 { name = "Masked"; desc = "masked"; };
        };

        field {
            name = "mask_f_seq_vc0";
            desc = "F_seq_vc0 interrupt mask.";
            sw = rw;
            hw = r;
            encode = MIPI_INTR1_MASK_mask_f_seq_vc0_enum;
            reset = 0x0;
        } mask_f_seq_vc0[8:8];

        enum MIPI_INTR1_MASK_mask_f_bndry_vc3_enum {
            NOT_MASKED = 0 { name = "Not Masked"; desc = "not masked"; };
            MASKED = 1 { name = "Masked"; desc = "masked"; };
        };

        field {
            name = "mask_f_bndry_vc3";
            desc = "F_bndry_vc3 interrupt mask.";
            sw = rw;
            hw = r;
            encode = MIPI_INTR1_MASK_mask_f_bndry_vc3_enum;
            reset = 0x0;
        } mask_f_bndry_vc3[7:7];

        enum MIPI_INTR1_MASK_mask_f_bndry_vc2_enum {
            NOT_MASKED = 0 { name = "Not Masked"; desc = "not masked"; };
            MASKED = 1 { name = "Masked"; desc = "masked"; };
        };

        field {
            name = "mask_f_bndry_vc2";
            desc = "F_bndry_vc2 interrupt mask.";
            sw = rw;
            hw = r;
            encode = MIPI_INTR1_MASK_mask_f_bndry_vc2_enum;
            reset = 0x0;
        } mask_f_bndry_vc2[6:6];

        enum MIPI_INTR1_MASK_mask_f_bndry_vc1_enum {
            NOT_MASKED = 0 { name = "Not Masked"; desc = "not masked"; };
            MASKED = 1 { name = "Masked"; desc = "masked"; };
        };

        field {
            name = "mask_f_bndry_vc1";
            desc = "F_bndry_vc1 interrupt mask.";
            sw = rw;
            hw = r;
            encode = MIPI_INTR1_MASK_mask_f_bndry_vc1_enum;
            reset = 0x0;
        } mask_f_bndry_vc1[5:5];

        enum MIPI_INTR1_MASK_mask_f_bndry_vc0_enum {
            NOT_MASKED = 0 { name = "Not Masked"; desc = "not masked"; };
            MASKED = 1 { name = "Masked"; desc = "masked"; };
        };

        field {
            name = "mask_f_bndry_vc0";
            desc = "F_bndry_vc0 interrupt mask.";
            sw = rw;
            hw = r;
            encode = MIPI_INTR1_MASK_mask_f_bndry_vc0_enum;
            reset = 0x0;
        } mask_f_bndry_vc0[4:4];
    } MIPI_INTR1_MASK @ 0x1048;

    reg {
        name = "MIPI interrupt 2 mask register";
        desc = "MIPI_INTR2_MASK is an MIPI interrupt 2 mask register.

Data sheet 10.3.6 MIPI_INTR2_MASK (offset 0x104C, printed page 10-305, `hi3516av100--Hi3516A-Hi3516D-Datasheet.txt` line 75916).";

        enum MIPI_INTR2_MASK_intr_l_seq_di7_enum {
            NOT_MASKED = 0 { name = "Not Masked"; desc = "not masked"; };
            MASKED = 1 { name = "Masked"; desc = "masked"; };
        };

        field {
            name = "intr_l_seq_di7";
            desc = "L_seq_di7 interrupt mask, corresponding to the relevant bit in the MIPI_INTR2_RAW register.";
            sw = rw;
            hw = r;
            encode = MIPI_INTR2_MASK_intr_l_seq_di7_enum;
            reset = 0x0;
        } intr_l_seq_di7[23:23];

        enum MIPI_INTR2_MASK_intr_l_seq_di6_enum {
            NOT_MASKED = 0 { name = "Not Masked"; desc = "not masked"; };
            MASKED = 1 { name = "Masked"; desc = "masked"; };
        };

        field {
            name = "intr_l_seq_di6";
            desc = "L_seq_di6 interrupt mask.";
            sw = rw;
            hw = r;
            encode = MIPI_INTR2_MASK_intr_l_seq_di6_enum;
            reset = 0x0;
        } intr_l_seq_di6[22:22];

        enum MIPI_INTR2_MASK_intr_l_seq_di5_enum {
            NOT_MASKED = 0 { name = "Not Masked"; desc = "not masked"; };
            MASKED = 1 { name = "Masked"; desc = "masked"; };
        };

        field {
            name = "intr_l_seq_di5";
            desc = "L_seq_di5 interrupt mask.";
            sw = rw;
            hw = r;
            encode = MIPI_INTR2_MASK_intr_l_seq_di5_enum;
            reset = 0x0;
        } intr_l_seq_di5[21:21];

        enum MIPI_INTR2_MASK_intr_l_seq_di4_enum {
            NOT_MASKED = 0 { name = "Not Masked"; desc = "not masked"; };
            MASKED = 1 { name = "Masked"; desc = "masked"; };
        };

        field {
            name = "intr_l_seq_di4";
            desc = "L_seq_di4 interrupt mask.";
            sw = rw;
            hw = r;
            encode = MIPI_INTR2_MASK_intr_l_seq_di4_enum;
            reset = 0x0;
        } intr_l_seq_di4[20:20];

        enum MIPI_INTR2_MASK_intr_l_bndry_di7_enum {
            NOT_MASKED = 0 { name = "Not Masked"; desc = "not masked"; };
            MASKED = 1 { name = "Masked"; desc = "masked"; };
        };

        field {
            name = "intr_l_bndry_di7";
            desc = "L_bndry_di7 interrupt mask.";
            sw = rw;
            hw = r;
            encode = MIPI_INTR2_MASK_intr_l_bndry_di7_enum;
            reset = 0x0;
        } intr_l_bndry_di7[19:19];

        enum MIPI_INTR2_MASK_intr_l_bndry_di6_enum {
            NOT_MASKED = 0 { name = "Not Masked"; desc = "not masked"; };
            MASKED = 1 { name = "Masked"; desc = "masked"; };
        };

        field {
            name = "intr_l_bndry_di6";
            desc = "L_bndry_di6 interrupt mask.";
            sw = rw;
            hw = r;
            encode = MIPI_INTR2_MASK_intr_l_bndry_di6_enum;
            reset = 0x0;
        } intr_l_bndry_di6[18:18];

        enum MIPI_INTR2_MASK_intr_l_bndry_di5_enum {
            NOT_MASKED = 0 { name = "Not Masked"; desc = "not masked"; };
            MASKED = 1 { name = "Masked"; desc = "masked"; };
        };

        field {
            name = "intr_l_bndry_di5";
            desc = "L_bndry_di5 interrupt mask.";
            sw = rw;
            hw = r;
            encode = MIPI_INTR2_MASK_intr_l_bndry_di5_enum;
            reset = 0x0;
        } intr_l_bndry_di5[17:17];

        enum MIPI_INTR2_MASK_intr_l_bndry_di4_enum {
            NOT_MASKED = 0 { name = "Not Masked"; desc = "not masked"; };
            MASKED = 1 { name = "Masked"; desc = "masked"; };
        };

        field {
            name = "intr_l_bndry_di4";
            desc = "L_bndry_di4 interrupt mask.";
            sw = rw;
            hw = r;
            encode = MIPI_INTR2_MASK_intr_l_bndry_di4_enum;
            reset = 0x0;
        } intr_l_bndry_di4[16:16];

        enum MIPI_INTR2_MASK_intr_err_id_vc3_enum {
            ENABLE_F = 0 { name = "Enable F"; desc = "enable"; };
            MASKED = 1 { name = "Masked"; desc = "masked"; };
        };

        field {
            name = "intr_err_id_vc3";
            desc = "Err_id_vc3 interrupt mask.";
            sw = rw;
            hw = r;
            encode = MIPI_INTR2_MASK_intr_err_id_vc3_enum;
            reset = 0x0;
        } intr_err_id_vc3[15:15];

        enum MIPI_INTR2_MASK_intr_err_id_vc2_enum {
            NOT_MASKED = 0 { name = "Not Masked"; desc = "not masked"; };
            MASKED = 1 { name = "Masked"; desc = "masked"; };
        };

        field {
            name = "intr_err_id_vc2";
            desc = "Err_id_vc2 interrupt mask.";
            sw = rw;
            hw = r;
            encode = MIPI_INTR2_MASK_intr_err_id_vc2_enum;
            reset = 0x0;
        } intr_err_id_vc2[14:14];

        enum MIPI_INTR2_MASK_intr_err_id_vc1_enum {
            NOT_MASKED = 0 { name = "Not Masked"; desc = "not masked"; };
            MASKED = 1 { name = "Masked"; desc = "masked"; };
        };

        field {
            name = "intr_err_id_vc1";
            desc = "Err_id_vc1 interrupt mask.";
            sw = rw;
            hw = r;
            encode = MIPI_INTR2_MASK_intr_err_id_vc1_enum;
            reset = 0x0;
        } intr_err_id_vc1[13:13];

        enum MIPI_INTR2_MASK_intr_err_id_vc0_enum {
            NOT_MASKED = 0 { name = "Not Masked"; desc = "not masked"; };
            MASKED = 1 { name = "Masked"; desc = "masked"; };
        };

        field {
            name = "intr_err_id_vc0";
            desc = "Err_id_vc0 interrupt mask.";
            sw = rw;
            hw = r;
            encode = MIPI_INTR2_MASK_intr_err_id_vc0_enum;
            reset = 0x0;
        } intr_err_id_vc0[12:12];

        enum MIPI_INTR2_MASK_intr_vc3_ecc_corrected_enum {
            NOT_MASKED = 0 { name = "Not Masked"; desc = "not masked"; };
            MASKED = 1 { name = "Masked"; desc = "masked"; };
        };

        field {
            name = "intr_vc3_ecc_corrected";
            desc = "Vc3_ecc_corrected interrupt mask.";
            sw = rw;
            hw = r;
            encode = MIPI_INTR2_MASK_intr_vc3_ecc_corrected_enum;
            reset = 0x0;
        } intr_vc3_ecc_corrected[11:11];

        enum MIPI_INTR2_MASK_intr_vc2_ecc_corrected_enum {
            NOT_MASKED = 0 { name = "Not Masked"; desc = "not masked"; };
            MASKED = 1 { name = "Masked"; desc = "masked"; };
        };

        field {
            name = "intr_vc2_ecc_corrected";
            desc = "Vc2_ecc_corrected interrupt mask.";
            sw = rw;
            hw = r;
            encode = MIPI_INTR2_MASK_intr_vc2_ecc_corrected_enum;
            reset = 0x0;
        } intr_vc2_ecc_corrected[10:10];

        enum MIPI_INTR2_MASK_intr_vc1_ecc_corrected_enum {
            NOT_MASKED = 0 { name = "Not Masked"; desc = "not masked"; };
            MASKED = 1 { name = "Masked"; desc = "masked"; };
        };

        field {
            name = "intr_vc1_ecc_corrected";
            desc = "Vc1_ecc_corrected interrupt mask.";
            sw = rw;
            hw = r;
            encode = MIPI_INTR2_MASK_intr_vc1_ecc_corrected_enum;
            reset = 0x0;
        } intr_vc1_ecc_corrected[9:9];

        enum MIPI_INTR2_MASK_intr_vc0_ecc_corrected_enum {
            NOT_MASKED = 0 { name = "Not Masked"; desc = "not masked"; };
            MASKED = 1 { name = "Masked"; desc = "masked"; };
        };

        field {
            name = "intr_vc0_ecc_corrected";
            desc = "Vc0_ecc_corrected interrupt mask.";
            sw = rw;
            hw = r;
            encode = MIPI_INTR2_MASK_intr_vc0_ecc_corrected_enum;
            reset = 0x0;
        } intr_vc0_ecc_corrected[8:8];
    } MIPI_INTR2_MASK @ 0x104C;

    reg {
        name = "Link 0 MIPI timeout register";
        desc = "MIPI_TIMEOUT is a link 0 MIPI timeout register. Huawei Proprietary and Confidential Hi3516A/Hi3516D Professional HD IP Camera SoC

Data sheet 10.3.6 MIPI_TIMEOUT (offset 0x1060, printed page 10-308, `hi3516av100--Hi3516A-Hi3516D-Datasheet.txt` line 76037).";

        enum MIPI_TIMEOUT_timeout_en_d_enum {
            DISABLED = 0 { name = "Disabled"; desc = "disabled"; };
            ENABLED = 1 { name = "Enabled"; desc = "enabled"; };
        };

        field {
            name = "timeout_en_d";
            desc = "FSM timeout detection enable for data lanes on link 0.";
            sw = rw;
            hw = r;
            encode = MIPI_TIMEOUT_timeout_en_d_enum;
            reset = 0x0;
        } timeout_en_d[31:31];

        enum MIPI_TIMEOUT_timeout_en_ck_enum {
            DISABLED = 0 { name = "Disabled"; desc = "disabled"; };
            ENABLED = 1 { name = "Enabled"; desc = "enabled"; };
        };

        field {
            name = "timeout_en_ck";
            desc = "FSM timeout detection enable for the clock lane on link 0. When in the blanking region, the sensor's clock lane may be still in HS mode or enters the LP mode, depending on the features and configuration of the sensor. If the clock lane is still in HS mode, the clock lane timeout detection must be disabled.";
            sw = rw;
            hw = r;
            encode = MIPI_TIMEOUT_timeout_en_ck_enum;
            reset = 0x0;
        } timeout_en_ck[30:30];

        field {
            name = "timeout_param";
            desc = "FSM timeout threshold for the link 0 PHYCIL module.";
            sw = rw;
            hw = r;
            reset = 0x004CFFFF;
        } timeout_param[23:0];
    } MIPI_TIMEOUT @ 0x1060;

    reg {
        name = "Link 0 MIPI time parameter register";
        desc = "MIPI_FSM_PARAM is a link 0 MIPI time parameter register.

Data sheet 10.3.6 MIPI_FSM_PARAM (offset 0x1064, printed page 10-308, `hi3516av100--Hi3516A-Hi3516D-Datasheet.txt` line 76073).";

        field {
            name = "cyc_clk_hs0";
            desc = "FSM HS-0 status duration for the clock lane on link 0. The configured value is the actual value minus 1. 0 indicates that the status lasts for one cycle.";
            sw = rw;
            hw = r;
            reset = 0x1D;
        } cyc_clk_hs0[29:24];

        field {
            name = "cyc_clk_lp00";
            desc = "FSM LP-00 status duration for the clock lane on link 0. The configured value is the actual value minus 1. 0 indicates that the status lasts for one cycle.";
            sw = rw;
            hw = r;
            reset = 0xC;
        } cyc_clk_lp00[21:16];

        field {
            name = "cyc_data_hs_trail";
            desc = "FSM HS-TRAIL status duration for data lanes on link 0. The configured value is the actual value minus 1. 0 indicates that the status lasts for one cycle.";
            sw = rw;
            hw = r;
            reset = 0x0;
        } cyc_data_hs_trail[13:8];

        field {
            name = "cyc_data_lp00";
            desc = "FSM LP-00 status duration for data lanes on link 0. The configured value is the actual value minus 1. 0 indicates that the status lasts for one cycle.";
            sw = rw;
            hw = r;
            reset = 0xD;
        } cyc_data_lp00[5:0];
    } MIPI_FSM_PARAM @ 0x1064;

    reg {
        name = "MIPI FSM clock gating register";
        desc = "MIPI_FSM_CKEN is an MIPI FSM clock gating register.

Data sheet 10.3.6 MIPI_FSM_CKEN (offset 0x1068, printed page 10-309, `hi3516av100--Hi3516A-Hi3516D-Datasheet.txt` line 76120).";

        enum MIPI_FSM_CKEN_mipi_d3_cken_enum {
            DISABLED = 0 { name = "Disabled"; desc = "disabled"; };
            ENABLED = 1 { name = "Enabled"; desc = "enabled"; };
        };

        field {
            name = "mipi_d3_cken";
            desc = "FSM clock enable for data lane 3 on link 0.";
            sw = rw;
            hw = r;
            encode = MIPI_FSM_CKEN_mipi_d3_cken_enum;
            reset = 0x1;
        } mipi_d3_cken[7:7];

        enum MIPI_FSM_CKEN_mipi_d2_cken_enum {
            DISABLED = 0 { name = "Disabled"; desc = "disabled"; };
            ENABLED = 1 { name = "Enabled"; desc = "enabled"; };
        };

        field {
            name = "mipi_d2_cken";
            desc = "FSM clock enable for data lane 2 on link 0.";
            sw = rw;
            hw = r;
            encode = MIPI_FSM_CKEN_mipi_d2_cken_enum;
            reset = 0x1;
        } mipi_d2_cken[6:6];

        enum MIPI_FSM_CKEN_mipi_d1_cken_enum {
            DISABLED = 0 { name = "Disabled"; desc = "disabled"; };
            ENABLED = 1 { name = "Enabled"; desc = "enabled"; };
        };

        field {
            name = "mipi_d1_cken";
            desc = "FSM clock enable for data lane 1 on link 0.";
            sw = rw;
            hw = r;
            encode = MIPI_FSM_CKEN_mipi_d1_cken_enum;
            reset = 0x1;
        } mipi_d1_cken[5:5];

        enum MIPI_FSM_CKEN_mipi_d0_cken_enum {
            DISABLED = 0 { name = "Disabled"; desc = "disabled"; };
            ENABLED = 1 { name = "Enabled"; desc = "enabled"; };
        };

        field {
            name = "mipi_d0_cken";
            desc = "FSM clock enable for data lane 0 on link 0.";
            sw = rw;
            hw = r;
            encode = MIPI_FSM_CKEN_mipi_d0_cken_enum;
            reset = 0x1;
        } mipi_d0_cken[4:4];

        enum MIPI_FSM_CKEN_mipi_ck_cken_enum {
            DISABLED = 0 { name = "Disabled"; desc = "disabled"; };
            ENABLED = 1 { name = "Enabled"; desc = "enabled"; };
        };

        field {
            name = "mipi_ck_cken";
            desc = "FSM clock enable for the clock lane on link 0.";
            sw = rw;
            hw = r;
            encode = MIPI_FSM_CKEN_mipi_ck_cken_enum;
            reset = 0x1;
        } mipi_ck_cken[0:0];
    } MIPI_FSM_CKEN @ 0x1068;

    reg {
        name = "SOF synchronization code configuration _01 register for lane 0 in LVDS or HiSPI mode";
        desc = "LINK0_LANE0_SOF_01 is an SOF synchronization code configuration register for lane 0 in LVDS or HiSPI mode.

Data sheet 10.3.6 LINK0_LANE0_SOF_01 (offset 0x1080, printed page 10-310, `hi3516av100--Hi3516A-Hi3516D-Datasheet.txt` line 76172).";

        field {
            name = "lane0_sof_1";
            desc = "SOF synchronization code of frame 1 for lane 0 in LVDS or HiSPI mode. The field is configurable only in WDR mode, and the configuration is invalid in linear mode.";
            sw = rw;
            hw = r;
            reset = 0x0;
        } lane0_sof_1[31:16];

        field {
            name = "lane0_sof_0";
            desc = "SOF synchronization code of frame 0 for lane 0 in LVDS or HiSPI mode. In WDR mode, the value is the SOF of frame 0. In linear mode, the value is the SOF.";
            sw = rw;
            hw = r;
            reset = 0x0;
        } lane0_sof_0[15:0];
    } LINK0_LANE0_SOF_01 @ 0x1080;

    reg {
        name = "LINK0 LANE0 SOF 23";
        desc = "[inferred] LINK0 LANE0 SOF 23. Not in the data sheet. Source: OpenIPC openhisilicon `kernel/mipi_rx/hi3516av100/mipi_reg.h` (GPL-3.0 repository, HiSilicon copyright; local copy sources/openhisilicon), union `U_LINK_LANE_SOF_23`, struct offset 0x1084 (GPL-3.0 repository, HiSilicon copyright; byte-identical to the hi3516cv200 file). Reset value and access type unknown (modelled RW, no reset). Confidence: medium (vendor header for this chip family, not hardware verified).";

        field {
            name = "lane0_sof_3";
            desc = "[inferred] Lane0 sof 3. (vendor header `hi3516av100/mipi_reg.h` field `lane0_sof_3`; access and reset unknown, modelled RW)";
            sw = rw;
            hw = r;
        } lane0_sof_3[31:16];

        field {
            name = "lane0_sof_2";
            desc = "[inferred] Lane0 sof 2. (vendor header `hi3516av100/mipi_reg.h` field `lane0_sof_2`; access and reset unknown, modelled RW)";
            sw = rw;
            hw = r;
        } lane0_sof_2[15:0];
    } LINK0_LANE0_SOF_23 @ 0x1084;

    reg {
        name = "EOF synchronization code configuration _01 register for lane 0 in LVDS or HiSPI mode";
        desc = "LINK0_LANE0_EOF_01 is an EOF synchronization code configuration register for lane 0 in LVDS or HiSPI mode. Huawei Proprietary and Confidential Hi3516A/Hi3516D Professional HD IP Camera SoC

Data sheet 10.3.6 LINK0_LANE0_EOF_01 (offset 0x1088, printed page 10-311, `hi3516av100--Hi3516A-Hi3516D-Datasheet.txt` line 76209).";

        field {
            name = "lane0_eof_1";
            desc = "EOF synchronization code of frame 1 for lane 0 in LVDS or HiSPI mode. The field is configurable only in WDR mode, and the configuration is invalid in linear mode.";
            sw = rw;
            hw = r;
            reset = 0x0;
        } lane0_eof_1[31:16];

        field {
            name = "lane0_eof_0";
            desc = "EOF synchronization code of frame 0 for lane 0 in LVDS or HiSPI mode. In WDR mode, the value is the EOF of frame 0. In linear mode, the value is the EOF.";
            sw = rw;
            hw = r;
            reset = 0x0;
        } lane0_eof_0[15:0];
    } LINK0_LANE0_EOF_01 @ 0x1088;

    reg {
        name = "LINK0 LANE0 EOF 23";
        desc = "[inferred] LINK0 LANE0 EOF 23. Not in the data sheet. Source: OpenIPC openhisilicon `kernel/mipi_rx/hi3516av100/mipi_reg.h` (GPL-3.0 repository, HiSilicon copyright; local copy sources/openhisilicon), union `U_LINK_LANE_EOF_23`, struct offset 0x108C (GPL-3.0 repository, HiSilicon copyright; byte-identical to the hi3516cv200 file). Reset value and access type unknown (modelled RW, no reset). Confidence: medium (vendor header for this chip family, not hardware verified).";

        field {
            name = "lane0_eof_3";
            desc = "[inferred] Lane0 eof 3. (vendor header `hi3516av100/mipi_reg.h` field `lane0_eof_3`; access and reset unknown, modelled RW)";
            sw = rw;
            hw = r;
        } lane0_eof_3[31:16];

        field {
            name = "lane0_eof_2";
            desc = "[inferred] Lane0 eof 2. (vendor header `hi3516av100/mipi_reg.h` field `lane0_eof_2`; access and reset unknown, modelled RW)";
            sw = rw;
            hw = r;
        } lane0_eof_2[15:0];
    } LINK0_LANE0_EOF_23 @ 0x108C;

    reg {
        name = "SOL synchronization code configuration _01 register for lane 0 in LVDS or HiSPI mode.";
        desc = "LINK0_LANE0_SOL_01 is an SOL synchronization code configuration register for lane 0 in LVDS or HiSPI mode.

Data sheet 10.3.6 LINK0_LANE0_SOL_01 (offset 0x1090, printed page 10-311, `hi3516av100--Hi3516A-Hi3516D-Datasheet.txt` line 76237).";

        field {
            name = "lane0_sol_1";
            desc = "SOL synchronization code of frame 1 for lane 0 in LVDS or HiSPI mode. The field is configurable only in WDR mode, and the configuration is invalid in linear mode.";
            sw = rw;
            hw = r;
            reset = 0x0;
        } lane0_sol_1[31:16];

        field {
            name = "lane0_sol_0";
            desc = "SOL synchronization code of frame 0 for lane 0 in LVDS or HiSPI mode. In WDR mode, the value is the SOL of frame 0. In linear mode, the value is the SOL.";
            sw = rw;
            hw = r;
            reset = 0x0;
        } lane0_sol_0[15:0];
    } LINK0_LANE0_SOL_01 @ 0x1090;

    reg {
        name = "LINK0 LANE0 SOL 23";
        desc = "[inferred] LINK0 LANE0 SOL 23. Not in the data sheet. Source: OpenIPC openhisilicon `kernel/mipi_rx/hi3516av100/mipi_reg.h` (GPL-3.0 repository, HiSilicon copyright; local copy sources/openhisilicon), union `U_LINK_LANE_SOL_23`, struct offset 0x1094 (GPL-3.0 repository, HiSilicon copyright; byte-identical to the hi3516cv200 file). Reset value and access type unknown (modelled RW, no reset). Confidence: medium (vendor header for this chip family, not hardware verified).";

        field {
            name = "lane0_sol_3";
            desc = "[inferred] Lane0 sol 3. (vendor header `hi3516av100/mipi_reg.h` field `lane0_sol_3`; access and reset unknown, modelled RW)";
            sw = rw;
            hw = r;
        } lane0_sol_3[31:16];

        field {
            name = "lane0_sol_2";
            desc = "[inferred] Lane0 sol 2. (vendor header `hi3516av100/mipi_reg.h` field `lane0_sol_2`; access and reset unknown, modelled RW)";
            sw = rw;
            hw = r;
        } lane0_sol_2[15:0];
    } LINK0_LANE0_SOL_23 @ 0x1094;

    reg {
        name = "EOL synchronization code configuration L_01 register for lane 0 in LVDS or HiSPI mode";
        desc = "LINK0_LANE0_EOL_01 is an EOL synchronization code configuration register for lane 0 in LVDS or HiSPI mode. Huawei Proprietary and Confidential Hi3516A/Hi3516D Professional HD IP Camera SoC

Data sheet 10.3.6 LINK0_LANE0_EOL_01 (offset 0x1098, printed page 10-312, `hi3516av100--Hi3516A-Hi3516D-Datasheet.txt` line 76273).";

        field {
            name = "lane0_eol_1";
            desc = "EOL synchronization code of frame 1 for lane 0 in LVDS or HiSPI mode. The field is configurable only in WDR mode, and the configuration is invalid in linear mode.";
            sw = rw;
            hw = r;
            reset = 0x0;
        } lane0_eol_1[31:16];

        field {
            name = "lane0_eol_0";
            desc = "EOL synchronization code of frame 0 for lane 0 in LVDS or HiSPI mode. In WDR mode, the value is the EOL of frame 0. In linear mode, the value is the EOL.";
            sw = rw;
            hw = r;
            reset = 0x0;
        } lane0_eol_0[15:0];
    } LINK0_LANE0_EOL_01 @ 0x1098;

    reg {
        name = "LINK0 LANE0 EOL 23";
        desc = "[inferred] LINK0 LANE0 EOL 23. Not in the data sheet. Source: OpenIPC openhisilicon `kernel/mipi_rx/hi3516av100/mipi_reg.h` (GPL-3.0 repository, HiSilicon copyright; local copy sources/openhisilicon), union `U_LINK_LANE_EOL_23`, struct offset 0x109C (GPL-3.0 repository, HiSilicon copyright; byte-identical to the hi3516cv200 file). Reset value and access type unknown (modelled RW, no reset). Confidence: medium (vendor header for this chip family, not hardware verified).";

        field {
            name = "lane0_eol_3";
            desc = "[inferred] Lane0 eol 3. (vendor header `hi3516av100/mipi_reg.h` field `lane0_eol_3`; access and reset unknown, modelled RW)";
            sw = rw;
            hw = r;
        } lane0_eol_3[31:16];

        field {
            name = "lane0_eol_2";
            desc = "[inferred] Lane0 eol 2. (vendor header `hi3516av100/mipi_reg.h` field `lane0_eol_2`; access and reset unknown, modelled RW)";
            sw = rw;
            hw = r;
        } lane0_eol_2[15:0];
    } LINK0_LANE0_EOL_23 @ 0x109C;

    reg {
        name = "SOF synchronization code configuration _01 register for lane 1 in LVDS or HiSPI mode";
        desc = "LINK0_LANE1_SOF_01 is an SOF synchronization code configuration register for lane 1 in LVDS or HiSPI mode.

Data sheet 10.3.6 LINK0_LANE1_SOF_01 (offset 0x10A0, printed page 10-312, `hi3516av100--Hi3516A-Hi3516D-Datasheet.txt` line 76301).";

        field {
            name = "lane1_sof_1";
            desc = "SOF synchronization code of frame 1 for lane 1 in LVDS or HiSPI mode. The field is configurable only in WDR mode, and the configuration is invalid in linear mode.";
            sw = rw;
            hw = r;
            reset = 0x0;
        } lane1_sof_1[31:16];

        field {
            name = "lane1_sof_0";
            desc = "SOF synchronization code of frame 0 for lane 1 in LVDS or HiSPI mode. In WDR mode, the value is the SOF of frame 0. In linear mode, the value is the SOF.";
            sw = rw;
            hw = r;
            reset = 0x0;
        } lane1_sof_0[15:0];
    } LINK0_LANE1_SOF_01 @ 0x10A0;

    reg {
        name = "LINK0 LANE1 SOF 23";
        desc = "[inferred] LINK0 LANE1 SOF 23. Not in the data sheet. Source: OpenIPC openhisilicon `kernel/mipi_rx/hi3516av100/mipi_reg.h` (GPL-3.0 repository, HiSilicon copyright; local copy sources/openhisilicon), union `U_LINK_LANE_SOF_23`, struct offset 0x10A4 (GPL-3.0 repository, HiSilicon copyright; byte-identical to the hi3516cv200 file). Reset value and access type unknown (modelled RW, no reset). Confidence: medium (vendor header for this chip family, not hardware verified).";

        field {
            name = "lane0_sof_3";
            desc = "[inferred] Lane0 sof 3. (vendor header `hi3516av100/mipi_reg.h` field `lane0_sof_3`; access and reset unknown, modelled RW)";
            sw = rw;
            hw = r;
        } lane0_sof_3[31:16];

        field {
            name = "lane0_sof_2";
            desc = "[inferred] Lane0 sof 2. (vendor header `hi3516av100/mipi_reg.h` field `lane0_sof_2`; access and reset unknown, modelled RW)";
            sw = rw;
            hw = r;
        } lane0_sof_2[15:0];
    } LINK0_LANE1_SOF_23 @ 0x10A4;

    reg {
        name = "EOF synchronization code configuration _01 register for lane 1 in LVDS or HiSPI mode";
        desc = "LINK0_LANE1_EOF_01 is an EOF synchronization code configuration register for lane 1 in LVDS or HiSPI mode. Huawei Proprietary and Confidential Hi3516A/Hi3516D Professional HD IP Camera SoC

Data sheet 10.3.6 LINK0_LANE1_EOF_01 (offset 0x10A8, printed page 10-313, `hi3516av100--Hi3516A-Hi3516D-Datasheet.txt` line 76337).";

        field {
            name = "lane1_eof_1";
            desc = "EOF synchronization code of frame 1 for lane 1 in LVDS or HiSPI mode. The field is configurable only in WDR mode, and the configuration is invalid in linear mode.";
            sw = rw;
            hw = r;
            reset = 0x0;
        } lane1_eof_1[31:16];

        field {
            name = "lane1_eof_0";
            desc = "EOF synchronization code of frame 0 for lane 1 in LVDS or HiSPI mode. In WDR mode, the value is the EOF of frame 0. In linear mode, the value is the EOF.";
            sw = rw;
            hw = r;
            reset = 0x0;
        } lane1_eof_0[15:0];
    } LINK0_LANE1_EOF_01 @ 0x10A8;

    reg {
        name = "LINK0 LANE1 EOF 23";
        desc = "[inferred] LINK0 LANE1 EOF 23. Not in the data sheet. Source: OpenIPC openhisilicon `kernel/mipi_rx/hi3516av100/mipi_reg.h` (GPL-3.0 repository, HiSilicon copyright; local copy sources/openhisilicon), union `U_LINK_LANE_EOF_23`, struct offset 0x10AC (GPL-3.0 repository, HiSilicon copyright; byte-identical to the hi3516cv200 file). Reset value and access type unknown (modelled RW, no reset). Confidence: medium (vendor header for this chip family, not hardware verified).";

        field {
            name = "lane0_eof_3";
            desc = "[inferred] Lane0 eof 3. (vendor header `hi3516av100/mipi_reg.h` field `lane0_eof_3`; access and reset unknown, modelled RW)";
            sw = rw;
            hw = r;
        } lane0_eof_3[31:16];

        field {
            name = "lane0_eof_2";
            desc = "[inferred] Lane0 eof 2. (vendor header `hi3516av100/mipi_reg.h` field `lane0_eof_2`; access and reset unknown, modelled RW)";
            sw = rw;
            hw = r;
        } lane0_eof_2[15:0];
    } LINK0_LANE1_EOF_23 @ 0x10AC;

    reg {
        name = "SOL synchronization code configuration _01 register for lane 1 in LVDS or HiSPI mode.";
        desc = "LINK0_LANE1_SOL_01 is an SOL synchronization code configuration register for lane 1 in LVDS or HiSPI mode.

Data sheet 10.3.6 LINK0_LANE1_SOL_01 (offset 0x10B0, printed page 10-313, `hi3516av100--Hi3516A-Hi3516D-Datasheet.txt` line 76365).";

        field {
            name = "lane1_sol_1";
            desc = "SOL synchronization code of frame 1 for lane 1 in LVDS or HiSPI mode. The field is configurable only in WDR mode, and the configuration is invalid in linear mode.";
            sw = rw;
            hw = r;
            reset = 0x0;
        } lane1_sol_1[31:16];

        field {
            name = "lane1_sol_0";
            desc = "SOL synchronization code of frame 0 for lane 1 in LVDS or HiSPI mode. In WDR mode, the value is the SOL of frame 0. In linear mode, the value is the SOL.";
            sw = rw;
            hw = r;
            reset = 0x0;
        } lane1_sol_0[15:0];
    } LINK0_LANE1_SOL_01 @ 0x10B0;

    reg {
        name = "LINK0 LANE1 SOL 23";
        desc = "[inferred] LINK0 LANE1 SOL 23. Not in the data sheet. Source: OpenIPC openhisilicon `kernel/mipi_rx/hi3516av100/mipi_reg.h` (GPL-3.0 repository, HiSilicon copyright; local copy sources/openhisilicon), union `U_LINK_LANE_SOL_23`, struct offset 0x10B4 (GPL-3.0 repository, HiSilicon copyright; byte-identical to the hi3516cv200 file). Reset value and access type unknown (modelled RW, no reset). Confidence: medium (vendor header for this chip family, not hardware verified).";

        field {
            name = "lane0_sol_3";
            desc = "[inferred] Lane0 sol 3. (vendor header `hi3516av100/mipi_reg.h` field `lane0_sol_3`; access and reset unknown, modelled RW)";
            sw = rw;
            hw = r;
        } lane0_sol_3[31:16];

        field {
            name = "lane0_sol_2";
            desc = "[inferred] Lane0 sol 2. (vendor header `hi3516av100/mipi_reg.h` field `lane0_sol_2`; access and reset unknown, modelled RW)";
            sw = rw;
            hw = r;
        } lane0_sol_2[15:0];
    } LINK0_LANE1_SOL_23 @ 0x10B4;

    reg {
        name = "EOL synchronization code configuration L_01 register for lane 1 in LVDS or HiSPI mode";
        desc = "LINK0_LANE1_EOL_01 is an EOL synchronization code configuration register for lane 1 in LVDS or HiSPI mode. Huawei Proprietary and Confidential Hi3516A/Hi3516D Professional HD IP Camera SoC

Data sheet 10.3.6 LINK0_LANE1_EOL_01 (offset 0x10B8, printed page 10-314, `hi3516av100--Hi3516A-Hi3516D-Datasheet.txt` line 76401).";

        field {
            name = "lane1_eol_1";
            desc = "EOL synchronization code of frame 1 for lane 1 in LVDS or HiSPI mode. The field is configurable only in WDR mode, and the configuration is invalid in linear mode.";
            sw = rw;
            hw = r;
            reset = 0x0;
        } lane1_eol_1[31:16];

        field {
            name = "lane1_eol_0";
            desc = "EOL synchronization code of frame 0 for lane 1 in LVDS or HiSPI mode. In WDR mode, the value is the EOL of frame 0. In linear mode, the value is the EOL.";
            sw = rw;
            hw = r;
            reset = 0x0;
        } lane1_eol_0[15:0];
    } LINK0_LANE1_EOL_01 @ 0x10B8;

    reg {
        name = "LINK0 LANE1 EOL 23";
        desc = "[inferred] LINK0 LANE1 EOL 23. Not in the data sheet. Source: OpenIPC openhisilicon `kernel/mipi_rx/hi3516av100/mipi_reg.h` (GPL-3.0 repository, HiSilicon copyright; local copy sources/openhisilicon), union `U_LINK_LANE_EOL_23`, struct offset 0x10BC (GPL-3.0 repository, HiSilicon copyright; byte-identical to the hi3516cv200 file). Reset value and access type unknown (modelled RW, no reset). Confidence: medium (vendor header for this chip family, not hardware verified).";

        field {
            name = "lane0_eol_3";
            desc = "[inferred] Lane0 eol 3. (vendor header `hi3516av100/mipi_reg.h` field `lane0_eol_3`; access and reset unknown, modelled RW)";
            sw = rw;
            hw = r;
        } lane0_eol_3[31:16];

        field {
            name = "lane0_eol_2";
            desc = "[inferred] Lane0 eol 2. (vendor header `hi3516av100/mipi_reg.h` field `lane0_eol_2`; access and reset unknown, modelled RW)";
            sw = rw;
            hw = r;
        } lane0_eol_2[15:0];
    } LINK0_LANE1_EOL_23 @ 0x10BC;

    reg {
        name = "SOF synchronization code configuration _01 register for lane 2 in LVDS or HiSPI mode";
        desc = "LINK0_LANE2_SOF_01 is an SOF synchronization code configuration register for lane 2 in LVDS or HiSPI mode.

Data sheet 10.3.6 LINK0_LANE2_SOF_01 (offset 0x10C0, printed page 10-314, `hi3516av100--Hi3516A-Hi3516D-Datasheet.txt` line 76429).";

        field {
            name = "lane2_sof_1";
            desc = "SOF synchronization code of frame 1 for lane 2 in LVDS or HiSPI mode. The field is configurable only in WDR mode, and the configuration is invalid in linear mode.";
            sw = rw;
            hw = r;
            reset = 0x0;
        } lane2_sof_1[31:16];

        field {
            name = "lane2_sof_0";
            desc = "SOF synchronization code of frame 0 for lane 2 in LVDS or HiSPI mode. In WDR mode, the value is the SOF of frame 0. In linear mode, the value is the SOF.";
            sw = rw;
            hw = r;
            reset = 0x0;
        } lane2_sof_0[15:0];
    } LINK0_LANE2_SOF_01 @ 0x10C0;

    reg {
        name = "LINK0 LANE2 SOF 23";
        desc = "[inferred] LINK0 LANE2 SOF 23. Not in the data sheet. Source: OpenIPC openhisilicon `kernel/mipi_rx/hi3516av100/mipi_reg.h` (GPL-3.0 repository, HiSilicon copyright; local copy sources/openhisilicon), union `U_LINK_LANE_SOF_23`, struct offset 0x10C4 (GPL-3.0 repository, HiSilicon copyright; byte-identical to the hi3516cv200 file). Reset value and access type unknown (modelled RW, no reset). Confidence: medium (vendor header for this chip family, not hardware verified).";

        field {
            name = "lane0_sof_3";
            desc = "[inferred] Lane0 sof 3. (vendor header `hi3516av100/mipi_reg.h` field `lane0_sof_3`; access and reset unknown, modelled RW)";
            sw = rw;
            hw = r;
        } lane0_sof_3[31:16];

        field {
            name = "lane0_sof_2";
            desc = "[inferred] Lane0 sof 2. (vendor header `hi3516av100/mipi_reg.h` field `lane0_sof_2`; access and reset unknown, modelled RW)";
            sw = rw;
            hw = r;
        } lane0_sof_2[15:0];
    } LINK0_LANE2_SOF_23 @ 0x10C4;

    reg {
        name = "EOF synchronization code configuration _01 register for lane 2 in LVDS or HiSPI mode";
        desc = "LINK0_LANE2_EOF_01 is an EOF synchronization code configuration register for lane 2 in LVDS or HiSPI mode. Huawei Proprietary and Confidential Hi3516A/Hi3516D Professional HD IP Camera SoC

Data sheet 10.3.6 LINK0_LANE2_EOF_01 (offset 0x10C8, printed page 10-315, `hi3516av100--Hi3516A-Hi3516D-Datasheet.txt` line 76465).";

        field {
            name = "lane2_eof_1";
            desc = "EOF synchronization code of frame 1 for lane 2 in LVDS or HiSPI mode. The field is configurable only in WDR mode, and the configuration is invalid in linear mode.";
            sw = rw;
            hw = r;
            reset = 0x0;
        } lane2_eof_1[31:16];

        field {
            name = "lane2_eof_0";
            desc = "EOF synchronization code of frame 0 for lane 2 in LVDS or HiSPI mode. In WDR mode, the value is the EOF of frame 0. In linear mode, the value is the EOF.";
            sw = rw;
            hw = r;
            reset = 0x0;
        } lane2_eof_0[15:0];
    } LINK0_LANE2_EOF_01 @ 0x10C8;

    reg {
        name = "LINK0 LANE2 EOF 23";
        desc = "[inferred] LINK0 LANE2 EOF 23. Not in the data sheet. Source: OpenIPC openhisilicon `kernel/mipi_rx/hi3516av100/mipi_reg.h` (GPL-3.0 repository, HiSilicon copyright; local copy sources/openhisilicon), union `U_LINK_LANE_EOF_23`, struct offset 0x10CC (GPL-3.0 repository, HiSilicon copyright; byte-identical to the hi3516cv200 file). Reset value and access type unknown (modelled RW, no reset). Confidence: medium (vendor header for this chip family, not hardware verified).";

        field {
            name = "lane0_eof_3";
            desc = "[inferred] Lane0 eof 3. (vendor header `hi3516av100/mipi_reg.h` field `lane0_eof_3`; access and reset unknown, modelled RW)";
            sw = rw;
            hw = r;
        } lane0_eof_3[31:16];

        field {
            name = "lane0_eof_2";
            desc = "[inferred] Lane0 eof 2. (vendor header `hi3516av100/mipi_reg.h` field `lane0_eof_2`; access and reset unknown, modelled RW)";
            sw = rw;
            hw = r;
        } lane0_eof_2[15:0];
    } LINK0_LANE2_EOF_23 @ 0x10CC;

    reg {
        name = "SOL synchronization code configuration _01 register for lane 2 in LVDS or HiSPI mode.";
        desc = "LINK0_LANE2_SOL_01 is an SOL synchronization code configuration register for lane 2 in LVDS or HiSPI mode.

Data sheet 10.3.6 LINK0_LANE2_SOL_01 (offset 0x10D0, printed page 10-315, `hi3516av100--Hi3516A-Hi3516D-Datasheet.txt` line 76493).";

        field {
            name = "lane2_sol_1";
            desc = "SOL synchronization code of frame 1 for lane 2 in LVDS or HiSPI mode. The field is configurable only in WDR mode, and the configuration is invalid in linear mode.";
            sw = rw;
            hw = r;
            reset = 0x0;
        } lane2_sol_1[31:16];

        field {
            name = "lane2_sol_0";
            desc = "SOL synchronization code of frame 0 for lane 2 in LVDS or HiSPI mode. In WDR mode, the value is the SOL of frame 0. In linear mode, the value is the SOL.";
            sw = rw;
            hw = r;
            reset = 0x0;
        } lane2_sol_0[15:0];
    } LINK0_LANE2_SOL_01 @ 0x10D0;

    reg {
        name = "LINK0 LANE2 SOL 23";
        desc = "[inferred] LINK0 LANE2 SOL 23. Not in the data sheet. Source: OpenIPC openhisilicon `kernel/mipi_rx/hi3516av100/mipi_reg.h` (GPL-3.0 repository, HiSilicon copyright; local copy sources/openhisilicon), union `U_LINK_LANE_SOL_23`, struct offset 0x10D4 (GPL-3.0 repository, HiSilicon copyright; byte-identical to the hi3516cv200 file). Reset value and access type unknown (modelled RW, no reset). Confidence: medium (vendor header for this chip family, not hardware verified).";

        field {
            name = "lane0_sol_3";
            desc = "[inferred] Lane0 sol 3. (vendor header `hi3516av100/mipi_reg.h` field `lane0_sol_3`; access and reset unknown, modelled RW)";
            sw = rw;
            hw = r;
        } lane0_sol_3[31:16];

        field {
            name = "lane0_sol_2";
            desc = "[inferred] Lane0 sol 2. (vendor header `hi3516av100/mipi_reg.h` field `lane0_sol_2`; access and reset unknown, modelled RW)";
            sw = rw;
            hw = r;
        } lane0_sol_2[15:0];
    } LINK0_LANE2_SOL_23 @ 0x10D4;

    reg {
        name = "EOL synchronization code configuration L_01 register for lane 2 in LVDS or HiSPI mode";
        desc = "LINK0_LANE2_EOL_01 is an EOL synchronization code configuration register for lane 2 in LVDS or HiSPI mode. Huawei Proprietary and Confidential Hi3516A/Hi3516D Professional HD IP Camera SoC

Data sheet 10.3.6 LINK0_LANE2_EOL_01 (offset 0x10D8, printed page 10-316, `hi3516av100--Hi3516A-Hi3516D-Datasheet.txt` line 76529).";

        field {
            name = "lane2_eol_1";
            desc = "EOL synchronization code of frame 1 for lane 2 in LVDS or HiSPI mode. The field is configurable only in WDR mode, and the configuration is invalid in linear mode.";
            sw = rw;
            hw = r;
            reset = 0x0;
        } lane2_eol_1[31:16];

        field {
            name = "lane2_eol_0";
            desc = "EOL synchronization code of frame 0 for lane 2 in LVDS or HiSPI mode. In WDR mode, the value is the EOL of frame 0. In linear mode, the value is the EOL.";
            sw = rw;
            hw = r;
            reset = 0x0;
        } lane2_eol_0[15:0];
    } LINK0_LANE2_EOL_01 @ 0x10D8;

    reg {
        name = "LINK0 LANE2 EOL 23";
        desc = "[inferred] LINK0 LANE2 EOL 23. Not in the data sheet. Source: OpenIPC openhisilicon `kernel/mipi_rx/hi3516av100/mipi_reg.h` (GPL-3.0 repository, HiSilicon copyright; local copy sources/openhisilicon), union `U_LINK_LANE_EOL_23`, struct offset 0x10DC (GPL-3.0 repository, HiSilicon copyright; byte-identical to the hi3516cv200 file). Reset value and access type unknown (modelled RW, no reset). Confidence: medium (vendor header for this chip family, not hardware verified).";

        field {
            name = "lane0_eol_3";
            desc = "[inferred] Lane0 eol 3. (vendor header `hi3516av100/mipi_reg.h` field `lane0_eol_3`; access and reset unknown, modelled RW)";
            sw = rw;
            hw = r;
        } lane0_eol_3[31:16];

        field {
            name = "lane0_eol_2";
            desc = "[inferred] Lane0 eol 2. (vendor header `hi3516av100/mipi_reg.h` field `lane0_eol_2`; access and reset unknown, modelled RW)";
            sw = rw;
            hw = r;
        } lane0_eol_2[15:0];
    } LINK0_LANE2_EOL_23 @ 0x10DC;

    reg {
        name = "SOF synchronization code configuration _01 register for lane 3 in LVDS or HiSPI mode";
        desc = "LINK0_LANE3_SOF_01 is an SOF synchronization code configuration register for lane 3 in LVDS or HiSPI mode.

Data sheet 10.3.6 LINK0_LANE3_SOF_01 (offset 0x10E0, printed page 10-316, `hi3516av100--Hi3516A-Hi3516D-Datasheet.txt` line 76557).";

        field {
            name = "lane3_sof_1";
            desc = "SOF synchronization code of frame 1 for lane 3 in LVDS or HiSPI mode. The field is configurable only in WDR mode, and the configuration is invalid in linear mode.";
            sw = rw;
            hw = r;
            reset = 0x0;
        } lane3_sof_1[31:16];

        field {
            name = "lane3_sof_0";
            desc = "SOF synchronization code of frame 0 for lane 3 in LVDS or HiSPI mode. In WDR mode, the value is the SOF of frame 0. In linear mode, the value is the SOF.";
            sw = rw;
            hw = r;
            reset = 0x0;
        } lane3_sof_0[15:0];
    } LINK0_LANE3_SOF_01 @ 0x10E0;

    reg {
        name = "LINK0 LANE3 SOF 23";
        desc = "[inferred] LINK0 LANE3 SOF 23. Not in the data sheet. Source: OpenIPC openhisilicon `kernel/mipi_rx/hi3516av100/mipi_reg.h` (GPL-3.0 repository, HiSilicon copyright; local copy sources/openhisilicon), union `U_LINK_LANE_SOF_23`, struct offset 0x10E4 (GPL-3.0 repository, HiSilicon copyright; byte-identical to the hi3516cv200 file). Reset value and access type unknown (modelled RW, no reset). Confidence: medium (vendor header for this chip family, not hardware verified).";

        field {
            name = "lane0_sof_3";
            desc = "[inferred] Lane0 sof 3. (vendor header `hi3516av100/mipi_reg.h` field `lane0_sof_3`; access and reset unknown, modelled RW)";
            sw = rw;
            hw = r;
        } lane0_sof_3[31:16];

        field {
            name = "lane0_sof_2";
            desc = "[inferred] Lane0 sof 2. (vendor header `hi3516av100/mipi_reg.h` field `lane0_sof_2`; access and reset unknown, modelled RW)";
            sw = rw;
            hw = r;
        } lane0_sof_2[15:0];
    } LINK0_LANE3_SOF_23 @ 0x10E4;

    reg {
        name = "EOF synchronization code configuration _01 register for lane 3 in LVDS or HiSPI mode";
        desc = "LINK0_LANE3_EOF_01 is an EOF synchronization code configuration register for lane 3 in LVDS or HiSPI mode. Huawei Proprietary and Confidential Hi3516A/Hi3516D Professional HD IP Camera SoC

Data sheet 10.3.6 LINK0_LANE3_EOF_01 (offset 0x10E8, printed page 10-317, `hi3516av100--Hi3516A-Hi3516D-Datasheet.txt` line 76593).";

        field {
            name = "lane3_eof_1";
            desc = "EOF synchronization code of frame 1 for lane 3 in LVDS or HiSPI mode. The field is configurable only in WDR mode, and the configuration is invalid in linear mode.";
            sw = rw;
            hw = r;
            reset = 0x0;
        } lane3_eof_1[31:16];

        field {
            name = "lane3_eof_0";
            desc = "EOF synchronization code of frame 0 for lane 3 in LVDS or HiSPI mode. In WDR mode, the value is the EOF of frame 0. In linear mode, the value is the EOF.";
            sw = rw;
            hw = r;
            reset = 0x0;
        } lane3_eof_0[15:0];
    } LINK0_LANE3_EOF_01 @ 0x10E8;

    reg {
        name = "LINK0 LANE3 EOF 23";
        desc = "[inferred] LINK0 LANE3 EOF 23. Not in the data sheet. Source: OpenIPC openhisilicon `kernel/mipi_rx/hi3516av100/mipi_reg.h` (GPL-3.0 repository, HiSilicon copyright; local copy sources/openhisilicon), union `U_LINK_LANE_EOF_23`, struct offset 0x10EC (GPL-3.0 repository, HiSilicon copyright; byte-identical to the hi3516cv200 file). Reset value and access type unknown (modelled RW, no reset). Confidence: medium (vendor header for this chip family, not hardware verified).";

        field {
            name = "lane0_eof_3";
            desc = "[inferred] Lane0 eof 3. (vendor header `hi3516av100/mipi_reg.h` field `lane0_eof_3`; access and reset unknown, modelled RW)";
            sw = rw;
            hw = r;
        } lane0_eof_3[31:16];

        field {
            name = "lane0_eof_2";
            desc = "[inferred] Lane0 eof 2. (vendor header `hi3516av100/mipi_reg.h` field `lane0_eof_2`; access and reset unknown, modelled RW)";
            sw = rw;
            hw = r;
        } lane0_eof_2[15:0];
    } LINK0_LANE3_EOF_23 @ 0x10EC;

    reg {
        name = "SOL synchronization code configuration _01 register for lane 3 in LVDS or HiSPI mode.";
        desc = "LINK0_LANE3_SOL_01 is an SOL synchronization code configuration register for lane 3 in LVDS or HiSPI mode.

Data sheet 10.3.6 LINK0_LANE3_SOL_01 (offset 0x10F0, printed page 10-317, `hi3516av100--Hi3516A-Hi3516D-Datasheet.txt` line 76621).";

        field {
            name = "lane3_sol_1";
            desc = "SOL synchronization code of frame 1 for lane 3 in LVDS or HiSPI mode. The field is configurable only in WDR mode, and the configuration is invalid in linear mode.";
            sw = rw;
            hw = r;
            reset = 0x0;
        } lane3_sol_1[31:16];

        field {
            name = "lane3_sol_0";
            desc = "SOL synchronization code of frame 0 for lane 3 in LVDS or HiSPI mode. In WDR mode, the value is the SOL of frame 0. In linear mode, the value is the SOL.";
            sw = rw;
            hw = r;
            reset = 0x0;
        } lane3_sol_0[15:0];
    } LINK0_LANE3_SOL_01 @ 0x10F0;

    reg {
        name = "LINK0 LANE3 SOL 23";
        desc = "[inferred] LINK0 LANE3 SOL 23. Not in the data sheet. Source: OpenIPC openhisilicon `kernel/mipi_rx/hi3516av100/mipi_reg.h` (GPL-3.0 repository, HiSilicon copyright; local copy sources/openhisilicon), union `U_LINK_LANE_SOL_23`, struct offset 0x10F4 (GPL-3.0 repository, HiSilicon copyright; byte-identical to the hi3516cv200 file). Reset value and access type unknown (modelled RW, no reset). Confidence: medium (vendor header for this chip family, not hardware verified).";

        field {
            name = "lane0_sol_3";
            desc = "[inferred] Lane0 sol 3. (vendor header `hi3516av100/mipi_reg.h` field `lane0_sol_3`; access and reset unknown, modelled RW)";
            sw = rw;
            hw = r;
        } lane0_sol_3[31:16];

        field {
            name = "lane0_sol_2";
            desc = "[inferred] Lane0 sol 2. (vendor header `hi3516av100/mipi_reg.h` field `lane0_sol_2`; access and reset unknown, modelled RW)";
            sw = rw;
            hw = r;
        } lane0_sol_2[15:0];
    } LINK0_LANE3_SOL_23 @ 0x10F4;

    reg {
        name = "EOL synchronization code configuration L_01 register for lane 3 in LVDS or HiSPI mode";
        desc = "LINK0_LANE3_EOL_01 is an EOL synchronization code configuration register for lane 3 in LVDS or HiSPI mode. Huawei Proprietary and Confidential Hi3516A/Hi3516D Professional HD IP Camera SoC

Data sheet 10.3.6 LINK0_LANE3_EOL_01 (offset 0x10F8, printed page 10-318, `hi3516av100--Hi3516A-Hi3516D-Datasheet.txt` line 76657).";

        field {
            name = "lane3_eol_1";
            desc = "EOL synchronization code of frame 1 for lane 3 in LVDS or HiSPI mode. The field is configurable only in WDR mode, and the configuration is invalid in linear mode.";
            sw = rw;
            hw = r;
            reset = 0x0;
        } lane3_eol_1[31:16];

        field {
            name = "lane3_eol_0";
            desc = "EOL synchronization code of frame 0 for lane 3 in LVDS or HiSPI mode. In WDR mode, the value is the EOL of frame 0. In linear mode, the value is the EOL.";
            sw = rw;
            hw = r;
            reset = 0x0;
        } lane3_eol_0[15:0];
    } LINK0_LANE3_EOL_01 @ 0x10F8;

    reg {
        name = "LINK0 LANE3 EOL 23";
        desc = "[inferred] LINK0 LANE3 EOL 23. Not in the data sheet. Source: OpenIPC openhisilicon `kernel/mipi_rx/hi3516av100/mipi_reg.h` (GPL-3.0 repository, HiSilicon copyright; local copy sources/openhisilicon), union `U_LINK_LANE_EOL_23`, struct offset 0x10FC (GPL-3.0 repository, HiSilicon copyright; byte-identical to the hi3516cv200 file). Reset value and access type unknown (modelled RW, no reset). Confidence: medium (vendor header for this chip family, not hardware verified).";

        field {
            name = "lane0_eol_3";
            desc = "[inferred] Lane0 eol 3. (vendor header `hi3516av100/mipi_reg.h` field `lane0_eol_3`; access and reset unknown, modelled RW)";
            sw = rw;
            hw = r;
        } lane0_eol_3[31:16];

        field {
            name = "lane0_eol_2";
            desc = "[inferred] Lane0 eol 2. (vendor header `hi3516av100/mipi_reg.h` field `lane0_eol_2`; access and reset unknown, modelled RW)";
            sw = rw;
            hw = r;
        } lane0_eol_2[15:0];
    } LINK0_LANE3_EOL_23 @ 0x10FC;

    reg {
        name = "DATA PHY LINK0";
        desc = "[inferred] DATA PHY LINK0. Not in the data sheet. Source: OpenIPC openhisilicon `kernel/mipi_rx/hi3516av100/mipi_reg.h` (GPL-3.0 repository, HiSilicon copyright; local copy sources/openhisilicon), union `U_DATA_PHY_LINK`, struct offset 0x1200 (GPL-3.0 repository, HiSilicon copyright; byte-identical to the hi3516cv200 file). Reset value and access type unknown (modelled RW, no reset). Confidence: medium (vendor header for this chip family, not hardware verified).";

        field {
            name = "data3_phy";
            desc = "[inferred] Data3 PHY. (vendor header `hi3516av100/mipi_reg.h` field `data3_phy`; access and reset unknown, modelled RW)";
            sw = rw;
            hw = r;
        } data3_phy[31:24];

        field {
            name = "data2_phy";
            desc = "[inferred] Data2 PHY. (vendor header `hi3516av100/mipi_reg.h` field `data2_phy`; access and reset unknown, modelled RW)";
            sw = rw;
            hw = r;
        } data2_phy[23:16];

        field {
            name = "data1_phy";
            desc = "[inferred] Data1 PHY. (vendor header `hi3516av100/mipi_reg.h` field `data1_phy`; access and reset unknown, modelled RW)";
            sw = rw;
            hw = r;
        } data1_phy[15:8];

        field {
            name = "data0_phy";
            desc = "[inferred] Data0 PHY. (vendor header `hi3516av100/mipi_reg.h` field `data0_phy`; access and reset unknown, modelled RW)";
            sw = rw;
            hw = r;
        } data0_phy[7:0];
    } DATA_PHY_LINK0 @ 0x1200;

    reg {
        name = "DATA CHN LINK0";
        desc = "[inferred] DATA CHN LINK0. Not in the data sheet. Source: OpenIPC openhisilicon `kernel/mipi_rx/hi3516av100/mipi_reg.h` (GPL-3.0 repository, HiSilicon copyright; local copy sources/openhisilicon), union `U_DATA_CHN_LINK`, struct offset 0x1204 (GPL-3.0 repository, HiSilicon copyright; byte-identical to the hi3516cv200 file). Reset value and access type unknown (modelled RW, no reset). Confidence: medium (vendor header for this chip family, not hardware verified).";

        field {
            name = "data3_chn";
            desc = "[inferred] Data3 chn. (vendor header `hi3516av100/mipi_reg.h` field `data3_chn`; access and reset unknown, modelled RW)";
            sw = rw;
            hw = r;
        } data3_chn[31:24];

        field {
            name = "data2_chn";
            desc = "[inferred] Data2 chn. (vendor header `hi3516av100/mipi_reg.h` field `data2_chn`; access and reset unknown, modelled RW)";
            sw = rw;
            hw = r;
        } data2_chn[23:16];

        field {
            name = "data1_chn";
            desc = "[inferred] Data1 chn. (vendor header `hi3516av100/mipi_reg.h` field `data1_chn`; access and reset unknown, modelled RW)";
            sw = rw;
            hw = r;
        } data1_chn[15:8];

        field {
            name = "data0_chn";
            desc = "[inferred] Data0 chn. (vendor header `hi3516av100/mipi_reg.h` field `data0_chn`; access and reset unknown, modelled RW)";
            sw = rw;
            hw = r;
        } data0_chn[7:0];
    } DATA_CHN_LINK0 @ 0x1204;

    reg {
        name = "MIPI FSMST DATA LINK0";
        desc = "[inferred] MIPI FSMST DATA LINK0. Not in the data sheet. Source: OpenIPC openhisilicon `kernel/mipi_rx/hi3516av100/mipi_reg.h` (GPL-3.0 repository, HiSilicon copyright; local copy sources/openhisilicon), union `U_MIPI_FSMST_DATA_LINK`, struct offset 0x1208 (GPL-3.0 repository, HiSilicon copyright; byte-identical to the hi3516cv200 file). Reset value and access type unknown (modelled RW, no reset). Confidence: medium (vendor header for this chip family, not hardware verified).";

        field {
            name = "nxt_st_d3";
            desc = "[inferred] Nxt st d3. (vendor header `hi3516av100/mipi_reg.h` field `nxt_st_d3`; access and reset unknown, modelled RW)";
            sw = rw;
            hw = r;
        } nxt_st_d3[31:28];

        field {
            name = "cur_st_d3";
            desc = "[inferred] Cur st d3. (vendor header `hi3516av100/mipi_reg.h` field `cur_st_d3`; access and reset unknown, modelled RW)";
            sw = rw;
            hw = r;
        } cur_st_d3[27:24];

        field {
            name = "nxt_st_d2";
            desc = "[inferred] Nxt st d2. (vendor header `hi3516av100/mipi_reg.h` field `nxt_st_d2`; access and reset unknown, modelled RW)";
            sw = rw;
            hw = r;
        } nxt_st_d2[23:20];

        field {
            name = "cur_st_d2";
            desc = "[inferred] Cur st d2. (vendor header `hi3516av100/mipi_reg.h` field `cur_st_d2`; access and reset unknown, modelled RW)";
            sw = rw;
            hw = r;
        } cur_st_d2[19:16];

        field {
            name = "nxt_st_d1";
            desc = "[inferred] Nxt st d1. (vendor header `hi3516av100/mipi_reg.h` field `nxt_st_d1`; access and reset unknown, modelled RW)";
            sw = rw;
            hw = r;
        } nxt_st_d1[15:12];

        field {
            name = "cur_st_d1";
            desc = "[inferred] Cur st d1. (vendor header `hi3516av100/mipi_reg.h` field `cur_st_d1`; access and reset unknown, modelled RW)";
            sw = rw;
            hw = r;
        } cur_st_d1[11:8];

        field {
            name = "nxt_st_d0";
            desc = "[inferred] Nxt st d0. (vendor header `hi3516av100/mipi_reg.h` field `nxt_st_d0`; access and reset unknown, modelled RW)";
            sw = rw;
            hw = r;
        } nxt_st_d0[7:4];

        field {
            name = "cur_st_d0";
            desc = "[inferred] Cur st d0. (vendor header `hi3516av100/mipi_reg.h` field `cur_st_d0`; access and reset unknown, modelled RW)";
            sw = rw;
            hw = r;
        } cur_st_d0[3:0];
    } MIPI_FSMST_DATA_LINK0 @ 0x1208;

    reg {
        name = "MIPI FSMST CK LINK0";
        desc = "[inferred] MIPI FSMST CK LINK0. Not in the data sheet. Source: OpenIPC openhisilicon `kernel/mipi_rx/hi3516av100/mipi_reg.h` (GPL-3.0 repository, HiSilicon copyright; local copy sources/openhisilicon), union `U_MIPI_FSMST_CK_LINK`, struct offset 0x120C (GPL-3.0 repository, HiSilicon copyright; byte-identical to the hi3516cv200 file). Reset value and access type unknown (modelled RW, no reset). Confidence: medium (vendor header for this chip family, not hardware verified).";

        field {
            name = "nxt_st_ck";
            desc = "[inferred] Nxt st ck. (vendor header `hi3516av100/mipi_reg.h` field `nxt_st_ck`; access and reset unknown, modelled RW)";
            sw = rw;
            hw = r;
        } nxt_st_ck[7:4];

        field {
            name = "cur_st_ck";
            desc = "[inferred] Cur st ck. (vendor header `hi3516av100/mipi_reg.h` field `cur_st_ck`; access and reset unknown, modelled RW)";
            sw = rw;
            hw = r;
        } cur_st_ck[3:0];
    } MIPI_FSMST_CK_LINK0 @ 0x120C;

    reg {
        name = "MIPI FIFO error LINK0";
        desc = "[inferred] MIPI FIFO error LINK0. Not in the data sheet. Source: OpenIPC openhisilicon `kernel/mipi_rx/hi3516av100/mipi_reg.h` (GPL-3.0 repository, HiSilicon copyright; local copy sources/openhisilicon), union `U_MIPI_FIFO_ERR_LINK`, struct offset 0x1210 (GPL-3.0 repository, HiSilicon copyright; byte-identical to the hi3516cv200 file). Reset value and access type unknown (modelled RW, no reset). Confidence: medium (vendor header for this chip family, not hardware verified).";

        field {
            name = "lvds_fifo_rderr";
            desc = "[inferred] Lvds fifo rderr. (vendor header `hi3516av100/mipi_reg.h` field `lvds_fifo_rderr`; access and reset unknown, modelled RW)";
            sw = rw;
            hw = r;
        } lvds_fifo_rderr[5:5];

        field {
            name = "lvds_fifo_wrerr";
            desc = "[inferred] Lvds fifo wrerr. (vendor header `hi3516av100/mipi_reg.h` field `lvds_fifo_wrerr`; access and reset unknown, modelled RW)";
            sw = rw;
            hw = r;
        } lvds_fifo_wrerr[4:4];

        field {
            name = "mipi_cmd_fifo_rderr";
            desc = "[inferred] Mipi cmd fifo rderr. (vendor header `hi3516av100/mipi_reg.h` field `mipi_cmd_fifo_rderr`; access and reset unknown, modelled RW)";
            sw = rw;
            hw = r;
        } mipi_cmd_fifo_rderr[3:3];

        field {
            name = "mipi_cmd_fifo_wrerr";
            desc = "[inferred] Mipi cmd fifo wrerr. (vendor header `hi3516av100/mipi_reg.h` field `mipi_cmd_fifo_wrerr`; access and reset unknown, modelled RW)";
            sw = rw;
            hw = r;
        } mipi_cmd_fifo_wrerr[2:2];

        field {
            name = "mipi_data_fifo_rderr";
            desc = "[inferred] Mipi data fifo rderr. (vendor header `hi3516av100/mipi_reg.h` field `mipi_data_fifo_rderr`; access and reset unknown, modelled RW)";
            sw = rw;
            hw = r;
        } mipi_data_fifo_rderr[1:1];

        field {
            name = "mipi_data_fifo_wrerr";
            desc = "[inferred] Mipi data fifo wrerr. (vendor header `hi3516av100/mipi_reg.h` field `mipi_data_fifo_wrerr`; access and reset unknown, modelled RW)";
            sw = rw;
            hw = r;
        } mipi_data_fifo_wrerr[0:0];
    } MIPI_FIFO_ERR_LINK0 @ 0x1210;

    reg {
        name = "PHY BAK EN0 LINK0";
        desc = "[inferred] PHY BAK EN0 LINK0. Not in the data sheet. Source: OpenIPC openhisilicon `kernel/mipi_rx/hi3516av100/mipi_reg.h` (GPL-3.0 repository, HiSilicon copyright; local copy sources/openhisilicon), union `U_PHY_BAK_EN0_LINK`, struct offset 0x1214 (GPL-3.0 repository, HiSilicon copyright; byte-identical to the hi3516cv200 file). Reset value and access type unknown (modelled RW, no reset). Confidence: medium (vendor header for this chip family, not hardware verified).";

        field {
            name = "phy_bak_en0";
            desc = "[inferred] PHY bak en0. (vendor header `hi3516av100/mipi_reg.h` field `phy_bak_en0`; access and reset unknown, modelled RW)";
            sw = rw;
            hw = r;
        } phy_bak_en0[31:31];

        field {
            name = "phy_ifimode_bak";
            desc = "[inferred] PHY ifimode bak. (vendor header `hi3516av100/mipi_reg.h` field `phy_ifimode_bak`; access and reset unknown, modelled RW)";
            sw = rw;
            hw = r;
        } phy_ifimode_bak[8:8];

        field {
            name = "phy_rstn_bak";
            desc = "[inferred] PHY rstn bak. (vendor header `hi3516av100/mipi_reg.h` field `phy_rstn_bak`; access and reset unknown, modelled RW)";
            sw = rw;
            hw = r;
        } phy_rstn_bak[4:4];

        field {
            name = "phy_pwdn_bak";
            desc = "[inferred] PHY pwdn bak. (vendor header `hi3516av100/mipi_reg.h` field `phy_pwdn_bak`; access and reset unknown, modelled RW)";
            sw = rw;
            hw = r;
        } phy_pwdn_bak[0:0];
    } PHY_BAK_EN0_LINK0 @ 0x1214;

    reg {
        name = "PHY BAK EN1 LINK0";
        desc = "[inferred] PHY BAK EN1 LINK0. Not in the data sheet. Source: OpenIPC openhisilicon `kernel/mipi_rx/hi3516av100/mipi_reg.h` (GPL-3.0 repository, HiSilicon copyright; local copy sources/openhisilicon), union `U_PHY_BAK_EN1_LINK`, struct offset 0x1218 (GPL-3.0 repository, HiSilicon copyright; byte-identical to the hi3516cv200 file). Reset value and access type unknown (modelled RW, no reset). Confidence: medium (vendor header for this chip family, not hardware verified).";

        field {
            name = "phy_bak_en1";
            desc = "[inferred] PHY bak en1. (vendor header `hi3516av100/mipi_reg.h` field `phy_bak_en1`; access and reset unknown, modelled RW)";
            sw = rw;
            hw = r;
        } phy_bak_en1[31:31];

        field {
            name = "te_d3en_bak";
            desc = "[inferred] Te d3en bak. (vendor header `hi3516av100/mipi_reg.h` field `te_d3en_bak`; access and reset unknown, modelled RW)";
            sw = rw;
            hw = r;
        } te_d3en_bak[23:23];

        field {
            name = "te_d2en_bak";
            desc = "[inferred] Te d2en bak. (vendor header `hi3516av100/mipi_reg.h` field `te_d2en_bak`; access and reset unknown, modelled RW)";
            sw = rw;
            hw = r;
        } te_d2en_bak[22:22];

        field {
            name = "te_d1en_bak";
            desc = "[inferred] Te d1en bak. (vendor header `hi3516av100/mipi_reg.h` field `te_d1en_bak`; access and reset unknown, modelled RW)";
            sw = rw;
            hw = r;
        } te_d1en_bak[21:21];

        field {
            name = "te_d0en_bak";
            desc = "[inferred] Te d0en bak. (vendor header `hi3516av100/mipi_reg.h` field `te_d0en_bak`; access and reset unknown, modelled RW)";
            sw = rw;
            hw = r;
        } te_d0en_bak[20:20];

        field {
            name = "te_cken_bak";
            desc = "[inferred] Te cken bak. (vendor header `hi3516av100/mipi_reg.h` field `te_cken_bak`; access and reset unknown, modelled RW)";
            sw = rw;
            hw = r;
        } te_cken_bak[16:16];

        field {
            name = "hs_d3en_bak";
            desc = "[inferred] Horizontal sync d3en bak. (vendor header `hi3516av100/mipi_reg.h` field `hs_d3en_bak`; access and reset unknown, modelled RW)";
            sw = rw;
            hw = r;
        } hs_d3en_bak[15:15];

        field {
            name = "hs_d2en_bak";
            desc = "[inferred] Horizontal sync d2en bak. (vendor header `hi3516av100/mipi_reg.h` field `hs_d2en_bak`; access and reset unknown, modelled RW)";
            sw = rw;
            hw = r;
        } hs_d2en_bak[14:14];

        field {
            name = "hs_d1en_bak";
            desc = "[inferred] Horizontal sync d1en bak. (vendor header `hi3516av100/mipi_reg.h` field `hs_d1en_bak`; access and reset unknown, modelled RW)";
            sw = rw;
            hw = r;
        } hs_d1en_bak[13:13];

        field {
            name = "hs_d0en_bak";
            desc = "[inferred] Horizontal sync d0en bak. (vendor header `hi3516av100/mipi_reg.h` field `hs_d0en_bak`; access and reset unknown, modelled RW)";
            sw = rw;
            hw = r;
        } hs_d0en_bak[12:12];

        field {
            name = "hs_cken_bak";
            desc = "[inferred] Horizontal sync cken bak. (vendor header `hi3516av100/mipi_reg.h` field `hs_cken_bak`; access and reset unknown, modelled RW)";
            sw = rw;
            hw = r;
        } hs_cken_bak[8:8];

        field {
            name = "lp_d3en_bak";
            desc = "[inferred] Low-power d3en bak. (vendor header `hi3516av100/mipi_reg.h` field `lp_d3en_bak`; access and reset unknown, modelled RW)";
            sw = rw;
            hw = r;
        } lp_d3en_bak[7:7];

        field {
            name = "lp_d2en_bak";
            desc = "[inferred] Low-power d2en bak. (vendor header `hi3516av100/mipi_reg.h` field `lp_d2en_bak`; access and reset unknown, modelled RW)";
            sw = rw;
            hw = r;
        } lp_d2en_bak[6:6];

        field {
            name = "lp_d1en_bak";
            desc = "[inferred] Low-power d1en bak. (vendor header `hi3516av100/mipi_reg.h` field `lp_d1en_bak`; access and reset unknown, modelled RW)";
            sw = rw;
            hw = r;
        } lp_d1en_bak[5:5];

        field {
            name = "lp_d0en_bak";
            desc = "[inferred] Low-power d0en bak. (vendor header `hi3516av100/mipi_reg.h` field `lp_d0en_bak`; access and reset unknown, modelled RW)";
            sw = rw;
            hw = r;
        } lp_d0en_bak[4:4];

        field {
            name = "lp_cken_bak";
            desc = "[inferred] Low-power cken bak. (vendor header `hi3516av100/mipi_reg.h` field `lp_cken_bak`; access and reset unknown, modelled RW)";
            sw = rw;
            hw = r;
        } lp_cken_bak[0:0];
    } PHY_BAK_EN1_LINK0 @ 0x1218;

    reg {
        name = "MIPI PHY ACT0 LINK0";
        desc = "[inferred] MIPI PHY ACT0 LINK0. Not in the data sheet. Source: OpenIPC openhisilicon `kernel/mipi_rx/hi3516av100/mipi_reg.h` (GPL-3.0 repository, HiSilicon copyright; local copy sources/openhisilicon), union `U_MIPI_PHY_ACT0_LINK`, struct offset 0x121C (GPL-3.0 repository, HiSilicon copyright; byte-identical to the hi3516cv200 file). Reset value and access type unknown (modelled RW, no reset). Confidence: medium (vendor header for this chip family, not hardware verified).";

        field {
            name = "phy_ifimode_act";
            desc = "[inferred] PHY ifimode act. (vendor header `hi3516av100/mipi_reg.h` field `phy_ifimode_act`; access and reset unknown, modelled RW)";
            sw = rw;
            hw = r;
        } phy_ifimode_act[8:8];

        field {
            name = "phy_rstn_act";
            desc = "[inferred] PHY rstn act. (vendor header `hi3516av100/mipi_reg.h` field `phy_rstn_act`; access and reset unknown, modelled RW)";
            sw = rw;
            hw = r;
        } phy_rstn_act[4:4];

        field {
            name = "phy_pwdn_act";
            desc = "[inferred] PHY pwdn act. (vendor header `hi3516av100/mipi_reg.h` field `phy_pwdn_act`; access and reset unknown, modelled RW)";
            sw = rw;
            hw = r;
        } phy_pwdn_act[0:0];
    } MIPI_PHY_ACT0_LINK0 @ 0x121C;

    reg {
        name = "MIPI PHY ACT1 LINK0";
        desc = "[inferred] MIPI PHY ACT1 LINK0. Not in the data sheet. Source: OpenIPC openhisilicon `kernel/mipi_rx/hi3516av100/mipi_reg.h` (GPL-3.0 repository, HiSilicon copyright; local copy sources/openhisilicon), union `U_MIPI_PHY_ACT1_LINK`, struct offset 0x1220 (GPL-3.0 repository, HiSilicon copyright; byte-identical to the hi3516cv200 file). Reset value and access type unknown (modelled RW, no reset). Confidence: medium (vendor header for this chip family, not hardware verified).";

        field {
            name = "te_d3en_act";
            desc = "[inferred] Te d3en act. (vendor header `hi3516av100/mipi_reg.h` field `te_d3en_act`; access and reset unknown, modelled RW)";
            sw = rw;
            hw = r;
        } te_d3en_act[23:23];

        field {
            name = "te_d2en_act";
            desc = "[inferred] Te d2en act. (vendor header `hi3516av100/mipi_reg.h` field `te_d2en_act`; access and reset unknown, modelled RW)";
            sw = rw;
            hw = r;
        } te_d2en_act[22:22];

        field {
            name = "te_d1en_act";
            desc = "[inferred] Te d1en act. (vendor header `hi3516av100/mipi_reg.h` field `te_d1en_act`; access and reset unknown, modelled RW)";
            sw = rw;
            hw = r;
        } te_d1en_act[21:21];

        field {
            name = "te_d0en_act";
            desc = "[inferred] Te d0en act. (vendor header `hi3516av100/mipi_reg.h` field `te_d0en_act`; access and reset unknown, modelled RW)";
            sw = rw;
            hw = r;
        } te_d0en_act[20:20];

        field {
            name = "te_cken_act";
            desc = "[inferred] Te cken act. (vendor header `hi3516av100/mipi_reg.h` field `te_cken_act`; access and reset unknown, modelled RW)";
            sw = rw;
            hw = r;
        } te_cken_act[16:16];

        field {
            name = "hs_d3en_act";
            desc = "[inferred] Horizontal sync d3en act. (vendor header `hi3516av100/mipi_reg.h` field `hs_d3en_act`; access and reset unknown, modelled RW)";
            sw = rw;
            hw = r;
        } hs_d3en_act[15:15];

        field {
            name = "hs_d2en_act";
            desc = "[inferred] Horizontal sync d2en act. (vendor header `hi3516av100/mipi_reg.h` field `hs_d2en_act`; access and reset unknown, modelled RW)";
            sw = rw;
            hw = r;
        } hs_d2en_act[14:14];

        field {
            name = "hs_d1en_act";
            desc = "[inferred] Horizontal sync d1en act. (vendor header `hi3516av100/mipi_reg.h` field `hs_d1en_act`; access and reset unknown, modelled RW)";
            sw = rw;
            hw = r;
        } hs_d1en_act[13:13];

        field {
            name = "hs_d0en_act";
            desc = "[inferred] Horizontal sync d0en act. (vendor header `hi3516av100/mipi_reg.h` field `hs_d0en_act`; access and reset unknown, modelled RW)";
            sw = rw;
            hw = r;
        } hs_d0en_act[12:12];

        field {
            name = "hs_cken_act";
            desc = "[inferred] Horizontal sync cken act. (vendor header `hi3516av100/mipi_reg.h` field `hs_cken_act`; access and reset unknown, modelled RW)";
            sw = rw;
            hw = r;
        } hs_cken_act[8:8];

        field {
            name = "lp_d3en_act";
            desc = "[inferred] Low-power d3en act. (vendor header `hi3516av100/mipi_reg.h` field `lp_d3en_act`; access and reset unknown, modelled RW)";
            sw = rw;
            hw = r;
        } lp_d3en_act[7:7];

        field {
            name = "lp_d2en_act";
            desc = "[inferred] Low-power d2en act. (vendor header `hi3516av100/mipi_reg.h` field `lp_d2en_act`; access and reset unknown, modelled RW)";
            sw = rw;
            hw = r;
        } lp_d2en_act[6:6];

        field {
            name = "lp_d1en_act";
            desc = "[inferred] Low-power d1en act. (vendor header `hi3516av100/mipi_reg.h` field `lp_d1en_act`; access and reset unknown, modelled RW)";
            sw = rw;
            hw = r;
        } lp_d1en_act[5:5];

        field {
            name = "lp_d0en_act";
            desc = "[inferred] Low-power d0en act. (vendor header `hi3516av100/mipi_reg.h` field `lp_d0en_act`; access and reset unknown, modelled RW)";
            sw = rw;
            hw = r;
        } lp_d0en_act[4:4];

        field {
            name = "lp_cken_act";
            desc = "[inferred] Low-power cken act. (vendor header `hi3516av100/mipi_reg.h` field `lp_cken_act`; access and reset unknown, modelled RW)";
            sw = rw;
            hw = r;
        } lp_cken_act[0:0];
    } MIPI_PHY_ACT1_LINK0 @ 0x1220;

    reg {
        name = "LVDS SYNC BORD LINK0";
        desc = "[inferred] LVDS SYNC BORD LINK0. Not in the data sheet. Source: OpenIPC openhisilicon `kernel/mipi_rx/hi3516av100/mipi_reg.h` (GPL-3.0 repository, HiSilicon copyright; local copy sources/openhisilicon), union `U_LVDS_SYNC_BORD_LINK`, struct offset 0x1224 (GPL-3.0 repository, HiSilicon copyright; byte-identical to the hi3516cv200 file). Reset value and access type unknown (modelled RW, no reset). Confidence: medium (vendor header for this chip family, not hardware verified).";

        field {
            name = "sync_bord_lane3";
            desc = "[inferred] Sync bord lane3. (vendor header `hi3516av100/mipi_reg.h` field `sync_bord_lane3`; access and reset unknown, modelled RW)";
            sw = rw;
            hw = r;
        } sync_bord_lane3[15:12];

        field {
            name = "sync_bord_lane2";
            desc = "[inferred] Sync bord lane2. (vendor header `hi3516av100/mipi_reg.h` field `sync_bord_lane2`; access and reset unknown, modelled RW)";
            sw = rw;
            hw = r;
        } sync_bord_lane2[11:8];

        field {
            name = "sync_bord_lane1";
            desc = "[inferred] Sync bord lane1. (vendor header `hi3516av100/mipi_reg.h` field `sync_bord_lane1`; access and reset unknown, modelled RW)";
            sw = rw;
            hw = r;
        } sync_bord_lane1[7:4];

        field {
            name = "sync_bord_lane0";
            desc = "[inferred] Sync bord lane0. (vendor header `hi3516av100/mipi_reg.h` field `sync_bord_lane0`; access and reset unknown, modelled RW)";
            sw = rw;
            hw = r;
        } sync_bord_lane0[3:0];
    } LVDS_SYNC_BORD_LINK0 @ 0x1224;

    reg {
        name = "Link 1 interrupt status register";
        desc = "INT_STAT_LINK1 is a link 1 interrupt status register.

Data sheet 10.3.6 INT_STAT_LINK1 (offset 0x1400, printed page 10-318, `hi3516av100--Hi3516A-Hi3516D-Datasheet.txt` line 76684).";

        enum INT_STAT_LINK1_vsync_err_stat_enum {
            NO_INTERRUPT_GENERATED = 0 { name = "No Interrupt Generated"; desc = "No interrupt is generated."; };
            INTERRUPT_GENERATED = 1 { name = "Interrupt Generated"; desc = "An interrupt is generated."; };
        };

        field {
            name = "vsync_err_stat";
            desc = "SOF or EOF signal async interrupt status for each lane on link 1.";
            sw = r;
            hw = w;
            encode = INT_STAT_LINK1_vsync_err_stat_enum;
            reset = 0x0;
        } vsync_err_stat[21:21];

        enum INT_STAT_LINK1_hsync_err_stat_enum {
            NO_INTERRUPT_GENERATED = 0 { name = "No Interrupt Generated"; desc = "No interrupt is generated."; };
            INTERRUPT_GENERATED = 1 { name = "Interrupt Generated"; desc = "An interrupt is generated."; };
        };

        field {
            name = "hsync_err_stat";
            desc = "SOL or EOL signal async interrupt status for each lane on link 1.";
            sw = r;
            hw = w;
            encode = INT_STAT_LINK1_hsync_err_stat_enum;
            reset = 0x0;
        } hsync_err_stat[20:20];

        enum INT_STAT_LINK1_lane3_sync_err_stat_enum {
            NO_INTERRUPT_GENERATED = 0 { name = "No Interrupt Generated"; desc = "No interrupt is generated."; };
            INTERRUPT_GENERATED = 1 { name = "Interrupt Generated"; desc = "An interrupt is generated."; };
        };

        field {
            name = "lane3_sync_err_stat";
            desc = "EOL or EOF signal detection failure interrupt status for lane 3 on link 1.";
            sw = r;
            hw = w;
            encode = INT_STAT_LINK1_lane3_sync_err_stat_enum;
            reset = 0x0;
        } lane3_sync_err_stat[19:19];

        enum INT_STAT_LINK1_lane2_sync_err_stat_enum {
            NO_INTERRUPT_GENERATED = 0 { name = "No Interrupt Generated"; desc = "No interrupt is generated."; };
            INTERRUPT_GENERATED = 1 { name = "Interrupt Generated"; desc = "An interrupt is generated."; };
        };

        field {
            name = "lane2_sync_err_stat";
            desc = "EOL or EOF signal detection failure interrupt status for lane 2 on link 1.";
            sw = r;
            hw = w;
            encode = INT_STAT_LINK1_lane2_sync_err_stat_enum;
            reset = 0x0;
        } lane2_sync_err_stat[18:18];

        enum INT_STAT_LINK1_lane1_sync_err_stat_enum {
            NO_INTERRUPT_GENERATED = 0 { name = "No Interrupt Generated"; desc = "No interrupt is generated."; };
            INTERRUPT_GENERATED = 1 { name = "Interrupt Generated"; desc = "An interrupt is generated."; };
        };

        field {
            name = "lane1_sync_err_stat";
            desc = "EOL or EOF signal detection failure interrupt status for lane 1 on link 1.";
            sw = r;
            hw = w;
            encode = INT_STAT_LINK1_lane1_sync_err_stat_enum;
            reset = 0x0;
        } lane1_sync_err_stat[17:17];

        enum INT_STAT_LINK1_lane0_sync_err_stat_enum {
            NO_INTERRUPT_GENERATED = 0 { name = "No Interrupt Generated"; desc = "No interrupt is generated."; };
            INTERRUPT_GENERATED = 1 { name = "Interrupt Generated"; desc = "An interrupt is generated."; };
        };

        field {
            name = "lane0_sync_err_stat";
            desc = "EOL or EOF signal detection failure interrupt status for lane 0 on link 1.";
            sw = r;
            hw = w;
            encode = INT_STAT_LINK1_lane0_sync_err_stat_enum;
            reset = 0x0;
        } lane0_sync_err_stat[16:16];

        field {
            name = "timeout_d3_stat";
            desc = "[inferred] Timeout d3 status. (bits reserved in the data sheet; vendor header `hi3516av100/mipi_reg.h` field `timeout_d3_stat`; access and reset unknown, modelled RW)";
            sw = rw;
            hw = r;
        } timeout_d3_stat[12:12];

        field {
            name = "timeout_d2_stat";
            desc = "[inferred] Timeout d2 status. (bits reserved in the data sheet; vendor header `hi3516av100/mipi_reg.h` field `timeout_d2_stat`; access and reset unknown, modelled RW)";
            sw = rw;
            hw = r;
        } timeout_d2_stat[11:11];

        field {
            name = "timeout_d1_stat";
            desc = "[inferred] Timeout d1 status. (bits reserved in the data sheet; vendor header `hi3516av100/mipi_reg.h` field `timeout_d1_stat`; access and reset unknown, modelled RW)";
            sw = rw;
            hw = r;
        } timeout_d1_stat[10:10];

        field {
            name = "timeout_d0_stat";
            desc = "[inferred] Timeout d0 status. (bits reserved in the data sheet; vendor header `hi3516av100/mipi_reg.h` field `timeout_d0_stat`; access and reset unknown, modelled RW)";
            sw = rw;
            hw = r;
        } timeout_d0_stat[9:9];

        field {
            name = "timeout_ck_stat";
            desc = "[inferred] Timeout ck status. (bits reserved in the data sheet; vendor header `hi3516av100/mipi_reg.h` field `timeout_ck_stat`; access and reset unknown, modelled RW)";
            sw = rw;
            hw = r;
        } timeout_ck_stat[8:8];

        field {
            name = "escape_d3_stat";
            desc = "[inferred] Escape d3 status. (bits reserved in the data sheet; vendor header `hi3516av100/mipi_reg.h` field `escape_d3_stat`; access and reset unknown, modelled RW)";
            sw = rw;
            hw = r;
        } escape_d3_stat[4:4];

        field {
            name = "escape_d2_stat";
            desc = "[inferred] Escape d2 status. (bits reserved in the data sheet; vendor header `hi3516av100/mipi_reg.h` field `escape_d2_stat`; access and reset unknown, modelled RW)";
            sw = rw;
            hw = r;
        } escape_d2_stat[3:3];

        field {
            name = "escape_d1_stat";
            desc = "[inferred] Escape d1 status. (bits reserved in the data sheet; vendor header `hi3516av100/mipi_reg.h` field `escape_d1_stat`; access and reset unknown, modelled RW)";
            sw = rw;
            hw = r;
        } escape_d1_stat[2:2];

        field {
            name = "escape_d0_stat";
            desc = "[inferred] Escape d0 status. (bits reserved in the data sheet; vendor header `hi3516av100/mipi_reg.h` field `escape_d0_stat`; access and reset unknown, modelled RW)";
            sw = rw;
            hw = r;
        } escape_d0_stat[1:1];

        field {
            name = "escape_ck_stat";
            desc = "[inferred] Escape ck status. (bits reserved in the data sheet; vendor header `hi3516av100/mipi_reg.h` field `escape_ck_stat`; access and reset unknown, modelled RW)";
            sw = rw;
            hw = r;
        } escape_ck_stat[0:0];
    } INT_STAT_LINK1 @ 0x1400;

    reg {
        name = "Link 1 interrupt mask register";
        desc = "INT_MASK_LINK1 is a link 1 interrupt mask register.

Data sheet 10.3.6 INT_MASK_LINK1 (offset 0x1404, printed page 10-319, `hi3516av100--Hi3516A-Hi3516D-Datasheet.txt` line 76747).";

        enum INT_MASK_LINK1_vsync_err_mask_enum {
            NOT_MASKED = 0 { name = "Not Masked"; desc = "not masked"; };
            MASKED = 1 { name = "Masked"; desc = "masked"; };
        };

        field {
            name = "vsync_err_mask";
            desc = "SOF or EOF signal async interrupt mask for each lane on link 1.";
            sw = rw;
            hw = r;
            encode = INT_MASK_LINK1_vsync_err_mask_enum;
            reset = 0x0;
        } vsync_err_mask[21:21];

        enum INT_MASK_LINK1_hsync_err_mask_enum {
            NOT_MASKED = 0 { name = "Not Masked"; desc = "not masked"; };
            MASKED = 1 { name = "Masked"; desc = "masked"; };
        };

        field {
            name = "hsync_err_mask";
            desc = "SOL or EOL signal async interrupt mask for each lane on link 1.";
            sw = rw;
            hw = r;
            encode = INT_MASK_LINK1_hsync_err_mask_enum;
            reset = 0x0;
        } hsync_err_mask[20:20];

        enum INT_MASK_LINK1_lane3_sync_err_mask_enum {
            NOT_MASKED = 0 { name = "Not Masked"; desc = "not masked"; };
            MASKED = 1 { name = "Masked"; desc = "masked"; };
        };

        field {
            name = "lane3_sync_err_mask";
            desc = "EOL or EOF signal detection failure interrupt mask for lane 3 on link 1.";
            sw = rw;
            hw = r;
            encode = INT_MASK_LINK1_lane3_sync_err_mask_enum;
            reset = 0x0;
        } lane3_sync_err_mask[19:19];

        enum INT_MASK_LINK1_lane2_sync_err_mask_enum {
            NOT_MASKED = 0 { name = "Not Masked"; desc = "not masked"; };
            MASKED = 1 { name = "Masked"; desc = "masked"; };
        };

        field {
            name = "lane2_sync_err_mask";
            desc = "EOL or EOF signal detection failure interrupt mask for lane 2.";
            sw = rw;
            hw = r;
            encode = INT_MASK_LINK1_lane2_sync_err_mask_enum;
            reset = 0x0;
        } lane2_sync_err_mask[18:18];

        enum INT_MASK_LINK1_lane1_sync_err_mask_enum {
            NOT_MASKED = 0 { name = "Not Masked"; desc = "not masked"; };
            MASKED = 1 { name = "Masked"; desc = "masked"; };
        };

        field {
            name = "lane1_sync_err_mask";
            desc = "EOL or EOF signal detection failure interrupt mask for lane 1.";
            sw = rw;
            hw = r;
            encode = INT_MASK_LINK1_lane1_sync_err_mask_enum;
            reset = 0x0;
        } lane1_sync_err_mask[17:17];

        enum INT_MASK_LINK1_lane0_sync_err_mask_enum {
            NOT_MASKED = 0 { name = "Not Masked"; desc = "not masked"; };
            MASKED = 1 { name = "Masked"; desc = "masked"; };
        };

        field {
            name = "lane0_sync_err_mask";
            desc = "EOL or EOF signal detection failure interrupt mask for lane 0.";
            sw = rw;
            hw = r;
            encode = INT_MASK_LINK1_lane0_sync_err_mask_enum;
            reset = 0x0;
        } lane0_sync_err_mask[16:16];

        field {
            name = "timeout_d3_mask";
            desc = "[inferred] Timeout d3 mask. (bits reserved in the data sheet; vendor header `hi3516av100/mipi_reg.h` field `timeout_d3_mask`; access and reset unknown, modelled RW)";
            sw = rw;
            hw = r;
        } timeout_d3_mask[12:12];

        field {
            name = "timeout_d2_mask";
            desc = "[inferred] Timeout d2 mask. (bits reserved in the data sheet; vendor header `hi3516av100/mipi_reg.h` field `timeout_d2_mask`; access and reset unknown, modelled RW)";
            sw = rw;
            hw = r;
        } timeout_d2_mask[11:11];

        field {
            name = "timeout_d1_mask";
            desc = "[inferred] Timeout d1 mask. (bits reserved in the data sheet; vendor header `hi3516av100/mipi_reg.h` field `timeout_d1_mask`; access and reset unknown, modelled RW)";
            sw = rw;
            hw = r;
        } timeout_d1_mask[10:10];

        field {
            name = "timeout_d0_mask";
            desc = "[inferred] Timeout d0 mask. (bits reserved in the data sheet; vendor header `hi3516av100/mipi_reg.h` field `timeout_d0_mask`; access and reset unknown, modelled RW)";
            sw = rw;
            hw = r;
        } timeout_d0_mask[9:9];

        field {
            name = "timeout_ck_mask";
            desc = "[inferred] Timeout ck mask. (bits reserved in the data sheet; vendor header `hi3516av100/mipi_reg.h` field `timeout_ck_mask`; access and reset unknown, modelled RW)";
            sw = rw;
            hw = r;
        } timeout_ck_mask[8:8];

        field {
            name = "escape_d3_mask";
            desc = "[inferred] Escape d3 mask. (bits reserved in the data sheet; vendor header `hi3516av100/mipi_reg.h` field `escape_d3_mask`; access and reset unknown, modelled RW)";
            sw = rw;
            hw = r;
        } escape_d3_mask[4:4];

        field {
            name = "escape_d2_mask";
            desc = "[inferred] Escape d2 mask. (bits reserved in the data sheet; vendor header `hi3516av100/mipi_reg.h` field `escape_d2_mask`; access and reset unknown, modelled RW)";
            sw = rw;
            hw = r;
        } escape_d2_mask[3:3];

        field {
            name = "escape_d1_mask";
            desc = "[inferred] Escape d1 mask. (bits reserved in the data sheet; vendor header `hi3516av100/mipi_reg.h` field `escape_d1_mask`; access and reset unknown, modelled RW)";
            sw = rw;
            hw = r;
        } escape_d1_mask[2:2];

        field {
            name = "escape_d0_mask";
            desc = "[inferred] Escape d0 mask. (bits reserved in the data sheet; vendor header `hi3516av100/mipi_reg.h` field `escape_d0_mask`; access and reset unknown, modelled RW)";
            sw = rw;
            hw = r;
        } escape_d0_mask[1:1];

        field {
            name = "escape_ck_mask";
            desc = "[inferred] Escape ck mask. (bits reserved in the data sheet; vendor header `hi3516av100/mipi_reg.h` field `escape_ck_mask`; access and reset unknown, modelled RW)";
            sw = rw;
            hw = r;
        } escape_ck_mask[0:0];
    } INT_MASK_LINK1 @ 0x1404;

    reg {
        name = "Link 1 raw interrupt status register";
        desc = "INT_RAW_LINK1 is a link 1 raw interrupt status register.

Data sheet 10.3.6 INT_RAW_LINK1 (offset 0x1408, printed page 10-320, `hi3516av100--Hi3516A-Hi3516D-Datasheet.txt` line 76810).";

        enum INT_RAW_LINK1_vsync_err_raw_enum {
            NO_INTERRUPT_GENERATED = 0 { name = "No Interrupt Generated"; desc = "No interrupt is generated."; };
            INTERRUPT_GENERATED = 1 { name = "Interrupt Generated"; desc = "An interrupt is generated."; };
        };

        field {
            name = "vsync_err_raw";
            desc = "Raw SOF or EOF signal async interrupt status for each lane on link 1.";
            sw = r;
            hw = w;
            encode = INT_RAW_LINK1_vsync_err_raw_enum;
            reset = 0x0;
        } vsync_err_raw[21:21];

        enum INT_RAW_LINK1_hsync_err_raw_enum {
            NO_INTERRUPT_GENERATED = 0 { name = "No Interrupt Generated"; desc = "No interrupt is generated."; };
            INTERRUPT_GENERATED = 1 { name = "Interrupt Generated"; desc = "An interrupt is generated."; };
        };

        field {
            name = "hsync_err_raw";
            desc = "Raw SOL or EOL signal async interrupt status for each lane on link 1.";
            sw = r;
            hw = w;
            encode = INT_RAW_LINK1_hsync_err_raw_enum;
            reset = 0x0;
        } hsync_err_raw[20:20];

        enum INT_RAW_LINK1_lane3_sync_err_raw_enum {
            NO_INTERRUPT_GENERATED = 0 { name = "No Interrupt Generated"; desc = "No interrupt is generated."; };
            INTERRUPT_GENERATED = 1 { name = "Interrupt Generated"; desc = "An interrupt is generated."; };
        };

        field {
            name = "lane3_sync_err_raw";
            desc = "Raw EOL or EOF signal detection failure interrupt status for lane 3 on link 1.";
            sw = r;
            hw = w;
            encode = INT_RAW_LINK1_lane3_sync_err_raw_enum;
            reset = 0x0;
        } lane3_sync_err_raw[19:19];

        enum INT_RAW_LINK1_lane2_sync_err_raw_enum {
            NO_INTERRUPT_GENERATED = 0 { name = "No Interrupt Generated"; desc = "No interrupt is generated."; };
            INTERRUPT_GENERATED = 1 { name = "Interrupt Generated"; desc = "An interrupt is generated."; };
        };

        field {
            name = "lane2_sync_err_raw";
            desc = "Raw EOL or EOF signal detection failure interrupt status for lane 2 on link 1.";
            sw = r;
            hw = w;
            encode = INT_RAW_LINK1_lane2_sync_err_raw_enum;
            reset = 0x0;
        } lane2_sync_err_raw[18:18];

        enum INT_RAW_LINK1_lane1_sync_err_raw_enum {
            NO_INTERRUPT_GENERATED = 0 { name = "No Interrupt Generated"; desc = "No interrupt is generated."; };
            INTERRUPT_GENERATED = 1 { name = "Interrupt Generated"; desc = "An interrupt is generated."; };
        };

        field {
            name = "lane1_sync_err_raw";
            desc = "Raw EOL or EOF signal detection failure interrupt status for lane 1 on link 1.";
            sw = r;
            hw = w;
            encode = INT_RAW_LINK1_lane1_sync_err_raw_enum;
            reset = 0x0;
        } lane1_sync_err_raw[17:17];

        enum INT_RAW_LINK1_lane0_sync_err_raw_enum {
            NO_INTERRUPT_GENERATED = 0 { name = "No Interrupt Generated"; desc = "No interrupt is generated."; };
            INTERRUPT_GENERATED = 1 { name = "Interrupt Generated"; desc = "An interrupt is generated."; };
        };

        field {
            name = "lane0_sync_err_raw";
            desc = "Raw EOL or EOF signal detection failure interrupt status for lane 0 on link 1.";
            sw = r;
            hw = w;
            encode = INT_RAW_LINK1_lane0_sync_err_raw_enum;
            reset = 0x0;
        } lane0_sync_err_raw[16:16];

        field {
            name = "timeout_d3_raw";
            desc = "[inferred] Timeout d3 raw. (bits reserved in the data sheet; vendor header `hi3516av100/mipi_reg.h` field `timeout_d3_raw`; access and reset unknown, modelled RW)";
            sw = rw;
            hw = r;
        } timeout_d3_raw[12:12];

        field {
            name = "timeout_d2_raw";
            desc = "[inferred] Timeout d2 raw. (bits reserved in the data sheet; vendor header `hi3516av100/mipi_reg.h` field `timeout_d2_raw`; access and reset unknown, modelled RW)";
            sw = rw;
            hw = r;
        } timeout_d2_raw[11:11];

        field {
            name = "timeout_d1_raw";
            desc = "[inferred] Timeout d1 raw. (bits reserved in the data sheet; vendor header `hi3516av100/mipi_reg.h` field `timeout_d1_raw`; access and reset unknown, modelled RW)";
            sw = rw;
            hw = r;
        } timeout_d1_raw[10:10];

        field {
            name = "timeout_d0_raw";
            desc = "[inferred] Timeout d0 raw. (bits reserved in the data sheet; vendor header `hi3516av100/mipi_reg.h` field `timeout_d0_raw`; access and reset unknown, modelled RW)";
            sw = rw;
            hw = r;
        } timeout_d0_raw[9:9];

        field {
            name = "timeout_ck_raw";
            desc = "[inferred] Timeout ck raw. (bits reserved in the data sheet; vendor header `hi3516av100/mipi_reg.h` field `timeout_ck_raw`; access and reset unknown, modelled RW)";
            sw = rw;
            hw = r;
        } timeout_ck_raw[8:8];

        field {
            name = "escape_d3_raw";
            desc = "[inferred] Escape d3 raw. (bits reserved in the data sheet; vendor header `hi3516av100/mipi_reg.h` field `escape_d3_raw`; access and reset unknown, modelled RW)";
            sw = rw;
            hw = r;
        } escape_d3_raw[4:4];

        field {
            name = "escape_d2_raw";
            desc = "[inferred] Escape d2 raw. (bits reserved in the data sheet; vendor header `hi3516av100/mipi_reg.h` field `escape_d2_raw`; access and reset unknown, modelled RW)";
            sw = rw;
            hw = r;
        } escape_d2_raw[3:3];

        field {
            name = "escape_d1_raw";
            desc = "[inferred] Escape d1 raw. (bits reserved in the data sheet; vendor header `hi3516av100/mipi_reg.h` field `escape_d1_raw`; access and reset unknown, modelled RW)";
            sw = rw;
            hw = r;
        } escape_d1_raw[2:2];

        field {
            name = "escape_d0_raw";
            desc = "[inferred] Escape d0 raw. (bits reserved in the data sheet; vendor header `hi3516av100/mipi_reg.h` field `escape_d0_raw`; access and reset unknown, modelled RW)";
            sw = rw;
            hw = r;
        } escape_d0_raw[1:1];

        field {
            name = "escape_ck_raw";
            desc = "[inferred] Escape ck raw. (bits reserved in the data sheet; vendor header `hi3516av100/mipi_reg.h` field `escape_ck_raw`; access and reset unknown, modelled RW)";
            sw = rw;
            hw = r;
        } escape_ck_raw[0:0];
    } INT_RAW_LINK1 @ 0x1408;

    reg {
        name = "Link 1 interrupt clear register";
        desc = "INT_CLR_LINK1 is a link 1 interrupt clear register.

Data sheet 10.3.6 INT_CLR_LINK1 (offset 0x140C, printed page 10-321, `hi3516av100--Hi3516A-Hi3516D-Datasheet.txt` line 76876).";

        field {
            name = "vsync_err_clr";
            desc = "SOF or EOF signal async interrupt clear for each lane on link 1. Writing 1 clears this interrupt.";
            sw = rw;
            hw = r;
            reset = 0x0;
        } vsync_err_clr[21:21];

        field {
            name = "hsync_err_clr";
            desc = "SOL or EOL signal async interrupt clear for each lane on link 1. Writing 1 clears this interrupt.";
            sw = rw;
            hw = r;
            reset = 0x0;
        } hsync_err_clr[20:20];

        field {
            name = "lane3_sync_err_clr";
            desc = "EOL or EOF signal detection failure interrupt clear for lane 3 on link 1. Writing 1 clears this interrupt.";
            sw = rw;
            hw = r;
            reset = 0x0;
        } lane3_sync_err_clr[19:19];

        field {
            name = "lane2_sync_err_clr";
            desc = "EOL or EOF signal detection failure interrupt clear for lane 2 on link 1. Writing 1 clears this interrupt.";
            sw = rw;
            hw = r;
            reset = 0x0;
        } lane2_sync_err_clr[18:18];

        field {
            name = "lane1_sync_err_clr";
            desc = "EOL or EOF signal detection failure interrupt clear for lane 1 on link 1. Writing 1 clears this interrupt.";
            sw = rw;
            hw = r;
            reset = 0x0;
        } lane1_sync_err_clr[17:17];

        field {
            name = "lane0_sync_err_clr";
            desc = "EOL or EOF signal detection failure interrupt clear for lane 0 on link 1. Writing 1 clears this interrupt.";
            sw = rw;
            hw = r;
            reset = 0x0;
        } lane0_sync_err_clr[16:16];

        field {
            name = "timeout_d3_clr";
            desc = "[inferred] Timeout d3 clear. (bits reserved in the data sheet; vendor header `hi3516av100/mipi_reg.h` field `timeout_d3_clr`; access and reset unknown, modelled RW)";
            sw = rw;
            hw = r;
        } timeout_d3_clr[12:12];

        field {
            name = "timeout_d2_clr";
            desc = "[inferred] Timeout d2 clear. (bits reserved in the data sheet; vendor header `hi3516av100/mipi_reg.h` field `timeout_d2_clr`; access and reset unknown, modelled RW)";
            sw = rw;
            hw = r;
        } timeout_d2_clr[11:11];

        field {
            name = "timeout_d1_clr";
            desc = "[inferred] Timeout d1 clear. (bits reserved in the data sheet; vendor header `hi3516av100/mipi_reg.h` field `timeout_d1_clr`; access and reset unknown, modelled RW)";
            sw = rw;
            hw = r;
        } timeout_d1_clr[10:10];

        field {
            name = "timeout_d0_clr";
            desc = "[inferred] Timeout d0 clear. (bits reserved in the data sheet; vendor header `hi3516av100/mipi_reg.h` field `timeout_d0_clr`; access and reset unknown, modelled RW)";
            sw = rw;
            hw = r;
        } timeout_d0_clr[9:9];

        field {
            name = "timeout_ck_clr";
            desc = "[inferred] Timeout ck clear. (bits reserved in the data sheet; vendor header `hi3516av100/mipi_reg.h` field `timeout_ck_clr`; access and reset unknown, modelled RW)";
            sw = rw;
            hw = r;
        } timeout_ck_clr[8:8];

        field {
            name = "escape_d3_clr";
            desc = "[inferred] Escape d3 clear. (bits reserved in the data sheet; vendor header `hi3516av100/mipi_reg.h` field `escape_d3_clr`; access and reset unknown, modelled RW)";
            sw = rw;
            hw = r;
        } escape_d3_clr[4:4];

        field {
            name = "escape_d2_clr";
            desc = "[inferred] Escape d2 clear. (bits reserved in the data sheet; vendor header `hi3516av100/mipi_reg.h` field `escape_d2_clr`; access and reset unknown, modelled RW)";
            sw = rw;
            hw = r;
        } escape_d2_clr[3:3];

        field {
            name = "escape_d1_clr";
            desc = "[inferred] Escape d1 clear. (bits reserved in the data sheet; vendor header `hi3516av100/mipi_reg.h` field `escape_d1_clr`; access and reset unknown, modelled RW)";
            sw = rw;
            hw = r;
        } escape_d1_clr[2:2];

        field {
            name = "escape_d0_clr";
            desc = "[inferred] Escape d0 clear. (bits reserved in the data sheet; vendor header `hi3516av100/mipi_reg.h` field `escape_d0_clr`; access and reset unknown, modelled RW)";
            sw = rw;
            hw = r;
        } escape_d0_clr[1:1];

        field {
            name = "escape_ck_clr";
            desc = "[inferred] Escape ck clear. (bits reserved in the data sheet; vendor header `hi3516av100/mipi_reg.h` field `escape_ck_clr`; access and reset unknown, modelled RW)";
            sw = rw;
            hw = r;
        } escape_ck_clr[0:0];
    } INT_CLR_LINK1 @ 0x140C;

    reg {
        name = "Link 1 lane enable configuration register";
        desc = "LANE_EN_LINK1 is a link 1 lane enable configuration register.

Data sheet 10.3.6 LANE_EN_LINK1 (offset 0x1410, printed page 10-322, `hi3516av100--Hi3516A-Hi3516D-Datasheet.txt` line 76931).";

        enum LANE_EN_LINK1_lane3_en_enum {
            DISABLED = 0 { name = "Disabled"; desc = "disabled"; };
            ENABLED = 1 { name = "Enabled"; desc = "enabled"; };
        };

        field {
            name = "lane3_en";
            desc = "Lane 3 enable for link 1.";
            sw = rw;
            hw = r;
            encode = LANE_EN_LINK1_lane3_en_enum;
            reset = 0x0;
        } lane3_en[12:12];

        enum LANE_EN_LINK1_lane2_en_enum {
            DISABLED = 0 { name = "Disabled"; desc = "disabled"; };
            ENABLED = 1 { name = "Enabled"; desc = "enabled"; };
        };

        field {
            name = "lane2_en";
            desc = "Lane 2 enable for link 1.";
            sw = rw;
            hw = r;
            encode = LANE_EN_LINK1_lane2_en_enum;
            reset = 0x0;
        } lane2_en[8:8];

        enum LANE_EN_LINK1_lane1_en_enum {
            DISABLED = 0 { name = "Disabled"; desc = "disabled"; };
            ENABLED = 1 { name = "Enabled"; desc = "enabled"; };
        };

        field {
            name = "lane1_en";
            desc = "Lane 1 enable for link 1.";
            sw = rw;
            hw = r;
            encode = LANE_EN_LINK1_lane1_en_enum;
            reset = 0x0;
        } lane1_en[4:4];

        enum LANE_EN_LINK1_lane0_en_enum {
            DISABLED = 0 { name = "Disabled"; desc = "disabled"; };
            ENABLED = 1 { name = "Enabled"; desc = "enabled"; };
        };

        field {
            name = "lane0_en";
            desc = "Lane 0 enable for link 1.";
            sw = rw;
            hw = r;
            encode = LANE_EN_LINK1_lane0_en_enum;
            reset = 0x0;
        } lane0_en[0:0];
    } LANE_EN_LINK1 @ 0x1410;

    reg {
        name = "Link 1 lane priority configuration register";
        desc = "LANE_ID_LINK1 is a link 1 lane priority configuration register.

Data sheet 10.3.6 LANE_ID_LINK1 (offset 0x1414, printed page 10-323, `hi3516av100--Hi3516A-Hi3516D-Datasheet.txt` line 76980).";

        field {
            name = "lane3_id";
            desc = "Lane 3 priority for link 1. The value ranges from 0 to 3.";
            sw = rw;
            hw = r;
            reset = 0x3;
        } lane3_id[13:12];

        field {
            name = "lane2_id";
            desc = "Lane 2 priority for link 1. The value ranges from 0 to 3.";
            sw = rw;
            hw = r;
            reset = 0x2;
        } lane2_id[9:8];

        field {
            name = "lane1_id";
            desc = "Lane 1 priority for link 1. The value ranges from 0 to 3.";
            sw = rw;
            hw = r;
            reset = 0x1;
        } lane1_id[5:4];

        field {
            name = "lane0_id";
            desc = "Lane 0 priority for link 1. The value ranges from 0 to 3.";
            sw = rw;
            hw = r;
            reset = 0x0;
        } lane0_id[1:0];
    } LANE_ID_LINK1 @ 0x1414;

    reg {
        name = "PHY mode LINK1";
        desc = "[inferred] PHY mode LINK1. Not in the data sheet. Source: OpenIPC openhisilicon `kernel/mipi_rx/hi3516av100/mipi_reg.h` (GPL-3.0 repository, HiSilicon copyright; local copy sources/openhisilicon), union `U_PHY_MODE_LINK`, struct offset 0x1418 (GPL-3.0 repository, HiSilicon copyright; byte-identical to the hi3516cv200 file). Reset value and access type unknown (modelled RW, no reset). Confidence: medium (vendor header for this chip family, not hardware verified).";

        field {
            name = "phy_offset";
            desc = "[inferred] PHY offset. (vendor header `hi3516av100/mipi_reg.h` field `phy_offset`; access and reset unknown, modelled RW)";
            sw = rw;
            hw = r;
        } phy_offset[21:20];

        field {
            name = "phy_frsck";
            desc = "[inferred] PHY frsck. (vendor header `hi3516av100/mipi_reg.h` field `phy_frsck`; access and reset unknown, modelled RW)";
            sw = rw;
            hw = r;
        } phy_frsck[9:9];

        field {
            name = "phy_frpck";
            desc = "[inferred] PHY frpck. (vendor header `hi3516av100/mipi_reg.h` field `phy_frpck`; access and reset unknown, modelled RW)";
            sw = rw;
            hw = r;
        } phy_frpck[8:8];

        field {
            name = "phy_btsel";
            desc = "[inferred] PHY btsel. (vendor header `hi3516av100/mipi_reg.h` field `phy_btsel`; access and reset unknown, modelled RW)";
            sw = rw;
            hw = r;
        } phy_btsel[6:5];

        field {
            name = "phy_sbsel";
            desc = "[inferred] PHY sbsel. (vendor header `hi3516av100/mipi_reg.h` field `phy_sbsel`; access and reset unknown, modelled RW)";
            sw = rw;
            hw = r;
        } phy_sbsel[4:4];

        field {
            name = "phy_ifimode";
            desc = "[inferred] PHY ifimode. (vendor header `hi3516av100/mipi_reg.h` field `phy_ifimode`; access and reset unknown, modelled RW)";
            sw = rw;
            hw = r;
        } phy_ifimode[2:0];
    } PHY_MODE_LINK1 @ 0x1418;

    reg {
        name = "PHY POWER LINK1";
        desc = "[inferred] PHY POWER LINK1. Not in the data sheet. Source: OpenIPC openhisilicon `kernel/mipi_rx/hi3516av100/mipi_reg.h` (GPL-3.0 repository, HiSilicon copyright; local copy sources/openhisilicon), union `U_PHY_POWER_LINK`, struct offset 0x141C (GPL-3.0 repository, HiSilicon copyright; byte-identical to the hi3516cv200 file). Reset value and access type unknown (modelled RW, no reset). Confidence: medium (vendor header for this chip family, not hardware verified).";

        field {
            name = "phy_rstn";
            desc = "[inferred] PHY rstn. (vendor header `hi3516av100/mipi_reg.h` field `phy_rstn`; access and reset unknown, modelled RW)";
            sw = rw;
            hw = r;
        } phy_rstn[4:4];

        field {
            name = "phy_pwdn";
            desc = "[inferred] PHY pwdn. (vendor header `hi3516av100/mipi_reg.h` field `phy_pwdn`; access and reset unknown, modelled RW)";
            sw = rw;
            hw = r;
        } phy_pwdn[0:0];
    } PHY_POWER_LINK1 @ 0x141C;

    reg {
        name = "PHY delay LINK1";
        desc = "[inferred] PHY delay LINK1. Not in the data sheet. Source: OpenIPC openhisilicon `kernel/mipi_rx/hi3516av100/mipi_reg.h` (GPL-3.0 repository, HiSilicon copyright; local copy sources/openhisilicon), union `U_PHY_DLY_LINK`, struct offset 0x1420 (GPL-3.0 repository, HiSilicon copyright; byte-identical to the hi3516cv200 file). Reset value and access type unknown (modelled RW, no reset). Confidence: medium (vendor header for this chip family, not hardware verified).";

        field {
            name = "phy_dlyd3";
            desc = "[inferred] PHY dlyd3. (vendor header `hi3516av100/mipi_reg.h` field `phy_dlyd3`; access and reset unknown, modelled RW)";
            sw = rw;
            hw = r;
        } phy_dlyd3[18:16];

        field {
            name = "phy_dlyd2";
            desc = "[inferred] PHY dlyd2. (vendor header `hi3516av100/mipi_reg.h` field `phy_dlyd2`; access and reset unknown, modelled RW)";
            sw = rw;
            hw = r;
        } phy_dlyd2[14:12];

        field {
            name = "phy_dlyd1";
            desc = "[inferred] PHY dlyd1. (vendor header `hi3516av100/mipi_reg.h` field `phy_dlyd1`; access and reset unknown, modelled RW)";
            sw = rw;
            hw = r;
        } phy_dlyd1[10:8];

        field {
            name = "phy_dlyd0";
            desc = "[inferred] PHY dlyd0. (vendor header `hi3516av100/mipi_reg.h` field `phy_dlyd0`; access and reset unknown, modelled RW)";
            sw = rw;
            hw = r;
        } phy_dlyd0[6:4];

        field {
            name = "phy_dlyck";
            desc = "[inferred] PHY dlyck. (vendor header `hi3516av100/mipi_reg.h` field `phy_dlyck`; access and reset unknown, modelled RW)";
            sw = rw;
            hw = r;
        } phy_dlyck[2:0];
    } PHY_DLY_LINK1 @ 0x1420;

    reg {
        name = "Link 1 PHY channel enable register";
        desc = "PHY_EN_LINK1 is a link 1 PHY channel enable register.

Data sheet 10.3.6 PHY_EN_LINK1 (offset 0x1424, printed page 10-324, `hi3516av100--Hi3516A-Hi3516D-Datasheet.txt` line 77014).";

        enum PHY_EN_LINK1_phy_te_d3en_enum {
            DISABLED = 0 { name = "Disabled"; desc = "disabled"; };
            ENABLED = 1 { name = "Enabled"; desc = "enabled"; };
        };

        field {
            name = "phy_te_d3en";
            desc = "Termination enable for data lane 3 on link 1.";
            sw = rw;
            hw = r;
            encode = PHY_EN_LINK1_phy_te_d3en_enum;
            reset = 0x0;
        } phy_te_d3en[23:23];

        enum PHY_EN_LINK1_phy_te_d2en_enum {
            DISABLED = 0 { name = "Disabled"; desc = "disabled"; };
            ENABLED = 1 { name = "Enabled"; desc = "enabled"; };
        };

        field {
            name = "phy_te_d2en";
            desc = "Termination enable for data lane 2 on link 1.";
            sw = rw;
            hw = r;
            encode = PHY_EN_LINK1_phy_te_d2en_enum;
            reset = 0x0;
        } phy_te_d2en[22:22];

        enum PHY_EN_LINK1_phy_te_d1en_enum {
            DISABLED = 0 { name = "Disabled"; desc = "disabled"; };
            ENABLED = 1 { name = "Enabled"; desc = "enabled"; };
        };

        field {
            name = "phy_te_d1en";
            desc = "Termination enable for data lane 1 on link 1.";
            sw = rw;
            hw = r;
            encode = PHY_EN_LINK1_phy_te_d1en_enum;
            reset = 0x0;
        } phy_te_d1en[21:21];

        enum PHY_EN_LINK1_phy_te_d0en_enum {
            DISABLED = 0 { name = "Disabled"; desc = "disabled"; };
            ENABLED = 1 { name = "Enabled"; desc = "enabled"; };
        };

        field {
            name = "phy_te_d0en";
            desc = "Termination enable for data lane 0 on link 1.";
            sw = rw;
            hw = r;
            encode = PHY_EN_LINK1_phy_te_d0en_enum;
            reset = 0x0;
        } phy_te_d0en[20:20];

        enum PHY_EN_LINK1_phy_te_cken_enum {
            DISABLED = 0 { name = "Disabled"; desc = "disabled"; };
            ENABLED = 1 { name = "Enabled"; desc = "enabled"; };
        };

        field {
            name = "phy_te_cken";
            desc = "Termination enable for the clock lane on link 1.";
            sw = rw;
            hw = r;
            encode = PHY_EN_LINK1_phy_te_cken_enum;
            reset = 0x0;
        } phy_te_cken[16:16];

        enum PHY_EN_LINK1_phy_hs_d3en_enum {
            DISABLED = 0 { name = "Disabled"; desc = "disabled"; };
            ENABLED = 1 { name = "Enabled"; desc = "enabled"; };
        };

        field {
            name = "phy_hs_d3en";
            desc = "High-speed mode enable for data lane 3 on link 1.";
            sw = rw;
            hw = r;
            encode = PHY_EN_LINK1_phy_hs_d3en_enum;
            reset = 0x0;
        } phy_hs_d3en[15:15];

        enum PHY_EN_LINK1_phy_hs_d2en_enum {
            DISABLED = 0 { name = "Disabled"; desc = "disabled"; };
            ENABLED = 1 { name = "Enabled"; desc = "enabled"; };
        };

        field {
            name = "phy_hs_d2en";
            desc = "High-speed mode enable for data lane 2 on link 1.";
            sw = rw;
            hw = r;
            encode = PHY_EN_LINK1_phy_hs_d2en_enum;
            reset = 0x0;
        } phy_hs_d2en[14:14];

        enum PHY_EN_LINK1_phy_hs_d1en_enum {
            DISABLED = 0 { name = "Disabled"; desc = "disabled"; };
            ENABLED = 1 { name = "Enabled"; desc = "enabled"; };
        };

        field {
            name = "phy_hs_d1en";
            desc = "High-speed mode enable for data lane 1 on link 1.";
            sw = rw;
            hw = r;
            encode = PHY_EN_LINK1_phy_hs_d1en_enum;
            reset = 0x0;
        } phy_hs_d1en[13:13];

        enum PHY_EN_LINK1_phy_hs_d0en_enum {
            DISABLED = 0 { name = "Disabled"; desc = "disabled"; };
            ENABLED = 1 { name = "Enabled"; desc = "enabled"; };
        };

        field {
            name = "phy_hs_d0en";
            desc = "High-speed mode enable for data lane 0 on link 1.";
            sw = rw;
            hw = r;
            encode = PHY_EN_LINK1_phy_hs_d0en_enum;
            reset = 0x0;
        } phy_hs_d0en[12:12];

        enum PHY_EN_LINK1_phy_hs_cken_enum {
            DISABLED = 0 { name = "Disabled"; desc = "disabled"; };
            ENABLED = 1 { name = "Enabled"; desc = "enabled"; };
        };

        field {
            name = "phy_hs_cken";
            desc = "High-speed mode enable for the clock lane on link 1.";
            sw = rw;
            hw = r;
            encode = PHY_EN_LINK1_phy_hs_cken_enum;
            reset = 0x0;
        } phy_hs_cken[8:8];

        field {
            name = "phy_lp_d3en";
            desc = "[inferred] PHY low-power d3en. (bits reserved in the data sheet; vendor header `hi3516av100/mipi_reg.h` field `phy_lp_d3en`; access and reset unknown, modelled RW)";
            sw = rw;
            hw = r;
        } phy_lp_d3en[7:7];

        field {
            name = "phy_lp_d2en";
            desc = "[inferred] PHY low-power d2en. (bits reserved in the data sheet; vendor header `hi3516av100/mipi_reg.h` field `phy_lp_d2en`; access and reset unknown, modelled RW)";
            sw = rw;
            hw = r;
        } phy_lp_d2en[6:6];

        field {
            name = "phy_lp_d1en";
            desc = "[inferred] PHY low-power d1en. (bits reserved in the data sheet; vendor header `hi3516av100/mipi_reg.h` field `phy_lp_d1en`; access and reset unknown, modelled RW)";
            sw = rw;
            hw = r;
        } phy_lp_d1en[5:5];

        field {
            name = "phy_lp_d0en";
            desc = "[inferred] PHY low-power d0en. (bits reserved in the data sheet; vendor header `hi3516av100/mipi_reg.h` field `phy_lp_d0en`; access and reset unknown, modelled RW)";
            sw = rw;
            hw = r;
        } phy_lp_d0en[4:4];

        field {
            name = "phy_lp_cken";
            desc = "[inferred] PHY low-power cken. (bits reserved in the data sheet; vendor header `hi3516av100/mipi_reg.h` field `phy_lp_cken`; access and reset unknown, modelled RW)";
            sw = rw;
            hw = r;
        } phy_lp_cken[0:0];
    } PHY_EN_LINK1 @ 0x1424;

    reg {
        name = "Link 1 PHY mode configuration register";
        desc = "PHY_CFG_LINK1 is a link 1 PHY mode configuration register.

Data sheet 10.3.6 PHY_CFG_LINK1 (offset 0x1428, printed page 10-325, `hi3516av100--Hi3516A-Hi3516D-Datasheet.txt` line 77086).";

        field {
            name = "rg_sa_en";
            desc = "SA enable (function tuning).";
            sw = rw;
            hw = r;
            reset = 0x1;
        } rg_sa_en[30:30];

        field {
            name = "rg_it_dt";
            desc = "High-speed mode current adjustment for data channels.";
            sw = rw;
            hw = r;
            reset = 0x2;
        } rg_it_dt[29:28];

        field {
            name = "rg_it_ck";
            desc = "High-speed mode current adjustment for the clock channel.";
            sw = rw;
            hw = r;
            reset = 0x2;
        } rg_it_ck[27:26];

        field {
            name = "rg_it_lp";
            desc = "Low-power mode current adjustment.";
            sw = rw;
            hw = r;
            reset = 0x2;
        } rg_it_lp[25:24];

        enum PHY_CFG_LINK1_da_ulpb_ck_enum {
            ENABLE_F = 0 { name = "Enable F"; desc = "enable"; };
            DISABLE = 1 { name = "Disable"; desc = "disable"; };
        };

        field {
            name = "da_ulpb_ck";
            desc = "Ultra-low-power mode enable for the clock lane.";
            sw = rw;
            hw = r;
            encode = PHY_CFG_LINK1_da_ulpb_ck_enum;
            reset = 0x1;
        } da_ulpb_ck[20:20];

        enum PHY_CFG_LINK1_da_ulpb_enum {
            ENABLE_F = 0 { name = "Enable F"; desc = "enable"; };
            DISABLE = 1 { name = "Disable"; desc = "disable"; };
        };

        field {
            name = "da_ulpb";
            desc = "Ultra-low-power mode enable for data lanes. Each bit corresponds to one data lane. Bit[16] corresponds to data lane 0. Bit[17] corresponds to data lane 1. Bit[18] corresponds to data lane 2. Bit[19] corresponds to data lane 3";
            sw = rw;
            hw = r;
            encode = PHY_CFG_LINK1_da_ulpb_enum;
            reset = 0xF;
        } da_ulpb[19:16];

        enum PHY_CFG_LINK1_rg_en_lp_enum {
            DISABLED = 0 { name = "Disabled"; desc = "disabled"; };
            ENABLED = 1 { name = "Enabled"; desc = "enabled"; };
        };

        field {
            name = "rg_en_lp";
            desc = "Low-power mode enable. In LVDS mode, the common mode voltage may trigger an internal LP-related circuit. Therefore, this signal must be disabled in LVDS mode.";
            sw = rw;
            hw = r;
            encode = PHY_CFG_LINK1_rg_en_lp_enum;
            reset = 0x0;
        } rg_en_lp[12:12];

        enum PHY_CFG_LINK1_rg_en_cmos_enum {
            DISABLED = 0 { name = "Disabled"; desc = "disabled"; };
            ENABLED = 1 { name = "Enabled"; desc = "enabled"; };
        };

        field {
            name = "rg_en_cmos";
            desc = "CMOS mode enable.";
            sw = rw;
            hw = r;
            encode = PHY_CFG_LINK1_rg_en_cmos_enum;
            reset = 0x0;
        } rg_en_cmos[8:8];

        enum PHY_CFG_LINK1_rg_en_clk_enum {
            DISABLED = 0 { name = "Disabled"; desc = "disabled"; };
            ENABLED = 1 { name = "Enabled"; desc = "enabled"; };
        };

        field {
            name = "rg_en_clk";
            desc = "Clock lane enable.";
            sw = rw;
            hw = r;
            encode = PHY_CFG_LINK1_rg_en_clk_enum;
            reset = 0x0;
        } rg_en_clk[4:4];

        enum PHY_CFG_LINK1_rg_en_d_enum {
            DISABLED = 0 { name = "Disabled"; desc = "disabled"; };
            ENABLED = 1 { name = "Enabled"; desc = "enabled"; };
        };

        field {
            name = "rg_en_d";
            desc = "Data lane enable.";
            sw = rw;
            hw = r;
            encode = PHY_CFG_LINK1_rg_en_d_enum;
            reset = 0x0;
        } rg_en_d[3:0];
    } PHY_CFG_LINK1 @ 0x1428;

    reg {
        name = "MIPI LANES number LINK1";
        desc = "[inferred] MIPI LANES number LINK1. Not in the data sheet. Source: OpenIPC openhisilicon `kernel/mipi_rx/hi3516av100/mipi_reg.h` (GPL-3.0 repository, HiSilicon copyright; local copy sources/openhisilicon), union `U_MIPI_LANES_NUM`, struct offset 0x1430 (GPL-3.0 repository, HiSilicon copyright; byte-identical to the hi3516cv200 file). Reset value and access type unknown (modelled RW, no reset). Confidence: medium (vendor header for this chip family, not hardware verified).";

        field {
            name = "mipi_lane_num";
            desc = "[inferred] Mipi lane number. (vendor header `hi3516av100/mipi_reg.h` field `mipi_lane_num`; access and reset unknown, modelled RW)";
            sw = rw;
            hw = r;
        } mipi_lane_num[1:0];
    } MIPI_LANES_NUM_LINK1 @ 0x1430;

    reg {
        name = "MIPI RSTN LINK1";
        desc = "[inferred] MIPI RSTN LINK1. Not in the data sheet. Source: OpenIPC openhisilicon `kernel/mipi_rx/hi3516av100/mipi_reg.h` (GPL-3.0 repository, HiSilicon copyright; local copy sources/openhisilicon), union `U_MIPI_RSTN`, struct offset 0x1434 (GPL-3.0 repository, HiSilicon copyright; byte-identical to the hi3516cv200 file). Reset value and access type unknown (modelled RW, no reset). Confidence: medium (vendor header for this chip family, not hardware verified).";

        field {
            name = "csi2_rstn";
            desc = "[inferred] Csi2 rstn. (vendor header `hi3516av100/mipi_reg.h` field `csi2_rstn`; access and reset unknown, modelled RW)";
            sw = rw;
            hw = r;
        } csi2_rstn[0:0];
    } MIPI_RSTN_LINK1 @ 0x1434;

    reg {
        name = "MIPI DI 1 LINK1";
        desc = "[inferred] MIPI DI 1 LINK1. Not in the data sheet. Source: OpenIPC openhisilicon `kernel/mipi_rx/hi3516av100/mipi_reg.h` (GPL-3.0 repository, HiSilicon copyright; local copy sources/openhisilicon), union `U_MIPI_DI_1`, struct offset 0x1438 (GPL-3.0 repository, HiSilicon copyright; byte-identical to the hi3516cv200 file). Reset value and access type unknown (modelled RW, no reset). Confidence: medium (vendor header for this chip family, not hardware verified).";

        field {
            name = "di3_vc";
            desc = "[inferred] Di3 vc. (vendor header `hi3516av100/mipi_reg.h` field `di3_vc`; access and reset unknown, modelled RW)";
            sw = rw;
            hw = r;
        } di3_vc[31:30];

        field {
            name = "di3_dt";
            desc = "[inferred] Di3 dt. (vendor header `hi3516av100/mipi_reg.h` field `di3_dt`; access and reset unknown, modelled RW)";
            sw = rw;
            hw = r;
        } di3_dt[29:24];

        field {
            name = "di2_vc";
            desc = "[inferred] Di2 vc. (vendor header `hi3516av100/mipi_reg.h` field `di2_vc`; access and reset unknown, modelled RW)";
            sw = rw;
            hw = r;
        } di2_vc[23:22];

        field {
            name = "di2_dt";
            desc = "[inferred] Di2 dt. (vendor header `hi3516av100/mipi_reg.h` field `di2_dt`; access and reset unknown, modelled RW)";
            sw = rw;
            hw = r;
        } di2_dt[21:16];

        field {
            name = "di1_vc";
            desc = "[inferred] Di1 vc. (vendor header `hi3516av100/mipi_reg.h` field `di1_vc`; access and reset unknown, modelled RW)";
            sw = rw;
            hw = r;
        } di1_vc[15:14];

        field {
            name = "di1_dt";
            desc = "[inferred] Di1 dt. (vendor header `hi3516av100/mipi_reg.h` field `di1_dt`; access and reset unknown, modelled RW)";
            sw = rw;
            hw = r;
        } di1_dt[13:8];

        field {
            name = "di0_vc";
            desc = "[inferred] Di0 vc. (vendor header `hi3516av100/mipi_reg.h` field `di0_vc`; access and reset unknown, modelled RW)";
            sw = rw;
            hw = r;
        } di0_vc[7:6];

        field {
            name = "di0_dt";
            desc = "[inferred] Di0 dt. (vendor header `hi3516av100/mipi_reg.h` field `di0_dt`; access and reset unknown, modelled RW)";
            sw = rw;
            hw = r;
        } di0_dt[5:0];
    } MIPI_DI_1_LINK1 @ 0x1438;

    reg {
        name = "MIPI DI 2 LINK1";
        desc = "[inferred] MIPI DI 2 LINK1. Not in the data sheet. Source: OpenIPC openhisilicon `kernel/mipi_rx/hi3516av100/mipi_reg.h` (GPL-3.0 repository, HiSilicon copyright; local copy sources/openhisilicon), union `U_MIPI_DI_2`, struct offset 0x143C (GPL-3.0 repository, HiSilicon copyright; byte-identical to the hi3516cv200 file). Reset value and access type unknown (modelled RW, no reset). Confidence: medium (vendor header for this chip family, not hardware verified).";

        field {
            name = "di7_vc";
            desc = "[inferred] Di7 vc. (vendor header `hi3516av100/mipi_reg.h` field `di7_vc`; access and reset unknown, modelled RW)";
            sw = rw;
            hw = r;
        } di7_vc[31:30];

        field {
            name = "di7_dt";
            desc = "[inferred] Di7 dt. (vendor header `hi3516av100/mipi_reg.h` field `di7_dt`; access and reset unknown, modelled RW)";
            sw = rw;
            hw = r;
        } di7_dt[29:24];

        field {
            name = "di6_vc";
            desc = "[inferred] Di6 vc. (vendor header `hi3516av100/mipi_reg.h` field `di6_vc`; access and reset unknown, modelled RW)";
            sw = rw;
            hw = r;
        } di6_vc[23:22];

        field {
            name = "di6_dt";
            desc = "[inferred] Di6 dt. (vendor header `hi3516av100/mipi_reg.h` field `di6_dt`; access and reset unknown, modelled RW)";
            sw = rw;
            hw = r;
        } di6_dt[21:16];

        field {
            name = "di5_vc";
            desc = "[inferred] Di5 vc. (vendor header `hi3516av100/mipi_reg.h` field `di5_vc`; access and reset unknown, modelled RW)";
            sw = rw;
            hw = r;
        } di5_vc[15:14];

        field {
            name = "di5_dt";
            desc = "[inferred] Di5 dt. (vendor header `hi3516av100/mipi_reg.h` field `di5_dt`; access and reset unknown, modelled RW)";
            sw = rw;
            hw = r;
        } di5_dt[13:8];

        field {
            name = "di4_vc";
            desc = "[inferred] Di4 vc. (vendor header `hi3516av100/mipi_reg.h` field `di4_vc`; access and reset unknown, modelled RW)";
            sw = rw;
            hw = r;
        } di4_vc[7:6];

        field {
            name = "di4_dt";
            desc = "[inferred] Di4 dt. (vendor header `hi3516av100/mipi_reg.h` field `di4_dt`; access and reset unknown, modelled RW)";
            sw = rw;
            hw = r;
        } di4_dt[5:0];
    } MIPI_DI_2_LINK1 @ 0x143C;

    reg {
        name = "MIPI INTR1 RAW LINK1";
        desc = "[inferred] MIPI INTR1 RAW LINK1. Not in the data sheet. Source: OpenIPC openhisilicon `kernel/mipi_rx/hi3516av100/mipi_reg.h` (GPL-3.0 repository, HiSilicon copyright; local copy sources/openhisilicon), union `U_MIPI_INTR1_RAW`, struct offset 0x1440 (GPL-3.0 repository, HiSilicon copyright; byte-identical to the hi3516cv200 file). Reset value and access type unknown (modelled RW, no reset). Confidence: medium (vendor header for this chip family, not hardware verified).";

        field {
            name = "intr_ecc_double";
            desc = "[inferred] Intr ecc double. (vendor header `hi3516av100/mipi_reg.h` field `intr_ecc_double`; access and reset unknown, modelled RW)";
            sw = rw;
            hw = r;
        } intr_ecc_double[28:28];

        field {
            name = "intr_crc_vc3";
            desc = "[inferred] Intr crc vc3. (vendor header `hi3516av100/mipi_reg.h` field `intr_crc_vc3`; access and reset unknown, modelled RW)";
            sw = rw;
            hw = r;
        } intr_crc_vc3[27:27];

        field {
            name = "intr_crc_vc2";
            desc = "[inferred] Intr crc vc2. (vendor header `hi3516av100/mipi_reg.h` field `intr_crc_vc2`; access and reset unknown, modelled RW)";
            sw = rw;
            hw = r;
        } intr_crc_vc2[26:26];

        field {
            name = "intr_crc_vc1";
            desc = "[inferred] Intr crc vc1. (vendor header `hi3516av100/mipi_reg.h` field `intr_crc_vc1`; access and reset unknown, modelled RW)";
            sw = rw;
            hw = r;
        } intr_crc_vc1[25:25];

        field {
            name = "intr_crc_vc0";
            desc = "[inferred] Intr crc vc0. (vendor header `hi3516av100/mipi_reg.h` field `intr_crc_vc0`; access and reset unknown, modelled RW)";
            sw = rw;
            hw = r;
        } intr_crc_vc0[24:24];

        field {
            name = "intr_l_seq_di3";
            desc = "[inferred] Intr l seq di3. (vendor header `hi3516av100/mipi_reg.h` field `intr_l_seq_di3`; access and reset unknown, modelled RW)";
            sw = rw;
            hw = r;
        } intr_l_seq_di3[23:23];

        field {
            name = "intr_l_seq_di2";
            desc = "[inferred] Intr l seq di2. (vendor header `hi3516av100/mipi_reg.h` field `intr_l_seq_di2`; access and reset unknown, modelled RW)";
            sw = rw;
            hw = r;
        } intr_l_seq_di2[22:22];

        field {
            name = "intr_l_seq_di1";
            desc = "[inferred] Intr l seq di1. (vendor header `hi3516av100/mipi_reg.h` field `intr_l_seq_di1`; access and reset unknown, modelled RW)";
            sw = rw;
            hw = r;
        } intr_l_seq_di1[21:21];

        field {
            name = "intr_l_seq_di0";
            desc = "[inferred] Intr l seq di0. (vendor header `hi3516av100/mipi_reg.h` field `intr_l_seq_di0`; access and reset unknown, modelled RW)";
            sw = rw;
            hw = r;
        } intr_l_seq_di0[20:20];

        field {
            name = "intr_l_bndy_di3";
            desc = "[inferred] Intr l bndy di3. (vendor header `hi3516av100/mipi_reg.h` field `intr_l_bndy_di3`; access and reset unknown, modelled RW)";
            sw = rw;
            hw = r;
        } intr_l_bndy_di3[19:19];

        field {
            name = "intr_l_bndy_di2";
            desc = "[inferred] Intr l bndy di2. (vendor header `hi3516av100/mipi_reg.h` field `intr_l_bndy_di2`; access and reset unknown, modelled RW)";
            sw = rw;
            hw = r;
        } intr_l_bndy_di2[18:18];

        field {
            name = "intr_l_bndy_di1";
            desc = "[inferred] Intr l bndy di1. (vendor header `hi3516av100/mipi_reg.h` field `intr_l_bndy_di1`; access and reset unknown, modelled RW)";
            sw = rw;
            hw = r;
        } intr_l_bndy_di1[17:17];

        field {
            name = "intr_l_bndy_di0";
            desc = "[inferred] Intr l bndy di0. (vendor header `hi3516av100/mipi_reg.h` field `intr_l_bndy_di0`; access and reset unknown, modelled RW)";
            sw = rw;
            hw = r;
        } intr_l_bndy_di0[16:16];

        field {
            name = "intr_f_crc_vc3";
            desc = "[inferred] Intr f crc vc3. (vendor header `hi3516av100/mipi_reg.h` field `intr_f_crc_vc3`; access and reset unknown, modelled RW)";
            sw = rw;
            hw = r;
        } intr_f_crc_vc3[15:15];

        field {
            name = "intr_f_crc_vc2";
            desc = "[inferred] Intr f crc vc2. (vendor header `hi3516av100/mipi_reg.h` field `intr_f_crc_vc2`; access and reset unknown, modelled RW)";
            sw = rw;
            hw = r;
        } intr_f_crc_vc2[14:14];

        field {
            name = "intr_f_crc_vc1";
            desc = "[inferred] Intr f crc vc1. (vendor header `hi3516av100/mipi_reg.h` field `intr_f_crc_vc1`; access and reset unknown, modelled RW)";
            sw = rw;
            hw = r;
        } intr_f_crc_vc1[13:13];

        field {
            name = "intr_f_crc_vc0";
            desc = "[inferred] Intr f crc vc0. (vendor header `hi3516av100/mipi_reg.h` field `intr_f_crc_vc0`; access and reset unknown, modelled RW)";
            sw = rw;
            hw = r;
        } intr_f_crc_vc0[12:12];

        field {
            name = "intr_f_seq_vc3";
            desc = "[inferred] Intr f seq vc3. (vendor header `hi3516av100/mipi_reg.h` field `intr_f_seq_vc3`; access and reset unknown, modelled RW)";
            sw = rw;
            hw = r;
        } intr_f_seq_vc3[11:11];

        field {
            name = "intr_f_seq_vc2";
            desc = "[inferred] Intr f seq vc2. (vendor header `hi3516av100/mipi_reg.h` field `intr_f_seq_vc2`; access and reset unknown, modelled RW)";
            sw = rw;
            hw = r;
        } intr_f_seq_vc2[10:10];

        field {
            name = "intr_f_seq_vc1";
            desc = "[inferred] Intr f seq vc1. (vendor header `hi3516av100/mipi_reg.h` field `intr_f_seq_vc1`; access and reset unknown, modelled RW)";
            sw = rw;
            hw = r;
        } intr_f_seq_vc1[9:9];

        field {
            name = "intr_f_seq_vc0";
            desc = "[inferred] Intr f seq vc0. (vendor header `hi3516av100/mipi_reg.h` field `intr_f_seq_vc0`; access and reset unknown, modelled RW)";
            sw = rw;
            hw = r;
        } intr_f_seq_vc0[8:8];

        field {
            name = "intr_f_bndry_vc3";
            desc = "[inferred] Intr f bndry vc3. (vendor header `hi3516av100/mipi_reg.h` field `intr_f_bndry_vc3`; access and reset unknown, modelled RW)";
            sw = rw;
            hw = r;
        } intr_f_bndry_vc3[7:7];

        field {
            name = "intr_f_bndry_vc2";
            desc = "[inferred] Intr f bndry vc2. (vendor header `hi3516av100/mipi_reg.h` field `intr_f_bndry_vc2`; access and reset unknown, modelled RW)";
            sw = rw;
            hw = r;
        } intr_f_bndry_vc2[6:6];

        field {
            name = "intr_f_bndry_vc1";
            desc = "[inferred] Intr f bndry vc1. (vendor header `hi3516av100/mipi_reg.h` field `intr_f_bndry_vc1`; access and reset unknown, modelled RW)";
            sw = rw;
            hw = r;
        } intr_f_bndry_vc1[5:5];

        field {
            name = "intr_f_bndry_vc0";
            desc = "[inferred] Intr f bndry vc0. (vendor header `hi3516av100/mipi_reg.h` field `intr_f_bndry_vc0`; access and reset unknown, modelled RW)";
            sw = rw;
            hw = r;
        } intr_f_bndry_vc0[4:4];
    } MIPI_INTR1_RAW_LINK1 @ 0x1440;

    reg {
        name = "MIPI INTR2 RAW LINK1";
        desc = "[inferred] MIPI INTR2 RAW LINK1. Not in the data sheet. Source: OpenIPC openhisilicon `kernel/mipi_rx/hi3516av100/mipi_reg.h` (GPL-3.0 repository, HiSilicon copyright; local copy sources/openhisilicon), union `U_MIPI_INTR2_RAW`, struct offset 0x1444 (GPL-3.0 repository, HiSilicon copyright; byte-identical to the hi3516cv200 file). Reset value and access type unknown (modelled RW, no reset). Confidence: medium (vendor header for this chip family, not hardware verified).";

        field {
            name = "intr_l_seq_di7";
            desc = "[inferred] Intr l seq di7. (vendor header `hi3516av100/mipi_reg.h` field `intr_l_seq_di7`; access and reset unknown, modelled RW)";
            sw = rw;
            hw = r;
        } intr_l_seq_di7[23:23];

        field {
            name = "intr_l_seq_di6";
            desc = "[inferred] Intr l seq di6. (vendor header `hi3516av100/mipi_reg.h` field `intr_l_seq_di6`; access and reset unknown, modelled RW)";
            sw = rw;
            hw = r;
        } intr_l_seq_di6[22:22];

        field {
            name = "intr_l_seq_di5";
            desc = "[inferred] Intr l seq di5. (vendor header `hi3516av100/mipi_reg.h` field `intr_l_seq_di5`; access and reset unknown, modelled RW)";
            sw = rw;
            hw = r;
        } intr_l_seq_di5[21:21];

        field {
            name = "intr_l_seq_di4";
            desc = "[inferred] Intr l seq di4. (vendor header `hi3516av100/mipi_reg.h` field `intr_l_seq_di4`; access and reset unknown, modelled RW)";
            sw = rw;
            hw = r;
        } intr_l_seq_di4[20:20];

        field {
            name = "intr_l_bndry_di7";
            desc = "[inferred] Intr l bndry di7. (vendor header `hi3516av100/mipi_reg.h` field `intr_l_bndry_di7`; access and reset unknown, modelled RW)";
            sw = rw;
            hw = r;
        } intr_l_bndry_di7[19:19];

        field {
            name = "intr_l_bndry_di6";
            desc = "[inferred] Intr l bndry di6. (vendor header `hi3516av100/mipi_reg.h` field `intr_l_bndry_di6`; access and reset unknown, modelled RW)";
            sw = rw;
            hw = r;
        } intr_l_bndry_di6[18:18];

        field {
            name = "intr_l_bndry_di5";
            desc = "[inferred] Intr l bndry di5. (vendor header `hi3516av100/mipi_reg.h` field `intr_l_bndry_di5`; access and reset unknown, modelled RW)";
            sw = rw;
            hw = r;
        } intr_l_bndry_di5[17:17];

        field {
            name = "intr_l_bndry_di4";
            desc = "[inferred] Intr l bndry di4. (vendor header `hi3516av100/mipi_reg.h` field `intr_l_bndry_di4`; access and reset unknown, modelled RW)";
            sw = rw;
            hw = r;
        } intr_l_bndry_di4[16:16];

        field {
            name = "intr_err_id_vc3";
            desc = "[inferred] Intr error id vc3. (vendor header `hi3516av100/mipi_reg.h` field `intr_err_id_vc3`; access and reset unknown, modelled RW)";
            sw = rw;
            hw = r;
        } intr_err_id_vc3[15:15];

        field {
            name = "intr_err_id_vc2";
            desc = "[inferred] Intr error id vc2. (vendor header `hi3516av100/mipi_reg.h` field `intr_err_id_vc2`; access and reset unknown, modelled RW)";
            sw = rw;
            hw = r;
        } intr_err_id_vc2[14:14];

        field {
            name = "intr_err_id_vc1";
            desc = "[inferred] Intr error id vc1. (vendor header `hi3516av100/mipi_reg.h` field `intr_err_id_vc1`; access and reset unknown, modelled RW)";
            sw = rw;
            hw = r;
        } intr_err_id_vc1[13:13];

        field {
            name = "intr_err_id_vc0";
            desc = "[inferred] Intr error id vc0. (vendor header `hi3516av100/mipi_reg.h` field `intr_err_id_vc0`; access and reset unknown, modelled RW)";
            sw = rw;
            hw = r;
        } intr_err_id_vc0[12:12];

        field {
            name = "intr_vc3_ecc_corrected";
            desc = "[inferred] Intr vc3 ecc corrected. (vendor header `hi3516av100/mipi_reg.h` field `intr_vc3_ecc_corrected`; access and reset unknown, modelled RW)";
            sw = rw;
            hw = r;
        } intr_vc3_ecc_corrected[11:11];

        field {
            name = "intr_vc2_ecc_corrected";
            desc = "[inferred] Intr vc2 ecc corrected. (vendor header `hi3516av100/mipi_reg.h` field `intr_vc2_ecc_corrected`; access and reset unknown, modelled RW)";
            sw = rw;
            hw = r;
        } intr_vc2_ecc_corrected[10:10];

        field {
            name = "intr_vc1_ecc_corrected";
            desc = "[inferred] Intr vc1 ecc corrected. (vendor header `hi3516av100/mipi_reg.h` field `intr_vc1_ecc_corrected`; access and reset unknown, modelled RW)";
            sw = rw;
            hw = r;
        } intr_vc1_ecc_corrected[9:9];

        field {
            name = "intr_vc0_ecc_corrected";
            desc = "[inferred] Intr vc0 ecc corrected. (vendor header `hi3516av100/mipi_reg.h` field `intr_vc0_ecc_corrected`; access and reset unknown, modelled RW)";
            sw = rw;
            hw = r;
        } intr_vc0_ecc_corrected[8:8];
    } MIPI_INTR2_RAW_LINK1 @ 0x1444;

    reg {
        name = "MIPI INTR1 MASK LINK1";
        desc = "[inferred] MIPI INTR1 MASK LINK1. Not in the data sheet. Source: OpenIPC openhisilicon `kernel/mipi_rx/hi3516av100/mipi_reg.h` (GPL-3.0 repository, HiSilicon copyright; local copy sources/openhisilicon), union `U_MIPI_INTR1_MASK`, struct offset 0x1448 (GPL-3.0 repository, HiSilicon copyright; byte-identical to the hi3516cv200 file). Reset value and access type unknown (modelled RW, no reset). Confidence: medium (vendor header for this chip family, not hardware verified).";

        field {
            name = "mask_ecc_double";
            desc = "[inferred] Mask ecc double. (vendor header `hi3516av100/mipi_reg.h` field `mask_ecc_double`; access and reset unknown, modelled RW)";
            sw = rw;
            hw = r;
        } mask_ecc_double[28:28];

        field {
            name = "mask_crc_vc3";
            desc = "[inferred] Mask crc vc3. (vendor header `hi3516av100/mipi_reg.h` field `mask_crc_vc3`; access and reset unknown, modelled RW)";
            sw = rw;
            hw = r;
        } mask_crc_vc3[27:27];

        field {
            name = "mask_crc_vc2";
            desc = "[inferred] Mask crc vc2. (vendor header `hi3516av100/mipi_reg.h` field `mask_crc_vc2`; access and reset unknown, modelled RW)";
            sw = rw;
            hw = r;
        } mask_crc_vc2[26:26];

        field {
            name = "mask_crc_vc1";
            desc = "[inferred] Mask crc vc1. (vendor header `hi3516av100/mipi_reg.h` field `mask_crc_vc1`; access and reset unknown, modelled RW)";
            sw = rw;
            hw = r;
        } mask_crc_vc1[25:25];

        field {
            name = "mask_crc_vc0";
            desc = "[inferred] Mask crc vc0. (vendor header `hi3516av100/mipi_reg.h` field `mask_crc_vc0`; access and reset unknown, modelled RW)";
            sw = rw;
            hw = r;
        } mask_crc_vc0[24:24];

        field {
            name = "mask_l_seq_di3";
            desc = "[inferred] Mask l seq di3. (vendor header `hi3516av100/mipi_reg.h` field `mask_l_seq_di3`; access and reset unknown, modelled RW)";
            sw = rw;
            hw = r;
        } mask_l_seq_di3[23:23];

        field {
            name = "mask_l_seq_di2";
            desc = "[inferred] Mask l seq di2. (vendor header `hi3516av100/mipi_reg.h` field `mask_l_seq_di2`; access and reset unknown, modelled RW)";
            sw = rw;
            hw = r;
        } mask_l_seq_di2[22:22];

        field {
            name = "mask_l_seq_di1";
            desc = "[inferred] Mask l seq di1. (vendor header `hi3516av100/mipi_reg.h` field `mask_l_seq_di1`; access and reset unknown, modelled RW)";
            sw = rw;
            hw = r;
        } mask_l_seq_di1[21:21];

        field {
            name = "mask_l_seq_di0";
            desc = "[inferred] Mask l seq di0. (vendor header `hi3516av100/mipi_reg.h` field `mask_l_seq_di0`; access and reset unknown, modelled RW)";
            sw = rw;
            hw = r;
        } mask_l_seq_di0[20:20];

        field {
            name = "mask_l_bndy_di3";
            desc = "[inferred] Mask l bndy di3. (vendor header `hi3516av100/mipi_reg.h` field `mask_l_bndy_di3`; access and reset unknown, modelled RW)";
            sw = rw;
            hw = r;
        } mask_l_bndy_di3[19:19];

        field {
            name = "mask_l_bndy_di2";
            desc = "[inferred] Mask l bndy di2. (vendor header `hi3516av100/mipi_reg.h` field `mask_l_bndy_di2`; access and reset unknown, modelled RW)";
            sw = rw;
            hw = r;
        } mask_l_bndy_di2[18:18];

        field {
            name = "mask_l_bndy_di1";
            desc = "[inferred] Mask l bndy di1. (vendor header `hi3516av100/mipi_reg.h` field `mask_l_bndy_di1`; access and reset unknown, modelled RW)";
            sw = rw;
            hw = r;
        } mask_l_bndy_di1[17:17];

        field {
            name = "mask_l_bndy_di0";
            desc = "[inferred] Mask l bndy di0. (vendor header `hi3516av100/mipi_reg.h` field `mask_l_bndy_di0`; access and reset unknown, modelled RW)";
            sw = rw;
            hw = r;
        } mask_l_bndy_di0[16:16];

        field {
            name = "mask_f_crc_vc3";
            desc = "[inferred] Mask f crc vc3. (vendor header `hi3516av100/mipi_reg.h` field `mask_f_crc_vc3`; access and reset unknown, modelled RW)";
            sw = rw;
            hw = r;
        } mask_f_crc_vc3[15:15];

        field {
            name = "mask_f_crc_vc2";
            desc = "[inferred] Mask f crc vc2. (vendor header `hi3516av100/mipi_reg.h` field `mask_f_crc_vc2`; access and reset unknown, modelled RW)";
            sw = rw;
            hw = r;
        } mask_f_crc_vc2[14:14];

        field {
            name = "mask_f_crc_vc1";
            desc = "[inferred] Mask f crc vc1. (vendor header `hi3516av100/mipi_reg.h` field `mask_f_crc_vc1`; access and reset unknown, modelled RW)";
            sw = rw;
            hw = r;
        } mask_f_crc_vc1[13:13];

        field {
            name = "mask_f_crc_vc0";
            desc = "[inferred] Mask f crc vc0. (vendor header `hi3516av100/mipi_reg.h` field `mask_f_crc_vc0`; access and reset unknown, modelled RW)";
            sw = rw;
            hw = r;
        } mask_f_crc_vc0[12:12];

        field {
            name = "mask_f_seq_vc3";
            desc = "[inferred] Mask f seq vc3. (vendor header `hi3516av100/mipi_reg.h` field `mask_f_seq_vc3`; access and reset unknown, modelled RW)";
            sw = rw;
            hw = r;
        } mask_f_seq_vc3[11:11];

        field {
            name = "mask_f_seq_vc2";
            desc = "[inferred] Mask f seq vc2. (vendor header `hi3516av100/mipi_reg.h` field `mask_f_seq_vc2`; access and reset unknown, modelled RW)";
            sw = rw;
            hw = r;
        } mask_f_seq_vc2[10:10];

        field {
            name = "mask_f_seq_vc1";
            desc = "[inferred] Mask f seq vc1. (vendor header `hi3516av100/mipi_reg.h` field `mask_f_seq_vc1`; access and reset unknown, modelled RW)";
            sw = rw;
            hw = r;
        } mask_f_seq_vc1[9:9];

        field {
            name = "mask_f_seq_vc0";
            desc = "[inferred] Mask f seq vc0. (vendor header `hi3516av100/mipi_reg.h` field `mask_f_seq_vc0`; access and reset unknown, modelled RW)";
            sw = rw;
            hw = r;
        } mask_f_seq_vc0[8:8];

        field {
            name = "mask_f_bndry_vc3";
            desc = "[inferred] Mask f bndry vc3. (vendor header `hi3516av100/mipi_reg.h` field `mask_f_bndry_vc3`; access and reset unknown, modelled RW)";
            sw = rw;
            hw = r;
        } mask_f_bndry_vc3[7:7];

        field {
            name = "mask_f_bndry_vc2";
            desc = "[inferred] Mask f bndry vc2. (vendor header `hi3516av100/mipi_reg.h` field `mask_f_bndry_vc2`; access and reset unknown, modelled RW)";
            sw = rw;
            hw = r;
        } mask_f_bndry_vc2[6:6];

        field {
            name = "mask_f_bndry_vc1";
            desc = "[inferred] Mask f bndry vc1. (vendor header `hi3516av100/mipi_reg.h` field `mask_f_bndry_vc1`; access and reset unknown, modelled RW)";
            sw = rw;
            hw = r;
        } mask_f_bndry_vc1[5:5];

        field {
            name = "mask_f_bndry_vc0";
            desc = "[inferred] Mask f bndry vc0. (vendor header `hi3516av100/mipi_reg.h` field `mask_f_bndry_vc0`; access and reset unknown, modelled RW)";
            sw = rw;
            hw = r;
        } mask_f_bndry_vc0[4:4];
    } MIPI_INTR1_MASK_LINK1 @ 0x1448;

    reg {
        name = "MIPI INTR2 MASK LINK1";
        desc = "[inferred] MIPI INTR2 MASK LINK1. Not in the data sheet. Source: OpenIPC openhisilicon `kernel/mipi_rx/hi3516av100/mipi_reg.h` (GPL-3.0 repository, HiSilicon copyright; local copy sources/openhisilicon), union `U_MIPI_INTR2_MASK`, struct offset 0x144C (GPL-3.0 repository, HiSilicon copyright; byte-identical to the hi3516cv200 file). Reset value and access type unknown (modelled RW, no reset). Confidence: medium (vendor header for this chip family, not hardware verified).";

        field {
            name = "intr_l_seq_di7";
            desc = "[inferred] Intr l seq di7. (vendor header `hi3516av100/mipi_reg.h` field `intr_l_seq_di7`; access and reset unknown, modelled RW)";
            sw = rw;
            hw = r;
        } intr_l_seq_di7[23:23];

        field {
            name = "intr_l_seq_di6";
            desc = "[inferred] Intr l seq di6. (vendor header `hi3516av100/mipi_reg.h` field `intr_l_seq_di6`; access and reset unknown, modelled RW)";
            sw = rw;
            hw = r;
        } intr_l_seq_di6[22:22];

        field {
            name = "intr_l_seq_di5";
            desc = "[inferred] Intr l seq di5. (vendor header `hi3516av100/mipi_reg.h` field `intr_l_seq_di5`; access and reset unknown, modelled RW)";
            sw = rw;
            hw = r;
        } intr_l_seq_di5[21:21];

        field {
            name = "intr_l_seq_di4";
            desc = "[inferred] Intr l seq di4. (vendor header `hi3516av100/mipi_reg.h` field `intr_l_seq_di4`; access and reset unknown, modelled RW)";
            sw = rw;
            hw = r;
        } intr_l_seq_di4[20:20];

        field {
            name = "intr_l_bndry_di7";
            desc = "[inferred] Intr l bndry di7. (vendor header `hi3516av100/mipi_reg.h` field `intr_l_bndry_di7`; access and reset unknown, modelled RW)";
            sw = rw;
            hw = r;
        } intr_l_bndry_di7[19:19];

        field {
            name = "intr_l_bndry_di6";
            desc = "[inferred] Intr l bndry di6. (vendor header `hi3516av100/mipi_reg.h` field `intr_l_bndry_di6`; access and reset unknown, modelled RW)";
            sw = rw;
            hw = r;
        } intr_l_bndry_di6[18:18];

        field {
            name = "intr_l_bndry_di5";
            desc = "[inferred] Intr l bndry di5. (vendor header `hi3516av100/mipi_reg.h` field `intr_l_bndry_di5`; access and reset unknown, modelled RW)";
            sw = rw;
            hw = r;
        } intr_l_bndry_di5[17:17];

        field {
            name = "intr_l_bndry_di4";
            desc = "[inferred] Intr l bndry di4. (vendor header `hi3516av100/mipi_reg.h` field `intr_l_bndry_di4`; access and reset unknown, modelled RW)";
            sw = rw;
            hw = r;
        } intr_l_bndry_di4[16:16];

        field {
            name = "intr_err_id_vc3";
            desc = "[inferred] Intr error id vc3. (vendor header `hi3516av100/mipi_reg.h` field `intr_err_id_vc3`; access and reset unknown, modelled RW)";
            sw = rw;
            hw = r;
        } intr_err_id_vc3[15:15];

        field {
            name = "intr_err_id_vc2";
            desc = "[inferred] Intr error id vc2. (vendor header `hi3516av100/mipi_reg.h` field `intr_err_id_vc2`; access and reset unknown, modelled RW)";
            sw = rw;
            hw = r;
        } intr_err_id_vc2[14:14];

        field {
            name = "intr_err_id_vc1";
            desc = "[inferred] Intr error id vc1. (vendor header `hi3516av100/mipi_reg.h` field `intr_err_id_vc1`; access and reset unknown, modelled RW)";
            sw = rw;
            hw = r;
        } intr_err_id_vc1[13:13];

        field {
            name = "intr_err_id_vc0";
            desc = "[inferred] Intr error id vc0. (vendor header `hi3516av100/mipi_reg.h` field `intr_err_id_vc0`; access and reset unknown, modelled RW)";
            sw = rw;
            hw = r;
        } intr_err_id_vc0[12:12];

        field {
            name = "intr_vc3_ecc_corrected";
            desc = "[inferred] Intr vc3 ecc corrected. (vendor header `hi3516av100/mipi_reg.h` field `intr_vc3_ecc_corrected`; access and reset unknown, modelled RW)";
            sw = rw;
            hw = r;
        } intr_vc3_ecc_corrected[11:11];

        field {
            name = "intr_vc2_ecc_corrected";
            desc = "[inferred] Intr vc2 ecc corrected. (vendor header `hi3516av100/mipi_reg.h` field `intr_vc2_ecc_corrected`; access and reset unknown, modelled RW)";
            sw = rw;
            hw = r;
        } intr_vc2_ecc_corrected[10:10];

        field {
            name = "intr_vc1_ecc_corrected";
            desc = "[inferred] Intr vc1 ecc corrected. (vendor header `hi3516av100/mipi_reg.h` field `intr_vc1_ecc_corrected`; access and reset unknown, modelled RW)";
            sw = rw;
            hw = r;
        } intr_vc1_ecc_corrected[9:9];

        field {
            name = "intr_vc0_ecc_corrected";
            desc = "[inferred] Intr vc0 ecc corrected. (vendor header `hi3516av100/mipi_reg.h` field `intr_vc0_ecc_corrected`; access and reset unknown, modelled RW)";
            sw = rw;
            hw = r;
        } intr_vc0_ecc_corrected[8:8];
    } MIPI_INTR2_MASK_LINK1 @ 0x144C;

    reg {
        name = "MIPI TIMEOUT LINK1";
        desc = "[inferred] MIPI TIMEOUT LINK1. Not in the data sheet. Source: OpenIPC openhisilicon `kernel/mipi_rx/hi3516av100/mipi_reg.h` (GPL-3.0 repository, HiSilicon copyright; local copy sources/openhisilicon), union `U_MIPI_TIMEOUT`, struct offset 0x1460 (GPL-3.0 repository, HiSilicon copyright; byte-identical to the hi3516cv200 file). Reset value and access type unknown (modelled RW, no reset). Confidence: medium (vendor header for this chip family, not hardware verified).";

        field {
            name = "timeout_en_d";
            desc = "[inferred] Timeout enable d. (vendor header `hi3516av100/mipi_reg.h` field `timeout_en_d`; access and reset unknown, modelled RW)";
            sw = rw;
            hw = r;
        } timeout_en_d[31:31];

        field {
            name = "timeout_en_ck";
            desc = "[inferred] Timeout enable ck. (vendor header `hi3516av100/mipi_reg.h` field `timeout_en_ck`; access and reset unknown, modelled RW)";
            sw = rw;
            hw = r;
        } timeout_en_ck[30:30];

        field {
            name = "timeout_param";
            desc = "[inferred] Timeout param. (vendor header `hi3516av100/mipi_reg.h` field `timeout_param`; access and reset unknown, modelled RW)";
            sw = rw;
            hw = r;
        } timeout_param[23:0];
    } MIPI_TIMEOUT_LINK1 @ 0x1460;

    reg {
        name = "MIPI FSM PARAM LINK1";
        desc = "[inferred] MIPI FSM PARAM LINK1. Not in the data sheet. Source: OpenIPC openhisilicon `kernel/mipi_rx/hi3516av100/mipi_reg.h` (GPL-3.0 repository, HiSilicon copyright; local copy sources/openhisilicon), union `U_MIPI_FSM_PARAM`, struct offset 0x1464 (GPL-3.0 repository, HiSilicon copyright; byte-identical to the hi3516cv200 file). Reset value and access type unknown (modelled RW, no reset). Confidence: medium (vendor header for this chip family, not hardware verified).";

        field {
            name = "cyc_clk_hs0";
            desc = "[inferred] Cyc clk hs0. (vendor header `hi3516av100/mipi_reg.h` field `cyc_clk_hs0`; access and reset unknown, modelled RW)";
            sw = rw;
            hw = r;
        } cyc_clk_hs0[29:24];

        field {
            name = "cyc_clk_lp00";
            desc = "[inferred] Cyc clk lp00. (vendor header `hi3516av100/mipi_reg.h` field `cyc_clk_lp00`; access and reset unknown, modelled RW)";
            sw = rw;
            hw = r;
        } cyc_clk_lp00[21:16];

        field {
            name = "cyc_data_hs0";
            desc = "[inferred] Cyc data hs0. (vendor header `hi3516av100/mipi_reg.h` field `cyc_data_hs0`; access and reset unknown, modelled RW)";
            sw = rw;
            hw = r;
        } cyc_data_hs0[13:8];

        field {
            name = "cyc_data_lp00";
            desc = "[inferred] Cyc data lp00. (vendor header `hi3516av100/mipi_reg.h` field `cyc_data_lp00`; access and reset unknown, modelled RW)";
            sw = rw;
            hw = r;
        } cyc_data_lp00[5:0];
    } MIPI_FSM_PARAM_LINK1 @ 0x1464;

    reg {
        name = "MIPI FSM CKEN LINK1";
        desc = "[inferred] MIPI FSM CKEN LINK1. Not in the data sheet. Source: OpenIPC openhisilicon `kernel/mipi_rx/hi3516av100/mipi_reg.h` (GPL-3.0 repository, HiSilicon copyright; local copy sources/openhisilicon), union `U_MIPI_FSM_CKEN`, struct offset 0x1468 (GPL-3.0 repository, HiSilicon copyright; byte-identical to the hi3516cv200 file). Reset value and access type unknown (modelled RW, no reset). Confidence: medium (vendor header for this chip family, not hardware verified).";

        field {
            name = "mipi_d3_cken";
            desc = "[inferred] Mipi d3 cken. (vendor header `hi3516av100/mipi_reg.h` field `mipi_d3_cken`; access and reset unknown, modelled RW)";
            sw = rw;
            hw = r;
        } mipi_d3_cken[7:7];

        field {
            name = "mipi_d2_cken";
            desc = "[inferred] Mipi d2 cken. (vendor header `hi3516av100/mipi_reg.h` field `mipi_d2_cken`; access and reset unknown, modelled RW)";
            sw = rw;
            hw = r;
        } mipi_d2_cken[6:6];

        field {
            name = "mipi_d1_cken";
            desc = "[inferred] Mipi d1 cken. (vendor header `hi3516av100/mipi_reg.h` field `mipi_d1_cken`; access and reset unknown, modelled RW)";
            sw = rw;
            hw = r;
        } mipi_d1_cken[5:5];

        field {
            name = "mipi_d0_cken";
            desc = "[inferred] Mipi d0 cken. (vendor header `hi3516av100/mipi_reg.h` field `mipi_d0_cken`; access and reset unknown, modelled RW)";
            sw = rw;
            hw = r;
        } mipi_d0_cken[4:4];

        field {
            name = "mipi_ck_cken";
            desc = "[inferred] Mipi ck cken. (vendor header `hi3516av100/mipi_reg.h` field `mipi_ck_cken`; access and reset unknown, modelled RW)";
            sw = rw;
            hw = r;
        } mipi_ck_cken[0:0];
    } MIPI_FSM_CKEN_LINK1 @ 0x1468;

    reg {
        name = "SOF synchronization code configuration _01 register for lane 0 in LVDS or HiSPI mode";
        desc = "LINK1_LANE0_SOF_01 is an SOF synchronization code configuration register for lane 0 in LVDS or HiSPI mode. Huawei Proprietary and Confidential Hi3516A/Hi3516D Professional HD IP Camera SoC

Data sheet 10.3.6 LINK1_LANE0_SOF_01 (offset 0x1480, printed page 10-327, `hi3516av100--Hi3516A-Hi3516D-Datasheet.txt` line 77165).";

        field {
            name = "lane0_sof_1";
            desc = "SOF synchronization code of frame 1 for lane 0 in LVDS or HiSPI mode. The field is configurable only in WDR mode, and the configuration is invalid in linear mode.";
            sw = rw;
            hw = r;
            reset = 0x0;
        } lane0_sof_1[31:16];

        field {
            name = "lane0_sof_0";
            desc = "SOF synchronization code of frame 0 for lane 0 in LVDS or HiSPI mode. In WDR mode, the value is the SOF of frame 0. In linear mode, the value is the SOF.";
            sw = rw;
            hw = r;
            reset = 0x0;
        } lane0_sof_0[15:0];
    } LINK1_LANE0_SOF_01 @ 0x1480;

    reg {
        name = "LINK1 LANE0 SOF 23";
        desc = "[inferred] LINK1 LANE0 SOF 23. Not in the data sheet. Source: OpenIPC openhisilicon `kernel/mipi_rx/hi3516av100/mipi_reg.h` (GPL-3.0 repository, HiSilicon copyright; local copy sources/openhisilicon), union `U_LINK_LANE_SOF_23`, struct offset 0x1484 (GPL-3.0 repository, HiSilicon copyright; byte-identical to the hi3516cv200 file). Reset value and access type unknown (modelled RW, no reset). Confidence: medium (vendor header for this chip family, not hardware verified).";

        field {
            name = "lane0_sof_3";
            desc = "[inferred] Lane0 sof 3. (vendor header `hi3516av100/mipi_reg.h` field `lane0_sof_3`; access and reset unknown, modelled RW)";
            sw = rw;
            hw = r;
        } lane0_sof_3[31:16];

        field {
            name = "lane0_sof_2";
            desc = "[inferred] Lane0 sof 2. (vendor header `hi3516av100/mipi_reg.h` field `lane0_sof_2`; access and reset unknown, modelled RW)";
            sw = rw;
            hw = r;
        } lane0_sof_2[15:0];
    } LINK1_LANE0_SOF_23 @ 0x1484;

    reg {
        name = "EOF synchronization code configuration _01 register for lane 0 in LVDS or HiSPI mode";
        desc = "LINK1_LANE0_EOF_01 is an EOF synchronization code configuration register for lane 0 in LVDS or HiSPI mode.

Data sheet 10.3.6 LINK1_LANE0_EOF_01 (offset 0x1488, printed page 10-327, `hi3516av100--Hi3516A-Hi3516D-Datasheet.txt` line 77193).";

        field {
            name = "lane0_eof_1";
            desc = "EOF synchronization code of frame 1 for lane 0 in LVDS or HiSPI mode. The field is configurable only in WDR mode, and the configuration is invalid in linear mode.";
            sw = rw;
            hw = r;
            reset = 0x0;
        } lane0_eof_1[31:16];

        field {
            name = "lane0_eof_0";
            desc = "EOF synchronization code of frame 0 for lane 0 in LVDS or HiSPI mode. In WDR mode, the value is the EOF of frame 0. In linear mode, the value is the EOF.";
            sw = rw;
            hw = r;
            reset = 0x0;
        } lane0_eof_0[15:0];
    } LINK1_LANE0_EOF_01 @ 0x1488;

    reg {
        name = "LINK1 LANE0 EOF 23";
        desc = "[inferred] LINK1 LANE0 EOF 23. Not in the data sheet. Source: OpenIPC openhisilicon `kernel/mipi_rx/hi3516av100/mipi_reg.h` (GPL-3.0 repository, HiSilicon copyright; local copy sources/openhisilicon), union `U_LINK_LANE_EOF_23`, struct offset 0x148C (GPL-3.0 repository, HiSilicon copyright; byte-identical to the hi3516cv200 file). Reset value and access type unknown (modelled RW, no reset). Confidence: medium (vendor header for this chip family, not hardware verified).";

        field {
            name = "lane0_eof_3";
            desc = "[inferred] Lane0 eof 3. (vendor header `hi3516av100/mipi_reg.h` field `lane0_eof_3`; access and reset unknown, modelled RW)";
            sw = rw;
            hw = r;
        } lane0_eof_3[31:16];

        field {
            name = "lane0_eof_2";
            desc = "[inferred] Lane0 eof 2. (vendor header `hi3516av100/mipi_reg.h` field `lane0_eof_2`; access and reset unknown, modelled RW)";
            sw = rw;
            hw = r;
        } lane0_eof_2[15:0];
    } LINK1_LANE0_EOF_23 @ 0x148C;

    reg {
        name = "SOL synchronization code configuration _01 register for lane 0 in LVDS or HiSPI mode.";
        desc = "LINK1_LANE0_SOL_01 is an SOL synchronization code configuration register for lane 0 in LVDS or HiSPI mode. Huawei Proprietary and Confidential Hi3516A/Hi3516D Professional HD IP Camera SoC

Data sheet 10.3.6 LINK1_LANE0_SOL_01 (offset 0x1490, printed page 10-328, `hi3516av100--Hi3516A-Hi3516D-Datasheet.txt` line 77229).";

        field {
            name = "lane0_sol_1";
            desc = "SOL synchronization code of frame 1 for lane 0 in LVDS or HiSPI mode. The field is configurable only in WDR mode, and the configuration is invalid in linear mode.";
            sw = rw;
            hw = r;
            reset = 0x0;
        } lane0_sol_1[31:16];

        field {
            name = "lane0_sol_0";
            desc = "SOL synchronization code of frame 0 for lane 0 in LVDS or HiSPI mode. In WDR mode, the value is the SOL of frame 0. In linear mode, the value is the SOL.";
            sw = rw;
            hw = r;
            reset = 0x0;
        } lane0_sol_0[15:0];
    } LINK1_LANE0_SOL_01 @ 0x1490;

    reg {
        name = "LINK1 LANE0 SOL 23";
        desc = "[inferred] LINK1 LANE0 SOL 23. Not in the data sheet. Source: OpenIPC openhisilicon `kernel/mipi_rx/hi3516av100/mipi_reg.h` (GPL-3.0 repository, HiSilicon copyright; local copy sources/openhisilicon), union `U_LINK_LANE_SOL_23`, struct offset 0x1494 (GPL-3.0 repository, HiSilicon copyright; byte-identical to the hi3516cv200 file). Reset value and access type unknown (modelled RW, no reset). Confidence: medium (vendor header for this chip family, not hardware verified).";

        field {
            name = "lane0_sol_3";
            desc = "[inferred] Lane0 sol 3. (vendor header `hi3516av100/mipi_reg.h` field `lane0_sol_3`; access and reset unknown, modelled RW)";
            sw = rw;
            hw = r;
        } lane0_sol_3[31:16];

        field {
            name = "lane0_sol_2";
            desc = "[inferred] Lane0 sol 2. (vendor header `hi3516av100/mipi_reg.h` field `lane0_sol_2`; access and reset unknown, modelled RW)";
            sw = rw;
            hw = r;
        } lane0_sol_2[15:0];
    } LINK1_LANE0_SOL_23 @ 0x1494;

    reg {
        name = "EOL synchronization code configuration L_01 register for lane 0 in LVDS or HiSPI mode";
        desc = "LINK1_LANE0_EOL_01 is an EOL synchronization code configuration register for lane 0 in LVDS or HiSPI mode.

Data sheet 10.3.6 LINK1_LANE0_EOL_01 (offset 0x1498, printed page 10-328, `hi3516av100--Hi3516A-Hi3516D-Datasheet.txt` line 77257).";

        field {
            name = "lane0_eol_1";
            desc = "EOL synchronization code of frame 1 for lane 0 in LVDS or HiSPI mode. The field is configurable only in WDR mode, and the configuration is invalid in linear mode.";
            sw = rw;
            hw = r;
            reset = 0x0;
        } lane0_eol_1[31:16];

        field {
            name = "lane0_eol_0";
            desc = "EOL synchronization code of frame 0 for lane 0 in LVDS or HiSPI mode. In WDR mode, the value is the EOL of frame 0. In linear mode, the value is the EOL.";
            sw = rw;
            hw = r;
            reset = 0x0;
        } lane0_eol_0[15:0];
    } LINK1_LANE0_EOL_01 @ 0x1498;

    reg {
        name = "LINK1 LANE0 EOL 23";
        desc = "[inferred] LINK1 LANE0 EOL 23. Not in the data sheet. Source: OpenIPC openhisilicon `kernel/mipi_rx/hi3516av100/mipi_reg.h` (GPL-3.0 repository, HiSilicon copyright; local copy sources/openhisilicon), union `U_LINK_LANE_EOL_23`, struct offset 0x149C (GPL-3.0 repository, HiSilicon copyright; byte-identical to the hi3516cv200 file). Reset value and access type unknown (modelled RW, no reset). Confidence: medium (vendor header for this chip family, not hardware verified).";

        field {
            name = "lane0_eol_3";
            desc = "[inferred] Lane0 eol 3. (vendor header `hi3516av100/mipi_reg.h` field `lane0_eol_3`; access and reset unknown, modelled RW)";
            sw = rw;
            hw = r;
        } lane0_eol_3[31:16];

        field {
            name = "lane0_eol_2";
            desc = "[inferred] Lane0 eol 2. (vendor header `hi3516av100/mipi_reg.h` field `lane0_eol_2`; access and reset unknown, modelled RW)";
            sw = rw;
            hw = r;
        } lane0_eol_2[15:0];
    } LINK1_LANE0_EOL_23 @ 0x149C;

    reg {
        name = "SOF synchronization code configuration _01 register for lane 1 in LVDS or HiSPI mode";
        desc = "LINK1_LANE1_SOF_01 is an SOF synchronization code configuration register for lane 1 in LVDS or HiSPI mode. Huawei Proprietary and Confidential Hi3516A/Hi3516D Professional HD IP Camera SoC

Data sheet 10.3.6 LINK1_LANE1_SOF_01 (offset 0x14A0, printed page 10-329, `hi3516av100--Hi3516A-Hi3516D-Datasheet.txt` line 77293).";

        field {
            name = "lane1_sof_1";
            desc = "SOF synchronization code of frame 1 for lane 1 in LVDS or HiSPI mode. The field is configurable only in WDR mode, and the configuration is invalid in linear mode.";
            sw = rw;
            hw = r;
            reset = 0x0;
        } lane1_sof_1[31:16];

        field {
            name = "lane1_sof_0";
            desc = "SOF synchronization code of frame 0 for lane 1 in LVDS or HiSPI mode. In WDR mode, the value is the SOF of frame 0. In linear mode, the value is the SOF.";
            sw = rw;
            hw = r;
            reset = 0x0;
        } lane1_sof_0[15:0];
    } LINK1_LANE1_SOF_01 @ 0x14A0;

    reg {
        name = "LINK1 LANE1 SOF 23";
        desc = "[inferred] LINK1 LANE1 SOF 23. Not in the data sheet. Source: OpenIPC openhisilicon `kernel/mipi_rx/hi3516av100/mipi_reg.h` (GPL-3.0 repository, HiSilicon copyright; local copy sources/openhisilicon), union `U_LINK_LANE_SOF_23`, struct offset 0x14A4 (GPL-3.0 repository, HiSilicon copyright; byte-identical to the hi3516cv200 file). Reset value and access type unknown (modelled RW, no reset). Confidence: medium (vendor header for this chip family, not hardware verified).";

        field {
            name = "lane0_sof_3";
            desc = "[inferred] Lane0 sof 3. (vendor header `hi3516av100/mipi_reg.h` field `lane0_sof_3`; access and reset unknown, modelled RW)";
            sw = rw;
            hw = r;
        } lane0_sof_3[31:16];

        field {
            name = "lane0_sof_2";
            desc = "[inferred] Lane0 sof 2. (vendor header `hi3516av100/mipi_reg.h` field `lane0_sof_2`; access and reset unknown, modelled RW)";
            sw = rw;
            hw = r;
        } lane0_sof_2[15:0];
    } LINK1_LANE1_SOF_23 @ 0x14A4;

    reg {
        name = "EOF synchronization code configuration _01 register for lane 1 in LVDS or HiSPI mode";
        desc = "LINK1_LANE1_EOF_01 is an EOF synchronization code configuration register for lane 1 in LVDS or HiSPI mode.

Data sheet 10.3.6 LINK1_LANE1_EOF_01 (offset 0x14A8, printed page 10-329, `hi3516av100--Hi3516A-Hi3516D-Datasheet.txt` line 77321).";

        field {
            name = "lane1_eof_1";
            desc = "EOF synchronization code of frame 1 for lane 1 in LVDS or HiSPI mode. The field is configurable only in WDR mode, and the configuration is invalid in linear mode.";
            sw = rw;
            hw = r;
            reset = 0x0;
        } lane1_eof_1[31:16];

        field {
            name = "lane1_eof_0";
            desc = "EOF synchronization code of frame 0 for lane 1 in LVDS or HiSPI mode. In WDR mode, the value is the EOF of frame 0. In linear mode, the value is the EOF.";
            sw = rw;
            hw = r;
            reset = 0x0;
        } lane1_eof_0[15:0];
    } LINK1_LANE1_EOF_01 @ 0x14A8;

    reg {
        name = "LINK1 LANE1 EOF 23";
        desc = "[inferred] LINK1 LANE1 EOF 23. Not in the data sheet. Source: OpenIPC openhisilicon `kernel/mipi_rx/hi3516av100/mipi_reg.h` (GPL-3.0 repository, HiSilicon copyright; local copy sources/openhisilicon), union `U_LINK_LANE_EOF_23`, struct offset 0x14AC (GPL-3.0 repository, HiSilicon copyright; byte-identical to the hi3516cv200 file). Reset value and access type unknown (modelled RW, no reset). Confidence: medium (vendor header for this chip family, not hardware verified).";

        field {
            name = "lane0_eof_3";
            desc = "[inferred] Lane0 eof 3. (vendor header `hi3516av100/mipi_reg.h` field `lane0_eof_3`; access and reset unknown, modelled RW)";
            sw = rw;
            hw = r;
        } lane0_eof_3[31:16];

        field {
            name = "lane0_eof_2";
            desc = "[inferred] Lane0 eof 2. (vendor header `hi3516av100/mipi_reg.h` field `lane0_eof_2`; access and reset unknown, modelled RW)";
            sw = rw;
            hw = r;
        } lane0_eof_2[15:0];
    } LINK1_LANE1_EOF_23 @ 0x14AC;

    reg {
        name = "SOL synchronization code configuration _01 register for lane 1 in LVDS or HiSPI mode.";
        desc = "LINK1_LANE1_SOL_01 is an SOL synchronization code configuration register for lane 1 in LVDS or HiSPI mode. Huawei Proprietary and Confidential Hi3516A/Hi3516D Professional HD IP Camera SoC

Data sheet 10.3.6 LINK1_LANE1_SOL_01 (offset 0x14B0, printed page 10-330, `hi3516av100--Hi3516A-Hi3516D-Datasheet.txt` line 77357).";

        field {
            name = "lane1_sol_1";
            desc = "SOL synchronization code of frame 1 for lane 1 in LVDS or HiSPI mode. The field is configurable only in WDR mode, and the configuration is invalid in linear mode.";
            sw = rw;
            hw = r;
            reset = 0x0;
        } lane1_sol_1[31:16];

        field {
            name = "lane1_sol_0";
            desc = "SOL synchronization code of frame 0 for lane 1 in LVDS or HiSPI mode. In WDR mode, the value is the SOL of frame 0. In linear mode, the value is the SOL.";
            sw = rw;
            hw = r;
            reset = 0x0;
        } lane1_sol_0[15:0];
    } LINK1_LANE1_SOL_01 @ 0x14B0;

    reg {
        name = "LINK1 LANE1 SOL 23";
        desc = "[inferred] LINK1 LANE1 SOL 23. Not in the data sheet. Source: OpenIPC openhisilicon `kernel/mipi_rx/hi3516av100/mipi_reg.h` (GPL-3.0 repository, HiSilicon copyright; local copy sources/openhisilicon), union `U_LINK_LANE_SOL_23`, struct offset 0x14B4 (GPL-3.0 repository, HiSilicon copyright; byte-identical to the hi3516cv200 file). Reset value and access type unknown (modelled RW, no reset). Confidence: medium (vendor header for this chip family, not hardware verified).";

        field {
            name = "lane0_sol_3";
            desc = "[inferred] Lane0 sol 3. (vendor header `hi3516av100/mipi_reg.h` field `lane0_sol_3`; access and reset unknown, modelled RW)";
            sw = rw;
            hw = r;
        } lane0_sol_3[31:16];

        field {
            name = "lane0_sol_2";
            desc = "[inferred] Lane0 sol 2. (vendor header `hi3516av100/mipi_reg.h` field `lane0_sol_2`; access and reset unknown, modelled RW)";
            sw = rw;
            hw = r;
        } lane0_sol_2[15:0];
    } LINK1_LANE1_SOL_23 @ 0x14B4;

    reg {
        name = "EOL synchronization code configuration L_01 register for lane 1 in LVDS or HiSPI mode";
        desc = "LINK1_LANE1_EOL_01 is an EOL synchronization code configuration register for lane 1 in LVDS or HiSPI mode.

Data sheet 10.3.6 LINK1_LANE1_EOL_01 (offset 0x14B8, printed page 10-330, `hi3516av100--Hi3516A-Hi3516D-Datasheet.txt` line 77385).";

        field {
            name = "lane1_eol_1";
            desc = "EOL synchronization code of frame 1 for lane 1 in LVDS or HiSPI mode. The field is configurable only in WDR mode, and the configuration is invalid in linear mode.";
            sw = rw;
            hw = r;
            reset = 0x0;
        } lane1_eol_1[31:16];

        field {
            name = "lane1_eol_0";
            desc = "EOL synchronization code of frame 0 for lane 1 in LVDS or HiSPI mode. In WDR mode, the value is the EOL of frame 0. In linear mode, the value is the EOL.";
            sw = rw;
            hw = r;
            reset = 0x0;
        } lane1_eol_0[15:0];
    } LINK1_LANE1_EOL_01 @ 0x14B8;

    reg {
        name = "LINK1 LANE1 EOL 23";
        desc = "[inferred] LINK1 LANE1 EOL 23. Not in the data sheet. Source: OpenIPC openhisilicon `kernel/mipi_rx/hi3516av100/mipi_reg.h` (GPL-3.0 repository, HiSilicon copyright; local copy sources/openhisilicon), union `U_LINK_LANE_EOL_23`, struct offset 0x14BC (GPL-3.0 repository, HiSilicon copyright; byte-identical to the hi3516cv200 file). Reset value and access type unknown (modelled RW, no reset). Confidence: medium (vendor header for this chip family, not hardware verified).";

        field {
            name = "lane0_eol_3";
            desc = "[inferred] Lane0 eol 3. (vendor header `hi3516av100/mipi_reg.h` field `lane0_eol_3`; access and reset unknown, modelled RW)";
            sw = rw;
            hw = r;
        } lane0_eol_3[31:16];

        field {
            name = "lane0_eol_2";
            desc = "[inferred] Lane0 eol 2. (vendor header `hi3516av100/mipi_reg.h` field `lane0_eol_2`; access and reset unknown, modelled RW)";
            sw = rw;
            hw = r;
        } lane0_eol_2[15:0];
    } LINK1_LANE1_EOL_23 @ 0x14BC;

    reg {
        name = "SOF synchronization code configuration _01 register for lane 2 in LVDS or HiSPI mode";
        desc = "LINK1_LANE2_SOF_01 is an SOF synchronization code configuration register for lane 2 in LVDS or HiSPI mode. Huawei Proprietary and Confidential Hi3516A/Hi3516D Professional HD IP Camera SoC

Data sheet 10.3.6 LINK1_LANE2_SOF_01 (offset 0x14C0, printed page 10-331, `hi3516av100--Hi3516A-Hi3516D-Datasheet.txt` line 77421).";

        field {
            name = "lane2_sof_1";
            desc = "SOF synchronization code of frame 1 for lane 2 in LVDS or HiSPI mode. The field is configurable only in WDR mode, and the configuration is invalid in linear mode.";
            sw = rw;
            hw = r;
            reset = 0x0;
        } lane2_sof_1[31:16];

        field {
            name = "lane2_sof_0";
            desc = "SOF synchronization code of frame 0 for lane 2 in LVDS or HiSPI mode. In WDR mode, the value is the SOF of frame 0. In linear mode, the value is the SOF.";
            sw = rw;
            hw = r;
            reset = 0x0;
        } lane2_sof_0[15:0];
    } LINK1_LANE2_SOF_01 @ 0x14C0;

    reg {
        name = "LINK1 LANE2 SOF 23";
        desc = "[inferred] LINK1 LANE2 SOF 23. Not in the data sheet. Source: OpenIPC openhisilicon `kernel/mipi_rx/hi3516av100/mipi_reg.h` (GPL-3.0 repository, HiSilicon copyright; local copy sources/openhisilicon), union `U_LINK_LANE_SOF_23`, struct offset 0x14C4 (GPL-3.0 repository, HiSilicon copyright; byte-identical to the hi3516cv200 file). Reset value and access type unknown (modelled RW, no reset). Confidence: medium (vendor header for this chip family, not hardware verified).";

        field {
            name = "lane0_sof_3";
            desc = "[inferred] Lane0 sof 3. (vendor header `hi3516av100/mipi_reg.h` field `lane0_sof_3`; access and reset unknown, modelled RW)";
            sw = rw;
            hw = r;
        } lane0_sof_3[31:16];

        field {
            name = "lane0_sof_2";
            desc = "[inferred] Lane0 sof 2. (vendor header `hi3516av100/mipi_reg.h` field `lane0_sof_2`; access and reset unknown, modelled RW)";
            sw = rw;
            hw = r;
        } lane0_sof_2[15:0];
    } LINK1_LANE2_SOF_23 @ 0x14C4;

    reg {
        name = "EOF synchronization code configuration _01 register for lane 2 in LVDS or HiSPI mode";
        desc = "LINK1_LANE2_EOF_01 is an EOF synchronization code configuration register for lane 2 in LVDS or HiSPI mode.

Data sheet 10.3.6 LINK1_LANE2_EOF_01 (offset 0x14C8, printed page 10-331, `hi3516av100--Hi3516A-Hi3516D-Datasheet.txt` line 77449).";

        field {
            name = "lane2_eof_1";
            desc = "EOF synchronization code of frame 1 for lane 2 in LVDS or HiSPI mode. The field is configurable only in WDR mode, and the configuration is invalid in linear mode.";
            sw = rw;
            hw = r;
            reset = 0x0;
        } lane2_eof_1[31:16];

        field {
            name = "lane2_eof_0";
            desc = "EOF synchronization code of frame 0 for lane 2 in LVDS or HiSPI mode. In WDR mode, the value is the EOF of frame 0. In linear mode, the value is the EOF.";
            sw = rw;
            hw = r;
            reset = 0x0;
        } lane2_eof_0[15:0];
    } LINK1_LANE2_EOF_01 @ 0x14C8;

    reg {
        name = "LINK1 LANE2 EOF 23";
        desc = "[inferred] LINK1 LANE2 EOF 23. Not in the data sheet. Source: OpenIPC openhisilicon `kernel/mipi_rx/hi3516av100/mipi_reg.h` (GPL-3.0 repository, HiSilicon copyright; local copy sources/openhisilicon), union `U_LINK_LANE_EOF_23`, struct offset 0x14CC (GPL-3.0 repository, HiSilicon copyright; byte-identical to the hi3516cv200 file). Reset value and access type unknown (modelled RW, no reset). Confidence: medium (vendor header for this chip family, not hardware verified).";

        field {
            name = "lane0_eof_3";
            desc = "[inferred] Lane0 eof 3. (vendor header `hi3516av100/mipi_reg.h` field `lane0_eof_3`; access and reset unknown, modelled RW)";
            sw = rw;
            hw = r;
        } lane0_eof_3[31:16];

        field {
            name = "lane0_eof_2";
            desc = "[inferred] Lane0 eof 2. (vendor header `hi3516av100/mipi_reg.h` field `lane0_eof_2`; access and reset unknown, modelled RW)";
            sw = rw;
            hw = r;
        } lane0_eof_2[15:0];
    } LINK1_LANE2_EOF_23 @ 0x14CC;

    reg {
        name = "SOL synchronization code configuration _01 register for lane 2 in LVDS or HiSPI mode.";
        desc = "LINK1_LANE2_SOL_01 is an SOL synchronization code configuration register for lane 2 in LVDS or HiSPI mode. Huawei Proprietary and Confidential Hi3516A/Hi3516D Professional HD IP Camera SoC

Data sheet 10.3.6 LINK1_LANE2_SOL_01 (offset 0x14D0, printed page 10-332, `hi3516av100--Hi3516A-Hi3516D-Datasheet.txt` line 77485).";

        field {
            name = "lane2_sol_1";
            desc = "SOL synchronization code of frame 1 for lane 2 in LVDS or HiSPI mode. The field is configurable only in WDR mode, and the configuration is invalid in linear mode.";
            sw = rw;
            hw = r;
            reset = 0x0;
        } lane2_sol_1[31:16];

        field {
            name = "lane2_sol_0";
            desc = "SOL synchronization code of frame 0 for lane 2 in LVDS or HiSPI mode. In WDR mode, the value is the SOL of frame 0. In linear mode, the value is the SOL.";
            sw = rw;
            hw = r;
            reset = 0x0;
        } lane2_sol_0[15:0];
    } LINK1_LANE2_SOL_01 @ 0x14D0;

    reg {
        name = "LINK1 LANE2 SOL 23";
        desc = "[inferred] LINK1 LANE2 SOL 23. Not in the data sheet. Source: OpenIPC openhisilicon `kernel/mipi_rx/hi3516av100/mipi_reg.h` (GPL-3.0 repository, HiSilicon copyright; local copy sources/openhisilicon), union `U_LINK_LANE_SOL_23`, struct offset 0x14D4 (GPL-3.0 repository, HiSilicon copyright; byte-identical to the hi3516cv200 file). Reset value and access type unknown (modelled RW, no reset). Confidence: medium (vendor header for this chip family, not hardware verified).";

        field {
            name = "lane0_sol_3";
            desc = "[inferred] Lane0 sol 3. (vendor header `hi3516av100/mipi_reg.h` field `lane0_sol_3`; access and reset unknown, modelled RW)";
            sw = rw;
            hw = r;
        } lane0_sol_3[31:16];

        field {
            name = "lane0_sol_2";
            desc = "[inferred] Lane0 sol 2. (vendor header `hi3516av100/mipi_reg.h` field `lane0_sol_2`; access and reset unknown, modelled RW)";
            sw = rw;
            hw = r;
        } lane0_sol_2[15:0];
    } LINK1_LANE2_SOL_23 @ 0x14D4;

    reg {
        name = "EOL synchronization code configuration L_01 register for lane 2 in LVDS or HiSPI mode";
        desc = "LINK1_LANE2_EOL_01 is an EOL synchronization code configuration register for lane 2 in LVDS or HiSPI mode.

Data sheet 10.3.6 LINK1_LANE2_EOL_01 (offset 0x14D8, printed page 10-332, `hi3516av100--Hi3516A-Hi3516D-Datasheet.txt` line 77513).";

        field {
            name = "lane2_eol_1";
            desc = "EOL synchronization code of frame 1 for lane 2 in LVDS or HiSPI mode. The field is configurable only in WDR mode, and the configuration is invalid in linear mode.";
            sw = rw;
            hw = r;
            reset = 0x0;
        } lane2_eol_1[31:16];

        field {
            name = "lane2_eol_0";
            desc = "EOL synchronization code of frame 0 for lane 2 in LVDS or HiSPI mode. In WDR mode, the value is the EOL of frame 0. In linear mode, the value is the EOL.";
            sw = rw;
            hw = r;
            reset = 0x0;
        } lane2_eol_0[15:0];
    } LINK1_LANE2_EOL_01 @ 0x14D8;

    reg {
        name = "LINK1 LANE2 EOL 23";
        desc = "[inferred] LINK1 LANE2 EOL 23. Not in the data sheet. Source: OpenIPC openhisilicon `kernel/mipi_rx/hi3516av100/mipi_reg.h` (GPL-3.0 repository, HiSilicon copyright; local copy sources/openhisilicon), union `U_LINK_LANE_EOL_23`, struct offset 0x14DC (GPL-3.0 repository, HiSilicon copyright; byte-identical to the hi3516cv200 file). Reset value and access type unknown (modelled RW, no reset). Confidence: medium (vendor header for this chip family, not hardware verified).";

        field {
            name = "lane0_eol_3";
            desc = "[inferred] Lane0 eol 3. (vendor header `hi3516av100/mipi_reg.h` field `lane0_eol_3`; access and reset unknown, modelled RW)";
            sw = rw;
            hw = r;
        } lane0_eol_3[31:16];

        field {
            name = "lane0_eol_2";
            desc = "[inferred] Lane0 eol 2. (vendor header `hi3516av100/mipi_reg.h` field `lane0_eol_2`; access and reset unknown, modelled RW)";
            sw = rw;
            hw = r;
        } lane0_eol_2[15:0];
    } LINK1_LANE2_EOL_23 @ 0x14DC;

    reg {
        name = "SOF synchronization code configuration _01 register for lane 3 in LVDS or HiSPI mode";
        desc = "LINK1_LANE3_SOF_01 is an SOF synchronization code configuration register for lane 3 in LVDS or HiSPI mode. Huawei Proprietary and Confidential Hi3516A/Hi3516D Professional HD IP Camera SoC

Data sheet 10.3.6 LINK1_LANE3_SOF_01 (offset 0x14E0, printed page 10-333, `hi3516av100--Hi3516A-Hi3516D-Datasheet.txt` line 77549).";

        field {
            name = "lane3_sof_1";
            desc = "SOF synchronization code of frame 1 for lane 3 in LVDS or HiSPI mode. The field is configurable only in WDR mode, and the configuration is invalid in linear mode.";
            sw = rw;
            hw = r;
            reset = 0x0;
        } lane3_sof_1[31:16];

        field {
            name = "lane3_sof_0";
            desc = "SOF synchronization code of frame 0 for lane 3 in LVDS or HiSPI mode. In WDR mode, the value is the SOF of frame 0. In linear mode, the value is the SOF.";
            sw = rw;
            hw = r;
            reset = 0x0;
        } lane3_sof_0[15:0];
    } LINK1_LANE3_SOF_01 @ 0x14E0;

    reg {
        name = "LINK1 LANE3 SOF 23";
        desc = "[inferred] LINK1 LANE3 SOF 23. Not in the data sheet. Source: OpenIPC openhisilicon `kernel/mipi_rx/hi3516av100/mipi_reg.h` (GPL-3.0 repository, HiSilicon copyright; local copy sources/openhisilicon), union `U_LINK_LANE_SOF_23`, struct offset 0x14E4 (GPL-3.0 repository, HiSilicon copyright; byte-identical to the hi3516cv200 file). Reset value and access type unknown (modelled RW, no reset). Confidence: medium (vendor header for this chip family, not hardware verified).";

        field {
            name = "lane0_sof_3";
            desc = "[inferred] Lane0 sof 3. (vendor header `hi3516av100/mipi_reg.h` field `lane0_sof_3`; access and reset unknown, modelled RW)";
            sw = rw;
            hw = r;
        } lane0_sof_3[31:16];

        field {
            name = "lane0_sof_2";
            desc = "[inferred] Lane0 sof 2. (vendor header `hi3516av100/mipi_reg.h` field `lane0_sof_2`; access and reset unknown, modelled RW)";
            sw = rw;
            hw = r;
        } lane0_sof_2[15:0];
    } LINK1_LANE3_SOF_23 @ 0x14E4;

    reg {
        name = "EOF synchronization code configuration _01 register for lane 3 in LVDS or HiSPI mode";
        desc = "LINK1_LANE3_EOF_01 is an EOF synchronization code configuration register for lane 3 in LVDS or HiSPI mode.

Data sheet 10.3.6 LINK1_LANE3_EOF_01 (offset 0x14E8, printed page 10-333, `hi3516av100--Hi3516A-Hi3516D-Datasheet.txt` line 77577).";

        field {
            name = "lane3_eof_1";
            desc = "EOF synchronization code of frame 1 for lane 3 in LVDS or HiSPI mode. The field is configurable only in WDR mode, and the configuration is invalid in linear mode.";
            sw = rw;
            hw = r;
            reset = 0x0;
        } lane3_eof_1[31:16];

        field {
            name = "lane3_eof_0";
            desc = "EOF synchronization code of frame 0 for lane 3 in LVDS or HiSPI mode. In WDR mode, the value is the EOF of frame 0. In linear mode, the value is the EOF.";
            sw = rw;
            hw = r;
            reset = 0x0;
        } lane3_eof_0[15:0];
    } LINK1_LANE3_EOF_01 @ 0x14E8;

    reg {
        name = "LINK1 LANE3 EOF 23";
        desc = "[inferred] LINK1 LANE3 EOF 23. Not in the data sheet. Source: OpenIPC openhisilicon `kernel/mipi_rx/hi3516av100/mipi_reg.h` (GPL-3.0 repository, HiSilicon copyright; local copy sources/openhisilicon), union `U_LINK_LANE_EOF_23`, struct offset 0x14EC (GPL-3.0 repository, HiSilicon copyright; byte-identical to the hi3516cv200 file). Reset value and access type unknown (modelled RW, no reset). Confidence: medium (vendor header for this chip family, not hardware verified).";

        field {
            name = "lane0_eof_3";
            desc = "[inferred] Lane0 eof 3. (vendor header `hi3516av100/mipi_reg.h` field `lane0_eof_3`; access and reset unknown, modelled RW)";
            sw = rw;
            hw = r;
        } lane0_eof_3[31:16];

        field {
            name = "lane0_eof_2";
            desc = "[inferred] Lane0 eof 2. (vendor header `hi3516av100/mipi_reg.h` field `lane0_eof_2`; access and reset unknown, modelled RW)";
            sw = rw;
            hw = r;
        } lane0_eof_2[15:0];
    } LINK1_LANE3_EOF_23 @ 0x14EC;

    reg {
        name = "SOL synchronization code configuration _01 register for lane 3 in LVDS or HiSPI mode.";
        desc = "LINK1_LANE3_SOL_01 is an SOL synchronization code configuration register for lane 3 in LVDS or HiSPI mode. Huawei Proprietary and Confidential Hi3516A/Hi3516D Professional HD IP Camera SoC

Data sheet 10.3.6 LINK1_LANE3_SOL_01 (offset 0x14F0, printed page 10-334, `hi3516av100--Hi3516A-Hi3516D-Datasheet.txt` line 77613).";

        field {
            name = "lane3_sol_1";
            desc = "SOL synchronization code of frame 1 for lane 3 in LVDS or HiSPI mode. The field is configurable only in WDR mode, and the configuration is invalid in linear mode.";
            sw = rw;
            hw = r;
            reset = 0x0;
        } lane3_sol_1[31:16];

        field {
            name = "lane3_sol_0";
            desc = "SOL synchronization code of frame 0 for lane 3 in LVDS or HiSPI mode. In WDR mode, the value is the SOL of frame 0. In linear mode, the value is the SOL.";
            sw = rw;
            hw = r;
            reset = 0x0;
        } lane3_sol_0[15:0];
    } LINK1_LANE3_SOL_01 @ 0x14F0;

    reg {
        name = "LINK1 LANE3 SOL 23";
        desc = "[inferred] LINK1 LANE3 SOL 23. Not in the data sheet. Source: OpenIPC openhisilicon `kernel/mipi_rx/hi3516av100/mipi_reg.h` (GPL-3.0 repository, HiSilicon copyright; local copy sources/openhisilicon), union `U_LINK_LANE_SOL_23`, struct offset 0x14F4 (GPL-3.0 repository, HiSilicon copyright; byte-identical to the hi3516cv200 file). Reset value and access type unknown (modelled RW, no reset). Confidence: medium (vendor header for this chip family, not hardware verified).";

        field {
            name = "lane0_sol_3";
            desc = "[inferred] Lane0 sol 3. (vendor header `hi3516av100/mipi_reg.h` field `lane0_sol_3`; access and reset unknown, modelled RW)";
            sw = rw;
            hw = r;
        } lane0_sol_3[31:16];

        field {
            name = "lane0_sol_2";
            desc = "[inferred] Lane0 sol 2. (vendor header `hi3516av100/mipi_reg.h` field `lane0_sol_2`; access and reset unknown, modelled RW)";
            sw = rw;
            hw = r;
        } lane0_sol_2[15:0];
    } LINK1_LANE3_SOL_23 @ 0x14F4;

    reg {
        name = "EOL synchronization code configuration L_01 register for lane 3 in LVDS or HiSPI mode";
        desc = "LINK1_LANE3_EOL_01 is an EOL synchronization code configuration register for lane 3 in LVDS or HiSPI mode.

Data sheet 10.3.6 LINK1_LANE3_EOL_01 (offset 0x14F8, printed page 10-334, `hi3516av100--Hi3516A-Hi3516D-Datasheet.txt` line 77641).";

        field {
            name = "lane3_eol_1";
            desc = "EOL synchronization code of frame 1 for lane 3 in LVDS or HiSPI mode. The field is configurable only in WDR mode, and the configuration is invalid in linear mode.";
            sw = rw;
            hw = r;
            reset = 0x0;
        } lane3_eol_1[31:16];

        field {
            name = "lane3_eol_0";
            desc = "EOL synchronization code of frame 0 for lane 3 in LVDS or HiSPI mode. In WDR mode, the value is the EOL of frame 0. In linear mode, the value is the EOL.";
            sw = rw;
            hw = r;
            reset = 0x0;
        } lane3_eol_0[15:0];
    } LINK1_LANE3_EOL_01 @ 0x14F8;

    reg {
        name = "LINK1 LANE3 EOL 23";
        desc = "[inferred] LINK1 LANE3 EOL 23. Not in the data sheet. Source: OpenIPC openhisilicon `kernel/mipi_rx/hi3516av100/mipi_reg.h` (GPL-3.0 repository, HiSilicon copyright; local copy sources/openhisilicon), union `U_LINK_LANE_EOL_23`, struct offset 0x14FC (GPL-3.0 repository, HiSilicon copyright; byte-identical to the hi3516cv200 file). Reset value and access type unknown (modelled RW, no reset). Confidence: medium (vendor header for this chip family, not hardware verified).";

        field {
            name = "lane0_eol_3";
            desc = "[inferred] Lane0 eol 3. (vendor header `hi3516av100/mipi_reg.h` field `lane0_eol_3`; access and reset unknown, modelled RW)";
            sw = rw;
            hw = r;
        } lane0_eol_3[31:16];

        field {
            name = "lane0_eol_2";
            desc = "[inferred] Lane0 eol 2. (vendor header `hi3516av100/mipi_reg.h` field `lane0_eol_2`; access and reset unknown, modelled RW)";
            sw = rw;
            hw = r;
        } lane0_eol_2[15:0];
    } LINK1_LANE3_EOL_23 @ 0x14FC;

    reg {
        name = "DATA PHY LINK1";
        desc = "[inferred] DATA PHY LINK1. Not in the data sheet. Source: OpenIPC openhisilicon `kernel/mipi_rx/hi3516av100/mipi_reg.h` (GPL-3.0 repository, HiSilicon copyright; local copy sources/openhisilicon), union `U_DATA_PHY_LINK`, struct offset 0x1600 (GPL-3.0 repository, HiSilicon copyright; byte-identical to the hi3516cv200 file). Reset value and access type unknown (modelled RW, no reset). Confidence: medium (vendor header for this chip family, not hardware verified).";

        field {
            name = "data3_phy";
            desc = "[inferred] Data3 PHY. (vendor header `hi3516av100/mipi_reg.h` field `data3_phy`; access and reset unknown, modelled RW)";
            sw = rw;
            hw = r;
        } data3_phy[31:24];

        field {
            name = "data2_phy";
            desc = "[inferred] Data2 PHY. (vendor header `hi3516av100/mipi_reg.h` field `data2_phy`; access and reset unknown, modelled RW)";
            sw = rw;
            hw = r;
        } data2_phy[23:16];

        field {
            name = "data1_phy";
            desc = "[inferred] Data1 PHY. (vendor header `hi3516av100/mipi_reg.h` field `data1_phy`; access and reset unknown, modelled RW)";
            sw = rw;
            hw = r;
        } data1_phy[15:8];

        field {
            name = "data0_phy";
            desc = "[inferred] Data0 PHY. (vendor header `hi3516av100/mipi_reg.h` field `data0_phy`; access and reset unknown, modelled RW)";
            sw = rw;
            hw = r;
        } data0_phy[7:0];
    } DATA_PHY_LINK1 @ 0x1600;

    reg {
        name = "DATA CHN LINK1";
        desc = "[inferred] DATA CHN LINK1. Not in the data sheet. Source: OpenIPC openhisilicon `kernel/mipi_rx/hi3516av100/mipi_reg.h` (GPL-3.0 repository, HiSilicon copyright; local copy sources/openhisilicon), union `U_DATA_CHN_LINK`, struct offset 0x1604 (GPL-3.0 repository, HiSilicon copyright; byte-identical to the hi3516cv200 file). Reset value and access type unknown (modelled RW, no reset). Confidence: medium (vendor header for this chip family, not hardware verified).";

        field {
            name = "data3_chn";
            desc = "[inferred] Data3 chn. (vendor header `hi3516av100/mipi_reg.h` field `data3_chn`; access and reset unknown, modelled RW)";
            sw = rw;
            hw = r;
        } data3_chn[31:24];

        field {
            name = "data2_chn";
            desc = "[inferred] Data2 chn. (vendor header `hi3516av100/mipi_reg.h` field `data2_chn`; access and reset unknown, modelled RW)";
            sw = rw;
            hw = r;
        } data2_chn[23:16];

        field {
            name = "data1_chn";
            desc = "[inferred] Data1 chn. (vendor header `hi3516av100/mipi_reg.h` field `data1_chn`; access and reset unknown, modelled RW)";
            sw = rw;
            hw = r;
        } data1_chn[15:8];

        field {
            name = "data0_chn";
            desc = "[inferred] Data0 chn. (vendor header `hi3516av100/mipi_reg.h` field `data0_chn`; access and reset unknown, modelled RW)";
            sw = rw;
            hw = r;
        } data0_chn[7:0];
    } DATA_CHN_LINK1 @ 0x1604;

    reg {
        name = "MIPI FSMST DATA LINK1";
        desc = "[inferred] MIPI FSMST DATA LINK1. Not in the data sheet. Source: OpenIPC openhisilicon `kernel/mipi_rx/hi3516av100/mipi_reg.h` (GPL-3.0 repository, HiSilicon copyright; local copy sources/openhisilicon), union `U_MIPI_FSMST_DATA_LINK`, struct offset 0x1608 (GPL-3.0 repository, HiSilicon copyright; byte-identical to the hi3516cv200 file). Reset value and access type unknown (modelled RW, no reset). Confidence: medium (vendor header for this chip family, not hardware verified).";

        field {
            name = "nxt_st_d3";
            desc = "[inferred] Nxt st d3. (vendor header `hi3516av100/mipi_reg.h` field `nxt_st_d3`; access and reset unknown, modelled RW)";
            sw = rw;
            hw = r;
        } nxt_st_d3[31:28];

        field {
            name = "cur_st_d3";
            desc = "[inferred] Cur st d3. (vendor header `hi3516av100/mipi_reg.h` field `cur_st_d3`; access and reset unknown, modelled RW)";
            sw = rw;
            hw = r;
        } cur_st_d3[27:24];

        field {
            name = "nxt_st_d2";
            desc = "[inferred] Nxt st d2. (vendor header `hi3516av100/mipi_reg.h` field `nxt_st_d2`; access and reset unknown, modelled RW)";
            sw = rw;
            hw = r;
        } nxt_st_d2[23:20];

        field {
            name = "cur_st_d2";
            desc = "[inferred] Cur st d2. (vendor header `hi3516av100/mipi_reg.h` field `cur_st_d2`; access and reset unknown, modelled RW)";
            sw = rw;
            hw = r;
        } cur_st_d2[19:16];

        field {
            name = "nxt_st_d1";
            desc = "[inferred] Nxt st d1. (vendor header `hi3516av100/mipi_reg.h` field `nxt_st_d1`; access and reset unknown, modelled RW)";
            sw = rw;
            hw = r;
        } nxt_st_d1[15:12];

        field {
            name = "cur_st_d1";
            desc = "[inferred] Cur st d1. (vendor header `hi3516av100/mipi_reg.h` field `cur_st_d1`; access and reset unknown, modelled RW)";
            sw = rw;
            hw = r;
        } cur_st_d1[11:8];

        field {
            name = "nxt_st_d0";
            desc = "[inferred] Nxt st d0. (vendor header `hi3516av100/mipi_reg.h` field `nxt_st_d0`; access and reset unknown, modelled RW)";
            sw = rw;
            hw = r;
        } nxt_st_d0[7:4];

        field {
            name = "cur_st_d0";
            desc = "[inferred] Cur st d0. (vendor header `hi3516av100/mipi_reg.h` field `cur_st_d0`; access and reset unknown, modelled RW)";
            sw = rw;
            hw = r;
        } cur_st_d0[3:0];
    } MIPI_FSMST_DATA_LINK1 @ 0x1608;

    reg {
        name = "MIPI FSMST CK LINK1";
        desc = "[inferred] MIPI FSMST CK LINK1. Not in the data sheet. Source: OpenIPC openhisilicon `kernel/mipi_rx/hi3516av100/mipi_reg.h` (GPL-3.0 repository, HiSilicon copyright; local copy sources/openhisilicon), union `U_MIPI_FSMST_CK_LINK`, struct offset 0x160C (GPL-3.0 repository, HiSilicon copyright; byte-identical to the hi3516cv200 file). Reset value and access type unknown (modelled RW, no reset). Confidence: medium (vendor header for this chip family, not hardware verified).";

        field {
            name = "nxt_st_ck";
            desc = "[inferred] Nxt st ck. (vendor header `hi3516av100/mipi_reg.h` field `nxt_st_ck`; access and reset unknown, modelled RW)";
            sw = rw;
            hw = r;
        } nxt_st_ck[7:4];

        field {
            name = "cur_st_ck";
            desc = "[inferred] Cur st ck. (vendor header `hi3516av100/mipi_reg.h` field `cur_st_ck`; access and reset unknown, modelled RW)";
            sw = rw;
            hw = r;
        } cur_st_ck[3:0];
    } MIPI_FSMST_CK_LINK1 @ 0x160C;

    reg {
        name = "MIPI FIFO error LINK1";
        desc = "[inferred] MIPI FIFO error LINK1. Not in the data sheet. Source: OpenIPC openhisilicon `kernel/mipi_rx/hi3516av100/mipi_reg.h` (GPL-3.0 repository, HiSilicon copyright; local copy sources/openhisilicon), union `U_MIPI_FIFO_ERR_LINK`, struct offset 0x1610 (GPL-3.0 repository, HiSilicon copyright; byte-identical to the hi3516cv200 file). Reset value and access type unknown (modelled RW, no reset). Confidence: medium (vendor header for this chip family, not hardware verified).";

        field {
            name = "lvds_fifo_rderr";
            desc = "[inferred] Lvds fifo rderr. (vendor header `hi3516av100/mipi_reg.h` field `lvds_fifo_rderr`; access and reset unknown, modelled RW)";
            sw = rw;
            hw = r;
        } lvds_fifo_rderr[5:5];

        field {
            name = "lvds_fifo_wrerr";
            desc = "[inferred] Lvds fifo wrerr. (vendor header `hi3516av100/mipi_reg.h` field `lvds_fifo_wrerr`; access and reset unknown, modelled RW)";
            sw = rw;
            hw = r;
        } lvds_fifo_wrerr[4:4];

        field {
            name = "mipi_cmd_fifo_rderr";
            desc = "[inferred] Mipi cmd fifo rderr. (vendor header `hi3516av100/mipi_reg.h` field `mipi_cmd_fifo_rderr`; access and reset unknown, modelled RW)";
            sw = rw;
            hw = r;
        } mipi_cmd_fifo_rderr[3:3];

        field {
            name = "mipi_cmd_fifo_wrerr";
            desc = "[inferred] Mipi cmd fifo wrerr. (vendor header `hi3516av100/mipi_reg.h` field `mipi_cmd_fifo_wrerr`; access and reset unknown, modelled RW)";
            sw = rw;
            hw = r;
        } mipi_cmd_fifo_wrerr[2:2];

        field {
            name = "mipi_data_fifo_rderr";
            desc = "[inferred] Mipi data fifo rderr. (vendor header `hi3516av100/mipi_reg.h` field `mipi_data_fifo_rderr`; access and reset unknown, modelled RW)";
            sw = rw;
            hw = r;
        } mipi_data_fifo_rderr[1:1];

        field {
            name = "mipi_data_fifo_wrerr";
            desc = "[inferred] Mipi data fifo wrerr. (vendor header `hi3516av100/mipi_reg.h` field `mipi_data_fifo_wrerr`; access and reset unknown, modelled RW)";
            sw = rw;
            hw = r;
        } mipi_data_fifo_wrerr[0:0];
    } MIPI_FIFO_ERR_LINK1 @ 0x1610;

    reg {
        name = "PHY BAK EN0 LINK1";
        desc = "[inferred] PHY BAK EN0 LINK1. Not in the data sheet. Source: OpenIPC openhisilicon `kernel/mipi_rx/hi3516av100/mipi_reg.h` (GPL-3.0 repository, HiSilicon copyright; local copy sources/openhisilicon), union `U_PHY_BAK_EN0_LINK`, struct offset 0x1614 (GPL-3.0 repository, HiSilicon copyright; byte-identical to the hi3516cv200 file). Reset value and access type unknown (modelled RW, no reset). Confidence: medium (vendor header for this chip family, not hardware verified).";

        field {
            name = "phy_bak_en0";
            desc = "[inferred] PHY bak en0. (vendor header `hi3516av100/mipi_reg.h` field `phy_bak_en0`; access and reset unknown, modelled RW)";
            sw = rw;
            hw = r;
        } phy_bak_en0[31:31];

        field {
            name = "phy_ifimode_bak";
            desc = "[inferred] PHY ifimode bak. (vendor header `hi3516av100/mipi_reg.h` field `phy_ifimode_bak`; access and reset unknown, modelled RW)";
            sw = rw;
            hw = r;
        } phy_ifimode_bak[8:8];

        field {
            name = "phy_rstn_bak";
            desc = "[inferred] PHY rstn bak. (vendor header `hi3516av100/mipi_reg.h` field `phy_rstn_bak`; access and reset unknown, modelled RW)";
            sw = rw;
            hw = r;
        } phy_rstn_bak[4:4];

        field {
            name = "phy_pwdn_bak";
            desc = "[inferred] PHY pwdn bak. (vendor header `hi3516av100/mipi_reg.h` field `phy_pwdn_bak`; access and reset unknown, modelled RW)";
            sw = rw;
            hw = r;
        } phy_pwdn_bak[0:0];
    } PHY_BAK_EN0_LINK1 @ 0x1614;

    reg {
        name = "PHY BAK EN1 LINK1";
        desc = "[inferred] PHY BAK EN1 LINK1. Not in the data sheet. Source: OpenIPC openhisilicon `kernel/mipi_rx/hi3516av100/mipi_reg.h` (GPL-3.0 repository, HiSilicon copyright; local copy sources/openhisilicon), union `U_PHY_BAK_EN1_LINK`, struct offset 0x1618 (GPL-3.0 repository, HiSilicon copyright; byte-identical to the hi3516cv200 file). Reset value and access type unknown (modelled RW, no reset). Confidence: medium (vendor header for this chip family, not hardware verified).";

        field {
            name = "phy_bak_en1";
            desc = "[inferred] PHY bak en1. (vendor header `hi3516av100/mipi_reg.h` field `phy_bak_en1`; access and reset unknown, modelled RW)";
            sw = rw;
            hw = r;
        } phy_bak_en1[31:31];

        field {
            name = "te_d3en_bak";
            desc = "[inferred] Te d3en bak. (vendor header `hi3516av100/mipi_reg.h` field `te_d3en_bak`; access and reset unknown, modelled RW)";
            sw = rw;
            hw = r;
        } te_d3en_bak[23:23];

        field {
            name = "te_d2en_bak";
            desc = "[inferred] Te d2en bak. (vendor header `hi3516av100/mipi_reg.h` field `te_d2en_bak`; access and reset unknown, modelled RW)";
            sw = rw;
            hw = r;
        } te_d2en_bak[22:22];

        field {
            name = "te_d1en_bak";
            desc = "[inferred] Te d1en bak. (vendor header `hi3516av100/mipi_reg.h` field `te_d1en_bak`; access and reset unknown, modelled RW)";
            sw = rw;
            hw = r;
        } te_d1en_bak[21:21];

        field {
            name = "te_d0en_bak";
            desc = "[inferred] Te d0en bak. (vendor header `hi3516av100/mipi_reg.h` field `te_d0en_bak`; access and reset unknown, modelled RW)";
            sw = rw;
            hw = r;
        } te_d0en_bak[20:20];

        field {
            name = "te_cken_bak";
            desc = "[inferred] Te cken bak. (vendor header `hi3516av100/mipi_reg.h` field `te_cken_bak`; access and reset unknown, modelled RW)";
            sw = rw;
            hw = r;
        } te_cken_bak[16:16];

        field {
            name = "hs_d3en_bak";
            desc = "[inferred] Horizontal sync d3en bak. (vendor header `hi3516av100/mipi_reg.h` field `hs_d3en_bak`; access and reset unknown, modelled RW)";
            sw = rw;
            hw = r;
        } hs_d3en_bak[15:15];

        field {
            name = "hs_d2en_bak";
            desc = "[inferred] Horizontal sync d2en bak. (vendor header `hi3516av100/mipi_reg.h` field `hs_d2en_bak`; access and reset unknown, modelled RW)";
            sw = rw;
            hw = r;
        } hs_d2en_bak[14:14];

        field {
            name = "hs_d1en_bak";
            desc = "[inferred] Horizontal sync d1en bak. (vendor header `hi3516av100/mipi_reg.h` field `hs_d1en_bak`; access and reset unknown, modelled RW)";
            sw = rw;
            hw = r;
        } hs_d1en_bak[13:13];

        field {
            name = "hs_d0en_bak";
            desc = "[inferred] Horizontal sync d0en bak. (vendor header `hi3516av100/mipi_reg.h` field `hs_d0en_bak`; access and reset unknown, modelled RW)";
            sw = rw;
            hw = r;
        } hs_d0en_bak[12:12];

        field {
            name = "hs_cken_bak";
            desc = "[inferred] Horizontal sync cken bak. (vendor header `hi3516av100/mipi_reg.h` field `hs_cken_bak`; access and reset unknown, modelled RW)";
            sw = rw;
            hw = r;
        } hs_cken_bak[8:8];

        field {
            name = "lp_d3en_bak";
            desc = "[inferred] Low-power d3en bak. (vendor header `hi3516av100/mipi_reg.h` field `lp_d3en_bak`; access and reset unknown, modelled RW)";
            sw = rw;
            hw = r;
        } lp_d3en_bak[7:7];

        field {
            name = "lp_d2en_bak";
            desc = "[inferred] Low-power d2en bak. (vendor header `hi3516av100/mipi_reg.h` field `lp_d2en_bak`; access and reset unknown, modelled RW)";
            sw = rw;
            hw = r;
        } lp_d2en_bak[6:6];

        field {
            name = "lp_d1en_bak";
            desc = "[inferred] Low-power d1en bak. (vendor header `hi3516av100/mipi_reg.h` field `lp_d1en_bak`; access and reset unknown, modelled RW)";
            sw = rw;
            hw = r;
        } lp_d1en_bak[5:5];

        field {
            name = "lp_d0en_bak";
            desc = "[inferred] Low-power d0en bak. (vendor header `hi3516av100/mipi_reg.h` field `lp_d0en_bak`; access and reset unknown, modelled RW)";
            sw = rw;
            hw = r;
        } lp_d0en_bak[4:4];

        field {
            name = "lp_cken_bak";
            desc = "[inferred] Low-power cken bak. (vendor header `hi3516av100/mipi_reg.h` field `lp_cken_bak`; access and reset unknown, modelled RW)";
            sw = rw;
            hw = r;
        } lp_cken_bak[0:0];
    } PHY_BAK_EN1_LINK1 @ 0x1618;

    reg {
        name = "MIPI PHY ACT0 LINK1";
        desc = "[inferred] MIPI PHY ACT0 LINK1. Not in the data sheet. Source: OpenIPC openhisilicon `kernel/mipi_rx/hi3516av100/mipi_reg.h` (GPL-3.0 repository, HiSilicon copyright; local copy sources/openhisilicon), union `U_MIPI_PHY_ACT0_LINK`, struct offset 0x161C (GPL-3.0 repository, HiSilicon copyright; byte-identical to the hi3516cv200 file). Reset value and access type unknown (modelled RW, no reset). Confidence: medium (vendor header for this chip family, not hardware verified).";

        field {
            name = "phy_ifimode_act";
            desc = "[inferred] PHY ifimode act. (vendor header `hi3516av100/mipi_reg.h` field `phy_ifimode_act`; access and reset unknown, modelled RW)";
            sw = rw;
            hw = r;
        } phy_ifimode_act[8:8];

        field {
            name = "phy_rstn_act";
            desc = "[inferred] PHY rstn act. (vendor header `hi3516av100/mipi_reg.h` field `phy_rstn_act`; access and reset unknown, modelled RW)";
            sw = rw;
            hw = r;
        } phy_rstn_act[4:4];

        field {
            name = "phy_pwdn_act";
            desc = "[inferred] PHY pwdn act. (vendor header `hi3516av100/mipi_reg.h` field `phy_pwdn_act`; access and reset unknown, modelled RW)";
            sw = rw;
            hw = r;
        } phy_pwdn_act[0:0];
    } MIPI_PHY_ACT0_LINK1 @ 0x161C;

    reg {
        name = "MIPI PHY ACT1 LINK1";
        desc = "[inferred] MIPI PHY ACT1 LINK1. Not in the data sheet. Source: OpenIPC openhisilicon `kernel/mipi_rx/hi3516av100/mipi_reg.h` (GPL-3.0 repository, HiSilicon copyright; local copy sources/openhisilicon), union `U_MIPI_PHY_ACT1_LINK`, struct offset 0x1620 (GPL-3.0 repository, HiSilicon copyright; byte-identical to the hi3516cv200 file). Reset value and access type unknown (modelled RW, no reset). Confidence: medium (vendor header for this chip family, not hardware verified).";

        field {
            name = "te_d3en_act";
            desc = "[inferred] Te d3en act. (vendor header `hi3516av100/mipi_reg.h` field `te_d3en_act`; access and reset unknown, modelled RW)";
            sw = rw;
            hw = r;
        } te_d3en_act[23:23];

        field {
            name = "te_d2en_act";
            desc = "[inferred] Te d2en act. (vendor header `hi3516av100/mipi_reg.h` field `te_d2en_act`; access and reset unknown, modelled RW)";
            sw = rw;
            hw = r;
        } te_d2en_act[22:22];

        field {
            name = "te_d1en_act";
            desc = "[inferred] Te d1en act. (vendor header `hi3516av100/mipi_reg.h` field `te_d1en_act`; access and reset unknown, modelled RW)";
            sw = rw;
            hw = r;
        } te_d1en_act[21:21];

        field {
            name = "te_d0en_act";
            desc = "[inferred] Te d0en act. (vendor header `hi3516av100/mipi_reg.h` field `te_d0en_act`; access and reset unknown, modelled RW)";
            sw = rw;
            hw = r;
        } te_d0en_act[20:20];

        field {
            name = "te_cken_act";
            desc = "[inferred] Te cken act. (vendor header `hi3516av100/mipi_reg.h` field `te_cken_act`; access and reset unknown, modelled RW)";
            sw = rw;
            hw = r;
        } te_cken_act[16:16];

        field {
            name = "hs_d3en_act";
            desc = "[inferred] Horizontal sync d3en act. (vendor header `hi3516av100/mipi_reg.h` field `hs_d3en_act`; access and reset unknown, modelled RW)";
            sw = rw;
            hw = r;
        } hs_d3en_act[15:15];

        field {
            name = "hs_d2en_act";
            desc = "[inferred] Horizontal sync d2en act. (vendor header `hi3516av100/mipi_reg.h` field `hs_d2en_act`; access and reset unknown, modelled RW)";
            sw = rw;
            hw = r;
        } hs_d2en_act[14:14];

        field {
            name = "hs_d1en_act";
            desc = "[inferred] Horizontal sync d1en act. (vendor header `hi3516av100/mipi_reg.h` field `hs_d1en_act`; access and reset unknown, modelled RW)";
            sw = rw;
            hw = r;
        } hs_d1en_act[13:13];

        field {
            name = "hs_d0en_act";
            desc = "[inferred] Horizontal sync d0en act. (vendor header `hi3516av100/mipi_reg.h` field `hs_d0en_act`; access and reset unknown, modelled RW)";
            sw = rw;
            hw = r;
        } hs_d0en_act[12:12];

        field {
            name = "hs_cken_act";
            desc = "[inferred] Horizontal sync cken act. (vendor header `hi3516av100/mipi_reg.h` field `hs_cken_act`; access and reset unknown, modelled RW)";
            sw = rw;
            hw = r;
        } hs_cken_act[8:8];

        field {
            name = "lp_d3en_act";
            desc = "[inferred] Low-power d3en act. (vendor header `hi3516av100/mipi_reg.h` field `lp_d3en_act`; access and reset unknown, modelled RW)";
            sw = rw;
            hw = r;
        } lp_d3en_act[7:7];

        field {
            name = "lp_d2en_act";
            desc = "[inferred] Low-power d2en act. (vendor header `hi3516av100/mipi_reg.h` field `lp_d2en_act`; access and reset unknown, modelled RW)";
            sw = rw;
            hw = r;
        } lp_d2en_act[6:6];

        field {
            name = "lp_d1en_act";
            desc = "[inferred] Low-power d1en act. (vendor header `hi3516av100/mipi_reg.h` field `lp_d1en_act`; access and reset unknown, modelled RW)";
            sw = rw;
            hw = r;
        } lp_d1en_act[5:5];

        field {
            name = "lp_d0en_act";
            desc = "[inferred] Low-power d0en act. (vendor header `hi3516av100/mipi_reg.h` field `lp_d0en_act`; access and reset unknown, modelled RW)";
            sw = rw;
            hw = r;
        } lp_d0en_act[4:4];

        field {
            name = "lp_cken_act";
            desc = "[inferred] Low-power cken act. (vendor header `hi3516av100/mipi_reg.h` field `lp_cken_act`; access and reset unknown, modelled RW)";
            sw = rw;
            hw = r;
        } lp_cken_act[0:0];
    } MIPI_PHY_ACT1_LINK1 @ 0x1620;

    reg {
        name = "LVDS SYNC BORD LINK1";
        desc = "[inferred] LVDS SYNC BORD LINK1. Not in the data sheet. Source: OpenIPC openhisilicon `kernel/mipi_rx/hi3516av100/mipi_reg.h` (GPL-3.0 repository, HiSilicon copyright; local copy sources/openhisilicon), union `U_LVDS_SYNC_BORD_LINK`, struct offset 0x1624 (GPL-3.0 repository, HiSilicon copyright; byte-identical to the hi3516cv200 file). Reset value and access type unknown (modelled RW, no reset). Confidence: medium (vendor header for this chip family, not hardware verified).";

        field {
            name = "sync_bord_lane3";
            desc = "[inferred] Sync bord lane3. (vendor header `hi3516av100/mipi_reg.h` field `sync_bord_lane3`; access and reset unknown, modelled RW)";
            sw = rw;
            hw = r;
        } sync_bord_lane3[15:12];

        field {
            name = "sync_bord_lane2";
            desc = "[inferred] Sync bord lane2. (vendor header `hi3516av100/mipi_reg.h` field `sync_bord_lane2`; access and reset unknown, modelled RW)";
            sw = rw;
            hw = r;
        } sync_bord_lane2[11:8];

        field {
            name = "sync_bord_lane1";
            desc = "[inferred] Sync bord lane1. (vendor header `hi3516av100/mipi_reg.h` field `sync_bord_lane1`; access and reset unknown, modelled RW)";
            sw = rw;
            hw = r;
        } sync_bord_lane1[7:4];

        field {
            name = "sync_bord_lane0";
            desc = "[inferred] Sync bord lane0. (vendor header `hi3516av100/mipi_reg.h` field `sync_bord_lane0`; access and reset unknown, modelled RW)";
            sw = rw;
            hw = r;
        } sync_bord_lane0[3:0];
    } LVDS_SYNC_BORD_LINK1 @ 0x1624;
};

`endif
