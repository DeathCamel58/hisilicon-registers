`ifndef MOTION_DETECT_RDL
`define MOTION_DETECT_RDL

regfile eMOTION_DETECT {
    name = "Motion Detect Unit Registers";
    desc = "
    # Overview

    As a high-performance hardware acceleration intellectual property (IP), the motion detect unit (MDU) is used to detect the motion status and video occlusion, implement modeling on the video background, and calculate the information about the object (OBJ) region. The OBJ region is a rectangular motion part of the current frame. By using the advanced eXtensible interface (AXI) master bus, the MDU reads picture information, and writes the updated information about the background, sum of absolute differences (SADs), and OBJ regions. By using the slave advanced high-performance bus (APB), the MDU obtains register configurations.

    ## Function Description

    The MDU provides the following features:

    * Calculates and outputs the SAD in the unit of 8x8 or 16x16.
    * Detects OBJ regions and outputs the information about the OBJ regions.
    * Refreshes the background.

    ## Operating Mode

    ### Software and Hardware for Motion Detection

    The software performs the following operations for the pictures to be encoded:

    * Allocates the storage space in the double-data rate (DDR).
    * Calls the hardware to capture videos or perform scaling.
    * Schedules multiple motion detection operations, specifies and divides the regions to be detected, and generates addresses.

    The hardware calculates the SADs of input pictures. The details are as follows:

    * Detects OBJ regions based on the SAD and threshold, and refreshes the background
    * Outputs the information about OBJ regions, background, and SADs based on the settings of the software.

    ### Software and Hardware for Video Occlusion Detection
    Based on the size of OBJ regions output by the hardware, the software checks whether the occlusion threshold is reached. If the threshold is reached, the background is forbidden to refresh, but motion detection is still performed. When the size of OBJ regions is greater than the occlusion threshold, an occlusion alarm is generated.

    ## Sources

    The register tables (offsets, bit ranges, access types) were compared register by register with the motion detection chapters of the Hi3516C V100 (data sheet issue 00B02 chapter 8, base 0x206C_0000), Hi3518A/C V100 (issue 01 chapter 8), Hi3518E V100 (issue 03 chapter 8), Hi3516A/Hi3516D (issue 08 chapter 8; adds the notes 'maximum picture height 960' to imgheightinpixelsminus1 and 'maximum picture width 960' to imgwidthinpixelsminus1), Hi3516 V100 (Chinese issue 00B60 chapter 13, base 0x2062_0000, interrupt 55) and Hi3520D/Hi3515A/Hi3515C (original Chinese issue 02 chapter 9) data sheets: all six give the same 31 registers with the same bit layout and the same reset values, so one definition serves every chip. The `MOTION_DETECT_RESET_G1` macro (defined by each of those chips) enables the data sheet reset values; without it the fields have no reset (kept for chips whose data sheet does not give them). The Hi3516AV200, Hi3516AV300, Hi3516CV300, Hi3519V101 and Hi3518EV200 data sheets have no MDU register block (they only mention the MD_DDRT/MD_SUM names of the DDR traffic monitor).

    ## Integration and cross-chip audit (2026-11-11)

    A scripted second pass (all 31 registers, every field's bit range, access, name and reset, and every register offset, against the data sheet of each chip) found no difference to this definition on Hi3516C V100, Hi3518A/C V100, Hi3516A/D, Hi3516 V100 and Hi3520D/Hi3515A/Hi3515C. The Hi3518E V100 data sheet (issue 03, no chip folder of its own) gives the same map with one exception: MDU_MODE bit 8 (mcpi_clkgate_en) is printed as reserved (RO), while the total reset value stays 0x0000_019C, so the bit still resets to 1. Printed names: the data sheets spell the imgheightinpixelsminus1/imgwidthinpixelsminus1 fields of MDU_VEDIMGSIZE with a line break; the RDL keeps the readable names.

    Base address is 0x206C_0000 on every chip except the Hi3516 V100 (0x2062_0000). Interrupt: GIC ID 76 on Hi3520D, Hi3515A, Hi3515C and Hi3516A/D (named MD in the A9 interrupt table); ID 55 (MD) on Hi3516 V100; ID 28 shared with the DDRT ('MDU/DDRT') on Hi3516C V100, Hi3518A/C V100 and Hi3518E V100. The MDU and the DDR test (DDRT) share one DDR master port: a system control bit selects which of the two is active (Hi3520D: PERIPHCTRL4 bit 15, 0 = MDU, 1 = DDRT; Hi3516C V100: mdu_ddrt_sel in its misc control register; Hi3516A/D: MISC_CTRL1 bit 2), and PERI_CRG26 (mdu_cken, mdu_srst_req) gates the clock and the reset. The data sheets do not relate the MDU to VICAP, VPSS or the ISP: it reads frames from DDR (Y plane of the reference and current picture) over its own AXI master and is software scheduled.

    Hi3520D/Hi3515A/Hi3515C data sheet limits: the register tables are complete, but the chapter gives no programming example and no OBJ/SAD output buffer layout. Vendor-derived usage (static analysis 2026-11-11 of the Hi3520D vendor module hi3520D_vda.ko, its public header hi_comm_vda.h and the Hi3516C V100/Hi3518 and Hi3516A/D modules; docs/rdl-campaign/motion-detect-vendor.md in the workspace; not verified on hardware): (1) Source: vendor module hi3520D_vda.ko (every MDU_HAL_* accessor), confidence HIGH, word-checked: yes: all 31 offsets and bit ranges used by the vendor code agree with this file; the module ioremaps 0x206C0000 (length 0x10000) and uses interrupt 76; it writes interrupt enable 0xFFFFFFFF and interrupt clear 0xFFFFFFFF, and programs the registers in the order INTEN, picture size, MODE bits, REF/CUR/BG/SAD/OBJ addresses and strides, weights, SAD threshold, timeout, window size, search timeout, minimum object size, maximum object count and MDU_START last. (2) Source: vendor module, confidence HIGH: picture limits enforced in software: width at most 960, height at most 576 on the Hi3520D (Hi3516A/D: 960 x 960); the module does not touch any clock, reset or DDRT-select register (only one ioremap). (3) Source: vendor public header hi_comm_vda.h, confidence HIGH: one OBJ record is four u16 in the order left, top, right, bottom; the SAD threshold range is 0..4080 (16 x 255, the largest SAD of a 4x4 block), the recommended value 100; the maximum object count 1..128; the background source weight 1..255 with a total weight of 256 (weight_sum_exp_2 = 8, confidence MEDIUM); the reference picture of the vendor 'dynamic' mode is the previous frame. (4) Unknown, not found in any local source: the unit of the OBJ coordinates, the scaling of 8-bit SAD entries, the layout of the SAD map inside its stride, the unit of MDU_TIMEOUT and the exact two-pass semantics of the background algorithm. Register layout HIGH (data sheet and vendor code), buffer formats LOW-MEDIUM (header only), hardware use NONE.
    ";

    /* Fields */

    /* Useful enums to keep from having to keep copying them */
    enum MD_zero_enable_enum {
        ENABLE  = 0x0 { desc = "Enable"; };
        DISABLE = 0x1 { desc = "Disable"; };
    };

    enum MD_one_enable_enum {
        DISABLE = 0x0 { desc = "Disable"; };
        ENABLE  = 0x1 { desc = "Enable"; };
    };

    reg {
        name = "Interrupt Status Register";

        field {
            name = "mdu_bus_err";
            desc = "Bus read/write error.";
            sw = r;
            hw = w;
`ifdef MOTION_DETECT_RESET_G1
            reset = 0x0;
`endif
        } mdu_bus_err[31:31];

        field {
            name = "mdu_cfg_err";
            desc = "Register configuration error.";
            sw = r;
            hw = w;
`ifdef MOTION_DETECT_RESET_G1
            reset = 0x0;
`endif
        } mdu_cfg_err[30:30];

        field {
            name = "mdu_timeout";
            desc = "MDU timeout interrupt. This interrupt is valid when the timeout detection mode of the MDU is enabled and the working cycle of the MDU is greater than the threshold configured by MDU_TIMEOUT.";
            sw = r;
            hw = w;
`ifdef MOTION_DETECT_RESET_G1
            reset = 0x0;
`endif
        } mdu_timeout[1:1];

        field {
            name = "mdu_endofpic";
            desc = "End of picture indicator of the MDU, active high.";
            sw = r;
            hw = w;
`ifdef MOTION_DETECT_RESET_G1
            reset = 0x0;
`endif
        } mdu_endofpic[0:0];

    } MDU_INTSTAT @ 0x00;

    reg {
        name = "Interrupt Enable Register";

        field {
            name = "mdu_bus_err_en";
            desc = "BUS read/write error interrupt enable.";
            encode = MD_one_enable_enum;
`ifdef MOTION_DETECT_RESET_G1
            reset = 0x0;
`endif
        } mdu_bus_err_en[31:31];

        field {
            name = "mdu_cfg_err_en";
            desc = "Register configuration error interrupt enable.";
            encode = MD_one_enable_enum;
`ifdef MOTION_DETECT_RESET_G1
            reset = 0x0;
`endif
        } mdu_cfg_err_en[30:30];

        field {
            name = "mdu_timeout_en";
            desc = "MDU timeout interrupt enable. When the timeout detection mode of the MDU is enabled and the working cycle of the MDU is greater than the threshold configured by MDU_TIMEOUT, this interrupt is valid.";
            encode = MD_one_enable_enum;
`ifdef MOTION_DETECT_RESET_G1
            reset = 0x0;
`endif
        } mdu_timeout_en[1:1];

        field {
            name = "mdu_endofpic_en";
            desc = "End of picture interrupt enable of the MDU.";
            encode = MD_one_enable_enum;
`ifdef MOTION_DETECT_RESET_G1
            reset = 0x0;
`endif
        } mdu_endofpic_en[0:0];

    } MDU_INTEN @ 0x04;

    reg {
        name = "Raw Interrupt Register";

        field {
            name = "mdu_bus_err_raw";
            desc = "Raw bus read/write error interrupt, active high.";
            sw = r;
            hw = w;
`ifdef MOTION_DETECT_RESET_G1
            reset = 0x0;
`endif
        } mdu_bus_err_raw[31:31];

        field {
            name = "mdu_cfg_err_raw";
            desc = "Raw register configuration error interrupt, active high.";
            sw = r;
            hw = w;
`ifdef MOTION_DETECT_RESET_G1
            reset = 0x0;
`endif
        } mdu_cfg_err_raw[30:30];

        field {
            name = "mdu_timeout_raw";
            desc = "Raw MDU timeout interrupt, active high.";
            sw = r;
            hw = w;
`ifdef MOTION_DETECT_RESET_G1
            reset = 0x0;
`endif
        } mdu_timeout_raw[1:1];

        field {
            name = "mdu_endofpic_raw";
            desc = "Raw end of picture interrupt of the MDU, active high.";
            sw = r;
            hw = w;
`ifdef MOTION_DETECT_RESET_G1
            reset = 0x0;
`endif
        } mdu_endofpic_raw[0:0];

    } MDU_RAWINT @ 0x08;

    reg {
        name = "Interrupt Clear Register";

        field {
            name = "mdu_bus_err_clr";
            desc = "Bus read/write error clear, active high.";
`ifdef MOTION_DETECT_RESET_G1
            reset = 0x0;
`endif
        } mdu_bus_err_clr[31:31];

        field {
            name = "mdu_cfg_err_clr";
            desc = "Register configuration error clear, active high.";
`ifdef MOTION_DETECT_RESET_G1
            reset = 0x0;
`endif
        } mdu_cfg_err_clr[30:30];

        field {
            name = "mdu_timeout_clr";
            desc = "MDU timeout interrupt clear. When the timeout detection mode of the MDU is enabled and the working cycle of the MDU is greater than the threshold configured by MDU_TIMEOUT, this interrupt is valid.";
`ifdef MOTION_DETECT_RESET_G1
            reset = 0x0;
`endif
        } mdu_timeout_clr[1:1];

        field {
            name = "mdu_endofpic_clr";
            desc = "End of picture indicator clear of the MDU, active high.";
`ifdef MOTION_DETECT_RESET_G1
            reset = 0x0;
`endif
        } mdu_endofpic_clr[0:0];

    } MDU_INTCLR @ 0x0C;

    reg {
        name = "Picture Size Configuration Register";

        field {
            name = "imgheightinpixelsminus1";
            desc = "Picture height. The value is in the unit of pixel, and the configured value is obtained by subtracting 1 from the actual height. For example, if the picture height is 352 pixels, this field must be set to 351 pixels.";
`ifdef MOTION_DETECT_RESET_G1
            reset = 0x0;
`endif
        } imgheightinpixelsminus1[28:16];

        field {
            name = "imgwidthinpixelsminus1";
            desc = "Picture width. The value is in the unit of pixel, and the configured value is obtained by subtracting 1 from the actual width. For example, if the picture width is 288 pixels, this field must be set to 287 pixels.";
`ifdef MOTION_DETECT_RESET_G1
            reset = 0x0;
`endif
        } imgwidthinpixelsminus1[12:0];

    } MDU_VEDIMGSIZE @ 0x20;

    reg {
        name = "Mode Configuration Register";

        field {
            name = "mcpi_clkgate_en";
            desc = "Clock gating enable.";
`ifdef MOTION_DETECT_RESET_G1
            reset = 0x1;
`endif
        } mcpi_clkgate_en[8:8];

        field {
            name = "mcpi_wrlock_en";
            desc = "Register configuration lock enable. If this field is enabled, registers cannot be configured even if the MDU is started until the detection ends. This avoids modifications made to registers.";
`ifdef MOTION_DETECT_RESET_G1
            reset = 0x1;
`endif
        } mcpi_wrlock_en[7:7];

        field {
            name = "timeout_en";
            desc = "MDU timeout detection enable. If this field is enabled, the upper limits of the working cycle that is configured using MDU_TIMEOUT by the software can be automatically queried.";
            encode = MD_one_enable_enum;
`ifdef MOTION_DETECT_RESET_G1
            reset = 0x0;
`endif
        } timeout_en[6:6];

        enum MD_md_mod_enum {
            BACKGROUND = 0x0 { desc = "Background Algorithm"; };
            FRAME_REF  = 0x1 { desc = "Frame Reference Algorithm"; };
        };

        field {
            name = "md_mod";
            desc = "Motion detection mode.";
            encode = MD_md_mod_enum;
`ifdef MOTION_DETECT_RESET_G1
            reset = 0x0;
`endif
        } md_mod[5:5];

        field {
            name = "bg_update_en";
            desc = "Background refresh enable.";
            encode = MD_one_enable_enum;
`ifdef MOTION_DETECT_RESET_G1
            reset = 0x1;
`endif
        } bg_update_en[4:4];

        field {
            name = "eg_find_en";
            desc = "
            Joint detection enable for OBJ regions.

            !!! NOTE
                If the background algorithm is selected, only the last joint detection based on the background is disabled.
            ";
            encode = MD_one_enable_enum;
`ifdef MOTION_DETECT_RESET_G1
            reset = 0x1;
`endif
        } eg_find_en[3:3];

        field {
            name = "obj_out_en";
            desc = "OBJ region output enable. If this field is enabled, MDU_OBJ_ADDR must be configured.";
            encode = MD_one_enable_enum;
`ifdef MOTION_DETECT_RESET_G1
            reset = 0x1;
`endif
        } obj_out_en[2:2];

        field {
            name = "sad_out_en";
            desc = "SAD output enable. If this field is enabled, MDU_MBSAD_ADDR and MDU_MBSAD_STRIDE must be";
            encode = MD_one_enable_enum;
`ifdef MOTION_DETECT_RESET_G1
            reset = 0x0;
`endif
        } sad_out_en[1:1];

        enum MD_sad_mad_sel_enum {
            BIT_8  = 0x0 { desc = "8 Bits"; };
            BIT_16 = 0x1 { desc = "16 Bits"; };
        };

        field {
            name = "sad_mad_sel";
            desc = "Number of SAD output bits.";
            encode = MD_sad_mad_sel_enum;
`ifdef MOTION_DETECT_RESET_G1
            reset = 0x0;
`endif
        } sad_mad_sel[0:0];

    } MDU_MODE @ 0x24;

    reg {
        name = "MDU Start Register";

        field {
            name = "mdu_start";
            desc = "MDU start control. E.g.: Is the MDU enabled?";
            encode = MD_one_enable_enum;
            sw = w;
`ifdef MOTION_DETECT_RESET_G1
            reset = 0x0;
`endif
        } mdu_start[0:0];

    } MDU_START @ 0x28;

    reg {
        name = "AXI Outstanding Configuration Register";

        field {
            name = "axi_outstd_num";
            desc = "AXI outstanding configuration. The count value is numbered from 0 and the actual value is obtained by adding 1 to the count value.";
`ifdef MOTION_DETECT_RESET_G1
            reset = 0x0;
`endif
        } axi_outstd_num[2:0];

    } MDU_AXI_OUTSTD_NUM @ 0x2C;

    reg {
        name = "Luminance Storage Address Register of the Reference Picture";

        field {
            name = "mdu_ref_yaddr";
            desc = "Storage address of the Y component of the reference picture. The input raw picture must be Qword-aligned (128 bits). That is, the lower four bits of the address are 0. The hardware automatically sets the lower four bits of the address to 0.";
`ifdef MOTION_DETECT_RESET_G1
            reset = 0x0;
`endif
        } mdu_ref_yaddr[31:0];

    } MDU_REF_YADDR @ 0x40;

    reg {
        name = "Luminance Stride Register of the Reference Picture";

        field {
            name = "mdu_ref_ystride";
            desc = "Luminance stride, in bytes. The lower four bits of Ystride must be set to 0. This is to ensure that the address is 128-bit-aligned after the picture is wrapped. The hardware automatically sets the lower four bits of Ystride to 0. The stride must be an integral multiple of 64 bytes.";
`ifdef MOTION_DETECT_RESET_G1
            reset = 0x0;
`endif
        } mdu_ref_ystride[15:0];

    } MDU_REF_YSTRIDE @ 0x44;

    reg {
        name = "Luminance Storage Address Register of the Current Picture";

        field {
            name = "mdu_cur_yaddr";
            desc = "Storage address of the Y component of the raw picture. The input raw picture must be Qword-aligned (128 bits). That is, the lower four bits of the address are 0. The hardware automatically sets the lower four bits of the address to 0.";
`ifdef MOTION_DETECT_RESET_G1
            reset = 0x0;
`endif
        } mdu_cur_yaddr[31:0];

    } MDU_CUR_YADDR @ 0x48;

    reg {
        name = "Luminance Stride Register of the Current Picture";

        field {
            name = "mdu_cur_ystride";
            desc = "Luminance stride, in bytes. The lower four bits of Ystride must be set to 0. This is to ensure that the address is 128-bit-aligned after the picture is wrapped. The hardware automatically sets the lower four bits of Ystride to 0. The stride must be an integral multiple of 64 bytes.";
`ifdef MOTION_DETECT_RESET_G1
            reset = 0x0;
`endif
        } mdu_cur_ystride[15:0];

    } MDU_CUR_YSTRIDE @ 0x4C;

    reg {
        name = "Macroblock SAD Storage Address Register";

        field {
            name = "mdu_mbsad_addr";
            desc = "Address for storing the macroblock SAD. The address must be Qword-aligned. Therefore, the lower four bits must be 0.";
`ifdef MOTION_DETECT_RESET_G1
            reset = 0x0;
`endif
        } mdu_mbsad_addr[31:0];

    } MDU_MBSAD_ADDR @ 0x60;

    reg {
        name = "Macroblock SAD Storage Stride Register";

        field {
            name = "mdu_mbsad_stride";
            desc = "Macroblock SAD stride, in bytes. The stride must be 128-bit-aligned. Therefore, the lower four bits must be 0.";
`ifdef MOTION_DETECT_RESET_G1
            reset = 0x0;
`endif
        } mdu_mbsad_stride[15:0];

    } MDU_MBSAD_STRIDE @ 0x64;

    reg {
        name = "Luminance Storage Address Register of the Background Picture";

        field {
            name = "bg_yaddr";
            desc = "Background address. The address must be Qword-aligned. Therefore, the lower four bits must be 0.";
            sw = r;
            hw = w;
`ifdef MOTION_DETECT_RESET_G1
            reset = 0x0;
`endif
        } bg_yaddr[31:0];

    } MDU_BACKGROUND_ADDR @ 0x70;

    reg {
        name = "Luminance Stride Register of the Background Picture";

        field {
            name = "bg_ystride";
            desc = "Background stride, in bytes. The stride must be 128-bit-aligned. Therefore, the lower four bits must be 0.";
`ifdef MOTION_DETECT_RESET_G1
            reset = 0x0;
`endif
        } bg_ystride[15:0];

    } MDU_BACKGROUND_STRIDE @ 0x74;

    reg {
        name = "OBJ Region Storage Address Register";

        field {
            name = "obj_addr";
            desc = "
            Address for storing OBJ regions. The address must be Qword-aligned. Therefore, the lower four bits must be 0.

            An OBJ region is stored as follows: The coordinates of the left, top, right, and bottom points of the OBJ region are stored in sequence in four 16-bit spaces. Therefore, two 32-bit DDRs are used to store an OBJ region. When the DDR is allocated by using the software, the minimum DDR size is calculated as follows: 2 x 32 bits x Maximum number of OBJ regions
            ";
`ifdef MOTION_DETECT_RESET_G1
            reset = 0x0;
`endif
        } obj_addr[31:0];

    } MDU_OBJ_ADDR @ 0x78;

    reg {
        name = "Background Refresh Weight Register";

        field {
            name = "src_weight";
            desc = "New picture weight.";
`ifdef MOTION_DETECT_RESET_G1
            reset = 0x1;
`endif
        } src_weight[15:8];

        field {
            name = "weight_sum_exp_2";
            desc = "
            Exponent of 2 to the weighted sum.

            When the MDU generates a new background by overlaying the source picture with the existing background, the following formula is used:

            `(Background pixel x ((1<<weight_sum_exp_2) – src_weight) + Pixel of source picture x bg_weight) >> weight_sum_exp_2)`

            The background weight bg_weight is calculated as follows:

            `((1<<weight_sum_exp_2) – src_weight)`

            The greater the value obtained from background weight bg_weight minus source weight src_weight, the more slowly the background is refreshed.

            The default value is 0x1, and the maximum value is 0x8.
            ";
`ifdef MOTION_DETECT_RESET_G1
            reset = 0x1;
`endif
        } weight_sum_exp_2[7:0];

    } MDU_BG_UP_WEIGHT @ 0x7C;

    reg {
        name = "Macroblock Motion Detection Threshold Register";

        field {
            name = "mdu_mbsad_th";
            desc = "Threshold for detecting the motion status of the 4x4 macroblock. All calculations of the MDU are based on the 4x4 macroblock.";
`ifdef MOTION_DETECT_RESET_G1
            reset = 0x1E;
`endif
        } mdu_mbsad_th[15:0];

    } MDU_MBSAD_TH @ 0x80;

    reg {
        name = "Timeout Upper Limit Register";

        field {
            name = "mdu_timeout";
            desc = "Maximum number of working cycles.";
`ifdef MOTION_DETECT_RESET_G1
            reset = 0x3600000;
`endif
        } mdu_timeout[31:0];

    } MDU_TIMEOUT @ 0x84;

    reg {
        name = "SAD Output Window Configuration Register";

        enum MD_sad_wnd_size_enum {
            SQUARE_8  = 0x0 { desc = "8x8"; };
            SQUARE_16 = 0x1 { desc = "16x16"; };
        };

        field {
            name = "sad_wnd_size";
            desc = "Size of the SAD output window. The calculations of the MDU are based on the 4x4 macroblock. After the sad_out_en bit of the mode register is enabled, the MDU adds the values of multiple 4x4 macroblocks based on the settings of sad_wnd_size, and outputs the value to the DDR.";
            encode = MD_sad_wnd_size_enum;
`ifdef MOTION_DETECT_RESET_G1
            reset = 0x1;
`endif
        } sad_wnd_size[0:0];

    } MDU_WND_SIZE @ 0x90;

    reg {
        name = "Minimum Window Configuration Register for Boundary Search";

        field {
            name = "egsearch_timeout";
            desc = "Boundary search timeout. If the number of points of an OBJ region is greater than the value, the boundary search of the OBJ region stops, and the search for the next region starts.";
`ifdef MOTION_DETECT_RESET_G1
            reset = 0x300;
`endif
        } egsearch_timeout[31:16];

        field {
            name = "min_obj_size_h";
            desc = "Minimum height of the OBJ region. The OBJ region whose height is smaller than this value is not reported. The value 1 of min_obj_size_h indicates a 4x4 macroblock.";
`ifdef MOTION_DETECT_RESET_G1
            reset = 0x1;
`endif
        } min_obj_size_h[15:8];

        field {
            name = "min_obj_size_w";
            desc = "Minimum width of the OBJ region. The OBJ region whose width is smaller than this value is not reported. The value 1 of min_obj_size_w indicates a 4x4 macroblock.";
`ifdef MOTION_DETECT_RESET_G1
            reset = 0x1;
`endif
        } min_obj_size_w[7:0];

    } MDU_MIN_OBJ_SIZE @ 0x94;

    reg {
        name = "Maximum Window Configuration Register for Boundary Search";

        field {
            name = "max_obj_cnt";
            desc = "Maximum value for detecting the OBJ regions.";
`ifdef MOTION_DETECT_RESET_G1
            reset = 0x100;
`endif
        } max_obj_cnt[15:0];

    } MDU_MAX_OBJ_CNT @ 0x98;

    reg {
        name = "OBJ Region Information Readback Register";

        field {
            name = "max_obj_index";
            desc = "Maximum OBJ region index. For the statistics register whose name does not contain the digital suffix, the statistics are obtained when the SAD is calculated and the OBJ region is searched for the first time based on the frame reference algorithm or background algorithm.";
            sw = r;
            hw = w;
`ifdef MOTION_DETECT_RESET_G1
            reset = 0x0;
`endif
        } max_obj_index[31:16];

        field {
            name = "obj_cnt";
            desc = "Number of detected OBJ regions.";
            sw = r;
            hw = w;
`ifdef MOTION_DETECT_RESET_G1
            reset = 0x0;
`endif
        } obj_cnt[15:0];

    } MDU_OBJ_CNT @ 0x9C;

    reg {
        name = "Maximum OBJ Region Readback Register";

        field {
            name = "max_obj_size";
            desc = "
            Maximum size of the OBJ region. This value is used to detect video occlusion. The value is in the unit of pixel.

            The software calculates the percentage of OBJ regions based on this value and compares the value with the size threshold of the OBJ region. If the value is greater than the threshold, the frame occlusion is considered, and the subsequent frames for detecting video occlusion are not used to refresh the background. In addition, the system checks whether the size of the OBJ region is greater than the threshold for consecutive times. If the occlusion time is greater than the time threshold, video occlusion is considered, and an alarm is generated.
            ";
            sw = r;
            hw = w;
`ifdef MOTION_DETECT_RESET_G1
            reset = 0x0;
`endif
        } max_obj_size[31:0];

    } MDU_MAX_OBJ_SIZE @ 0xA0;

    reg {
        name = "All OBJ Region Readback Register";

        field {
            name = "total_obj_size";
            desc = "
            Total size of all OBJ regions. This value is used to detect whether a camera is sprayed. The working principle is the same as that of the max_obj_size field.

            The MDU adds the sizes of all OBJ regions. The size is in the unit of pixel. The size of each OBJ region is calculated as follows:

            `number of 4x4 macroblocks x 16`

            !!! NOTE
                * In some cases, the OBJ regions may overlap, and the total size of OBJ regions may be greater than the size of the original picture.
                * Based on the 4x4 macroblock, the height and width of each OBJ region are calculated as follows:
                  `Width = (Horizontal coordinate of the right point – Horizontal coordinate of the left point) + 1`
                  `Height = (Vertical coordinate of the bottom point – Vertical coordinate of the top point) + 1`
            ";
            sw = r;
            hw = w;
            reset = 0x0;
        } total_obj_size[31:0];

    } MDU_TOTAL_OBJ_SIZE @ 0xA4;

    reg {
        name = "Motion Pixel Statistics Register for Frame";

        field {
            name = "move_pix_cnt";
            desc = "
            Number of motion pixels of an entire frame. This value can be used to detect video occlusion. The working principle is the same as that of the max_obj_size field.

            !!! NOTE
                The value of this register is based on pixels. Therefore, the register value may be different from the value of total_obj_size.
            ";
            sw = r;
            hw = w;
`ifdef MOTION_DETECT_RESET_G1
            reset = 0x0;
`endif
        } move_pix_cnt[31:0];

    } MDU_MOVE_PIX_CNT @ 0xA8;

    reg {
        name = "OBJ Region Information Readback Register Based on Background";

        field {
            name = "max_obj_index1";
            desc = "Index of the maximum OBJ region based on the background. The registers with the suffix 1 indicate statistics registers. The statistics are obtained when the background algorithm is used and the SAD is calculated and the OBJ region is searched for the second time.";
            sw = r;
            hw = w;
`ifdef MOTION_DETECT_RESET_G1
            reset = 0x0;
`endif
        } max_obj_index1[31:16];

        field {
            name = "obj_cnt1";
            desc = "Number of detected OBJ regions based on the background.";
            sw = r;
            hw = w;
`ifdef MOTION_DETECT_RESET_G1
            reset = 0x0;
`endif
        } obj_cnt1[15:0];

    } MDU_OBJ_CNT1 @ 0xAC;

    reg {
        name = "OBJ Region Readback Register Based on Background";

        field {
            name = "max_obj_size1";
            desc = "
            Maximum size of the OBJ region based on the background. This value is used to detect video occlusion, and is in the unit of pixel.

            The software calculates the percentage of OBJ regions based on this value and compares the value with the size threshold of the OBJ region. If the value is greater than the threshold, the frame occlusion is considered, and the subsequent frames for detecting video occlusion are not used to refresh the background. In addition, the system checks whether the size of the OBJ region is greater than the threshold for consecutive times. If the occlusion time is greater than the time threshold, video occlusion is considered, and an alarm is generated.
            ";
            sw = r;
            hw = w;
`ifdef MOTION_DETECT_RESET_G1
            reset = 0x0;
`endif
        } max_obj_size1[31:0];

    } MDU_MAX_OBJ_SIZE1 @ 0xB0;

    reg {
        name = "All OBJ Region Readback Register Based on Background";

        field {
            name = "total_obj_size1";
            desc = "Total size of all OBJ regions based on the background (sum of the sizes of all OBJ regions, in pixels). The working principle is the same as that of the total_obj_size field.";
            sw = r;
            hw = w;
            reset = 0x0;
        } total_obj_size1[31:0];

    } MDU_TOTAL_OBJ_SIZE1 @ 0xB4;

    reg {
        name = "Motion Pixel Statistics Register for a Frame Based on Background";

        field {
            name = "move_pix_cnt1";
            desc = "Number of motion pixels of an entire frame based on the background. This value can be used to detect video occlusion. The working principle is the same as that of the max_obj_size field.";
            sw = r;
            hw = w;
`ifdef MOTION_DETECT_RESET_G1
            reset = 0x0;
`endif
        } move_pix_cnt1[31:0];

    } MDU_MOVE_PIX_CNT1 @ 0xB8;

};
`endif
