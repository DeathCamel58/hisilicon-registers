`ifndef HISI_MIPI_RX_CV300_RDL
`define HISI_MIPI_RX_CV300_RDL


regfile eHISI_MIPI_RX_CV300 {
    name = "MIPI RX (sensor serial interface receiver, Hi3516C V300 / Hi3516E V100)";
    desc = "
    MIPI RX (combo PHY + controller for MIPI D-PHY CSI-2, LVDS / sub-LVDS / HiSPI and CMOS parallel sensors, feeding the VICAP) of the Hi3516C V300 / Hi3516E V100 at 0x11300000. Second-generation layout: PHY link 0 registers at 0x0 (PHY_MODE_LINK0 .. PHY_SYNC_CODEn_LINK0, CIL interrupts at 0x1F0), channel/system registers at 0x800 (CHN0_*, PHY_ID), the MIPI controller of device 0 at 0x1000 (MIPI0_*: lanes, DI, packet/frame/line interrupts, DOL IDs, crop, image-size statistics) and the LVDS controller at 0x1300 (LVDS0_*: WDR, crop, per-lane SOF/EOF/SOL/EOL and next-frame sync codes, LI words, statistics) plus ALIGN0_* at 0x1600. 78 of these 143 registers also appear (same names) in the 421-register Hi3516A V200 / Hi3519 V101 block `eHISI_MIPI_RX_AV200`. The header (COMBO_MAX_DEV_NUM 1, 4 lanes per link) matches the data sheet register for register. Non-hardware-verified transcription.

    Generated 2026-11-10 by build/rdl-audit/video-rdl-scratch/gen_blocks.py: mechanical transcription of the data sheet register tables (ds_extract2 + description extraction from the PDF) merged with the vendor header; not hardware verified.

    Register sources: 143 registers from the data sheet (hi3516cv300--Hi3516CV300-Hi3516EV100-Datasheet.txt, section 9.3.6); 0 registers and 1 fields from OpenIPC openhisilicon `kernel/mipi_rx/hi3516cv300/mipi_reg.h` (GPL-3.0 repository, HiSilicon copyright; local copy sources/openhisilicon) (GPL-3.0 repository, HiSilicon copyright), each marked `[inferred]` in its desc (names from the header, meanings inferred from the names, reset/access unknown). 6 field names that the data-sheet text extraction garbled (two column cells run together) were taken from the header. Name differences, data sheet kept: 0x20 PHY_DATA_MIPI_LINK0 [7:0] DS sphy0_data0_mipi_hs / header phy_data0_mipi_hs; 0x20 PHY_DATA_MIPI_LINK0 [15:8] DS sphy0_data1_mipi_hsphy0_data0_mipi_h / header phy_data1_mipi_hs; 0x20 PHY_DATA_MIPI_LINK0 [23:16] DS sphy0_data2_mipi_hsphy0_data1_mipi_h / header phy_data2_mipi_hs; 0x20 PHY_DATA_MIPI_LINK0 [31:24] DS phy0_data3_mipi_hsphy0_data2_mipi_h / header phy_data3_mipi_hs; 0x1250 MIPI0_IMGSIZE0_STATIS [15:0] data-sheet text `c0imgwidth_statis_vc` garbled, header name imgwidth_statis_vc used; 0x1250 MIPI0_IMGSIZE0_STATIS [31:16] data-sheet text `imgheight_statis_vc0imgwidth_statis_vc` garbled, header name imgheight_statis_vc used; 0x1258 MIPI0_IMGSIZE2_STATIS [15:0] data-sheet text `c2imgwidth_statis_vc` garbled, header name imgwidth_statis_vc used; 0x1258 MIPI0_IMGSIZE2_STATIS [31:16] data-sheet text `imgheight_statis_vc2imgwidth_statis_vc` garbled, header name imgheight_statis_vc used; 0x125C MIPI0_IMGSIZE3_STATIS [15:0] data-sheet text `c3imgwidth_statis_vc` garbled, header name imgwidth_statis_vc used; 0x125C MIPI0_IMGSIZE3_STATIS [31:16] data-sheet text `imgheight_statis_vc3imgwidth_statis_vc` garbled, header name imgheight_statis_vc used; 0x1308 LVDS0_DOLSCD_HBLK header field dol_hblank1 [11:0] overlaps DS fields differently; 0x1308 LVDS0_DOLSCD_HBLK header field dol_hblank2 [27:16] overlaps DS fields differently; 0x13A0 LVDS0_LANE0_NXT_SOF_01 [15:0] DS lane0_nxt_sof_0 / header lane_sof_0; 0x13A0 LVDS0_LANE0_NXT_SOF_01 [31:16] DS lane0_nxt_sof_1 / header lane_sof_1; 0x13A4 LVDS0_LANE0_NXT_SOF_23 [15:0] DS lane0_nxt_sof_2 / header lane_sof_2; 0x13A4 LVDS0_LANE0_NXT_SOF_23 [31:16] DS lane0_nxt_sof_3 / header lane_sof_3; 0x13A8 LVDS0_LANE0_NXT_EOF_01 [15:0] DS lane0_nxt_eof_0 / header lane_eof_0; 0x13A8 LVDS0_LANE0_NXT_EOF_01 [31:16] DS lane0_nxt_eof_1 / header lane_eof_1; 0x13AC LVDS0_LANE0_NXT_EOF_23 [15:0] DS lane0_nxt_eof_2 / header lane_eof_2; 0x13AC LVDS0_LANE0_NXT_EOF_23 [31:16] DS lane0_nxt_eof_3 / header lane_eof_3; 0x13B0 LVDS0_LANE0_NXT_SOL_01 [15:0] DS lane0_nxt_sol_0 / header lane_sol_0; 0x13B0 LVDS0_LANE0_NXT_SOL_01 [31:16] DS lane0_nxt_sol_1 / header lane_sol_1; 0x13B4 LVDS0_LANE0_NXT_SOL_23 [15:0] DS lane0_nxt_sol_2 / header lane_sol_2; 0x13B4 LVDS0_LANE0_NXT_SOL_23 [31:16] DS lane0_nxt_sol_3 / header lane_sol_3; 0x13B8 LVDS0_LANE0_NXT_EOL_01 [15:0] DS lane0_nxt_eol_0 / header lane_eol_0; 0x13B8 LVDS0_LANE0_NXT_EOL_01 [31:16] DS lane0_nxt_eol_1 / header lane_eol_1; 0x13BC LVDS0_LANE0_NXT_EOL_23 [15:0] DS lane0_nxt_eol_2 / header lane_eol_2; 0x13BC LVDS0_LANE0_NXT_EOL_23 [31:16] DS lane0_nxt_eol_3 / header lane_eol_3; 0x13C0 LVDS0_LANE1_NXT_SOF_01 [15:0] DS lane1_nxt_sof_0 / header lane_sof_0; 0x13C0 LVDS0_LANE1_NXT_SOF_01 [31:16] DS lane1_nxt_sof_1 / header lane_sof_1; 0x13C4 LVDS0_LANE1_NXT_SOF_23 [15:0] DS lane1_nxt_sof_2 / header lane_sof_2; 0x13C4 LVDS0_LANE1_NXT_SOF_23 [31:16] DS lane1_nxt_sof_3 / header lane_sof_3; 0x13C8 LVDS0_LANE1_NXT_EOF_01 [15:0] DS lane1_nxt_eof_0 / header lane_eof_0; 0x13C8 LVDS0_LANE1_NXT_EOF_01 [31:16] DS lane1_nxt_eof_1 / header lane_eof_1; 0x13CC LVDS0_LANE1_NXT_EOF_23 [15:0] DS lane1_nxt_eof_2 / header lane_eof_2; 0x13CC LVDS0_LANE1_NXT_EOF_23 [31:16] DS lane1_nxt_eof_3 / header lane_eof_3; 0x13D0 LVDS0_LANE1_NXT_SOL_01 [15:0] DS lane1_nxt_sol_0 / header lane_sol_0; 0x13D0 LVDS0_LANE1_NXT_SOL_01 [31:16] DS lane1_nxt_sol_1 / header lane_sol_1; 0x13D4 LVDS0_LANE1_NXT_SOL_23 [15:0] DS lane1_nxt_sol_2 / header lane_sol_2; 0x13D4 LVDS0_LANE1_NXT_SOL_23 [31:16] DS lane1_nxt_sol_3 / header lane_sol_3 (and 42 more).";

    reg {
        name = "Link 0 PHY operating mode register";
        desc = "PHY_MODE_LINK0 is a link 0 PHY operating mode register.

Data sheet 9.3.6 PHY_MODE_LINK0 (offset 0x0, printed page 9-133, `hi3516cv300--Hi3516CV300-Hi3516EV100-Datasheet.txt` line 34991).";

        enum PHY_MODE_LINK0_phy0_rg_mipi_mode_enum {
            COMMON_VOLTAGE_HIGHER = 0 { name = "Common Voltage Higher"; desc = "The common voltage is higher than 1.25 V."; };
            COMMON_VOLTAGE_1 = 1 { name = "Common Voltage 1"; desc = "The common voltage is 1.25 V or lower."; };
        };

        field {
            name = "phy0_rg_mipi_mode";
            desc = "MIPI/LVDS input mode select. This field is set to 0 when the PHY works in LVDS mode and the common voltage is greater than 1.25 V.";
            sw = rw;
            hw = r;
            encode = PHY_MODE_LINK0_phy0_rg_mipi_mode_enum;
            reset = 0x0;
        } phy0_rg_mipi_mode[24:24];

        enum PHY_MODE_LINK0_phy0_rg_ext_clk_en_enum {
            PAD_INPUT_DIFFERENTIAL = 0 { name = "Pad Input Differential"; desc = "PAD input differential clock."; };
            DIFFERENTIAL_CLOCK_OTHER = 1 { name = "Differential Clock Other"; desc = "differential clock of other links."; };
        };

        field {
            name = "phy0_rg_ext_clk_en";
            desc = "Differential clock source select";
            sw = rw;
            hw = r;
            encode = PHY_MODE_LINK0_phy0_rg_ext_clk_en_enum;
            reset = 0x0;
        } phy0_rg_ext_clk_en[20:20];

        enum PHY_MODE_LINK0_phy0_rg_faclk_en_enum {
            DATA_OUTPUT_AT = 0 { name = "Data Output At"; desc = "Data is output at the rising edge of the clock."; };
            DATA_OUTPUT_AT_2 = 1 { name = "Data Output At 2"; desc = "Data is output at the falling edge of the clock."; };
        };

        field {
            name = "phy0_rg_faclk_en";
            desc = "Phase of the associated clock for the PHY output data";
            sw = rw;
            hw = r;
            encode = PHY_MODE_LINK0_phy0_rg_faclk_en_enum;
            reset = 0x0;
        } phy0_rg_faclk_en[16:16];

        enum PHY_MODE_LINK0_phy0_rg_en_lp_enum {
            DISABLED = 0 { name = "Disabled"; desc = "disabled"; };
            ENABLED = 1 { name = "Enabled"; desc = "enabled"; };
        };

        field {
            name = "phy0_rg_en_lp";
            desc = "PHY LP mode enable. The LP mode is enabled in MIPI mode and disabled in other modes.";
            sw = rw;
            hw = r;
            encode = PHY_MODE_LINK0_phy0_rg_en_lp_enum;
            reset = 0x0;
        } phy0_rg_en_lp[12:12];

        enum PHY_MODE_LINK0_phy0_rg_en_cmos_enum {
            DISABLED = 0 { name = "Disabled"; desc = "disabled"; };
            ENABLED = 1 { name = "Enabled"; desc = "enabled"; };
        };

        field {
            name = "phy0_rg_en_cmos";
            desc = "PHY CMOS mode enable";
            sw = rw;
            hw = r;
            encode = PHY_MODE_LINK0_phy0_rg_en_cmos_enum;
            reset = 0x0;
        } phy0_rg_en_cmos[8:8];

        enum PHY_MODE_LINK0_phy0_rg_en_clk_enum {
            DISABLED = 0 { name = "Disabled"; desc = "disabled"; };
            ENABLED = 1 { name = "Enabled"; desc = "enabled"; };
        };

        field {
            name = "phy0_rg_en_clk";
            desc = "Clock lane enable";
            sw = rw;
            hw = r;
            encode = PHY_MODE_LINK0_phy0_rg_en_clk_enum;
            reset = 0x0;
        } phy0_rg_en_clk[4:4];

        enum PHY_MODE_LINK0_phy0_rg_en_d_enum {
            DISABLED = 0 { name = "Disabled"; desc = "disabled"; };
            ENABLED = 1 { name = "Enabled"; desc = "enabled"; };
        };

        field {
            name = "phy0_rg_en_d";
            desc = "Data lane enable";
            sw = rw;
            hw = r;
            encode = PHY_MODE_LINK0_phy0_rg_en_d_enum;
            reset = 0x0;
        } phy0_rg_en_d[3:0];
    } PHY_MODE_LINK0 @ 0x0;

    reg {
        name = "Link 0 PHY channel delay adjustment register";
        desc = "PHY_SKEW_LINK0 is a link 0 PHY channel delay adjustment register.

Data sheet 9.3.6 PHY_SKEW_LINK0 (offset 0x4, printed page 9-134, `hi3516cv300--Hi3516CV300-Hi3516EV100-Datasheet.txt` line 35063).";

        field {
            name = "phy0_d3_skew";
            desc = "Timing delay adjustment for data lane 3. The phase is delayed by about 62.5 ps each time the register value is incremented by 1.";
            sw = rw;
            hw = r;
            reset = 0x0;
        } phy0_d3_skew[18:16];

        field {
            name = "phy0_d2_skew";
            desc = "Timing delay adjustment for data lane 2. The phase is delayed by about 62.5 ps each time the register value is incremented by 1.";
            sw = rw;
            hw = r;
            reset = 0x0;
        } phy0_d2_skew[14:12];

        field {
            name = "phy0_d1_skew";
            desc = "Timing delay adjustment for data lane 1. The phase is delayed by about 62.5 ps each time the register value is incremented by 1.";
            sw = rw;
            hw = r;
            reset = 0x0;
        } phy0_d1_skew[10:8];

        field {
            name = "phy0_d0_skew";
            desc = "Timing delay adjustment for data lane 0. The phase is delayed by about 62.5 ps each time the register value is incremented by 1.";
            sw = rw;
            hw = r;
            reset = 0x0;
        } phy0_d0_skew[6:4];

        field {
            name = "phy0_clk_skew";
            desc = "Timing delay adjustment for the clock lane. The phase is delayed by about 62.5 ps each time the register value is incremented by 1.";
            sw = rw;
            hw = r;
            reset = 0x0;
        } phy0_clk_skew[2:0];
    } PHY_SKEW_LINK0 @ 0x4;

    reg {
        name = "Link 0 PHY channel enable register";
        desc = "PHY_EN_LINK0 is a link 0 PHY channel enable register.

Data sheet 9.3.6 PHY_EN_LINK0 (offset 0x8, printed page 9-135, `hi3516cv300--Hi3516CV300-Hi3516EV100-Datasheet.txt` line 35118).";

        enum PHY_EN_LINK0_phy0_clk_term_en_enum {
            INTERNAL_MATCHED_RESISTOR = 0 { name = "Internal Matched Resistor"; desc = "The internal matched resistor is disabled."; };
            INTERNAL_MATCHED_RESISTOR_2 = 1 { name = "Internal Matched Resistor 2"; desc = "The internal matched resistor is enabled."; };
        };

        field {
            name = "phy0_clk_term_en";
            desc = "Termination matched impedance enable for the clock lane";
            sw = rw;
            hw = r;
            encode = PHY_EN_LINK0_phy0_clk_term_en_enum;
            reset = 0x0;
        } phy0_clk_term_en[8:8];

        enum PHY_EN_LINK0_phy0_d3_term_en_enum {
            INTERNAL_MATCHED_RESISTOR = 0 { name = "Internal Matched Resistor"; desc = "The internal matched resistor is disabled."; };
            INTERNAL_MATCHED_RESISTOR_2 = 1 { name = "Internal Matched Resistor 2"; desc = "The internal matched resistor is enabled."; };
        };

        field {
            name = "phy0_d3_term_en";
            desc = "Termination matched impedance enable for data lane 3";
            sw = rw;
            hw = r;
            encode = PHY_EN_LINK0_phy0_d3_term_en_enum;
            reset = 0x0;
        } phy0_d3_term_en[7:7];

        enum PHY_EN_LINK0_phy0_d2_term_en_enum {
            INTERNAL_MATCHED_RESISTOR = 0 { name = "Internal Matched Resistor"; desc = "The internal matched resistor is disabled."; };
            INTERNAL_MATCHED_RESISTOR_2 = 1 { name = "Internal Matched Resistor 2"; desc = "The internal matched resistor is enabled."; };
        };

        field {
            name = "phy0_d2_term_en";
            desc = "Termination matched impedance enable for data lane 2";
            sw = rw;
            hw = r;
            encode = PHY_EN_LINK0_phy0_d2_term_en_enum;
            reset = 0x0;
        } phy0_d2_term_en[6:6];

        enum PHY_EN_LINK0_phy0_d1_term_en_enum {
            INTERNAL_MATCHED_RESISTOR = 0 { name = "Internal Matched Resistor"; desc = "The internal matched resistor is disabled."; };
            INTERNAL_MATCHED_RESISTOR_2 = 1 { name = "Internal Matched Resistor 2"; desc = "The internal matched resistor is enabled."; };
        };

        field {
            name = "phy0_d1_term_en";
            desc = "Termination matched impedance enable for data lane 1";
            sw = rw;
            hw = r;
            encode = PHY_EN_LINK0_phy0_d1_term_en_enum;
            reset = 0x0;
        } phy0_d1_term_en[5:5];

        enum PHY_EN_LINK0_phy0_d0_term_en_enum {
            INTERNAL_MATCHED_RESISTOR = 0 { name = "Internal Matched Resistor"; desc = "The internal matched resistor is disabled."; };
            INTERNAL_MATCHED_RESISTOR_2 = 1 { name = "Internal Matched Resistor 2"; desc = "The internal matched resistor is enabled."; };
        };

        field {
            name = "phy0_d0_term_en";
            desc = "Termination matched impedance enable for data lane 0";
            sw = rw;
            hw = r;
            encode = PHY_EN_LINK0_phy0_d0_term_en_enum;
            reset = 0x0;
        } phy0_d0_term_en[4:4];

        enum PHY_EN_LINK0_phy0_da_d3_valid_enum {
            DISABLED = 0 { name = "Disabled"; desc = "disabled"; };
            ENABLED = 1 { name = "Enabled"; desc = "enabled"; };
        };

        field {
            name = "phy0_da_d3_valid";
            desc = "High-speed mode enable for data lane 3";
            sw = rw;
            hw = r;
            encode = PHY_EN_LINK0_phy0_da_d3_valid_enum;
            reset = 0x0;
        } phy0_da_d3_valid[3:3];

        enum PHY_EN_LINK0_phy0_da_d2_valid_enum {
            DISABLED = 0 { name = "Disabled"; desc = "disabled"; };
            ENABLED = 1 { name = "Enabled"; desc = "enabled"; };
        };

        field {
            name = "phy0_da_d2_valid";
            desc = "High-speed mode enable for data lane 2";
            sw = rw;
            hw = r;
            encode = PHY_EN_LINK0_phy0_da_d2_valid_enum;
            reset = 0x0;
        } phy0_da_d2_valid[2:2];

        enum PHY_EN_LINK0_phy0_da_d1_valid_enum {
            DISABLED = 0 { name = "Disabled"; desc = "disabled"; };
            ENABLED = 1 { name = "Enabled"; desc = "enabled"; };
        };

        field {
            name = "phy0_da_d1_valid";
            desc = "High-speed mode enable for data lane 1";
            sw = rw;
            hw = r;
            encode = PHY_EN_LINK0_phy0_da_d1_valid_enum;
            reset = 0x0;
        } phy0_da_d1_valid[1:1];

        enum PHY_EN_LINK0_phy0_da_d0_valid_enum {
            DISABLED = 0 { name = "Disabled"; desc = "disabled"; };
            ENABLED = 1 { name = "Enabled"; desc = "enabled"; };
        };

        field {
            name = "phy0_da_d0_valid";
            desc = "High-speed mode enable for data lane 0";
            sw = rw;
            hw = r;
            encode = PHY_EN_LINK0_phy0_da_d0_valid_enum;
            reset = 0x0;
        } phy0_da_d0_valid[0:0];
    } PHY_EN_LINK0 @ 0x8;

    reg {
        name = "Link 0 PHY output parallel data register";
        desc = "PHY_DATA_LINK0 is a link 0 PHY output parallel data register.

Data sheet 9.3.6 PHY_DATA_LINK0 (offset 0x18, printed page 9-136, `hi3516cv300--Hi3516CV300-Hi3516EV100-Datasheet.txt` line 35181).";

        field {
            name = "phy0_data3_mipi";
            desc = "Data received by data lane 3";
            sw = r;
            hw = w;
            reset = 0x0;
        } phy0_data3_mipi[31:24];

        field {
            name = "phy0_data2_mipi";
            desc = "Data received by data lane 2";
            sw = r;
            hw = w;
            reset = 0x0;
        } phy0_data2_mipi[23:16];

        field {
            name = "phy0_data1_mipi";
            desc = "Data received by data lane 1";
            sw = r;
            hw = w;
            reset = 0x0;
        } phy0_data1_mipi[15:8];

        field {
            name = "phy0_data0_mipi";
            desc = "Data received by data lane 0";
            sw = r;
            hw = w;
            reset = 0x0;
        } phy0_data0_mipi[7:0];
    } PHY_DATA_LINK0 @ 0x18;

    reg {
        name = "Link 0 MIPI data packet header register";
        desc = "PHY_PH_MIPI_LINK0 is a link 0 MIPI data packet header register. Hi3516C V300/Hi3516E V100 Professional HD IP Camera SoC

Data sheet 9.3.6 PHY_PH_MIPI_LINK0 (offset 0x1C, printed page 9-137, `hi3516cv300--Hi3516CV300-Hi3516EV100-Datasheet.txt` line 35212).";

        field {
            name = "phy0_ph3_mipi";
            desc = "Data packet header received by data lane 3";
            sw = r;
            hw = w;
            reset = 0x0;
        } phy0_ph3_mipi[31:24];

        field {
            name = "phy0_ph2_mipi";
            desc = "Data packet header received by data lane 2";
            sw = r;
            hw = w;
            reset = 0x0;
        } phy0_ph2_mipi[23:16];

        field {
            name = "phy0_ph1_mipi";
            desc = "Data packet header received by data lane 1";
            sw = r;
            hw = w;
            reset = 0x0;
        } phy0_ph1_mipi[15:8];

        field {
            name = "phy0_ph0_mipi";
            desc = "Data packet header received by data lane 0";
            sw = r;
            hw = w;
            reset = 0x0;
        } phy0_ph0_mipi[7:0];
    } PHY_PH_MIPI_LINK0 @ 0x1C;

    reg {
        name = "Link 0 MIPI mode data register 0";
        desc = "PHY_DATA_MIPI_LINK0 is a link 0 MIPI mode data register.

Data sheet 9.3.6 PHY_DATA_MIPI_LINK0 (offset 0x20, printed page 9-137, `hi3516cv300--Hi3516CV300-Hi3516EV100-Datasheet.txt` line 35233).";

        field {
            name = "phy0_data3_mipi_hsphy0_data2_mipi_h";
            desc = "MIPI data for data lane 3";
            sw = r;
            hw = w;
            reset = 0x0;
        } phy0_data3_mipi_hsphy0_data2_mipi_h[31:24];

        field {
            name = "sphy0_data2_mipi_hsphy0_data1_mipi_h";
            desc = "MIPI data for data lane 2";
            sw = r;
            hw = w;
            reset = 0x0;
        } sphy0_data2_mipi_hsphy0_data1_mipi_h[23:16];

        field {
            name = "sphy0_data1_mipi_hsphy0_data0_mipi_h";
            desc = "MIPI data for data lane 1";
            sw = r;
            hw = w;
            reset = 0x0;
        } sphy0_data1_mipi_hsphy0_data0_mipi_h[15:8];

        field {
            name = "sphy0_data0_mipi_hs";
            desc = "MIPI data for data lane 0";
            sw = r;
            hw = w;
            reset = 0x0;
        } sphy0_data0_mipi_hs[7:0];
    } PHY_DATA_MIPI_LINK0 @ 0x20;

    reg {
        name = "Link 0 PHY LVDS mode synchronization header detection control register";
        desc = "PHY_SYNC_DCT_LINK0 is a link 0 PHY LVDS mode synchronization header detection control register. Hi3516C V300/Hi3516E V100 Professional HD IP Camera SoC

Data sheet 9.3.6 PHY_SYNC_DCT_LINK0 (offset 0x24, printed page 9-138, `hi3516cv300--Hi3516CV300-Hi3516EV100-Datasheet.txt` line 35274).";

        enum PHY_SYNC_DCT_LINK0_cil0_code_big_endian_enum {
            LSB_LOWER_BITS = 0 { name = "Lsb Lower Bits"; desc = "LSB. The lower bits are transmitted first. The serial data sequence of the received synchronization code is bit 0, bit 1, ..., and bit 11."; };
            MSB_UPPER_BITS = 1 { name = "Msb Upper Bits"; desc = "MSB. The upper bits are transmitted first. The serial data sequence of the received synchronization code is bit 11, bit 10, ..., and bit 0."; };
        };

        field {
            name = "cil0_code_big_endian";
            desc = "Serial bit transmission sequence for the synchronization code (sync_code) of the raw data to be transmitted in LVDS or HiSPI mode";
            sw = rw;
            hw = r;
            encode = PHY_SYNC_DCT_LINK0_cil0_code_big_endian_enum;
            reset = 0x1;
        } cil0_code_big_endian[8:8];

        enum PHY_SYNC_DCT_LINK0_cil0_split_mode_enum {
            PER_LANE_MODE = 0 { name = "Per Lane Mode"; desc = "per lane mode"; };
            SPLIT_2_LANE = 3 { name = "Split 2 Lane"; desc = "Split 2 lane mode"; };
            SPLIT_4_LANE = 7 { name = "Split 4 Lane"; desc = "Split 4 lane mode Other values: reserved"; };
        };

        field {
            name = "cil0_split_mode";
            desc = "Transfer type for the synchronization code in LVDS or HiSPI mode";
            sw = rw;
            hw = r;
            encode = PHY_SYNC_DCT_LINK0_cil0_split_mode_enum;
            reset = 0x0;
        } cil0_split_mode[6:4];

        enum PHY_SYNC_DCT_LINK0_cil0_raw_type_enum {
            V_8_BIT_RAW = 1 { name = "V 8 Bit Raw"; desc = "8-bit raw data"; };
            V_10_BIT_RAW = 2 { name = "V 10 Bit Raw"; desc = "10-bit raw data"; };
            V_12_BIT_RAW = 3 { name = "V 12 Bit Raw"; desc = "12-bit raw data"; };
            V_14_BIT_RAW = 4 { name = "V 14 Bit Raw"; desc = "14-bit raw data"; };
            V_16_BIT_RAW = 5 { name = "V 16 Bit Raw"; desc = "16-bit raw data Other values: reserved"; };
        };

        field {
            name = "cil0_raw_type";
            desc = "Type of the raw data to be transmitted in LVDS or HiSPI mode";
            sw = rw;
            hw = r;
            encode = PHY_SYNC_DCT_LINK0_cil0_raw_type_enum;
            reset = 0x1;
        } cil0_raw_type[2:0];
    } PHY_SYNC_DCT_LINK0 @ 0x24;

    reg {
        name = "Link 0 PHY LVDS mode lane 0 K0 synchronization header register";
        desc = "PHY_SYNC_CODE0_LINK0 is link 0 PHY LVDS mode lane 0 synchronization header register.

Data sheet 9.3.6 PHY_SYNC_CODE0_LINK0 (offset 0x30, printed page 9-139, `hi3516cv300--Hi3516CV300-Hi3516EV100-Datasheet.txt` line 35335).";

        field {
            name = "cil0_sof1_word4_0";
            desc = "Lane 0 SOF synchronization code (for frame + 1)";
            sw = rw;
            hw = r;
            reset = 0x0;
        } cil0_sof1_word4_0[31:16];

        field {
            name = "cil0_sof0_word4_0";
            desc = "Lane 0 SOF synchronization code (for frame N)";
            sw = rw;
            hw = r;
            reset = 0x0;
        } cil0_sof0_word4_0[15:0];
    } PHY_SYNC_CODE0_LINK0 @ 0x30;

    reg {
        name = "Link 0 PHY LVDS mode lane 1 K0 synchronization header register";
        desc = "PHY_SYNC_CODE1_LINK0 is link 0 PHY LVDS mode lane 1 synchronization header register.

Data sheet 9.3.6 PHY_SYNC_CODE1_LINK0 (offset 0x34, printed page 9-139, `hi3516cv300--Hi3516CV300-Hi3516EV100-Datasheet.txt` line 35356).";

        field {
            name = "cil0_sof1_word4_1";
            desc = "Lane 1 SOF synchronization code (for frame N + 1)";
            sw = rw;
            hw = r;
            reset = 0x0;
        } cil0_sof1_word4_1[31:16];

        field {
            name = "cil0_sof0_word4_1";
            desc = "Lane 1 SOF synchronization code (for frame N)";
            sw = rw;
            hw = r;
            reset = 0x0;
        } cil0_sof0_word4_1[15:0];
    } PHY_SYNC_CODE1_LINK0 @ 0x34;

    reg {
        name = "Link 0 PHY LVDS mode lane 2 K0 synchronization header register";
        desc = "PHY_SYNC_CODE2_LINK0 is link 0 PHY LVDS mode lane 2 synchronization header register. Hi3516C V300/Hi3516E V100 Professional HD IP Camera SoC

Data sheet 9.3.6 PHY_SYNC_CODE2_LINK0 (offset 0x38, printed page 9-140, `hi3516cv300--Hi3516CV300-Hi3516EV100-Datasheet.txt` line 35386).";

        field {
            name = "cil0_sof1_word4_2";
            desc = "Lane 2 SOF synchronization code (for frame N + 1)";
            sw = rw;
            hw = r;
            reset = 0x0;
        } cil0_sof1_word4_2[31:16];

        field {
            name = "cil0_sof0_word4_2";
            desc = "Lane 2 SOF synchronization code (for frame N)";
            sw = rw;
            hw = r;
            reset = 0x0;
        } cil0_sof0_word4_2[15:0];
    } PHY_SYNC_CODE2_LINK0 @ 0x38;

    reg {
        name = "Link 0 PHY LVDS mode lane 3 K0 synchronization header register";
        desc = "PHY_SYNC_CODE3_LINK0 is link 0 PHY LVDS mode lane 3 synchronization header register.

Data sheet 9.3.6 PHY_SYNC_CODE3_LINK0 (offset 0x3C, printed page 9-140, `hi3516cv300--Hi3516CV300-Hi3516EV100-Datasheet.txt` line 35406).";

        field {
            name = "cil0_sof1_word4_3";
            desc = "Lane 3 SOF synchronization code (for frame + 1)";
            sw = rw;
            hw = r;
            reset = 0x0;
        } cil0_sof1_word4_3[31:16];

        field {
            name = "cil0_sof0_word4_3";
            desc = "Lane 3 SOF synchronization code (for frame";
            sw = rw;
            hw = r;
            reset = 0x0;
        } cil0_sof0_word4_3[15:0];
    } PHY_SYNC_CODE3_LINK0 @ 0x3C;

    reg {
        name = "Link 0 MIPI CIL raw interrupt status NK0 register";
        desc = "MIPI_CIL_INT_RAW_LINK0 is a link 0 MIPI CIL raw interrupt status register. Hi3516C V300/Hi3516E V100 Professional HD IP Camera SoC

Data sheet 9.3.6 MIPI_CIL_INT_RAW_LINK0 (offset 0x1F0, printed page 9-141, `hi3516cv300--Hi3516CV300-Hi3516EV100-Datasheet.txt` line 35435).";

        enum MIPI_CIL_INT_RAW_LINK0_err0_timeout_ck_raw_enum {
            NO_RAW_INTERRUPT = 0 { name = "No Raw Interrupt"; desc = "No raw interrupt is generated."; };
            RAW_INTERRUPT_GENERATED = 1 { name = "Raw Interrupt Generated"; desc = "A raw interrupt is generated."; };
        };

        field {
            name = "err0_timeout_ck_raw";
            desc = "Status of the raw FSM timeout interrupt for the clock lane";
            sw = rw;
            hw = w;
            onwrite = woclr;
            encode = MIPI_CIL_INT_RAW_LINK0_err0_timeout_ck_raw_enum;
            reset = 0x0;
        } err0_timeout_ck_raw[12:12];

        enum MIPI_CIL_INT_RAW_LINK0_err0_timeout_d3_raw_enum {
            NO_RAW_INTERRUPT = 0 { name = "No Raw Interrupt"; desc = "No raw interrupt is generated."; };
            RAW_INTERRUPT_GENERATED = 1 { name = "Raw Interrupt Generated"; desc = "A raw interrupt is generated."; };
        };

        field {
            name = "err0_timeout_d3_raw";
            desc = "Status of the raw FSM timeout interrupt for data lane 3";
            sw = rw;
            hw = w;
            onwrite = woclr;
            encode = MIPI_CIL_INT_RAW_LINK0_err0_timeout_d3_raw_enum;
            reset = 0x0;
        } err0_timeout_d3_raw[11:11];

        enum MIPI_CIL_INT_RAW_LINK0_err0_timeout_d2_raw_enum {
            NO_RAW_INTERRUPT = 0 { name = "No Raw Interrupt"; desc = "No raw interrupt is generated."; };
            RAW_INTERRUPT_GENERATED = 1 { name = "Raw Interrupt Generated"; desc = "A raw interrupt is generated."; };
        };

        field {
            name = "err0_timeout_d2_raw";
            desc = "Status of the raw FSM timeout interrupt for data lane 2";
            sw = rw;
            hw = w;
            onwrite = woclr;
            encode = MIPI_CIL_INT_RAW_LINK0_err0_timeout_d2_raw_enum;
            reset = 0x0;
        } err0_timeout_d2_raw[10:10];

        enum MIPI_CIL_INT_RAW_LINK0_err0_timeout_d1_raw_enum {
            NO_RAW_INTERRUPT = 0 { name = "No Raw Interrupt"; desc = "No raw interrupt is generated."; };
            RAW_INTERRUPT_GENERATED = 1 { name = "Raw Interrupt Generated"; desc = "A raw interrupt is generated."; };
        };

        field {
            name = "err0_timeout_d1_raw";
            desc = "Status of the raw FSM timeout interrupt for data lane 1";
            sw = rw;
            hw = w;
            onwrite = woclr;
            encode = MIPI_CIL_INT_RAW_LINK0_err0_timeout_d1_raw_enum;
            reset = 0x0;
        } err0_timeout_d1_raw[9:9];

        enum MIPI_CIL_INT_RAW_LINK0_err0_timeout_d0_raw_enum {
            NO_RAW_INTERRUPT = 0 { name = "No Raw Interrupt"; desc = "No raw interrupt is generated."; };
            RAW_INTERRUPT_GENERATED = 1 { name = "Raw Interrupt Generated"; desc = "A raw interrupt is generated."; };
        };

        field {
            name = "err0_timeout_d0_raw";
            desc = "Status of the raw FSM timeout interrupt for data lane 0";
            sw = rw;
            hw = w;
            onwrite = woclr;
            encode = MIPI_CIL_INT_RAW_LINK0_err0_timeout_d0_raw_enum;
            reset = 0x0;
        } err0_timeout_d0_raw[8:8];

        enum MIPI_CIL_INT_RAW_LINK0_err0_escape_ck_raw_enum {
            NO_RAW_INTERRUPT = 0 { name = "No Raw Interrupt"; desc = "No raw interrupt is generated."; };
            RAW_INTERRUPT_GENERATED = 1 { name = "Raw Interrupt Generated"; desc = "A raw interrupt is generated."; };
        };

        field {
            name = "err0_escape_ck_raw";
            desc = "Status of the raw escape sequence interrupt for the clock lane";
            sw = rw;
            hw = w;
            onwrite = woclr;
            encode = MIPI_CIL_INT_RAW_LINK0_err0_escape_ck_raw_enum;
            reset = 0x0;
        } err0_escape_ck_raw[4:4];

        enum MIPI_CIL_INT_RAW_LINK0_err0_escape_d3_raw_enum {
            NO_RAW_INTERRUPT = 0 { name = "No Raw Interrupt"; desc = "No raw interrupt is generated."; };
            RAW_INTERRUPT_GENERATED = 1 { name = "Raw Interrupt Generated"; desc = "A raw interrupt is generated."; };
        };

        field {
            name = "err0_escape_d3_raw";
            desc = "Status of the raw escape sequence interrupt for data lane 3";
            sw = rw;
            hw = w;
            onwrite = woclr;
            encode = MIPI_CIL_INT_RAW_LINK0_err0_escape_d3_raw_enum;
            reset = 0x0;
        } err0_escape_d3_raw[3:3];

        enum MIPI_CIL_INT_RAW_LINK0_err0_escape_d2_raw_enum {
            NO_RAW_INTERRUPT = 0 { name = "No Raw Interrupt"; desc = "No raw interrupt is generated."; };
            RAW_INTERRUPT_GENERATED = 1 { name = "Raw Interrupt Generated"; desc = "A raw interrupt is generated."; };
        };

        field {
            name = "err0_escape_d2_raw";
            desc = "Status of the raw escape sequence interrupt for data lane 2";
            sw = rw;
            hw = w;
            onwrite = woclr;
            encode = MIPI_CIL_INT_RAW_LINK0_err0_escape_d2_raw_enum;
            reset = 0x0;
        } err0_escape_d2_raw[2:2];

        enum MIPI_CIL_INT_RAW_LINK0_err0_escape_d1_raw_enum {
            NO_RAW_INTERRUPT = 0 { name = "No Raw Interrupt"; desc = "No raw interrupt is generated."; };
            RAW_INTERRUPT_GENERATED = 1 { name = "Raw Interrupt Generated"; desc = "A raw interrupt is generated."; };
        };

        field {
            name = "err0_escape_d1_raw";
            desc = "Status of the raw escape sequence interrupt for data lane 1";
            sw = rw;
            hw = w;
            onwrite = woclr;
            encode = MIPI_CIL_INT_RAW_LINK0_err0_escape_d1_raw_enum;
            reset = 0x0;
        } err0_escape_d1_raw[1:1];

        enum MIPI_CIL_INT_RAW_LINK0_err0_escape_d0_raw_enum {
            NO_RAW_INTERRUPT = 0 { name = "No Raw Interrupt"; desc = "No raw interrupt is generated."; };
            RAW_INTERRUPT_GENERATED = 1 { name = "Raw Interrupt Generated"; desc = "A raw interrupt is generated."; };
        };

        field {
            name = "err0_escape_d0_raw";
            desc = "Status of the raw escape sequence interrupt for data lane 0";
            sw = rw;
            hw = w;
            onwrite = woclr;
            encode = MIPI_CIL_INT_RAW_LINK0_err0_escape_d0_raw_enum;
            reset = 0x0;
        } err0_escape_d0_raw[0:0];
    } MIPI_CIL_INT_RAW_LINK0 @ 0x1F0;

    reg {
        name = "Link 0 MIPI CIL interrupt status register";
        desc = "MIPI_CIL_INT_LINK0 is a link 0 MIPI CIL interrupt status register.

Data sheet 9.3.6 MIPI_CIL_INT_LINK0 (offset 0x1F4, printed page 9-142, `hi3516cv300--Hi3516CV300-Hi3516EV100-Datasheet.txt` line 35520).";

        enum MIPI_CIL_INT_LINK0_err0_timeout_ck_st_enum {
            NO_INTERRUPT_GENERATED = 0 { name = "No Interrupt Generated"; desc = "No interrupt is generated."; };
            INTERRUPT_GENERATED = 1 { name = "Interrupt Generated"; desc = "An interrupt is generated."; };
        };

        field {
            name = "err0_timeout_ck_st";
            desc = "Status of the FSM timeout interrupt for the clock lane";
            sw = r;
            hw = w;
            encode = MIPI_CIL_INT_LINK0_err0_timeout_ck_st_enum;
            reset = 0x0;
        } err0_timeout_ck_st[12:12];

        enum MIPI_CIL_INT_LINK0_err0_timeout_d3_st_enum {
            NO_INTERRUPT_GENERATED = 0 { name = "No Interrupt Generated"; desc = "No interrupt is generated."; };
            INTERRUPT_GENERATED = 1 { name = "Interrupt Generated"; desc = "An interrupt is generated."; };
        };

        field {
            name = "err0_timeout_d3_st";
            desc = "Status of the FSM timeout interrupt for data lane 3";
            sw = r;
            hw = w;
            encode = MIPI_CIL_INT_LINK0_err0_timeout_d3_st_enum;
            reset = 0x0;
        } err0_timeout_d3_st[11:11];

        enum MIPI_CIL_INT_LINK0_err0_timeout_d2_st_enum {
            NO_INTERRUPT_GENERATED = 0 { name = "No Interrupt Generated"; desc = "No interrupt is generated."; };
            INTERRUPT_GENERATED = 1 { name = "Interrupt Generated"; desc = "An interrupt is generated."; };
        };

        field {
            name = "err0_timeout_d2_st";
            desc = "Status of the FSM timeout interrupt for data lane 2";
            sw = r;
            hw = w;
            encode = MIPI_CIL_INT_LINK0_err0_timeout_d2_st_enum;
            reset = 0x0;
        } err0_timeout_d2_st[10:10];

        enum MIPI_CIL_INT_LINK0_err0_timeout_d1_st_enum {
            NO_INTERRUPT_GENERATED = 0 { name = "No Interrupt Generated"; desc = "No interrupt is generated."; };
            INTERRUPT_GENERATED = 1 { name = "Interrupt Generated"; desc = "An interrupt is generated."; };
        };

        field {
            name = "err0_timeout_d1_st";
            desc = "Status of the FSM timeout interrupt for data lane 1";
            sw = r;
            hw = w;
            encode = MIPI_CIL_INT_LINK0_err0_timeout_d1_st_enum;
            reset = 0x0;
        } err0_timeout_d1_st[9:9];

        enum MIPI_CIL_INT_LINK0_err0_timeout_d0_st_enum {
            NO_INTERRUPT_GENERATED = 0 { name = "No Interrupt Generated"; desc = "No interrupt is generated."; };
            INTERRUPT_GENERATED = 1 { name = "Interrupt Generated"; desc = "An interrupt is generated."; };
        };

        field {
            name = "err0_timeout_d0_st";
            desc = "Status of the FSM timeout interrupt for data lane 0";
            sw = r;
            hw = w;
            encode = MIPI_CIL_INT_LINK0_err0_timeout_d0_st_enum;
            reset = 0x0;
        } err0_timeout_d0_st[8:8];

        enum MIPI_CIL_INT_LINK0_err0_escape_ck_st_enum {
            NO_INTERRUPT_GENERATED = 0 { name = "No Interrupt Generated"; desc = "No interrupt is generated."; };
            INTERRUPT_GENERATED = 1 { name = "Interrupt Generated"; desc = "An interrupt is generated."; };
        };

        field {
            name = "err0_escape_ck_st";
            desc = "Status of the escape sequence interrupt for the clock lane";
            sw = r;
            hw = w;
            encode = MIPI_CIL_INT_LINK0_err0_escape_ck_st_enum;
            reset = 0x0;
        } err0_escape_ck_st[4:4];

        enum MIPI_CIL_INT_LINK0_err0_escape_d3_st_enum {
            NO_INTERRUPT_GENERATED = 0 { name = "No Interrupt Generated"; desc = "No interrupt is generated."; };
            INTERRUPT_GENERATED = 1 { name = "Interrupt Generated"; desc = "An interrupt is generated."; };
        };

        field {
            name = "err0_escape_d3_st";
            desc = "Status of the escape sequence interrupt for data lane 3";
            sw = r;
            hw = w;
            encode = MIPI_CIL_INT_LINK0_err0_escape_d3_st_enum;
            reset = 0x0;
        } err0_escape_d3_st[3:3];

        enum MIPI_CIL_INT_LINK0_err0_escape_d2_st_enum {
            NO_INTERRUPT_GENERATED = 0 { name = "No Interrupt Generated"; desc = "No interrupt is generated."; };
            INTERRUPT_GENERATED = 1 { name = "Interrupt Generated"; desc = "An interrupt is generated."; };
        };

        field {
            name = "err0_escape_d2_st";
            desc = "Status of the escape sequence interrupt for data lane 2";
            sw = r;
            hw = w;
            encode = MIPI_CIL_INT_LINK0_err0_escape_d2_st_enum;
            reset = 0x0;
        } err0_escape_d2_st[2:2];

        enum MIPI_CIL_INT_LINK0_err0_escape_d1_st_enum {
            NO_INTERRUPT_GENERATED = 0 { name = "No Interrupt Generated"; desc = "No interrupt is generated."; };
            INTERRUPT_GENERATED = 1 { name = "Interrupt Generated"; desc = "An interrupt is generated."; };
        };

        field {
            name = "err0_escape_d1_st";
            desc = "Status of the escape sequence interrupt for data lane 1";
            sw = r;
            hw = w;
            encode = MIPI_CIL_INT_LINK0_err0_escape_d1_st_enum;
            reset = 0x0;
        } err0_escape_d1_st[1:1];

        enum MIPI_CIL_INT_LINK0_err0_escape_d0_st_enum {
            NO_INTERRUPT_GENERATED = 0 { name = "No Interrupt Generated"; desc = "No interrupt is generated."; };
            INTERRUPT_GENERATED = 1 { name = "Interrupt Generated"; desc = "An interrupt is generated."; };
        };

        field {
            name = "err0_escape_d0_st";
            desc = "Status of the escape sequence interrupt for data lane 0";
            sw = r;
            hw = w;
            encode = MIPI_CIL_INT_LINK0_err0_escape_d0_st_enum;
            reset = 0x0;
        } err0_escape_d0_st[0:0];
    } MIPI_CIL_INT_LINK0 @ 0x1F4;

    reg {
        name = "Link 0 MIPI CIL interrupt mask NK0 register";
        desc = "MIPI_CIL_INT_MSK_LINK0 is a link 0 MIPI CIL interrupt mask register.

Data sheet 9.3.6 MIPI_CIL_INT_MSK_LINK0 (offset 0x1F8, printed page 9-143, `hi3516cv300--Hi3516CV300-Hi3516EV100-Datasheet.txt` line 35587).";

        enum MIPI_CIL_INT_MSK_LINK0_err0_timeout_ck_msk_enum {
            MASKED = 0 { name = "Masked"; desc = "masked"; };
            ENABLED = 1 { name = "Enabled"; desc = "enabled"; };
        };

        field {
            name = "err0_timeout_ck_msk";
            desc = "Enable of the FSM timeout interrupt for the clock lane";
            sw = rw;
            hw = r;
            encode = MIPI_CIL_INT_MSK_LINK0_err0_timeout_ck_msk_enum;
            reset = 0x0;
        } err0_timeout_ck_msk[12:12];

        enum MIPI_CIL_INT_MSK_LINK0_err0_timeout_d3_msk_enum {
            MASKED = 0 { name = "Masked"; desc = "masked"; };
            ENABLED = 1 { name = "Enabled"; desc = "enabled"; };
        };

        field {
            name = "err0_timeout_d3_msk";
            desc = "Enable of the FSM timeout interrupt for data lane 3";
            sw = rw;
            hw = r;
            encode = MIPI_CIL_INT_MSK_LINK0_err0_timeout_d3_msk_enum;
            reset = 0x0;
        } err0_timeout_d3_msk[11:11];

        enum MIPI_CIL_INT_MSK_LINK0_err0_timeout_d2_msk_enum {
            MASKED = 0 { name = "Masked"; desc = "masked"; };
            ENABLED = 1 { name = "Enabled"; desc = "enabled"; };
        };

        field {
            name = "err0_timeout_d2_msk";
            desc = "Enable of the FSM timeout interrupt for data lane 2";
            sw = rw;
            hw = r;
            encode = MIPI_CIL_INT_MSK_LINK0_err0_timeout_d2_msk_enum;
            reset = 0x0;
        } err0_timeout_d2_msk[10:10];

        enum MIPI_CIL_INT_MSK_LINK0_err0_timeout_d1_msk_enum {
            MASKED = 0 { name = "Masked"; desc = "masked"; };
            ENABLED = 1 { name = "Enabled"; desc = "enabled"; };
        };

        field {
            name = "err0_timeout_d1_msk";
            desc = "Enable of the FSM timeout interrupt for data lane 1";
            sw = rw;
            hw = r;
            encode = MIPI_CIL_INT_MSK_LINK0_err0_timeout_d1_msk_enum;
            reset = 0x0;
        } err0_timeout_d1_msk[9:9];

        enum MIPI_CIL_INT_MSK_LINK0_err0_timeout_d0_msk_enum {
            MASKED = 0 { name = "Masked"; desc = "masked"; };
            ENABLED = 1 { name = "Enabled"; desc = "enabled"; };
        };

        field {
            name = "err0_timeout_d0_msk";
            desc = "Enable of the FSM timeout interrupt for data lane 0";
            sw = rw;
            hw = r;
            encode = MIPI_CIL_INT_MSK_LINK0_err0_timeout_d0_msk_enum;
            reset = 0x0;
        } err0_timeout_d0_msk[8:8];

        enum MIPI_CIL_INT_MSK_LINK0_err0_escape_ck_msk_enum {
            MASKED = 0 { name = "Masked"; desc = "masked"; };
            ENABLED = 1 { name = "Enabled"; desc = "enabled"; };
        };

        field {
            name = "err0_escape_ck_msk";
            desc = "Enable of the escape sequence interrupt for the clock lane";
            sw = rw;
            hw = r;
            encode = MIPI_CIL_INT_MSK_LINK0_err0_escape_ck_msk_enum;
            reset = 0x0;
        } err0_escape_ck_msk[4:4];

        enum MIPI_CIL_INT_MSK_LINK0_err0_escape_d3_msk_enum {
            MASKED = 0 { name = "Masked"; desc = "masked"; };
            ENABLED = 1 { name = "Enabled"; desc = "enabled"; };
        };

        field {
            name = "err0_escape_d3_msk";
            desc = "Enable of the escape sequence interrupt for data lane 3";
            sw = rw;
            hw = r;
            encode = MIPI_CIL_INT_MSK_LINK0_err0_escape_d3_msk_enum;
            reset = 0x0;
        } err0_escape_d3_msk[3:3];

        enum MIPI_CIL_INT_MSK_LINK0_err0_escape_d2_msk_enum {
            MASKED = 0 { name = "Masked"; desc = "masked"; };
            ENABLED = 1 { name = "Enabled"; desc = "enabled"; };
        };

        field {
            name = "err0_escape_d2_msk";
            desc = "Enable of the escape sequence interrupt for data lane 2";
            sw = rw;
            hw = r;
            encode = MIPI_CIL_INT_MSK_LINK0_err0_escape_d2_msk_enum;
            reset = 0x0;
        } err0_escape_d2_msk[2:2];

        enum MIPI_CIL_INT_MSK_LINK0_err0_escape_d1_msk_enum {
            MASKED = 0 { name = "Masked"; desc = "masked"; };
            ENABLED = 1 { name = "Enabled"; desc = "enabled"; };
        };

        field {
            name = "err0_escape_d1_msk";
            desc = "Enable of the escape sequence interrupt for data lane 1";
            sw = rw;
            hw = r;
            encode = MIPI_CIL_INT_MSK_LINK0_err0_escape_d1_msk_enum;
            reset = 0x0;
        } err0_escape_d1_msk[1:1];

        enum MIPI_CIL_INT_MSK_LINK0_err0_escape_d0_msk_enum {
            MASKED = 0 { name = "Masked"; desc = "masked"; };
            ENABLED = 1 { name = "Enabled"; desc = "enabled"; };
        };

        field {
            name = "err0_escape_d0_msk";
            desc = "Enable of the escape sequence interrupt for data lane 0";
            sw = rw;
            hw = r;
            encode = MIPI_CIL_INT_MSK_LINK0_err0_escape_d0_msk_enum;
            reset = 0x0;
        } err0_escape_d0_msk[0:0];
    } MIPI_CIL_INT_MSK_LINK0 @ 0x1F8;

    reg {
        name = "CHN0 PHY enable register";
        desc = "CHN0_PHY_EN is a CHN0 PHY enable register. Hi3516C V300/Hi3516E V100 Professional HD IP Camera SoC

Data sheet 9.3.6 CHN0_PHY_EN (offset 0x800, printed page 9-145, `hi3516cv300--Hi3516CV300-Hi3516EV100-Datasheet.txt` line 35685).";

        enum CHN0_PHY_EN_phy0_en_enum {
            DISABLED = 0 { name = "Disabled"; desc = "disabled"; };
            ENABLED = 1 { name = "Enabled"; desc = "enabled"; };
        };

        field {
            name = "phy0_en";
            desc = "PHY 0 enable";
            sw = rw;
            hw = r;
            encode = CHN0_PHY_EN_phy0_en_enum;
            reset = 0x0;
        } phy0_en[0:0];
    } CHN0_PHY_EN @ 0x800;

    reg {
        name = "CHN0 Memory control register";
        desc = "CHN0_MEM_CTRL is a CHN0 memory control register.

Data sheet 9.3.6 CHN0_MEM_CTRL (offset 0x808, printed page 9-145, `hi3516cv300--Hi3516CV300-Hi3516EV100-Datasheet.txt` line 35710).";

        enum CHN0_MEM_CTRL_mem_ck_gt_enum {
            DISABLED = 0 { name = "Disabled"; desc = "disabled"; };
            ENABLED_MEMORY_PORT = 1 { name = "Enabled Memory Port"; desc = "enabled. The memory port clock is not inverted when the memory is not read or written."; };
        };

        field {
            name = "mem_ck_gt";
            desc = "CHN0 memory clock gating enable";
            sw = rw;
            hw = r;
            encode = CHN0_MEM_CTRL_mem_ck_gt_enum;
            reset = 0x0;
        } mem_ck_gt[12:12];
    } CHN0_MEM_CTRL @ 0x808;

    reg {
        name = "CHN0 Lane enable register";
        desc = "CHN0_LANE_EN is a CHN0 lane enable register. Hi3516C V300/Hi3516E V100 Professional HD IP Camera SoC

Data sheet 9.3.6 CHN0_LANE_EN (offset 0x80C, printed page 9-146, `hi3516cv300--Hi3516CV300-Hi3516EV100-Datasheet.txt` line 35750).";

        enum CHN0_LANE_EN_lane3_en_enum {
            DISABLED = 0 { name = "Disabled"; desc = "disabled"; };
            ENABLED = 1 { name = "Enabled"; desc = "enabled"; };
        };

        field {
            name = "lane3_en";
            desc = "Lane 3 enable";
            sw = rw;
            hw = r;
            encode = CHN0_LANE_EN_lane3_en_enum;
            reset = 0x0;
        } lane3_en[3:3];

        enum CHN0_LANE_EN_lane2_en_enum {
            DISABLED = 0 { name = "Disabled"; desc = "disabled"; };
            ENABLED = 1 { name = "Enabled"; desc = "enabled"; };
        };

        field {
            name = "lane2_en";
            desc = "Lane 2 enable";
            sw = rw;
            hw = r;
            encode = CHN0_LANE_EN_lane2_en_enum;
            reset = 0x0;
        } lane2_en[2:2];

        enum CHN0_LANE_EN_lane1_en_enum {
            DISABLED = 0 { name = "Disabled"; desc = "disabled"; };
            ENABLED = 1 { name = "Enabled"; desc = "enabled"; };
        };

        field {
            name = "lane1_en";
            desc = "Lane 1 enable";
            sw = rw;
            hw = r;
            encode = CHN0_LANE_EN_lane1_en_enum;
            reset = 0x0;
        } lane1_en[1:1];

        enum CHN0_LANE_EN_lane0_en_enum {
            DISABLED = 0 { name = "Disabled"; desc = "disabled"; };
            ENABLED = 1 { name = "Enabled"; desc = "enabled"; };
        };

        field {
            name = "lane0_en";
            desc = "Lane 0 enable";
            sw = rw;
            hw = r;
            encode = CHN0_LANE_EN_lane0_en_enum;
            reset = 0x0;
        } lane0_en[0:0];
    } CHN0_LANE_EN @ 0x80C;

    reg {
        name = "CHN0 PHY configuration mode register";
        desc = "CHN0_PHYCFG_MODE is a CHN0 PHY configuration mode register.

Data sheet 9.3.6 CHN0_PHYCFG_MODE (offset 0x810, printed page 9-146, `hi3516cv300--Hi3516CV300-Hi3516EV100-Datasheet.txt` line 35787).";

        enum CHN0_PHYCFG_MODE_chn0_phycfg_mode_enum {
            PHY_CONFIGURATION_CONTROLLED = 0 { name = "Phy Configuration Controlled"; desc = "The PHY configuration is controlled by PHYCFG_EN and FSM."; };
            PHY_CONFIGURATION_CONTROLLED_2 = 1 { name = "Phy Configuration Controlled 2"; desc = "The PHY configuration is controlled by PHYCFG_EN."; };
            PHY_CONFIGURATION_DIRECTLY = 2 { name = "Phy Configuration Directly"; desc = "The PHY configuration is directly controlled by the value of MIPI_PHYCFG_MODE."; };
            PHY_CONFIGURATION_CONTROLLED_3 = 3 { name = "Phy Configuration Controlled 3"; desc = "The PHY configuration is controlled by the value of MIPI_PHYCFG_MODE and FSM."; };
            PHY_CONFIGURATION_CONTROLLED_4 = 4 { name = "Phy Configuration Controlled 4"; desc = "The PHY configuration is controlled by PHYCFG_EN and FSM, and the clock channel enable is controlled by PHYCFG_EN. Other values: reserved"; };
        };

        field {
            name = "chn0_phycfg_mode";
            desc = "CHN0 PHY configuration mode";
            sw = rw;
            hw = r;
            encode = CHN0_PHYCFG_MODE_chn0_phycfg_mode_enum;
            reset = 0x0;
        } chn0_phycfg_mode[2:0];
    } CHN0_PHYCFG_MODE @ 0x810;

    reg {
        name = "CHN0 PHY configuration enable register";
        desc = "CHN0_PHYCFG_EN is a CHN0 PHY configuration enable register.

Data sheet 9.3.6 CHN0_PHYCFG_EN (offset 0x814, printed page 9-147, `hi3516cv300--Hi3516CV300-Hi3516EV100-Datasheet.txt` line 35832).";

        enum CHN0_PHYCFG_EN_chn0_phycfg_en_enum {
            DISABLED = 0 { name = "Disabled"; desc = "disabled"; };
            ENABLED = 1 { name = "Enabled"; desc = "enabled"; };
        };

        field {
            name = "chn0_phycfg_en";
            desc = "CHN0 PHY configuration enable";
            sw = w;
            hw = r;
            encode = CHN0_PHYCFG_EN_chn0_phycfg_en_enum;
            reset = 0x0;
        } chn0_phycfg_en[0:0];
    } CHN0_PHYCFG_EN @ 0x814;

    reg {
        name = "CHN0 forced setting enable register";
        desc = "CHN0_CLR_EN is CHN0 forced setting enable register. Hi3516C V300/Hi3516E V100 Professional HD IP Camera SoC

Data sheet 9.3.6 CHN0_CLR_EN (offset 0x818, printed page 9-148, `hi3516cv300--Hi3516CV300-Hi3516EV100-Datasheet.txt` line 35870).";

        enum CHN0_CLR_EN_clr_en_align0_enum {
            DISABLE_SETTING_1 = 0 { name = "Disable Setting 1"; desc = "disable the setting to 1 request of ALIGN0"; };
            ENABLE_SETTING_1 = 1 { name = "Enable Setting 1"; desc = "enable the setting to 1 request of ALIGN0"; };
        };

        field {
            name = "clr_en_align0";
            desc = "Forced setting control of the LVDS0 PRE SYNC module";
            sw = rw;
            hw = r;
            encode = CHN0_CLR_EN_clr_en_align0_enum;
            reset = 0x0;
        } clr_en_align0[1:1];

        enum CHN0_CLR_EN_clr_en_lvds0_enum {
            DISABLE_SETTING_1 = 0 { name = "Disable Setting 1"; desc = "disable the setting to 1 request of LVDS0 CTRL"; };
            ENABLE_SETTING_1 = 1 { name = "Enable Setting 1"; desc = "enable the setting to 1 request of LVDS0 CTRL"; };
        };

        field {
            name = "clr_en_lvds0";
            desc = "Forced setting control of the LVDS0 PRE SYNC module";
            sw = rw;
            hw = r;
            encode = CHN0_CLR_EN_clr_en_lvds0_enum;
            reset = 0x0;
        } clr_en_lvds0[0:0];
    } CHN0_CLR_EN @ 0x818;

    reg {
        name = "CHN0 CIL control register";
        desc = "MIPI_CHN0_INT_RAW is CHN0 CIL control register.

Data sheet 9.3.6 CHN0_CIL_CTRL (offset 0x81C, printed page 9-148, `hi3516cv300--Hi3516CV300-Hi3516EV100-Datasheet.txt` line 35902).";

        enum CHN0_CIL_CTRL_phycil0_cken_enum {
            DISABLED = 0 { name = "Disabled"; desc = "disabled"; };
            ENABLED = 1 { name = "Enabled"; desc = "enabled"; };
        };

        field {
            name = "phycil0_cken";
            desc = "PHYCIL0 clock gating";
            sw = rw;
            hw = r;
            encode = CHN0_CIL_CTRL_phycil0_cken_enum;
            reset = 0x0;
        } phycil0_cken[0:0];
    } CHN0_CIL_CTRL @ 0x81C;

    reg {
        name = "MIPI channel 0 raw interrupt status register";
        desc = "MIPI_CHN0_INT_RAW is an MIPI channel 0 raw interrupt status register.

Data sheet 9.3.6 MIPI_CHN0_INT_RAW (offset 0xEF0, printed page 9-149, `hi3516cv300--Hi3516CV300-Hi3516EV100-Datasheet.txt` line 35935).";

        enum MIPI_CHN0_INT_RAW_int_data_align_raw_enum {
            THERE_NO_RAW = 0 { name = "There No Raw"; desc = "There is no raw interrupt."; };
            THERE_RAW_INTERRUPT = 1 { name = "There Raw Interrupt"; desc = "There is a raw interrupt."; };
        };

        field {
            name = "int_data_align_raw";
            desc = "MIPI ALIGN raw interrupt status";
            sw = rw;
            hw = w;
            onwrite = woclr;
            encode = MIPI_CHN0_INT_RAW_int_data_align_raw_enum;
            reset = 0x0;
        } int_data_align_raw[4:4];

        enum MIPI_CHN0_INT_RAW_int_mipi_ctrl_raw_enum {
            THERE_NO_RAW = 0 { name = "There No Raw"; desc = "There is no raw interrupt."; };
            THERE_RAW_INTERRUPT = 1 { name = "There Raw Interrupt"; desc = "There is a raw interrupt."; };
        };

        field {
            name = "int_mipi_ctrl_raw";
            desc = "MIPI CTRL raw interrupt status";
            sw = rw;
            hw = w;
            onwrite = woclr;
            encode = MIPI_CHN0_INT_RAW_int_mipi_ctrl_raw_enum;
            reset = 0x0;
        } int_mipi_ctrl_raw[3:3];

        enum MIPI_CHN0_INT_RAW_int_mipi_csi_raw_enum {
            THERE_NO_RAW = 0 { name = "There No Raw"; desc = "There is no raw interrupt."; };
            THERE_RAW_INTERRUPT = 1 { name = "There Raw Interrupt"; desc = "There is a raw interrupt."; };
        };

        field {
            name = "int_mipi_csi_raw";
            desc = "MIPI CSI2 raw interrupt status";
            sw = rw;
            hw = w;
            onwrite = woclr;
            encode = MIPI_CHN0_INT_RAW_int_mipi_csi_raw_enum;
            reset = 0x0;
        } int_mipi_csi_raw[2:2];

        enum MIPI_CHN0_INT_RAW_int_lvds_ctrl_raw_enum {
            THERE_NO_RAW = 0 { name = "There No Raw"; desc = "There is no raw interrupt."; };
            THERE_RAW_INTERRUPT = 1 { name = "There Raw Interrupt"; desc = "There is a raw interrupt."; };
        };

        field {
            name = "int_lvds_ctrl_raw";
            desc = "LVDS CTRL raw interrupt status";
            sw = rw;
            hw = w;
            onwrite = woclr;
            encode = MIPI_CHN0_INT_RAW_int_lvds_ctrl_raw_enum;
            reset = 0x0;
        } int_lvds_ctrl_raw[1:1];

        enum MIPI_CHN0_INT_RAW_int_phycil0_raw_enum {
            THERE_NO_RAW = 0 { name = "There No Raw"; desc = "There is no raw interrupt."; };
            THERE_RAW_INTERRUPT = 1 { name = "There Raw Interrupt"; desc = "There is a raw interrupt."; };
        };

        field {
            name = "int_phycil0_raw";
            desc = "PHYCIL0 raw interrupt status";
            sw = rw;
            hw = w;
            onwrite = woclr;
            encode = MIPI_CHN0_INT_RAW_int_phycil0_raw_enum;
            reset = 0x0;
        } int_phycil0_raw[0:0];
    } MIPI_CHN0_INT_RAW @ 0xEF0;

    reg {
        name = "MIPI channel 0 interrupt status register";
        desc = "MIPI_CHN0_INT is an MIPI channel 0 interrupt status register. Hi3516C V300/Hi3516E V100 Professional HD IP Camera SoC

Data sheet 9.3.6 MIPI_CHN0_INT (offset 0xEF4, printed page 9-150, `hi3516cv300--Hi3516CV300-Hi3516EV100-Datasheet.txt` line 35988).";

        enum MIPI_CHN0_INT_int_data_align_st_enum {
            NO_INTERRUPT_GENERATED = 0 { name = "No Interrupt Generated"; desc = "No interrupt is generated."; };
            INTERRUPT_GENERATED = 1 { name = "Interrupt Generated"; desc = "An interrupt is generated."; };
        };

        field {
            name = "int_data_align_st";
            desc = "MIPI ALIGN interrupt status";
            sw = r;
            hw = w;
            encode = MIPI_CHN0_INT_int_data_align_st_enum;
            reset = 0x0;
        } int_data_align_st[4:4];

        enum MIPI_CHN0_INT_int_mipi_ctrl_st_enum {
            NO_INTERRUPT_GENERATED = 0 { name = "No Interrupt Generated"; desc = "No interrupt is generated."; };
            INTERRUPT_GENERATED = 1 { name = "Interrupt Generated"; desc = "An interrupt is generated."; };
        };

        field {
            name = "int_mipi_ctrl_st";
            desc = "MIPI CTRL interrupt status";
            sw = r;
            hw = w;
            encode = MIPI_CHN0_INT_int_mipi_ctrl_st_enum;
            reset = 0x0;
        } int_mipi_ctrl_st[3:3];

        enum MIPI_CHN0_INT_int_mipi_csi_st_enum {
            NO_INTERRUPT_GENERATED = 0 { name = "No Interrupt Generated"; desc = "No interrupt is generated."; };
            INTERRUPT_GENERATED = 1 { name = "Interrupt Generated"; desc = "An interrupt is generated."; };
        };

        field {
            name = "int_mipi_csi_st";
            desc = "MIPI CSI2 interrupt status";
            sw = r;
            hw = w;
            encode = MIPI_CHN0_INT_int_mipi_csi_st_enum;
            reset = 0x0;
        } int_mipi_csi_st[2:2];

        enum MIPI_CHN0_INT_int_lvds_ctrl_st_enum {
            NO_INTERRUPT_GENERATED = 0 { name = "No Interrupt Generated"; desc = "No interrupt is generated."; };
            INTERRUPT_GENERATED = 1 { name = "Interrupt Generated"; desc = "An interrupt is generated."; };
        };

        field {
            name = "int_lvds_ctrl_st";
            desc = "LVDS CTRL interrupt status";
            sw = r;
            hw = w;
            encode = MIPI_CHN0_INT_int_lvds_ctrl_st_enum;
            reset = 0x0;
        } int_lvds_ctrl_st[1:1];

        enum MIPI_CHN0_INT_int_phycil0_st_enum {
            NO_INTERRUPT_GENERATED = 0 { name = "No Interrupt Generated"; desc = "No interrupt is generated."; };
            INTERRUPT_GENERATED = 1 { name = "Interrupt Generated"; desc = "An interrupt is generated."; };
        };

        field {
            name = "int_phycil0_st";
            desc = "PHYCIL0 interrupt status";
            sw = r;
            hw = w;
            encode = MIPI_CHN0_INT_int_phycil0_st_enum;
            reset = 0x0;
        } int_phycil0_st[0:0];
    } MIPI_CHN0_INT @ 0xEF4;

    reg {
        name = "MIPI channel 0 interrupt mask register";
        desc = "MIPI_CHN0_INT_MSK is an MIPI channel 0 interrupt mask register. Hi3516C V300/Hi3516E V100 Professional HD IP Camera SoC

Data sheet 9.3.6 MIPI_CHN0_INT_MSK (offset 0xEF8, printed page 9-151, `hi3516cv300--Hi3516CV300-Hi3516EV100-Datasheet.txt` line 36038).";

        enum MIPI_CHN0_INT_MSK_int_data_align_msk_enum {
            MASKED = 0 { name = "Masked"; desc = "masked"; };
            ENABLED = 1 { name = "Enabled"; desc = "enabled"; };
        };

        field {
            name = "int_data_align_msk";
            desc = "MIPI ALIGN interrupt enable";
            sw = rw;
            hw = r;
            encode = MIPI_CHN0_INT_MSK_int_data_align_msk_enum;
            reset = 0x0;
        } int_data_align_msk[4:4];

        enum MIPI_CHN0_INT_MSK_int_mipi_ctrl_msk_enum {
            MASKED = 0 { name = "Masked"; desc = "masked"; };
            ENABLED = 1 { name = "Enabled"; desc = "enabled"; };
        };

        field {
            name = "int_mipi_ctrl_msk";
            desc = "MIPI CTRL interrupt enable";
            sw = rw;
            hw = r;
            encode = MIPI_CHN0_INT_MSK_int_mipi_ctrl_msk_enum;
            reset = 0x0;
        } int_mipi_ctrl_msk[3:3];

        enum MIPI_CHN0_INT_MSK_int_mipi_csi_msk_enum {
            MASKED = 0 { name = "Masked"; desc = "masked"; };
            ENABLED = 1 { name = "Enabled"; desc = "enabled"; };
        };

        field {
            name = "int_mipi_csi_msk";
            desc = "MIPI CSI2 interrupt enable";
            sw = rw;
            hw = r;
            encode = MIPI_CHN0_INT_MSK_int_mipi_csi_msk_enum;
            reset = 0x0;
        } int_mipi_csi_msk[2:2];

        enum MIPI_CHN0_INT_MSK_int_lvds_ctrl_msk_enum {
            MASKED = 0 { name = "Masked"; desc = "masked"; };
            ENABLED = 1 { name = "Enabled"; desc = "enabled"; };
        };

        field {
            name = "int_lvds_ctrl_msk";
            desc = "LVDS CTRL interrupt enable";
            sw = rw;
            hw = r;
            encode = MIPI_CHN0_INT_MSK_int_lvds_ctrl_msk_enum;
            reset = 0x0;
        } int_lvds_ctrl_msk[1:1];

        enum MIPI_CHN0_INT_MSK_int_phycil0_msk_enum {
            MASKED = 0 { name = "Masked"; desc = "masked"; };
            ENABLED = 1 { name = "Enabled"; desc = "enabled"; };
        };

        field {
            name = "int_phycil0_msk";
            desc = "PHYCIL0 interrupt enable";
            sw = rw;
            hw = r;
            encode = MIPI_CHN0_INT_MSK_int_phycil0_msk_enum;
            reset = 0x0;
        } int_phycil0_msk[0:0];
    } MIPI_CHN0_INT_MSK @ 0xEF8;

    reg {
        name = "MIPI 0 enabled data channel quantity register";
        desc = "MIPI0_LANES_NUM is an MIPI 0 enabled data channel quantity register. Hi3516C V300/Hi3516E V100 Professional HD IP Camera SoC

Data sheet 9.3.6 MIPI0_LANES_NUM (offset 0x1004, printed page 9-152, `hi3516cv300--Hi3516CV300-Hi3516EV100-Datasheet.txt` line 36088).";

        enum MIPI0_LANES_NUM_lane_num_enum {
            V_1 = 0 { name = "V 1"; desc = "1"; };
            V_2 = 1 { name = "V 2"; desc = "2"; };
            V_3 = 2 { name = "V 3"; desc = "3"; };
            V_4 = 3 { name = "V 4"; desc = "4"; };
            V_5 = 4 { name = "V 5"; desc = "5"; };
            V_6 = 5 { name = "V 6"; desc = "6"; };
            V_7 = 6 { name = "V 7"; desc = "7"; };
            V_8 = 7 { name = "V 8"; desc = "8"; };
        };

        field {
            name = "lane_num";
            desc = "Number of enabled data channels";
            sw = rw;
            hw = r;
            encode = MIPI0_LANES_NUM_lane_num_enum;
            reset = 0x3;
        } lane_num[2:0];
    } MIPI0_LANES_NUM @ 0x1004;

    reg {
        name = "MIPI 0 global interrupt status register";
        desc = "MIPI0_MAIN_INT_ST is an MIPI 0 global interrupt status register.

Data sheet 9.3.6 MIPI0_MAIN_INT_ST (offset 0x100C, printed page 9-152, `hi3516cv300--Hi3516CV300-Hi3516EV100-Datasheet.txt` line 36122).";

        field {
            name = "status_int_line";
            desc = "Line interrupt status. This bit is set to 1 when any of the bits in the MIPI0_LINE_INTR_ST register is set to 1. This bit is cleared when it is read. To clear the reported interrupt, clear this bit and MIPI0_LINE_INTR_ST.";
            sw = r;
            hw = w;
            reset = 0x0;
        } status_int_line[18:18];

        field {
            name = "status_int_pkt";
            desc = "Packet interrupt status. This bit is set to 1 when any of the bits in the MIPI0_PKT_INTR2_ST register is set to 1. This bit is cleared when it is read. To clear the reported interrupt, clear this bit and MIPI0_PKT_INTR2_ST.";
            sw = r;
            hw = w;
            reset = 0x0;
        } status_int_pkt[17:17];

        field {
            name = "status_int_frame_fatal";
            desc = "Frame interrupt status. This bit is set to 1 when any of the bits in the MIPI0_FRAME_INTR_ST register is set to 1. This bit is cleared when it is read. To clear the reported interrupt, clear this bit and MIPI0_FRAME_INTR_ST.";
            sw = r;
            hw = w;
            reset = 0x0;
        } status_int_frame_fatal[2:2];

        field {
            name = "status_int_pkt_fatal";
            desc = "Packet interrupt status. This bit is set to 1 when any of the bits in the MIPI0_PKT_INTR_ST register is set to 1. This bit is cleared when it is read. To clear the reported interrupt, clear this bit and MIPI0_PKT_INTR_ST.";
            sw = r;
            hw = w;
            reset = 0x0;
        } status_int_pkt_fatal[1:1];
    } MIPI0_MAIN_INT_ST @ 0x100C;

    reg {
        name = "MIPI 0 controller data ID 1 register";
        desc = "MIPI0_DI_1 is an MIPI 0 controller data ID 1 register.

Data sheet 9.3.6 MIPI0_DI_1 (offset 0x1010, printed page 9-153, `hi3516cv300--Hi3516CV300-Hi3516EV100-Datasheet.txt` line 36180).";

        field {
            name = "di3_vc";
            desc = "Virtual channel ID of data with the ID 3 Error check is performed only when the configured data ID matches the ID of received data.";
            sw = rw;
            hw = r;
            reset = 0x0;
        } di3_vc[31:30];

        enum MIPI0_DI_1_di3_dt_enum {
            RAW8 = 0x2A { name = "Raw8"; desc = "raw8"; };
            RAW10 = 0x2B { name = "Raw10"; desc = "raw10"; };
            RAW12 = 0x2C { name = "Raw12"; desc = "raw12"; };
            RAW14 = 0x2D { name = "Raw14"; desc = "raw14"; };
            RAW16_OTHER_VALUES = 0x2E { name = "Raw16 Other Values"; desc = "RAW16 Other values: reserved"; };
        };

        field {
            name = "di3_dt";
            desc = "Type of data with the ID 3 Error check is performed only when the configured data ID matches the ID of received data.";
            sw = rw;
            hw = r;
            encode = MIPI0_DI_1_di3_dt_enum;
            reset = 0x0;
        } di3_dt[29:24];

        field {
            name = "di2_vc";
            desc = "Virtual channel ID of data with the ID 2 Error check is performed only when the configured data ID matches the ID of received data.";
            sw = rw;
            hw = r;
            reset = 0x0;
        } di2_vc[23:22];

        enum MIPI0_DI_1_di2_dt_enum {
            RAW8 = 0x2A { name = "Raw8"; desc = "raw8"; };
            RAW10 = 0x2B { name = "Raw10"; desc = "raw10"; };
            RAW12 = 0x2C { name = "Raw12"; desc = "raw12"; };
            RAW14 = 0x2D { name = "Raw14"; desc = "raw14"; };
            RAW16_OTHER_VALUES = 0x2E { name = "Raw16 Other Values"; desc = "RAW16 Other values: reserved"; };
        };

        field {
            name = "di2_dt";
            desc = "Type of data with the ID 2 Error check is performed only when the configured data ID matches the ID of received data.";
            sw = rw;
            hw = r;
            encode = MIPI0_DI_1_di2_dt_enum;
            reset = 0x0;
        } di2_dt[21:16];

        field {
            name = "di1_vc";
            desc = "Virtual channel ID of data with the ID 1 Error check is performed only when the configured data ID matches the ID of received data.";
            sw = rw;
            hw = r;
            reset = 0x0;
        } di1_vc[15:14];

        enum MIPI0_DI_1_di1_dt_enum {
            RAW8 = 0x2A { name = "Raw8"; desc = "raw8"; };
            RAW10 = 0x2B { name = "Raw10"; desc = "raw10"; };
            RAW12 = 0x2C { name = "Raw12"; desc = "raw12"; };
            RAW14 = 0x2D { name = "Raw14"; desc = "raw14"; };
            RAW16_OTHER_VALUES = 0x2E { name = "Raw16 Other Values"; desc = "RAW16 Other values: reserved"; };
        };

        field {
            name = "di1_dt";
            desc = "Type of data with the ID 1 Error check is performed only when the configured data ID matches the ID of received data.";
            sw = rw;
            hw = r;
            encode = MIPI0_DI_1_di1_dt_enum;
            reset = 0x0;
        } di1_dt[13:8];

        field {
            name = "di0_vc";
            desc = "Virtual channel ID of data with the ID 0 Error check is performed only when the configured data ID matches the ID of received data.";
            sw = rw;
            hw = r;
            reset = 0x0;
        } di0_vc[7:6];

        enum MIPI0_DI_1_di0_dt_enum {
            RAW8 = 0x2A { name = "Raw8"; desc = "raw8"; };
            RAW10 = 0x2B { name = "Raw10"; desc = "raw10"; };
            RAW12 = 0x2C { name = "Raw12"; desc = "raw12"; };
            RAW14 = 0x2D { name = "Raw14"; desc = "raw14"; };
            RAW16_OTHER_VALUES = 0x2E { name = "Raw16 Other Values"; desc = "RAW16 Other values: reserved"; };
        };

        field {
            name = "di0_dt";
            desc = "Type of data with the ID 0 Error check is performed only when the configured data ID matches the ID of received data.";
            sw = rw;
            hw = r;
            encode = MIPI0_DI_1_di0_dt_enum;
            reset = 0x0;
        } di0_dt[5:0];
    } MIPI0_DI_1 @ 0x1010;

    reg {
        name = "MIPI 0 controller data ID 2 register";
        desc = "MIPI0_DI_2 is an MIPI 0 controller data ID 2 register.

Data sheet 9.3.6 MIPI0_DI_2 (offset 0x1014, printed page 9-155, `hi3516cv300--Hi3516CV300-Hi3516EV100-Datasheet.txt` line 36269).";

        field {
            name = "di7_vc";
            desc = "Virtual channel ID of data with the ID 7 Error check is performed only when the configured data ID matches the ID of received data.";
            sw = rw;
            hw = r;
            reset = 0x0;
        } di7_vc[31:30];

        enum MIPI0_DI_2_di7_dt_enum {
            RAW8 = 0x2A { name = "Raw8"; desc = "raw8"; };
            RAW10 = 0x2B { name = "Raw10"; desc = "raw10"; };
            RAW12 = 0x2C { name = "Raw12"; desc = "raw12"; };
            RAW14 = 0x2D { name = "Raw14"; desc = "raw14"; };
            RAW16_OTHER_VALUES = 0x2E { name = "Raw16 Other Values"; desc = "RAW16 Other values: reserved"; };
        };

        field {
            name = "di7_dt";
            desc = "Type of data with the ID 7 Error check is performed only when the configured data ID matches the ID of received data.";
            sw = rw;
            hw = r;
            encode = MIPI0_DI_2_di7_dt_enum;
            reset = 0x0;
        } di7_dt[29:24];

        field {
            name = "di6_vc";
            desc = "Virtual channel ID of data with the ID 6 Error check is performed only when the configured data ID matches the ID of received data.";
            sw = rw;
            hw = r;
            reset = 0x0;
        } di6_vc[23:22];

        enum MIPI0_DI_2_di6_dt_enum {
            RAW8 = 0x2A { name = "Raw8"; desc = "raw8"; };
            RAW10 = 0x2B { name = "Raw10"; desc = "raw10"; };
            RAW12 = 0x2C { name = "Raw12"; desc = "raw12"; };
            RAW14 = 0x2D { name = "Raw14"; desc = "raw14"; };
            RAW16_OTHER_VALUES = 0x2E { name = "Raw16 Other Values"; desc = "RAW16 Other values: reserved"; };
        };

        field {
            name = "di6_dt";
            desc = "Type of data with the ID 6 Error check is performed only when the configured data ID matches the ID of received data.";
            sw = rw;
            hw = r;
            encode = MIPI0_DI_2_di6_dt_enum;
            reset = 0x0;
        } di6_dt[21:16];

        field {
            name = "di5_vc";
            desc = "Virtual channel ID of data with the ID 5 Error check is performed only when the configured data ID matches the ID of received data.";
            sw = rw;
            hw = r;
            reset = 0x0;
        } di5_vc[15:14];

        enum MIPI0_DI_2_di5_dt_enum {
            RAW8 = 0x2A { name = "Raw8"; desc = "raw8"; };
            RAW10 = 0x2B { name = "Raw10"; desc = "raw10"; };
            RAW12 = 0x2C { name = "Raw12"; desc = "raw12"; };
            RAW14 = 0x2D { name = "Raw14"; desc = "raw14"; };
            RAW16_OTHER_VALUES = 0x2E { name = "Raw16 Other Values"; desc = "RAW16 Other values: reserved"; };
        };

        field {
            name = "di5_dt";
            desc = "Type of data with the ID 5 Error check is performed only when the configured data ID matches the ID of received data.";
            sw = rw;
            hw = r;
            encode = MIPI0_DI_2_di5_dt_enum;
            reset = 0x0;
        } di5_dt[13:8];

        field {
            name = "di4_vc";
            desc = "Virtual channel ID of data with the ID 4 Error check is performed only when the configured data ID matches the ID of received data.";
            sw = rw;
            hw = r;
            reset = 0x0;
        } di4_vc[7:6];

        enum MIPI0_DI_2_di4_dt_enum {
            RAW8 = 0x2A { name = "Raw8"; desc = "raw8"; };
            RAW10 = 0x2B { name = "Raw10"; desc = "raw10"; };
            RAW12 = 0x2C { name = "Raw12"; desc = "raw12"; };
            RAW14 = 0x2D { name = "Raw14"; desc = "raw14"; };
            RAW16_OTHER_VALUES = 0x2E { name = "Raw16 Other Values"; desc = "RAW16 Other values: reserved"; };
        };

        field {
            name = "di4_dt";
            desc = "Type of data with the ID 4 Error check is performed only when the configured data ID matches the ID of received data.";
            sw = rw;
            hw = r;
            encode = MIPI0_DI_2_di4_dt_enum;
            reset = 0x0;
        } di4_dt[5:0];
    } MIPI0_DI_2 @ 0x1014;

    reg {
        name = "MIPI 0 packet interrupt status register";
        desc = "MIPI0_PKT_INTR_ST is an MIPI 0 packet interrupt status register. Hi3516C V300/Hi3516E V100 Professional HD IP Camera SoC

Data sheet 9.3.6 MIPI0_PKT_INTR_ST (offset 0x1060, printed page 9-157, `hi3516cv300--Hi3516CV300-Hi3516EV100-Datasheet.txt` line 36357).";

        enum MIPI0_PKT_INTR_ST_err_ecc_double_enum {
            NO_ECC_ERROR = 0 { name = "No Ecc Error"; desc = "No ECC error occurs."; };
            ECC_ERRORS_OCCUR = 1 { name = "Ecc Errors Occur"; desc = "ECC errors occur."; };
        };

        field {
            name = "err_ecc_double";
            desc = "Whether the header has at least two uncorrectable ECC errors. This bit is cleared when it is read.";
            sw = r;
            hw = w;
            onread = rclr;
            encode = MIPI0_PKT_INTR_ST_err_ecc_double_enum;
            reset = 0x0;
        } err_ecc_double[16:16];

        enum MIPI0_PKT_INTR_ST_vc3_err_crc_enum {
            NO = 0 { name = "No"; desc = "no"; };
            YES = 1 { name = "Yes"; desc = "yes"; };
        };

        field {
            name = "vc3_err_crc";
            desc = "Whether the VC 3 data has CRC errors. This bit is cleared when it is read.";
            sw = r;
            hw = w;
            onread = rclr;
            encode = MIPI0_PKT_INTR_ST_vc3_err_crc_enum;
            reset = 0x0;
        } vc3_err_crc[3:3];

        enum MIPI0_PKT_INTR_ST_vc2_err_crc_enum {
            NO = 0 { name = "No"; desc = "no"; };
            YES = 1 { name = "Yes"; desc = "yes"; };
        };

        field {
            name = "vc2_err_crc";
            desc = "Whether the VC 2 data has CRC errors. This bit is cleared when it is read.";
            sw = r;
            hw = w;
            onread = rclr;
            encode = MIPI0_PKT_INTR_ST_vc2_err_crc_enum;
            reset = 0x0;
        } vc2_err_crc[2:2];

        enum MIPI0_PKT_INTR_ST_vc1_err_crc_enum {
            NO = 0 { name = "No"; desc = "no"; };
            YES = 1 { name = "Yes"; desc = "yes"; };
        };

        field {
            name = "vc1_err_crc";
            desc = "Whether the VC 1 data has CRC errors. This bit is cleared when it is read.";
            sw = r;
            hw = w;
            onread = rclr;
            encode = MIPI0_PKT_INTR_ST_vc1_err_crc_enum;
            reset = 0x0;
        } vc1_err_crc[1:1];

        enum MIPI0_PKT_INTR_ST_vc0_err_crc_enum {
            NO = 0 { name = "No"; desc = "no"; };
            YES = 1 { name = "Yes"; desc = "yes"; };
        };

        field {
            name = "vc0_err_crc";
            desc = "Whether the VC 0 data has CRC errors. This bit is cleared when it is read.";
            sw = r;
            hw = w;
            onread = rclr;
            encode = MIPI0_PKT_INTR_ST_vc0_err_crc_enum;
            reset = 0x0;
        } vc0_err_crc[0:0];
    } MIPI0_PKT_INTR_ST @ 0x1060;

    reg {
        name = "MIPI 0 packet interrupt mask register";
        desc = "MIPI0_PKT_INTR_MSK is an MIPI 0 packet interrupt mask register. Hi3516C V300/Hi3516E V100 Professional HD IP Camera SoC

Data sheet 9.3.6 MIPI0_PKT_INTR_MSK (offset 0x1064, printed page 9-158, `hi3516cv300--Hi3516CV300-Hi3516EV100-Datasheet.txt` line 36419).";

        enum MIPI0_PKT_INTR_MSK_mask_err_ecc_double_enum {
            MASKED = 0 { name = "Masked"; desc = "masked"; };
            ENABLED = 1 { name = "Enabled"; desc = "enabled"; };
        };

        field {
            name = "mask_err_ecc_double";
            desc = "err_ecc_double interrupt mask";
            sw = rw;
            hw = r;
            encode = MIPI0_PKT_INTR_MSK_mask_err_ecc_double_enum;
            reset = 0x0;
        } mask_err_ecc_double[16:16];

        enum MIPI0_PKT_INTR_MSK_mask_vc3_err_crc_enum {
            MASKED = 0 { name = "Masked"; desc = "masked"; };
            ENABLED = 1 { name = "Enabled"; desc = "enabled"; };
        };

        field {
            name = "mask_vc3_err_crc";
            desc = "vc3_err_crc interrupt mask";
            sw = rw;
            hw = r;
            encode = MIPI0_PKT_INTR_MSK_mask_vc3_err_crc_enum;
            reset = 0x0;
        } mask_vc3_err_crc[3:3];

        enum MIPI0_PKT_INTR_MSK_mask_vc2_err_crc_enum {
            MASKED = 0 { name = "Masked"; desc = "masked"; };
            ENABLED = 1 { name = "Enabled"; desc = "enabled"; };
        };

        field {
            name = "mask_vc2_err_crc";
            desc = "vc2_err_crc interrupt mask";
            sw = rw;
            hw = r;
            encode = MIPI0_PKT_INTR_MSK_mask_vc2_err_crc_enum;
            reset = 0x0;
        } mask_vc2_err_crc[2:2];

        enum MIPI0_PKT_INTR_MSK_mask_vc1_err_crc_enum {
            MASKED = 0 { name = "Masked"; desc = "masked"; };
            ENABLED = 1 { name = "Enabled"; desc = "enabled"; };
        };

        field {
            name = "mask_vc1_err_crc";
            desc = "vc1_err_crc interrupt mask";
            sw = rw;
            hw = r;
            encode = MIPI0_PKT_INTR_MSK_mask_vc1_err_crc_enum;
            reset = 0x0;
        } mask_vc1_err_crc[1:1];

        enum MIPI0_PKT_INTR_MSK_mask_vc0_err_crc_enum {
            MASKED = 0 { name = "Masked"; desc = "masked"; };
            ENABLED = 1 { name = "Enabled"; desc = "enabled"; };
        };

        field {
            name = "mask_vc0_err_crc";
            desc = "vc0_err_crc interrupt mask";
            sw = rw;
            hw = r;
            encode = MIPI0_PKT_INTR_MSK_mask_vc0_err_crc_enum;
            reset = 0x0;
        } mask_vc0_err_crc[0:0];
    } MIPI0_PKT_INTR_MSK @ 0x1064;

    reg {
        name = "MIPI 0 packet interrupt status 2 register";
        desc = "MIPI0_PKT_INTR2_ST is MIPI 0 packet interrupt status 2 register. Hi3516C V300/Hi3516E V100 Professional HD IP Camera SoC

Data sheet 9.3.6 MIPI0_PKT_INTR2_ST (offset 0x1070, printed page 9-159, `hi3516cv300--Hi3516CV300-Hi3516EV100-Datasheet.txt` line 36472).";

        enum MIPI0_PKT_INTR2_ST_vc3_err_ecc_corrected_enum {
            NO = 0 { name = "No"; desc = "no"; };
            YES_ECC_ERRORS = 1 { name = "Yes Ecc Errors"; desc = "yes. The ECC errors have been corrected."; };
        };

        field {
            name = "vc3_err_ecc_corrected";
            desc = "Whether the VC 3 channel header has ECC errors. This bit is cleared when it is read.";
            sw = r;
            hw = w;
            onread = rclr;
            encode = MIPI0_PKT_INTR2_ST_vc3_err_ecc_corrected_enum;
            reset = 0x0;
        } vc3_err_ecc_corrected[19:19];

        enum MIPI0_PKT_INTR2_ST_vc2_err_ecc_corrected_enum {
            NO = 0 { name = "No"; desc = "no"; };
            YES_ECC_ERRORS = 1 { name = "Yes Ecc Errors"; desc = "yes. The ECC errors have been corrected."; };
        };

        field {
            name = "vc2_err_ecc_corrected";
            desc = "Whether the VC 2 channel header has ECC errors. This bit is cleared when it is read.";
            sw = r;
            hw = w;
            onread = rclr;
            encode = MIPI0_PKT_INTR2_ST_vc2_err_ecc_corrected_enum;
            reset = 0x0;
        } vc2_err_ecc_corrected[18:18];

        enum MIPI0_PKT_INTR2_ST_vc1_err_ecc_corrected_enum {
            NO = 0 { name = "No"; desc = "no"; };
            YES_ECC_ERRORS = 1 { name = "Yes Ecc Errors"; desc = "yes. The ECC errors have been corrected."; };
        };

        field {
            name = "vc1_err_ecc_corrected";
            desc = "Whether the VC 1 channel header has ECC errors. This bit is cleared when it is read.";
            sw = r;
            hw = w;
            onread = rclr;
            encode = MIPI0_PKT_INTR2_ST_vc1_err_ecc_corrected_enum;
            reset = 0x0;
        } vc1_err_ecc_corrected[17:17];

        enum MIPI0_PKT_INTR2_ST_vc0_err_ecc_corrected_enum {
            NO = 0 { name = "No"; desc = "no"; };
            YES_ECC_ERRORS = 1 { name = "Yes Ecc Errors"; desc = "yes. The ECC errors have been corrected."; };
        };

        field {
            name = "vc0_err_ecc_corrected";
            desc = "Whether the VC 0 channel header has ECC errors. This bit is cleared when it is read.";
            sw = r;
            hw = w;
            onread = rclr;
            encode = MIPI0_PKT_INTR2_ST_vc0_err_ecc_corrected_enum;
            reset = 0x0;
        } vc0_err_ecc_corrected[16:16];

        enum MIPI0_PKT_INTR2_ST_err_id_vc3_enum {
            SUPPORTED = 0 { name = "Supported"; desc = "supported"; };
            NOT_SUPPORTED = 1 { name = "Not Supported"; desc = "not supported"; };
        };

        field {
            name = "err_id_vc3";
            desc = "Whether the VC 3 channel data type is supported. This bit is cleared when it is read.";
            sw = r;
            hw = w;
            onread = rclr;
            encode = MIPI0_PKT_INTR2_ST_err_id_vc3_enum;
            reset = 0x0;
        } err_id_vc3[3:3];

        enum MIPI0_PKT_INTR2_ST_err_id_vc2_enum {
            SUPPORTED = 0 { name = "Supported"; desc = "supported"; };
            NOT_SUPPORTED = 1 { name = "Not Supported"; desc = "not supported"; };
        };

        field {
            name = "err_id_vc2";
            desc = "Whether the VC 2 channel data type is supported. This bit is cleared when it is read.";
            sw = r;
            hw = w;
            onread = rclr;
            encode = MIPI0_PKT_INTR2_ST_err_id_vc2_enum;
            reset = 0x0;
        } err_id_vc2[2:2];

        enum MIPI0_PKT_INTR2_ST_err_id_vc1_enum {
            SUPPORTED = 0 { name = "Supported"; desc = "supported"; };
            NOT_SUPPORTED = 1 { name = "Not Supported"; desc = "not supported"; };
        };

        field {
            name = "err_id_vc1";
            desc = "Whether the VC 1 channel data type is supported. This bit is cleared when it is read.";
            sw = r;
            hw = w;
            onread = rclr;
            encode = MIPI0_PKT_INTR2_ST_err_id_vc1_enum;
            reset = 0x0;
        } err_id_vc1[1:1];

        enum MIPI0_PKT_INTR2_ST_err_id_vc0_enum {
            SUPPORTED = 0 { name = "Supported"; desc = "supported"; };
            NOT_SUPPORTED = 1 { name = "Not Supported"; desc = "not supported"; };
        };

        field {
            name = "err_id_vc0";
            desc = "Whether the VC 0 channel data type is supported. This bit is cleared when it is read.";
            sw = r;
            hw = w;
            onread = rclr;
            encode = MIPI0_PKT_INTR2_ST_err_id_vc0_enum;
            reset = 0x0;
        } err_id_vc0[0:0];
    } MIPI0_PKT_INTR2_ST @ 0x1070;

    reg {
        name = "MIPI 0 packet interrupt mask 2 register";
        desc = "MIPI0_PKT_INTR2_MSK is MIPI 0 packet interrupt mask 2 register.

Data sheet 9.3.6 MIPI0_PKT_INTR2_MSK (offset 0x1074, printed page 9-160, `hi3516cv300--Hi3516CV300-Hi3516EV100-Datasheet.txt` line 36550).";

        enum MIPI0_PKT_INTR2_MSK_mask_vc3_err_ecc_corrected_enum {
            MASKED = 0 { name = "Masked"; desc = "masked"; };
            ENABLED = 1 { name = "Enabled"; desc = "enabled"; };
        };

        field {
            name = "mask_vc3_err_ecc_corrected";
            desc = "vc3_err_ecc_corrected interrupt mask";
            sw = rw;
            hw = r;
            encode = MIPI0_PKT_INTR2_MSK_mask_vc3_err_ecc_corrected_enum;
            reset = 0x0;
        } mask_vc3_err_ecc_corrected[19:19];

        enum MIPI0_PKT_INTR2_MSK_mask_vc2_err_ecc_corrected_enum {
            MASKED = 0 { name = "Masked"; desc = "masked"; };
            ENABLED = 1 { name = "Enabled"; desc = "enabled"; };
        };

        field {
            name = "mask_vc2_err_ecc_corrected";
            desc = "vc2_err_ecc_corrected interrupt mask";
            sw = rw;
            hw = r;
            encode = MIPI0_PKT_INTR2_MSK_mask_vc2_err_ecc_corrected_enum;
            reset = 0x0;
        } mask_vc2_err_ecc_corrected[18:18];

        enum MIPI0_PKT_INTR2_MSK_mask_vc1_err_ecc_corrected_enum {
            MASKED = 0 { name = "Masked"; desc = "masked"; };
            ENABLED = 1 { name = "Enabled"; desc = "enabled"; };
        };

        field {
            name = "mask_vc1_err_ecc_corrected";
            desc = "vc1_err_ecc_corrected interrupt mask";
            sw = rw;
            hw = r;
            encode = MIPI0_PKT_INTR2_MSK_mask_vc1_err_ecc_corrected_enum;
            reset = 0x0;
        } mask_vc1_err_ecc_corrected[17:17];

        enum MIPI0_PKT_INTR2_MSK_mask_vc0_err_ecc_corrected_enum {
            MASKED = 0 { name = "Masked"; desc = "masked"; };
            ENABLED = 1 { name = "Enabled"; desc = "enabled"; };
        };

        field {
            name = "mask_vc0_err_ecc_corrected";
            desc = "vc0_err_ecc_corrected interrupt mask";
            sw = rw;
            hw = r;
            encode = MIPI0_PKT_INTR2_MSK_mask_vc0_err_ecc_corrected_enum;
            reset = 0x0;
        } mask_vc0_err_ecc_corrected[16:16];

        enum MIPI0_PKT_INTR2_MSK_mask_err_id_vc3_enum {
            MASKED = 0 { name = "Masked"; desc = "masked"; };
            ENABLED = 1 { name = "Enabled"; desc = "enabled"; };
        };

        field {
            name = "mask_err_id_vc3";
            desc = "err_id_vc3 interrupt mask";
            sw = rw;
            hw = r;
            encode = MIPI0_PKT_INTR2_MSK_mask_err_id_vc3_enum;
            reset = 0x0;
        } mask_err_id_vc3[3:3];

        enum MIPI0_PKT_INTR2_MSK_mask_err_id_vc2_enum {
            MASKED = 0 { name = "Masked"; desc = "masked"; };
            ENABLED = 1 { name = "Enabled"; desc = "enabled"; };
        };

        field {
            name = "mask_err_id_vc2";
            desc = "err_id_vc2 interrupt mask";
            sw = rw;
            hw = r;
            encode = MIPI0_PKT_INTR2_MSK_mask_err_id_vc2_enum;
            reset = 0x0;
        } mask_err_id_vc2[2:2];

        enum MIPI0_PKT_INTR2_MSK_mask_err_id_vc1_enum {
            MASKED = 0 { name = "Masked"; desc = "masked"; };
            ENABLED = 1 { name = "Enabled"; desc = "enabled"; };
        };

        field {
            name = "mask_err_id_vc1";
            desc = "err_id_vc1 interrupt mask";
            sw = rw;
            hw = r;
            encode = MIPI0_PKT_INTR2_MSK_mask_err_id_vc1_enum;
            reset = 0x0;
        } mask_err_id_vc1[1:1];

        enum MIPI0_PKT_INTR2_MSK_mask_err_id_vc0_enum {
            MASKED = 0 { name = "Masked"; desc = "masked"; };
            ENABLED = 1 { name = "Enabled"; desc = "enabled"; };
        };

        field {
            name = "mask_err_id_vc0";
            desc = "err_id_vc0 interrupt mask";
            sw = rw;
            hw = r;
            encode = MIPI0_PKT_INTR2_MSK_mask_err_id_vc0_enum;
            reset = 0x0;
        } mask_err_id_vc0[0:0];
    } MIPI0_PKT_INTR2_MSK @ 0x1074;

    reg {
        name = "MIPI 0 frame interrupt status register";
        desc = "MIPI0_FRAME_INTR_ST is an MIPI 0 frame interrupt status register.

Data sheet 9.3.6 MIPI0_FRAME_INTR_ST (offset 0x1080, printed page 9-161, `hi3516cv300--Hi3516CV300-Hi3516EV100-Datasheet.txt` line 36620).";

        enum MIPI0_FRAME_INTR_ST_err_frame_data_vc3_enum {
            NO_CRC_ERROR = 0 { name = "No Crc Error"; desc = "No CRC error occurs."; };
            CRC_ERRORS_OCCUR = 1 { name = "Crc Errors Occur"; desc = "CRC errors occur."; };
        };

        field {
            name = "err_frame_data_vc3";
            desc = "Whether the last frame of VC 3 channel data has at least one CRC error. This bit is cleared when it is read.";
            sw = r;
            hw = w;
            encode = MIPI0_FRAME_INTR_ST_err_frame_data_vc3_enum;
            reset = 0x0;
        } err_frame_data_vc3[19:19];

        enum MIPI0_FRAME_INTR_ST_err_frame_data_vc2_enum {
            NO_CRC_ERROR = 0 { name = "No Crc Error"; desc = "No CRC error occurs."; };
            CRC_ERRORS_OCCUR = 1 { name = "Crc Errors Occur"; desc = "CRC errors occur."; };
        };

        field {
            name = "err_frame_data_vc2";
            desc = "Whether the last frame of VC 2 channel data has at least one CRC error. This bit is cleared when it is read.";
            sw = r;
            hw = w;
            encode = MIPI0_FRAME_INTR_ST_err_frame_data_vc2_enum;
            reset = 0x0;
        } err_frame_data_vc2[18:18];

        enum MIPI0_FRAME_INTR_ST_err_frame_data_vc1_enum {
            NO_CRC_ERROR = 0 { name = "No Crc Error"; desc = "No CRC error occurs."; };
            CRC_ERRORS_OCCUR = 1 { name = "Crc Errors Occur"; desc = "CRC errors occur."; };
        };

        field {
            name = "err_frame_data_vc1";
            desc = "Whether the last frame of VC 1 channel data has at least one CRC error. This bit is cleared when it is read.";
            sw = r;
            hw = w;
            encode = MIPI0_FRAME_INTR_ST_err_frame_data_vc1_enum;
            reset = 0x0;
        } err_frame_data_vc1[17:17];

        enum MIPI0_FRAME_INTR_ST_err_frame_data_vc0_enum {
            NO_CRC_ERROR = 0 { name = "No Crc Error"; desc = "No CRC error occurs."; };
            CRC_ERRORS_OCCUR = 1 { name = "Crc Errors Occur"; desc = "CRC errors occur."; };
        };

        field {
            name = "err_frame_data_vc0";
            desc = "Whether the last frame of VC 0 channel data has at least one CRC error. This bit is cleared when it is read.";
            sw = r;
            hw = w;
            encode = MIPI0_FRAME_INTR_ST_err_frame_data_vc0_enum;
            reset = 0x0;
        } err_frame_data_vc0[16:16];

        enum MIPI0_FRAME_INTR_ST_err_f_seq_vc3_enum {
            YES = 0 { name = "Yes"; desc = "yes"; };
            NO = 1 { name = "No"; desc = "no"; };
        };

        field {
            name = "err_f_seq_vc3";
            desc = "Whether the VC 3 frame sequence is correct. This bit is cleared when it is read.";
            sw = r;
            hw = w;
            encode = MIPI0_FRAME_INTR_ST_err_f_seq_vc3_enum;
            reset = 0x0;
        } err_f_seq_vc3[11:11];

        enum MIPI0_FRAME_INTR_ST_err_f_seq_vc2_enum {
            YES = 0 { name = "Yes"; desc = "yes"; };
            NO = 1 { name = "No"; desc = "no"; };
        };

        field {
            name = "err_f_seq_vc2";
            desc = "Whether the VC 2 frame sequence is correct. This bit is cleared when it is read.";
            sw = r;
            hw = w;
            encode = MIPI0_FRAME_INTR_ST_err_f_seq_vc2_enum;
            reset = 0x0;
        } err_f_seq_vc2[10:10];

        enum MIPI0_FRAME_INTR_ST_err_f_seq_vc1_enum {
            YES = 0 { name = "Yes"; desc = "yes"; };
            NO = 1 { name = "No"; desc = "no"; };
        };

        field {
            name = "err_f_seq_vc1";
            desc = "Whether the VC 1 frame sequence is correct. This bit is cleared when it is read.";
            sw = r;
            hw = w;
            encode = MIPI0_FRAME_INTR_ST_err_f_seq_vc1_enum;
            reset = 0x0;
        } err_f_seq_vc1[9:9];

        enum MIPI0_FRAME_INTR_ST_err_f_seq_vc0_enum {
            YES = 0 { name = "Yes"; desc = "yes"; };
            NO = 1 { name = "No"; desc = "no"; };
        };

        field {
            name = "err_f_seq_vc0";
            desc = "Whether the VC 0 frame sequence is correct. This bit is cleared when it is read.";
            sw = r;
            hw = w;
            encode = MIPI0_FRAME_INTR_ST_err_f_seq_vc0_enum;
            reset = 0x0;
        } err_f_seq_vc0[8:8];

        enum MIPI0_FRAME_INTR_ST_err_f_bndry_match_vc3_enum {
            YES = 0 { name = "Yes"; desc = "yes"; };
            NO = 1 { name = "No"; desc = "no"; };
        };

        field {
            name = "err_f_bndry_match_vc3";
            desc = "Whether the SOF matches the EOF for the VC 3 channel. This bit is cleared when it is read.";
            sw = r;
            hw = w;
            encode = MIPI0_FRAME_INTR_ST_err_f_bndry_match_vc3_enum;
            reset = 0x0;
        } err_f_bndry_match_vc3[3:3];

        enum MIPI0_FRAME_INTR_ST_err_f_bndry_match_vc2_enum {
            YES = 0 { name = "Yes"; desc = "yes"; };
            NO = 1 { name = "No"; desc = "no"; };
        };

        field {
            name = "err_f_bndry_match_vc2";
            desc = "Whether the SOF matches the EOF for the VC 2 channel. This bit is cleared when it is read.";
            sw = r;
            hw = w;
            encode = MIPI0_FRAME_INTR_ST_err_f_bndry_match_vc2_enum;
            reset = 0x0;
        } err_f_bndry_match_vc2[2:2];

        enum MIPI0_FRAME_INTR_ST_err_f_bndry_match_vc1_enum {
            YES = 0 { name = "Yes"; desc = "yes"; };
            NO = 1 { name = "No"; desc = "no"; };
        };

        field {
            name = "err_f_bndry_match_vc1";
            desc = "Whether the SOF matches the EOF for the VC 1 channel. This bit is cleared when it is read.";
            sw = r;
            hw = w;
            encode = MIPI0_FRAME_INTR_ST_err_f_bndry_match_vc1_enum;
            reset = 0x0;
        } err_f_bndry_match_vc1[1:1];

        enum MIPI0_FRAME_INTR_ST_err_f_bndry_match_vc0_enum {
            YES = 0 { name = "Yes"; desc = "yes"; };
            NO = 1 { name = "No"; desc = "no"; };
        };

        field {
            name = "err_f_bndry_match_vc0";
            desc = "Whether the SOF matches the EOF for the VC 0 channel. This bit is cleared when it is read.";
            sw = r;
            hw = w;
            encode = MIPI0_FRAME_INTR_ST_err_f_bndry_match_vc0_enum;
            reset = 0x0;
        } err_f_bndry_match_vc0[0:0];
    } MIPI0_FRAME_INTR_ST @ 0x1080;

    reg {
        name = "MIPI 0 frame interrupt mask register SK";
        desc = "MIPI0_FRAME_INTR_MSK is an MIPI 0 frame interrupt mask register.

Data sheet 9.3.6 MIPI0_FRAME_INTR_MSK (offset 0x1084, printed page 9-163, `hi3516cv300--Hi3516CV300-Hi3516EV100-Datasheet.txt` line 36730).";

        enum MIPI0_FRAME_INTR_MSK_mask_err_frame_data_vc3_enum {
            MASKED = 0 { name = "Masked"; desc = "masked"; };
            ENABLED = 1 { name = "Enabled"; desc = "enabled"; };
        };

        field {
            name = "mask_err_frame_data_vc3";
            desc = "err_frame_data_vc3 interrupt mask";
            sw = rw;
            hw = r;
            encode = MIPI0_FRAME_INTR_MSK_mask_err_frame_data_vc3_enum;
            reset = 0x0;
        } mask_err_frame_data_vc3[19:19];

        enum MIPI0_FRAME_INTR_MSK_mask_err_frame_data_vc2_enum {
            MASKED = 0 { name = "Masked"; desc = "masked"; };
            ENABLED = 1 { name = "Enabled"; desc = "enabled"; };
        };

        field {
            name = "mask_err_frame_data_vc2";
            desc = "err_frame_data_vc2 interrupt mask";
            sw = rw;
            hw = r;
            encode = MIPI0_FRAME_INTR_MSK_mask_err_frame_data_vc2_enum;
            reset = 0x0;
        } mask_err_frame_data_vc2[18:18];

        enum MIPI0_FRAME_INTR_MSK_mask_err_frame_data_vc1_enum {
            MASKED = 0 { name = "Masked"; desc = "masked"; };
            ENABLED = 1 { name = "Enabled"; desc = "enabled"; };
        };

        field {
            name = "mask_err_frame_data_vc1";
            desc = "err_frame_data_vc1 interrupt mask";
            sw = rw;
            hw = r;
            encode = MIPI0_FRAME_INTR_MSK_mask_err_frame_data_vc1_enum;
            reset = 0x0;
        } mask_err_frame_data_vc1[17:17];

        enum MIPI0_FRAME_INTR_MSK_mask_err_frame_data_vc0_enum {
            MASKED = 0 { name = "Masked"; desc = "masked"; };
            ENABLED = 1 { name = "Enabled"; desc = "enabled"; };
        };

        field {
            name = "mask_err_frame_data_vc0";
            desc = "err_frame_data_vc0 interrupt mask";
            sw = rw;
            hw = r;
            encode = MIPI0_FRAME_INTR_MSK_mask_err_frame_data_vc0_enum;
            reset = 0x0;
        } mask_err_frame_data_vc0[16:16];

        enum MIPI0_FRAME_INTR_MSK_mask_err_f_seq_vc_enum {
            MASKED = 0 { name = "Masked"; desc = "masked"; };
            ENABLED = 1 { name = "Enabled"; desc = "enabled"; };
        };

        field {
            name = "mask_err_f_seq_vc";
            desc = "err_f_seq_vc3 interrupt mask";
            sw = rw;
            hw = r;
            encode = MIPI0_FRAME_INTR_MSK_mask_err_f_seq_vc_enum;
            reset = 0x0;
        } mask_err_f_seq_vc[11:11];

        enum MIPI0_FRAME_INTR_MSK_mask_err_f_seq_vc_2_enum {
            MASKED = 0 { name = "Masked"; desc = "masked"; };
            ENABLED = 1 { name = "Enabled"; desc = "enabled"; };
        };

        field {
            name = "mask_err_f_seq_vc";
            desc = "err_f_seq_vc2 interrupt mask";
            sw = rw;
            hw = r;
            encode = MIPI0_FRAME_INTR_MSK_mask_err_f_seq_vc_2_enum;
            reset = 0x0;
        } mask_err_f_seq_vc_2[10:10];

        enum MIPI0_FRAME_INTR_MSK_mask_err_f_seq_vc_3_enum {
            MASKED = 0 { name = "Masked"; desc = "masked"; };
            ENABLED = 1 { name = "Enabled"; desc = "enabled"; };
        };

        field {
            name = "mask_err_f_seq_vc";
            desc = "err_f_seq_vc1 interrupt mask";
            sw = rw;
            hw = r;
            encode = MIPI0_FRAME_INTR_MSK_mask_err_f_seq_vc_3_enum;
            reset = 0x0;
        } mask_err_f_seq_vc_3[9:9];

        enum MIPI0_FRAME_INTR_MSK_mask_err_f_seq_vc_4_enum {
            MASKED = 0 { name = "Masked"; desc = "masked"; };
            ENABLED = 1 { name = "Enabled"; desc = "enabled"; };
        };

        field {
            name = "mask_err_f_seq_vc";
            desc = "err_f_seq_vc0 interrupt mask";
            sw = rw;
            hw = r;
            encode = MIPI0_FRAME_INTR_MSK_mask_err_f_seq_vc_4_enum;
            reset = 0x0;
        } mask_err_f_seq_vc_4[8:8];

        enum MIPI0_FRAME_INTR_MSK_mask_err_f_bndry_match_vc3_enum {
            MASKED = 0 { name = "Masked"; desc = "masked"; };
            ENABLED = 1 { name = "Enabled"; desc = "enabled"; };
        };

        field {
            name = "mask_err_f_bndry_match_vc3";
            desc = "err_f_bndry_match_vc3 interrupt mask";
            sw = rw;
            hw = r;
            encode = MIPI0_FRAME_INTR_MSK_mask_err_f_bndry_match_vc3_enum;
            reset = 0x0;
        } mask_err_f_bndry_match_vc3[3:3];

        enum MIPI0_FRAME_INTR_MSK_mask_err_f_bndry_match_vc2_enum {
            MASKED = 0 { name = "Masked"; desc = "masked"; };
            ENABLED = 1 { name = "Enabled"; desc = "enabled"; };
        };

        field {
            name = "mask_err_f_bndry_match_vc2";
            desc = "err_f_bndry_match_vc2 interrupt mask";
            sw = rw;
            hw = r;
            encode = MIPI0_FRAME_INTR_MSK_mask_err_f_bndry_match_vc2_enum;
            reset = 0x0;
        } mask_err_f_bndry_match_vc2[2:2];

        enum MIPI0_FRAME_INTR_MSK_mask_err_f_bndry_match_vc1_enum {
            MASKED = 0 { name = "Masked"; desc = "masked"; };
            ENABLED = 1 { name = "Enabled"; desc = "enabled"; };
        };

        field {
            name = "mask_err_f_bndry_match_vc1";
            desc = "err_f_bndry_match_vc1 interrupt mask";
            sw = rw;
            hw = r;
            encode = MIPI0_FRAME_INTR_MSK_mask_err_f_bndry_match_vc1_enum;
            reset = 0x0;
        } mask_err_f_bndry_match_vc1[1:1];

        enum MIPI0_FRAME_INTR_MSK_mask_err_f_bndry_match_vc0_enum {
            MASKED = 0 { name = "Masked"; desc = "masked"; };
            ENABLED = 1 { name = "Enabled"; desc = "enabled"; };
        };

        field {
            name = "mask_err_f_bndry_match_vc0";
            desc = "err_f_bndry_match_vc0 interrupt mask";
            sw = rw;
            hw = r;
            encode = MIPI0_FRAME_INTR_MSK_mask_err_f_bndry_match_vc0_enum;
            reset = 0x0;
        } mask_err_f_bndry_match_vc0[0:0];
    } MIPI0_FRAME_INTR_MSK @ 0x1084;

    reg {
        name = "MIPI 0 line interrupt status register";
        desc = "MIPI0_LINE_INTR_ST is an MIPI 0 line interrupt status register. Hi3516C V300/Hi3516E V100 Professional HD IP Camera SoC

Data sheet 9.3.6 MIPI0_LINE_INTR_ST (offset 0x1090, printed page 9-165, `hi3516cv300--Hi3516CV300-Hi3516EV100-Datasheet.txt` line 36837).";

        enum MIPI0_LINE_INTR_ST_err_l_seq_di7_enum {
            YES = 0 { name = "Yes"; desc = "yes"; };
            NO = 1 { name = "No"; desc = "no"; };
        };

        field {
            name = "err_l_seq_di7";
            desc = "Whether the line sequence of VC 7 and DT 7 is correct. This bit is cleared when it is read.";
            sw = r;
            hw = w;
            onread = rclr;
            encode = MIPI0_LINE_INTR_ST_err_l_seq_di7_enum;
            reset = 0x0;
        } err_l_seq_di7[23:23];

        enum MIPI0_LINE_INTR_ST_err_l_seq_di6_enum {
            YES = 0 { name = "Yes"; desc = "yes"; };
            NO = 1 { name = "No"; desc = "no"; };
        };

        field {
            name = "err_l_seq_di6";
            desc = "Whether the line sequence of VC 6 and DT 6 is correct. This bit is cleared when it is read.";
            sw = r;
            hw = w;
            onread = rclr;
            encode = MIPI0_LINE_INTR_ST_err_l_seq_di6_enum;
            reset = 0x0;
        } err_l_seq_di6[22:22];

        enum MIPI0_LINE_INTR_ST_err_l_seq_di5_enum {
            YES = 0 { name = "Yes"; desc = "yes"; };
            NO = 1 { name = "No"; desc = "no"; };
        };

        field {
            name = "err_l_seq_di5";
            desc = "Whether the line sequence of VC 5 and DT 5 is correct. This bit is cleared when it is read.";
            sw = r;
            hw = w;
            onread = rclr;
            encode = MIPI0_LINE_INTR_ST_err_l_seq_di5_enum;
            reset = 0x0;
        } err_l_seq_di5[21:21];

        enum MIPI0_LINE_INTR_ST_err_l_seq_di4_enum {
            YES = 0 { name = "Yes"; desc = "yes"; };
            NO = 1 { name = "No"; desc = "no"; };
        };

        field {
            name = "err_l_seq_di4";
            desc = "Whether the line sequence of VC 4 and DT 4 is correct. This bit is cleared when it is read.";
            sw = r;
            hw = w;
            onread = rclr;
            encode = MIPI0_LINE_INTR_ST_err_l_seq_di4_enum;
            reset = 0x0;
        } err_l_seq_di4[20:20];

        enum MIPI0_LINE_INTR_ST_err_l_seq_di3_enum {
            YES = 0 { name = "Yes"; desc = "yes"; };
            NO = 1 { name = "No"; desc = "no"; };
        };

        field {
            name = "err_l_seq_di3";
            desc = "Whether the line sequence of VC 3 and DT 3 is correct. This bit is cleared when it is read.";
            sw = r;
            hw = w;
            onread = rclr;
            encode = MIPI0_LINE_INTR_ST_err_l_seq_di3_enum;
            reset = 0x0;
        } err_l_seq_di3[19:19];

        enum MIPI0_LINE_INTR_ST_err_l_seq_di2_enum {
            YES = 0 { name = "Yes"; desc = "yes"; };
            NO = 1 { name = "No"; desc = "no"; };
        };

        field {
            name = "err_l_seq_di2";
            desc = "Whether the line sequence of VC 2 and DT 2 is correct. This bit is cleared when it is read.";
            sw = r;
            hw = w;
            onread = rclr;
            encode = MIPI0_LINE_INTR_ST_err_l_seq_di2_enum;
            reset = 0x0;
        } err_l_seq_di2[18:18];

        enum MIPI0_LINE_INTR_ST_err_l_seq_di1_enum {
            YES = 0 { name = "Yes"; desc = "yes"; };
            NO = 1 { name = "No"; desc = "no"; };
        };

        field {
            name = "err_l_seq_di1";
            desc = "Whether the line sequence of VC 1 and DT 1 is correct. This bit is cleared when it is read.";
            sw = r;
            hw = w;
            onread = rclr;
            encode = MIPI0_LINE_INTR_ST_err_l_seq_di1_enum;
            reset = 0x0;
        } err_l_seq_di1[17:17];

        enum MIPI0_LINE_INTR_ST_err_l_seq_di0_enum {
            YES = 0 { name = "Yes"; desc = "yes"; };
            NO = 1 { name = "No"; desc = "no"; };
        };

        field {
            name = "err_l_seq_di0";
            desc = "Whether the line sequence of VC 0 and DT 0 is correct. This bit is cleared when it is read.";
            sw = r;
            hw = w;
            onread = rclr;
            encode = MIPI0_LINE_INTR_ST_err_l_seq_di0_enum;
            reset = 0x0;
        } err_l_seq_di0[16:16];

        enum MIPI0_LINE_INTR_ST_err_l_bndry_match_di7_enum {
            YES = 0 { name = "Yes"; desc = "yes"; };
            NO = 1 { name = "No"; desc = "no"; };
        };

        field {
            name = "err_l_bndry_match_di7";
            desc = "Whether the SOL matches the EOL for VC 7 and DT 7. This bit is cleared when it is read.";
            sw = r;
            hw = w;
            onread = rclr;
            encode = MIPI0_LINE_INTR_ST_err_l_bndry_match_di7_enum;
            reset = 0x0;
        } err_l_bndry_match_di7[7:7];

        enum MIPI0_LINE_INTR_ST_err_l_bndry_match_di6_enum {
            YES = 0 { name = "Yes"; desc = "yes"; };
            NO = 1 { name = "No"; desc = "no"; };
        };

        field {
            name = "err_l_bndry_match_di6";
            desc = "Whether the SOL matches the EOL for VC 6 and DT 6. This bit is cleared when it is read.";
            sw = r;
            hw = w;
            onread = rclr;
            encode = MIPI0_LINE_INTR_ST_err_l_bndry_match_di6_enum;
            reset = 0x0;
        } err_l_bndry_match_di6[6:6];

        enum MIPI0_LINE_INTR_ST_err_l_bndry_match_di5_enum {
            YES = 0 { name = "Yes"; desc = "yes"; };
            NO = 1 { name = "No"; desc = "no"; };
        };

        field {
            name = "err_l_bndry_match_di5";
            desc = "Whether the SOL matches the EOL for VC 5 and DT 5. This bit is cleared when it is read.";
            sw = r;
            hw = w;
            onread = rclr;
            encode = MIPI0_LINE_INTR_ST_err_l_bndry_match_di5_enum;
            reset = 0x0;
        } err_l_bndry_match_di5[5:5];

        enum MIPI0_LINE_INTR_ST_err_l_bndry_match_di4_enum {
            YES = 0 { name = "Yes"; desc = "yes"; };
            NO = 1 { name = "No"; desc = "no"; };
        };

        field {
            name = "err_l_bndry_match_di4";
            desc = "Whether the SOL matches the EOL for VC 4 and DT 4. This bit is cleared when it is read.";
            sw = r;
            hw = w;
            onread = rclr;
            encode = MIPI0_LINE_INTR_ST_err_l_bndry_match_di4_enum;
            reset = 0x0;
        } err_l_bndry_match_di4[4:4];

        enum MIPI0_LINE_INTR_ST_err_l_bndry_match_di3_enum {
            YES = 0 { name = "Yes"; desc = "yes"; };
            NO = 1 { name = "No"; desc = "no"; };
        };

        field {
            name = "err_l_bndry_match_di3";
            desc = "Whether the SOL matches the EOL for VC 3 and DT 3. This bit is cleared when it is read.";
            sw = r;
            hw = w;
            onread = rclr;
            encode = MIPI0_LINE_INTR_ST_err_l_bndry_match_di3_enum;
            reset = 0x0;
        } err_l_bndry_match_di3[3:3];

        enum MIPI0_LINE_INTR_ST_err_l_bndry_match_di2_enum {
            YES = 0 { name = "Yes"; desc = "yes"; };
            NO = 1 { name = "No"; desc = "no"; };
        };

        field {
            name = "err_l_bndry_match_di2";
            desc = "Whether the SOL matches the EOL for VC 2 and DT 2. This bit is cleared when it is read.";
            sw = r;
            hw = w;
            onread = rclr;
            encode = MIPI0_LINE_INTR_ST_err_l_bndry_match_di2_enum;
            reset = 0x0;
        } err_l_bndry_match_di2[2:2];

        enum MIPI0_LINE_INTR_ST_err_l_bndry_match_di1_enum {
            YES = 0 { name = "Yes"; desc = "yes"; };
            NO = 1 { name = "No"; desc = "no"; };
        };

        field {
            name = "err_l_bndry_match_di1";
            desc = "Whether the SOL matches the EOL for VC 1 and DT 1. This bit is cleared when it is read.";
            sw = r;
            hw = w;
            onread = rclr;
            encode = MIPI0_LINE_INTR_ST_err_l_bndry_match_di1_enum;
            reset = 0x0;
        } err_l_bndry_match_di1[1:1];

        enum MIPI0_LINE_INTR_ST_err_l_bndry_match_di0_enum {
            YES = 0 { name = "Yes"; desc = "yes"; };
            NO = 1 { name = "No"; desc = "no"; };
        };

        field {
            name = "err_l_bndry_match_di0";
            desc = "Whether the SOL matches the EOL for VC 0 and DT 0. This bit is cleared when it is read.";
            sw = r;
            hw = w;
            onread = rclr;
            encode = MIPI0_LINE_INTR_ST_err_l_bndry_match_di0_enum;
            reset = 0x0;
        } err_l_bndry_match_di0[0:0];
    } MIPI0_LINE_INTR_ST @ 0x1090;

    reg {
        name = "MIPI 0 line interrupt mask register";
        desc = "MIPI0_LINE_INTR_MSK is an MIPI 0 line interrupt mask register.

Data sheet 9.3.6 MIPI0_LINE_INTR_MSK (offset 0x1094, printed page 9-167, `hi3516cv300--Hi3516CV300-Hi3516EV100-Datasheet.txt` line 36960).";

        enum MIPI0_LINE_INTR_MSK_mask_err_l_seq_di_enum {
            MASKED = 0 { name = "Masked"; desc = "masked"; };
            ENABLED = 1 { name = "Enabled"; desc = "enabled"; };
        };

        field {
            name = "mask_err_l_seq_di";
            desc = "err_l_seq_di7 interrupt mask";
            sw = rw;
            hw = r;
            encode = MIPI0_LINE_INTR_MSK_mask_err_l_seq_di_enum;
            reset = 0x0;
        } mask_err_l_seq_di[23:23];

        enum MIPI0_LINE_INTR_MSK_mask_err_l_seq_di_2_enum {
            MASKED = 0 { name = "Masked"; desc = "masked"; };
            ENABLED = 1 { name = "Enabled"; desc = "enabled"; };
        };

        field {
            name = "mask_err_l_seq_di";
            desc = "err_l_seq_di6 interrupt mask";
            sw = rw;
            hw = r;
            encode = MIPI0_LINE_INTR_MSK_mask_err_l_seq_di_2_enum;
            reset = 0x0;
        } mask_err_l_seq_di_2[22:22];

        enum MIPI0_LINE_INTR_MSK_mask_err_l_seq_di_3_enum {
            MASKED = 0 { name = "Masked"; desc = "masked"; };
            ENABLED = 1 { name = "Enabled"; desc = "enabled"; };
        };

        field {
            name = "mask_err_l_seq_di";
            desc = "err_l_seq_di5 interrupt mask";
            sw = rw;
            hw = r;
            encode = MIPI0_LINE_INTR_MSK_mask_err_l_seq_di_3_enum;
            reset = 0x0;
        } mask_err_l_seq_di_3[21:21];

        enum MIPI0_LINE_INTR_MSK_mask_err_l_seq_di_4_enum {
            MASKED = 0 { name = "Masked"; desc = "masked"; };
            ENABLED = 1 { name = "Enabled"; desc = "enabled"; };
        };

        field {
            name = "mask_err_l_seq_di";
            desc = "err_l_seq_di4 interrupt mask";
            sw = rw;
            hw = r;
            encode = MIPI0_LINE_INTR_MSK_mask_err_l_seq_di_4_enum;
            reset = 0x0;
        } mask_err_l_seq_di_4[20:20];

        enum MIPI0_LINE_INTR_MSK_mask_err_l_seq_di_5_enum {
            MASKED = 0 { name = "Masked"; desc = "masked"; };
            ENABLED = 1 { name = "Enabled"; desc = "enabled"; };
        };

        field {
            name = "mask_err_l_seq_di";
            desc = "err_l_seq_di3 interrupt mask";
            sw = rw;
            hw = r;
            encode = MIPI0_LINE_INTR_MSK_mask_err_l_seq_di_5_enum;
            reset = 0x0;
        } mask_err_l_seq_di_5[19:19];

        enum MIPI0_LINE_INTR_MSK_mask_err_l_seq_di_6_enum {
            MASKED = 0 { name = "Masked"; desc = "masked"; };
            ENABLED = 1 { name = "Enabled"; desc = "enabled"; };
        };

        field {
            name = "mask_err_l_seq_di";
            desc = "err_l_seq_di2 interrupt mask";
            sw = rw;
            hw = r;
            encode = MIPI0_LINE_INTR_MSK_mask_err_l_seq_di_6_enum;
            reset = 0x0;
        } mask_err_l_seq_di_6[18:18];

        enum MIPI0_LINE_INTR_MSK_mask_err_l_seq_di_7_enum {
            MASKED = 0 { name = "Masked"; desc = "masked"; };
            ENABLED = 1 { name = "Enabled"; desc = "enabled"; };
        };

        field {
            name = "mask_err_l_seq_di";
            desc = "err_l_seq_di1 interrupt mask";
            sw = rw;
            hw = r;
            encode = MIPI0_LINE_INTR_MSK_mask_err_l_seq_di_7_enum;
            reset = 0x0;
        } mask_err_l_seq_di_7[17:17];

        enum MIPI0_LINE_INTR_MSK_mask_err_l_seq_di_8_enum {
            MASKED = 0 { name = "Masked"; desc = "masked"; };
            ENABLED = 1 { name = "Enabled"; desc = "enabled"; };
        };

        field {
            name = "mask_err_l_seq_di";
            desc = "err_l_seq_di0 interrupt mask";
            sw = rw;
            hw = r;
            encode = MIPI0_LINE_INTR_MSK_mask_err_l_seq_di_8_enum;
            reset = 0x0;
        } mask_err_l_seq_di_8[16:16];

        enum MIPI0_LINE_INTR_MSK_mask_err_l_bndry_match_di7_enum {
            MASKED = 0 { name = "Masked"; desc = "masked"; };
            ENABLED = 1 { name = "Enabled"; desc = "enabled"; };
        };

        field {
            name = "mask_err_l_bndry_match_di7";
            desc = "err_l_bndry_match_di7 interrupt mask";
            sw = rw;
            hw = r;
            encode = MIPI0_LINE_INTR_MSK_mask_err_l_bndry_match_di7_enum;
            reset = 0x0;
        } mask_err_l_bndry_match_di7[7:7];

        enum MIPI0_LINE_INTR_MSK_mask_err_l_bndry_match_di6_enum {
            MASKED = 0 { name = "Masked"; desc = "masked"; };
            ENABLED = 1 { name = "Enabled"; desc = "enabled"; };
        };

        field {
            name = "mask_err_l_bndry_match_di6";
            desc = "err_l_bndry_match_di6 interrupt mask";
            sw = rw;
            hw = r;
            encode = MIPI0_LINE_INTR_MSK_mask_err_l_bndry_match_di6_enum;
            reset = 0x0;
        } mask_err_l_bndry_match_di6[6:6];

        enum MIPI0_LINE_INTR_MSK_mask_err_l_bndry_match_di5_enum {
            MASKED = 0 { name = "Masked"; desc = "masked"; };
            ENABLED = 1 { name = "Enabled"; desc = "enabled"; };
        };

        field {
            name = "mask_err_l_bndry_match_di5";
            desc = "err_l_bndry_match_di5 interrupt mask";
            sw = rw;
            hw = r;
            encode = MIPI0_LINE_INTR_MSK_mask_err_l_bndry_match_di5_enum;
            reset = 0x0;
        } mask_err_l_bndry_match_di5[5:5];

        enum MIPI0_LINE_INTR_MSK_mask_err_l_bndry_match_di4_enum {
            MASKED = 0 { name = "Masked"; desc = "masked"; };
            ENABLED = 1 { name = "Enabled"; desc = "enabled"; };
        };

        field {
            name = "mask_err_l_bndry_match_di4";
            desc = "err_l_bndry_match_di4 interrupt mask";
            sw = rw;
            hw = r;
            encode = MIPI0_LINE_INTR_MSK_mask_err_l_bndry_match_di4_enum;
            reset = 0x0;
        } mask_err_l_bndry_match_di4[4:4];

        enum MIPI0_LINE_INTR_MSK_mask_err_l_bndry_match_di3_enum {
            MASKED = 0 { name = "Masked"; desc = "masked"; };
            ENABLED = 1 { name = "Enabled"; desc = "enabled"; };
        };

        field {
            name = "mask_err_l_bndry_match_di3";
            desc = "err_l_bndry_match_di3 interrupt mask";
            sw = rw;
            hw = r;
            encode = MIPI0_LINE_INTR_MSK_mask_err_l_bndry_match_di3_enum;
            reset = 0x0;
        } mask_err_l_bndry_match_di3[3:3];

        enum MIPI0_LINE_INTR_MSK_mask_err_l_bndry_match_di2_enum {
            MASKED = 0 { name = "Masked"; desc = "masked"; };
            ENABLED = 1 { name = "Enabled"; desc = "enabled"; };
        };

        field {
            name = "mask_err_l_bndry_match_di2";
            desc = "err_l_bndry_match_di2 interrupt mask";
            sw = rw;
            hw = r;
            encode = MIPI0_LINE_INTR_MSK_mask_err_l_bndry_match_di2_enum;
            reset = 0x0;
        } mask_err_l_bndry_match_di2[2:2];

        enum MIPI0_LINE_INTR_MSK_mask_err_l_bndry_match_di1_enum {
            MASKED = 0 { name = "Masked"; desc = "masked"; };
            ENABLED = 1 { name = "Enabled"; desc = "enabled"; };
        };

        field {
            name = "mask_err_l_bndry_match_di1";
            desc = "err_l_bndry_match_di1 interrupt mask";
            sw = rw;
            hw = r;
            encode = MIPI0_LINE_INTR_MSK_mask_err_l_bndry_match_di1_enum;
            reset = 0x0;
        } mask_err_l_bndry_match_di1[1:1];

        enum MIPI0_LINE_INTR_MSK_mask_err_l_bndry_match_di0_enum {
            MASKED = 0 { name = "Masked"; desc = "masked"; };
            ENABLED = 1 { name = "Enabled"; desc = "enabled"; };
        };

        field {
            name = "mask_err_l_bndry_match_di0";
            desc = "err_l_bndry_match_di0 interrupt mask";
            sw = rw;
            hw = r;
            encode = MIPI0_LINE_INTR_MSK_mask_err_l_bndry_match_di0_enum;
            reset = 0x0;
        } mask_err_l_bndry_match_di0[0:0];
    } MIPI0_LINE_INTR_MSK @ 0x1094;

    reg {
        name = "MIPI 0 pixel bit width configuration register for the user-defined data type";
        desc = "MIPI0_USERDEF_DT is an MIPI 0 pixel bit width configuration register for the user-defined data type. Hi3516C V300/Hi3516E V100 Professional HD IP Camera SoC

Data sheet 9.3.6 MIPI0_USERDEF_DT (offset 0x1100, printed page 9-169, `hi3516cv300--Hi3516CV300-Hi3516EV100-Datasheet.txt` line 37090).";

        enum MIPI0_USERDEF_DT_user_def3_dt_enum {
            V_8_BITS = 0 { name = "V 8 Bits"; desc = "8 bits"; };
            V_10_BITS = 1 { name = "V 10 Bits"; desc = "10 bits"; };
            V_12_BITS = 2 { name = "V 12 Bits"; desc = "12 bits"; };
            V_14_BITS = 3 { name = "V 14 Bits"; desc = "14 bits"; };
            V_16_BITS_OTHER = 4 { name = "V 16 Bits Other"; desc = "16 bits Other values: reserved"; };
        };

        field {
            name = "user_def3_dt";
            desc = "Bit width of the transferred pixel when the data type is user_def3";
            sw = rw;
            hw = r;
            encode = MIPI0_USERDEF_DT_user_def3_dt_enum;
            reset = 0x0;
        } user_def3_dt[14:12];

        enum MIPI0_USERDEF_DT_user_def2_dt_enum {
            V_8_BITS = 0 { name = "V 8 Bits"; desc = "8 bits"; };
            V_10_BITS = 1 { name = "V 10 Bits"; desc = "10 bits"; };
            V_12_BITS = 2 { name = "V 12 Bits"; desc = "12 bits"; };
            V_14_BITS = 3 { name = "V 14 Bits"; desc = "14 bits"; };
            V_16_BITS_OTHER = 4 { name = "V 16 Bits Other"; desc = "16 bits Other values: reserved"; };
        };

        field {
            name = "user_def2_dt";
            desc = "Bit width of the transferred pixel when the data type is user_def2";
            sw = rw;
            hw = r;
            encode = MIPI0_USERDEF_DT_user_def2_dt_enum;
            reset = 0x0;
        } user_def2_dt[10:8];

        enum MIPI0_USERDEF_DT_user_def1_dt_enum {
            V_8_BITS = 0 { name = "V 8 Bits"; desc = "8 bits"; };
            V_10_BITS = 1 { name = "V 10 Bits"; desc = "10 bits"; };
            V_12_BITS = 2 { name = "V 12 Bits"; desc = "12 bits"; };
            V_14_BITS = 3 { name = "V 14 Bits"; desc = "14 bits"; };
            V_16_BITS_OTHER = 4 { name = "V 16 Bits Other"; desc = "16 bits Other values: reserved"; };
        };

        field {
            name = "user_def1_dt";
            desc = "Bit width of the transferred pixel when the data type is user_def1";
            sw = rw;
            hw = r;
            encode = MIPI0_USERDEF_DT_user_def1_dt_enum;
            reset = 0x0;
        } user_def1_dt[6:4];

        enum MIPI0_USERDEF_DT_user_def0_dt_enum {
            V_8_BITS = 0 { name = "V 8 Bits"; desc = "8 bits"; };
            V_10_BITS = 1 { name = "V 10 Bits"; desc = "10 bits"; };
            V_12_BITS = 2 { name = "V 12 Bits"; desc = "12 bits"; };
            V_14_BITS = 3 { name = "V 14 Bits"; desc = "14 bits"; };
            V_16_BITS_OTHER = 4 { name = "V 16 Bits Other"; desc = "16 bits Other values: reserved"; };
        };

        field {
            name = "user_def0_dt";
            desc = "Bit width of the transferred pixel when the data type is user_def0";
            sw = rw;
            hw = r;
            encode = MIPI0_USERDEF_DT_user_def0_dt_enum;
            reset = 0x0;
        } user_def0_dt[2:0];
    } MIPI0_USERDEF_DT @ 0x1100;

    reg {
        name = "MIPI 0 user-defined data type enable configuration register";
        desc = "MIPI0_USER_DEF is an MIPI 0 user-defined data type enable configuration register.

Data sheet 9.3.6 MIPI0_USER_DEF (offset 0x1104, printed page 9-170, `hi3516cv300--Hi3516CV300-Hi3516EV100-Datasheet.txt` line 37158).";

        field {
            name = "user_def3";
            desc = "User-defined data type 3 The value of this field is used for matching the type of the sensor output data. This field works with MIPI0_USERDEF_DT user_def3_dt.";
            sw = rw;
            hw = r;
            reset = 0x10;
        } user_def3[29:24];

        field {
            name = "user_def2";
            desc = "User-defined data type 2 The value of this field is used for matching the type of the sensor output data. This field works with MIPI0_USERDEF_DT user_def2_dt.";
            sw = rw;
            hw = r;
            reset = 0x36;
        } user_def2[21:16];

        field {
            name = "user_def1";
            desc = "User-defined data type 1 The value of this field is used for matching the type of the sensor output data. This field works with MIPI0_USERDEF_DT user_def1_dt.";
            sw = rw;
            hw = r;
            reset = 0x35;
        } user_def1[13:8];

        field {
            name = "user_def0";
            desc = "User-defined data type 0 The value of this field is used for matching the type of the sensor output data. This field works with MIPI0_USERDEF_DT user_def0_dt.";
            sw = rw;
            hw = r;
            reset = 0x34;
        } user_def0[5:0];
    } MIPI0_USER_DEF @ 0x1104;

    reg {
        name = "MIPI 0 operating mode enable register";
        desc = "MIPI0_CTRL_MODE_HS is an MIPI 0 operating mode enable register.

Data sheet 9.3.6 MIPI0_CTRL_MODE_HS (offset 0x1108, printed page 9-171, `hi3516cv300--Hi3516CV300-Hi3516EV100-Datasheet.txt` line 37211).";

        enum MIPI0_CTRL_MODE_HS_user_def_en_enum {
            DISABLED = 0 { name = "Disabled"; desc = "disabled"; };
            ENABLED = 1 { name = "Enabled"; desc = "enabled"; };
        };

        field {
            name = "user_def_en";
            desc = "User-defined mode enable";
            sw = rw;
            hw = r;
            encode = MIPI0_CTRL_MODE_HS_user_def_en_enum;
            reset = 0x0;
        } user_def_en[8:8];
    } MIPI0_CTRL_MODE_HS @ 0x1108;

    reg {
        name = "MIPI 0 DOL mode frame identification register 0";
        desc = "MIPI0_DOL_ID_CODE0 is the MIPI 0 DOL mode frame identification register 0.

Data sheet 9.3.6 MIPI0_DOL_ID_CODE0 (offset 0x1200, printed page 9-171, `hi3516cv300--Hi3516CV300-Hi3516EV100-Datasheet.txt` line 37241).";

        field {
            name = "id_code_reg1";
            desc = "ID of SEF1 frame N in MIPI DOL mode";
            sw = rw;
            hw = r;
            reset = 0x242;
        } id_code_reg1[31:16];

        field {
            name = "id_code_reg0";
            desc = "ID of LEF frame N in MIPI DOL mode";
            sw = rw;
            hw = r;
            reset = 0x241;
        } id_code_reg0[15:0];
    } MIPI0_DOL_ID_CODE0 @ 0x1200;

    reg {
        name = "MIPI 0 DOL mode frame identification register 1";
        desc = "MIPI0_DOL_ID_CODE1 is the MIPI 0 DOL mode frame identification register 1.

Data sheet 9.3.6 MIPI0_DOL_ID_CODE1 (offset 0x1204, printed page 9-172, `hi3516cv300--Hi3516CV300-Hi3516EV100-Datasheet.txt` line 37266).";

        field {
            name = "id_code_reg3";
            desc = "ID of LEF frame + 1 in MIPI DOL mode";
            sw = rw;
            hw = r;
            reset = 0x251;
        } id_code_reg3[31:16];

        field {
            name = "id_code_reg2";
            desc = "ID of SEF2 frame in MIPI DOL mode";
            sw = rw;
            hw = r;
            reset = 0x244;
        } id_code_reg2[15:0];
    } MIPI0_DOL_ID_CODE1 @ 0x1204;

    reg {
        name = "MIPI 0 DOL mode frame identification register 2";
        desc = "MIPI0_DOL_ID_CODE2 is the MIPI 0 DOL mode frame identification register 2.

Data sheet 9.3.6 MIPI0_DOL_ID_CODE2 (offset 0x1208, printed page 9-172, `hi3516cv300--Hi3516CV300-Hi3516EV100-Datasheet.txt` line 37286).";

        field {
            name = "id_code_reg5";
            desc = "ID of SEF2 frame N + 1 in MIPI DOL mode";
            sw = rw;
            hw = r;
            reset = 0x254;
        } id_code_reg5[31:16];

        field {
            name = "id_code_reg4";
            desc = "ID of SEF1 frame N + 1 in MIPI DOL mode";
            sw = rw;
            hw = r;
            reset = 0x252;
        } id_code_reg4[15:0];
    } MIPI0_DOL_ID_CODE2 @ 0x1208;

    reg {
        name = "MIPI0 channel 0 crop start point HN0 horizontal/vertical coordinate register";
        desc = "MIPI0_CROP_START_CHN0 is an MIPI0 channel 0 crop start point horizontal/vertical coordinate register. Hi3516C V300/Hi3516E V100 Professional HD IP Camera SoC

Data sheet 9.3.6 MIPI0_CROP_START_CHN0 (offset 0x1210, printed page 9-173, `hi3516cv300--Hi3516CV300-Hi3516EV100-Datasheet.txt` line 37316).";

        field {
            name = "mipi_start_y_chn0";
            desc = "Vertical coordinate of the crop start point of channel 0";
            sw = rw;
            hw = r;
            reset = 0x0;
        } mipi_start_y_chn0[31:16];

        field {
            name = "mipi_start_x_chn0";
            desc = "Horizontal coordinate of the crop start point of channel 0";
            sw = rw;
            hw = r;
            reset = 0x0;
        } mipi_start_x_chn0[15:0];
    } MIPI0_CROP_START_CHN0 @ 0x1210;

    reg {
        name = "MIPI0 channel 1 crop start point HN1 horizontal/vertical coordinate register";
        desc = "MIPI0_CROP_START_CHN1 is the MIPI0 channel 1 crop start point horizontal/vertical coordinate register.

Data sheet 9.3.6 MIPI0_CROP_START_CHN1 (offset 0x1214, printed page 9-173, `hi3516cv300--Hi3516CV300-Hi3516EV100-Datasheet.txt` line 37336).";

        field {
            name = "mipi_start_y_chn1";
            desc = "Vertical coordinate of the crop start point of channel 1";
            sw = rw;
            hw = r;
            reset = 0x0;
        } mipi_start_y_chn1[31:16];

        field {
            name = "mipi_start_x_chn1";
            desc = "Horizontal coordinate of the crop start point of channel 1";
            sw = rw;
            hw = r;
            reset = 0x0;
        } mipi_start_x_chn1[15:0];
    } MIPI0_CROP_START_CHN1 @ 0x1214;

    reg {
        name = "MIPI0 channel 2 crop start point HN2 horizontal/vertical coordinate register";
        desc = "MIPI0_CROP_START_CHN2 is an MIPI0 channel 2 crop start point horizontal/vertical coordinate register.

Data sheet 9.3.6 MIPI0_CROP_START_CHN2 (offset 0x1218, printed page 9-173, `hi3516cv300--Hi3516CV300-Hi3516EV100-Datasheet.txt` line 37356).";

        field {
            name = "mipi_start_y_chn2";
            desc = "Vertical coordinate of the crop start point of channel 2";
            sw = rw;
            hw = r;
            reset = 0x0;
        } mipi_start_y_chn2[31:16];

        field {
            name = "mipi_start_x_chn2";
            desc = "Horizontal coordinate of the crop start point of channel 2";
            sw = rw;
            hw = r;
            reset = 0x0;
        } mipi_start_x_chn2[15:0];
    } MIPI0_CROP_START_CHN2 @ 0x1218;

    reg {
        name = "MIPI0 channel 3 crop start point HN3 horizontal/vertical coordinate register";
        desc = "MIPI0_CROP_START_CHN3 is an MIPI0 channel 3 crop start point horizontal/vertical coordinate register.

Data sheet 9.3.6 MIPI0_CROP_START_CHN3 (offset 0x121C, printed page 9-174, `hi3516cv300--Hi3516CV300-Hi3516EV100-Datasheet.txt` line 37385).";

        field {
            name = "mipi_start_y_chn3";
            desc = "Vertical coordinate of the crop start point of channel 3";
            sw = rw;
            hw = r;
            reset = 0x0;
        } mipi_start_y_chn3[31:16];

        field {
            name = "mipi_start_x_chn3";
            desc = "Horizontal coordinate of the crop start point of channel 3";
            sw = rw;
            hw = r;
            reset = 0x0;
        } mipi_start_x_chn3[15:0];
    } MIPI0_CROP_START_CHN3 @ 0x121C;

    reg {
        name = "MIPI0 image size register";
        desc = "MIPI0_IMGSIZE is an MIPI0 image size register.

Data sheet 9.3.6 MIPI0_IMGSIZE (offset 0x1224, printed page 9-174, `hi3516cv300--Hi3516CV300-Hi3516EV100-Datasheet.txt` line 37405).";

        field {
            name = "mipi_imgheight";
            desc = "Image height. The configured value is the actual value minus 1.";
            sw = rw;
            hw = r;
            reset = 0x0;
        } mipi_imgheight[31:16];

        field {
            name = "mipi_imgwidth";
            desc = "Image width. The configured value is the actual value minus 1.";
            sw = rw;
            hw = r;
            reset = 0x0;
        } mipi_imgwidth[15:0];
    } MIPI0_IMGSIZE @ 0x1224;

    reg {
        name = "MIPI 0 output operating mode enable XEL register";
        desc = "MIPI0_CTRL_MODE_PIXEL is an MIPI 0 output operating mode enable register. Hi3516C V300/Hi3516E V100 Professional HD IP Camera SoC

Data sheet 9.3.6 MIPI0_CTRL_MODE_PIXEL (offset 0x1230, printed page 9-175, `hi3516cv300--Hi3516CV300-Hi3516EV100-Datasheet.txt` line 37434).";

        enum MIPI0_CTRL_MODE_PIXEL_stagger_frm_num_enum {
            V_2_FRAME_HDR = 1 { name = "V 2 Frame Hdr"; desc = "2-frame HDR"; };
            V_3_FRAME_HDR = 2 { name = "V 3 Frame Hdr"; desc = "3-frame HDR"; };
            V_4_FRAME_HDR = 3 { name = "V 4 Frame Hdr"; desc = "4-frame HDR Other values: reserved"; };
        };

        field {
            name = "stagger_frm_num";
            desc = "Number of frames in staggered HDR mode";
            sw = rw;
            hw = r;
            encode = MIPI0_CTRL_MODE_PIXEL_stagger_frm_num_enum;
            reset = 0x0;
        } stagger_frm_num[14:13];

        enum MIPI0_CTRL_MODE_PIXEL_stagger_hdr_mode_enum {
            DISABLED = 0 { name = "Disabled"; desc = "disabled"; };
            ENABLED = 1 { name = "Enabled"; desc = "enabled"; };
        };

        field {
            name = "stagger_hdr_mode";
            desc = "OmniVision staggered HDR mode enable";
            sw = rw;
            hw = r;
            encode = MIPI0_CTRL_MODE_PIXEL_stagger_hdr_mode_enum;
            reset = 0x0;
        } stagger_hdr_mode[12:12];

        enum MIPI0_CTRL_MODE_PIXEL_mipi_dol_mode_enum {
            DISABLED = 0 { name = "Disabled"; desc = "disabled"; };
            ENABLED = 1 { name = "Enabled"; desc = "enabled"; };
        };

        field {
            name = "mipi_dol_mode";
            desc = "MIPI DOL mode enable";
            sw = rw;
            hw = r;
            encode = MIPI0_CTRL_MODE_PIXEL_mipi_dol_mode_enum;
            reset = 0x0;
        } mipi_dol_mode[4:4];

        field {
            name = "crop_en";
            desc = "[inferred] Crop enable. (bits reserved in the data sheet; vendor header `hi3516cv300/mipi_reg.h` field `crop_en`; access and reset unknown, modelled RW)";
            sw = rw;
            hw = r;
        } crop_en[0:0];
    } MIPI0_CTRL_MODE_PIXEL @ 0x1230;

    reg {
        name = "MIPI 0 dummy line pixel value G register";
        desc = "MIPI0_DUMMY_PIX_REG is an MIPI 0 dummy line pixel value register. Hi3516C V300/Hi3516E V100 Professional HD IP Camera SoC

Data sheet 9.3.6 MIPI0_DUMMY_PIX_REG (offset 0x1240, printed page 9-176, `hi3516cv300--Hi3516CV300-Hi3516EV100-Datasheet.txt` line 37482).";

        field {
            name = "dummy_pix_reg";
            desc = "Dummy line pixel value in staggered HDR mode";
            sw = rw;
            hw = r;
            reset = 0x0;
        } dummy_pix_reg[15:0];
    } MIPI0_DUMMY_PIX_REG @ 0x1240;

    reg {
        name = "MIPI 0 VC 0 transferred image size S register";
        desc = "MIPI0_IMGSIZE0_STATIS is an MIPI 0 VC 0 transferred image size register.

Data sheet 9.3.6 MIPI0_IMGSIZE0_STATIS (offset 0x1250, printed page 9-176, `hi3516cv300--Hi3516CV300-Hi3516EV100-Datasheet.txt` line 37501).";

        field {
            name = "imgheight_statis_vc";
            desc = "Height of the previous frame of image transferred by virtual channel 0 in MIPI mode";
            sw = r;
            hw = w;
            reset = 0x0;
        } imgheight_statis_vc[31:16];

        field {
            name = "imgwidth_statis_vc";
            desc = "Width of the previous frame of image transferred by virtual channel 0 in MIPI mode";
            sw = r;
            hw = w;
            reset = 0x0;
        } imgwidth_statis_vc[15:0];
    } MIPI0_IMGSIZE0_STATIS @ 0x1250;

    reg {
        name = "MIPI 0 VC 1 transferred image size S register";
        desc = "MIPI0_IMGSIZE1_STATIS is an MIPI 0 VC 1 transferred image size register.

Data sheet 9.3.6 MIPI0_IMGSIZE1_STATIS (offset 0x1254, printed page 9-176, `hi3516cv300--Hi3516CV300-Hi3516EV100-Datasheet.txt` line 37525).";

        field {
            name = "imgheight_statis_vc1";
            desc = "Height of the previous frame of image transferred by virtual channel 1 in MIPI mode";
            sw = r;
            hw = w;
            reset = 0x0;
        } imgheight_statis_vc1[31:16];

        field {
            name = "imgwidth_statis_vc";
            desc = "Width of the previous frame of image transferred by virtual channel 1 in MIPI mode";
            sw = r;
            hw = w;
            reset = 0x0;
        } imgwidth_statis_vc[15:0];
    } MIPI0_IMGSIZE1_STATIS @ 0x1254;

    reg {
        name = "MIPI 0 VC 2 transferred image size S register";
        desc = "MIPI0_IMGSIZE2_STATIS is an MIPI 0 VC 2 transferred image size register.

Data sheet 9.3.6 MIPI0_IMGSIZE2_STATIS (offset 0x1258, printed page 9-177, `hi3516cv300--Hi3516CV300-Hi3516EV100-Datasheet.txt` line 37560).";

        field {
            name = "imgheight_statis_vc";
            desc = "Height of the previous frame of image transferred by virtual channel 2 in MIPI mode";
            sw = r;
            hw = w;
            reset = 0x0;
        } imgheight_statis_vc[31:16];

        field {
            name = "imgwidth_statis_vc";
            desc = "Width of the previous frame of image transferred by virtual channel 2 in MIPI mode";
            sw = r;
            hw = w;
            reset = 0x0;
        } imgwidth_statis_vc[15:0];
    } MIPI0_IMGSIZE2_STATIS @ 0x1258;

    reg {
        name = "MIPI 0 VC 3 transferred image size S register";
        desc = "MIPI0_IMGSIZE3_STATIS is an MIPI 0 VC 3 transferred image size register.

Data sheet 9.3.6 MIPI0_IMGSIZE3_STATIS (offset 0x125C, printed page 9-177, `hi3516cv300--Hi3516CV300-Hi3516EV100-Datasheet.txt` line 37584).";

        field {
            name = "imgheight_statis_vc";
            desc = "Height of the previous frame of image transferred by virtual channel 3 in MIPI mode";
            sw = r;
            hw = w;
            reset = 0x0;
        } imgheight_statis_vc[31:16];

        field {
            name = "imgwidth_statis_vc";
            desc = "Width of the previous frame of image transferred by virtual channel 3 in MIPI mode";
            sw = r;
            hw = w;
            reset = 0x0;
        } imgwidth_statis_vc[15:0];
    } MIPI0_IMGSIZE3_STATIS @ 0x125C;

    reg {
        name = "MIPI 0 read data error raw interrupt status register";
        desc = "MIPI0_CTRL_INT_RAW is an MIPI 0 read data error raw interrupt status register. Hi3516C V300/Hi3516E V100 Professional HD IP Camera SoC

Data sheet 9.3.6 MIPI0_CTRL_INT_RAW (offset 0x12F0, printed page 9-178, `hi3516cv300--Hi3516CV300-Hi3516EV100-Datasheet.txt` line 37618).";

        enum MIPI0_CTRL_INT_RAW_int_dfifo_rderr_raw_enum {
            NO_RAW_INTERRUPT = 0 { name = "No Raw Interrupt"; desc = "No raw interrupt is generated."; };
            RAW_INTERRUPT_GENERATED = 1 { name = "Raw Interrupt Generated"; desc = "A raw interrupt is generated."; };
        };

        field {
            name = "int_dfifo_rderr_raw";
            desc = "MIPI CTRL read data FIFO raw interrupt status";
            sw = rw;
            hw = w;
            onwrite = woclr;
            encode = MIPI0_CTRL_INT_RAW_int_dfifo_rderr_raw_enum;
            reset = 0x0;
        } int_dfifo_rderr_raw[17:17];

        enum MIPI0_CTRL_INT_RAW_int_cfifo_rderr_raw_enum {
            NO_RAW_INTERRUPT = 0 { name = "No Raw Interrupt"; desc = "No raw interrupt is generated."; };
            RAW_INTERRUPT_GENERATED = 1 { name = "Raw Interrupt Generated"; desc = "A raw interrupt is generated."; };
        };

        field {
            name = "int_cfifo_rderr_raw";
            desc = "MIPI CTRL read command FIFO raw interrupt status";
            sw = rw;
            hw = w;
            onwrite = woclr;
            encode = MIPI0_CTRL_INT_RAW_int_cfifo_rderr_raw_enum;
            reset = 0x0;
        } int_cfifo_rderr_raw[16:16];

        enum MIPI0_CTRL_INT_RAW_int_dfifo_wrerr_raw_enum {
            NO_RAW_INTERRUPT = 0 { name = "No Raw Interrupt"; desc = "No raw interrupt is generated."; };
            RAW_INTERRUPT_GENERATED = 1 { name = "Raw Interrupt Generated"; desc = "A raw interrupt is generated."; };
        };

        field {
            name = "int_dfifo_wrerr_raw";
            desc = "MIPI CTRL write data FIFO raw interrupt status";
            sw = rw;
            hw = w;
            onwrite = woclr;
            encode = MIPI0_CTRL_INT_RAW_int_dfifo_wrerr_raw_enum;
            reset = 0x0;
        } int_dfifo_wrerr_raw[1:1];

        enum MIPI0_CTRL_INT_RAW_int_cfifo_wrerr_raw_enum {
            NO_RAW_INTERRUPT = 0 { name = "No Raw Interrupt"; desc = "No raw interrupt is generated."; };
            RAW_INTERRUPT_GENERATED = 1 { name = "Raw Interrupt Generated"; desc = "A raw interrupt is generated."; };
        };

        field {
            name = "int_cfifo_wrerr_raw";
            desc = "MIPI CTRL write command FIFO raw interrupt status";
            sw = rw;
            hw = w;
            onwrite = woclr;
            encode = MIPI0_CTRL_INT_RAW_int_cfifo_wrerr_raw_enum;
            reset = 0x0;
        } int_cfifo_wrerr_raw[0:0];
    } MIPI0_CTRL_INT_RAW @ 0x12F0;

    reg {
        name = "MIPI 0 read data error interrupt status register";
        desc = "MIPI0_CTRL_INT is an MIPI 0 read data error interrupt status register. Hi3516C V300/Hi3516E V100 Professional HD IP Camera SoC

Data sheet 9.3.6 MIPI0_CTRL_INT (offset 0x12F4, printed page 9-179, `hi3516cv300--Hi3516CV300-Hi3516EV100-Datasheet.txt` line 37670).";

        enum MIPI0_CTRL_INT_int_dfifo_rderr_st_enum {
            NO_INTERRUPT_GENERATED = 0 { name = "No Interrupt Generated"; desc = "No interrupt is generated."; };
            INTERRUPT_GENERATED = 1 { name = "Interrupt Generated"; desc = "An interrupt is generated."; };
        };

        field {
            name = "int_dfifo_rderr_st";
            desc = "MIPI CTRL read data FIFO interrupt status";
            sw = r;
            hw = w;
            encode = MIPI0_CTRL_INT_int_dfifo_rderr_st_enum;
            reset = 0x0;
        } int_dfifo_rderr_st[17:17];

        enum MIPI0_CTRL_INT_int_cfifo_rderr_st_enum {
            NO_INTERRUPT_GENERATED = 0 { name = "No Interrupt Generated"; desc = "No interrupt is generated."; };
            INTERRUPT_GENERATED = 1 { name = "Interrupt Generated"; desc = "An interrupt is generated."; };
        };

        field {
            name = "int_cfifo_rderr_st";
            desc = "MIPI CTRL read command FIFO interrupt status";
            sw = r;
            hw = w;
            encode = MIPI0_CTRL_INT_int_cfifo_rderr_st_enum;
            reset = 0x0;
        } int_cfifo_rderr_st[16:16];

        enum MIPI0_CTRL_INT_int_dfifo_wrerr_st_enum {
            NO_INTERRUPT_GENERATED = 0 { name = "No Interrupt Generated"; desc = "No interrupt is generated."; };
            INTERRUPT_GENERATED = 1 { name = "Interrupt Generated"; desc = "An interrupt is generated."; };
        };

        field {
            name = "int_dfifo_wrerr_st";
            desc = "MIPI CTRL write data FIFO interrupt status";
            sw = r;
            hw = w;
            encode = MIPI0_CTRL_INT_int_dfifo_wrerr_st_enum;
            reset = 0x0;
        } int_dfifo_wrerr_st[1:1];

        enum MIPI0_CTRL_INT_int_cfifo_wrerr_st_enum {
            NO_INTERRUPT_GENERATED = 0 { name = "No Interrupt Generated"; desc = "No interrupt is generated."; };
            INTERRUPT_GENERATED = 1 { name = "Interrupt Generated"; desc = "An interrupt is generated."; };
        };

        field {
            name = "int_cfifo_wrerr_st";
            desc = "MIPI CTRL write command FIFO interrupt status";
            sw = r;
            hw = w;
            encode = MIPI0_CTRL_INT_int_cfifo_wrerr_st_enum;
            reset = 0x0;
        } int_cfifo_wrerr_st[0:0];
    } MIPI0_CTRL_INT @ 0x12F4;

    reg {
        name = "MIPI 0 read data error interrupt mask register";
        desc = "MIPI0_CTRL_INT_MSK is an MIPI 0 read data error interrupt mask register. Hi3516C V300/Hi3516E V100 Professional HD IP Camera SoC

Data sheet 9.3.6 MIPI0_CTRL_INT_MSK (offset 0x12F8, printed page 9-180, `hi3516cv300--Hi3516CV300-Hi3516EV100-Datasheet.txt` line 37719).";

        enum MIPI0_CTRL_INT_MSK_int_dfifo_rderr_msk_enum {
            MASKED = 0 { name = "Masked"; desc = "masked"; };
            ENABLED = 1 { name = "Enabled"; desc = "enabled"; };
        };

        field {
            name = "int_dfifo_rderr_msk";
            desc = "MIPI CTRL read data FIFO interrupt enable";
            sw = rw;
            hw = r;
            encode = MIPI0_CTRL_INT_MSK_int_dfifo_rderr_msk_enum;
            reset = 0x0;
        } int_dfifo_rderr_msk[17:17];

        enum MIPI0_CTRL_INT_MSK_int_cfifo_rderr_msk_enum {
            MASKED = 0 { name = "Masked"; desc = "masked"; };
            ENABLED = 1 { name = "Enabled"; desc = "enabled"; };
        };

        field {
            name = "int_cfifo_rderr_msk";
            desc = "MIPI CTRL read command FIFO interrupt enable";
            sw = rw;
            hw = r;
            encode = MIPI0_CTRL_INT_MSK_int_cfifo_rderr_msk_enum;
            reset = 0x0;
        } int_cfifo_rderr_msk[16:16];

        enum MIPI0_CTRL_INT_MSK_int_dfifo_wrerr_msk_enum {
            MASKED = 0 { name = "Masked"; desc = "masked"; };
            ENABLED = 1 { name = "Enabled"; desc = "enabled"; };
        };

        field {
            name = "int_dfifo_wrerr_msk";
            desc = "MIPI CTRL write data FIFO interrupt enable";
            sw = rw;
            hw = r;
            encode = MIPI0_CTRL_INT_MSK_int_dfifo_wrerr_msk_enum;
            reset = 0x0;
        } int_dfifo_wrerr_msk[1:1];

        enum MIPI0_CTRL_INT_MSK_int_cfifo_wrerr_msk_enum {
            MASKED = 0 { name = "Masked"; desc = "masked"; };
            ENABLED = 1 { name = "Enabled"; desc = "enabled"; };
        };

        field {
            name = "int_cfifo_wrerr_msk";
            desc = "MIPI CTRL write command FIFO interrupt enable";
            sw = rw;
            hw = r;
            encode = MIPI0_CTRL_INT_MSK_int_cfifo_wrerr_msk_enum;
            reset = 0x0;
        } int_cfifo_wrerr_msk[0:0];
    } MIPI0_CTRL_INT_MSK @ 0x12F8;

    reg {
        name = "LVDS WDR control register";
        desc = "LVDS0_WDR is an LVDS WDR control register. Hi3516C V300/Hi3516E V100 Professional HD IP Camera SoC

Data sheet 9.3.6 LVDS0_WDR (offset 0x1300, printed page 9-181, `hi3516cv300--Hi3516CV300-Hi3516EV100-Datasheet.txt` line 37775).";

        field {
            name = "lvds_wdr_id_shift";
            desc = "IMX136 frame ID shift register, indicating the number of bits to be shifted rightwards to make the frame ID be in bit 0";
            sw = rw;
            hw = r;
            reset = 0x0;
        } lvds_wdr_id_shift[15:12];

        enum LVDS0_WDR_lvds_wdr_mode_enum {
            WDR_MODE_WITH = 0 { name = "Wdr Mode With"; desc = "WDR mode with the SOF-EOF flag. In this mode, the long exposure frame and short exposure frame have independent synchronization codes."; };
            HISPI_WDR_MODE = 2 { name = "Hispi Wdr Mode"; desc = "HiSPI WDR mode. In this mode, the long and short exposure frames share one SOF-EOF flag, and the first several lines of the short exposure frame are stuffed with 0x04."; };
            SONY_DOL_WDR = 4 { name = "Sony Dol Wdr"; desc = "SONY DOL WDR mode. In this mode, the synchronization code consists of four fields, the SAV-EAV flag is used, and the long exposure frame and short exposure frame have independent synchronization codes."; };
            SONY_DOL_MODE = 5 { name = "Sony Dol Mode"; desc = "SONY DOL mode. In this mode, the synchronization code consists of four fields. The SAV-EAV flag mode is used. The long and short exposure frames share a group of sync code, and the region between the long and short exposure frames is the blanking region."; };
            SONY_DOL_WDR_2 = 6 { name = "Sony Dol Wdr 2"; desc = "SONY DOL WDR mode. In this mode, the synchronization code consists of five fields, and the fifth field indicates the long or short frame."; };
            SONY_IMX136_MODE = 8 { name = "Sony Imx136 Mode"; desc = "SONY IMX136 mode, frame WDR mode. Do not enable WDR_EN."; };
            SHARP_LONG_SHORT = 9 { name = "Sharp Long Short"; desc = "SHARP long and short exposure frame interleaving mode. The long exposure frame is before the short exposure frame."; };
            SHARP_LONG_SHORT_2 = 10 { name = "Sharp Long Short 2"; desc = "SHARP long and short exposure frame interleaving mode. The short exposure frame is before the long exposure frame."; };
        };

        field {
            name = "lvds_wdr_mode";
            desc = "LVDS WDR mode select";
            sw = rw;
            hw = r;
            encode = LVDS0_WDR_lvds_wdr_mode_enum;
            reset = 0x0;
        } lvds_wdr_mode[11:8];

        enum LVDS0_WDR_lvds_wdr_num_enum {
            RESERVED = 0 { name = "Reserved"; desc = "reserved"; };
            V_2_FRAME_WDR = 1 { name = "V 2 Frame Wdr"; desc = "2-frame WDR"; };
            V_3_FRAME_WDR = 2 { name = "V 3 Frame Wdr"; desc = "3-frame WDR"; };
            V_4_FRAME_WDR = 3 { name = "V 4 Frame Wdr"; desc = "4-frame WDR"; };
        };

        field {
            name = "lvds_wdr_num";
            desc = "WDR mode configuration";
            sw = rw;
            hw = r;
            encode = LVDS0_WDR_lvds_wdr_num_enum;
            reset = 0x0;
        } lvds_wdr_num[5:4];

        enum LVDS0_WDR_lvds_wdr_en_enum {
            LINEAR_MODE = 0 { name = "Linear Mode"; desc = "linear mode"; };
            WDR_MODE = 1 { name = "Wdr Mode"; desc = "WDR mode"; };
        };

        field {
            name = "lvds_wdr_en";
            desc = "WDR enable";
            sw = rw;
            hw = r;
            encode = LVDS0_WDR_lvds_wdr_en_enum;
            reset = 0x0;
        } lvds_wdr_en[0:0];
    } LVDS0_WDR @ 0x1300;

    reg {
        name = "LVDS control register";
        desc = "LVDS0_CTRL is an LVDS control register.

Data sheet 9.3.6 LVDS0_CTRL (offset 0x1304, printed page 9-182, `hi3516cv300--Hi3516CV300-Hi3516EV100-Datasheet.txt` line 37851).";

        enum LVDS0_CTRL_lvds_split_mode_enum {
            PER_LANE_MODE = 0 { name = "Per Lane Mode"; desc = "Per lane mode"; };
            SPLIT_2_LANE = 3 { name = "Split 2 Lane"; desc = "Split 2 lane mode"; };
            SPLIT_4_LANE = 7 { name = "Split 4 Lane"; desc = "Split 4 lane mode Other values: reserved"; };
        };

        field {
            name = "lvds_split_mode";
            desc = "LVDS/HiSPI sync code transfer type";
            sw = rw;
            hw = r;
            encode = LVDS0_CTRL_lvds_split_mode_enum;
            reset = 0x0;
        } lvds_split_mode[18:16];

        enum LVDS0_CTRL_lvds_crop_en_enum {
            DISABLED = 0 { name = "Disabled"; desc = "disabled"; };
            ENABLED = 1 { name = "Enabled"; desc = "enabled"; };
        };

        field {
            name = "lvds_crop_en";
            desc = "Image cropping enable in LVDS or HiSPi mode";
            sw = rw;
            hw = r;
            encode = LVDS0_CTRL_lvds_crop_en_enum;
            reset = 0x0;
        } lvds_crop_en[12:12];

        enum LVDS0_CTRL_lvds_code_big_endian_enum {
            LSB_LOWER_BITS = 0 { name = "Lsb Lower Bits"; desc = "LSB. Lower bits are transferred first. The sequence of the received sync code (sync_code) serial data is bit 0, bit 1, ..., and bit 11."; };
            MSB_UPPER_BITS = 1 { name = "Msb Upper Bits"; desc = "MSB. Upper bits are transferred first. The sequence of the received sync code (sync_code) serial data is bit 11, bit 10, ..., and bit 0."; };
        };

        field {
            name = "lvds_code_big_endian";
            desc = "Transfer sequence of serial bits of transferred RAW data sync code (sync_code) in LVDS/HiSPI mode";
            sw = rw;
            hw = r;
            encode = LVDS0_CTRL_lvds_code_big_endian_enum;
            reset = 0x1;
        } lvds_code_big_endian[9:9];

        enum LVDS0_CTRL_lvds_pix_big_endian_enum {
            LSB_LOWER_BITS = 0 { name = "Lsb Lower Bits"; desc = "LSB. Lower bits are transferred first. The sequence of the received valid pixel serial data is bit 0, bit 1, ..., and bit 11."; };
            MSB_UPPER_BITS = 1 { name = "Msb Upper Bits"; desc = "MSB. Upper bits are transferred first. The sequence of the received valid pixel serial data is bit 11, bit 10, ..., and bit 0."; };
        };

        field {
            name = "lvds_pix_big_endian";
            desc = "Transfer sequence of serial bits of transferred RAW data valid pixels in LVDS/HiSPI mode";
            sw = rw;
            hw = r;
            encode = LVDS0_CTRL_lvds_pix_big_endian_enum;
            reset = 0x1;
        } lvds_pix_big_endian[8:8];

        enum LVDS0_CTRL_lvds_raw_type_enum {
            RAW_8_BIT = 1 { name = "Raw 8 Bit"; desc = "Raw 8-bit"; };
            RAW_10_BIT = 2 { name = "Raw 10 Bit"; desc = "Raw 10-bit"; };
            RAW_12_BIT = 3 { name = "Raw 12 Bit"; desc = "Raw 12-bit"; };
            RAW_14_BIT = 4 { name = "Raw 14 Bit"; desc = "Raw 14-bit"; };
            RAW_16_BIT = 5 { name = "Raw 16 Bit"; desc = "Raw 16-bit"; };
        };

        field {
            name = "lvds_raw_type";
            desc = "Type of transferred RAW data in LVDS/HiSPI mode";
            sw = rw;
            hw = r;
            encode = LVDS0_CTRL_lvds_raw_type_enum;
            reset = 0x1;
        } lvds_raw_type[6:4];

        enum LVDS0_CTRL_lvds_sync_mode_enum {
            SYNC_MODE_SOF = 0 { name = "Sync Mode Sof"; desc = "The sync mode is SOF/EOF/SOL/EOL mode. SOF indicates the start of the first line of the valid region, EOF indicates the end of the last line of the valid region, and SOL and EOL indicate the start and end of other valid regions respectively."; };
            SYNC_MODE_SAV = 1 { name = "Sync Mode Sav"; desc = "The sync mode is SAV/EAV mode. SAV(Invalid) and EAV(Invalid) indicate the invalid data of the blanking region, and SAV(Valid) and EAV(Valid) indicate pixel data of the valid region."; };
        };

        field {
            name = "lvds_sync_mode";
            desc = "Frame/Line sync mode in LVDS mode";
            sw = rw;
            hw = r;
            encode = LVDS0_CTRL_lvds_sync_mode_enum;
            reset = 0x0;
        } lvds_sync_mode[0:0];
    } LVDS0_CTRL @ 0x1304;

    reg {
        name = "LVDS SCD control register";
        desc = "LVDS0_DOLSCD_HBLK is an LVDS SCD control register. Hi3516C V300/Hi3516E V100 Professional HD IP Camera SoC

Data sheet 9.3.6 LVDS0_DOLSCD_HBLK (offset 0x1308, printed page 9-184, `hi3516cv300--Hi3516CV300-Hi3516EV100-Datasheet.txt` line 37942).";

        field {
            name = "dol_hblank2";
            desc = "Value of HBLANK2 in DOL mode";
            sw = rw;
            hw = r;
            reset = 0x0;
        } dol_hblank2[31:16];

        field {
            name = "dol_hblank1";
            desc = "Value of HBLANK1 in DOL mode";
            sw = rw;
            hw = r;
            reset = 0x0;
        } dol_hblank1[15:0];
    } LVDS0_DOLSCD_HBLK @ 0x1308;

    reg {
        name = "LVDS image size register";
        desc = "LVDS0_IMGSIZE is an LVDS image size register.

Data sheet 9.3.6 LVDS0_IMGSIZE (offset 0x130C, printed page 9-184, `hi3516cv300--Hi3516CV300-Hi3516EV100-Datasheet.txt` line 37961).";

        field {
            name = "lvds_imgheight";
            desc = "Image height minus 1";
            sw = rw;
            hw = r;
            reset = 0x0;
        } lvds_imgheight[31:16];

        field {
            name = "lvds_imgwidth_lane";
            desc = "Width of the image transferred by each channel minus 1";
            sw = rw;
            hw = r;
            reset = 0x0;
        } lvds_imgwidth_lane[15:0];
    } LVDS0_IMGSIZE @ 0x130C;

    reg {
        name = "LVDS first frame cropping register";
        desc = "LVDS0_CROP_START0 is an LVDS first frame cropping register.

Data sheet 9.3.6 LVDS0_CROP_START0 (offset 0x1310, printed page 9-184, `hi3516cv300--Hi3516CV300-Hi3516EV100-Datasheet.txt` line 37983).";

        field {
            name = "lvds_start_y0";
            desc = "Height of the cropping start point for the first frame";
            sw = rw;
            hw = r;
            reset = 0x0;
        } lvds_start_y0[31:16];

        field {
            name = "lvds_start_x0_lane";
            desc = "lvds_start_x0_lane";
            sw = rw;
            hw = r;
            reset = 0x0;
        } lvds_start_x0_lane[15:0];
    } LVDS0_CROP_START0 @ 0x1310;

    reg {
        name = "LVDS second frame cropping register";
        desc = "LVDS0_CROP_START1 is an LVDS second frame cropping register.

Data sheet 9.3.6 LVDS0_CROP_START1 (offset 0x1314, printed page 9-185, `hi3516cv300--Hi3516CV300-Hi3516EV100-Datasheet.txt` line 38026).";

        field {
            name = "lvds_start_y1";
            desc = "Height of the cropping start point for the second frame";
            sw = rw;
            hw = r;
            reset = 0x0;
        } lvds_start_y1[31:16];

        field {
            name = "lvds_start_x1_lane";
            desc = "Width of the cropping start point for the second frame. The configured value is the start pixel to be cropped divided by the number of channels.";
            sw = rw;
            hw = r;
            reset = 0x0;
        } lvds_start_x1_lane[15:0];
    } LVDS0_CROP_START1 @ 0x1314;

    reg {
        name = "LVDS third frame cropping register";
        desc = "LVDS0_CROP_START2 is an LVDS third frame cropping register.

Data sheet 9.3.6 LVDS0_CROP_START2 (offset 0x1318, printed page 9-185, `hi3516cv300--Hi3516CV300-Hi3516EV100-Datasheet.txt` line 38047).";

        field {
            name = "lvds_start_y2";
            desc = "Height of the cropping start point for the third frame";
            sw = rw;
            hw = r;
            reset = 0x0;
        } lvds_start_y2[31:16];

        field {
            name = "lvds_start_x2_lane";
            desc = "lvds_start_x2_lane";
            sw = rw;
            hw = r;
            reset = 0x0;
        } lvds_start_x2_lane[15:0];
    } LVDS0_CROP_START2 @ 0x1318;

    reg {
        name = "LVDS fourth frame cropping register";
        desc = "LVDS0_CROP_START3 is an LVDS fourth frame cropping register.

Data sheet 9.3.6 LVDS0_CROP_START3 (offset 0x131C, printed page 9-186, `hi3516cv300--Hi3516CV300-Hi3516EV100-Datasheet.txt` line 38089).";

        field {
            name = "lvds_start_y3";
            desc = "Height of the cropping start point for the fourth frame";
            sw = rw;
            hw = r;
            reset = 0x0;
        } lvds_start_y3[31:16];

        field {
            name = "lvds_start_x3_lane";
            desc = "Width of the cropping start point for the fourth frame. The configured value is the start pixel to be cropped divided by the number of channels.";
            sw = rw;
            hw = r;
            reset = 0x0;
        } lvds_start_x3_lane[15:0];
    } LVDS0_CROP_START3 @ 0x131C;

    reg {
        name = "Lane 0 SOF synchronization code configuration register in LVDS or HiSPI mode";
        desc = "LVDS0_LANE0_SOF_01 is a lane 0 SOF synchronization code configuration register in LVDS or HiSPI mode. Hi3516C V300/Hi3516E V100 Professional HD IP Camera SoC

Data sheet 9.3.6 LVDS0_LANE0_SOF_01 (offset 0x1320, printed page 9-187, `hi3516cv300--Hi3516CV300-Hi3516EV100-Datasheet.txt` line 38121).";

        field {
            name = "lane0_sof_1";
            desc = "Lane 0 SOF synchronization code of frame 1 in LVDS or HiSPI mode This field is configurable only in WDR mode, and the configuration is invalid in linear mode.";
            sw = rw;
            hw = r;
            reset = 0x0;
        } lane0_sof_1[31:16];

        field {
            name = "lane0_sof_0";
            desc = "Lane 0 SOF synchronization code of frame 0 in LVDS or HiSPI mode In WDR mode, the value is the SOF of frame 0. In linear mode, the value is the SOF.";
            sw = rw;
            hw = r;
            reset = 0x0;
        } lane0_sof_0[15:0];
    } LVDS0_LANE0_SOF_01 @ 0x1320;

    reg {
        name = "Lane 0 SOF synchronization code configuration register in LVDS or HiSPI mode";
        desc = "LVDS0_LANE0_SOF_23 is a lane 0 SOF synchronization code configuration register in LVDS or HiSPI mode.

Data sheet 9.3.6 LVDS0_LANE0_SOF_23 (offset 0x1324, printed page 9-187, `hi3516cv300--Hi3516CV300-Hi3516EV100-Datasheet.txt` line 38149).";

        field {
            name = "lane0_sof_3";
            desc = "Lane 0 SOF synchronization code of frame 3 in LVDS or HiSPI mode This field is configurable only in WDR mode, and the configuration is invalid in linear mode.";
            sw = rw;
            hw = r;
            reset = 0x0;
        } lane0_sof_3[31:16];

        field {
            name = "lane0_sof_2";
            desc = "Lane 0 SOF synchronization code of frame 2 in LVDS or HiSPI mode This field is configurable only in WDR mode, and the configuration is invalid in linear mode.";
            sw = rw;
            hw = r;
            reset = 0x0;
        } lane0_sof_2[15:0];
    } LVDS0_LANE0_SOF_23 @ 0x1324;

    reg {
        name = "Lane 0 EOF synchronization code configuration register in LVDS or HiSPI mode";
        desc = "LVDS0_LANE0_EOF_01 is a lane 0 EOF synchronization code configuration register in LVDS or HiSPI mode. Hi3516C V300/Hi3516E V100 Professional HD IP Camera SoC

Data sheet 9.3.6 LVDS0_LANE0_EOF_01 (offset 0x1328, printed page 9-188, `hi3516cv300--Hi3516CV300-Hi3516EV100-Datasheet.txt` line 38186).";

        field {
            name = "lane0_eof_1";
            desc = "Lane 0 EOF synchronization code of frame 1 in LVDS or HiSPI mode This field is configurable only in WDR mode, and the configuration is invalid in linear mode.";
            sw = rw;
            hw = r;
            reset = 0x0;
        } lane0_eof_1[31:16];

        field {
            name = "lane0_eof_0";
            desc = "Lane 0 EOF synchronization code of frame 0 in LVDS or HiSPI mode In WDR mode, the value is the EOF of frame 0. In linear mode, the value is the EOF.";
            sw = rw;
            hw = r;
            reset = 0x0;
        } lane0_eof_0[15:0];
    } LVDS0_LANE0_EOF_01 @ 0x1328;

    reg {
        name = "Lane 0 EOF synchronization code configuration register in LVDS or HiSPI mode";
        desc = "LVDS0_LANE0_EOF_23 is a lane 0 EOF synchronization code configuration register in LVDS or HiSPI mode.

Data sheet 9.3.6 LVDS0_LANE0_EOF_23 (offset 0x132C, printed page 9-188, `hi3516cv300--Hi3516CV300-Hi3516EV100-Datasheet.txt` line 38214).";

        field {
            name = "lane0_eof_3";
            desc = "Lane 0 EOF synchronization code of frame 3 in LVDS or HiSPI mode This field is configurable only in WDR mode, and the configuration is invalid in linear mode.";
            sw = rw;
            hw = r;
            reset = 0x0;
        } lane0_eof_3[31:16];

        field {
            name = "lane0_eof_2";
            desc = "Lane 0 EOF synchronization code of frame 2 in LVDS or HiSPI mode This field is configurable only in WDR mode, and the configuration is invalid in linear mode.";
            sw = rw;
            hw = r;
            reset = 0x0;
        } lane0_eof_2[15:0];
    } LVDS0_LANE0_EOF_23 @ 0x132C;

    reg {
        name = "Lane 0 SOL synchronization code configuration register in LVDS or HiSPI mode";
        desc = "LVDS0_LANE0_SOL_01 is a lane 0 SOL synchronization code configuration register in LVDS or HiSPI mode. Hi3516C V300/Hi3516E V100 Professional HD IP Camera SoC

Data sheet 9.3.6 LVDS0_LANE0_SOL_01 (offset 0x1330, printed page 9-189, `hi3516cv300--Hi3516CV300-Hi3516EV100-Datasheet.txt` line 38251).";

        field {
            name = "lane0_sol_1";
            desc = "Lane 0 SOL synchronization code of frame 1 in LVDS or HiSPI mode This field is configurable only in WDR mode, and the configuration is invalid in linear mode.";
            sw = rw;
            hw = r;
            reset = 0x0;
        } lane0_sol_1[31:16];

        field {
            name = "lane0_sol_0";
            desc = "Lane 0 SOL synchronization code of frame 0 in LVDS or HiSPI mode In WDR mode, the value is the SOL of frame 0. In linear mode, the value is the SOL.";
            sw = rw;
            hw = r;
            reset = 0x0;
        } lane0_sol_0[15:0];
    } LVDS0_LANE0_SOL_01 @ 0x1330;

    reg {
        name = "Lane 0 SOL synchronization code configuration register in LVDS or HiSPI mode";
        desc = "LVDS0_LANE0_SOL_23 is a lane 0 SOL synchronization code configuration register in LVDS or HiSPI mode.

Data sheet 9.3.6 LVDS0_LANE0_SOL_23 (offset 0x1334, printed page 9-189, `hi3516cv300--Hi3516CV300-Hi3516EV100-Datasheet.txt` line 38279).";

        field {
            name = "lane0_sol_3";
            desc = "Lane 0 SOL synchronization code of frame 3 in LVDS or HiSPI mode This field is configurable only in WDR mode, and the configuration is invalid in linear mode.";
            sw = rw;
            hw = r;
            reset = 0x0;
        } lane0_sol_3[31:16];

        field {
            name = "lane0_sol_2";
            desc = "Lane 0 SOL synchronization code of frame 2 in LVDS or HiSPI mode This field is configurable only in WDR mode, and the configuration is invalid in linear mode.";
            sw = rw;
            hw = r;
            reset = 0x0;
        } lane0_sol_2[15:0];
    } LVDS0_LANE0_SOL_23 @ 0x1334;

    reg {
        name = "Lane 0 EOL synchronization code configuration register in LVDS or HiSPI mode";
        desc = "LVDS0_LANE0_EOL_01 is a lane 0 EOL synchronization code configuration register in LVDS or HiSPI mode. Hi3516C V300/Hi3516E V100 Professional HD IP Camera SoC

Data sheet 9.3.6 LVDS0_LANE0_EOL_01 (offset 0x1338, printed page 9-190, `hi3516cv300--Hi3516CV300-Hi3516EV100-Datasheet.txt` line 38316).";

        field {
            name = "lane0_eol_1";
            desc = "Lane 0 EOL synchronization code of frame 1 in LVDS or HiSPI mode This field is configurable only in WDR mode, and the configuration is invalid in linear mode.";
            sw = rw;
            hw = r;
            reset = 0x0;
        } lane0_eol_1[31:16];

        field {
            name = "lane0_eol_0";
            desc = "Lane 0 EOL synchronization code of frame 0 in LVDS or HiSPI mode In WDR mode, the value is the EOL of frame 0. In linear mode, the value is the EOL.";
            sw = rw;
            hw = r;
            reset = 0x0;
        } lane0_eol_0[15:0];
    } LVDS0_LANE0_EOL_01 @ 0x1338;

    reg {
        name = "Lane 0 EOL synchronization code configuration register in LVDS or HiSPI mode";
        desc = "LVDS0_LANE0_EOL_23 is a lane 0 EOL synchronization code configuration register in LVDS or HiSPI mode.

Data sheet 9.3.6 LVDS0_LANE0_EOL_23 (offset 0x133C, printed page 9-190, `hi3516cv300--Hi3516CV300-Hi3516EV100-Datasheet.txt` line 38344).";

        field {
            name = "lane0_eol_3";
            desc = "Lane 0 EOL synchronization code of frame 3 in LVDS or HiSPI mode This field is configurable only in WDR mode, and the configuration is invalid in linear mode.";
            sw = rw;
            hw = r;
            reset = 0x0;
        } lane0_eol_3[31:16];

        field {
            name = "lane0_eol_2";
            desc = "Lane 0 EOL synchronization code of frame 2 in LVDS or HiSPI mode This field is configurable only in WDR mode, and the configuration is invalid in linear mode.";
            sw = rw;
            hw = r;
            reset = 0x0;
        } lane0_eol_2[15:0];
    } LVDS0_LANE0_EOL_23 @ 0x133C;

    reg {
        name = "Lane 1 SOF synchronization code configuration register in LVDS or HiSPI mode";
        desc = "LVDS0_LANE1_SOF_01 is a lane 1 SOF synchronization code configuration register in LVDS or HiSPI mode. Hi3516C V300/Hi3516E V100 Professional HD IP Camera SoC

Data sheet 9.3.6 LVDS0_LANE1_SOF_01 (offset 0x1340, printed page 9-191, `hi3516cv300--Hi3516CV300-Hi3516EV100-Datasheet.txt` line 38381).";

        field {
            name = "lane1_sof_1";
            desc = "Lane 1 SOF synchronization code of frame 1 in LVDS or HiSPI mode This field is configurable only in WDR mode, and the configuration is invalid in linear mode.";
            sw = rw;
            hw = r;
            reset = 0x0;
        } lane1_sof_1[31:16];

        field {
            name = "lane1_sof_0";
            desc = "Lane 1 SOF synchronization code of frame 0 in LVDS or HiSPI mode In WDR mode, the value is the SOF of frame 0. In linear mode, the value is the SOF.";
            sw = rw;
            hw = r;
            reset = 0x0;
        } lane1_sof_0[15:0];
    } LVDS0_LANE1_SOF_01 @ 0x1340;

    reg {
        name = "Lane 1 SOF synchronization code configuration register in LVDS or HiSPI mode";
        desc = "LVDS0_LANE1_SOF_23 is a lane 1 SOF synchronization code configuration register in LVDS or HiSPI mode.

Data sheet 9.3.6 LVDS0_LANE1_SOF_23 (offset 0x1344, printed page 9-191, `hi3516cv300--Hi3516CV300-Hi3516EV100-Datasheet.txt` line 38409).";

        field {
            name = "lane1_sof_3";
            desc = "Lane 1 SOF synchronization code of frame 3 in LVDS or HiSPI mode This field is configurable only in WDR mode, and the configuration is invalid in linear mode.";
            sw = rw;
            hw = r;
            reset = 0x0;
        } lane1_sof_3[31:16];

        field {
            name = "lane1_sof_2";
            desc = "Lane 1 SOF synchronization code of frame 2 in LVDS or HiSPI mode This field is configurable only in WDR mode, and the configuration is invalid in linear mode.";
            sw = rw;
            hw = r;
            reset = 0x0;
        } lane1_sof_2[15:0];
    } LVDS0_LANE1_SOF_23 @ 0x1344;

    reg {
        name = "Lane 1 EOF synchronization code configuration register in LVDS or HiSPI mode";
        desc = "LVDS0_LANE1_EOF_01 is a lane 1 EOF synchronization code configuration register in LVDS or HiSPI mode. Hi3516C V300/Hi3516E V100 Professional HD IP Camera SoC

Data sheet 9.3.6 LVDS0_LANE1_EOF_01 (offset 0x1348, printed page 9-192, `hi3516cv300--Hi3516CV300-Hi3516EV100-Datasheet.txt` line 38446).";

        field {
            name = "lane1_eof_1";
            desc = "Lane 1 EOF synchronization code of frame 1 in LVDS or HiSPI mode This field is configurable only in WDR mode, and the configuration is invalid in linear mode.";
            sw = rw;
            hw = r;
            reset = 0x0;
        } lane1_eof_1[31:16];

        field {
            name = "lane1_eof_0";
            desc = "Lane 1 EOF synchronization code of frame 0 in LVDS or HiSPI mode In WDR mode, the value is the EOF of frame 0. In linear mode, the value is the EOF.";
            sw = rw;
            hw = r;
            reset = 0x0;
        } lane1_eof_0[15:0];
    } LVDS0_LANE1_EOF_01 @ 0x1348;

    reg {
        name = "Lane 1 EOF synchronization code configuration register in LVDS or HiSPI mode";
        desc = "LVDS0_LANE1_EOF_23 is a lane 1 EOF synchronization code configuration register in LVDS or HiSPI mode.

Data sheet 9.3.6 LVDS0_LANE1_EOF_23 (offset 0x134C, printed page 9-192, `hi3516cv300--Hi3516CV300-Hi3516EV100-Datasheet.txt` line 38474).";

        field {
            name = "lane1_eof_3";
            desc = "Lane 1 EOF synchronization code of frame 3 in LVDS or HiSPI mode This field is configurable only in WDR mode, and the configuration is invalid in linear mode.";
            sw = rw;
            hw = r;
            reset = 0x0;
        } lane1_eof_3[31:16];

        field {
            name = "lane1_eof_2";
            desc = "Lane 1 EOF synchronization code of frame 2 in LVDS or HiSPI mode This field is configurable only in WDR mode, and the configuration is invalid in linear mode.";
            sw = rw;
            hw = r;
            reset = 0x0;
        } lane1_eof_2[15:0];
    } LVDS0_LANE1_EOF_23 @ 0x134C;

    reg {
        name = "Lane 1 SOL synchronization code configuration register in LVDS or HiSPI mode";
        desc = "LVDS0_LANE1_SOL_01 is a lane 1 SOL synchronization code configuration register in LVDS or HiSPI mode. Hi3516C V300/Hi3516E V100 Professional HD IP Camera SoC

Data sheet 9.3.6 LVDS0_LANE1_SOL_01 (offset 0x1350, printed page 9-193, `hi3516cv300--Hi3516CV300-Hi3516EV100-Datasheet.txt` line 38511).";

        field {
            name = "lane1_sol_1";
            desc = "Lane 1 SOL synchronization code of frame 1 in LVDS or HiSPI mode This field is configurable only in WDR mode, and the configuration is invalid in linear mode.";
            sw = rw;
            hw = r;
            reset = 0x0;
        } lane1_sol_1[31:16];

        field {
            name = "lane1_sol_0";
            desc = "Lane 1 SOL synchronization code of frame 0 in LVDS or HiSPI mode In WDR mode, the value is the SOL of frame 0. In linear mode, the value is the SOL.";
            sw = rw;
            hw = r;
            reset = 0x0;
        } lane1_sol_0[15:0];
    } LVDS0_LANE1_SOL_01 @ 0x1350;

    reg {
        name = "Lane 1 SOL synchronization code configuration register in LVDS or HiSPI mode";
        desc = "LVDS0_LANE1_SOL_23 is a lane 1 SOL synchronization code configuration register in LVDS or HiSPI mode.

Data sheet 9.3.6 LVDS0_LANE1_SOL_23 (offset 0x1354, printed page 9-193, `hi3516cv300--Hi3516CV300-Hi3516EV100-Datasheet.txt` line 38539).";

        field {
            name = "lane1_sol_3";
            desc = "Lane 1 SOL synchronization code of frame 3 in LVDS or HiSPI mode This field is configurable only in WDR mode, and the configuration is invalid in linear mode.";
            sw = rw;
            hw = r;
            reset = 0x0;
        } lane1_sol_3[31:16];

        field {
            name = "lane1_sol_2";
            desc = "Lane 1 SOL synchronization code of frame 2 in LVDS or HiSPI mode This field is configurable only in WDR mode, and the configuration is invalid in linear mode.";
            sw = rw;
            hw = r;
            reset = 0x0;
        } lane1_sol_2[15:0];
    } LVDS0_LANE1_SOL_23 @ 0x1354;

    reg {
        name = "Lane 1 EOL synchronization code configuration register in LVDS or HiSPI mode";
        desc = "LVDS0_LANE1_EOL_01 is a lane 1 EOL synchronization code configuration register in LVDS or HiSPI mode. Hi3516C V300/Hi3516E V100 Professional HD IP Camera SoC

Data sheet 9.3.6 LVDS0_LANE1_EOL_01 (offset 0x1358, printed page 9-194, `hi3516cv300--Hi3516CV300-Hi3516EV100-Datasheet.txt` line 38576).";

        field {
            name = "lane1_eol_1";
            desc = "Lane 1 EOL synchronization code of frame 1 in LVDS or HiSPI mode This field is configurable only in WDR mode, and the configuration is invalid in linear mode.";
            sw = rw;
            hw = r;
            reset = 0x0;
        } lane1_eol_1[31:16];

        field {
            name = "lane1_eol_0";
            desc = "Lane 1 EOL synchronization code of frame 0 in LVDS or HiSPI mode In WDR mode, the value is the EOL of frame 0. In linear mode, the value is the EOL.";
            sw = rw;
            hw = r;
            reset = 0x0;
        } lane1_eol_0[15:0];
    } LVDS0_LANE1_EOL_01 @ 0x1358;

    reg {
        name = "Lane 1 EOL synchronization code configuration register in LVDS or HiSPI mode";
        desc = "LVDS0_LANE1_EOL_23 is a lane 1 EOL synchronization code configuration register in LVDS or HiSPI mode.

Data sheet 9.3.6 LVDS0_LANE1_EOL_23 (offset 0x135C, printed page 9-194, `hi3516cv300--Hi3516CV300-Hi3516EV100-Datasheet.txt` line 38604).";

        field {
            name = "lane1_eol_3";
            desc = "Lane 1 EOL synchronization code of frame 3 in LVDS or HiSPI mode This field is configurable only in WDR mode, and the configuration is invalid in linear mode.";
            sw = rw;
            hw = r;
            reset = 0x0;
        } lane1_eol_3[31:16];

        field {
            name = "lane1_eol_2";
            desc = "Lane 1 EOL synchronization code of frame 2 in LVDS or HiSPI mode This field is configurable only in WDR mode, and the configuration is invalid in linear mode.";
            sw = rw;
            hw = r;
            reset = 0x0;
        } lane1_eol_2[15:0];
    } LVDS0_LANE1_EOL_23 @ 0x135C;

    reg {
        name = "Lane 2 SOF synchronization code configuration register in LVDS or HiSPI mode";
        desc = "LVDS0_LANE2_SOF_01 is a lane 2 SOF synchronization code configuration register in LVDS or HiSPI mode. Hi3516C V300/Hi3516E V100 Professional HD IP Camera SoC

Data sheet 9.3.6 LVDS0_LANE2_SOF_01 (offset 0x1360, printed page 9-195, `hi3516cv300--Hi3516CV300-Hi3516EV100-Datasheet.txt` line 38641).";

        field {
            name = "lane2_sof_1";
            desc = "Lane 2 SOF synchronization code of frame 1 in LVDS or HiSPI mode This field is configurable only in WDR mode, and the configuration is invalid in linear mode.";
            sw = rw;
            hw = r;
            reset = 0x0;
        } lane2_sof_1[31:16];

        field {
            name = "lane2_sof_0";
            desc = "Lane 2 SOF synchronization code of frame 0 in LVDS or HiSPI mode In WDR mode, the value is the SOF of frame 0. In linear mode, the value is the SOF.";
            sw = rw;
            hw = r;
            reset = 0x0;
        } lane2_sof_0[15:0];
    } LVDS0_LANE2_SOF_01 @ 0x1360;

    reg {
        name = "Lane 2 SOF synchronization code configuration register in LVDS or HiSPI mode";
        desc = "LVDS0_LANE2_SOF_23 is a lane 2 SOF synchronization code configuration register in LVDS or HiSPI mode.

Data sheet 9.3.6 LVDS0_LANE2_SOF_23 (offset 0x1364, printed page 9-195, `hi3516cv300--Hi3516CV300-Hi3516EV100-Datasheet.txt` line 38669).";

        field {
            name = "lane2_sof_3";
            desc = "Lane 2 SOF synchronization code of frame 3 in LVDS or HiSPI mode This field is configurable only in WDR mode, and the configuration is invalid in linear mode.";
            sw = rw;
            hw = r;
            reset = 0x0;
        } lane2_sof_3[31:16];

        field {
            name = "lane2_sof_2";
            desc = "Lane 2 SOF synchronization code of frame 2 in LVDS or HiSPI mode This field is configurable only in WDR mode, and the configuration is invalid in linear mode.";
            sw = rw;
            hw = r;
            reset = 0x0;
        } lane2_sof_2[15:0];
    } LVDS0_LANE2_SOF_23 @ 0x1364;

    reg {
        name = "Lane 2 EOF synchronization code configuration register in LVDS or HiSPI mode";
        desc = "LVDS0_LANE2_EOF_01 is a lane 2 EOF synchronization code configuration register in LVDS or HiSPI mode. Hi3516C V300/Hi3516E V100 Professional HD IP Camera SoC

Data sheet 9.3.6 LVDS0_LANE2_EOF_01 (offset 0x1368, printed page 9-196, `hi3516cv300--Hi3516CV300-Hi3516EV100-Datasheet.txt` line 38706).";

        field {
            name = "lane2_eof_1";
            desc = "Lane 2 EOF synchronization code of frame 1 in LVDS or HiSPI mode This field is configurable only in WDR mode, and the configuration is invalid in linear mode.";
            sw = rw;
            hw = r;
            reset = 0x0;
        } lane2_eof_1[31:16];

        field {
            name = "lane2_eof_0";
            desc = "Lane 2 EOF synchronization code of frame 0 in LVDS or HiSPI mode In WDR mode, the value is the EOF of frame 0. In linear mode, the value is the EOF.";
            sw = rw;
            hw = r;
            reset = 0x0;
        } lane2_eof_0[15:0];
    } LVDS0_LANE2_EOF_01 @ 0x1368;

    reg {
        name = "Lane 2 EOF synchronization code configuration register in LVDS or HiSPI mode";
        desc = "LVDS0_LANE2_EOF_23 is a lane 2 EOF synchronization code configuration register in LVDS or HiSPI mode.

Data sheet 9.3.6 LVDS0_LANE2_EOF_23 (offset 0x136C, printed page 9-196, `hi3516cv300--Hi3516CV300-Hi3516EV100-Datasheet.txt` line 38734).";

        field {
            name = "lane2_eof_3";
            desc = "Lane 2 EOF synchronization code of frame 3 in LVDS or HiSPI mode This field is configurable only in WDR mode, and the configuration is invalid in linear mode.";
            sw = rw;
            hw = r;
            reset = 0x0;
        } lane2_eof_3[31:16];

        field {
            name = "lane2_eof_2";
            desc = "Lane 2 EOF synchronization code of frame 2 in LVDS or HiSPI mode This field is configurable only in WDR mode, and the configuration is invalid in linear mode.";
            sw = rw;
            hw = r;
            reset = 0x0;
        } lane2_eof_2[15:0];
    } LVDS0_LANE2_EOF_23 @ 0x136C;

    reg {
        name = "Lane 2 SOL synchronization code configuration register in LVDS or HiSPI mode";
        desc = "LVDS0_LANE2_SOL_01 is a lane 2 SOL synchronization code configuration register in LVDS or HiSPI mode. Hi3516C V300/Hi3516E V100 Professional HD IP Camera SoC

Data sheet 9.3.6 LVDS0_LANE2_SOL_01 (offset 0x1370, printed page 9-197, `hi3516cv300--Hi3516CV300-Hi3516EV100-Datasheet.txt` line 38771).";

        field {
            name = "lane2_sol_1";
            desc = "Lane 2 SOL synchronization code of frame 1 in LVDS or HiSPI mode This field is configurable only in WDR mode, and the configuration is invalid in linear mode.";
            sw = rw;
            hw = r;
            reset = 0x0;
        } lane2_sol_1[31:16];

        field {
            name = "lane2_sol_0";
            desc = "Lane 2 SOL synchronization code of frame 0 in LVDS or HiSPI mode In WDR mode, the value is the SOL of frame 0. In linear mode, the value is the SOL.";
            sw = rw;
            hw = r;
            reset = 0x0;
        } lane2_sol_0[15:0];
    } LVDS0_LANE2_SOL_01 @ 0x1370;

    reg {
        name = "Lane 2 SOL synchronization code configuration register in LVDS or HiSPI mode";
        desc = "LVDS0_LANE2_SOL_23 is a lane 2 SOL synchronization code configuration register in LVDS or HiSPI mode.

Data sheet 9.3.6 LVDS0_LANE2_SOL_23 (offset 0x1374, printed page 9-197, `hi3516cv300--Hi3516CV300-Hi3516EV100-Datasheet.txt` line 38799).";

        field {
            name = "lane2_sol_3";
            desc = "Lane 2 SOL synchronization code of frame 3 in LVDS or HiSPI mode This field is configurable only in WDR mode, and the configuration is invalid in linear mode.";
            sw = rw;
            hw = r;
            reset = 0x0;
        } lane2_sol_3[31:16];

        field {
            name = "lane2_sol_2";
            desc = "Lane 2 SOL synchronization code of frame 2 in LVDS or HiSPI mode This field is configurable only in WDR mode, and the configuration is invalid in linear mode.";
            sw = rw;
            hw = r;
            reset = 0x0;
        } lane2_sol_2[15:0];
    } LVDS0_LANE2_SOL_23 @ 0x1374;

    reg {
        name = "Lane 2 EOL synchronization code configuration register in LVDS or HiSPI mode";
        desc = "LVDS0_LANE2_EOL_01 is a lane 2 EOL synchronization code configuration register in LVDS or HiSPI mode. Hi3516C V300/Hi3516E V100 Professional HD IP Camera SoC

Data sheet 9.3.6 LVDS0_LANE2_EOL_01 (offset 0x1378, printed page 9-198, `hi3516cv300--Hi3516CV300-Hi3516EV100-Datasheet.txt` line 38836).";

        field {
            name = "lane2_eol_1";
            desc = "Lane 2 EOL synchronization code of frame 1 in LVDS or HiSPI mode This field is configurable only in WDR mode, and the configuration is invalid in linear mode.";
            sw = rw;
            hw = r;
            reset = 0x0;
        } lane2_eol_1[31:16];

        field {
            name = "lane2_eol_0";
            desc = "Lane 2 EOL synchronization code of frame 0 in LVDS or HiSPI mode In WDR mode, the value is the EOL of frame 0. In linear mode, the value is the EOL.";
            sw = rw;
            hw = r;
            reset = 0x0;
        } lane2_eol_0[15:0];
    } LVDS0_LANE2_EOL_01 @ 0x1378;

    reg {
        name = "Lane 2 EOL synchronization code configuration register in LVDS or HiSPI mode";
        desc = "LVDS0_LANE2_EOL_23 is a lane 2 EOL synchronization code configuration register in LVDS or HiSPI mode.

Data sheet 9.3.6 LVDS0_LANE2_EOL_23 (offset 0x137C, printed page 9-198, `hi3516cv300--Hi3516CV300-Hi3516EV100-Datasheet.txt` line 38864).";

        field {
            name = "lane2_eol_3";
            desc = "Lane 2 EOL synchronization code of frame 3 in LVDS or HiSPI mode This field is configurable only in WDR mode, and the configuration is invalid in linear mode.";
            sw = rw;
            hw = r;
            reset = 0x0;
        } lane2_eol_3[31:16];

        field {
            name = "lane2_eol_2";
            desc = "Lane 2 EOL synchronization code of frame 2 in LVDS or HiSPI mode This field is configurable only in WDR mode, and the configuration is invalid in linear mode.";
            sw = rw;
            hw = r;
            reset = 0x0;
        } lane2_eol_2[15:0];
    } LVDS0_LANE2_EOL_23 @ 0x137C;

    reg {
        name = "Lane 3 SOF synchronization code configuration register in LVDS or HiSPI mode";
        desc = "LVDS0_LANE3_SOF_01 is a lane 3 SOF synchronization code configuration register in LVDS or HiSPI mode. Hi3516C V300/Hi3516E V100 Professional HD IP Camera SoC

Data sheet 9.3.6 LVDS0_LANE3_SOF_01 (offset 0x1380, printed page 9-199, `hi3516cv300--Hi3516CV300-Hi3516EV100-Datasheet.txt` line 38901).";

        field {
            name = "lane3_sof_1";
            desc = "Lane 3 SOF synchronization code of frame 1 in LVDS or HiSPI mode This field is configurable only in WDR mode, and the configuration is invalid in linear mode.";
            sw = rw;
            hw = r;
            reset = 0x0;
        } lane3_sof_1[31:16];

        field {
            name = "lane3_sof_0";
            desc = "Lane 3 SOF synchronization code of frame 0 in LVDS or HiSPI mode In WDR mode, the value is the SOF of frame 0. In linear mode, the value is the SOF.";
            sw = rw;
            hw = r;
            reset = 0x0;
        } lane3_sof_0[15:0];
    } LVDS0_LANE3_SOF_01 @ 0x1380;

    reg {
        name = "Lane 3 SOF synchronization code configuration register in LVDS or HiSPI mode";
        desc = "LVDS0_LANE3_SOF_23 is a lane 3 SOF synchronization code configuration register in LVDS or HiSPI mode.

Data sheet 9.3.6 LVDS0_LANE3_SOF_23 (offset 0x1384, printed page 9-199, `hi3516cv300--Hi3516CV300-Hi3516EV100-Datasheet.txt` line 38929).";

        field {
            name = "lane3_sof_3";
            desc = "Lane 3 SOF synchronization code of frame 3 in LVDS or HiSPI mode This field is configurable only in WDR mode, and the configuration is invalid in linear mode.";
            sw = rw;
            hw = r;
            reset = 0x0;
        } lane3_sof_3[31:16];

        field {
            name = "lane3_sof_2";
            desc = "Lane 3 SOF synchronization code of frame 2 in LVDS or HiSPI mode This field is configurable only in WDR mode, and the configuration is invalid in linear mode.";
            sw = rw;
            hw = r;
            reset = 0x0;
        } lane3_sof_2[15:0];
    } LVDS0_LANE3_SOF_23 @ 0x1384;

    reg {
        name = "Lane 3 EOF synchronization code configuration register in LVDS or HiSPI mode";
        desc = "LVDS0_LANE3_EOF_01 is a lane 3 EOF synchronization code configuration register in LVDS or HiSPI mode. Hi3516C V300/Hi3516E V100 Professional HD IP Camera SoC

Data sheet 9.3.6 LVDS0_LANE3_EOF_01 (offset 0x1388, printed page 9-200, `hi3516cv300--Hi3516CV300-Hi3516EV100-Datasheet.txt` line 38966).";

        field {
            name = "lane3_eof_1";
            desc = "Lane 3 EOF synchronization code of frame 1 in LVDS or HiSPI mode This field is configurable only in WDR mode, and the configuration is invalid in linear mode.";
            sw = rw;
            hw = r;
            reset = 0x0;
        } lane3_eof_1[31:16];

        field {
            name = "lane3_eof_0";
            desc = "Lane 3 EOF synchronization code of frame 0 in LVDS or HiSPI mode In WDR mode, the value is the EOF of frame 0. In linear mode, the value is the EOF.";
            sw = rw;
            hw = r;
            reset = 0x0;
        } lane3_eof_0[15:0];
    } LVDS0_LANE3_EOF_01 @ 0x1388;

    reg {
        name = "Lane 3 EOF synchronization code configuration register in LVDS or HiSPI mode";
        desc = "LVDS0_LANE3_EOF_23 is a lane 3 EOF synchronization code configuration register in LVDS or HiSPI mode.

Data sheet 9.3.6 LVDS0_LANE3_EOF_23 (offset 0x138C, printed page 9-200, `hi3516cv300--Hi3516CV300-Hi3516EV100-Datasheet.txt` line 38994).";

        field {
            name = "lane3_eof_3";
            desc = "Lane 3 EOF synchronization code of frame 3 in LVDS or HiSPI mode This field is configurable only in WDR mode, and the configuration is invalid in linear mode.";
            sw = rw;
            hw = r;
            reset = 0x0;
        } lane3_eof_3[31:16];

        field {
            name = "lane3_eof_2";
            desc = "Lane 3 EOF synchronization code of frame 2 in LVDS or HiSPI mode This field is configurable only in WDR mode, and the configuration is invalid in linear mode.";
            sw = rw;
            hw = r;
            reset = 0x0;
        } lane3_eof_2[15:0];
    } LVDS0_LANE3_EOF_23 @ 0x138C;

    reg {
        name = "Lane 3 SOL synchronization code configuration register in LVDS or HiSPI mode";
        desc = "LVDS0_LANE3_SOL_01 is a lane 3 SOL synchronization code configuration register in LVDS or HiSPI mode. Hi3516C V300/Hi3516E V100 Professional HD IP Camera SoC

Data sheet 9.3.6 LVDS0_LANE3_SOL_01 (offset 0x1390, printed page 9-201, `hi3516cv300--Hi3516CV300-Hi3516EV100-Datasheet.txt` line 39031).";

        field {
            name = "lane3_sol_1";
            desc = "Lane 3 SOL synchronization code of frame 1 in LVDS or HiSPI mode This field is configurable only in WDR mode, and the configuration is invalid in linear mode.";
            sw = rw;
            hw = r;
            reset = 0x0;
        } lane3_sol_1[31:16];

        field {
            name = "lane3_sol_0";
            desc = "Lane 3 SOL synchronization code of frame 0 in LVDS or HiSPI mode In WDR mode, the value is the SOL of frame 0. In linear mode, the value is the SOL.";
            sw = rw;
            hw = r;
            reset = 0x0;
        } lane3_sol_0[15:0];
    } LVDS0_LANE3_SOL_01 @ 0x1390;

    reg {
        name = "Lane 3 SOL synchronization code configuration register in LVDS or HiSPI mode";
        desc = "LVDS0_LANE3_SOL_23 is a lane 3 SOL synchronization code configuration register in LVDS or HiSPI mode.

Data sheet 9.3.6 LVDS0_LANE3_SOL_23 (offset 0x1394, printed page 9-201, `hi3516cv300--Hi3516CV300-Hi3516EV100-Datasheet.txt` line 39059).";

        field {
            name = "lane3_sol_3";
            desc = "Lane 3 SOL synchronization code of frame 3 in LVDS or HiSPI mode This field is configurable only in WDR mode, and the configuration is invalid in linear mode.";
            sw = rw;
            hw = r;
            reset = 0x0;
        } lane3_sol_3[31:16];

        field {
            name = "lane3_sol_2";
            desc = "Lane 3 SOL synchronization code of frame 2 in LVDS or HiSPI mode This field is configurable only in WDR mode, and the configuration is invalid in linear mode.";
            sw = rw;
            hw = r;
            reset = 0x0;
        } lane3_sol_2[15:0];
    } LVDS0_LANE3_SOL_23 @ 0x1394;

    reg {
        name = "Lane 3 EOL synchronization code configuration register in LVDS or HiSPI mode";
        desc = "LVDS0_LANE3_EOL_01 is a lane 3 EOL synchronization code configuration register in LVDS or HiSPI mode. Hi3516C V300/Hi3516E V100 Professional HD IP Camera SoC

Data sheet 9.3.6 LVDS0_LANE3_EOL_01 (offset 0x1398, printed page 9-202, `hi3516cv300--Hi3516CV300-Hi3516EV100-Datasheet.txt` line 39096).";

        field {
            name = "lane3_eol_1";
            desc = "Lane 3 EOL synchronization code of frame 1 in LVDS or HiSPI mode This field is configurable only in WDR mode, and the configuration is invalid in linear mode.";
            sw = rw;
            hw = r;
            reset = 0x0;
        } lane3_eol_1[31:16];

        field {
            name = "lane3_eol_0";
            desc = "Lane 3 EOL synchronization code of frame 0 in LVDS or HiSPI mode In WDR mode, the value is the EOL of frame 0. In linear mode, the value is the EOL.";
            sw = rw;
            hw = r;
            reset = 0x0;
        } lane3_eol_0[15:0];
    } LVDS0_LANE3_EOL_01 @ 0x1398;

    reg {
        name = "Lane 3 EOL synchronization code configuration register in LVDS or HiSPI mode";
        desc = "LVDS0_LANE3_EOL_23 is a lane 3 EOL synchronization code configuration register in LVDS or HiSPI mode.

Data sheet 9.3.6 LVDS0_LANE3_EOL_23 (offset 0x139C, printed page 9-202, `hi3516cv300--Hi3516CV300-Hi3516EV100-Datasheet.txt` line 39124).";

        field {
            name = "lane3_eol_3";
            desc = "Lane 3 EOL synchronization code of frame 3 in LVDS or HiSPI mode This field is configurable only in WDR mode, and the configuration is invalid in linear mode.";
            sw = rw;
            hw = r;
            reset = 0x0;
        } lane3_eol_3[31:16];

        field {
            name = "lane3_eol_2";
            desc = "Lane 3 EOL synchronization code of frame 2 in LVDS or HiSPI mode This field is configurable only in WDR mode, and the configuration is invalid in linear mode.";
            sw = rw;
            hw = r;
            reset = 0x0;
        } lane3_eol_2[15:0];
    } LVDS0_LANE3_EOL_23 @ 0x139C;

    reg {
        name = "Lane 0 SOF synchronization code OF_01 configuration register for frame (N + 1) in LVDS or HiSPI mode";
        desc = "LVDS0_LANE0_NXT_SOF_01 is a lane 0 SOF synchronization code configuration register for frame (N + 1) in LVDS or HiSPI mode. Hi3516C V300/Hi3516E V100 Professional HD IP Camera SoC

Data sheet 9.3.6 LVDS0_LANE0_NXT_SOF_01 (offset 0x13A0, printed page 9-203, `hi3516cv300--Hi3516CV300-Hi3516EV100-Datasheet.txt` line 39161).";

        field {
            name = "lane0_nxt_sof_1";
            desc = "Lane 0 SOF synchronization code of frame 1 in LVDS or HiSPI mode This field is configurable only in WDR mode, and the configuration is invalid in linear mode.";
            sw = rw;
            hw = r;
            reset = 0x0;
        } lane0_nxt_sof_1[31:16];

        field {
            name = "lane0_nxt_sof_0";
            desc = "Lane 0 SOF synchronization code of frame 0 in LVDS or HiSPI mode In WDR mode, the value is the SOF of frame 0. In linear mode, the value is the SOF.";
            sw = rw;
            hw = r;
            reset = 0x0;
        } lane0_nxt_sof_0[15:0];
    } LVDS0_LANE0_NXT_SOF_01 @ 0x13A0;

    reg {
        name = "Lane 0 SOF synchronization code OF_23 configuration register for frame (N + 1) in LVDS or HiSPI mode";
        desc = "LVDS0_LANE0_NXT_SOF_23 is a lane 0 SOF synchronization code configuration register for frame (N + 1) in LVDS or HiSPI mode.

Data sheet 9.3.6 LVDS0_LANE0_NXT_SOF_23 (offset 0x13A4, printed page 9-203, `hi3516cv300--Hi3516CV300-Hi3516EV100-Datasheet.txt` line 39189).";

        field {
            name = "lane0_nxt_sof_3";
            desc = "Lane 0 SOF synchronization code of frame 3 in LVDS or HiSPI mode This field is configurable only in WDR mode, and the configuration is invalid in linear mode.";
            sw = rw;
            hw = r;
            reset = 0x0;
        } lane0_nxt_sof_3[31:16];

        field {
            name = "lane0_nxt_sof_2";
            desc = "Lane 0 SOF synchronization code of frame 2 in LVDS or HiSPI mode This field is configurable only in WDR mode, and the configuration is invalid in linear mode.";
            sw = rw;
            hw = r;
            reset = 0x0;
        } lane0_nxt_sof_2[15:0];
    } LVDS0_LANE0_NXT_SOF_23 @ 0x13A4;

    reg {
        name = "Lane 0 EOF synchronization code OF_01 configuration register for frame (N + 1) in LVDS or HiSPI mode";
        desc = "LVDS0_LANE0_NXT_EOF_01 is a lane 0 EOF synchronization code configuration register for frame (N + 1) in LVDS or HiSPI mode. Hi3516C V300/Hi3516E V100 Professional HD IP Camera SoC

Data sheet 9.3.6 LVDS0_LANE0_NXT_EOF_01 (offset 0x13A8, printed page 9-204, `hi3516cv300--Hi3516CV300-Hi3516EV100-Datasheet.txt` line 39226).";

        field {
            name = "lane0_nxt_eof_1";
            desc = "Lane 0 EOF synchronization code of frame 1 in LVDS or HiSPI mode This field is configurable only in WDR mode, and the configuration is invalid in linear mode.";
            sw = rw;
            hw = r;
            reset = 0x0;
        } lane0_nxt_eof_1[31:16];

        field {
            name = "lane0_nxt_eof_0";
            desc = "Lane 0 EOF synchronization code of frame 0 in LVDS or HiSPI mode In WDR mode, the value is the EOF of frame 0. In linear mode, the value is the EOF.";
            sw = rw;
            hw = r;
            reset = 0x0;
        } lane0_nxt_eof_0[15:0];
    } LVDS0_LANE0_NXT_EOF_01 @ 0x13A8;

    reg {
        name = "Lane 0 EOF synchronization code OF_23 configuration register for frame (N + 1) in LVDS or HiSPI mode";
        desc = "LVDS0_LANE0_NXT_EOF_23 is a lane 0 EOF synchronization code configuration register for frame (N + 1) in LVDS or HiSPI mode.

Data sheet 9.3.6 LVDS0_LANE0_NXT_EOF_23 (offset 0x13AC, printed page 9-204, `hi3516cv300--Hi3516CV300-Hi3516EV100-Datasheet.txt` line 39254).";

        field {
            name = "lane0_nxt_eof_3";
            desc = "Lane 0 EOF synchronization code of frame 3 in LVDS or HiSPI mode This field is configurable only in WDR mode, and the configuration is invalid in linear mode.";
            sw = rw;
            hw = r;
            reset = 0x0;
        } lane0_nxt_eof_3[31:16];

        field {
            name = "lane0_nxt_eof_2";
            desc = "Lane 0 EOF synchronization code of frame 2 in LVDS or HiSPI mode This field is configurable only in WDR mode, and the configuration is invalid in linear mode.";
            sw = rw;
            hw = r;
            reset = 0x0;
        } lane0_nxt_eof_2[15:0];
    } LVDS0_LANE0_NXT_EOF_23 @ 0x13AC;

    reg {
        name = "Lane 0 SOL synchronization code OL_01 configuration register for frame (N + 1) in LVDS or HiSPI mode";
        desc = "LVDS0_LANE0_NXT_SOL_01 is a lane 0 SOL synchronization code configuration register for frame (N + 1) in LVDS or HiSPI mode. Hi3516C V300/Hi3516E V100 Professional HD IP Camera SoC

Data sheet 9.3.6 LVDS0_LANE0_NXT_SOL_01 (offset 0x13B0, printed page 9-205, `hi3516cv300--Hi3516CV300-Hi3516EV100-Datasheet.txt` line 39291).";

        field {
            name = "lane0_nxt_sol_1";
            desc = "Lane 0 SOL synchronization code of frame 1 in LVDS or HiSPI mode This field is configurable only in WDR mode, and the configuration is invalid in linear mode.";
            sw = rw;
            hw = r;
            reset = 0x0;
        } lane0_nxt_sol_1[31:16];

        field {
            name = "lane0_nxt_sol_0";
            desc = "Lane 0 SOL synchronization code of frame 0 in LVDS or HiSPI mode In WDR mode, the value is the SOL of frame 0. In linear mode, the value is the SOL.";
            sw = rw;
            hw = r;
            reset = 0x0;
        } lane0_nxt_sol_0[15:0];
    } LVDS0_LANE0_NXT_SOL_01 @ 0x13B0;

    reg {
        name = "Lane 0 SOL synchronization code OL_23 configuration register for frame (N + 1) in LVDS or HiSPI mode";
        desc = "LVDS0_LANE0_NXT_SOL_23 is a lane 0 SOL synchronization code configuration register for frame (N + 1) in LVDS or HiSPI mode.

Data sheet 9.3.6 LVDS0_LANE0_NXT_SOL_23 (offset 0x13B4, printed page 9-205, `hi3516cv300--Hi3516CV300-Hi3516EV100-Datasheet.txt` line 39319).";

        field {
            name = "lane0_nxt_sol_3";
            desc = "Lane 0 SOL synchronization code of frame 3 in LVDS or HiSPI mode This field is configurable only in WDR mode, and the configuration is invalid in linear mode.";
            sw = rw;
            hw = r;
            reset = 0x0;
        } lane0_nxt_sol_3[31:16];

        field {
            name = "lane0_nxt_sol_2";
            desc = "Lane 0 SOL synchronization code of frame 2 in LVDS or HiSPI mode This field is configurable only in WDR mode, and the configuration is invalid in linear mode.";
            sw = rw;
            hw = r;
            reset = 0x0;
        } lane0_nxt_sol_2[15:0];
    } LVDS0_LANE0_NXT_SOL_23 @ 0x13B4;

    reg {
        name = "Lane 0 EOL synchronization code OL_01 configuration register for frame (N + 1) in LVDS or HiSPI mode";
        desc = "LVDS0_LANE0_NXT_EOL_01 is a lane 0 EOL synchronization code configuration register for frame (N + 1) in LVDS or HiSPI mode. Hi3516C V300/Hi3516E V100 Professional HD IP Camera SoC

Data sheet 9.3.6 LVDS0_LANE0_NXT_EOL_01 (offset 0x13B8, printed page 9-206, `hi3516cv300--Hi3516CV300-Hi3516EV100-Datasheet.txt` line 39356).";

        field {
            name = "lane0_nxt_eol_1";
            desc = "Lane 0 EOL synchronization code of frame 1 in LVDS or HiSPI mode This field is configurable only in WDR mode, and the configuration is invalid in linear mode.";
            sw = rw;
            hw = r;
            reset = 0x0;
        } lane0_nxt_eol_1[31:16];

        field {
            name = "lane0_nxt_eol_0";
            desc = "Lane 0 EOL synchronization code of frame 0 in LVDS or HiSPI mode In WDR mode, the value is the EOL of frame 0. In linear mode, the value is the EOL.";
            sw = rw;
            hw = r;
            reset = 0x0;
        } lane0_nxt_eol_0[15:0];
    } LVDS0_LANE0_NXT_EOL_01 @ 0x13B8;

    reg {
        name = "Lane 0 EOL synchronization code OL_23 configuration register for frame (N + 1) in LVDS or HiSPI mode";
        desc = "LVDS0_LANE0_NXT_EOL_23 is a lane 0 EOL synchronization code configuration register for frame (N + 1) in LVDS or HiSPI mode.

Data sheet 9.3.6 LVDS0_LANE0_NXT_EOL_23 (offset 0x13BC, printed page 9-206, `hi3516cv300--Hi3516CV300-Hi3516EV100-Datasheet.txt` line 39384).";

        field {
            name = "lane0_nxt_eol_3";
            desc = "Lane 0 EOL synchronization code of frame 3 in LVDS or HiSPI mode This field is configurable only in WDR mode, and the configuration is invalid in linear mode.";
            sw = rw;
            hw = r;
            reset = 0x0;
        } lane0_nxt_eol_3[31:16];

        field {
            name = "lane0_nxt_eol_2";
            desc = "Lane 0 EOL synchronization code of frame 2 in LVDS or HiSPI mode This field is configurable only in WDR mode, and the configuration is invalid in linear mode.";
            sw = rw;
            hw = r;
            reset = 0x0;
        } lane0_nxt_eol_2[15:0];
    } LVDS0_LANE0_NXT_EOL_23 @ 0x13BC;

    reg {
        name = "Lane 1 SOF synchronization code OF_01 configuration register for frame (N + 1) in LVDS or HiSPI mode";
        desc = "LVDS0_LANE1_NXT_SOF_01 is a lane 1 SOF synchronization code configuration register for frame (N + 1) in LVDS or HiSPI mode. Hi3516C V300/Hi3516E V100 Professional HD IP Camera SoC

Data sheet 9.3.6 LVDS0_LANE1_NXT_SOF_01 (offset 0x13C0, printed page 9-207, `hi3516cv300--Hi3516CV300-Hi3516EV100-Datasheet.txt` line 39421).";

        field {
            name = "lane1_nxt_sof_1";
            desc = "Lane 1 SOF synchronization code of frame 1 in LVDS or HiSPI mode This field is configurable only in WDR mode, and the configuration is invalid in linear mode.";
            sw = rw;
            hw = r;
            reset = 0x0;
        } lane1_nxt_sof_1[31:16];

        field {
            name = "lane1_nxt_sof_0";
            desc = "Lane 1 SOF synchronization code of frame 0 in LVDS or HiSPI mode In WDR mode, the value is the SOF of frame 0. In linear mode, the value is the SOF.";
            sw = rw;
            hw = r;
            reset = 0x0;
        } lane1_nxt_sof_0[15:0];
    } LVDS0_LANE1_NXT_SOF_01 @ 0x13C0;

    reg {
        name = "Lane 1 SOF synchronization code OF_23 configuration register for frame (N + 1) in LVDS or HiSPI mode";
        desc = "LVDS0_LANE1_NXT_SOF_23 is a lane 1 SOF synchronization code configuration register for frame (N + 1) in LVDS or HiSPI mode.

Data sheet 9.3.6 LVDS0_LANE1_NXT_SOF_23 (offset 0x13C4, printed page 9-207, `hi3516cv300--Hi3516CV300-Hi3516EV100-Datasheet.txt` line 39449).";

        field {
            name = "lane1_nxt_sof_3";
            desc = "Lane 1 SOF synchronization code of frame 3 in LVDS or HiSPI mode This field is configurable only in WDR mode, and the configuration is invalid in linear mode.";
            sw = rw;
            hw = r;
            reset = 0x0;
        } lane1_nxt_sof_3[31:16];

        field {
            name = "lane1_nxt_sof_2";
            desc = "Lane 1 SOF synchronization code of frame 2 in LVDS or HiSPI mode This field is configurable only in WDR mode, and the configuration is invalid in linear mode.";
            sw = rw;
            hw = r;
            reset = 0x0;
        } lane1_nxt_sof_2[15:0];
    } LVDS0_LANE1_NXT_SOF_23 @ 0x13C4;

    reg {
        name = "Lane 1 EOF synchronization code OF_01 configuration register for frame (N + 1) in LVDS or HiSPI mode";
        desc = "LVDS0_LANE1_NXT_EOF_01 is a lane 1 EOF synchronization code configuration register for frame (N + 1) in LVDS or HiSPI mode. Hi3516C V300/Hi3516E V100 Professional HD IP Camera SoC

Data sheet 9.3.6 LVDS0_LANE1_NXT_EOF_01 (offset 0x13C8, printed page 9-208, `hi3516cv300--Hi3516CV300-Hi3516EV100-Datasheet.txt` line 39486).";

        field {
            name = "lane1_nxt_eof_1";
            desc = "Lane 1 EOF synchronization code of frame 1 in LVDS or HiSPI mode This field is configurable only in WDR mode, and the configuration is invalid in linear mode.";
            sw = rw;
            hw = r;
            reset = 0x0;
        } lane1_nxt_eof_1[31:16];

        field {
            name = "lane1_nxt_eof_0";
            desc = "Lane 1 EOF synchronization code of frame 0 in LVDS or HiSPI mode In WDR mode, the value is the EOF of frame 0. In linear mode, the value is the EOF.";
            sw = rw;
            hw = r;
            reset = 0x0;
        } lane1_nxt_eof_0[15:0];
    } LVDS0_LANE1_NXT_EOF_01 @ 0x13C8;

    reg {
        name = "Lane 1 EOF synchronization code OF_23 configuration register for frame (N + 1) in LVDS or HiSPI mode";
        desc = "LVDS0_LANE1_NXT_EOF_23 is a lane 1 EOF synchronization code configuration register for frame (N + 1) in LVDS or HiSPI mode.

Data sheet 9.3.6 LVDS0_LANE1_NXT_EOF_23 (offset 0x13CC, printed page 9-208, `hi3516cv300--Hi3516CV300-Hi3516EV100-Datasheet.txt` line 39514).";

        field {
            name = "lane1_nxt_eof_3";
            desc = "Lane 1 EOF synchronization code of frame 3 in LVDS or HiSPI mode This field is configurable only in WDR mode, and the configuration is invalid in linear mode.";
            sw = rw;
            hw = r;
            reset = 0x0;
        } lane1_nxt_eof_3[31:16];

        field {
            name = "lane1_nxt_eof_2";
            desc = "Lane 1 EOF synchronization code of frame 2 in LVDS or HiSPI mode This field is configurable only in WDR mode, and the configuration is invalid in linear mode.";
            sw = rw;
            hw = r;
            reset = 0x0;
        } lane1_nxt_eof_2[15:0];
    } LVDS0_LANE1_NXT_EOF_23 @ 0x13CC;

    reg {
        name = "Lane 1 SOL synchronization code OL_01 configuration register for frame (N + 1) in LVDS or HiSPI mode";
        desc = "LVDS0_LANE1_NXT_SOL_01 is a lane 1 SOL synchronization code configuration register for frame (N + 1) in LVDS or HiSPI mode. Hi3516C V300/Hi3516E V100 Professional HD IP Camera SoC

Data sheet 9.3.6 LVDS0_LANE1_NXT_SOL_01 (offset 0x13D0, printed page 9-209, `hi3516cv300--Hi3516CV300-Hi3516EV100-Datasheet.txt` line 39551).";

        field {
            name = "lane1_nxt_sol_1";
            desc = "Lane 1 SOL synchronization code of frame 1 in LVDS or HiSPI mode This field is configurable only in WDR mode, and the configuration is invalid in linear mode.";
            sw = rw;
            hw = r;
            reset = 0x0;
        } lane1_nxt_sol_1[31:16];

        field {
            name = "lane1_nxt_sol_0";
            desc = "Lane 1 SOL synchronization code of frame 0 in LVDS or HiSPI mode In WDR mode, the value is the SOL of frame 0. In linear mode, the value is the SOL.";
            sw = rw;
            hw = r;
            reset = 0x0;
        } lane1_nxt_sol_0[15:0];
    } LVDS0_LANE1_NXT_SOL_01 @ 0x13D0;

    reg {
        name = "Lane 1 SOL synchronization code OL_23 configuration register for frame (N + 1) in LVDS or HiSPI mode";
        desc = "LVDS0_LANE1_NXT_SOL_23 is a lane 1 SOL synchronization code configuration register for frame (N + 1) in LVDS or HiSPI mode.

Data sheet 9.3.6 LVDS0_LANE1_NXT_SOL_23 (offset 0x13D4, printed page 9-209, `hi3516cv300--Hi3516CV300-Hi3516EV100-Datasheet.txt` line 39579).";

        field {
            name = "lane1_nxt_sol_3";
            desc = "Lane 1 SOL synchronization code of frame 3 in LVDS or HiSPI mode This field is configurable only in WDR mode, and the configuration is invalid in linear mode.";
            sw = rw;
            hw = r;
            reset = 0x0;
        } lane1_nxt_sol_3[31:16];

        field {
            name = "lane1_nxt_sol_2";
            desc = "Lane 1 SOL synchronization code of frame 2 in LVDS or HiSPI mode This field is configurable only in WDR mode, and the configuration is invalid in linear mode.";
            sw = rw;
            hw = r;
            reset = 0x0;
        } lane1_nxt_sol_2[15:0];
    } LVDS0_LANE1_NXT_SOL_23 @ 0x13D4;

    reg {
        name = "Lane 1 EOL synchronization code OL_01 configuration register for frame (N + 1) in LVDS or HiSPI mode";
        desc = "LVDS0_LANE1_NXT_EOL_01 is a lane 1 EOL synchronization code configuration register for frame (N + 1) in LVDS or HiSPI mode. Hi3516C V300/Hi3516E V100 Professional HD IP Camera SoC

Data sheet 9.3.6 LVDS0_LANE1_NXT_EOL_01 (offset 0x13D8, printed page 9-210, `hi3516cv300--Hi3516CV300-Hi3516EV100-Datasheet.txt` line 39616).";

        field {
            name = "lane1_nxt_eol_1";
            desc = "Lane 1 EOL synchronization code of frame 1 in LVDS or HiSPI mode This field is configurable only in WDR mode, and the configuration is invalid in linear mode.";
            sw = rw;
            hw = r;
            reset = 0x0;
        } lane1_nxt_eol_1[31:16];

        field {
            name = "lane1_nxt_eol_0";
            desc = "Lane 1 EOL synchronization code of frame 0 in LVDS or HiSPI mode In WDR mode, the value is the EOL of frame 0. In linear mode, the value is the EOL.";
            sw = rw;
            hw = r;
            reset = 0x0;
        } lane1_nxt_eol_0[15:0];
    } LVDS0_LANE1_NXT_EOL_01 @ 0x13D8;

    reg {
        name = "Lane 1 EOL synchronization code OL_23 configuration register for frame (N + 1) in LVDS or HiSPI mode";
        desc = "LVDS0_LANE1_NXT_EOL_23 is a lane 1 EOL synchronization code configuration register for frame (N + 1) in LVDS or HiSPI mode.

Data sheet 9.3.6 LVDS0_LANE1_NXT_EOL_23 (offset 0x13DC, printed page 9-210, `hi3516cv300--Hi3516CV300-Hi3516EV100-Datasheet.txt` line 39644).";

        field {
            name = "lane1_nxt_eol_3";
            desc = "Lane 1 EOL synchronization code of frame 3 in LVDS or HiSPI mode This field is configurable only in WDR mode, and the configuration is invalid in linear mode.";
            sw = rw;
            hw = r;
            reset = 0x0;
        } lane1_nxt_eol_3[31:16];

        field {
            name = "lane1_nxt_eol_2";
            desc = "Lane 1 EOL synchronization code of frame 2 in LVDS or HiSPI mode This field is configurable only in WDR mode, and the configuration is invalid in linear mode.";
            sw = rw;
            hw = r;
            reset = 0x0;
        } lane1_nxt_eol_2[15:0];
    } LVDS0_LANE1_NXT_EOL_23 @ 0x13DC;

    reg {
        name = "Lane 2 SOF synchronization code OF_01 configuration register for frame (N + 1) in LVDS or HiSPI mode";
        desc = "LVDS0_LANE2_NXT_SOF_01 is a lane 2 SOF synchronization code configuration register for frame (N + 1) in LVDS or HiSPI mode. Hi3516C V300/Hi3516E V100 Professional HD IP Camera SoC

Data sheet 9.3.6 LVDS0_LANE2_NXT_SOF_01 (offset 0x13E0, printed page 9-211, `hi3516cv300--Hi3516CV300-Hi3516EV100-Datasheet.txt` line 39681).";

        field {
            name = "lane2_nxt_sof_1";
            desc = "Lane 2 SOF synchronization code of frame 1 in LVDS or HiSPI mode This field is configurable only in WDR mode, and the configuration is invalid in linear mode.";
            sw = rw;
            hw = r;
            reset = 0x0;
        } lane2_nxt_sof_1[31:16];

        field {
            name = "lane2_nxt_sof_0";
            desc = "Lane 2 SOF synchronization code of frame 0 in LVDS or HiSPI mode In WDR mode, the value is the SOF of frame 0. In linear mode, the value is the SOF.";
            sw = rw;
            hw = r;
            reset = 0x0;
        } lane2_nxt_sof_0[15:0];
    } LVDS0_LANE2_NXT_SOF_01 @ 0x13E0;

    reg {
        name = "Lane 2 SOF synchronization code OF_23 configuration register for frame (N + 1) in LVDS or HiSPI mode";
        desc = "LVDS0_LANE2_NXT_SOF_23 is a lane 2 SOF synchronization code configuration register for frame (N + 1) in LVDS or HiSPI mode.

Data sheet 9.3.6 LVDS0_LANE2_NXT_SOF_23 (offset 0x13E4, printed page 9-211, `hi3516cv300--Hi3516CV300-Hi3516EV100-Datasheet.txt` line 39709).";

        field {
            name = "lane2_nxt_sof_3";
            desc = "Lane 2 SOF synchronization code of frame 3 in LVDS or HiSPI mode This field is configurable only in WDR mode, and the configuration is invalid in linear mode.";
            sw = rw;
            hw = r;
            reset = 0x0;
        } lane2_nxt_sof_3[31:16];

        field {
            name = "lane2_nxt_sof_2";
            desc = "Lane 2 SOF synchronization code of frame 2 in LVDS or HiSPI mode This field is configurable only in WDR mode, and the configuration is invalid in linear mode.";
            sw = rw;
            hw = r;
            reset = 0x0;
        } lane2_nxt_sof_2[15:0];
    } LVDS0_LANE2_NXT_SOF_23 @ 0x13E4;

    reg {
        name = "Lane 2 EOF synchronization code OF_01 configuration register for frame (N + 1) in LVDS or HiSPI mode";
        desc = "LVDS0_LANE2_NXT_EOF_01 is a lane 2 EOF synchronization code configuration register for frame (N + 1) in LVDS or HiSPI mode. Hi3516C V300/Hi3516E V100 Professional HD IP Camera SoC

Data sheet 9.3.6 LVDS0_LANE2_NXT_EOF_01 (offset 0x13E8, printed page 9-212, `hi3516cv300--Hi3516CV300-Hi3516EV100-Datasheet.txt` line 39746).";

        field {
            name = "lane2_nxt_eof_1";
            desc = "Lane 2 EOF synchronization code of frame 1 in LVDS or HiSPI mode This field is configurable only in WDR mode, and the configuration is invalid in linear mode.";
            sw = rw;
            hw = r;
            reset = 0x0;
        } lane2_nxt_eof_1[31:16];

        field {
            name = "lane2_nxt_eof_0";
            desc = "Lane 2 EOF synchronization code of frame 0 in LVDS or HiSPI mode In WDR mode, the value is the EOF of frame 0. In linear mode, the value is the EOF.";
            sw = rw;
            hw = r;
            reset = 0x0;
        } lane2_nxt_eof_0[15:0];
    } LVDS0_LANE2_NXT_EOF_01 @ 0x13E8;

    reg {
        name = "Lane 2 EOF synchronization code OF_23 configuration register for frame (N + 1) in LVDS or HiSPI mode";
        desc = "LVDS0_LANE2_NXT_EOF_23 is a lane 2 EOF synchronization code configuration register for frame (N + 1) in LVDS or HiSPI mode.

Data sheet 9.3.6 LVDS0_LANE2_NXT_EOF_23 (offset 0x13EC, printed page 9-212, `hi3516cv300--Hi3516CV300-Hi3516EV100-Datasheet.txt` line 39774).";

        field {
            name = "lane2_nxt_eof_3";
            desc = "Lane 2 EOF synchronization code of frame 3 in LVDS or HiSPI mode This field is configurable only in WDR mode, and the configuration is invalid in linear mode.";
            sw = rw;
            hw = r;
            reset = 0x0;
        } lane2_nxt_eof_3[31:16];

        field {
            name = "lane2_nxt_eof_2";
            desc = "Lane 2 EOF synchronization code of frame 2 in LVDS or HiSPI mode This field is configurable only in WDR mode, and the configuration is invalid in linear mode.";
            sw = rw;
            hw = r;
            reset = 0x0;
        } lane2_nxt_eof_2[15:0];
    } LVDS0_LANE2_NXT_EOF_23 @ 0x13EC;

    reg {
        name = "Lane 2 SOL synchronization code OL_01 configuration register for frame (N + 1) in LVDS or HiSPI mode";
        desc = "LVDS0_LANE2_NXT_SOL_01 is a lane 2 SOL synchronization code configuration register for frame (N + 1) in LVDS or HiSPI mode. Hi3516C V300/Hi3516E V100 Professional HD IP Camera SoC

Data sheet 9.3.6 LVDS0_LANE2_NXT_SOL_01 (offset 0x13F0, printed page 9-213, `hi3516cv300--Hi3516CV300-Hi3516EV100-Datasheet.txt` line 39811).";

        field {
            name = "lane2_nxt_sol_1";
            desc = "Lane 2 SOL synchronization code of frame 1 in LVDS or HiSPI mode This field is configurable only in WDR mode, and the configuration is invalid in linear mode.";
            sw = rw;
            hw = r;
            reset = 0x0;
        } lane2_nxt_sol_1[31:16];

        field {
            name = "lane2_nxt_sol_0";
            desc = "Lane 2 SOL synchronization code of frame 0 in LVDS or HiSPI mode In WDR mode, the value is the SOL of frame 0. In linear mode, the value is the SOL.";
            sw = rw;
            hw = r;
            reset = 0x0;
        } lane2_nxt_sol_0[15:0];
    } LVDS0_LANE2_NXT_SOL_01 @ 0x13F0;

    reg {
        name = "Lane 2 SOL synchronization code OL_23 configuration register for frame (N + 1) in LVDS or HiSPI mode";
        desc = "LVDS0_LANE2_NXT_SOL_23 is a lane 2 SOL synchronization code configuration register for frame (N + 1) in LVDS or HiSPI mode.

Data sheet 9.3.6 LVDS0_LANE2_NXT_SOL_23 (offset 0x13F4, printed page 9-213, `hi3516cv300--Hi3516CV300-Hi3516EV100-Datasheet.txt` line 39839).";

        field {
            name = "lane2_nxt_sol_3";
            desc = "Lane 2 SOL synchronization code of frame 3 in LVDS or HiSPI mode This field is configurable only in WDR mode, and the configuration is invalid in linear mode.";
            sw = rw;
            hw = r;
            reset = 0x0;
        } lane2_nxt_sol_3[31:16];

        field {
            name = "lane2_nxt_sol_2";
            desc = "Lane 2 SOL synchronization code of frame 2 in LVDS or HiSPI mode This field is configurable only in WDR mode, and the configuration is invalid in linear mode.";
            sw = rw;
            hw = r;
            reset = 0x0;
        } lane2_nxt_sol_2[15:0];
    } LVDS0_LANE2_NXT_SOL_23 @ 0x13F4;

    reg {
        name = "Lane 2 EOL synchronization code OL_01 configuration register for frame (N + 1) in LVDS or HiSPI mode";
        desc = "LVDS0_LANE2_NXT_EOL_01 is a lane 2 EOL synchronization code configuration register for frame (N + 1) in LVDS or HiSPI mode. Hi3516C V300/Hi3516E V100 Professional HD IP Camera SoC

Data sheet 9.3.6 LVDS0_LANE2_NXT_EOL_01 (offset 0x13F8, printed page 9-214, `hi3516cv300--Hi3516CV300-Hi3516EV100-Datasheet.txt` line 39876).";

        field {
            name = "lane2_nxt_eol_1";
            desc = "Lane 2 EOL synchronization code of frame 1 in LVDS or HiSPI mode This field is configurable only in WDR mode, and the configuration is invalid in linear mode.";
            sw = rw;
            hw = r;
            reset = 0x0;
        } lane2_nxt_eol_1[31:16];

        field {
            name = "lane2_nxt_eol_0";
            desc = "Lane 2 EOL synchronization code of frame 0 in LVDS or HiSPI mode In WDR mode, the value is the EOL of frame 0. In linear mode, the value is the EOL.";
            sw = rw;
            hw = r;
            reset = 0x0;
        } lane2_nxt_eol_0[15:0];
    } LVDS0_LANE2_NXT_EOL_01 @ 0x13F8;

    reg {
        name = "Lane 2 EOL synchronization code OL_23 configuration register for frame (N + 1) in LVDS or HiSPI mode";
        desc = "LVDS0_LANE2_NXT_EOL_23 is a lane 2 EOL synchronization code configuration register for frame (N + 1) in LVDS or HiSPI mode.

Data sheet 9.3.6 LVDS0_LANE2_NXT_EOL_23 (offset 0x13FC, printed page 9-214, `hi3516cv300--Hi3516CV300-Hi3516EV100-Datasheet.txt` line 39904).";

        field {
            name = "lane2_nxt_eol_3";
            desc = "Lane 2 EOL synchronization code of frame 3 in LVDS or HiSPI mode This field is configurable only in WDR mode, and the configuration is invalid in linear mode.";
            sw = rw;
            hw = r;
            reset = 0x0;
        } lane2_nxt_eol_3[31:16];

        field {
            name = "lane2_nxt_eol_2";
            desc = "Lane 2 EOL synchronization code of frame 2 in LVDS or HiSPI mode This field is configurable only in WDR mode, and the configuration is invalid in linear mode.";
            sw = rw;
            hw = r;
            reset = 0x0;
        } lane2_nxt_eol_2[15:0];
    } LVDS0_LANE2_NXT_EOL_23 @ 0x13FC;

    reg {
        name = "Lane 3 SOF synchronization code OF_01 configuration register for frame (N + 1) in LVDS or HiSPI mode";
        desc = "LVDS0_LANE3_NXT_SOF_01 is a lane 3 SOF synchronization code configuration register for frame (N + 1) in LVDS or HiSPI mode. Hi3516C V300/Hi3516E V100 Professional HD IP Camera SoC

Data sheet 9.3.6 LVDS0_LANE3_NXT_SOF_01 (offset 0x1400, printed page 9-215, `hi3516cv300--Hi3516CV300-Hi3516EV100-Datasheet.txt` line 39941).";

        field {
            name = "lane3_nxt_sof_1";
            desc = "Lane 3 SOF synchronization code of frame 1 in LVDS or HiSPI mode This field is configurable only in WDR mode, and the configuration is invalid in linear mode.";
            sw = rw;
            hw = r;
            reset = 0x0;
        } lane3_nxt_sof_1[31:16];

        field {
            name = "lane3_nxt_sof_0";
            desc = "Lane 3 SOF synchronization code of frame 0 in LVDS or HiSPI mode In WDR mode, the value is the SOF of frame 0. In linear mode, the value is the SOF.";
            sw = rw;
            hw = r;
            reset = 0x0;
        } lane3_nxt_sof_0[15:0];
    } LVDS0_LANE3_NXT_SOF_01 @ 0x1400;

    reg {
        name = "Lane 3 SOF synchronization code OF_23 configuration register for frame (N + 1) in LVDS or HiSPI mode";
        desc = "LVDS0_LANE3_NXT_SOF_23 is a lane 3 SOF synchronization code configuration register for frame (N + 1) in LVDS or HiSPI mode.

Data sheet 9.3.6 LVDS0_LANE3_NXT_SOF_23 (offset 0x1404, printed page 9-215, `hi3516cv300--Hi3516CV300-Hi3516EV100-Datasheet.txt` line 39969).";

        field {
            name = "lane3_nxt_sof_3";
            desc = "Lane 3 SOF synchronization code of frame 3 in LVDS or HiSPI mode This field is configurable only in WDR mode, and the configuration is invalid in linear mode.";
            sw = rw;
            hw = r;
            reset = 0x0;
        } lane3_nxt_sof_3[31:16];

        field {
            name = "lane3_nxt_sof_2";
            desc = "Lane 3 SOF synchronization code of frame 2 in LVDS or HiSPI mode This field is configurable only in WDR mode, and the configuration is invalid in linear mode.";
            sw = rw;
            hw = r;
            reset = 0x0;
        } lane3_nxt_sof_2[15:0];
    } LVDS0_LANE3_NXT_SOF_23 @ 0x1404;

    reg {
        name = "Lane 3 EOF synchronization code OF_01 configuration register for frame (N + 1) in LVDS or HiSPI mode";
        desc = "LVDS0_LANE3_NXT_EOF_01 is a lane 3 EOF synchronization code configuration register for frame (N + 1) in LVDS or HiSPI mode. Hi3516C V300/Hi3516E V100 Professional HD IP Camera SoC

Data sheet 9.3.6 LVDS0_LANE3_NXT_EOF_01 (offset 0x1408, printed page 9-216, `hi3516cv300--Hi3516CV300-Hi3516EV100-Datasheet.txt` line 40006).";

        field {
            name = "lane3_nxt_eof_1";
            desc = "Lane 3 EOF synchronization code of frame 1 in LVDS or HiSPI mode This field is configurable only in WDR mode, and the configuration is invalid in linear mode.";
            sw = rw;
            hw = r;
            reset = 0x0;
        } lane3_nxt_eof_1[31:16];

        field {
            name = "lane3_nxt_eof_0";
            desc = "Lane 3 EOF synchronization code of frame 0 in LVDS or HiSPI mode In WDR mode, the value is the EOF of frame 0. In linear mode, the value is the EOF.";
            sw = rw;
            hw = r;
            reset = 0x0;
        } lane3_nxt_eof_0[15:0];
    } LVDS0_LANE3_NXT_EOF_01 @ 0x1408;

    reg {
        name = "Lane 3 EOF synchronization code OF_23 configuration register for frame (N + 1) in LVDS or HiSPI mode";
        desc = "LVDS0_LANE3_NXT_EOF_23 is a lane 3 EOF synchronization code configuration register for frame (N + 1) in LVDS or HiSPI mode.

Data sheet 9.3.6 LVDS0_LANE3_NXT_EOF_23 (offset 0x140C, printed page 9-216, `hi3516cv300--Hi3516CV300-Hi3516EV100-Datasheet.txt` line 40034).";

        field {
            name = "lane3_nxt_eof_3";
            desc = "Lane 3 EOF synchronization code of frame 3 in LVDS or HiSPI mode This field is configurable only in WDR mode, and the configuration is invalid in linear mode.";
            sw = rw;
            hw = r;
            reset = 0x0;
        } lane3_nxt_eof_3[31:16];

        field {
            name = "lane3_nxt_eof_2";
            desc = "Lane 3 EOF synchronization code of frame 2 in LVDS or HiSPI mode This field is configurable only in WDR mode, and the configuration is invalid in linear mode.";
            sw = rw;
            hw = r;
            reset = 0x0;
        } lane3_nxt_eof_2[15:0];
    } LVDS0_LANE3_NXT_EOF_23 @ 0x140C;

    reg {
        name = "Lane 3 SOL synchronization code OL_01 configuration register for frame (N + 1) in LVDS or HiSPI mode";
        desc = "LVDS0_LANE3_NXT_SOL_01 is a lane 3 SOL synchronization code configuration register for frame (N + 1) in LVDS or HiSPI mode. Hi3516C V300/Hi3516E V100 Professional HD IP Camera SoC

Data sheet 9.3.6 LVDS0_LANE3_NXT_SOL_01 (offset 0x1410, printed page 9-217, `hi3516cv300--Hi3516CV300-Hi3516EV100-Datasheet.txt` line 40071).";

        field {
            name = "lane3_nxt_sol_1";
            desc = "Lane 3 SOL synchronization code of frame 1 in LVDS or HiSPI mode This field is configurable only in WDR mode, and the configuration is invalid in linear mode.";
            sw = rw;
            hw = r;
            reset = 0x0;
        } lane3_nxt_sol_1[31:16];

        field {
            name = "lane3_nxt_sol_0";
            desc = "Lane 3 SOL synchronization code of frame 0 in LVDS or HiSPI mode In WDR mode, the value is the SOL of frame 0. In linear mode, the value is the SOL.";
            sw = rw;
            hw = r;
            reset = 0x0;
        } lane3_nxt_sol_0[15:0];
    } LVDS0_LANE3_NXT_SOL_01 @ 0x1410;

    reg {
        name = "Lane 3 SOL synchronization code OL_23 configuration register for frame (N + 1) in LVDS or HiSPI mode";
        desc = "LVDS0_LANE3_NXT_SOL_23 is a lane 3 SOL synchronization code configuration register for frame (N + 1) in LVDS or HiSPI mode.

Data sheet 9.3.6 LVDS0_LANE3_NXT_SOL_23 (offset 0x1414, printed page 9-217, `hi3516cv300--Hi3516CV300-Hi3516EV100-Datasheet.txt` line 40099).";

        field {
            name = "lane3_nxt_sol_3";
            desc = "Lane 3 SOL synchronization code of frame 3 in LVDS or HiSPI mode This field is configurable only in WDR mode, and the configuration is invalid in linear mode.";
            sw = rw;
            hw = r;
            reset = 0x0;
        } lane3_nxt_sol_3[31:16];

        field {
            name = "lane3_nxt_sol_2";
            desc = "Lane 3 SOL synchronization code of frame 2 in LVDS or HiSPI mode This field is configurable only in WDR mode, and the configuration is invalid in linear mode.";
            sw = rw;
            hw = r;
            reset = 0x0;
        } lane3_nxt_sol_2[15:0];
    } LVDS0_LANE3_NXT_SOL_23 @ 0x1414;

    reg {
        name = "Lane 3 EOL synchronization code OL_01 configuration register for frame (N + 1) in LVDS or HiSPI mode";
        desc = "LVDS0_LANE3_NXT_EOL_01 is a lane 3 EOL synchronization code configuration register for frame (N + 1) in LVDS or HiSPI mode. Hi3516C V300/Hi3516E V100 Professional HD IP Camera SoC

Data sheet 9.3.6 LVDS0_LANE3_NXT_EOL_01 (offset 0x1418, printed page 9-218, `hi3516cv300--Hi3516CV300-Hi3516EV100-Datasheet.txt` line 40136).";

        field {
            name = "lane3_nxt_eol_1";
            desc = "Lane 3 EOL synchronization code of frame 1 in LVDS or HiSPI mode This field is configurable only in WDR mode, and the configuration is invalid in linear mode.";
            sw = rw;
            hw = r;
            reset = 0x0;
        } lane3_nxt_eol_1[31:16];

        field {
            name = "lane3_nxt_eol_0";
            desc = "Lane 3 EOL synchronization code of frame 0 in LVDS or HiSPI mode In WDR mode, the value is the EOL of frame 0. In linear mode, the value is the EOL.";
            sw = rw;
            hw = r;
            reset = 0x0;
        } lane3_nxt_eol_0[15:0];
    } LVDS0_LANE3_NXT_EOL_01 @ 0x1418;

    reg {
        name = "Lane 3 EOL synchronization code OL_23 configuration register for frame (N + 1) in LVDS or HiSPI mode";
        desc = "LVDS0_LANE3_NXT_EOL_23 is a lane 3 EOL synchronization code configuration register for frame (N + 1) in LVDS or HiSPI mode.

Data sheet 9.3.6 LVDS0_LANE3_NXT_EOL_23 (offset 0x141C, printed page 9-218, `hi3516cv300--Hi3516CV300-Hi3516EV100-Datasheet.txt` line 40164).";

        field {
            name = "lane3_nxt_eol_3";
            desc = "Lane 3 EOL synchronization code of frame 3 in LVDS or HiSPI mode This field is configurable only in WDR mode, and the configuration is invalid in linear mode.";
            sw = rw;
            hw = r;
            reset = 0x0;
        } lane3_nxt_eol_3[31:16];

        field {
            name = "lane3_nxt_eol_2";
            desc = "Lane 3 EOL synchronization code of frame 2 in LVDS or HiSPI mode This field is configurable only in WDR mode, and the configuration is invalid in linear mode.";
            sw = rw;
            hw = r;
            reset = 0x0;
        } lane3_nxt_eol_2[15:0];
    } LVDS0_LANE3_NXT_EOL_23 @ 0x141C;

    reg {
        name = "LVDS DOL mode frame 0 LI register";
        desc = "LVDS0_LI_WORD0 is an LVDS DOL mode frame 0 LI register. Hi3516C V300/Hi3516E V100 Professional HD IP Camera SoC

Data sheet 9.3.6 LVDS0_LI_WORD0 (offset 0x1420, printed page 9-219, `hi3516cv300--Hi3516CV300-Hi3516EV100-Datasheet.txt` line 40201).";

        field {
            name = "li_word0_1";
            desc = "LEF line information in DOL mode (for frame N + 1)";
            sw = rw;
            hw = r;
            reset = 0x211;
        } li_word0_1[31:16];

        field {
            name = "li_word0_0";
            desc = "LEF line information in DOL mode (for frame N)";
            sw = rw;
            hw = r;
            reset = 0x201;
        } li_word0_0[15:0];
    } LVDS0_LI_WORD0 @ 0x1420;

    reg {
        name = "LVDS DOL mode frame 1 LI register";
        desc = "LVDS0_LI_WORD1 is an LVDS DOL mode frame 1 LI register.

Data sheet 9.3.6 LVDS0_LI_WORD1 (offset 0x1424, printed page 9-219, `hi3516cv300--Hi3516CV300-Hi3516EV100-Datasheet.txt` line 40220).";

        field {
            name = "li_word1_1";
            desc = "SEF1 line information in DOL mode (for frame N + 1)";
            sw = rw;
            hw = r;
            reset = 0x212;
        } li_word1_1[31:16];

        field {
            name = "li_word1_0";
            desc = "SEF1 line information in DOL mode (for frame";
            sw = rw;
            hw = r;
            reset = 0x202;
        } li_word1_0[15:0];
    } LVDS0_LI_WORD1 @ 0x1424;

    reg {
        name = "LVDS DOL mode frame 2 LI register";
        desc = "LVDS0_LI_WORD2 is an LVDS DOL mode frame 2 LI register.

Data sheet 9.3.6 LVDS0_LI_WORD2 (offset 0x1428, printed page 9-219, `hi3516cv300--Hi3516CV300-Hi3516EV100-Datasheet.txt` line 40240).";

        field {
            name = "li_word2_1";
            desc = "SEF2 line information in DOL mode (for frame + 1)";
            sw = rw;
            hw = r;
            reset = 0x214;
        } li_word2_1[31:16];

        field {
            name = "li_word2_0";
            desc = "SEF2 line information in DOL mode (for frame";
            sw = rw;
            hw = r;
            reset = 0x204;
        } li_word2_0[15:0];
    } LVDS0_LI_WORD2 @ 0x1428;

    reg {
        name = "LVDS DOL mode frame 3 LI register";
        desc = "LVDS0_LI_WORD3 is an LVDS DOL mode frame 3 LI register.

Data sheet 9.3.6 LVDS0_LI_WORD3 (offset 0x142C, printed page 9-220, `hi3516cv300--Hi3516CV300-Hi3516EV100-Datasheet.txt` line 40265).";

        field {
            name = "li_word3_1";
            desc = "SEF3 line information in DOL mode (for frame + 1)";
            sw = rw;
            hw = r;
            reset = 0x218;
        } li_word3_1[31:16];

        field {
            name = "li_word3_0";
            desc = "SEF3 line information in DOL mode (for frame";
            sw = rw;
            hw = r;
            reset = 0x208;
        } li_word3_0[15:0];
    } LVDS0_LI_WORD3 @ 0x142C;

    reg {
        name = "LVDS LEF image size statistics TIS register";
        desc = "LVDS0_IMGSIZE0_STATIS is an LVDS LEF image size statistics register.

Data sheet 9.3.6 LVDS0_IMGSIZE0_STATIS (offset 0x1500, printed page 9-220, `hi3516cv300--Hi3516CV300-Hi3516EV100-Datasheet.txt` line 40285).";

        field {
            name = "lvds_imgheight0";
            desc = "Height of the image transferred by virtual channel 0 in LVDS or HiSPI mode";
            sw = r;
            hw = w;
            reset = 0x0;
        } lvds_imgheight0[31:16];

        field {
            name = "lvds_imgwidth0";
            desc = "Width of the image transferred by virtual channel 0 in LVDS or HiSPI mode";
            sw = r;
            hw = w;
            reset = 0x0;
        } lvds_imgwidth0[15:0];
    } LVDS0_IMGSIZE0_STATIS @ 0x1500;

    reg {
        name = "LVDS SEF1 image size statistics TIS register";
        desc = "LVDS0_IMGSIZE1_STATIS is an LVDS SEF1 image size statistics register. Hi3516C V300/Hi3516E V100 Professional HD IP Camera SoC

Data sheet 9.3.6 LVDS0_IMGSIZE1_STATIS (offset 0x1504, printed page 9-221, `hi3516cv300--Hi3516CV300-Hi3516EV100-Datasheet.txt` line 40319).";

        field {
            name = "lvds_imgheight1";
            desc = "Height of the image transferred by virtual channel 1 in LVDS or HiSPI mode";
            sw = r;
            hw = w;
            reset = 0x0;
        } lvds_imgheight1[31:16];

        field {
            name = "lvds_imgwidth1";
            desc = "Width of the image transferred by virtual channel 1 in LVDS or HiSPI mode";
            sw = r;
            hw = w;
            reset = 0x0;
        } lvds_imgwidth1[15:0];
    } LVDS0_IMGSIZE1_STATIS @ 0x1504;

    reg {
        name = "LVDS SEF2 image size statistics TIS register";
        desc = "LVDS0_IMGSIZE2_STATIS is an LVDS SEF2 image size statistics register.

Data sheet 9.3.6 LVDS0_IMGSIZE2_STATIS (offset 0x1508, printed page 9-221, `hi3516cv300--Hi3516CV300-Hi3516EV100-Datasheet.txt` line 40342).";

        field {
            name = "lvds_imgheight2";
            desc = "Height of the image transferred by virtual channel 2 in LVDS or HiSPI mode";
            sw = r;
            hw = w;
            reset = 0x0;
        } lvds_imgheight2[31:16];

        field {
            name = "lvds_imgwidth2";
            desc = "Width of the image transferred by virtual channel 2 in LVDS or HiSPI mode";
            sw = r;
            hw = w;
            reset = 0x0;
        } lvds_imgwidth2[15:0];
    } LVDS0_IMGSIZE2_STATIS @ 0x1508;

    reg {
        name = "LVDS SEF3 image size statistics TIS register";
        desc = "LVDS0_IMGSIZE3_STATIS is an LVDS SEF3 image size statistics register. Hi3516C V300/Hi3516E V100 Professional HD IP Camera SoC

Data sheet 9.3.6 LVDS0_IMGSIZE3_STATIS (offset 0x150C, printed page 9-222, `hi3516cv300--Hi3516CV300-Hi3516EV100-Datasheet.txt` line 40375).";

        field {
            name = "lvds_imgheight3";
            desc = "Height of the image transferred by virtual channel 3 in LVDS or HiSPI mode";
            sw = r;
            hw = w;
            reset = 0x0;
        } lvds_imgheight3[31:16];

        field {
            name = "lvds_imgwidth3";
            desc = "Width of the image transferred by virtual channel 3 in LVDS or HiSPI mode";
            sw = r;
            hw = w;
            reset = 0x0;
        } lvds_imgwidth3[15:0];
    } LVDS0_IMGSIZE3_STATIS @ 0x150C;

    reg {
        name = "LVDS read data raw interrupt status W register";
        desc = "LVDS0_CTRL_INT_RAW is an LVDS read data raw interrupt status register.

Data sheet 9.3.6 LVDS0_CTRL_INT_RAW (offset 0x15F0, printed page 9-222, `hi3516cv300--Hi3516CV300-Hi3516EV100-Datasheet.txt` line 40398).";

        enum LVDS0_CTRL_INT_RAW_link0_rderr_raw_enum {
            THERE_NO_RAW = 0 { name = "There No Raw"; desc = "There is no raw interrupt."; };
            THERE_RAW_INTERRUPT = 1 { name = "There Raw Interrupt"; desc = "There is a raw interrupt."; };
        };

        field {
            name = "link0_rderr_raw";
            desc = "Status of the link 0 data read error raw interrupt";
            sw = rw;
            hw = w;
            onwrite = woclr;
            encode = LVDS0_CTRL_INT_RAW_link0_rderr_raw_enum;
            reset = 0x0;
        } link0_rderr_raw[8:8];

        enum LVDS0_CTRL_INT_RAW_link0_wrerr_raw_enum {
            THERE_NO_RAW = 0 { name = "There No Raw"; desc = "There is no raw interrupt."; };
            THERE_RAW_INTERRUPT = 1 { name = "There Raw Interrupt"; desc = "There is a raw interrupt."; };
        };

        field {
            name = "link0_wrerr_raw";
            desc = "Status of the link 0 data write error raw interrupt";
            sw = rw;
            hw = w;
            onwrite = woclr;
            encode = LVDS0_CTRL_INT_RAW_link0_wrerr_raw_enum;
            reset = 0x0;
        } link0_wrerr_raw[7:7];

        enum LVDS0_CTRL_INT_RAW_link0_hsync_err_raw_enum {
            THERE_NO_RAW = 0 { name = "There No Raw"; desc = "There is no raw interrupt."; };
            THERE_RAW_INTERRUPT = 1 { name = "There Raw Interrupt"; desc = "There is a raw interrupt."; };
        };

        field {
            name = "link0_hsync_err_raw";
            desc = "Status of the link 0 hsync error raw interrupt";
            sw = rw;
            hw = w;
            onwrite = woclr;
            encode = LVDS0_CTRL_INT_RAW_link0_hsync_err_raw_enum;
            reset = 0x0;
        } link0_hsync_err_raw[6:6];

        enum LVDS0_CTRL_INT_RAW_link0_vsync_err_raw_enum {
            THERE_NO_RAW = 0 { name = "There No Raw"; desc = "There is no raw interrupt."; };
            THERE_RAW_INTERRUPT = 1 { name = "There Raw Interrupt"; desc = "There is a raw interrupt."; };
        };

        field {
            name = "link0_vsync_err_raw";
            desc = "Status of the link 0 vsync error raw interrupt";
            sw = rw;
            hw = w;
            onwrite = woclr;
            encode = LVDS0_CTRL_INT_RAW_link0_vsync_err_raw_enum;
            reset = 0x0;
        } link0_vsync_err_raw[5:5];

        enum LVDS0_CTRL_INT_RAW_lvds_stat_err_raw_enum {
            THERE_NO_RAW = 0 { name = "There No Raw"; desc = "There is no raw interrupt."; };
            THERE_RAW_INTERRUPT = 1 { name = "There Raw Interrupt"; desc = "There is a raw interrupt."; };
        };

        field {
            name = "lvds_stat_err_raw";
            desc = "Status of the LVDS status error raw interrupt";
            sw = rw;
            hw = w;
            onwrite = woclr;
            encode = LVDS0_CTRL_INT_RAW_lvds_stat_err_raw_enum;
            reset = 0x0;
        } lvds_stat_err_raw[4:4];

        enum LVDS0_CTRL_INT_RAW_lane3_sync_err_raw_enum {
            THERE_NO_RAW = 0 { name = "There No Raw"; desc = "There is no raw interrupt."; };
            THERE_RAW_INTERRUPT = 1 { name = "There Raw Interrupt"; desc = "There is a raw interrupt."; };
        };

        field {
            name = "lane3_sync_err_raw";
            desc = "Status of the lane 3 sync error raw interrupt";
            sw = rw;
            hw = w;
            onwrite = woclr;
            encode = LVDS0_CTRL_INT_RAW_lane3_sync_err_raw_enum;
            reset = 0x0;
        } lane3_sync_err_raw[3:3];

        enum LVDS0_CTRL_INT_RAW_lane2_sync_err_raw_enum {
            THERE_NO_RAW = 0 { name = "There No Raw"; desc = "There is no raw interrupt."; };
            THERE_RAW_INTERRUPT = 1 { name = "There Raw Interrupt"; desc = "There is a raw interrupt."; };
        };

        field {
            name = "lane2_sync_err_raw";
            desc = "Status of the lane 2 sync error raw interrupt";
            sw = rw;
            hw = w;
            onwrite = woclr;
            encode = LVDS0_CTRL_INT_RAW_lane2_sync_err_raw_enum;
            reset = 0x0;
        } lane2_sync_err_raw[2:2];

        enum LVDS0_CTRL_INT_RAW_lane1_sync_err_raw_enum {
            THERE_NO_RAW = 0 { name = "There No Raw"; desc = "There is no raw interrupt."; };
            THERE_RAW_INTERRUPT = 1 { name = "There Raw Interrupt"; desc = "There is a raw interrupt."; };
        };

        field {
            name = "lane1_sync_err_raw";
            desc = "Status of the lane 1 sync error raw interrupt";
            sw = rw;
            hw = w;
            onwrite = woclr;
            encode = LVDS0_CTRL_INT_RAW_lane1_sync_err_raw_enum;
            reset = 0x0;
        } lane1_sync_err_raw[1:1];

        enum LVDS0_CTRL_INT_RAW_lane0_sync_err_raw_enum {
            THERE_NO_RAW = 0 { name = "There No Raw"; desc = "There is no raw interrupt."; };
            THERE_RAW_INTERRUPT = 1 { name = "There Raw Interrupt"; desc = "There is a raw interrupt."; };
        };

        field {
            name = "lane0_sync_err_raw";
            desc = "Status of the lane 0 sync error raw interrupt";
            sw = rw;
            hw = w;
            onwrite = woclr;
            encode = LVDS0_CTRL_INT_RAW_lane0_sync_err_raw_enum;
            reset = 0x0;
        } lane0_sync_err_raw[0:0];
    } LVDS0_CTRL_INT_RAW @ 0x15F0;

    reg {
        name = "LVDS read data interrupt status register";
        desc = "LVDS0_CTRL_INT is an LVDS read data interrupt status register.

Data sheet 9.3.6 LVDS0_CTRL_INT (offset 0x15F4, printed page 9-223, `hi3516cv300--Hi3516CV300-Hi3516EV100-Datasheet.txt` line 40475).";

        enum LVDS0_CTRL_INT_link0_rderr_st_enum {
            THERE_NO_INTERRUPT = 0 { name = "There No Interrupt"; desc = "There is no interrupt."; };
            THERE_INTERRUPT = 1 { name = "There Interrupt"; desc = "There is an interrupt."; };
        };

        field {
            name = "link0_rderr_st";
            desc = "Status of the link 0 data read error interrupt";
            sw = r;
            hw = w;
            encode = LVDS0_CTRL_INT_link0_rderr_st_enum;
            reset = 0x0;
        } link0_rderr_st[8:8];

        enum LVDS0_CTRL_INT_link0_wrerr_st_enum {
            THERE_NO_INTERRUPT = 0 { name = "There No Interrupt"; desc = "There is no interrupt."; };
            THERE_INTERRUPT = 1 { name = "There Interrupt"; desc = "There is an interrupt."; };
        };

        field {
            name = "link0_wrerr_st";
            desc = "Status of the link 0 data write error interrupt";
            sw = r;
            hw = w;
            encode = LVDS0_CTRL_INT_link0_wrerr_st_enum;
            reset = 0x0;
        } link0_wrerr_st[7:7];

        enum LVDS0_CTRL_INT_link0_hsync_err_st_enum {
            THERE_NO_INTERRUPT = 0 { name = "There No Interrupt"; desc = "There is no interrupt."; };
            THERE_INTERRUPT = 1 { name = "There Interrupt"; desc = "There is an interrupt."; };
        };

        field {
            name = "link0_hsync_err_st";
            desc = "Status of the link 0 hsync error interrupt";
            sw = r;
            hw = w;
            encode = LVDS0_CTRL_INT_link0_hsync_err_st_enum;
            reset = 0x0;
        } link0_hsync_err_st[6:6];

        enum LVDS0_CTRL_INT_link0_vsync_err_st_enum {
            THERE_NO_INTERRUPT = 0 { name = "There No Interrupt"; desc = "There is no interrupt."; };
            THERE_INTERRUPT = 1 { name = "There Interrupt"; desc = "There is an interrupt."; };
        };

        field {
            name = "link0_vsync_err_st";
            desc = "Status of the link 0 vsync error interrupt";
            sw = r;
            hw = w;
            encode = LVDS0_CTRL_INT_link0_vsync_err_st_enum;
            reset = 0x0;
        } link0_vsync_err_st[5:5];

        enum LVDS0_CTRL_INT_lvds_stat_err_st_enum {
            THERE_NO_INTERRUPT = 0 { name = "There No Interrupt"; desc = "There is no interrupt."; };
            THERE_INTERRUPT = 1 { name = "There Interrupt"; desc = "There is an interrupt."; };
        };

        field {
            name = "lvds_stat_err_st";
            desc = "Status of the LVDS status error interrupt";
            sw = r;
            hw = w;
            encode = LVDS0_CTRL_INT_lvds_stat_err_st_enum;
            reset = 0x0;
        } lvds_stat_err_st[4:4];

        enum LVDS0_CTRL_INT_lane3_sync_err_st_enum {
            THERE_NO_INTERRUPT = 0 { name = "There No Interrupt"; desc = "There is no interrupt."; };
            THERE_INTERRUPT = 1 { name = "There Interrupt"; desc = "There is an interrupt."; };
        };

        field {
            name = "lane3_sync_err_st";
            desc = "Status of the lane 3 sync error interrupt";
            sw = r;
            hw = w;
            encode = LVDS0_CTRL_INT_lane3_sync_err_st_enum;
            reset = 0x0;
        } lane3_sync_err_st[3:3];

        enum LVDS0_CTRL_INT_lane2_sync_err_st_enum {
            THERE_NO_INTERRUPT = 0 { name = "There No Interrupt"; desc = "There is no interrupt."; };
            THERE_INTERRUPT = 1 { name = "There Interrupt"; desc = "There is an interrupt."; };
        };

        field {
            name = "lane2_sync_err_st";
            desc = "Status of the lane 2 sync error interrupt";
            sw = r;
            hw = w;
            encode = LVDS0_CTRL_INT_lane2_sync_err_st_enum;
            reset = 0x0;
        } lane2_sync_err_st[2:2];

        enum LVDS0_CTRL_INT_lane1_sync_err_st_enum {
            THERE_NO_INTERRUPT = 0 { name = "There No Interrupt"; desc = "There is no interrupt."; };
            THERE_INTERRUPT = 1 { name = "There Interrupt"; desc = "There is an interrupt."; };
        };

        field {
            name = "lane1_sync_err_st";
            desc = "Status of the lane 1 sync error interrupt";
            sw = r;
            hw = w;
            encode = LVDS0_CTRL_INT_lane1_sync_err_st_enum;
            reset = 0x0;
        } lane1_sync_err_st[1:1];

        enum LVDS0_CTRL_INT_lane0_sync_err_st_enum {
            THERE_NO_INTERRUPT = 0 { name = "There No Interrupt"; desc = "There is no interrupt."; };
            THERE_INTERRUPT = 1 { name = "There Interrupt"; desc = "There is an interrupt."; };
        };

        field {
            name = "lane0_sync_err_st";
            desc = "Status of the lane 0 sync error interrupt";
            sw = r;
            hw = w;
            encode = LVDS0_CTRL_INT_lane0_sync_err_st_enum;
            reset = 0x0;
        } lane0_sync_err_st[0:0];
    } LVDS0_CTRL_INT @ 0x15F4;

    reg {
        name = "LVDS read data interrupt mask register";
        desc = "LVDS0_CTRL_INT_MSK is an LVDS read data interrupt mask register.

Data sheet 9.3.6 LVDS0_CTRL_INT_MSK (offset 0x15F8, printed page 9-224, `hi3516cv300--Hi3516CV300-Hi3516EV100-Datasheet.txt` line 40538).";

        enum LVDS0_CTRL_INT_MSK_link0_rderr_msk_enum {
            MASKED = 0 { name = "Masked"; desc = "masked"; };
            ENABLED = 1 { name = "Enabled"; desc = "enabled"; };
        };

        field {
            name = "link0_rderr_msk";
            desc = "Link 0 data read error interrupt enable";
            sw = rw;
            hw = r;
            encode = LVDS0_CTRL_INT_MSK_link0_rderr_msk_enum;
            reset = 0x0;
        } link0_rderr_msk[8:8];

        enum LVDS0_CTRL_INT_MSK_link0_wrerr_msk_enum {
            MASKED = 0 { name = "Masked"; desc = "masked"; };
            ENABLED = 1 { name = "Enabled"; desc = "enabled"; };
        };

        field {
            name = "link0_wrerr_msk";
            desc = "Link 0 data write error interrupt enable";
            sw = rw;
            hw = r;
            encode = LVDS0_CTRL_INT_MSK_link0_wrerr_msk_enum;
            reset = 0x0;
        } link0_wrerr_msk[7:7];

        enum LVDS0_CTRL_INT_MSK_link0_hsync_err_msk_enum {
            MASKED = 0 { name = "Masked"; desc = "masked"; };
            ENABLED = 1 { name = "Enabled"; desc = "enabled"; };
        };

        field {
            name = "link0_hsync_err_msk";
            desc = "Link 0 hsync error interrupt enable";
            sw = rw;
            hw = r;
            encode = LVDS0_CTRL_INT_MSK_link0_hsync_err_msk_enum;
            reset = 0x0;
        } link0_hsync_err_msk[6:6];

        enum LVDS0_CTRL_INT_MSK_link0_vsync_err_msk_enum {
            MASKED = 0 { name = "Masked"; desc = "masked"; };
            ENABLED = 1 { name = "Enabled"; desc = "enabled"; };
        };

        field {
            name = "link0_vsync_err_msk";
            desc = "Link 0 vsync error interrupt enable";
            sw = rw;
            hw = r;
            encode = LVDS0_CTRL_INT_MSK_link0_vsync_err_msk_enum;
            reset = 0x0;
        } link0_vsync_err_msk[5:5];

        enum LVDS0_CTRL_INT_MSK_lvds_stat_err_st_msk_enum {
            MASKED = 0 { name = "Masked"; desc = "masked"; };
            ENABLED = 1 { name = "Enabled"; desc = "enabled"; };
        };

        field {
            name = "lvds_stat_err_st_msk";
            desc = "LVDS status error interrupt enable";
            sw = rw;
            hw = r;
            encode = LVDS0_CTRL_INT_MSK_lvds_stat_err_st_msk_enum;
            reset = 0x0;
        } lvds_stat_err_st_msk[4:4];

        enum LVDS0_CTRL_INT_MSK_lane3_sync_err_msk_enum {
            MASKED = 0 { name = "Masked"; desc = "masked"; };
            ENABLED = 1 { name = "Enabled"; desc = "enabled"; };
        };

        field {
            name = "lane3_sync_err_msk";
            desc = "Lane 3 sync error interrupt enable";
            sw = rw;
            hw = r;
            encode = LVDS0_CTRL_INT_MSK_lane3_sync_err_msk_enum;
            reset = 0x0;
        } lane3_sync_err_msk[3:3];

        enum LVDS0_CTRL_INT_MSK_lane2_sync_err_msk_enum {
            MASKED = 0 { name = "Masked"; desc = "masked"; };
            ENABLED = 1 { name = "Enabled"; desc = "enabled"; };
        };

        field {
            name = "lane2_sync_err_msk";
            desc = "Lane 2 sync error interrupt enable";
            sw = rw;
            hw = r;
            encode = LVDS0_CTRL_INT_MSK_lane2_sync_err_msk_enum;
            reset = 0x0;
        } lane2_sync_err_msk[2:2];

        enum LVDS0_CTRL_INT_MSK_lane1_sync_err_msk_enum {
            MASKED = 0 { name = "Masked"; desc = "masked"; };
            ENABLED = 1 { name = "Enabled"; desc = "enabled"; };
        };

        field {
            name = "lane1_sync_err_msk";
            desc = "Lane 1 sync error interrupt enable";
            sw = rw;
            hw = r;
            encode = LVDS0_CTRL_INT_MSK_lane1_sync_err_msk_enum;
            reset = 0x0;
        } lane1_sync_err_msk[1:1];

        enum LVDS0_CTRL_INT_MSK_lane0_sync_err_msk_enum {
            MASKED = 0 { name = "Masked"; desc = "masked"; };
            ENABLED = 1 { name = "Enabled"; desc = "enabled"; };
        };

        field {
            name = "lane0_sync_err_msk";
            desc = "Lane 0 sync error interrupt enable";
            sw = rw;
            hw = r;
            encode = LVDS0_CTRL_INT_MSK_lane0_sync_err_msk_enum;
            reset = 0x0;
        } lane0_sync_err_msk[0:0];
    } LVDS0_CTRL_INT_MSK @ 0x15F8;

    reg {
        name = "Link 0 lane priority configuration register";
        desc = "ALIGN0_LANE_ID is a link 0 lane priority configuration register. Hi3516C V300/Hi3516E V100 Professional HD IP Camera SoC

Data sheet 9.3.6 ALIGN0_LANE_ID (offset 0x1600, printed page 9-226, `hi3516cv300--Hi3516CV300-Hi3516EV100-Datasheet.txt` line 40622).";

        field {
            name = "lane3_id";
            desc = "Lane 3 channel ID Value range: 0-3 The field value indicates the ID of image sensor channel connected to lane 3.";
            sw = rw;
            hw = r;
            reset = 0x3;
        } lane3_id[15:12];

        field {
            name = "lane2_id";
            desc = "Lane 2 channel ID Value range: 0-3 The field value indicates the ID of image sensor channel connected to lane 2.";
            sw = rw;
            hw = r;
            reset = 0x2;
        } lane2_id[11:8];

        field {
            name = "lane1_id";
            desc = "Lane 1 channel ID Value range: 0-3 The field value indicates the ID of image sensor channel connected to lane 1.";
            sw = rw;
            hw = r;
            reset = 0x1;
        } lane1_id[7:4];

        field {
            name = "lane0_id";
            desc = "Lane 0 channel ID Value range: 0-3 The field value indicates the ID of image sensor channel connected to lane 0.";
            sw = rw;
            hw = r;
            reset = 0x0;
        } lane0_id[3:0];
    } ALIGN0_LANE_ID @ 0x1600;

    reg {
        name = "MIPI_ALIGN raw interrupt status register";
        desc = "ALIGN0_INT_RAW is an MIPI_ALIGN raw interrupt status register.

Data sheet 9.3.6 ALIGN0_INT_RAW (offset 0x16F0, printed page 9-226, `hi3516cv300--Hi3516CV300-Hi3516EV100-Datasheet.txt` line 40660).";

        enum ALIGN0_INT_RAW_err_full_raw_enum {
            NO_RAW_INTERRUPT = 0 { name = "No Raw Interrupt"; desc = "No raw interrupt is generated."; };
            RAW_INTERRUPT_GENERATED = 1 { name = "Raw Interrupt Generated"; desc = "A raw interrupt is generated."; };
        };

        field {
            name = "err_full_raw";
            desc = "MIPI_ALIGN FIFO raw interrupt status";
            sw = rw;
            hw = w;
            onwrite = woclr;
            encode = ALIGN0_INT_RAW_err_full_raw_enum;
            reset = 0x0;
        } err_full_raw[4:4];

        enum ALIGN0_INT_RAW_err_lane3_raw_enum {
            NO_RAW_INTERRUPT = 0 { name = "No Raw Interrupt"; desc = "No raw interrupt is generated."; };
            RAW_INTERRUPT_GENERATED = 1 { name = "Raw Interrupt Generated"; desc = "A raw interrupt is generated."; };
        };

        field {
            name = "err_lane3_raw";
            desc = "MIPI_ALIGN lane 3 raw interrupt status";
            sw = rw;
            hw = w;
            onwrite = woclr;
            encode = ALIGN0_INT_RAW_err_lane3_raw_enum;
            reset = 0x0;
        } err_lane3_raw[3:3];

        enum ALIGN0_INT_RAW_err_lane2_raw_enum {
            NO_RAW_INTERRUPT = 0 { name = "No Raw Interrupt"; desc = "No raw interrupt is generated."; };
            RAW_INTERRUPT_GENERATED = 1 { name = "Raw Interrupt Generated"; desc = "A raw interrupt is generated."; };
        };

        field {
            name = "err_lane2_raw";
            desc = "MIPI_ALIGN lane 2 raw interrupt status";
            sw = rw;
            hw = w;
            onwrite = woclr;
            encode = ALIGN0_INT_RAW_err_lane2_raw_enum;
            reset = 0x0;
        } err_lane2_raw[2:2];

        enum ALIGN0_INT_RAW_err_lane1_raw_enum {
            NO_RAW_INTERRUPT = 0 { name = "No Raw Interrupt"; desc = "No raw interrupt is generated."; };
            RAW_INTERRUPT_GENERATED = 1 { name = "Raw Interrupt Generated"; desc = "A raw interrupt is generated."; };
        };

        field {
            name = "err_lane1_raw";
            desc = "MIPI_ALIGN lane 1 raw interrupt status";
            sw = rw;
            hw = w;
            onwrite = woclr;
            encode = ALIGN0_INT_RAW_err_lane1_raw_enum;
            reset = 0x0;
        } err_lane1_raw[1:1];

        enum ALIGN0_INT_RAW_err_lane0_raw_enum {
            NO_RAW_INTERRUPT = 0 { name = "No Raw Interrupt"; desc = "No raw interrupt is generated."; };
            RAW_INTERRUPT_GENERATED = 1 { name = "Raw Interrupt Generated"; desc = "A raw interrupt is generated."; };
        };

        field {
            name = "err_lane0_raw";
            desc = "MIPI_ALIGN lane 0 raw interrupt status";
            sw = rw;
            hw = w;
            onwrite = woclr;
            encode = ALIGN0_INT_RAW_err_lane0_raw_enum;
            reset = 0x0;
        } err_lane0_raw[0:0];
    } ALIGN0_INT_RAW @ 0x16F0;

    reg {
        name = "MIPI_ALIGN interrupt status register";
        desc = "ALIGN0_INT is an MIPI_ALIGN interrupt status register.

Data sheet 9.3.6 ALIGN0_INT (offset 0x16F4, printed page 9-227, `hi3516cv300--Hi3516CV300-Hi3516EV100-Datasheet.txt` line 40707).";

        enum ALIGN0_INT_err_full_st_enum {
            NO_INTERRUPT_GENERATED = 0 { name = "No Interrupt Generated"; desc = "No interrupt is generated."; };
            INTERRUPT_GENERATED = 1 { name = "Interrupt Generated"; desc = "An interrupt is generated."; };
        };

        field {
            name = "err_full_st";
            desc = "MIPI_ALIGN FIFO interrupt status";
            sw = r;
            hw = w;
            encode = ALIGN0_INT_err_full_st_enum;
            reset = 0x0;
        } err_full_st[4:4];

        enum ALIGN0_INT_err_lane3_st_enum {
            NO_INTERRUPT_GENERATED = 0 { name = "No Interrupt Generated"; desc = "No interrupt is generated."; };
            INTERRUPT_GENERATED = 1 { name = "Interrupt Generated"; desc = "An interrupt is generated."; };
        };

        field {
            name = "err_lane3_st";
            desc = "MIPI_ALIGN lane 3 interrupt status";
            sw = r;
            hw = w;
            encode = ALIGN0_INT_err_lane3_st_enum;
            reset = 0x0;
        } err_lane3_st[3:3];

        enum ALIGN0_INT_err_lane2_st_enum {
            NO_INTERRUPT_GENERATED = 0 { name = "No Interrupt Generated"; desc = "No interrupt is generated."; };
            INTERRUPT_GENERATED = 1 { name = "Interrupt Generated"; desc = "An interrupt is generated."; };
        };

        field {
            name = "err_lane2_st";
            desc = "MIPI_ALIGN lane 2 interrupt status";
            sw = r;
            hw = w;
            encode = ALIGN0_INT_err_lane2_st_enum;
            reset = 0x0;
        } err_lane2_st[2:2];

        enum ALIGN0_INT_err_lane1_st_enum {
            NO_INTERRUPT_GENERATED = 0 { name = "No Interrupt Generated"; desc = "No interrupt is generated."; };
            INTERRUPT_GENERATED = 1 { name = "Interrupt Generated"; desc = "An interrupt is generated."; };
        };

        field {
            name = "err_lane1_st";
            desc = "MIPI_ALIGN lane 1 interrupt status";
            sw = r;
            hw = w;
            encode = ALIGN0_INT_err_lane1_st_enum;
            reset = 0x0;
        } err_lane1_st[1:1];

        enum ALIGN0_INT_err_lane0_st_enum {
            NO_INTERRUPT_GENERATED = 0 { name = "No Interrupt Generated"; desc = "No interrupt is generated."; };
            INTERRUPT_GENERATED = 1 { name = "Interrupt Generated"; desc = "An interrupt is generated."; };
        };

        field {
            name = "err_lane0_st";
            desc = "MIPI_ALIGN lane 0 interrupt status";
            sw = r;
            hw = w;
            encode = ALIGN0_INT_err_lane0_st_enum;
            reset = 0x0;
        } err_lane0_st[0:0];
    } ALIGN0_INT @ 0x16F4;

    reg {
        name = "MIPI_ALIGN interrupt mask register";
        desc = "ALIGN0_INT_MSK is an MIPI_ALIGN interrupt mask register.

Data sheet 9.3.6 ALIGN0_INT_MSK (offset 0x16F8, printed page 9-228, `hi3516cv300--Hi3516CV300-Hi3516EV100-Datasheet.txt` line 40759).";

        enum ALIGN0_INT_MSK_err_full_mask_enum {
            MASKED = 0 { name = "Masked"; desc = "masked"; };
            ENABLED = 1 { name = "Enabled"; desc = "enabled"; };
        };

        field {
            name = "err_full_mask";
            desc = "MIPI_ALIGN FIFO interrupt enable";
            sw = rw;
            hw = r;
            encode = ALIGN0_INT_MSK_err_full_mask_enum;
            reset = 0x0;
        } err_full_mask[4:4];

        enum ALIGN0_INT_MSK_err_lane3_mask_enum {
            MASKED = 0 { name = "Masked"; desc = "masked"; };
            ENABLED = 1 { name = "Enabled"; desc = "enabled"; };
        };

        field {
            name = "err_lane3_mask";
            desc = "MIPI_ALIGN lane 3 interrupt enable";
            sw = rw;
            hw = r;
            encode = ALIGN0_INT_MSK_err_lane3_mask_enum;
            reset = 0x0;
        } err_lane3_mask[3:3];

        enum ALIGN0_INT_MSK_err_lane2_mask_enum {
            MASKED = 0 { name = "Masked"; desc = "masked"; };
            ENABLED = 1 { name = "Enabled"; desc = "enabled"; };
        };

        field {
            name = "err_lane2_mask";
            desc = "MIPI_ALIGN lane 2 interrupt enable";
            sw = rw;
            hw = r;
            encode = ALIGN0_INT_MSK_err_lane2_mask_enum;
            reset = 0x0;
        } err_lane2_mask[2:2];

        enum ALIGN0_INT_MSK_err_lane1_mask_enum {
            MASKED = 0 { name = "Masked"; desc = "masked"; };
            ENABLED = 1 { name = "Enabled"; desc = "enabled"; };
        };

        field {
            name = "err_lane1_mask";
            desc = "MIPI_ALIGN lane 1 interrupt enable";
            sw = rw;
            hw = r;
            encode = ALIGN0_INT_MSK_err_lane1_mask_enum;
            reset = 0x0;
        } err_lane1_mask[1:1];

        enum ALIGN0_INT_MSK_err_lane0_mask_enum {
            MASKED = 0 { name = "Masked"; desc = "masked"; };
            ENABLED = 1 { name = "Enabled"; desc = "enabled"; };
        };

        field {
            name = "err_lane0_mask";
            desc = "MIPI_ALIGN lane 0 interrupt enable";
            sw = rw;
            hw = r;
            encode = ALIGN0_INT_MSK_err_lane0_mask_enum;
            reset = 0x0;
        } err_lane0_mask[0:0];
    } ALIGN0_INT_MSK @ 0x16F8;
};

`endif
