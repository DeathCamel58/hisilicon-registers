`ifndef HISI_AIAO_RDL
`define HISI_AIAO_RDL

// AIAO (audio input/output, I2S/PCM, one RX + one TX port) of the Hi3518EV200 / Hi3516CV200 (data sheet 11.1) and of the other chips of the same generation.
// Cross-chip audit (register tables compared offset by offset and bit by bit with the extracted data sheet tables):
//   Hi3516AV200 (issue 06? chapter 11, base 0x1108_0000, GIC 68), Hi3519V101 (chapter 11, 0x1108_0000, GIC 68) and Hi3516CV300/Hi3516EV100 (chapter 11, 0x1131_0000, VIC 9):
//     identical to the Hi3518EV200 tables (same 31 registers, same bits, access and resets, same three data sheet typos); the shared definition needs no macro.
//   Hi3516AV300 (Chinese issue 01, chapter 11, base 0x113B_0000, GIC 87): same tables plus a second TX channel (tx_ch1 bits 17 of the three AIAO_INT_* registers) and its
//     clock generator I2S_CRG_CFG0_09/CFG1_09 at 0x148/0x14C: define `AIAO_TX1` in the chip's defines.rdl.
//   Hi3516A/Hi3516D (issue 08, chapter 12 'AIO', base 0x2065_0000, GIC 71): older edition of the same IP with 41 registers: adds AIAO_SWITCH_RX_BCLK/AIAO_SWITCH_TX_BCLK/AIAO_STATUS,
//     RX_WPTR_TMP, TX_DSP_STATUS/TX_IF_STATUS/TX_DMAR_STATUS/TX_WS_CNT/TX_BCLK_CNT, TX_RPTR_TMP; I2S_CRG_CFG1_xx has six more control bits ([15:10]) and resets to 0 instead of
//     0x131; RX_IF_ATTRI/TX_IF_ATTRI name the serial data line selects (sd0..sd3_sel, [31:24], reset 0xE4 = the bits this file models as reserved_b31_24 for the Hi3518EV200),
//     rx_multislot_en [7], tx_underflow_ctrl [6], and rx_ch_num is 2 bits ([5:4]): define `AIAO_HI3516A`. Its RX_DSP_CTRL table claims reset 0 and RW for disable_done
//     (the TX_DSP_CTRL table of the same edition and all later editions say 0x2000_0000 / RO), kept as the later editions say.
regfile eHISI_AIAO {
    name = "AIAO (audio input/output)";
    desc = "
    Audio input/output (AIAO) of the Hi3518E V20X / Hi3516C V200 at 0x20650000 (data sheet 11.1), VIC interrupt 9: one audio input port (RX 0 / AIP, pins I2S_SD_RX) and one audio output port
    (TX 0 / AOP, I2S_SD_TX), I2S (16/24-bit stereo, 8-192 kHz) or PCM (16-bit, short frame sync) in master mode, each with its own clock generator (I2S_CRG_CFG0/1_00 for RX, _08 for TX: MCLK,
    BCLK and WS dividers; the I2S_MCLK / I2S_RX_WS / I2S_RX_BCLK pins come from the RX generator in the block diagram). Data moves by DMA between a cyclic DDR buffer (SADDR / SIZE / WPTR /
    RPTR / threshold / TRANS_SIZE per direction) and the port; interrupts per direction (transfer done, buffer full/empty, almost full/empty, bus FIFO over/underflow, stop, TX mute fade done) are
    enabled in RX_INT_ENA / TX_INT_ENA and gated by AIAO_INT_ENA. The on-chip audio CODEC is controlled through the MISC_CTRL registers at 0x20120000 + 0xC4..0xD8 (data sheet 11.2, `eHISI_MISC_CTRL`),
    not through this block.

    This is the AIAO generation of the Hi3516CV300 / Hi3519V101 / Hi3516AV200 (register names RX_IF_ATTRI, RX_DSP_CTRL, TX_DSP_CTRL with volume/fade, I2S_CRG_CFG), whose data sheets
    give exactly the same register tables; the Hi3516AV300 (second TX channel, `AIAO_TX1`) and the older Hi3516A/Hi3516D (`AIAO_HI3516A`, extra status registers and control bits) variants are
    macro-guarded in this file (see the file header). It is NOT the AIP/AOP layout of the Hi3520D (`eHISI_AIO`) nor the FIFO-based SIO of the Hi3511/Hi3515/Hi3520 (`eHISI_SIO`). Vendor drivers for it are binary (`mpp` libraries); nothing in the local trees; no hardware verification. Register table: data sheet 11.1.5 / 11.1.6 (`hi3518ev200--Hi3518EV20X-Hi3516CV200-Datasheet.txt`
    lines 75750-77294), 31 registers; the three data sheet typos corrected are listed in the register descriptions.
    ";

    reg {
        name = "AIAO interrupt enable register";
        desc = "AIAO_INT_ENA is an AIAO interrupt enable register.

Top-level interrupt enable (VIC interrupt 9 'AIAO'); the per-channel causes are enabled in RX_INT_ENA / TX_INT_ENA.

Data sheet 11.1.6 AIAO_INT_ENA (offset 0x0, printed page 11-9, `hi3518ev200--Hi3518EV20X-Hi3516CV200-Datasheet.txt` line 75833).";

        enum AIAO_INT_ENA_tx_ch0_int_ena_enum {
            DISABLED = 0 { name = "Disabled"; desc = "disabled"; };
            ENABLED = 1 { name = "Enabled"; desc = "enabled"; };
        };

`ifdef AIAO_TX1
        field {
            name = "tx_ch1_int_ena";
            desc = "TX channel 1 interrupt enable (Hi3516AV300 only: second TX channel; data sheet 11.1 AIAO_INT_ENA bit 17).";
            sw = rw;
            hw = r;
            encode = AIAO_INT_ENA_tx_ch0_int_ena_enum;
            reset = 0x0;
        } tx_ch1_int_ena[17:17];
`endif
        field {
            name = "tx_ch0_int_ena";
            desc = "TX channel 0 interrupt enable";
            sw = rw;
            hw = r;
            encode = AIAO_INT_ENA_tx_ch0_int_ena_enum;
            reset = 0x0;
        } tx_ch0_int_ena[16:16];

        enum AIAO_INT_ENA_rx_ch0_int_ena_enum {
            DISABLED = 0 { name = "Disabled"; desc = "disabled"; };
            ENABLED = 1 { name = "Enabled"; desc = "enabled"; };
        };

        field {
            name = "rx_ch0_int_ena";
            desc = "RX channel 0 interrupt enable";
            sw = rw;
            hw = r;
            encode = AIAO_INT_ENA_rx_ch0_int_ena_enum;
            reset = 0x0;
        } rx_ch0_int_ena[0:0];
    } AIAO_INT_ENA @ 0x0;

    reg {
        name = "AIAO interrupt status register";
        desc = "AIAO_INT_STATUS is an AIAO interrupt status register.

Data sheet 11.1.6 AIAO_INT_STATUS (offset 0x4, printed page 11-9, `hi3518ev200--Hi3518EV20X-Hi3516CV200-Datasheet.txt` line 75865).";

        enum AIAO_INT_STATUS_tx_ch0_int_status_enum {
            NO_INTERRUPT_GENERATED = 0 { name = "No Interrupt Generated"; desc = "No interrupt is generated."; };
            INTERRUPT_GENERATED = 1 { name = "Interrupt Generated"; desc = "An interrupt is generated."; };
        };

`ifdef AIAO_TX1
        field {
            name = "tx_ch1_int_status";
            desc = "Interrupt status of TX channel 1 (Hi3516AV300 only: second TX channel; data sheet 11.1 AIAO_INT_STATUS bit 17).";
            sw = r;
            hw = w;
            encode = AIAO_INT_STATUS_tx_ch0_int_status_enum;
            reset = 0x0;
        } tx_ch1_int_status[17:17];
`endif
        field {
            name = "tx_ch0_int_status";
            desc = "Interrupt status of TX channel 0";
            sw = r;
            hw = w;
            encode = AIAO_INT_STATUS_tx_ch0_int_status_enum;
            reset = 0x0;
        } tx_ch0_int_status[16:16];

        enum AIAO_INT_STATUS_rx_ch0_int_status_enum {
            NO_INTERRUPT_GENERATED = 0 { name = "No Interrupt Generated"; desc = "No interrupt is generated."; };
            INTERRUPT_GENERATED = 1 { name = "Interrupt Generated"; desc = "An interrupt is generated."; };
        };

        field {
            name = "rx_ch0_int_status";
            desc = "Interrupt status of RX channel 0";
            sw = r;
            hw = w;
            encode = AIAO_INT_STATUS_rx_ch0_int_status_enum;
            reset = 0x0;
        } rx_ch0_int_status[0:0];
    } AIAO_INT_STATUS @ 0x4;

    reg {
        name = "AIAO raw interrupt register";
        desc = "AIAO_INT_RAW is an AIAO raw interrupt register.

Data sheet 11.1.6 AIAO_INT_RAW (offset 0x8, printed page 11-10, `hi3518ev200--Hi3518EV20X-Hi3516CV200-Datasheet.txt` line 75906).";

        enum AIAO_INT_RAW_tx_ch0_int_raw_enum {
            NO_RAW_INTERRUPT = 0 { name = "No Raw Interrupt"; desc = "No raw interrupt is generated."; };
            RAW_INTERRUPT_GENERATED = 1 { name = "Raw Interrupt Generated"; desc = "A raw interrupt is generated."; };
        };

`ifdef AIAO_TX1
        field {
            name = "tx_ch1_int_raw";
            desc = "Raw interrupt of TX channel 1 (Hi3516AV300 only: second TX channel; data sheet 11.1 AIAO_INT_RAW bit 17).";
            sw = r;
            hw = w;
            encode = AIAO_INT_RAW_tx_ch0_int_raw_enum;
            reset = 0x0;
        } tx_ch1_int_raw[17:17];
`endif
        field {
            name = "tx_ch0_int_raw";
            desc = "Raw interrupt of TX channel 0";
            sw = r;
            hw = w;
            encode = AIAO_INT_RAW_tx_ch0_int_raw_enum;
            reset = 0x0;
        } tx_ch0_int_raw[16:16];

        enum AIAO_INT_RAW_rx_ch0_int_raw_enum {
            NO_RAW_INTERRUPT = 0 { name = "No Raw Interrupt"; desc = "No raw interrupt is generated."; };
            RAW_INTERRUPT_GENERATED = 1 { name = "Raw Interrupt Generated"; desc = "A raw interrupt is generated."; };
        };

        field {
            name = "rx_ch0_int_raw";
            desc = "Raw interrupt of RX channel 0";
            sw = r;
            hw = w;
            encode = AIAO_INT_RAW_rx_ch0_int_raw_enum;
            reset = 0x0;
        } rx_ch0_int_raw[0:0];
    } AIAO_INT_RAW @ 0x8;

`ifdef AIAO_HI3516A
    reg {
        name = "AIAO I2S RX BCLK switch configuration register";
        desc = "AIAO_SWITCH_RX_BCLK is an AIAO I2S RX BCLK switch configuration register (Hi3516A/Hi3516D only). Total reset value 0x7654_3210: the data sheet marks bits 31:4 'reserved' but gives them the reset 0x7654321, i.e. the register is a bank of eight 4-bit selects of which only the first (RX 00) is documented.
Data sheet 12.3 AIAO_SWITCH_RX_BCLK (offset 0x28, printed page 12-11, `hi3516av100--Hi3516A-Hi3516D-Datasheet.txt` line 84598).";

        field {
            name = "reserved_b31_4";
            desc = "Reserved in the data sheet (RW, reset 0x7654321; by the pattern these are the BCLK selects of RX channels 01..07 of the full 8-channel IP).";
            sw = rw;
            hw = r;
            reset = 0x7654321;
        } reserved_b31_4[31:4];

        enum AIAO_SWITCH_RX_BCLK_inner_bclk_ws_sel_rx_00_enum {
            BCLK0 = 0 { name = "BCLK0"; desc = "BCLK0 (the RX clock generator I2S_CRG_CFGx_00)"; };
            BCLK8 = 8 { name = "BCLK8"; desc = "BCLK8 (the TX clock generator I2S_CRG_CFGx_08). Other values: reserved"; };
        };

        field {
            name = "inner_bclk_ws_sel_rx_00";
            desc = "Internal BCLK select for the RX channel.";
            sw = rw;
            hw = r;
            encode = AIAO_SWITCH_RX_BCLK_inner_bclk_ws_sel_rx_00_enum;
            reset = 0x0;
        } inner_bclk_ws_sel_rx_00[3:0];
    } AIAO_SWITCH_RX_BCLK @ 0x28;

    reg {
        name = "AIAO I2S TX BCLK switch configuration register";
        desc = "AIAO_SWITCH_TX_BCLK is an AIAO I2S TX BCLK switch configuration register (Hi3516A/Hi3516D only). Total reset value 0x7654_3210 (see AIAO_SWITCH_RX_BCLK).
Data sheet 12.3 AIAO_SWITCH_TX_BCLK (offset 0x2C, printed page 12-11, `hi3516av100--Hi3516A-Hi3516D-Datasheet.txt` line 84633).";

        field {
            name = "reserved_b31_4";
            desc = "Reserved in the data sheet (RW, reset 0x7654321; by the pattern the BCLK selects of TX channels 01..07 of the full 8-channel IP).";
            sw = rw;
            hw = r;
            reset = 0x7654321;
        } reserved_b31_4[31:4];

        enum AIAO_SWITCH_TX_BCLK_inner_bclk_ws_sel_tx_00_enum {
            BCLK0 = 0 { name = "BCLK0"; desc = "BCLK0 (the RX clock generator I2S_CRG_CFGx_00)"; };
            BCLK8 = 8 { name = "BCLK8"; desc = "BCLK8 (the TX clock generator I2S_CRG_CFGx_08). Other values: reserved"; };
        };

        field {
            name = "inner_bclk_ws_sel_tx_00";
            desc = "Internal BCLK select for the TX channel.";
            sw = rw;
            hw = r;
            encode = AIAO_SWITCH_TX_BCLK_inner_bclk_ws_sel_tx_00_enum;
            reset = 0x0;
        } inner_bclk_ws_sel_tx_00[3:0];
    } AIAO_SWITCH_TX_BCLK @ 0x2C;

    reg {
        name = "AIAO status register";
        desc = "AIAO_STATUS is an AIAO status register (Hi3516A/Hi3516D only).
Data sheet 12.3 AIAO_STATUS (offset 0x30, printed page 12-12, `hi3516av100--Hi3516A-Hi3516D-Datasheet.txt` line 84658).";

        enum AIAO_STATUS_srst_rdy_enum {
            RESETTING = 0 { name = "Resetting"; desc = "resetting"; };
            RESET_COMPLETED = 1 { name = "Reset Completed"; desc = "reset completed"; };
        };

        field {
            name = "srst_rdy";
            desc = "Soft reset status.";
            sw = r;
            hw = w;
            encode = AIAO_STATUS_srst_rdy_enum;
            reset = 0x0;
        } srst_rdy[0:0];
    } AIAO_STATUS @ 0x30;
`endif

    reg {
        name = "I2S00 CRG configuration register 0";
        desc = "I2S_CRG_CFG0_00 is I2S00 CRG configuration register 0.

Data sheet 11.1.6 I2S_CRG_CFG0_00 (offset 0x100, printed page 11-10, `hi3518ev200--Hi3518EV20X-Hi3516CV200-Datasheet.txt` line 75938).";

        field {
            name = "aiao_mclk_div";
            desc = "Configured value of the frequency division clock of the MCLK: (target MCLK frequency / frequency of the MCLK clock source) x 2^27. The MCLK clock source is the AIAO PLL output selected in PERI_CRG (data sheet 3.2); reset 0x00AA_AAAA = 1/3 of the source.";
            sw = rw;
            hw = r;
            reset = 0x00AAAAAA;
        } aiao_mclk_div[26:0];
    } I2S_CRG_CFG0_00 @ 0x100;

    reg {
        name = "I2S00 CRG configuration register 1";
        desc = "I2S_CRG_CFG1_00 is I2S00 CRG configuration register 1.

Clock generator of the RX (AIP, 'CRG00') port: MCLK (I2S_CRG_CFG0_00) -> BCLK (aiao_bclk_div) -> WS / sampling clock (aiao_fsclk_div). Total reset value 0x131: cken 1, fsclk_div 3 (BCLK/64), bclk_div 1 (MCLK/3). Hi3516A/Hi3516D (`AIAO_HI3516A`): total reset value 0x0 and six more control bits [15:10] (WS/BCLK gating, BCLK polarity, master/slave select); data sheet 12.3 (`hi3516av100--Hi3516A-Hi3516D-Datasheet.txt` line 84720).

Data sheet 11.1.6 I2S_CRG_CFG1_00 (offset 0x104, printed page 11-11, `hi3518ev200--Hi3518EV20X-Hi3516CV200-Datasheet.txt` line 75972).";

`ifdef AIAO_HI3516A
        field {
            name = "aiao_rx_ws_en";
            desc = "RX WS gating select (Hi3516A/Hi3516D only; the data sheet text says 'rx bclk gating select' for both bits 15 and 14). 0: disabled, 1: enabled.";
            sw = rw;
            hw = r;
            reset = 0x0;
        } aiao_rx_ws_en[15:15];

        field {
            name = "aiao_rx_bclk_en";
            desc = "RX BCLK gating select (Hi3516A/Hi3516D only). 0: disabled, 1: enabled.";
            sw = rw;
            hw = r;
            reset = 0x0;
        } aiao_rx_bclk_en[14:14];

        field {
            name = "aiao_bclkout_pctrl";
            desc = "BCLKOUT polarity (Hi3516A/Hi3516D only). 0: positive, 1: negative.";
            sw = rw;
            hw = r;
            reset = 0x0;
        } aiao_bclkout_pctrl[13:13];

        field {
            name = "aiao_bclkin_pctrl";
            desc = "BCLKIN polarity (Hi3516A/Hi3516D only). 0: positive, 1: negative.";
            sw = rw;
            hw = r;
            reset = 0x0;
        } aiao_bclkin_pctrl[12:12];

        field {
            name = "aiao_bclk_sel";
            desc = "BCLK/FCLK select (Hi3516A/Hi3516D only). 0: the clocks are generated internally; 1: the clocks are input from the external ADAC.";
            sw = rw;
            hw = r;
            reset = 0x0;
        } aiao_bclk_sel[11:11];

        field {
            name = "aiao_bclk_oen";
            desc = "BCLK/FCLK I/O output enable control (Hi3516A/Hi3516D only). 0: the BCLK/FCLK I/O is an output; 1: it is an input. Works with aiao_bclk_sel to select the master/slave mode of the I2S interface.";
            sw = rw;
            hw = r;
            reset = 0x0;
        } aiao_bclk_oen[10:10];
`endif

        enum I2S_CRG_CFG1_00_aiao_srst_req_enum {
            DEASSERT_RESET = 0 { name = "Deassert Reset"; desc = "deassert reset"; };
            RESET_F = 1 { name = "Reset F"; desc = "reset"; };
        };

        field {
            name = "aiao_srst_req";
            desc = "Independent soft reset request of the RX 0 channel";
            sw = rw;
            hw = r;
            encode = I2S_CRG_CFG1_00_aiao_srst_req_enum;
            reset = 0x0;
        } aiao_srst_req[9:9];

        enum I2S_CRG_CFG1_00_aiao_cken_enum {
            DISABLED = 0 { name = "Disabled"; desc = "disabled"; };
            ENABLED = 1 { name = "Enabled"; desc = "enabled"; };
        };

        field {
            name = "aiao_cken";
            desc = "MCLK/BCLK/WS clock gating for CRG00";
            sw = rw;
            hw = r;
            encode = I2S_CRG_CFG1_00_aiao_cken_enum;
`ifdef AIAO_HI3516A
            reset = 0x0;
`else
            reset = 0x1;
`endif
        } aiao_cken[8:8];

        enum I2S_CRG_CFG1_00_aiao_fsclk_div_enum {
            FS_OBTAINED_DIVIDING = 0 { name = "Fs Obtained Dividing"; desc = "The FS is obtained by dividing the BCLK by 16."; };
            FS_OBTAINED_DIVIDING_2 = 1 { name = "Fs Obtained Dividing 2"; desc = "The FS is obtained by dividing the BCLK by 32."; };
            FS_OBTAINED_DIVIDING_3 = 2 { name = "Fs Obtained Dividing 3"; desc = "The FS is obtained by dividing the BCLK by 48."; };
            FS_OBTAINED_DIVIDING_4 = 3 { name = "Fs Obtained Dividing 4"; desc = "The FS is obtained by dividing the BCLK by 64."; };
            FS_OBTAINED_DIVIDING_5 = 4 { name = "Fs Obtained Dividing 5"; desc = "The FS is obtained by dividing the BCLK by 128."; };
            FS_OBTAINED_DIVIDING_6 = 5 { name = "Fs Obtained Dividing 6"; desc = "The FS is obtained by dividing the BCLK by 256. Other values: The FS is obtained by dividing the BCLK by 8."; };
        };

        field {
            name = "aiao_fsclk_div";
            desc = "Frequency division relationship between the bit clock BCLK and the sampling clock FS";
            sw = rw;
            hw = r;
            encode = I2S_CRG_CFG1_00_aiao_fsclk_div_enum;
`ifdef AIAO_HI3516A
            reset = 0x0;
`else
            reset = 0x3;
`endif
        } aiao_fsclk_div[6:4];

        enum I2S_CRG_CFG1_00_aiao_bclk_div_enum {
            BCLK_OBTAINED_DIVIDING = 0 { name = "Bclk Obtained Dividing"; desc = "The BCLK is obtained by dividing the MCLK by 1."; };
            BCLK_OBTAINED_DIVIDING_2 = 1 { name = "Bclk Obtained Dividing 2"; desc = "The BCLK is obtained by dividing the MCLK by 3."; };
            BCLK_OBTAINED_DIVIDING_3 = 2 { name = "Bclk Obtained Dividing 3"; desc = "The BCLK is obtained by dividing the MCLK by 2."; };
            BCLK_OBTAINED_DIVIDING_4 = 3 { name = "Bclk Obtained Dividing 4"; desc = "The BCLK is obtained by dividing the MCLK by 4."; };
            BCLK_OBTAINED_DIVIDING_5 = 4 { name = "Bclk Obtained Dividing 5"; desc = "The BCLK is obtained by dividing the MCLK by 6."; };
            BCLK_OBTAINED_DIVIDING_6 = 5 { name = "Bclk Obtained Dividing 6"; desc = "The BCLK is obtained by dividing the MCLK by 8."; };
            BCLK_OBTAINED_DIVIDING_7 = 6 { name = "Bclk Obtained Dividing 7"; desc = "The BCLK is obtained by dividing the MCLK by 12."; };
            BCLK_OBTAINED_DIVIDING_8 = 7 { name = "Bclk Obtained Dividing 8"; desc = "The BCLK is obtained by dividing the MCLK by 16."; };
            BCLK_OBTAINED_DIVIDING_9 = 8 { name = "Bclk Obtained Dividing 9"; desc = "The BCLK is obtained by dividing the MCLK by 24."; };
            BCLK_OBTAINED_DIVIDING_10 = 9 { name = "Bclk Obtained Dividing 10"; desc = "The BCLK is obtained by dividing the MCLK by 32."; };
            BCLK_OBTAINED_DIVIDING_11 = 10 { name = "Bclk Obtained Dividing 11"; desc = "The BCLK is obtained by dividing the MCLK by 48."; };
            BCLK_OBTAINED_DIVIDING_12 = 11 { name = "Bclk Obtained Dividing 12"; desc = "The BCLK is obtained by dividing the MCLK by 64. Other values: The BCLK is obtained by dividing the MCLK by 8."; };
        };

        field {
            name = "aiao_bclk_div";
            desc = "Frequency division relationship between the main clock MCLK and the bit clock BCLK";
            sw = rw;
            hw = r;
            encode = I2S_CRG_CFG1_00_aiao_bclk_div_enum;
`ifdef AIAO_HI3516A
            reset = 0x0;
`else
            reset = 0x1;
`endif
        } aiao_bclk_div[3:0];
    } I2S_CRG_CFG1_00 @ 0x104;

    reg {
        name = "I2S08 CRG configuration register 0";
        desc = "I2S_CRG_CFG0_08 is I2S08 CRG configuration register 0.

Data sheet 11.1.6 I2S_CRG_CFG0_08 (offset 0x140, printed page 11-12, `hi3518ev200--Hi3518EV20X-Hi3516CV200-Datasheet.txt` line 76038).";

        field {
            name = "aiao_mclk_div";
            desc = "Configured value of the frequency division clock of the MCLK: (target MCLK frequency / frequency of the MCLK clock source) x 2^27. The MCLK clock source is the AIAO PLL output selected in PERI_CRG (data sheet 3.2); reset 0x00AA_AAAA = 1/3 of the source.";
            sw = rw;
            hw = r;
            reset = 0x00AAAAAA;
        } aiao_mclk_div[26:0];
    } I2S_CRG_CFG0_08 @ 0x140;

    reg {
        name = "I2S08 CRG configuration register 1";
        desc = "I2S_CRG_CFG1_08 is I2S08 CRG configuration register 1.

Clock generator of the TX (AOP, 'CRG08') port, same layout as I2S_CRG_CFG1_00.

Data sheet 11.1.6 I2S_CRG_CFG1_08 (offset 0x144, printed page 11-13, `hi3518ev200--Hi3518EV20X-Hi3516CV200-Datasheet.txt` line 76074).";

`ifdef AIAO_HI3516A
        field {
            name = "aiao_tx_ws_en";
            desc = "TX WS gating select (Hi3516A/Hi3516D only; the data sheet text says 'tx bclk gating select' for both bits 15 and 14). 0: disabled, 1: enabled.";
            sw = rw;
            hw = r;
            reset = 0x0;
        } aiao_tx_ws_en[15:15];

        field {
            name = "aiao_tx_bclk_en";
            desc = "TX BCLK gating select (Hi3516A/Hi3516D only). 0: disabled, 1: enabled.";
            sw = rw;
            hw = r;
            reset = 0x0;
        } aiao_tx_bclk_en[14:14];

        field {
            name = "aiao_bclkout_pctrl";
            desc = "BCLKOUT polarity (Hi3516A/Hi3516D only). 0: positive, 1: negative.";
            sw = rw;
            hw = r;
            reset = 0x0;
        } aiao_bclkout_pctrl[13:13];

        field {
            name = "aiao_bclkin_pctrl";
            desc = "BCLKIN polarity (Hi3516A/Hi3516D only). 0: positive, 1: negative.";
            sw = rw;
            hw = r;
            reset = 0x0;
        } aiao_bclkin_pctrl[12:12];

        field {
            name = "aiao_bclk_sel";
            desc = "BCLK/FCLK select (Hi3516A/Hi3516D only). 0: the clocks are generated internally; 1: the clocks are input from the external ADAC.";
            sw = rw;
            hw = r;
            reset = 0x0;
        } aiao_bclk_sel[11:11];

        field {
            name = "aiao_bclk_oen";
            desc = "BCLK/FCLK I/O output enable control (Hi3516A/Hi3516D only). 0: the BCLK/FCLK I/O is an output; 1: it is an input. Works with aiao_bclk_sel to select the master/slave mode of the I2S interface.";
            sw = rw;
            hw = r;
            reset = 0x0;
        } aiao_bclk_oen[10:10];
`endif

        enum I2S_CRG_CFG1_08_aiao_srst_req_enum {
            DEASSERT_RESET = 0 { name = "Deassert Reset"; desc = "deassert reset"; };
            RESET_F = 1 { name = "Reset F"; desc = "reset"; };
        };

        field {
            name = "aiao_srst_req";
            desc = "Independent soft reset request of the TX 0 channel";
            sw = rw;
            hw = r;
            encode = I2S_CRG_CFG1_08_aiao_srst_req_enum;
            reset = 0x0;
        } aiao_srst_req[9:9];

        enum I2S_CRG_CFG1_08_aiao_cken_enum {
            DISABLED = 0 { name = "Disabled"; desc = "disabled"; };
            ENABLED = 1 { name = "Enabled"; desc = "enabled"; };
        };

        field {
            name = "aiao_cken";
            desc = "MCLK/BCLK/WS clock gating for CRG08";
            sw = rw;
            hw = r;
            encode = I2S_CRG_CFG1_08_aiao_cken_enum;
`ifdef AIAO_HI3516A
            reset = 0x0;
`else
            reset = 0x1;
`endif
        } aiao_cken[8:8];

        enum I2S_CRG_CFG1_08_aiao_fsclk_div_enum {
            FS_OBTAINED_DIVIDING = 0 { name = "Fs Obtained Dividing"; desc = "The FS is obtained by dividing the BCLK by 16."; };
            FS_OBTAINED_DIVIDING_2 = 1 { name = "Fs Obtained Dividing 2"; desc = "The FS is obtained by dividing the BCLK by 32."; };
            FS_OBTAINED_DIVIDING_3 = 2 { name = "Fs Obtained Dividing 3"; desc = "The FS is obtained by dividing the BCLK by 48."; };
            FS_OBTAINED_DIVIDING_4 = 3 { name = "Fs Obtained Dividing 4"; desc = "The FS is obtained by dividing the BCLK by 64."; };
            FS_OBTAINED_DIVIDING_5 = 4 { name = "Fs Obtained Dividing 5"; desc = "The FS is obtained by dividing the BCLK by 128."; };
            FS_OBTAINED_DIVIDING_6 = 5 { name = "Fs Obtained Dividing 6"; desc = "The FS is obtained by dividing the BCLK by 256. Other values: The FS is obtained by dividing the BCLK by 8."; };
        };

        field {
            name = "aiao_fsclk_div";
            desc = "Frequency division relationship between the bit clock BCLK and the sampling clock FS";
            sw = rw;
            hw = r;
            encode = I2S_CRG_CFG1_08_aiao_fsclk_div_enum;
`ifdef AIAO_HI3516A
            reset = 0x0;
`else
            reset = 0x3;
`endif
        } aiao_fsclk_div[6:4];

        enum I2S_CRG_CFG1_08_aiao_bclk_div_enum {
            BCLK_OBTAINED_DIVIDING = 0 { name = "Bclk Obtained Dividing"; desc = "The BCLK is obtained by dividing the MCLK by 1."; };
            BCLK_OBTAINED_DIVIDING_2 = 1 { name = "Bclk Obtained Dividing 2"; desc = "The BCLK is obtained by dividing the MCLK by 3."; };
            BCLK_OBTAINED_DIVIDING_3 = 2 { name = "Bclk Obtained Dividing 3"; desc = "The BCLK is obtained by dividing the MCLK by 2."; };
            BCLK_OBTAINED_DIVIDING_4 = 3 { name = "Bclk Obtained Dividing 4"; desc = "The BCLK is obtained by dividing the MCLK by 4."; };
            BCLK_OBTAINED_DIVIDING_5 = 4 { name = "Bclk Obtained Dividing 5"; desc = "The BCLK is obtained by dividing the MCLK by 6."; };
            BCLK_OBTAINED_DIVIDING_6 = 5 { name = "Bclk Obtained Dividing 6"; desc = "The BCLK is obtained by dividing the MCLK by 8."; };
            BCLK_OBTAINED_DIVIDING_7 = 6 { name = "Bclk Obtained Dividing 7"; desc = "The BCLK is obtained by dividing the MCLK by 12."; };
            BCLK_OBTAINED_DIVIDING_8 = 7 { name = "Bclk Obtained Dividing 8"; desc = "The BCLK is obtained by dividing the MCLK by 16."; };
            BCLK_OBTAINED_DIVIDING_9 = 8 { name = "Bclk Obtained Dividing 9"; desc = "The BCLK is obtained by dividing the MCLK by 24."; };
            BCLK_OBTAINED_DIVIDING_10 = 9 { name = "Bclk Obtained Dividing 10"; desc = "The BCLK is obtained by dividing the MCLK by 32."; };
            BCLK_OBTAINED_DIVIDING_11 = 10 { name = "Bclk Obtained Dividing 11"; desc = "The BCLK is obtained by dividing the MCLK by 48."; };
            BCLK_OBTAINED_DIVIDING_12 = 11 { name = "Bclk Obtained Dividing 12"; desc = "The BCLK is obtained by dividing the MCLK by 64. Other values: The BCLK is obtained by dividing the MCLK by 8."; };
        };

        field {
            name = "aiao_bclk_div";
            desc = "Frequency division relationship between the main clock MCLK and the bit clock BCLK";
            sw = rw;
            hw = r;
            encode = I2S_CRG_CFG1_08_aiao_bclk_div_enum;
`ifdef AIAO_HI3516A
            reset = 0x0;
`else
            reset = 0x1;
`endif
        } aiao_bclk_div[3:0];
    } I2S_CRG_CFG1_08 @ 0x144;

`ifdef AIAO_TX1
    reg {
        name = "I2S09 CRG configuration register 0";
        desc = "I2S_CRG_CFG0_09 is I2S09 CRG configuration register 0: MCLK divider of the second TX channel's clock generator (Hi3516AV300 only; same layout as I2S_CRG_CFG0_08).
Data sheet 11.1 I2S_CRG_CFG0_09 (offset 0x148, Chinese issue 01, `hi3516av300--Hi3516AV300-Datasheet.txt` line 53165).";

        field {
            name = "aiao_mclk_div";
            desc = "Configured value of the frequency division clock of the MCLK: (target MCLK frequency / MCLK source PLL frequency, 1188 MHz by default) x 2^27; reset 0x00AA_AAAA = 1/3 of the source.";
            sw = rw;
            hw = r;
            reset = 0x00AAAAAA;
        } aiao_mclk_div[26:0];
    } I2S_CRG_CFG0_09 @ 0x148;

    reg {
        name = "I2S09 CRG configuration register 1";
        desc = "I2S_CRG_CFG1_09 is I2S09 CRG configuration register 1: soft reset, clock gate and BCLK/WS dividers of the second TX channel (TX1) clock generator (Hi3516AV300 only; same layout and total reset value 0x131 as I2S_CRG_CFG1_08).
Data sheet 11.1 I2S_CRG_CFG1_09 (offset 0x14C, Chinese issue 01, `hi3516av300--Hi3516AV300-Datasheet.txt` line 53183).";

        enum I2S_CRG_CFG1_09_aiao_srst_req_enum {
            DEASSERT_RESET = 0 { name = "Deassert Reset"; desc = "deassert reset"; };
            RESET_F = 1 { name = "Reset F"; desc = "reset"; };
        };
        enum I2S_CRG_CFG1_09_aiao_cken_enum {
            DISABLED = 0 { name = "Disabled"; desc = "disabled"; };
            ENABLED = 1 { name = "Enabled"; desc = "enabled"; };
        };
        enum I2S_CRG_CFG1_09_aiao_fsclk_div_enum {
            FS_OBTAINED_DIVIDING = 0 { name = "Fs Obtained Dividing"; desc = "The FS is obtained by dividing the BCLK by 16."; };
            FS_OBTAINED_DIVIDING_2 = 1 { name = "Fs Obtained Dividing 2"; desc = "The FS is obtained by dividing the BCLK by 32."; };
            FS_OBTAINED_DIVIDING_3 = 2 { name = "Fs Obtained Dividing 3"; desc = "The FS is obtained by dividing the BCLK by 48."; };
            FS_OBTAINED_DIVIDING_4 = 3 { name = "Fs Obtained Dividing 4"; desc = "The FS is obtained by dividing the BCLK by 64."; };
            FS_OBTAINED_DIVIDING_5 = 4 { name = "Fs Obtained Dividing 5"; desc = "The FS is obtained by dividing the BCLK by 128."; };
            FS_OBTAINED_DIVIDING_6 = 5 { name = "Fs Obtained Dividing 6"; desc = "The FS is obtained by dividing the BCLK by 256. Other values: The FS is obtained by dividing the BCLK by 8."; };
        };
        enum I2S_CRG_CFG1_09_aiao_bclk_div_enum {
            BCLK_OBTAINED_DIVIDING = 0 { name = "Bclk Obtained Dividing"; desc = "The BCLK is obtained by dividing the MCLK by 1."; };
            BCLK_OBTAINED_DIVIDING_2 = 1 { name = "Bclk Obtained Dividing 2"; desc = "The BCLK is obtained by dividing the MCLK by 3."; };
            BCLK_OBTAINED_DIVIDING_3 = 2 { name = "Bclk Obtained Dividing 3"; desc = "The BCLK is obtained by dividing the MCLK by 2."; };
            BCLK_OBTAINED_DIVIDING_4 = 3 { name = "Bclk Obtained Dividing 4"; desc = "The BCLK is obtained by dividing the MCLK by 4."; };
            BCLK_OBTAINED_DIVIDING_5 = 4 { name = "Bclk Obtained Dividing 5"; desc = "The BCLK is obtained by dividing the MCLK by 6."; };
            BCLK_OBTAINED_DIVIDING_6 = 5 { name = "Bclk Obtained Dividing 6"; desc = "The BCLK is obtained by dividing the MCLK by 8."; };
            BCLK_OBTAINED_DIVIDING_7 = 6 { name = "Bclk Obtained Dividing 7"; desc = "The BCLK is obtained by dividing the MCLK by 12."; };
            BCLK_OBTAINED_DIVIDING_8 = 7 { name = "Bclk Obtained Dividing 8"; desc = "The BCLK is obtained by dividing the MCLK by 16."; };
            BCLK_OBTAINED_DIVIDING_9 = 8 { name = "Bclk Obtained Dividing 9"; desc = "The BCLK is obtained by dividing the MCLK by 24."; };
            BCLK_OBTAINED_DIVIDING_10 = 9 { name = "Bclk Obtained Dividing 10"; desc = "The BCLK is obtained by dividing the MCLK by 32."; };
            BCLK_OBTAINED_DIVIDING_11 = 10 { name = "Bclk Obtained Dividing 11"; desc = "The BCLK is obtained by dividing the MCLK by 48."; };
            BCLK_OBTAINED_DIVIDING_12 = 11 { name = "Bclk Obtained Dividing 12"; desc = "The BCLK is obtained by dividing the MCLK by 64. Other values: The BCLK is obtained by dividing the MCLK by 8."; };
        };

        field {
            name = "aiao_srst_req";
            desc = "Independent soft reset request of the TX 1 channel. 0: deassert reset, 1: reset.";
            sw = rw;
            hw = r;
            encode = I2S_CRG_CFG1_09_aiao_srst_req_enum;
            reset = 0x0;
        } aiao_srst_req[9:9];

        field {
            name = "aiao_cken";
            desc = "MCLK/BCLK/WS clock gating for CRG09. 0: off, 1: on.";
            sw = rw;
            hw = r;
            encode = I2S_CRG_CFG1_09_aiao_cken_enum;
            reset = 0x1;
        } aiao_cken[8:8];

        field {
            name = "aiao_fsclk_div";
            desc = "Frequency division relationship between the bit clock BCLK and the sampling clock FS (same encoding as I2S_CRG_CFG1_08).";
            sw = rw;
            hw = r;
            encode = I2S_CRG_CFG1_09_aiao_fsclk_div_enum;
            reset = 0x3;
        } aiao_fsclk_div[6:4];

        field {
            name = "aiao_bclk_div";
            desc = "Frequency division relationship between the main clock MCLK and the bit clock BCLK (same encoding as I2S_CRG_CFG1_08).";
            sw = rw;
            hw = r;
            encode = I2S_CRG_CFG1_09_aiao_bclk_div_enum;
            reset = 0x1;
        } aiao_bclk_div[3:0];
    } I2S_CRG_CFG1_09 @ 0x14C;
`endif

    reg {
        name = "Interface attribute configuration register for the RX channel";
        desc = "RX_IF_ATTRI is an interface attribute configuration register for the RX channel.

Total reset value 0xE400_0004: rx_i2s_precision = 1 (16 bits) and the data sheet 'reserved' bits 31:30, 29 and 26 read 1 (modelled as reserved_b* fields). The vendor AIAO code of this generation (`aiao_hal`) writes the whole register.

Data sheet 11.1.6 RX_IF_ATTRI (offset 0x1000, printed page 11-14, `hi3518ev200--Hi3518EV20X-Hi3516CV200-Datasheet.txt` line 76139).";

`ifdef AIAO_HI3516A
        enum RX_IF_ATTRI_rx_sd_sel_enum {
            SD0 = 0 { name = "SD0"; desc = "SD0"; };
            SD1 = 1 { name = "SD1"; desc = "SD1"; };
            SD2 = 2 { name = "SD2"; desc = "SD2"; };
            SD3 = 3 { name = "SD3"; desc = "SD3"; };
        };

        field {
            name = "rx_sd3_sel";
            desc = "SD3 select: which serial data line carries the data of channel pair 3 (Hi3516A/Hi3516D only; 'select the channel and data line in sequence'). Reset 3 = SD3.";
            sw = rw;
            hw = r;
            encode = RX_IF_ATTRI_rx_sd_sel_enum;
            reset = 0x3;
        } rx_sd3_sel[31:30];

        field {
            name = "rx_sd2_sel";
            desc = "SD2 select: which serial data line carries the data of channel pair 2 (Hi3516A/Hi3516D only; 'select the channel and data line in sequence'). Reset 2 = SD2.";
            sw = rw;
            hw = r;
            encode = RX_IF_ATTRI_rx_sd_sel_enum;
            reset = 0x2;
        } rx_sd2_sel[29:28];

        field {
            name = "rx_sd1_sel";
            desc = "SD1 select: which serial data line carries the data of channel pair 1 (Hi3516A/Hi3516D only; 'select the channel and data line in sequence'). Reset 1 = SD1.";
            sw = rw;
            hw = r;
            encode = RX_IF_ATTRI_rx_sd_sel_enum;
            reset = 0x1;
        } rx_sd1_sel[27:26];

        field {
            name = "rx_sd0_sel";
            desc = "SD0 select: which serial data line carries the data of channel pair 0 (Hi3516A/Hi3516D only; 'select the channel and data line in sequence'). Reset 0 = SD0.";
            sw = rw;
            hw = r;
            encode = RX_IF_ATTRI_rx_sd_sel_enum;
            reset = 0x0;
        } rx_sd0_sel[25:24];

`else
        field {
            name = "reserved_b31_24";
            desc = "Reserved in the data sheet; modelled so that the total reset value 0xE4000004 of the data sheet header is reproduced (reads 0xE4). The Hi3516A/Hi3516D data sheet names these bits rx_sd3_sel..rx_sd0_sel (serial data line select per channel pair, reset 3,2,1,0 = 0xE4), so the same hardware is likely present here.";
            sw = r;
            hw = w;
            reset = 0xE4;
        } reserved_b31_24[31:24];
`endif

        field {
            name = "rx_sd_source_sel";
            desc = "Serial data source select. The data sheet says only: 'This bit is set to 0x1000 in normal mode' (i.e. 0x8, bit 23 set; the reset value is 0 and the total reset value 0xE400_0004 has bits 23:20 = 0).";
            sw = rw;
            hw = r;
            reset = 0x0;
        } rx_sd_source_sel[23:20];

        enum RX_IF_ATTRI_rx_trackmode_enum {
            SOUND_NOT_PROCESSED = 0 { name = "Sound Not Processed"; desc = "The sound is not processed."; };
            SOUNDS_TWO_CHANNELS = 1 { name = "Sounds Two Channels"; desc = "The sounds in two channels are audio-left channel sounds."; };
            SOUNDS_TWO_CHANNELS_2 = 2 { name = "Sounds Two Channels 2"; desc = "The sounds in two channels are audio-right channel sounds."; };
            SOUNDS_TWO_CHANNELS_3 = 3 { name = "Sounds Two Channels 3"; desc = "The sounds in two channels are exchanged."; };
            SOUNDS_TWO_CHANNELS_4 = 4 { name = "Sounds Two Channels 4"; desc = "The sounds of two channels are added and then output."; };
            AUDIO_LEFT_CHANNEL = 5 { name = "Audio Left Channel"; desc = "The audio-left channel is muted, and the sound of the audio-right channel is from the original audio-right channel."; };
            AUDIO_RIGHT_CHANNEL = 6 { name = "Audio Right Channel"; desc = "The audio-right channel is muted, and the sound of the audio-left channel is from the original audio-left channel."; };
            RESERVED = 7 { name = "Reserved"; desc = "reserved"; };
        };

        field {
            name = "rx_trackmode";
            desc = "Audio-left and audio-right channel mode in I2S mode";
            sw = rw;
            hw = r;
            encode = RX_IF_ATTRI_rx_trackmode_enum;
            reset = 0x0;
        } rx_trackmode[18:16];

        field {
            name = "rx_sd_offset";
            desc = "Serial data offset (PCM timing mode; the TX register documents 0x0 = left-aligned mode, 0x1 = standard mode, other values reserved; the RX bit table gives no value list).";
            sw = rw;
            hw = r;
            reset = 0x0;
        } rx_sd_offset[15:8];

        enum RX_IF_ATTRI_rx_ch_num_enum {
            V_1 = 0 { name = "V 1"; desc = "1"; };
            V_2_OTHER_VALUES = 1 { name = "V 2 Other Values"; desc = "2 Other values: reserved"; };
        };

`ifdef AIAO_HI3516A
        enum RX_IF_ATTRI_rx_multislot_en_enum {
            NORMAL = 0 { name = "Normal"; desc = "invalid (normal mode)"; };
            TDM = 1 { name = "TDM"; desc = "valid (time-division multiplexing mode)"; };
        };

        field {
            name = "rx_multislot_en";
            desc = "Time-division multiplexing validity indicator (Hi3516A/Hi3516D only). Changes the meaning of rx_ch_num and rx_i2s_precision.";
            sw = rw;
            hw = r;
            encode = RX_IF_ATTRI_rx_multislot_en_enum;
            reset = 0x0;
        } rx_multislot_en[7:7];

        enum RX_IF_ATTRI_rx_ch_num_hi3516a_enum {
            CH_1 = 0 { name = "1 Channel"; desc = "rx_multislot_en = 0: 1-channel RX (SD0 data line); = 1: 2-channel RX (SD0)"; };
            CH_2 = 1 { name = "2 Channels"; desc = "rx_multislot_en = 0: 2-channel RX (SD0 data line); = 1: 4-channel RX (SD0)"; };
            CH_RESERVED = 2 { name = "Reserved"; desc = "rx_multislot_en = 0: reserved; = 1: 8-channel RX (SD0)"; };
            CH_8 = 3 { name = "8 Channels"; desc = "rx_multislot_en = 0: 8-channel RX (data lines SD0, SD1, SD2 and SD3); = 1: 16-channel RX (SD0)"; };
        };

        field {
            name = "rx_ch_num";
            desc = "Number of RX channels (Hi3516A/Hi3516D: 2 bits; the data line must be SD0 for multi-channel RX).";
            sw = rw;
            hw = r;
            encode = RX_IF_ATTRI_rx_ch_num_hi3516a_enum;
            reset = 0x0;
        } rx_ch_num[5:4];
`else
        field {
            name = "rx_ch_num";
            desc = "Number of RX channels";
            sw = rw;
            hw = r;
            encode = RX_IF_ATTRI_rx_ch_num_enum;
            reset = 0x0;
        } rx_ch_num[6:4];
`endif

        field {
            name = "rx_i2s_precision";
            desc = "Data sampling precision 2 I S mode: 01: 16 bits 10: 24 bits Other values: reserved PCM mode: 01: 16 bits Other values: reserved";
            sw = rw;
            hw = r;
            reset = 0x1;
        } rx_i2s_precision[3:2];

        enum RX_IF_ATTRI_rx_mode_enum {
            I_S_MODE = 0 { name = "I S Mode"; desc = "I S mode"; };
            PCM_MODE_OTHER = 1 { name = "Pcm Mode Other"; desc = "PCM mode Other values: reserved"; };
        };

        field {
            name = "rx_mode";
            desc = "Interface mode of the RX channel";
            sw = rw;
            hw = r;
            encode = RX_IF_ATTRI_rx_mode_enum;
            reset = 0x0;
        } rx_mode[1:0];
    } RX_IF_ATTRI @ 0x1000;

    reg {
        name = "RX channel control register";
        desc = "RX_DSP_CTRL is an RX channel control register.

Start: set rx_enable = 1 after programming the buffer registers; stop: rx_enable = 0 and wait for rx_disable_done = 1 (the stop interrupt rx_stop_int also reports it).

Data sheet 11.1.6 RX_DSP_CTRL (offset 0x1004, printed page 11-16, `hi3518ev200--Hi3518EV20X-Hi3516CV200-Datasheet.txt` line 76227).";

        enum RX_DSP_CTRL_rx_disable_done_enum {
            NOT_COMPLETE = 0 { name = "Not Complete"; desc = "not complete"; };
            COMPLETE = 1 { name = "Complete"; desc = "complete"; };
        };

        field {
            name = "rx_disable_done";
            desc = "RX channel disable completion identifier. (The Hi3516A/Hi3516D data sheet table gives this bit as RW with total reset 0x0000_0000, but its own TX_DSP_CTRL table and every later edition say RO / 0x2000_0000; kept as RO, reset 1.)";
            sw = r;
            hw = w;
            encode = RX_DSP_CTRL_rx_disable_done_enum;
            reset = 0x1;
        } rx_disable_done[29:29];

        enum RX_DSP_CTRL_rx_enable_enum {
            STOP = 0 { name = "Stop"; desc = "stop"; };
            START = 1 { name = "Start"; desc = "start"; };
        };

        field {
            name = "rx_enable";
            desc = "RX channel start/stop control bit";
            sw = rw;
            hw = r;
            encode = RX_DSP_CTRL_rx_enable_enum;
            reset = 0x0;
        } rx_enable[28:28];

        enum RX_DSP_CTRL_bypass_en_enum {
            DATA_PROCESSING_IMPLEMENTED = 0 { name = "Data Processing Implemented"; desc = "Data processing is implemented normally."; };
            OPERATIONS_SUCH_AS = 1 { name = "Operations Such As"; desc = "Operations such as trackmode are not implemented."; };
        };

        field {
            name = "bypass_en";
            desc = "Data processing disable bit. The control function still takes effect after data processing is disabled.";
            sw = rw;
            hw = r;
            encode = RX_DSP_CTRL_bypass_en_enum;
            reset = 0x0;
        } bypass_en[27:27];
    } RX_DSP_CTRL @ 0x1004;

    reg {
        name = "DDR buffer start address register for the RX channel";
        desc = "RX_BUFF_SADDR is a DDR buffer start address register for the RX channel.

Data sheet 11.1.6 RX_BUFF_SADDR (offset 0x1080, printed page 11-16, `hi3518ev200--Hi3518EV20X-Hi3516CV200-Datasheet.txt` line 76264).";

        field {
            name = "rx_buff_saddr";
            desc = "Start address for the DDR buffer of RX channel 0. Its unit is byte.";
            sw = rw;
            hw = r;
            reset = 0x0;
        } rx_buff_saddr[31:0];
    } RX_BUFF_SADDR @ 0x1080;

    reg {
        name = "DDR buffer size register for the RX channel";
        desc = "RX_BUFF_SIZE is a DDR buffer size register for the RX channel.

Data sheet 11.1.6 RX_BUFF_SIZE (offset 0x1084, printed page 11-17, `hi3518ev200--Hi3518EV20X-Hi3516CV200-Datasheet.txt` line 76293).";

        field {
            name = "rx_buff_size";
            desc = "DDR buffer size of the RX channel. Its unit is byte.";
            sw = rw;
            hw = r;
            reset = 0x0;
        } rx_buff_size[23:0];
    } RX_BUFF_SIZE @ 0x1084;

    reg {
        name = "DDR buffer write address register for the RX channel";
        desc = "RX_BUFF_WPTR is a DDR buffer write address register for the RX channel.

Data sheet 11.1.6 RX_BUFF_WPTR (offset 0x1088, printed page 11-17, `hi3518ev200--Hi3518EV20X-Hi3516CV200-Datasheet.txt` line 76314).";

        field {
            name = "rx_buff_wptr";
            desc = "Write address for the DDR buffer of the RX channel. Its unit is byte.";
            sw = rw;
            hw = r;
            reset = 0x0;
        } rx_buff_wptr[23:0];
    } RX_BUFF_WPTR @ 0x1088;

    reg {
        name = "DDR buffer read address register for the RX channel";
        desc = "RX_BUFF_RPTR is a DDR buffer read address register for the RX channel.

Data sheet 11.1.6 RX_BUFF_RPTR (offset 0x108C, printed page 11-18, `hi3518ev200--Hi3518EV20X-Hi3516CV200-Datasheet.txt` line 76349).";

        field {
            name = "rx_buff_rptr";
            desc = "Read address for the DDR buffer of the RX channel. Its unit is byte.";
            sw = rw;
            hw = r;
            reset = 0x0;
        } rx_buff_rptr[23:0];
    } RX_BUFF_RPTR @ 0x108C;

    reg {
        name = "DDR buffer almost full threshold register _TH for the RX channel";
        desc = "RX_BUFF_ALFULL_TH is a DDR buffer almost full threshold register for the RX channel.

Data sheet 11.1.6 RX_BUFF_ALFULL_TH (offset 0x1090, printed page 11-18, `hi3518ev200--Hi3518EV20X-Hi3516CV200-Datasheet.txt` line 76375).";

        field {
            name = "rx_buff_alfull_th";
            desc = "Almost full threshold for the DDR buffer of the RX channel. Its unit is byte. If the available space of the DDR buffer is below the almost full threshold, the almost full raw interrupt is generated.";
            sw = rw;
            hw = r;
            reset = 0x0;
        } rx_buff_alfull_th[23:0];
    } RX_BUFF_ALFULL_TH @ 0x1090;

    reg {
        name = "Data transfer length register for the RX channel";
        desc = "RX_TRANS_SIZE is data transfer length register for the RX interrupt.

Data sheet 11.1.6 RX_TRANS_SIZE (offset 0x1094, printed page 11-19, `hi3518ev200--Hi3518EV20X-Hi3516CV200-Datasheet.txt` line 76410).";

        field {
            name = "rx_trans_size";
            desc = "After the RX channel receives the audio data with the length of rx_trans_size (in byte), a transfer completion interrupt is generated.";
            sw = rw;
            hw = r;
            reset = 0x0;
        } rx_trans_size[23:0];
    } RX_TRANS_SIZE @ 0x1094;

`ifdef AIAO_HI3516A
    reg {
        name = "RX write address at the transfer completion interrupt";
        desc = "RX_WPTR_TMP is a write address storage register for the RX channel upon reporting of the transfer completion interrupt (Hi3516A/Hi3516D only).
Data sheet 12.3 RX_WPTR_TMP (offset 0x1098, printed page 12-21, `hi3516av100--Hi3516A-Hi3516D-Datasheet.txt` line 85312).";

        field {
            name = "rx_wptr_tmp";
            desc = "Write address of the RX channel saved when the transfer completion interrupt is reported.";
            sw = r;
            hw = w;
            reset = 0x0;
        } rx_wptr_tmp[23:0];
    } RX_WPTR_TMP @ 0x1098;
`endif

    reg {
        name = "Interrupt enable register for the RX channel";
        desc = "RX_INT_ENA is an interrupt enable register for the RX channel.

Data sheet 11.1.6 RX_INT_ENA (offset 0x10A0, printed page 11-19, `hi3518ev200--Hi3518EV20X-Hi3516CV200-Datasheet.txt` line 76432).";

        enum RX_INT_ENA_rx_if_full_lost_int_ena_enum {
            DISABLED = 0 { name = "Disabled"; desc = "disabled"; };
            ENABLED = 1 { name = "Enabled"; desc = "enabled"; };
        };

        field {
            name = "rx_if_full_lost_int_ena";
            desc = "Interface data full loss raw interrupt enable for the RX channel";
            sw = rw;
            hw = r;
            encode = RX_INT_ENA_rx_if_full_lost_int_ena_enum;
            reset = 0x0;
        } rx_if_full_lost_int_ena[7:7];

        enum RX_INT_ENA_rx_stop_int_ena_enum {
            DISABLED = 0 { name = "Disabled"; desc = "disabled"; };
            ENABLED = 1 { name = "Enabled"; desc = "enabled"; };
        };

        field {
            name = "rx_stop_int_ena";
            desc = "Stop interrupt enable for the RX channel";
            sw = rw;
            hw = r;
            encode = RX_INT_ENA_rx_stop_int_ena_enum;
            reset = 0x0;
        } rx_stop_int_ena[5:5];

        enum RX_INT_ENA_rx_bfifo_full_int_ena_enum {
            DISABLED = 0 { name = "Disabled"; desc = "disabled"; };
            ENABLED = 1 { name = "Enabled"; desc = "enabled"; };
        };

        field {
            name = "rx_bfifo_full_int_ena";
            desc = "Bus fifo overflow interrupt enable for the RX channel";
            sw = rw;
            hw = r;
            encode = RX_INT_ENA_rx_bfifo_full_int_ena_enum;
            reset = 0x0;
        } rx_bfifo_full_int_ena[3:3];

        enum RX_INT_ENA_rx_alfull_int_ena_enum {
            DISABLED = 0 { name = "Disabled"; desc = "disabled"; };
            ENABLED = 1 { name = "Enabled"; desc = "enabled"; };
        };

        field {
            name = "rx_alfull_int_ena";
            desc = "DDR buffer almost full interrupt enable for the RX channel";
            sw = rw;
            hw = r;
            encode = RX_INT_ENA_rx_alfull_int_ena_enum;
            reset = 0x0;
        } rx_alfull_int_ena[2:2];

        enum RX_INT_ENA_rx_full_int_ena_enum {
            DISABLED = 0 { name = "Disabled"; desc = "disabled"; };
            ENABLED = 1 { name = "Enabled"; desc = "enabled"; };
        };

        field {
            name = "rx_full_int_ena";
            desc = "DDR buffer full interrupt for the RX channel";
            sw = rw;
            hw = r;
            encode = RX_INT_ENA_rx_full_int_ena_enum;
            reset = 0x0;
        } rx_full_int_ena[1:1];

        enum RX_INT_ENA_rx_trans_int_ena_enum {
            DISABLED = 0 { name = "Disabled"; desc = "disabled"; };
            ENABLED = 1 { name = "Enabled"; desc = "enabled"; };
        };

        field {
            name = "rx_trans_int_ena";
            desc = "Transfer completion interrupt enable for the RX channel";
            sw = rw;
            hw = r;
            encode = RX_INT_ENA_rx_trans_int_ena_enum;
            reset = 0x0;
        } rx_trans_int_ena[0:0];
    } RX_INT_ENA @ 0x10A0;

    reg {
        name = "Raw interrupt register for the RX channel";
        desc = "RX_INT_RAW is a raw interrupt register for the RX channel.

Data sheet 11.1.6 RX_INT_RAW (offset 0x10A4, printed page 11-20, `hi3518ev200--Hi3518EV20X-Hi3516CV200-Datasheet.txt` line 76493).";

        enum RX_INT_RAW_rx_if_full_lost_int_raw_enum {
            NO_RAW_INTERRUPT = 0 { name = "No Raw Interrupt"; desc = "No raw interrupt is generated."; };
            RAW_INTERRUPT_GENERATED = 1 { name = "Raw Interrupt Generated"; desc = "A raw interrupt is generated."; };
        };

        field {
            name = "rx_if_full_lost_int_raw";
            desc = "Data full lost raw interrupt of the RX channel";
            sw = r;
            hw = w;
            encode = RX_INT_RAW_rx_if_full_lost_int_raw_enum;
            reset = 0x0;
        } rx_if_full_lost_int_raw[7:7];

        enum RX_INT_RAW_rx_stop_int_raw_enum {
            NO_RAW_INTERRUPT = 0 { name = "No Raw Interrupt"; desc = "No raw interrupt is generated."; };
            RAW_INTERRUPT_GENERATED = 1 { name = "Raw Interrupt Generated"; desc = "A raw interrupt is generated."; };
        };

        field {
            name = "rx_stop_int_raw";
            desc = "Stop raw interrupt of the RX channel";
            sw = r;
            hw = w;
            encode = RX_INT_RAW_rx_stop_int_raw_enum;
            reset = 0x0;
        } rx_stop_int_raw[5:5];

        enum RX_INT_RAW_rx_bfifo_full_int_raw_enum {
            NO_RAW_INTERRUPT = 0 { name = "No Raw Interrupt"; desc = "No raw interrupt is generated."; };
            RAW_INTERRUPT_GENERATED = 1 { name = "Raw Interrupt Generated"; desc = "A raw interrupt is generated."; };
        };

        field {
            name = "rx_bfifo_full_int_raw";
            desc = "Bus FIFO overflow raw interrupt of the RX channel";
            sw = r;
            hw = w;
            encode = RX_INT_RAW_rx_bfifo_full_int_raw_enum;
            reset = 0x0;
        } rx_bfifo_full_int_raw[3:3];

        enum RX_INT_RAW_rx_alfull_int_raw_enum {
            NO_RAW_INTERRUPT = 0 { name = "No Raw Interrupt"; desc = "No raw interrupt is generated."; };
            RAW_INTERRUPT_GENERATED = 1 { name = "Raw Interrupt Generated"; desc = "A raw interrupt is generated."; };
        };

        field {
            name = "rx_alfull_int_raw";
            desc = "DDR buffer almost full raw interrupt of the RX channel";
            sw = r;
            hw = w;
            encode = RX_INT_RAW_rx_alfull_int_raw_enum;
            reset = 0x0;
        } rx_alfull_int_raw[2:2];

        enum RX_INT_RAW_rx_full_int_raw_enum {
            NO_RAW_INTERRUPT = 0 { name = "No Raw Interrupt"; desc = "No raw interrupt is generated."; };
            RAW_INTERRUPT_GENERATED = 1 { name = "Raw Interrupt Generated"; desc = "A raw interrupt is generated."; };
        };

        field {
            name = "rx_full_int_raw";
            desc = "DDR buffer full raw interrupt of the RX channel";
            sw = r;
            hw = w;
            encode = RX_INT_RAW_rx_full_int_raw_enum;
            reset = 0x0;
        } rx_full_int_raw[1:1];

        enum RX_INT_RAW_rx_trans_int_raw_enum {
            NO_RAW_INTERRUPT = 0 { name = "No Raw Interrupt"; desc = "No raw interrupt is generated."; };
            RAW_INTERRUPT_GENERATED = 1 { name = "Raw Interrupt Generated"; desc = "A raw interrupt is generated."; };
        };

        field {
            name = "rx_trans_int_raw";
            desc = "Transfer completion raw interrupt of the RX interrupt";
            sw = r;
            hw = w;
            encode = RX_INT_RAW_rx_trans_int_raw_enum;
            reset = 0x0;
        } rx_trans_int_raw[0:0];
    } RX_INT_RAW @ 0x10A4;

    reg {
        name = "Interrupt status register for the RX channel";
        desc = "RX_INT_STATUS is an interrupt status register for the RX channel.

The data sheet bit table names bit 7 'tx_if_full_lost_int_status' (copy error); it is the RX interface full-loss interrupt and is named rx_* here.

Data sheet 11.1.6 RX_INT_STATUS (offset 0x10A8, printed page 11-21, `hi3518ev200--Hi3518EV20X-Hi3516CV200-Datasheet.txt` line 76552).";

        enum RX_INT_STATUS_rx_if_full_lost_int_status_enum {
            NO_INTERRUPT_GENERATED = 0 { name = "No Interrupt Generated"; desc = "No interrupt is generated."; };
            INTERRUPT_GENERATED = 1 { name = "Interrupt Generated"; desc = "An interrupt is generated."; };
        };

        field {
            name = "rx_if_full_lost_int_status";
            desc = "Status of the data full loss interrupt of the RX channel";
            sw = r;
            hw = w;
            encode = RX_INT_STATUS_rx_if_full_lost_int_status_enum;
            reset = 0x0;
        } rx_if_full_lost_int_status[7:7];

        enum RX_INT_STATUS_rx_stop_int_status_enum {
            NO_INTERRUPT_GENERATED = 0 { name = "No Interrupt Generated"; desc = "No interrupt is generated."; };
            INTERRUPT_GENERATED = 1 { name = "Interrupt Generated"; desc = "An interrupt is generated."; };
        };

        field {
            name = "rx_stop_int_status";
            desc = "Status of the stop interrupt of the RX interrupt";
            sw = r;
            hw = w;
            encode = RX_INT_STATUS_rx_stop_int_status_enum;
            reset = 0x0;
        } rx_stop_int_status[5:5];

        enum RX_INT_STATUS_rx_bfifo_full_int_status_enum {
            NO_INTERRUPT_GENERATED = 0 { name = "No Interrupt Generated"; desc = "No interrupt is generated."; };
            INTERRUPT_GENERATED = 1 { name = "Interrupt Generated"; desc = "An interrupt is generated."; };
        };

        field {
            name = "rx_bfifo_full_int_status";
            desc = "Status of the bus fifo overflow interrupt of the RC channel";
            sw = r;
            hw = w;
            encode = RX_INT_STATUS_rx_bfifo_full_int_status_enum;
            reset = 0x0;
        } rx_bfifo_full_int_status[3:3];

        enum RX_INT_STATUS_rx_alfull_int_status_enum {
            NO_INTERRUPT_GENERATED = 0 { name = "No Interrupt Generated"; desc = "No interrupt is generated."; };
            INTERRUPT_GENERATED = 1 { name = "Interrupt Generated"; desc = "An interrupt is generated."; };
        };

        field {
            name = "rx_alfull_int_status";
            desc = "Status of the DDR buffer almost full interrupt of the RX channel";
            sw = r;
            hw = w;
            encode = RX_INT_STATUS_rx_alfull_int_status_enum;
            reset = 0x0;
        } rx_alfull_int_status[2:2];

        enum RX_INT_STATUS_rx_full_int_status_enum {
            NO_INTERRUPT_GENERATED = 0 { name = "No Interrupt Generated"; desc = "No interrupt is generated."; };
            INTERRUPT_GENERATED = 1 { name = "Interrupt Generated"; desc = "An interrupt is generated."; };
        };

        field {
            name = "rx_full_int_status";
            desc = "Status of the DDR buffer full interrupt of the RX interrupt";
            sw = r;
            hw = w;
            encode = RX_INT_STATUS_rx_full_int_status_enum;
            reset = 0x0;
        } rx_full_int_status[1:1];

        enum RX_INT_STATUS_rx_trans_int_status_enum {
            NO_INTERRUPT_GENERATED = 0 { name = "No Interrupt Generated"; desc = "No interrupt is generated."; };
            INTERRUPT_GENERATED = 1 { name = "Interrupt Generated"; desc = "An interrupt is generated."; };
        };

        field {
            name = "rx_trans_int_status";
            desc = "Status of the transfer completion interrupt of the RX channel";
            sw = r;
            hw = w;
            encode = RX_INT_STATUS_rx_trans_int_status_enum;
            reset = 0x0;
        } rx_trans_int_status[0:0];
    } RX_INT_STATUS @ 0x10A8;

    reg {
        name = "Interrupt clear register for the RX channel";
        desc = "RX_INT_CLR is an interrupt clear register for the RX channel.

The data sheet bit table names bit 7 'tx_if_full_lost_int_clear' (copy error, named rx_* here) and gives bit 0 the access type W, the other bits WC; all are write-one-to-clear.

Data sheet 11.1.6 RX_INT_CLR (offset 0x10AC, printed page 11-22, `hi3518ev200--Hi3518EV20X-Hi3516CV200-Datasheet.txt` line 76611).";

        enum RX_INT_CLR_rx_if_full_lost_int_clear_enum {
            NOT_CLEARED = 0 { name = "Not Cleared"; desc = "not cleared"; };
            CLEARED = 1 { name = "Cleared"; desc = "cleared"; };
        };

        field {
            name = "rx_if_full_lost_int_clear";
            desc = "Data full loss interrupt clear for the RX channel";
            sw = rw;
            hw = w;
            onwrite = woclr;
            encode = RX_INT_CLR_rx_if_full_lost_int_clear_enum;
            reset = 0x0;
        } rx_if_full_lost_int_clear[7:7];

        enum RX_INT_CLR_rx_stop_int_clear_enum {
            NOT_CLEARED = 0 { name = "Not Cleared"; desc = "not cleared"; };
            CLEARED = 1 { name = "Cleared"; desc = "cleared"; };
        };

        field {
            name = "rx_stop_int_clear";
            desc = "Stop interrupt clear for the RX channel";
            sw = rw;
            hw = w;
            onwrite = woclr;
            encode = RX_INT_CLR_rx_stop_int_clear_enum;
            reset = 0x0;
        } rx_stop_int_clear[5:5];

        enum RX_INT_CLR_rx_bfifo_full_int_clear_enum {
            NOT_CLEARED = 0 { name = "Not Cleared"; desc = "not cleared"; };
            CLEARED = 1 { name = "Cleared"; desc = "cleared"; };
        };

`ifdef AIAO_HI3516A
        field {
            name = "rx_ififo_full_int_clear";
            desc = "Interface FIFO full interrupt clear for the RX channel (Hi3516A/Hi3516D only: its data sheet lists this clear bit although bit 4 of RX_INT_ENA/RAW/STATUS is reserved there too). Write 1 to clear.";
            sw = w;
            hw = r;
            onwrite = woclr;
        } rx_ififo_full_int_clear[4:4];
`endif

        field {
            name = "rx_bfifo_full_int_clear";
            desc = "Bus fifo overflow interrupt clear for the RX channel";
            sw = rw;
            hw = w;
            onwrite = woclr;
            encode = RX_INT_CLR_rx_bfifo_full_int_clear_enum;
            reset = 0x0;
        } rx_bfifo_full_int_clear[3:3];

        enum RX_INT_CLR_rx_alfull_int_clear_enum {
            NOT_CLEARED = 0 { name = "Not Cleared"; desc = "not cleared"; };
            CLEARED = 1 { name = "Cleared"; desc = "cleared"; };
        };

        field {
            name = "rx_alfull_int_clear";
            desc = "DDR buffer almost full interrupt clear for the RX channel";
            sw = rw;
            hw = w;
            onwrite = woclr;
            encode = RX_INT_CLR_rx_alfull_int_clear_enum;
            reset = 0x0;
        } rx_alfull_int_clear[2:2];

        enum RX_INT_CLR_rx_full_int_clear_enum {
            NOT_CLEARED = 0 { name = "Not Cleared"; desc = "not cleared"; };
            CLEARED = 1 { name = "Cleared"; desc = "cleared"; };
        };

        field {
            name = "rx_full_int_clear";
            desc = "DDR buffer full interrupt clear for the RX channel";
            sw = rw;
            hw = w;
            onwrite = woclr;
            encode = RX_INT_CLR_rx_full_int_clear_enum;
            reset = 0x0;
        } rx_full_int_clear[1:1];

        enum RX_INT_CLR_rx_trans_int_clear_enum {
            NOT_CLEARED = 0 { name = "Not Cleared"; desc = "not cleared"; };
            CLEARED = 1 { name = "Cleared"; desc = "cleared"; };
        };

        field {
            name = "rx_trans_int_clear";
            desc = "Transfer completion interrupt clear for the RX interrupt";
            sw = rw;
            hw = w;
            onwrite = woclr;
            encode = RX_INT_CLR_rx_trans_int_clear_enum;
            reset = 0x0;
        } rx_trans_int_clear[0:0];
    } RX_INT_CLR @ 0x10AC;

    reg {
        name = "Interface attribute configuration register for the TX channel";
        desc = "TX_IF_ATTRI is an interface attribute configuration register for the TX channel.

Total reset value 0xE400_0004: tx_i2s_precision = 1 (16 bits) and the data sheet 'reserved' bits 31:30, 29 and 26 read 1 (modelled as reserved_b* fields).

Data sheet 11.1.6 TX_IF_ATTRI (offset 0x2000, printed page 11-23, `hi3518ev200--Hi3518EV20X-Hi3516CV200-Datasheet.txt` line 76669).";

`ifdef AIAO_HI3516A
        enum TX_IF_ATTRI_tx_sd_sel_enum {
            SD0 = 0 { name = "SD0"; desc = "SD0"; };
            SD1 = 1 { name = "SD1"; desc = "SD1"; };
            SD2 = 2 { name = "SD2"; desc = "SD2"; };
            SD3 = 3 { name = "SD3"; desc = "SD3"; };
        };

        field {
            name = "tx_sd3_sel";
            desc = "SD3 select: which serial data line carries the data of channel pair 3 (Hi3516A/Hi3516D only; 'select the channel and data line in sequence'). Reset 3 = SD3.";
            sw = rw;
            hw = r;
            encode = TX_IF_ATTRI_tx_sd_sel_enum;
            reset = 0x3;
        } tx_sd3_sel[31:30];

        field {
            name = "tx_sd2_sel";
            desc = "SD2 select: which serial data line carries the data of channel pair 2 (Hi3516A/Hi3516D only; 'select the channel and data line in sequence'). Reset 2 = SD2.";
            sw = rw;
            hw = r;
            encode = TX_IF_ATTRI_tx_sd_sel_enum;
            reset = 0x2;
        } tx_sd2_sel[29:28];

        field {
            name = "tx_sd1_sel";
            desc = "SD1 select: which serial data line carries the data of channel pair 1 (Hi3516A/Hi3516D only; 'select the channel and data line in sequence'). Reset 1 = SD1.";
            sw = rw;
            hw = r;
            encode = TX_IF_ATTRI_tx_sd_sel_enum;
            reset = 0x1;
        } tx_sd1_sel[27:26];

        field {
            name = "tx_sd0_sel";
            desc = "SD0 select: which serial data line carries the data of channel pair 0 (Hi3516A/Hi3516D only; 'select the channel and data line in sequence'). Reset 0 = SD0.";
            sw = rw;
            hw = r;
            encode = TX_IF_ATTRI_tx_sd_sel_enum;
            reset = 0x0;
        } tx_sd0_sel[25:24];

        enum TX_IF_ATTRI_tx_sd_source_sel_enum {
            I2S_TX0 = 0 { name = "I2S TX0"; desc = "I2S TX0"; };
            I2S_RX0 = 8 { name = "I2S RX0"; desc = "I2S RX0. Other values: reserved"; };
        };

        field {
            name = "tx_sd_source_sel";
            desc = "Source select for SD0, SD1, SD2 and SD3 (Hi3516A/Hi3516D only).";
            sw = rw;
            hw = r;
            encode = TX_IF_ATTRI_tx_sd_source_sel_enum;
            reset = 0x0;
        } tx_sd_source_sel[23:20];
`else
        field {
            name = "reserved_b31_19";
            desc = "Reserved in the data sheet; modelled so that the total reset value 0xE4000004 of the data sheet header is reproduced (reads 0x1C80). The Hi3516A/Hi3516D data sheet names these bits tx_sd3_sel..tx_sd0_sel [31:24] (reset 3,2,1,0 = 0xE4) and tx_sd_source_sel [23:20], so the same hardware is likely present here.";
            sw = r;
            hw = w;
            reset = 0x1C80;
        } reserved_b31_19[31:19];
`endif

        enum TX_IF_ATTRI_tx_trackmode_enum {
            SOUND_NOT_PROCESSED = 0 { name = "Sound Not Processed"; desc = "The sound is not processed."; };
            SOUNDS_TWO_CHANNELS = 1 { name = "Sounds Two Channels"; desc = "The sounds in two channels are audio-left channel sounds."; };
            SOUNDS_TWO_CHANNELS_2 = 2 { name = "Sounds Two Channels 2"; desc = "The sounds in two channels are audio-right channel sounds."; };
            SOUNDS_TWO_CHANNELS_3 = 3 { name = "Sounds Two Channels 3"; desc = "The sounds in two channels are exchanged."; };
            SOUNDS_TWO_CHANNELS_4 = 4 { name = "Sounds Two Channels 4"; desc = "The sounds of two channels are added and then output."; };
            AUDIO_LEFT_CHANNEL = 5 { name = "Audio Left Channel"; desc = "The audio-left channel is muted, and the sound of the audio- right channel is from the original audio-right channel."; };
            AUDIO_RIGHT_CHANNEL = 6 { name = "Audio Right Channel"; desc = "The audio-right channel is muted, and the sound of the audio- left channel is from the original audio-left channel."; };
            AUDIO_LEFT_AUDIO = 7 { name = "Audio Left Audio"; desc = "The audio-left and audio-right channels are muted."; };
        };

        field {
            name = "tx_trackmode";
            desc = "Audio-left and audio-right channel mode in I S mode";
            sw = rw;
            hw = r;
            encode = TX_IF_ATTRI_tx_trackmode_enum;
            reset = 0x0;
        } tx_trackmode[18:16];

        enum TX_IF_ATTRI_tx_sd_offset_enum {
            LEFT_ALIGNED_MODE = 0x0 { name = "Left Aligned Mode"; desc = "left-aligned mode"; };
            STANDARD_MODE_OTHER = 0x1 { name = "Standard Mode Other"; desc = "standard mode Other values: reserved"; };
        };

        field {
            name = "tx_sd_offset";
            desc = "PCM timing mode";
            sw = rw;
            hw = r;
            encode = TX_IF_ATTRI_tx_sd_offset_enum;
            reset = 0x0;
        } tx_sd_offset[15:8];

        enum TX_IF_ATTRI_tx_ch_num_enum {
            DATA_TRANSMITTED_ONE = 0 { name = "Data Transmitted One"; desc = "Data is transmitted by one audio channel."; };
            DATA_TRANSMITTED_TWO = 1 { name = "Data Transmitted Two"; desc = "Data is transmitted by two audio channels as stereo. Other values: reserved"; };
        };

`ifdef AIAO_HI3516A
        enum TX_IF_ATTRI_tx_underflow_ctrl_enum {
            ZERO = 0 { name = "Zero"; desc = "0 is output."; };
            LAST_SAMPLE = 1 { name = "Last Sample"; desc = "The data at the last sampling point is output."; };
        };

        field {
            name = "tx_underflow_ctrl";
            desc = "Output control when an underflow occurs in the TX channel (Hi3516A/Hi3516D only).";
            sw = rw;
            hw = r;
            encode = TX_IF_ATTRI_tx_underflow_ctrl_enum;
            reset = 0x0;
        } tx_underflow_ctrl[6:6];
`endif

        field {
            name = "tx_ch_num";
            desc = "Select of the TX channel";
            sw = rw;
            hw = r;
            encode = TX_IF_ATTRI_tx_ch_num_enum;
            reset = 0x0;
        } tx_ch_num[5:4];

        field {
            name = "tx_i2s_precision";
            desc = "Data sampling precision 2 I S mode: 01: 16 bits 10: 24 bits Other values: reserved PCM mode: 01: 16 bits Other values: reserved";
            sw = rw;
            hw = r;
            reset = 0x1;
        } tx_i2s_precision[3:2];

        enum TX_IF_ATTRI_tx_mode_enum {
            I_S_MODE = 0 { name = "I S Mode"; desc = "I S mode"; };
            PCM_MODE_OTHER = 1 { name = "Pcm Mode Other"; desc = "PCM mode Other values: reserved"; };
        };

        field {
            name = "tx_mode";
            desc = "Interface mode of the TX channel";
            sw = rw;
            hw = r;
            encode = TX_IF_ATTRI_tx_mode_enum;
            reset = 0x0;
        } tx_mode[1:0];
    } TX_IF_ATTRI @ 0x2000;

    reg {
        name = "TX channel control register";
        desc = "TX_DSP_CTRL is a TX channel control register.

Start: set tx_enable = 1 after the DDR buffer has been filled past the almost-empty threshold; stop: tx_enable = 0 and wait for tx_disable_done = 1. Volume 0x79 = 0 dB.

Data sheet 11.1.6 TX_DSP_CTRL (offset 0x2004, printed page 11-24, `hi3518ev200--Hi3518EV20X-Hi3516CV200-Datasheet.txt` line 76743).";

        enum TX_DSP_CTRL_tx_disable_done_enum {
            NOT_COMPLETE = 0 { name = "Not Complete"; desc = "not complete"; };
            COMPLETE = 1 { name = "Complete"; desc = "complete"; };
        };

        field {
            name = "tx_disable_done";
            desc = "TX channel disable completion identifier";
            sw = r;
            hw = w;
            encode = TX_DSP_CTRL_tx_disable_done_enum;
            reset = 0x1;
        } tx_disable_done[29:29];

        enum TX_DSP_CTRL_tx_enable_enum {
            STOP = 0 { name = "Stop"; desc = "stop"; };
            START = 1 { name = "Start"; desc = "start"; };
        };

        field {
            name = "tx_enable";
            desc = "TX channel start/stop control bit";
            sw = rw;
            hw = r;
            encode = TX_DSP_CTRL_tx_enable_enum;
            reset = 0x0;
        } tx_enable[28:28];

        enum TX_DSP_CTRL_bypass_en_enum {
            DATA_PROCESSING_IMPLEMENTED = 0 { name = "Data Processing Implemented"; desc = "Data processing is implemented normally."; };
            OPERATIONS_SUCH_AS = 1 { name = "Operations Such As"; desc = "Operations such as trackmode and volume processing are not implemented."; };
        };

        field {
            name = "bypass_en";
            desc = "Data processing disable bit. The control function still takes effect after data processing is disabled.";
            sw = rw;
            hw = r;
            encode = TX_DSP_CTRL_bypass_en_enum;
            reset = 0x0;
        } bypass_en[27:27];

        field {
            name = "fade_out_rate";
            desc = "Fade-out rate 0000: The fade-out rate changes every one sampling point. 0001: The fade-out rate changes every two sampling points. 0110: The fade-out rate changes every four sampling points. 0011: The fade-out rate changes every eight sampling points. 0100: The fade-out rate changes every 16 sampling points. 0101: The fade-out rate changes every 32 sampling points. 0110: The fade-out rate changes every 64 sampling points. 0111: The fade-out rate changes every 128 sampling points. Other values: reserved";
            sw = rw;
            hw = r;
            reset = 0x0;
        } fade_out_rate[23:20];

        enum TX_DSP_CTRL_fade_in_rate_enum {
            FADE_RATE_CHANGES = 0 { name = "Fade Rate Changes"; desc = "The fade-in rate changes every one sampling point."; };
            FADE_RATE_CHANGES_2 = 1 { name = "Fade Rate Changes 2"; desc = "The fade-in rate changes every two sampling points."; };
            FADE_RATE_CHANGES_3 = 2 { name = "Fade Rate Changes 3"; desc = "The fade-in rate changes every four sampling points."; };
            FADE_RATE_CHANGES_4 = 3 { name = "Fade Rate Changes 4"; desc = "The fade-in rate changes every eight sampling points."; };
            FADE_RATE_CHANGES_5 = 4 { name = "Fade Rate Changes 5"; desc = "The fade-in rate changes every 16 sampling points."; };
            FADE_RATE_CHANGES_6 = 5 { name = "Fade Rate Changes 6"; desc = "The fade-in rate changes every 32 sampling points."; };
            FADE_RATE_CHANGES_7 = 6 { name = "Fade Rate Changes 7"; desc = "The fade-in rate changes every 64 sampling points."; };
            FADE_RATE_CHANGES_8 = 7 { name = "Fade Rate Changes 8"; desc = "The fade-in rate changes every 128 sampling points. Other values: reserved"; };
        };

        field {
            name = "fade_in_rate";
            desc = "Fade-in rate";
            sw = rw;
            hw = r;
            encode = TX_DSP_CTRL_fade_in_rate_enum;
            reset = 0x0;
        } fade_in_rate[19:16];

        enum TX_DSP_CTRL_volume_enum {
            V_80_DB = 0x29 { name = "V 80 Db"; desc = "-80 dB"; };
            V_79_DB = 0x2A { name = "V 79 Db"; desc = "-79 dB …"; };
            V_4_DB = 0x75 { name = "V 4 Db"; desc = "-4 dB"; };
            V_2_DB = 0x77 { name = "V 2 Db"; desc = "-2 dB"; };
            V_0_DB = 0x79 { name = "V 0 Db"; desc = "0 dB"; };
            V_2_DB_2 = 0x7B { name = "V 2 Db 2"; desc = "+2 dB"; };
            V_4_DB_2 = 0x7D { name = "V 4 Db 2"; desc = "+4 dB"; };
            V_6_DB = 0x7F { name = "V 6 Db"; desc = "+6 dB (maximum value)"; };
        };

        field {
            name = "volume";
            desc = "Volume. The volume is incremented by 1 dB when the field value is incremented by 1. 0x00-0x28: mute";
            sw = rw;
            hw = r;
            encode = TX_DSP_CTRL_volume_enum;
            reset = 0x0;
        } volume[14:8];

        enum TX_DSP_CTRL_mute_fade_en_enum {
            DISABLED = 0 { name = "Disabled"; desc = "disabled"; };
            ENABLED = 1 { name = "Enabled"; desc = "enabled"; };
        };

        field {
            name = "mute_fade_en";
            desc = "Mute fade-in/fade-out control";
            sw = rw;
            hw = r;
            encode = TX_DSP_CTRL_mute_fade_en_enum;
            reset = 0x0;
        } mute_fade_en[1:1];

        enum TX_DSP_CTRL_mute_en_enum {
            NOT_MUTED = 0 { name = "Not Muted"; desc = "not muted"; };
            MUTED = 1 { name = "Muted"; desc = "muted"; };
        };

        field {
            name = "mute_en";
            desc = "Mute control";
            sw = rw;
            hw = r;
            encode = TX_DSP_CTRL_mute_en_enum;
            reset = 0x0;
        } mute_en[0:0];
    } TX_DSP_CTRL @ 0x2004;

`ifdef AIAO_HI3516A
    reg {
        name = "TX DSP status register";
        desc = "TX_DSP_STATUS is a TX DSP status register (Hi3516A/Hi3516D only; read-only debug view of the TX data path). Total reset value 0x4000_0079.
Data sheet 12.3 TX_DSP_STATUS (offset 0x2008, printed page 12-34, `hi3516av100--Hi3516A-Hi3516D-Datasheet.txt` line 85837).";

        field { name = "tx_enable"; desc = "TX enable. 0: disabled, 1: enabled."; sw = r; hw = w; reset = 0x0; } tx_enable[31:31];
        field { name = "tx_axi_afifo_rd_aempty"; desc = "Bus FIFO almost empty status of the current channel. 0: not almost empty, 1: almost empty."; sw = r; hw = w; reset = 0x1; } tx_axi_afifo_rd_aempty[30:30];
        field { name = "tx_if_afifo_wr_full"; desc = "Interface FIFO full status of the current channel. 0: not full, 1: full."; sw = r; hw = w; reset = 0x0; } tx_if_afifo_wr_full[29:29];
        field { name = "proc_256bit_done"; desc = "256-bit processing complete status of the current channel. 0: not complete, 1: complete."; sw = r; hw = w; reset = 0x0; } proc_256bit_done[28:28];
        field { name = "if_fifo_wr_en"; desc = "Write interface FIFO enable for the current channel. 0: disabled, 1: enabled."; sw = r; hw = w; reset = 0x0; } if_fifo_wr_en[27:27];
        field { name = "tx_dsp_stop_done_req"; desc = "DSP stop request for the current channel. 0: no request, 1: request."; sw = r; hw = w; reset = 0x0; } tx_dsp_stop_done_req[26:26];
        field { name = "tx_rd_bus_fifo_cnt"; desc = "Read bus FIFO counter. The FIFO is read twice each time."; sw = r; hw = w; reset = 0x0; } tx_rd_bus_fifo_cnt[25:24];
        field { name = "state_clr_end"; desc = "Status clear complete. 0: not complete, 1: complete."; sw = r; hw = w; reset = 0x0; } state_clr_end[23:23];
        field { name = "cur_fifo_id"; desc = "ID of the current channel."; sw = r; hw = w; reset = 0x0; } cur_fifo_id[22:19];
        field { name = "cur_state"; desc = "Status of the state machine."; sw = r; hw = w; reset = 0x0; } cur_state[18:16];
        field { name = "tx_axi_afifo_rd_empty"; desc = "Bus FIFO empty status of the current channel. 0: not empty, 1: empty."; sw = r; hw = w; reset = 0x0; } tx_axi_afifo_rd_empty[7:7];
        field { name = "mute_fade_vol"; desc = "Mute fade-in/fade-out volume: 0x00-0x28 mute, 0x29 -80 dB ... 0x7E +5 dB, 0x7F +6 dB (same scale as TX_DSP_CTRL volume). Reset 0x79."; sw = r; hw = w; reset = 0x79; } mute_fade_vol[6:0];
    } TX_DSP_STATUS @ 0x2008;

    reg {
        name = "TX control interface status register";
        desc = "TX_IF_STATUS is a TX control interface status register (Hi3516A/Hi3516D only). Total reset value 0x0100_0060.
Data sheet 12.3 TX_IF_STATUS (offset 0x200C, printed page 12-36, `hi3516av100--Hi3516A-Hi3516D-Datasheet.txt` line 85912).";

        field { name = "if_fifo_empty_cnt"; desc = "Interface FIFO empty counter."; sw = r; hw = w; reset = 0x0; } if_fifo_empty_cnt[31:28];
        field { name = "i2s_tx_afifo_raddr"; desc = "Interface FIFO read address."; sw = r; hw = w; reset = 0x0; } i2s_tx_afifo_raddr[25:25];
        field { name = "i2s_tx_afifo_rd_aempty"; desc = "Interface FIFO write almost empty."; sw = r; hw = w; reset = 0x1; } i2s_tx_afifo_rd_aempty[24:24];
        field { name = "i2s_tx_afifo_waddr"; desc = "Interface FIFO write address."; sw = r; hw = w; reset = 0x0; } i2s_tx_afifo_waddr[17:17];
        field { name = "i2s_tx_afifo_wr_afull"; desc = "Interface FIFO write almost full."; sw = r; hw = w; reset = 0x0; } i2s_tx_afifo_wr_afull[16:16];
        field { name = "tx_bit_cnt"; desc = "TX bit counter."; sw = r; hw = w; reset = 0x0; } tx_bit_cnt[15:8];
        field { name = "i2s_tx_ctrl_stop_done"; desc = "IF ctrl stop complete."; sw = r; hw = w; reset = 0x1; } i2s_tx_ctrl_stop_done[6:6];
        field { name = "i2s_tx_afifo_rd_empty"; desc = "Interface FIFO empty."; sw = r; hw = w; reset = 0x1; } i2s_tx_afifo_rd_empty[5:5];
        field { name = "cur_state"; desc = "Status of the tx_if_ctrl state machine (the data sheet says 'rx_if_ctrl')."; sw = r; hw = w; reset = 0x0; } cur_state[2:0];
    } TX_IF_STATUS @ 0x200C;

    reg {
        name = "TX DMA read status register";
        desc = "TX_DMAR_STATUS is a TX DMA read (the data sheet says 'DMAW') status register (Hi3516A/Hi3516D only). Total reset value 0x0000_0200.
Data sheet 12.3 TX_DMAR_STATUS (offset 0x2010, printed page 12-37, `hi3516av100--Hi3516A-Hi3516D-Datasheet.txt` line 85970).";

        field { name = "tx_fifo_raddr"; desc = "Read pointer of the bus FIFO."; sw = r; hw = w; reset = 0x0; } tx_fifo_raddr[29:24];
        field { name = "tx_fifo_waddr"; desc = "Write pointer of the bus FIFO."; sw = r; hw = w; reset = 0x0; } tx_fifo_waddr[21:16];
        field { name = "tx_fifo_full"; desc = "Bus FIFO full."; sw = r; hw = w; reset = 0x0; } tx_fifo_full[14:14];
        field { name = "state_clr_end"; desc = "Status clear complete."; sw = r; hw = w; reset = 0x0; } state_clr_end[13:13];
        field { name = "trans_finish_ind"; desc = "Burst transfer complete. 0: not complete, 1: complete."; sw = r; hw = w; reset = 0x0; } trans_finish_ind[12:12];
        field { name = "vcmdready"; desc = "Transfer command complete. 0: not complete, 1: complete."; sw = r; hw = w; reset = 0x0; } vcmdready[11:11];
        field { name = "vtrans"; desc = "Transfer command start."; sw = r; hw = w; reset = 0x0; } vtrans[10:10];
        field { name = "tx_buf_empty"; desc = "Buffer empty."; sw = r; hw = w; reset = 0x1; } tx_buf_empty[9:9];
        field { name = "tx_fifo_afull"; desc = "Bus FIFO almost full."; sw = r; hw = w; reset = 0x0; } tx_fifo_afull[8:8];
        field { name = "cur_state"; desc = "Status of the DMAR state machine."; sw = r; hw = w; reset = 0x0; } cur_state[2:0];
    } TX_DMAR_STATUS @ 0x2010;

    reg {
        name = "TX WS cyclic count status register";
        desc = "TX_WS_CNT is a WS cyclic count status register for the TX channel (Hi3516A/Hi3516D only).
Data sheet 12.3 TX_WS_CNT (offset 0x2020, printed page 12-38, `hi3516av100--Hi3516A-Hi3516D-Datasheet.txt` line 86021).";

        field { name = "ws_count"; desc = "FSCLK cyclic count register. The unit is FSCLK."; sw = r; hw = w; reset = 0x0; } ws_count[23:0];
    } TX_WS_CNT @ 0x2020;

    reg {
        name = "TX BCLK cyclic count status register";
        desc = "TX_BCLK_CNT is a BCLK cyclic count status register for the TX channel (Hi3516A/Hi3516D only).
Data sheet 12.3 TX_BCLK_CNT (offset 0x2024, printed page 12-38, `hi3516av100--Hi3516A-Hi3516D-Datasheet.txt` line 86042).";

        field { name = "bclk_count"; desc = "BCLK cyclic count register. The unit is BCLK."; sw = r; hw = w; reset = 0x0; } bclk_count[23:0];
    } TX_BCLK_CNT @ 0x2024;
`endif

    reg {
        name = "DDR buffer start address register for the TX channel";
        desc = "TX_BUFF_SADDR is a DDR buffer start address register for the TX channel.

Data sheet 11.1.6 TX_BUFF_SADDR (offset 0x2080, printed page 11-26, `hi3518ev200--Hi3518EV20X-Hi3516CV200-Datasheet.txt` line 76839).";

        field {
            name = "tx_buff_saddr";
            desc = "Start address for the DDR buffer of the TX channel. Its unit is byte.";
            sw = rw;
            hw = r;
            reset = 0x0;
        } tx_buff_saddr[31:0];
    } TX_BUFF_SADDR @ 0x2080;

    reg {
        name = "DDR buffer size register for the TX channel";
        desc = "TX_BUFF_SIZE is a DDR buffer size register for the TX channel.

Data sheet 11.1.6 TX_BUFF_SIZE (offset 0x2084, printed page 11-27, `hi3518ev200--Hi3518EV20X-Hi3516CV200-Datasheet.txt` line 76869).";

        field {
            name = "tx_buff_size";
            desc = "DDR buffer size of the TX channel. Its unit is byte.";
            sw = rw;
            hw = r;
            reset = 0x0;
        } tx_buff_size[23:0];
    } TX_BUFF_SIZE @ 0x2084;

    reg {
        name = "DDR buffer write address register for the TX channel";
        desc = "TX_BUFF_WPTR is a DDR buffer write address register for the TX channel.

Data sheet 11.1.6 TX_BUFF_WPTR (offset 0x2088, printed page 11-27, `hi3518ev200--Hi3518EV20X-Hi3516CV200-Datasheet.txt` line 76891).";

        field {
            name = "tx_buff_wptr";
            desc = "Write address for the DDR buffer of the TX channel. Its unit is byte.";
            sw = rw;
            hw = r;
            reset = 0x0;
        } tx_buff_wptr[23:0];
    } TX_BUFF_WPTR @ 0x2088;

    reg {
        name = "DDR buffer read address register for the TX channel";
        desc = "TX_BUFF_RPTR is a DDR buffer read address register for the TX channel.

Data sheet 11.1.6 TX_BUFF_RPTR (offset 0x208C, printed page 11-28, `hi3518ev200--Hi3518EV20X-Hi3516CV200-Datasheet.txt` line 76928).";

        field {
            name = "tx_buff_rptr";
            desc = "Read address for the DDR buffer of the TX channel";
            sw = rw;
            hw = r;
            reset = 0x0;
        } tx_buff_rptr[23:0];
    } TX_BUFF_RPTR @ 0x208C;

    reg {
        name = "DDR buffer almost empty threshold Y_TH register for the TX channel";
        desc = "TX_BUFF_ALEMPTY_TH is a DDR buffer almost empty threshold register for the TX channel.

Data sheet 11.1.6 TX_BUFF_ALEMPTY_TH (offset 0x2090, printed page 11-28, `hi3518ev200--Hi3518EV20X-Hi3516CV200-Datasheet.txt` line 76953).";

        field {
            name = "tx_buff_alempty_th";
            desc = "Almost empty threshold for the DDR buffer of the TX channel. Its unit is byte. If the available space of the DDR buffer is below the almost empty threshold, the almost empty raw interrupt is generated.";
            sw = rw;
            hw = r;
            reset = 0x0;
        } tx_buff_alempty_th[23:0];
    } TX_BUFF_ALEMPTY_TH @ 0x2090;

    reg {
        name = "Data transfer length register for the TX channel";
        desc = "TX_TRANS_SIZE is a data transfer length register for the TX channel.

Data sheet 11.1.6 TX_TRANS_SIZE (offset 0x2094, printed page 11-29, `hi3518ev200--Hi3518EV20X-Hi3516CV200-Datasheet.txt` line 76987).";

        field {
            name = "tx_trans_size";
            desc = "After the TX channel transmits the audio data with the length of tx_trans_size (in byte), a transfer completion interrupt is generated.";
            sw = rw;
            hw = r;
            reset = 0x0;
        } tx_trans_size[23:0];
    } TX_TRANS_SIZE @ 0x2094;

`ifdef AIAO_HI3516A
    reg {
        name = "TX read address at the transfer completion interrupt";
        desc = "TX_RPTR_TMP is a read address storage register for the TX channel upon reporting of the transfer completion interrupt (Hi3516A/Hi3516D only).
Data sheet 12.3 TX_RPTR_TMP (offset 0x2098, printed page 12-41, `hi3516av100--Hi3516A-Hi3516D-Datasheet.txt` line 86235).";

        field {
            name = "tx_rptr_tmp";
            desc = "Read address of the TX channel saved when the transfer completion interrupt is reported.";
            sw = r;
            hw = w;
            reset = 0x0;
        } tx_rptr_tmp[23:0];
    } TX_RPTR_TMP @ 0x2098;
`endif

    reg {
        name = "Interrupt enable register for the TX channel";
        desc = "TX_INT_ENA is an interrupt enable register for the TX channel.

Data sheet 11.1.6 TX_INT_ENA (offset 0x20A0, printed page 11-29, `hi3518ev200--Hi3518EV20X-Hi3516CV200-Datasheet.txt` line 77009).";

        enum TX_INT_ENA_tx_dat_break_int_ena_enum {
            DISABLED = 0 { name = "Disabled"; desc = "disabled"; };
            ENABLED = 1 { name = "Enabled"; desc = "enabled"; };
        };

        field {
            name = "tx_dat_break_int_ena";
            desc = "Interface data break interrupt enable for the TX channel";
            sw = rw;
            hw = r;
            encode = TX_INT_ENA_tx_dat_break_int_ena_enum;
            reset = 0x0;
        } tx_dat_break_int_ena[7:7];

        enum TX_INT_ENA_tx_mfade_int_ena_enum {
            DISABLED = 0 { name = "Disabled"; desc = "disabled"; };
            ENABLED = 1 { name = "Enabled"; desc = "enabled"; };
        };

        field {
            name = "tx_mfade_int_ena";
            desc = "Mute fade-in/fade-output completion interrupt enable for the TX channel";
            sw = rw;
            hw = r;
            encode = TX_INT_ENA_tx_mfade_int_ena_enum;
            reset = 0x0;
        } tx_mfade_int_ena[6:6];

        enum TX_INT_ENA_tx_stop_int_ena_enum {
            DISABLED = 0 { name = "Disabled"; desc = "disabled"; };
            ENABLED = 1 { name = "Enabled"; desc = "enabled"; };
        };

        field {
            name = "tx_stop_int_ena";
            desc = "Stop interrupt enable for the TX channel";
            sw = rw;
            hw = r;
            encode = TX_INT_ENA_tx_stop_int_ena_enum;
            reset = 0x0;
        } tx_stop_int_ena[5:5];

        enum TX_INT_ENA_tx_ififo_empty_int_ena_enum {
            DISABLED = 0 { name = "Disabled"; desc = "disabled"; };
            ENABLED = 1 { name = "Enabled"; desc = "enabled"; };
        };

        field {
            name = "tx_ififo_empty_int_ena";
            desc = "Interface fifo underflow interrupt enable for the TX channel";
            sw = rw;
            hw = r;
            encode = TX_INT_ENA_tx_ififo_empty_int_ena_enum;
            reset = 0x0;
        } tx_ififo_empty_int_ena[4:4];

        enum TX_INT_ENA_tx_bfifo_empty_int_ena_enum {
            DISABLED = 0 { name = "Disabled"; desc = "disabled"; };
            ENABLED = 1 { name = "Enabled"; desc = "enabled"; };
        };

        field {
            name = "tx_bfifo_empty_int_ena";
            desc = "Bus fifo underflow interrupt enable for the TX channel";
            sw = rw;
            hw = r;
            encode = TX_INT_ENA_tx_bfifo_empty_int_ena_enum;
            reset = 0x0;
        } tx_bfifo_empty_int_ena[3:3];

        enum TX_INT_ENA_tx_alempty_int_ena_enum {
            DISABLED = 0 { name = "Disabled"; desc = "disabled"; };
            ENABLED = 1 { name = "Enabled"; desc = "enabled"; };
        };

        field {
            name = "tx_alempty_int_ena";
            desc = "DDR buffer almost empty interrupt enable for the TX channel";
            sw = rw;
            hw = r;
            encode = TX_INT_ENA_tx_alempty_int_ena_enum;
            reset = 0x0;
        } tx_alempty_int_ena[2:2];

        enum TX_INT_ENA_tx_empty_int_ena_enum {
            DISABLED = 0 { name = "Disabled"; desc = "disabled"; };
            ENABLED = 1 { name = "Enabled"; desc = "enabled"; };
        };

        field {
            name = "tx_empty_int_ena";
            desc = "DDR buffer empty interrupt for the TX channel";
            sw = rw;
            hw = r;
            encode = TX_INT_ENA_tx_empty_int_ena_enum;
            reset = 0x0;
        } tx_empty_int_ena[1:1];

        enum TX_INT_ENA_tx_trans_int_ena_enum {
            DISABLED = 0 { name = "Disabled"; desc = "disabled"; };
            ENABLED = 1 { name = "Enabled"; desc = "enabled"; };
        };

        field {
            name = "tx_trans_int_ena";
            desc = "Transfer completion interrupt enable for the TX channel";
            sw = rw;
            hw = r;
            encode = TX_INT_ENA_tx_trans_int_ena_enum;
            reset = 0x0;
        } tx_trans_int_ena[0:0];
    } TX_INT_ENA @ 0x20A0;

    reg {
        name = "Raw interrupt register for the TX channel";
        desc = "TX_INT_RAW is a raw interrupt register for the TX channel.

Data sheet 11.1.6 TX_INT_RAW (offset 0x20A4, printed page 11-30, `hi3518ev200--Hi3518EV20X-Hi3516CV200-Datasheet.txt` line 77078).";

        enum TX_INT_RAW_tx_dat_break_int_raw_enum {
            NO_RAW_INTERRUPT = 0 { name = "No Raw Interrupt"; desc = "No raw interrupt is generated."; };
            RAW_INTERRUPT_GENERATED = 1 { name = "Raw Interrupt Generated"; desc = "A raw interrupt is generated."; };
        };

        field {
            name = "tx_dat_break_int_raw";
            desc = "Interface data break raw interrupt of the TX channel";
            sw = r;
            hw = w;
            encode = TX_INT_RAW_tx_dat_break_int_raw_enum;
            reset = 0x0;
        } tx_dat_break_int_raw[7:7];

        enum TX_INT_RAW_tx_mfade_int_raw_enum {
            NO_RAW_INTERRUPT = 0 { name = "No Raw Interrupt"; desc = "No raw interrupt is generated."; };
            RAW_INTERRUPT_GENERATED = 1 { name = "Raw Interrupt Generated"; desc = "A raw interrupt is generated."; };
        };

        field {
            name = "tx_mfade_int_raw";
            desc = "Mute fade-in/fade-output completion raw interrupt of the TX channel";
            sw = r;
            hw = w;
            encode = TX_INT_RAW_tx_mfade_int_raw_enum;
            reset = 0x0;
        } tx_mfade_int_raw[6:6];

        enum TX_INT_RAW_tx_stop_int_raw_enum {
            NO_RAW_INTERRUPT = 0 { name = "No Raw Interrupt"; desc = "No raw interrupt is generated."; };
            RAW_INTERRUPT_GENERATED = 1 { name = "Raw Interrupt Generated"; desc = "A raw interrupt is generated."; };
        };

        field {
            name = "tx_stop_int_raw";
            desc = "Stop raw interrupt of the TX channel";
            sw = r;
            hw = w;
            encode = TX_INT_RAW_tx_stop_int_raw_enum;
            reset = 0x0;
        } tx_stop_int_raw[5:5];

        enum TX_INT_RAW_tx_ififo_empty_int_raw_enum {
            NO_RAW_INTERRUPT = 0 { name = "No Raw Interrupt"; desc = "No raw interrupt is generated."; };
            RAW_INTERRUPT_GENERATED = 1 { name = "Raw Interrupt Generated"; desc = "A raw interrupt is generated."; };
        };

        field {
            name = "tx_ififo_empty_int_raw";
            desc = "Interface fifo underflow raw interrupt of the TX channel";
            sw = r;
            hw = w;
            encode = TX_INT_RAW_tx_ififo_empty_int_raw_enum;
            reset = 0x0;
        } tx_ififo_empty_int_raw[4:4];

        enum TX_INT_RAW_tx_bfifo_empty_int_raw_enum {
            NO_RAW_INTERRUPT = 0 { name = "No Raw Interrupt"; desc = "No raw interrupt is generated."; };
            RAW_INTERRUPT_GENERATED = 1 { name = "Raw Interrupt Generated"; desc = "A raw interrupt is generated."; };
        };

        field {
            name = "tx_bfifo_empty_int_raw";
            desc = "Bus fifo underflow raw interrupt of the TX channel";
            sw = r;
            hw = w;
            encode = TX_INT_RAW_tx_bfifo_empty_int_raw_enum;
            reset = 0x0;
        } tx_bfifo_empty_int_raw[3:3];

        enum TX_INT_RAW_tx_alempty_int_raw_enum {
            NO_RAW_INTERRUPT = 0 { name = "No Raw Interrupt"; desc = "No raw interrupt is generated."; };
            RAW_INTERRUPT_GENERATED = 1 { name = "Raw Interrupt Generated"; desc = "A raw interrupt is generated."; };
        };

        field {
            name = "tx_alempty_int_raw";
            desc = "DDR buffer almost empty raw interrupt of the TX channel";
            sw = r;
            hw = w;
            encode = TX_INT_RAW_tx_alempty_int_raw_enum;
            reset = 0x0;
        } tx_alempty_int_raw[2:2];

        enum TX_INT_RAW_tx_empty_int_raw_enum {
            NO_RAW_INTERRUPT = 0 { name = "No Raw Interrupt"; desc = "No raw interrupt is generated."; };
            RAW_INTERRUPT_GENERATED = 1 { name = "Raw Interrupt Generated"; desc = "A raw interrupt is generated."; };
        };

        field {
            name = "tx_empty_int_raw";
            desc = "DDR buffer empty raw interrupt of the TX channel";
            sw = r;
            hw = w;
            encode = TX_INT_RAW_tx_empty_int_raw_enum;
            reset = 0x0;
        } tx_empty_int_raw[1:1];

        enum TX_INT_RAW_tx_trans_int_raw_enum {
            NO_RAW_INTERRUPT = 0 { name = "No Raw Interrupt"; desc = "No raw interrupt is generated."; };
            RAW_INTERRUPT_GENERATED = 1 { name = "Raw Interrupt Generated"; desc = "A raw interrupt is generated."; };
        };

        field {
            name = "tx_trans_int_raw";
            desc = "Transfer completion raw interrupt of the TX channel";
            sw = r;
            hw = w;
            encode = TX_INT_RAW_tx_trans_int_raw_enum;
            reset = 0x0;
        } tx_trans_int_raw[0:0];
    } TX_INT_RAW @ 0x20A4;

    reg {
        name = "Interrupt status register for the TX channel";
        desc = "TX_INT_STATUS is an interrupt status register for the TX channel.

Data sheet 11.1.6 TX_INT_STATUS (offset 0x20A8, printed page 11-32, `hi3518ev200--Hi3518EV20X-Hi3516CV200-Datasheet.txt` line 77158).";

        enum TX_INT_STATUS_tx_dat_break_int_status_enum {
            NO_INTERRUPT_GENERATED = 0 { name = "No Interrupt Generated"; desc = "No interrupt is generated."; };
            INTERRUPT_GENERATED = 1 { name = "Interrupt Generated"; desc = "An interrupt is generated."; };
        };

        field {
            name = "tx_dat_break_int_status";
            desc = "Status of the interface data break interrupt of the TX channel";
            sw = r;
            hw = w;
            encode = TX_INT_STATUS_tx_dat_break_int_status_enum;
            reset = 0x0;
        } tx_dat_break_int_status[7:7];

        enum TX_INT_STATUS_tx_mfade_int_status_enum {
            NO_INTERRUPT_GENERATED = 0 { name = "No Interrupt Generated"; desc = "No interrupt is generated."; };
            INTERRUPT_GENERATED = 1 { name = "Interrupt Generated"; desc = "An interrupt is generated."; };
        };

        field {
            name = "tx_mfade_int_status";
            desc = "Status of the mute fade-in/fade-output completion interrupt of the TX channel";
            sw = r;
            hw = w;
            encode = TX_INT_STATUS_tx_mfade_int_status_enum;
            reset = 0x0;
        } tx_mfade_int_status[6:6];

        enum TX_INT_STATUS_tx_stop_int_status_enum {
            NO_INTERRUPT_GENERATED = 0 { name = "No Interrupt Generated"; desc = "No interrupt is generated."; };
            INTERRUPT_GENERATED = 1 { name = "Interrupt Generated"; desc = "An interrupt is generated."; };
        };

        field {
            name = "tx_stop_int_status";
            desc = "Status of the stop interrupt of the TX interrupt";
            sw = r;
            hw = w;
            encode = TX_INT_STATUS_tx_stop_int_status_enum;
            reset = 0x0;
        } tx_stop_int_status[5:5];

        enum TX_INT_STATUS_tx_ififo_empty_int_status_enum {
            NO_INTERRUPT_GENERATED = 0 { name = "No Interrupt Generated"; desc = "No interrupt is generated."; };
            INTERRUPT_GENERATED = 1 { name = "Interrupt Generated"; desc = "An interrupt is generated."; };
        };

        field {
            name = "tx_ififo_empty_int_status";
            desc = "Status of the interface FIFO underflow interrupt of the TX channel";
            sw = r;
            hw = w;
            encode = TX_INT_STATUS_tx_ififo_empty_int_status_enum;
            reset = 0x0;
        } tx_ififo_empty_int_status[4:4];

        enum TX_INT_STATUS_tx_bfifo_empty_int_status_enum {
            NO_INTERRUPT_GENERATED = 0 { name = "No Interrupt Generated"; desc = "No interrupt is generated."; };
            INTERRUPT_GENERATED = 1 { name = "Interrupt Generated"; desc = "An interrupt is generated."; };
        };

        field {
            name = "tx_bfifo_empty_int_status";
            desc = "Status of the bus FIFO underflow interrupt of the TX channel";
            sw = r;
            hw = w;
            encode = TX_INT_STATUS_tx_bfifo_empty_int_status_enum;
            reset = 0x0;
        } tx_bfifo_empty_int_status[3:3];

        enum TX_INT_STATUS_tx_alempty_int_status_enum {
            NO_INTERRUPT_GENERATED = 0 { name = "No Interrupt Generated"; desc = "No interrupt is generated."; };
            INTERRUPT_GENERATED = 1 { name = "Interrupt Generated"; desc = "An interrupt is generated."; };
        };

        field {
            name = "tx_alempty_int_status";
            desc = "DDR buffer almost empty interrupt of the TX channel";
            sw = r;
            hw = w;
            encode = TX_INT_STATUS_tx_alempty_int_status_enum;
            reset = 0x0;
        } tx_alempty_int_status[2:2];

        enum TX_INT_STATUS_tx_empty_int_status_enum {
            NO_INTERRUPT_GENERATED = 0 { name = "No Interrupt Generated"; desc = "No interrupt is generated."; };
            INTERRUPT_GENERATED = 1 { name = "Interrupt Generated"; desc = "An interrupt is generated."; };
        };

        field {
            name = "tx_empty_int_status";
            desc = "Status of the DDR buffer empty interrupt of the TX channel";
            sw = r;
            hw = w;
            encode = TX_INT_STATUS_tx_empty_int_status_enum;
            reset = 0x0;
        } tx_empty_int_status[1:1];

        enum TX_INT_STATUS_tx_trans_int_status_enum {
            NO_INTERRUPT_GENERATED = 0 { name = "No Interrupt Generated"; desc = "No interrupt is generated."; };
            INTERRUPT_GENERATED = 1 { name = "Interrupt Generated"; desc = "An interrupt is generated."; };
        };

        field {
            name = "tx_trans_int_status";
            desc = "Status of the transfer completion interrupt of the TX channel";
            sw = r;
            hw = w;
            encode = TX_INT_STATUS_tx_trans_int_status_enum;
            reset = 0x0;
        } tx_trans_int_status[0:0];
    } TX_INT_STATUS @ 0x20A8;

    reg {
        name = "Interrupt clear register for the TX channel";
        desc = "TX_INT_CLR is an interrupt clear register for the TX channel.

The data sheet gives bit 7 (tx_dat_break_int_clear) the access type RO with the enable-register text; it is modelled write-one-to-clear like the other bits.

Data sheet 11.1.6 TX_INT_CLR (offset 0x20AC, printed page 11-33, `hi3518ev200--Hi3518EV20X-Hi3516CV200-Datasheet.txt` line 77229).";

        enum TX_INT_CLR_tx_dat_break_int_clear_enum {
            NOT_CLEARED = 0 { name = "Not Cleared"; desc = "not cleared"; };
            CLEARED = 1 { name = "Cleared"; desc = "cleared"; };
        };

        field {
            name = "tx_dat_break_int_clear";
            desc = "Interface data break interrupt clear for the TX channel";
            sw = rw;
            hw = w;
            onwrite = woclr;
            encode = TX_INT_CLR_tx_dat_break_int_clear_enum;
            reset = 0x0;
        } tx_dat_break_int_clear[7:7];

        enum TX_INT_CLR_tx_mfade_int_clear_enum {
            NOT_CLEARED = 0 { name = "Not Cleared"; desc = "not cleared"; };
            CLEARED = 1 { name = "Cleared"; desc = "cleared"; };
        };

        field {
            name = "tx_mfade_int_clear";
            desc = "Mute fade-in/fade-output completion interrupt clear for the TX channel";
            sw = rw;
            hw = w;
            onwrite = woclr;
            encode = TX_INT_CLR_tx_mfade_int_clear_enum;
            reset = 0x0;
        } tx_mfade_int_clear[6:6];

        enum TX_INT_CLR_tx_stop_int_clear_enum {
            NOT_CLEARED = 0 { name = "Not Cleared"; desc = "not cleared"; };
            CLEARED = 1 { name = "Cleared"; desc = "cleared"; };
        };

        field {
            name = "tx_stop_int_clear";
            desc = "Stop interrupt clear for the TX channel";
            sw = rw;
            hw = w;
            onwrite = woclr;
            encode = TX_INT_CLR_tx_stop_int_clear_enum;
            reset = 0x0;
        } tx_stop_int_clear[5:5];

        enum TX_INT_CLR_tx_ififo_empty_int_clear_enum {
            NOT_CLEARED = 0 { name = "Not Cleared"; desc = "not cleared"; };
            CLEARED = 1 { name = "Cleared"; desc = "cleared"; };
        };

        field {
            name = "tx_ififo_empty_int_clear";
            desc = "Interface fifo underflow interrupt clear for the TX channel";
            sw = rw;
            hw = w;
            onwrite = woclr;
            encode = TX_INT_CLR_tx_ififo_empty_int_clear_enum;
            reset = 0x0;
        } tx_ififo_empty_int_clear[4:4];

        enum TX_INT_CLR_tx_bfifo_empty_int_clear_enum {
            NOT_CLEARED = 0 { name = "Not Cleared"; desc = "not cleared"; };
            CLEARED = 1 { name = "Cleared"; desc = "cleared"; };
        };

        field {
            name = "tx_bfifo_empty_int_clear";
            desc = "Bus fifo underflow interrupt clear for the TX channel";
            sw = rw;
            hw = w;
            onwrite = woclr;
            encode = TX_INT_CLR_tx_bfifo_empty_int_clear_enum;
            reset = 0x0;
        } tx_bfifo_empty_int_clear[3:3];

        enum TX_INT_CLR_tx_alempty_int_clear_enum {
            NOT_CLEARED = 0 { name = "Not Cleared"; desc = "not cleared"; };
            CLEARED = 1 { name = "Cleared"; desc = "cleared"; };
        };

        field {
            name = "tx_alempty_int_clear";
            desc = "DDR buffer almost empty interrupt clear for the TX channel";
            sw = rw;
            hw = w;
            onwrite = woclr;
            encode = TX_INT_CLR_tx_alempty_int_clear_enum;
            reset = 0x0;
        } tx_alempty_int_clear[2:2];

        enum TX_INT_CLR_tx_empty_int_clear_enum {
            NOT_CLEARED = 0 { name = "Not Cleared"; desc = "not cleared"; };
            CLEARED = 1 { name = "Cleared"; desc = "cleared"; };
        };

        field {
            name = "tx_empty_int_clear";
            desc = "DDR buffer empty interrupt clear for the TX channel";
            sw = rw;
            hw = w;
            onwrite = woclr;
            encode = TX_INT_CLR_tx_empty_int_clear_enum;
            reset = 0x0;
        } tx_empty_int_clear[1:1];

        enum TX_INT_CLR_tx_trans_int_clear_enum {
            NOT_CLEARED = 0 { name = "Not Cleared"; desc = "not cleared"; };
            CLEARED = 1 { name = "Cleared"; desc = "cleared"; };
        };

        field {
            name = "tx_trans_int_clear";
            desc = "Transfer completion interrupt clear for the TX channel";
            sw = rw;
            hw = w;
            onwrite = woclr;
            encode = TX_INT_CLR_tx_trans_int_clear_enum;
            reset = 0x0;
        } tx_trans_int_clear[0:0];
    } TX_INT_CLR @ 0x20AC;
};

`endif
