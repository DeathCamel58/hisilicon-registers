`ifndef ARM_PL061_RDL
`define ARM_PL061_RDL

regfile eARM_PL061 {
    name = "ARM PL061";
    desc = "
    Each pin can be configured as input or output and these pins are used to generate input signals or output signals for special purposes. As input, each GPIO pin can act as an interrupt source; as output, each GPIO pin can be set to 0 or 1 separately. The GPIO can generate maskable interrupts based on the level or transition value. The general purpose input output interrupt (GPIOINTR) signal provides an indicator to the interrupt controller, indicating that an interrupt occurs.

    ## Features

    Each GPIO pin can be configured as input or output.
    * As input, each GPIO pin can act as an interrupt source.
    * As output, each GPIO can be set to 0 or 1 separately

    ## Operating Mode

    ### Interface Reset

    !!! NOTE
        Although this is based on the PL061, it looks like HiSilicon's implementation may be missing some of the registers. Consult the full PDF documentation of the SoC to find what registers exist.

        * ARM documentation can be found [here](https://developer.arm.com/documentation/ddi0190/b)
        * Datasheet of ARM PL061 can be found [here](https://documentation-service.arm.com/static/5e8e38e9fd977155116a9267)

    ## Instances per SoC

    The register map (GPIO_DATA .. GPIO_IC, 8-bit registers on a 4-byte stride, GPIO_DATA address-masked through PADDR[9:2]) is identical in every data sheet
    checked (Hi3511/Hi3512, Hi3515, Hi3516/Hi3516C/Hi3518 V100, Hi3516A/D V100, Hi3520/Hi3520D V100, Hi3518E V20X/Hi3516C V200, Hi3516A V200, Hi3519 V101,
    Hi3516C V300/Hi3516E V100, Hi3516A V300). The Hi3511 and Hi3515 data sheets also list a reserved register at 0x420 (no fields); it is not modelled.
    The PL061 PeriphID/PCellID registers (0xFE0..0xFFC) are not in any data sheet and are not modelled. Each bank has 8 pins unless noted.

    | SoC | Banks | Base addresses (4 KB each unless noted) | Interrupt |
    |-----|-------|------------------------------------------|-----------|
    | Hi3511 / Hi3512 | GPIO0-7 | 0x101E4000-0x101E7000 (GPIO0-3), 0x101F7000-0x101FA000 (GPIO4-7) | VIC 6 (GPIO0), 7 (GPIO1), 8 (GPIO2-7 combined) |
    | Hi3515 / Hi3520 V100 | GPIO0-7 | 0x20150000 + n x 0x10000 (64 KB windows) | VIC 6 (GPIO0), 7 (GPIO1), 8 (GPIO2-7 combined) |
    | Hi3516C V100 / Hi3518 V100 | GPIO0-11 | 0x20140000 + n x 0x10000 | VIC 29 (GPIO0/1/2/11), 30 (GPIO3/4/5/10), 31 (GPIO6/7/8/9) |
    | Hi3516 V100 | GPIO1-7, GPIO8-10 | 0x20160000-0x201C0000, 0x20200000-0x20220000 (0x20140000/0x20150000 are reserved: no GPIO0) | GIC 37-44 (GPIO0-7 as numbered by the data sheet), 87-89 (GPIO8-10) |
    | Hi3516A / Hi3516D V100 | GPIO0-15 | 0x20140000 + n x 0x10000 (GPIO0-14), 0x20260000 (GPIO15) | GIC 79-87 (GPIO0 .. GPIO8; GPIO15..GPIO9 share 81..87 pairwise) |
    | Hi3520D V100 | GPIO0-8 | 0x20150000 + n x 0x10000 | GIC 79-87 |
    | Hi3518E V20X / Hi3516C V200 | GPIO0-8 | 0x20140000 + n x 0x10000 | VIC 31 (all banks combined) |
    | Hi3516A V200 / Hi3519 V101 | GPIO0-14, GPIO16 | 0x12140000 + n x 0x1000 (GPIO0-14), 0x12150000 (GPIO16; no GPIO15) | GIC 75 (GPIO0-7), 76 (GPIO8-14, GPIO16) |
    | Hi3516C V300 / Hi3516E V100 | GPIO0-8 | 0x12140000 + n x 0x1000 | VIC 31 (all banks combined) |
    | Hi3516A V300 | GPIO0-11 (GPIO11 has 4 pins) | 0x120D0000 + n x 0x1000 | GIC 48-58 (GPIO0-10), 112 (GPIO11) |

    Second pass 2026-11-11 (scripted compare of all 15 data-sheet editions, bases and interrupts rechecked): no register difference. Notes: the Hi3515 English data sheet calls interrupt 8
    the combined interrupt of GPIO2-GPIO5 (the Hi3511 and Hi3520 Chinese sheets say GPIO2-GPIO7; the SoC has banks 0-7, so the English text is probably a typo); the Hi3518E V100 data sheet
    (no RDL chip) has 12 banks like Hi3518 V100 and VIC 29/30/31, not the 9 banks of the V20X edition. The data-sheet register 0x420 of Hi3511/Hi3515/Hi3520 (reserved, must be 0x00)
    is GPIOAFSEL (mode control select, reset 0x00) in the ARM PL061 TRM (DDI 0190B table 3-1); the other data sheets omit it. The TRM PeriphID0-3 are 0x61/0x10/0x04/0x00 (revision nibble
    in PeriphID2 is implementation dependent) and PCellID0-3 0x0D/0xF0/0x05/0xB1; Linux binds `arm,pl061` through the AMBA id 0x00041061 (mask 0x000fffff) without a periphid override on the
    Hi3520D, so the hardware ID matches (probe works on the board).
    ";

    // All GPIO registers are 8 bits wide in every data sheet (Hi3511 ... Hi3519, Hi3516Axxx). They keep the 4-byte
    // address stride of the APB map (the GPIO_DATA array below is explicit about it).
    default regwidth = 8;

    /* Fields */

    reg {
        name = "GPIO Data Register";
        desc = "
        GPIO_DATA is a GPIO data register. It is used to buffer the input or output data. When the corresponding bit of the GPIO_DIR is configured as output, the values written to the GPIO_DATA register are sent to the corresponding pin (note that the pin multiplexing configuration must be correct). If the bit is configured as input, the value of the corresponding input pin is read.

        !!! CAUTION
            If the corresponding bit of GPIO_DIR is configured as input, the pin value is returned after a valid read; if the corresponding bit is configured as output, the written value is returned after a valid read.

            Through PADDR[9:2], the GPIO_DATA register masks the read and write operations on the register. The register corresponds to 256 address spaces. PADDR[9:2] corresponds to GPIO_DATA[7:0]. When the corresponding bit is high, it can be read or written. When the corresponding bit is low, no operations are supported. For example:

            * If the address is 0x3FC (0b11_1111_1100), the operations on all the eight bits of GPIO_DATA bit[7:0] are valid.
            * If the address is 0x200 (0b10_0000_0000), only the operation on GPIO_DATA bit[7] is valid.
        ";

        field {
            name = "gpio_data";
            desc = "Indicates the GPIO input data when the GPIO is configured as input; indicates the GPIO output data when the GPIO is configured as output. Each bit can be controlled separately. The register is used together with GPIO_DIR.";
            reset = 0x0;
        } gpio_data[7:0];

    } GPIO_DATA[0x100] @ 0x000 += 0x4;

    reg {
        name = "GPIO Direction Control Register";
        desc = "GPIO_DIR is a GPIO direction control register. It is used to configure the direction of each GPIO pin.";

        enum GPIO_DIR_enum {
            INPUT  = 0x0 { desc = "Input"; };
            OUTPUT = 0x1 { desc = "Output"; };
        };

        field {
            name = "gpio_dir";
            desc = "GPIO direction control register. Bit[7:0] correspond to GPIO_DATA [7:0] respectively. Each bit can be controlled separately.";
            encode = GPIO_DIR_enum;
            reset = 0x0;
        } gpio_dir[7:0];

    } GPIO_DIR @ 0x400;

    reg {
        name = "GPIO Interrupt Trigger Register";
        desc = "GPIO_IS is a GPIO interrupt trigger register. It is used to configure the interrupt trigger mode.";

        enum GPIO_IS_enum {
            EDGE  = 0x0 { desc = "Edge sensitive mode"; };
            LEVEL = 0x1 { desc = "Level sensitive mode"; };
        };

        field {
            name = "gpio_is";
            desc = "GPIO interrupt trigger control register. Bit[7:0] correspond to GPIO_DATA [7:0]. Each bit is controlled separately.";
            encode = GPIO_IS_enum;
            reset = 0x0;
        } gpio_is[7:0];

    } GPIO_IS @ 0x404;

    reg {
        name = "GPIO Interrupt Dual-Edge Trigger Register";
        desc = "GPIO_IBE is a GPIO interrupt dual-edge trigger register. It is used to configure the edge trigger mode of each GPIO pin.";

        enum GPIO_IBE_enum {
            SINGLE_EDGE = 0x0 { desc = "single-edge-sensitive mode. The GPIO_IEV register controls whether the interrupt is rising-edge-sensitive or falling-edge-sensitive."; };
            DUAL_EDGE   = 0x1 { desc = "dual-edge-sensitive mode"; };
        };

        field {
            name = "gpio_ibe";
            desc = "GPIO interrupt edge control register. Bit[7:0] correspond to GPIO_DATA [7:0] respectively. Each bit is controlled independently.";
            encode = GPIO_IBE_enum;
            reset = 0x0;
        } gpio_ibe[7:0];

    } GPIO_IBE @ 0x408;

    reg {
        name = "GPIO Interrupt Event Register";
        desc = "GPIO_IEV is a GPIO interrupt event register. It is used to configure the interrupt trigger event of each GPIO pin.";

        enum GPIO_IEV_enum {
            FALLING = 0x0 { desc = "falling-edge-sensitive mode or low-level-sensitive mode"; };
            RISING  = 0x1 { desc = "rising-edge-sensitive mode or high-level-sensitive mode"; };
        };

        field {
            name = "gpio_iev";
            desc = "GPIO interrupt trigger event register. Bit[7:0] correspond to GPIO_DATA [7:0]. Each bit is controlled separately.";
            encode = GPIO_IEV_enum;
            reset = 0x0;
        } gpio_iev[7:0];

    } GPIO_IEV @ 0x40C;

    reg {
        name = "GPIO Interrupt Mask Register";
        desc = "GPIO_IE is a GPIO interrupt mask register. It is used to mask GPIO interrupts.";

        enum GPIO_IE_enum {
            MASKED     = 0x0 { desc = "Masked"; };
            NOT_MASKED = 0x1 { desc = "Not Masked"; };
        };

        field {
            name = "gpio_ie";
            desc = "GPIO interrupt mask register. Bit[7:0] correspond to GPIO_DATA [7:0]. Each bit is controlled separately.";
            encode = GPIO_IE_enum;
            reset = 0x0;
        } gpio_ie[7:0];

    } GPIO_IE @ 0x410;

    reg {
        name = "GPIO Raw Interrupt Status Register";
        desc = "GPIO_RIS is a GPIO raw interrupt status register. It is used to query the raw interrupt status of each GPIO pin. The Hi3520D data sheet describes gpio_ris with the opposite polarity (0: interrupt occurred, 1: not occurred), contradicting its own GPIO_MIS description and the PL061; the PL061 polarity (1 = interrupt pending) is kept here.";

        enum GPIO_RIS_enum {
            INVALID = 0x0 { desc = "The interrupt is invalid"; };
            VALID   = 0x1 { desc = "The interrupt is valid"; };
        };

        field {
            name = "gpio_ris";
            desc = "GPIO raw interrupt status register. Bit[7:0] correspond to GPIO_DATA [7:0], indicating the unmasked interrupt status. The status cannot be masked and controlled by the GPIO_IE register.";
            encode = GPIO_RIS_enum;
            sw = r;
            hw = w;
            reset = 0x0;
        } gpio_ris[7:0];

    } GPIO_RIS @ 0x414;

    reg {
        name = "GPIO Masked Interrupt Status Register";
        desc = "GPIO_MIS is a GPIO masked interrupt status register. It is used to query the masked interrupt status of each GPIO pin.";

        enum GPIO_MIS_enum {
            INVALID = 0x0 { desc = "The interrupt is invalid"; };
            VALID   = 0x1 { desc = "The interrupt is valid"; };
        };

        field {
            name = "gpio_mis";
            desc = "GPIO masked interrupt status register. Bit[7:0] correspond to GPIO_DATA [7:0], indicating the masked interrupt status. The status is controlled by the GPIO_IE register.";
            encode = GPIO_MIS_enum;
            sw = r;
            hw = w;
            reset = 0x0;
        } gpio_mis[7:0];

    } GPIO_MIS @ 0x418;

    reg {
        name = "GPIO Interrupt Clear Register";
        desc = "GPIO_IC is a GPIO interrupt clear register. It is used to clear the interrupts generated by GPIO pins and clear the GPIO_RIS and GPIO_MIS registers. ";

        enum GPIO_IC_enum {
            NO_EFFECT = 0x0 { desc = "No Effect"; };
            CLEARED   = 0x1 { desc = "Cleared"; };
        };

        field {
            name = "gpio_ic";
            desc = "GPIO interrupt clear register. Bit[7:0] correspond to GPIO_DATA [7:0]. Each bit is controlled separately. ";
            encode = GPIO_IC_enum;
            sw = w;
            onwrite = woclr;
            hw = r;
            reset = 0x0;
        } gpio_ic[7:0];

    } GPIO_IC @ 0x41C;
};
`endif
