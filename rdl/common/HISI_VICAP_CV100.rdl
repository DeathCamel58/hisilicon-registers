`ifndef HISI_VICAP_CV100_RDL
`define HISI_VICAP_CV100_RDL


regfile eHISI_VICAP_CV100 {
    name = "VICAP (video capture, Hi3516C V100 / Hi3518 V100 / Hi3518E V100)";
    desc = "Video capture unit (VICAP, interrupt 22) of the Hi3516C V100 and Hi3518A/C V100 at 0x20580000 (256 KB window, data sheet chapter 10.1; the ISP registers of this window are described in a separate chapter and not part of this regfile). The Hi3518 V100 and Hi3518E V100 data sheets list the same 116 registers with identical names, offsets and bit fields. Generated 2026-11-15 by scripts/rdl-extract/gen_m_cells.py from the data sheet register tables (ds_extract2 + description extraction from the PDF); PROVENANCE: PROVEN = offsets, names, bit fields, access and reset values from the data sheet tables; nothing here is hardware verified.

    Register sources: 116 registers from the data sheet (hi3516cv100--Hi3516C-Datasheet.txt, section 10.1.6). ";

    reg {
        name = "Global working configuration register";
        desc = "WK_MODE is a global working configuration register.

Data sheet 10.1.6 WK_MODE (offset 0x0, printed page 10-19, `hi3516cv100--Hi3516C-Datasheet.txt` line 37299).";

        enum WK_MODE_power_mode_enum {
            LOW_POWER_MODE = 0 { name = "Low Power Mode"; desc = "The low-power mode is disabled."; };
            LOW_POWER_MODE_2 = 1 { name = "Low Power Mode 2"; desc = "The low-power mode is enabled."; };
        };

        field {
            name = "power_mode";
            desc = "Clock mode.";
            sw = rw;
            hw = r;
            encode = WK_MODE_power_mode_enum;
            reset = 0x0;
        } power_mode[0:0];
    } WK_MODE @ 0x0;

    reg {
        name = "Bus configuration register";
        desc = "AXI_CFG is a bus configuration register.

Data sheet 10.1.6 AXI_CFG (offset 0x10, printed page 10-19, `hi3516cv100--Hi3516C-Datasheet.txt` line 37327).";

        field {
            name = "m0_otd";
            desc = "Number of outstandings. The value range is 1-4.";
            sw = rw;
            hw = r;
            reset = 0x0;
        } m0_otd[3:0];
    } AXI_CFG @ 0x10;

    reg {
        name = "Port input select register";
        desc = "PT_SEL is a port input select register.

Data sheet 10.1.6 PT_SEL (offset 0x20, printed page 10-20, `hi3516cv100--Hi3516C-Datasheet.txt` line 37357).";

        enum PT_SEL_pt0_sel_enum {
            EXTERNAL_INPUT = 0 { name = "External Input"; desc = "external input"; };
            COLORBAR = 1 { name = "Colorbar"; desc = "colorbar"; };
        };

        field {
            name = "pt0_sel";
            desc = "Port input select.";
            sw = rw;
            hw = r;
            encode = PT_SEL_pt0_sel_enum;
            reset = 0x0;
        } pt0_sel[0:0];
    } PT_SEL @ 0x20;

    reg {
        name = "Channel input select register";
        desc = "CH_SEL is a channel input select register.

Data sheet 10.1.6 CH_SEL (offset 0x30, printed page 10-20, `hi3516cv100--Hi3516C-Datasheet.txt` line 37381).";

        enum CH_SEL_ch0_sel_enum {
            ISP_BYPASS = 0 { name = "Isp Bypass"; desc = "ISP bypass"; };
            INPUT_FROM_ISP = 1 { name = "Input From Isp"; desc = "input from the ISP"; };
        };

        field {
            name = "ch0_sel";
            desc = "Channel input select.";
            sw = rw;
            hw = r;
            encode = CH_SEL_ch0_sel_enum;
            reset = 0x0;
        } ch0_sel[0:0];
    } CH_SEL @ 0x30;

    reg {
        name = "APB timeout register";
        desc = "APB_TIMEOUT is an APB timeout register.

Data sheet 10.1.6 APB_TIMEOUT (offset 0xE0, printed page 10-21, `hi3516cv100--Hi3516C-Datasheet.txt` line 37417).";

        enum APB_TIMEOUT_enable_f_enum {
            DISABLED = 0 { name = "Disabled"; desc = "disabled"; };
            ENABLED = 1 { name = "Enabled"; desc = "enabled"; };
        };

        field {
            name = "enable";
            desc = "Timeout enable.";
            sw = rw;
            hw = r;
            encode = APB_TIMEOUT_enable_f_enum;
            reset = 0x1;
        } enable_f[31:31];

        field {
            name = "timeout";
            desc = "Timeout threshold. The unit is APB clock.";
            sw = rw;
            hw = r;
            reset = 0x100;
        } timeout[15:0];
    } APB_TIMEOUT @ 0xE0;

    reg {
        name = "Interrupt indicator register";
        desc = "VICAP_INT is an interrupt indicator register.

Data sheet 10.1.6 VICAP_INT (offset 0xF0, printed page 10-21, `hi3516cv100--Hi3516C-Datasheet.txt` line 37441).";

        enum VICAP_INT_int_isp_enum {
            NO_INTERRUPT_GENERATED = 0 { name = "No Interrupt Generated"; desc = "No interrupt is generated."; };
            INTERRUPT_GENERATED = 1 { name = "Interrupt Generated"; desc = "An interrupt is generated."; };
        };

        field {
            name = "int_isp";
            desc = "ISP interrupt indicator.";
            sw = r;
            hw = w;
            encode = VICAP_INT_int_isp_enum;
            reset = 0x0;
        } int_isp[24:24];

        enum VICAP_INT_int_pt0_enum {
            NO_INTERRUPT_GENERATED = 0 { name = "No Interrupt Generated"; desc = "No interrupt is generated."; };
            INTERRUPT_GENERATED = 1 { name = "Interrupt Generated"; desc = "An interrupt is generated."; };
        };

        field {
            name = "int_pt0";
            desc = "Port 0 interrupt indicator.";
            sw = r;
            hw = w;
            encode = VICAP_INT_int_pt0_enum;
            reset = 0x0;
        } int_pt0[16:16];

        field {
            name = "int_ch0";
            desc = "int_ch0";
            sw = r;
            hw = w;
            reset = 0x0;
        } int_ch0[0:0];
    } VICAP_INT @ 0xF0;

    reg {
        name = "Interrupt indicator register";
        desc = "VICAP_INT_MASK is an interrupt indicator register.

Data sheet 10.1.6 VICAP_INT_MASK (offset 0xF8, printed page 10-22, `hi3516cv100--Hi3516C-Datasheet.txt` line 37497).";

        enum VICAP_INT_MASK_int_isp_en_enum {
            MASKED = 0 { name = "Masked"; desc = "masked"; };
            ENABLED = 1 { name = "Enabled"; desc = "enabled"; };
        };

        field {
            name = "int_isp_en";
            desc = "ISP interrupt enable.";
            sw = rw;
            hw = r;
            encode = VICAP_INT_MASK_int_isp_en_enum;
            reset = 0x1;
        } int_isp_en[24:24];

        enum VICAP_INT_MASK_int_pt0_en_enum {
            MASKED = 0 { name = "Masked"; desc = "masked"; };
            ENABLED = 1 { name = "Enabled"; desc = "enabled"; };
        };

        field {
            name = "int_pt0_en";
            desc = "Port 0 interrupt enable.";
            sw = rw;
            hw = r;
            encode = VICAP_INT_MASK_int_pt0_en_enum;
            reset = 0x1;
        } int_pt0_en[16:16];

        field {
            name = "int_ch0_en";
            desc = "int_ch0_en";
            sw = rw;
            hw = r;
            reset = 0x1;
        } int_ch0_en[0:0];
    } VICAP_INT_MASK @ 0xF8;

    reg {
        name = "Port mode register";
        desc = "PT_INTF_MOD is a port mode register.

Data sheet 10.1.6 PT_INTF_MOD (offset 0x100, printed page 10-23, `hi3516cv100--Hi3516C-Datasheet.txt` line 37560).";

        enum PT_INTF_MOD_enable_f_enum {
            DISABLED = 0 { name = "Disabled"; desc = "disabled"; };
            ENABLED = 1 { name = "Enabled"; desc = "enabled"; };
        };

        field {
            name = "enable";
            desc = "Port enable.";
            sw = rw;
            hw = r;
            encode = PT_INTF_MOD_enable_f_enum;
            reset = 0x0;
        } enable_f[31:31];

        enum PT_INTF_MOD_mode_enum {
            EXTERNAL_SYNCHRONIZATION = 0 { name = "External Synchronization"; desc = "external synchronization"; };
            BT_656 = 1 { name = "Bt 656"; desc = "BT.656"; };
        };

        field {
            name = "mode";
            desc = "Timing mode.";
            sw = rw;
            hw = r;
            encode = PT_INTF_MOD_mode_enum;
            reset = 0x0;
        } mode[0:0];
    } PT_INTF_MOD @ 0x100;

    reg {
        name = "Component 0 offset register";
        desc = "PT_OFFSET0 is component 0 offset register.

Data sheet 10.1.6 PT_OFFSET0 (offset 0x110, printed page 10-24, `hi3516cv100--Hi3516C-Datasheet.txt` line 37596).";

        field {
            name = "mask";
            desc = "Component 0 mask.";
            sw = rw;
            hw = r;
            reset = 0xFFF0;
        } mask_f[31:16];

        enum PT_OFFSET0_rev_enum {
            NO = 0 { name = "No"; desc = "no"; };
            YES = 1 { name = "Yes"; desc = "yes"; };
        };

        field {
            name = "rev";
            desc = "Whether the data line is reversed.";
            sw = rw;
            hw = r;
            encode = PT_OFFSET0_rev_enum;
            reset = 0x0;
        } rev[15:15];

        field {
            name = "offset";
            desc = "Component 0 offset.";
            sw = rw;
            hw = r;
            reset = 0x0;
        } offset[5:0];
    } PT_OFFSET0 @ 0x110;

    reg {
        name = "Component 1 offset register";
        desc = "PT_OFFSET1 is component 1 offset register.

Data sheet 10.1.6 PT_OFFSET1 (offset 0x114, printed page 10-24, `hi3516cv100--Hi3516C-Datasheet.txt` line 37620).";

        field {
            name = "mask";
            desc = "Component 1 mask.";
            sw = rw;
            hw = r;
            reset = 0xFFF0;
        } mask_f[31:16];

        enum PT_OFFSET1_rev_enum {
            NO = 0 { name = "No"; desc = "no"; };
            YES = 1 { name = "Yes"; desc = "yes"; };
        };

        field {
            name = "rev";
            desc = "Whether the data line is reversed.";
            sw = rw;
            hw = r;
            encode = PT_OFFSET1_rev_enum;
            reset = 0x0;
        } rev[15:15];

        field {
            name = "offset";
            desc = "Component 1 offset.";
            sw = rw;
            hw = r;
            reset = 0x10;
        } offset[5:0];
    } PT_OFFSET1 @ 0x114;

    reg {
        name = "Component 2 offset register";
        desc = "PT_OFFSET2 is component 2 offset register.

Data sheet 10.1.6 PT_OFFSET2 (offset 0x118, printed page 10-25, `hi3516cv100--Hi3516C-Datasheet.txt` line 37653).";

        field {
            name = "mask";
            desc = "Component 2 mask.";
            sw = rw;
            hw = r;
            reset = 0xFFF0;
        } mask_f[31:16];

        enum PT_OFFSET2_rev_enum {
            NO = 0 { name = "No"; desc = "no"; };
            YES = 1 { name = "Yes"; desc = "yes"; };
        };

        field {
            name = "rev";
            desc = "Whether the data line is reversed.";
            sw = rw;
            hw = r;
            encode = PT_OFFSET2_rev_enum;
            reset = 0x0;
        } rev[15:15];

        field {
            name = "offset";
            desc = "Component 2 offset.";
            sw = rw;
            hw = r;
            reset = 0x20;
        } offset[5:0];
    } PT_OFFSET2 @ 0x118;

    reg {
        name = "PT_BT656_CFG";
        desc = "PT_BT656_CFG is a BT.656 configuration register.

Data sheet 10.1.6 PT_BT656_CFG (offset 0x120, printed page 10-25, `hi3516cv100--Hi3516C-Datasheet.txt` line 37677).";

        enum PT_BT656_CFG_enable_f_enum {
            DISABLED = 0 { name = "Disabled"; desc = "disabled"; };
            ENABLED = 1 { name = "Enabled"; desc = "enabled"; };
        };

        field {
            name = "enable";
            desc = "BT.656 enable.";
            sw = rw;
            hw = r;
            encode = PT_BT656_CFG_enable_f_enum;
            reset = 0x0;
        } enable_f[31:31];

        enum PT_BT656_CFG_field_inv_enum {
            NOT_REVERSED = 0 { name = "Not Reversed"; desc = "not reversed"; };
            REVERSED = 1 { name = "Reversed"; desc = "reversed"; };
        };

        field {
            name = "field_inv";
            desc = "Field reverse control.";
            sw = rw;
            hw = r;
            encode = PT_BT656_CFG_field_inv_enum;
            reset = 0x0;
        } field_inv[10:10];

        enum PT_BT656_CFG_vsync_inv_enum {
            NOT_REVERSED = 0 { name = "Not Reversed"; desc = "not reversed"; };
            REVERSED = 1 { name = "Reversed"; desc = "reversed"; };
        };

        field {
            name = "vsync_inv";
            desc = "vsync reverse control.";
            sw = rw;
            hw = r;
            encode = PT_BT656_CFG_vsync_inv_enum;
            reset = 0x1;
        } vsync_inv[9:9];

        field {
            name = "hsync_inv";
            desc = "hsync_inv";
            sw = rw;
            hw = r;
            reset = 0x1;
        } hsync_inv[8:8];

        field {
            name = "mode";
            desc = "mode";
            sw = rw;
            hw = r;
            reset = 0x3;
        } mode[3:0];
    } PT_BT656_CFG @ 0x120;

    reg {
        name = "Timing configuration register";
        desc = "PT_UNIFY_TIMING_CFG is a timing configuration register.

Data sheet 10.1.6 PT_UNIFY_TIMING_CFG (offset 0x130, printed page 10-27, `hi3516cv100--Hi3516C-Datasheet.txt` line 37761).";

        enum PT_UNIFY_TIMING_CFG_field_inv_enum {
            NOT_REVERSED = 0 { name = "Not Reversed"; desc = "not reversed"; };
            REVERSED = 1 { name = "Reversed"; desc = "reversed"; };
        };

        field {
            name = "field_inv";
            desc = "Field reverse (level-1 processing for field).";
            sw = rw;
            hw = r;
            encode = PT_UNIFY_TIMING_CFG_field_inv_enum;
            reset = 0x0;
        } field_inv[26:26];

        enum PT_UNIFY_TIMING_CFG_field_sel_enum {
            INPUT_FIELD = 0 { name = "Input Field"; desc = "input field"; };
            INPUT_VSYNC = 1 { name = "Input Vsync"; desc = "input vsync"; };
            DETECTED_BASED_RELATIONSHIP = 2 { name = "Detected Based Relationship"; desc = "detected based on the relationship between vsync and hsync"; };
            V_0 = 3 { name = "V 0"; desc = "0"; };
        };

        field {
            name = "field_sel";
            desc = "Field source select (level-0 processing for field).";
            sw = rw;
            hw = r;
            encode = PT_UNIFY_TIMING_CFG_field_sel_enum;
            reset = 0x0;
        } field_sel[25:24];

        enum PT_UNIFY_TIMING_CFG_vsync_mode_enum {
            NO_OPERATION_PERFORMED = 0 { name = "No Operation Performed"; desc = "No operation is performed."; };
            PULSES_GENERATED_BASED = 1 { name = "Pulses Generated Based"; desc = "Pulses are generated based on the rising edge."; };
            PULSES_GENERATED_BASED_2 = 2 { name = "Pulses Generated Based 2"; desc = "Pulses are generated based on the rising and falling edge."; };
            RESERVED = 3 { name = "Reserved"; desc = "reserved"; };
        };

        field {
            name = "vsync_mode";
            desc = "vsync processing mode (level-2 processing for vsync).";
            sw = rw;
            hw = r;
            encode = PT_UNIFY_TIMING_CFG_vsync_mode_enum;
            reset = 0x1;
        } vsync_mode[20:19];

        enum PT_UNIFY_TIMING_CFG_vsync_inv_enum {
            NOT_REVERSED = 0 { name = "Not Reversed"; desc = "not reversed"; };
            REVERSED = 1 { name = "Reversed"; desc = "reversed"; };
        };

        field {
            name = "vsync_inv";
            desc = "vsync reverse (level-1 processing for vsync).";
            sw = rw;
            hw = r;
            encode = PT_UNIFY_TIMING_CFG_vsync_inv_enum;
            reset = 0x0;
        } vsync_inv[18:18];

        enum PT_UNIFY_TIMING_CFG_vsync_sel_enum {
            INPUT_VSYNC = 0 { name = "Input Vsync"; desc = "input vsync"; };
            INPUT_FIELD = 1 { name = "Input Field"; desc = "input field"; };
            V_0 = 2 { name = "V 0"; desc = "0"; };
            RESERVED = 3 { name = "Reserved"; desc = "reserved"; };
        };

        field {
            name = "vsync_sel";
            desc = "vsync source select (level-0 processing for vsync).";
            sw = rw;
            hw = r;
            encode = PT_UNIFY_TIMING_CFG_vsync_sel_enum;
            reset = 0x0;
        } vsync_sel[17:16];

        enum PT_UNIFY_TIMING_CFG_hsync_mode_enum {
            NO_OPERATION_PERFORMED = 0 { name = "No Operation Performed"; desc = "No operation is performed."; };
            PULSES_GENERATED_BASED = 1 { name = "Pulses Generated Based"; desc = "Pulses are generated based on the rising edge."; };
        };

        field {
            name = "hsync_mode";
            desc = "hsync processing mode (level-3 processing for hsync).";
            sw = rw;
            hw = r;
            encode = PT_UNIFY_TIMING_CFG_hsync_mode_enum;
            reset = 0x1;
        } hsync_mode[14:13];

        field {
            name = "hsync_and";
            desc = "hsync_and";
            sw = rw;
            hw = r;
            reset = 0x1;
        } hsync_and[12:11];

        field {
            name = "hsync_inv";
            desc = "hsync_inv";
            sw = rw;
            hw = r;
            reset = 0x0;
        } hsync_inv[10:10];

        field {
            name = "hsync_sel";
            desc = "hsync_sel";
            sw = rw;
            hw = r;
            reset = 0x0;
        } hsync_sel[9:8];

        field {
            name = "de_inv";
            desc = "de_inv";
            sw = rw;
            hw = r;
            reset = 0x0;
        } de_inv[2:2];

        field {
            name = "de_sel";
            desc = "de_sel";
            sw = rw;
            hw = r;
            reset = 0x1;
        } de_sel[1:0];
    } PT_UNIFY_TIMING_CFG @ 0x130;

    reg {
        name = "Timing restoration module configuration register";
        desc = "PT_GEN_TIMING_CFG is a timing restoration module configuration register.

Data sheet 10.1.6 PT_GEN_TIMING_CFG (offset 0x134, printed page 10-29, `hi3516cv100--Hi3516C-Datasheet.txt` line 37874).";

        enum PT_GEN_TIMING_CFG_enable_f_enum {
            DISABLED = 0 { name = "Disabled"; desc = "disabled"; };
            ENABLED = 1 { name = "Enabled"; desc = "enabled"; };
        };

        field {
            name = "enable";
            desc = "Timing restoration enable. Timings are resorted based on timing parameters.";
            sw = rw;
            hw = r;
            encode = PT_GEN_TIMING_CFG_enable_f_enum;
            reset = 0x0;
        } enable_f[31:31];

        enum PT_GEN_TIMING_CFG_vsync_mode_enum {
            NOT_RESTORED = 0 { name = "Not Restored"; desc = "not restored"; };
            RESTORED = 1 { name = "Restored"; desc = "restored"; };
        };

        field {
            name = "vsync_mode";
            desc = "vsync restore.";
            sw = rw;
            hw = r;
            encode = PT_GEN_TIMING_CFG_vsync_mode_enum;
            reset = 0x0;
        } vsync_mode[2:2];

        enum PT_GEN_TIMING_CFG_hsync_mode_enum {
            NOT_RESTORED = 0 { name = "Not Restored"; desc = "not restored"; };
            RESTORED = 1 { name = "Restored"; desc = "restored"; };
        };

        field {
            name = "hsync_mode";
            desc = "hsync restore.";
            sw = rw;
            hw = r;
            encode = PT_GEN_TIMING_CFG_hsync_mode_enum;
            reset = 0x0;
        } hsync_mode[1:1];
    } PT_GEN_TIMING_CFG @ 0x134;

    reg {
        name = "Data configuration register";
        desc = "PT_UNIFY_DATA_CFG is a data configuration register.

Data sheet 10.1.6 PT_UNIFY_DATA_CFG (offset 0x140, printed page 10-30, `hi3516cv100--Hi3516C-Datasheet.txt` line 37921).";

        enum PT_UNIFY_DATA_CFG_enable_f_enum {
            DISABLED = 0 { name = "Disabled"; desc = "disabled"; };
            ENABLED = 1 { name = "Enabled"; desc = "enabled"; };
        };

        field {
            name = "enable";
            desc = "Data separation enable.";
            sw = rw;
            hw = r;
            encode = PT_UNIFY_DATA_CFG_enable_f_enum;
            reset = 0x0;
        } enable_f[31:31];

        enum PT_UNIFY_DATA_CFG_uv_seq_enum {
            CBCR = 0 { name = "Cbcr"; desc = "CbCr"; };
            CRCB = 1 { name = "Crcb"; desc = "CrCb"; };
        };

        field {
            name = "uv_seq";
            desc = "CbCr sequence.";
            sw = rw;
            hw = r;
            encode = PT_UNIFY_DATA_CFG_uv_seq_enum;
            reset = 0x0;
        } uv_seq[3:3];

        enum PT_UNIFY_DATA_CFG_yc_seq_enum {
            CY = 0 { name = "Cy"; desc = "CY"; };
            YC = 1 { name = "Yc"; desc = "YC"; };
        };

        field {
            name = "yc_seq";
            desc = "YC sequence.";
            sw = rw;
            hw = r;
            encode = PT_UNIFY_DATA_CFG_yc_seq_enum;
            reset = 0x0;
        } yc_seq[2:2];

        enum PT_UNIFY_DATA_CFG_comp_num_enum {
            COMPONENT_1 = 0 { name = "Component 1"; desc = "component 1"; };
            COMPONENT_2 = 1 { name = "Component 2"; desc = "component 2"; };
            COMPONENT_3 = 2 { name = "Component 3"; desc = "component 3"; };
            RESERVED = 3 { name = "Reserved"; desc = "reserved"; };
        };

        field {
            name = "comp_num";
            desc = "Data component select.";
            sw = rw;
            hw = r;
            encode = PT_UNIFY_DATA_CFG_comp_num_enum;
            reset = 0x0;
        } comp_num[1:0];
    } PT_UNIFY_DATA_CFG @ 0x140;

    reg {
        name = "Data generation module configuration register";
        desc = "PT_GEN_DATA_CFG is a data generation module configuration register.

Data sheet 10.1.6 PT_GEN_DATA_CFG (offset 0x144, printed page 10-31, `hi3516cv100--Hi3516C-Datasheet.txt` line 37968).";

        enum PT_GEN_DATA_CFG_enable_f_enum {
            DISABLED = 0 { name = "Disabled"; desc = "disabled"; };
            ENABLED = 1 { name = "Enabled"; desc = "enabled"; };
        };

        field {
            name = "enable";
            desc = "Timing restoration enable. Timings are resorted based on timing parameters.";
            sw = rw;
            hw = r;
            encode = PT_GEN_DATA_CFG_enable_f_enum;
            reset = 0x0;
        } enable_f[31:31];

        enum PT_GEN_DATA_CFG_data2_move_enum {
            NO_INCREMENT = 0 { name = "No Increment"; desc = "no increment"; };
            INCREMENT = 1 { name = "Increment"; desc = "increment"; };
        };

        field {
            name = "data2_move";
            desc = "Data 2 increment.";
            sw = rw;
            hw = r;
            encode = PT_GEN_DATA_CFG_data2_move_enum;
            reset = 0x1;
        } data2_move[7:7];

        enum PT_GEN_DATA_CFG_data1_move_enum {
            NO_INCREMENT = 0 { name = "No Increment"; desc = "no increment"; };
            INCREMENT = 1 { name = "Increment"; desc = "increment"; };
        };

        field {
            name = "data1_move";
            desc = "Data 1 increment.";
            sw = rw;
            hw = r;
            encode = PT_GEN_DATA_CFG_data1_move_enum;
            reset = 0x1;
        } data1_move[6:6];

        enum PT_GEN_DATA_CFG_data0_move_enum {
            NO_INCREMENT = 0 { name = "No Increment"; desc = "no increment"; };
            INCREMENT = 1 { name = "Increment"; desc = "increment"; };
        };

        field {
            name = "data0_move";
            desc = "Data 0 increment.";
            sw = rw;
            hw = r;
            encode = PT_GEN_DATA_CFG_data0_move_enum;
            reset = 0x1;
        } data0_move[5:5];

        enum PT_GEN_DATA_CFG_vsync_reset_enum {
            NOT_RESET = 0 { name = "Not Reset"; desc = "not reset"; };
            RESET_F = 1 { name = "Reset F"; desc = "reset"; };
        };

        field {
            name = "vsync_reset";
            desc = "Data reset for the vsync signal.";
            sw = rw;
            hw = r;
            encode = PT_GEN_DATA_CFG_vsync_reset_enum;
            reset = 0x0;
        } vsync_reset[4:4];

        enum PT_GEN_DATA_CFG_hsync_reset_enum {
            NOT_RESET = 0 { name = "Not Reset"; desc = "not reset"; };
            RESET_F = 1 { name = "Reset F"; desc = "reset"; };
        };

        field {
            name = "hsync_reset";
            desc = "Data reset for the hsync signal.";
            sw = rw;
            hw = r;
            encode = PT_GEN_DATA_CFG_hsync_reset_enum;
            reset = 0x1;
        } hsync_reset[3:3];

        enum PT_GEN_DATA_CFG_vsync_move_enum {
            NO_INCREMENT = 0 { name = "No Increment"; desc = "no increment"; };
            INCREMENT = 1 { name = "Increment"; desc = "increment"; };
        };

        field {
            name = "vsync_move";
            desc = "Data increment for the vsync signal.";
            sw = rw;
            hw = r;
            encode = PT_GEN_DATA_CFG_vsync_move_enum;
            reset = 0x0;
        } vsync_move[2:2];

        enum PT_GEN_DATA_CFG_hsync_move_enum {
            NO_INCREMENT = 0 { name = "No Increment"; desc = "no increment"; };
            INCREMENT = 1 { name = "Increment"; desc = "increment"; };
        };

        field {
            name = "hsync_move";
            desc = "Data increment for the hsync signal.";
            sw = rw;
            hw = r;
            encode = PT_GEN_DATA_CFG_hsync_move_enum;
            reset = 0x0;
        } hsync_move[1:1];

        field {
            name = "de_move";
            desc = "de_move";
            sw = rw;
            hw = r;
            reset = 0x1;
        } de_move[0:0];
    } PT_GEN_DATA_CFG @ 0x144;

    reg {
        name = "Data generation module coefficient register";
        desc = "PT_GEN_DATA_COEF is a data generation module coefficient register.

Data sheet 10.1.6 PT_GEN_DATA_COEF (offset 0x148, printed page 10-32, `hi3516cv100--Hi3516C-Datasheet.txt` line 38049).";

        field {
            name = "inc_frame";
            desc = "Pixel incremental value between frames. The incremental value is accumulated in the upper eight bits of data.";
            sw = rw;
            hw = r;
            reset = 0x1;
        } inc_frame[31:24];

        field {
            name = "step_frame";
            desc = "Pixel value increment interval between frames. The configured value is the actual value minus 1. The value 0 indicates that the pixel value is incremented in each frame.";
            sw = rw;
            hw = r;
            reset = 0x0;
        } step_frame[23:16];

        field {
            name = "inc_space";
            desc = "Data pixel incremental value. The incremental value is accumulated in the upper 10 bits of data.";
            sw = rw;
            hw = r;
            reset = 0x1;
        } inc_space[15:8];

        field {
            name = "step_space";
            desc = "Pixel increment interval between pixels. The value 0 indicates that the pixel value is incremented for each pixel.";
            sw = rw;
            hw = r;
            reset = 0x0;
        } step_space[7:0];
    } PT_GEN_DATA_COEF @ 0x148;

    reg {
        name = "Data generation module initial value register";
        desc = "PT_GEN_DATA_INIT is a data generation module initial value register.

Data sheet 10.1.6 PT_GEN_DATA_INIT (offset 0x14C, printed page 10-33, `hi3516cv100--Hi3516C-Datasheet.txt` line 38087).";

        field {
            name = "data2";
            desc = "Initial V/B value.";
            sw = rw;
            hw = r;
            reset = 0x0;
        } data2[23:16];

        field {
            name = "data1";
            desc = "Initial U/G value.";
            sw = rw;
            hw = r;
            reset = 0x0;
        } data1[15:8];

        field {
            name = "data0";
            desc = "Initial Y/R value.";
            sw = rw;
            hw = r;
            reset = 0x0;
        } data0[7:0];
    } PT_GEN_DATA_INIT @ 0x14C;

    reg {
        name = "YUV444 configuration register";
        desc = "PT_YUV444_CFG is a YUV444 configuration register.

Data sheet 10.1.6 PT_YUV444_CFG (offset 0x150, printed page 10-33, `hi3516cv100--Hi3516C-Datasheet.txt` line 38109).";

        enum PT_YUV444_CFG_enable_f_enum {
            DISABLED = 0 { name = "Disabled"; desc = "disabled"; };
            ENABLED = 1 { name = "Enabled"; desc = "enabled"; };
        };

        field {
            name = "enable";
            desc = "YUV enable. YUV422 signals are converted into YUV444 signals.";
            sw = rw;
            hw = r;
            encode = PT_YUV444_CFG_enable_f_enum;
            reset = 0x0;
        } enable_f[31:31];
    } PT_YUV444_CFG @ 0x150;

    reg {
        name = "Port fstart interrupt delay register";
        desc = "PT_FSTART_DLY is a port fstart interrupt delay register.

Data sheet 10.1.6 PT_FSTART_DLY (offset 0x160, printed page 10-34, `hi3516cv100--Hi3516C-Datasheet.txt` line 38141).";

        field {
            name = "fstart_dly";
            desc = "Delay time. Its unit is port clock.";
            sw = rw;
            hw = r;
            reset = 0x0;
        } fstart_dly[31:0];
    } PT_FSTART_DLY @ 0x160;

    reg {
        name = "Horizontal front blanking width register";
        desc = "PT_INTF_HFB is a horizontal front blanking width register.

Data sheet 10.1.6 PT_INTF_HFB (offset 0x180, printed page 10-34, `hi3516cv100--Hi3516C-Datasheet.txt` line 38160).";

        field {
            name = "hfb";
            desc = "Horizontal front blanking width.";
            sw = rw;
            hw = r;
            reset = 0x10;
        } hfb[15:0];
    } PT_INTF_HFB @ 0x180;

    reg {
        name = "Horizontal active width register";
        desc = "PT_INTF_HACT is a horizontal active width register.

Data sheet 10.1.6 PT_INTF_HACT (offset 0x184, printed page 10-34, `hi3516cv100--Hi3516C-Datasheet.txt` line 38179).";

        field {
            name = "hact";
            desc = "Horizontal active width. Its unit is clock cycle.";
            sw = rw;
            hw = r;
            reset = 0x10;
        } hact[15:0];
    } PT_INTF_HACT @ 0x184;

    reg {
        name = "Horizontal back blanking width register";
        desc = "PT_INTF_HBB is a horizontal back blanking width register.

Data sheet 10.1.6 PT_INTF_HBB (offset 0x188, printed page 10-35, `hi3516cv100--Hi3516C-Datasheet.txt` line 38204).";

        field {
            name = "hbb";
            desc = "Horizontal back blanking width.";
            sw = rw;
            hw = r;
            reset = 0x10;
        } hbb[15:0];
    } PT_INTF_HBB @ 0x188;

    reg {
        name = "Vertical front blanking width register";
        desc = "PT_INTF_VFB is a vertical front blanking width register.

Data sheet 10.1.6 PT_INTF_VFB (offset 0x18C, printed page 10-35, `hi3516cv100--Hi3516C-Datasheet.txt` line 38224).";

        field {
            name = "vfb";
            desc = "Vertical front blanking width.";
            sw = rw;
            hw = r;
            reset = 0x10;
        } vfb[15:0];
    } PT_INTF_VFB @ 0x18C;

    reg {
        name = "Vertical active width register";
        desc = "PT_INTF_VACT is a vertical active width register.

Data sheet 10.1.6 PT_INTF_VACT (offset 0x190, printed page 10-35, `hi3516cv100--Hi3516C-Datasheet.txt` line 38243).";

        field {
            name = "vact";
            desc = "vact";
            sw = rw;
            hw = r;
            reset = 0x10;
        } vact[15:0];
    } PT_INTF_VACT @ 0x190;

    reg {
        name = "Vertical back blanking width register";
        desc = "PT_INTF_VBB is a vertical back blanking width register.

Data sheet 10.1.6 PT_INTF_VBB (offset 0x194, printed page 10-36, `hi3516cv100--Hi3516C-Datasheet.txt` line 38283).";

        field {
            name = "vbb";
            desc = "Vertical back blanking width.";
            sw = rw;
            hw = r;
            reset = 0x10;
        } vbb[15:0];
    } PT_INTF_VBB @ 0x194;

    reg {
        name = "Vertical bottom front blanking width register";
        desc = "PT_INTF_VBFB is a vertical bottom front blanking width register.

Data sheet 10.1.6 PT_INTF_VBFB (offset 0x198, printed page 10-36, `hi3516cv100--Hi3516C-Datasheet.txt` line 38302).";

        field {
            name = "vbfb";
            desc = "Vertical bottom front blanking width.";
            sw = rw;
            hw = r;
            reset = 0x10;
        } vbfb[15:0];
    } PT_INTF_VBFB @ 0x198;

    reg {
        name = "Vertical bottom active width register";
        desc = "PT_INTF_VBACT is a vertical bottom active width register.

Data sheet 10.1.6 PT_INTF_VBACT (offset 0x19C, printed page 10-37, `hi3516cv100--Hi3516C-Datasheet.txt` line 38327).";

        field {
            name = "vact";
            desc = "Vertical bottom active width.";
            sw = rw;
            hw = r;
            reset = 0x10;
        } vact[15:0];
    } PT_INTF_VBACT @ 0x19C;

    reg {
        name = "Vertical bottom back blanking width register";
        desc = "PT_INTF_VBBB is a vertical bottom back blanking width register.

Data sheet 10.1.6 PT_INTF_VBBB (offset 0x1A0, printed page 10-37, `hi3516cv100--Hi3516C-Datasheet.txt` line 38347).";

        field {
            name = "vbbb";
            desc = "Vertical bottom back blanking width.";
            sw = rw;
            hw = r;
            reset = 0x10;
        } vbbb[15:0];
    } PT_INTF_VBBB @ 0x1A0;

    reg {
        name = "Camera flash configuration register";
        desc = "PT_FLASH_CFG is a camera flash configuration register.

Data sheet 10.1.6 PT_FLASH_CFG (offset 0x1B0, printed page 10-38, `hi3516cv100--Hi3516C-Datasheet.txt` line 38375).";

        enum PT_FLASH_CFG_shutter_times_enum {
            TWICE = 0 { name = "Twice"; desc = "twice"; };
            ONCE = 1 { name = "Once"; desc = "once"; };
        };

        field {
            name = "shutter_times";
            desc = "Shutter pulse times.";
            sw = rw;
            hw = r;
            encode = PT_FLASH_CFG_shutter_times_enum;
            reset = 0x0;
        } shutter_times[18:18];

        enum PT_FLASH_CFG_shutter_phase_enum {
            NOT_REVERSED = 0 { name = "Not Reversed"; desc = "not reversed"; };
            REVERSED = 1 { name = "Reversed"; desc = "reversed"; };
        };

        field {
            name = "shutter_phase";
            desc = "Shutter signal reverse.";
            sw = rw;
            hw = r;
            encode = PT_FLASH_CFG_shutter_phase_enum;
            reset = 0x0;
        } shutter_phase[17:17];

        field {
            name = "shutter_en";
            desc = "Shutter enable. This field is automatically cleared.";
            sw = w;
            hw = r;
            reset = 0x0;
        } shutter_en[16:16];

        enum PT_FLASH_CFG_flash_phase_enum {
            NOT_REVERSED = 0 { name = "Not Reversed"; desc = "not reversed"; };
            REVERSED = 1 { name = "Reversed"; desc = "reversed"; };
        };

        field {
            name = "flash_phase";
            desc = "Camera flash signal reverse.";
            sw = rw;
            hw = r;
            encode = PT_FLASH_CFG_flash_phase_enum;
            reset = 0x0;
        } flash_phase[1:1];

        field {
            name = "flash_en";
            desc = "Camera flash enable. This field is automatically cleared.";
            sw = w;
            hw = r;
            reset = 0x0;
        } flash_en[0:0];
    } PT_FLASH_CFG @ 0x1B0;

    reg {
        name = "Flash timing 0 width register";
        desc = "PT_FLASH_CYC0 is flash timing 0 width register.

Data sheet 10.1.6 PT_FLASH_CYC0 (offset 0x1C0, printed page 10-38, `hi3516cv100--Hi3516C-Datasheet.txt` line 38412).";

        field {
            name = "cyc";
            desc = "Duration of flash timing 0. Its unit is port clock. The configured value is the actual value minus 1.";
            sw = rw;
            hw = r;
            reset = 0x0;
        } cyc[31:0];
    } PT_FLASH_CYC0 @ 0x1C0;

    reg {
        name = "Flash timing 1 width register";
        desc = "PT_FLASH_CYC1 is flash timing 1 width register.

Data sheet 10.1.6 PT_FLASH_CYC1 (offset 0x1C4, printed page 10-39, `hi3516cv100--Hi3516C-Datasheet.txt` line 38439).";

        field {
            name = "cyc";
            desc = "Duration of flash timing 1. Its unit is port clock. The configured value is the actual value minus 1.";
            sw = rw;
            hw = r;
            reset = 0x0;
        } cyc[31:0];
    } PT_FLASH_CYC1 @ 0x1C4;

    reg {
        name = "Shutter timing 0 width register";
        desc = "PT_SHUTTER_CYC0 is shutter timing 0 width register.

Data sheet 10.1.6 PT_SHUTTER_CYC0 (offset 0x1D0, printed page 10-39, `hi3516cv100--Hi3516C-Datasheet.txt` line 38459).";

        field {
            name = "cyc";
            desc = "Duration of shutter timing 0. Its unit is port clock. The configured value is the actual value minus 1.";
            sw = rw;
            hw = r;
            reset = 0x0;
        } cyc[31:0];
    } PT_SHUTTER_CYC0 @ 0x1D0;

    reg {
        name = "Shutter timing 1 width register";
        desc = "PT_SHUTTER_CYC1 is shutter timing 1 width register.

Data sheet 10.1.6 PT_SHUTTER_CYC1 (offset 0x1D4, printed page 10-40, `hi3516cv100--Hi3516C-Datasheet.txt` line 38489).";

        field {
            name = "cyc";
            desc = "Duration of shutter timing 1. Its unit is port clock. The configured value is the actual value minus 1.";
            sw = rw;
            hw = r;
            reset = 0x0;
        } cyc[31:0];
    } PT_SHUTTER_CYC1 @ 0x1D4;

    reg {
        name = "Shutter timing 2 width register";
        desc = "PT_SHUTTER_CYC2 is shutter timing 2 width register.

Data sheet 10.1.6 PT_SHUTTER_CYC2 (offset 0x1D8, printed page 10-40, `hi3516cv100--Hi3516C-Datasheet.txt` line 38510).";

        field {
            name = "cyc";
            desc = "Duration of shutter timing 2. Its unit is port clock. The configured value is the actual value minus 1.";
            sw = rw;
            hw = r;
            reset = 0x0;
        } cyc[31:0];
    } PT_SHUTTER_CYC2 @ 0x1D8;

    reg {
        name = "Shutter timing 3 width register";
        desc = "PT_SHUTTER_CYC3 is shutter timing 3 width register.

Data sheet 10.1.6 PT_SHUTTER_CYC3 (offset 0x1DC, printed page 10-40, `hi3516cv100--Hi3516C-Datasheet.txt` line 38531).";

        field {
            name = "cyc";
            desc = "Duration of shutter timing 3. Its unit is port clock. The configured value is the actual value minus 1.";
            sw = rw;
            hw = r;
            reset = 0x0;
        } cyc[31:0];
    } PT_SHUTTER_CYC3 @ 0x1DC;

    reg {
        name = "Port status register";
        desc = "PT_STATUS is a port status register.

Data sheet 10.1.6 PT_STATUS (offset 0x1E0, printed page 10-41, `hi3516cv100--Hi3516C-Datasheet.txt` line 38557).";

        field {
            name = "field";
            desc = "Field signal output over the port.";
            sw = r;
            hw = w;
            reset = 0x0;
        } field_f[3:3];

        field {
            name = "vysnc";
            desc = "vysnc signal output over the port.";
            sw = r;
            hw = w;
            reset = 0x0;
        } vysnc[2:2];

        field {
            name = "hsync";
            desc = "hsync signal output over the port.";
            sw = r;
            hw = w;
            reset = 0x0;
        } hsync[1:1];

        field {
            name = "de";
            desc = "de signal output over the port.";
            sw = r;
            hw = w;
            reset = 0x0;
        } de[0:0];
    } PT_STATUS @ 0x1E0;

    reg {
        name = "PT_BT656_STATUS";
        desc = "PT_BT656_STATUS is a BT.656 status register.

Data sheet 10.1.6 PT_BT656_STATUS (offset 0x1E4, printed page 10-41, `hi3516cv100--Hi3516C-Datasheet.txt` line 38582).";

        field {
            name = "seav";
            desc = "Synchronization code.";
            sw = r;
            hw = w;
            reset = 0x0;
        } seav[15:8];
    } PT_BT656_STATUS @ 0x1E4;

    reg {
        name = "Input size indicator register";
        desc = "PT_SIZE is an input size indicator register.

Data sheet 10.1.6 PT_SIZE (offset 0x1EC, printed page 10-42, `hi3516cv100--Hi3516C-Datasheet.txt` line 38612).";

        field {
            name = "height";
            desc = "Picture height. Its unit is pixel.";
            sw = r;
            hw = w;
            reset = 0x0;
        } height[31:16];

        field {
            name = "width";
            desc = "Picture width. Its unit is pixel.";
            sw = r;
            hw = w;
            reset = 0x0;
        } width[15:0];
    } PT_SIZE @ 0x1EC;

    reg {
        name = "Channel interrupt indicator register";
        desc = "PT_INT is a channel interrupt indicator register.

Data sheet 10.1.6 PT_INT (offset 0x1F0, printed page 10-42, `hi3516cv100--Hi3516C-Datasheet.txt` line 38632).";

        enum PT_INT_height_err_enum {
            NO_INTERRUPT_GENERATED = 0 { name = "No Interrupt Generated"; desc = "No interrupt is generated."; };
            INTERRUPT_GENERATED = 1 { name = "Interrupt Generated"; desc = "An interrupt is generated."; };
        };

        field {
            name = "height_err";
            desc = "Status of the picture height change interrupt. Writing 1 clears the status.";
            sw = rw;
            hw = w;
            onwrite = woclr;
            encode = PT_INT_height_err_enum;
            reset = 0x0;
        } height_err[2:2];

        enum PT_INT_width_err_enum {
            NO_INTERRUPT_GENERATED = 0 { name = "No Interrupt Generated"; desc = "No interrupt is generated."; };
            INTERRUPT_GENERATED = 1 { name = "Interrupt Generated"; desc = "An interrupt is generated."; };
        };

        field {
            name = "width_err";
            desc = "Status of the picture width change interrupt. Writing 1 clears the status.";
            sw = rw;
            hw = w;
            onwrite = woclr;
            encode = PT_INT_width_err_enum;
            reset = 0x0;
        } width_err[1:1];

        enum PT_INT_fstart_enum {
            NO_INTERRUPT_GENERATED = 0 { name = "No Interrupt Generated"; desc = "No interrupt is generated."; };
            INTERRUPT_GENERATED = 1 { name = "Interrupt Generated"; desc = "An interrupt is generated."; };
        };

        field {
            name = "fstart";
            desc = "Status of the field/frame start interrupt. Writing 1 clears the status.";
            sw = rw;
            hw = w;
            onwrite = woclr;
            encode = PT_INT_fstart_enum;
            reset = 0x0;
        } fstart[0:0];
    } PT_INT @ 0x1F0;

    reg {
        name = "Channel interrupt mask register";
        desc = "PT_INT_MASK is a channel interrupt mask register.

Data sheet 10.1.6 PT_INT_MASK (offset 0x1F8, printed page 10-43, `hi3516cv100--Hi3516C-Datasheet.txt` line 38676).";

        enum PT_INT_MASK_height_err_en_enum {
            MASKED = 0 { name = "Masked"; desc = "masked"; };
            ENABLED = 1 { name = "Enabled"; desc = "enabled"; };
        };

        field {
            name = "height_err_en";
            desc = "Picture height change interrupt enable.";
            sw = rw;
            hw = r;
            encode = PT_INT_MASK_height_err_en_enum;
            reset = 0x0;
        } height_err_en[2:2];

        enum PT_INT_MASK_width_err_en_enum {
            MASKED = 0 { name = "Masked"; desc = "masked"; };
            ENABLED = 1 { name = "Enabled"; desc = "enabled"; };
        };

        field {
            name = "width_err_en";
            desc = "Picture width change interrupt enable.";
            sw = rw;
            hw = r;
            encode = PT_INT_MASK_width_err_en_enum;
            reset = 0x0;
        } width_err_en[1:1];

        enum PT_INT_MASK_fstart_en_enum {
            MASKED = 0 { name = "Masked"; desc = "masked"; };
            ENABLED = 1 { name = "Enabled"; desc = "enabled"; };
        };

        field {
            name = "fstart_en";
            desc = "Frame/Field start interrupt enable.";
            sw = rw;
            hw = r;
            encode = PT_INT_MASK_fstart_en_enum;
            reset = 0x0;
        } fstart_en[0:0];
    } PT_INT_MASK @ 0x1F8;

    reg {
        name = "Channel control register";
        desc = "CH_CTRL is a channel control register.

Data sheet 10.1.6 CH_CTRL (offset 0x1000, printed page 10-44, `hi3516cv100--Hi3516C-Datasheet.txt` line 38720).";

        enum CH_CTRL_enable_f_enum {
            DISABLED = 0 { name = "Disabled"; desc = "disabled"; };
            ENABLED_0X1000_0X1FFF = 1 { name = "Enabled 0X1000 0X1Fff"; desc = "enabled 0x1000-0x1FFF indicates the channel address range."; };
        };

        field {
            name = "enable";
            desc = "Channel enable.";
            sw = rw;
            hw = r;
            encode = CH_CTRL_enable_f_enum;
            reset = 0x0;
        } enable_f[31:31];
    } CH_CTRL @ 0x1000;

    reg {
        name = "Capture control register";
        desc = "CH_REG_NEWER is a capture control register.

Data sheet 10.1.6 CH_REG_NEWER (offset 0x1004, printed page 10-44, `hi3516cv100--Hi3516C-Datasheet.txt` line 38745).";

        field {
            name = "reg_newer";
            desc = "Channel updated. This bit is automatically cleared when a frame is received.";
            sw = rw;
            hw = r;
            reset = 0x0;
        } reg_newer[0:0];
    } CH_REG_NEWER @ 0x1004;

    reg {
        name = "Timing adaptation register";
        desc = "CH_ADAPTER_CFG is a timing adaptation register.

Data sheet 10.1.6 CH_ADAPTER_CFG (offset 0x1010, printed page 10-45, `hi3516cv100--Hi3516C-Datasheet.txt` line 38782).";

        enum CH_ADAPTER_CFG_vsync_mode_enum {
            NO_DELAY = 0 { name = "No Delay"; desc = "no delay"; };
            DELAY = 1 { name = "Delay"; desc = "delay"; };
        };

        field {
            name = "vsync_mode";
            desc = "Delay processing for the vsync signal.";
            sw = rw;
            hw = r;
            encode = CH_ADAPTER_CFG_vsync_mode_enum;
            reset = 0x1;
        } vsync_mode[1:1];

        enum CH_ADAPTER_CFG_hsync_mode_enum {
            NO_DELAY = 0 { name = "No Delay"; desc = "no delay"; };
            DELAY = 1 { name = "Delay"; desc = "delay"; };
        };

        field {
            name = "hsync_mode";
            desc = "Delay processing for the hsync signal.";
            sw = rw;
            hw = r;
            encode = CH_ADAPTER_CFG_hsync_mode_enum;
            reset = 0x1;
        } hsync_mode[0:0];
    } CH_ADAPTER_CFG @ 0x1010;

    reg {
        name = "Y component control register for the PACK module";
        desc = "CH_PACK_Y_CFG is a Y component control register for the PACK module.

Data sheet 10.1.6 CH_PACK_Y_CFG (offset 0x1080, printed page 10-45, `hi3516cv100--Hi3516C-Datasheet.txt` line 38813).";

        enum CH_PACK_Y_CFG_mode_enum {
            NORMAL_MODE = 0 { name = "Normal Mode"; desc = "normal mode"; };
            MIRROR_MODE_OTHER = 3 { name = "Mirror Mode Other"; desc = "mirror mode Other values: reserved"; };
        };

        field {
            name = "mode";
            desc = "PACK mode.";
            sw = rw;
            hw = r;
            encode = CH_PACK_Y_CFG_mode_enum;
            reset = 0x0;
        } mode[31:30];

        field {
            name = "bitw";
            desc = "bitw";
            sw = rw;
            hw = r;
            reset = 0x8;
        } bitw[7:0];
    } CH_PACK_Y_CFG @ 0x1080;

    reg {
        name = "Y component input width register for the PACK module";
        desc = "CH_PACK_Y_WIDTH is a Y component input width register for the PACK module.

Data sheet 10.1.6 CH_PACK_Y_WIDTH (offset 0x1084, printed page 10-46, `hi3516cv100--Hi3516C-Datasheet.txt` line 38866).";

        field {
            name = "width";
            desc = "Number of input bits of the PACK module. The configured value is the actual value minus 1.";
            sw = rw;
            hw = r;
            reset = 0x27FF;
        } width[19:0];
    } CH_PACK_Y_WIDTH @ 0x1084;

    reg {
        name = "C component control register for the PACK module";
        desc = "CH_PACK_C_CFG is a C component control register for the PACK module.

Data sheet 10.1.6 CH_PACK_C_CFG (offset 0x1090, printed page 10-47, `hi3516cv100--Hi3516C-Datasheet.txt` line 38897).";

        enum CH_PACK_C_CFG_mode_enum {
            NORMAL_MODE = 0 { name = "Normal Mode"; desc = "normal mode"; };
            MIRROR_MODE_OTHER = 3 { name = "Mirror Mode Other"; desc = "mirror mode Other values: reserved"; };
        };

        field {
            name = "mode";
            desc = "PACK mode.";
            sw = rw;
            hw = r;
            encode = CH_PACK_C_CFG_mode_enum;
            reset = 0x0;
        } mode[31:30];

        field {
            name = "bitw";
            desc = "Data bit width. 0x10: 8 bits Other values: reserved";
            sw = rw;
            hw = r;
            reset = 0x10;
        } bitw[7:0];
    } CH_PACK_C_CFG @ 0x1090;

    reg {
        name = "C component input width register for the PACK module";
        desc = "CH_PACK_C_WIDTH is a C component input width register for the PACK module.

Data sheet 10.1.6 CH_PACK_C_WIDTH (offset 0x1094, printed page 10-47, `hi3516cv100--Hi3516C-Datasheet.txt` line 38926).";

        field {
            name = "width";
            desc = "Number of input bits of the PACK module. The configured value is the actual value minus 1.";
            sw = rw;
            hw = r;
            reset = 0x27FF;
        } width[19:0];
    } CH_PACK_C_WIDTH @ 0x1094;

    reg {
        name = "Y component configuration register for the DES module";
        desc = "CH_DES_Y_CFG is a Y component configuration register for the DES module.

Data sheet 10.1.6 CH_DES_Y_CFG (offset 0x10B0, printed page 10-48, `hi3516cv100--Hi3516C-Datasheet.txt` line 38957).";

        field {
            name = "buf_len";
            desc = "Buffer size of the DES module. Its unit is 128 bits and it must be an integral multiple of 16. The configured value is the actual value minus 1.";
            sw = rw;
            hw = r;
            reset = 0x3F;
        } buf_len[31:16];

        field {
            name = "dis";
            desc = "Minimum interval between two consecutive bus requests. Its unit is channel clock.";
            sw = rw;
            hw = r;
            reset = 0x8;
        } dis[15:8];

        enum CH_DES_Y_CFG_flip_enum {
            DISABLED = 0 { name = "Disabled"; desc = "disabled"; };
            ENABLED = 1 { name = "Enabled"; desc = "enabled"; };
        };

        field {
            name = "flip";
            desc = "Flip enable.";
            sw = rw;
            hw = r;
            encode = CH_DES_Y_CFG_flip_enum;
            reset = 0x0;
        } flip[1:1];

        enum CH_DES_Y_CFG_mirror_enum {
            DISABLED = 0 { name = "Disabled"; desc = "disabled"; };
            ENABLED = 1 { name = "Enabled"; desc = "enabled"; };
        };

        field {
            name = "mirror";
            desc = "Mirror enable.";
            sw = rw;
            hw = r;
            encode = CH_DES_Y_CFG_mirror_enum;
            reset = 0x0;
        } mirror[0:0];
    } CH_DES_Y_CFG @ 0x10B0;

    reg {
        name = "Y component storage base address register";
        desc = "CH_DES_Y_FADDR is a Y component storage base address register.

Data sheet 10.1.6 CH_DES_Y_FADDR (offset 0x10B4, printed page 10-48, `hi3516cv100--Hi3516C-Datasheet.txt` line 38989).";

        field {
            name = "faddr";
            desc = "Base address for storing the Y component in raw streams.";
            sw = rw;
            hw = r;
            reset = 0x0;
        } faddr[31:0];
    } CH_DES_Y_FADDR @ 0x10B4;

    reg {
        name = "Y component storage size register";
        desc = "CH_DES_Y_SIZE is a Y component storage size register.

Data sheet 10.1.6 CH_DES_Y_SIZE (offset 0x10B8, printed page 10-49, `hi3516cv100--Hi3516C-Datasheet.txt` line 39017).";

        field {
            name = "height";
            desc = "Y component output height. Its unit is line. The configured value is the actual value minus 1.";
            sw = rw;
            hw = r;
            reset = 0x2CF;
        } height[31:16];

        field {
            name = "width";
            desc = "Y component output width. Its unit is 128 bits. The configured value is the actual value minus 1.";
            sw = rw;
            hw = r;
            reset = 0x4F;
        } width[11:0];
    } CH_DES_Y_SIZE @ 0x10B8;

    reg {
        name = "Y component stride register";
        desc = "CH_DES_Y_STRIDE is a Y component stride register.

Data sheet 10.1.6 CH_DES_Y_STRIDE (offset 0x10BC, printed page 10-49, `hi3516cv100--Hi3516C-Datasheet.txt` line 39042).";

        field {
            name = "stride";
            desc = "Stride for storing the Y component. Its unit is byte.";
            sw = rw;
            hw = r;
            reset = 0x500;
        } stride[15:0];
    } CH_DES_Y_STRIDE @ 0x10BC;

    reg {
        name = "C component configuration register for the DES module";
        desc = "CH_DES_C_CFG is a C component configuration register for the DES module.

Data sheet 10.1.6 CH_DES_C_CFG (offset 0x10C0, printed page 10-50, `hi3516cv100--Hi3516C-Datasheet.txt` line 39071).";

        field {
            name = "buf_len";
            desc = "Buffer size of the DES module. Its unit is 128 bits and it must be an integral multiple of 16. The configured value is the actual value minus 1.";
            sw = rw;
            hw = r;
            reset = 0x3F;
        } buf_len[31:16];

        field {
            name = "dis";
            desc = "Minimum interval between two consecutive bus requests. Its unit is channel clock.";
            sw = rw;
            hw = r;
            reset = 0x8;
        } dis[15:8];

        enum CH_DES_C_CFG_flip_enum {
            DISABLED = 0 { name = "Disabled"; desc = "disabled"; };
            ENABLED = 1 { name = "Enabled"; desc = "enabled"; };
        };

        field {
            name = "flip";
            desc = "Flip enable.";
            sw = rw;
            hw = r;
            encode = CH_DES_C_CFG_flip_enum;
            reset = 0x0;
        } flip[1:1];

        enum CH_DES_C_CFG_mirror_enum {
            DISABLED = 0 { name = "Disabled"; desc = "disabled"; };
            ENABLED = 1 { name = "Enabled"; desc = "enabled"; };
        };

        field {
            name = "mirror";
            desc = "Mirror enable.";
            sw = rw;
            hw = r;
            encode = CH_DES_C_CFG_mirror_enum;
            reset = 0x0;
        } mirror[0:0];
    } CH_DES_C_CFG @ 0x10C0;

    reg {
        name = "C component storage base address register";
        desc = "CH_DES_C_FADDR is a C component storage base address register.

Data sheet 10.1.6 CH_DES_C_FADDR (offset 0x10C4, printed page 10-50, `hi3516cv100--Hi3516C-Datasheet.txt` line 39103).";

        field {
            name = "faddr";
            desc = "Base address for storing the C component in raw streams.";
            sw = rw;
            hw = r;
            reset = 0x0;
        } faddr[31:0];
    } CH_DES_C_FADDR @ 0x10C4;

    reg {
        name = "C component storage size register";
        desc = "CH_DES_C_SIZE is a C component storage size register.

Data sheet 10.1.6 CH_DES_C_SIZE (offset 0x10C8, printed page 10-51, `hi3516cv100--Hi3516C-Datasheet.txt` line 39131).";

        field {
            name = "height";
            desc = "C component output height. Its unit is line. The configured value is the actual value minus 1.";
            sw = rw;
            hw = r;
            reset = 0x2CF;
        } height[31:16];

        field {
            name = "width";
            desc = "C component output width. Its unit is 128 bits. The configured value is the actual value minus 1.";
            sw = rw;
            hw = r;
            reset = 0x4F;
        } width[11:0];
    } CH_DES_C_SIZE @ 0x10C8;

    reg {
        name = "C component stride register";
        desc = "CH_DES_C_STRIDE is a C component stride register.

Data sheet 10.1.6 CH_DES_C_STRIDE (offset 0x10CC, printed page 10-51, `hi3516cv100--Hi3516C-Datasheet.txt` line 39156).";

        field {
            name = "stride";
            desc = "Stride for storing the C component. Its unit is byte.";
            sw = rw;
            hw = r;
            reset = 0x500;
        } stride[15:0];
    } CH_DES_C_STRIDE @ 0x10CC;

    reg {
        name = "Channel raw interrupt register";
        desc = "CH_INT is a channel raw interrupt register.

Data sheet 10.1.6 CH_INT (offset 0x10F0, printed page 10-52, `hi3516cv100--Hi3516C-Datasheet.txt` line 39185).";

        enum CH_INT_bus_err_y_enum {
            NO_INTERRUPT_GENERATED = 0 { name = "No Interrupt Generated"; desc = "No interrupt is generated."; };
            INTERRUPT_GENERATED = 1 { name = "Interrupt Generated"; desc = "An interrupt is generated."; };
        };

        field {
            name = "bus_err_y";
            desc = "Status of the Y data channel bus error interrupt. Writing 1 clears the status.";
            sw = rw;
            hw = w;
            onwrite = woclr;
            encode = CH_INT_bus_err_y_enum;
            reset = 0x0;
        } bus_err_y[6:6];

        enum CH_INT_bus_err_c_enum {
            NO_INTERRUPT_GENERATED = 0 { name = "No Interrupt Generated"; desc = "No interrupt is generated."; };
            INTERRUPT_GENERATED = 1 { name = "Interrupt Generated"; desc = "An interrupt is generated."; };
        };

        field {
            name = "bus_err_c";
            desc = "Status of the C data channel bus error interrupt. Writing 1 clears the status.";
            sw = rw;
            hw = w;
            onwrite = woclr;
            encode = CH_INT_bus_err_c_enum;
            reset = 0x0;
        } bus_err_c[5:5];

        enum CH_INT_update_cfg_enum {
            NO_INTERRUPT_GENERATED = 0 { name = "No Interrupt Generated"; desc = "No interrupt is generated."; };
            INTERRUPT_GENERATED = 1 { name = "Interrupt Generated"; desc = "An interrupt is generated."; };
        };

        field {
            name = "update_cfg";
            desc = "Status of the register update interrupt. Writing 1 clears the status.";
            sw = rw;
            hw = w;
            onwrite = woclr;
            encode = CH_INT_update_cfg_enum;
            reset = 0x0;
        } update_cfg[4:4];

        enum CH_INT_field_throw_enum {
            NO_INTERRUPT_GENERATED = 0 { name = "No Interrupt Generated"; desc = "No interrupt is generated."; };
            INTERRUPT_GENERATED = 1 { name = "Interrupt Generated"; desc = "An interrupt is generated."; };
        };

        field {
            name = "field_throw";
            desc = "Status of the field/frame loss interrupt. Writing 1 clears the status.";
            sw = rw;
            hw = w;
            onwrite = woclr;
            encode = CH_INT_field_throw_enum;
            reset = 0x0;
        } field_throw[3:3];

        enum CH_INT_buf_ovf_enum {
            NO_INTERRUPT_GENERATED = 0 { name = "No Interrupt Generated"; desc = "No interrupt is generated."; };
            INTERRUPT_GENERATED = 1 { name = "Interrupt Generated"; desc = "An interrupt is generated."; };
        };

        field {
            name = "buf_ovf";
            desc = "Status of the internal FIFO overflow error interrupt. Writing 1 clears the status.";
            sw = rw;
            hw = w;
            onwrite = woclr;
            encode = CH_INT_buf_ovf_enum;
            reset = 0x0;
        } buf_ovf[2:2];

        enum CH_INT_cc_int_enum {
            NO_INTERRUPT_GENERATED = 0 { name = "No Interrupt Generated"; desc = "No interrupt is generated."; };
            INTERRUPT_GENERATED = 1 { name = "Interrupt Generated"; desc = "An interrupt is generated."; };
        };

        field {
            name = "cc_int";
            desc = "Status of the capture completion interrupt. Writing 1 clears the status.";
            sw = rw;
            hw = w;
            onwrite = woclr;
            encode = CH_INT_cc_int_enum;
            reset = 0x0;
        } cc_int[1:1];

        enum CH_INT_fstart_enum {
            NO_INTERRUPT_GENERATED = 0 { name = "No Interrupt Generated"; desc = "No interrupt is generated."; };
            INTERRUPT_GENERATED = 1 { name = "Interrupt Generated"; desc = "An interrupt is generated."; };
        };

        field {
            name = "fstart";
            desc = "Status of the field/frame start interrupt. Writing 1 clears the status.";
            sw = rw;
            hw = w;
            onwrite = woclr;
            encode = CH_INT_fstart_enum;
            reset = 0x0;
        } fstart[0:0];
    } CH_INT @ 0x10F0;

    reg {
        name = "Channel interrupt mask register";
        desc = "CH_INT_MASK is a channel interrupt mask register.

Data sheet 10.1.6 CH_INT_MASK (offset 0x10F8, printed page 10-53, `hi3516cv100--Hi3516C-Datasheet.txt` line 39245).";

        enum CH_INT_MASK_bus_err_y_en_enum {
            MASKED = 0 { name = "Masked"; desc = "masked"; };
            ENABLED = 1 { name = "Enabled"; desc = "enabled"; };
        };

        field {
            name = "bus_err_y_en";
            desc = "Y data channel bus error interrupt enable.";
            sw = rw;
            hw = r;
            encode = CH_INT_MASK_bus_err_y_en_enum;
            reset = 0x0;
        } bus_err_y_en[6:6];

        enum CH_INT_MASK_bus_err_c_en_enum {
            MASKED = 0 { name = "Masked"; desc = "masked"; };
            ENABLED = 1 { name = "Enabled"; desc = "enabled"; };
        };

        field {
            name = "bus_err_c_en";
            desc = "C data channel bus error interrupt enable.";
            sw = rw;
            hw = r;
            encode = CH_INT_MASK_bus_err_c_en_enum;
            reset = 0x0;
        } bus_err_c_en[5:5];

        enum CH_INT_MASK_update_cfg_enum {
            MASKED = 0 { name = "Masked"; desc = "masked"; };
            ENABLED = 1 { name = "Enabled"; desc = "enabled"; };
        };

        field {
            name = "update_cfg";
            desc = "Register update interrupt enable.";
            sw = rw;
            hw = r;
            encode = CH_INT_MASK_update_cfg_enum;
            reset = 0x0;
        } update_cfg[4:4];

        enum CH_INT_MASK_field_throw_en_enum {
            MASKED = 0 { name = "Masked"; desc = "masked"; };
            ENABLED = 1 { name = "Enabled"; desc = "enabled"; };
        };

        field {
            name = "field_throw_en";
            desc = "Field/Frame loss interrupt enable.";
            sw = rw;
            hw = r;
            encode = CH_INT_MASK_field_throw_en_enum;
            reset = 0x0;
        } field_throw_en[3:3];

        enum CH_INT_MASK_buf_ovf_en_enum {
            MASKED = 0 { name = "Masked"; desc = "masked"; };
            ENABLED = 1 { name = "Enabled"; desc = "enabled"; };
        };

        field {
            name = "buf_ovf_en";
            desc = "Internal FIFO overflow error interrupt enable.";
            sw = rw;
            hw = r;
            encode = CH_INT_MASK_buf_ovf_en_enum;
            reset = 0x0;
        } buf_ovf_en[2:2];

        enum CH_INT_MASK_cc_int_en_enum {
            MASKED = 0 { name = "Masked"; desc = "masked"; };
            ENABLED = 1 { name = "Enabled"; desc = "enabled"; };
        };

        field {
            name = "cc_int_en";
            desc = "Capture completion interrupt enable.";
            sw = rw;
            hw = r;
            encode = CH_INT_MASK_cc_int_en_enum;
            reset = 0x0;
        } cc_int_en[1:1];

        enum CH_INT_MASK_fstart_en_enum {
            MASKED = 0 { name = "Masked"; desc = "masked"; };
            ENABLED = 1 { name = "Enabled"; desc = "enabled"; };
        };

        field {
            name = "fstart_en";
            desc = "Field/Frame start interrupt enable.";
            sw = rw;
            hw = r;
            encode = CH_INT_MASK_fstart_en_enum;
            reset = 0x0;
        } fstart_en[0:0];
    } CH_INT_MASK @ 0x10F8;

    reg {
        name = "Crop enable register";
        desc = "CH_CROP_CFG is a crop enable register.

Data sheet 10.1.6 CH_CROP_CFG (offset 0x1100, printed page 10-54, `hi3516cv100--Hi3516C-Datasheet.txt` line 39298).";

        field {
            name = "n0_en";
            desc = "Region 0 enable.";
            sw = rw;
            hw = r;
            reset = 0x0;
        } n0_en[0:0];
    } CH_CROP_CFG @ 0x1100;

    reg {
        name = "Crop window register";
        desc = "CH_CROP_WIN is a crop window register.

Data sheet 10.1.6 CH_CROP_WIN (offset 0x1104, printed page 10-54, `hi3516cv100--Hi3516C-Datasheet.txt` line 39320).";

        field {
            name = "height";
            desc = "Window height. Its unit is pixel. The configured value is the actual value minus 1.";
            sw = rw;
            hw = r;
            reset = 0xFFFF;
        } height[31:16];

        field {
            name = "width";
            desc = "Window width. Its unit is pixel. The configured value is the actual value minus 1.";
            sw = rw;
            hw = r;
            reset = 0xFFFF;
        } width[15:0];
    } CH_CROP_WIN @ 0x1104;

    reg {
        name = "Crop start position register for region 0";
        desc = "CH_CROP0_START is a crop start position register for region 0.

Data sheet 10.1.6 CH_CROP0_START (offset 0x1110, printed page 10-55, `hi3516cv100--Hi3516C-Datasheet.txt` line 39353).";

        field {
            name = "y_start";
            desc = "Number of the line from which pictures start to be captured.";
            sw = rw;
            hw = r;
            reset = 0x0;
        } y_start[31:16];

        field {
            name = "x_start";
            desc = "Number of the pixel from which pictures start to be captured.";
            sw = rw;
            hw = r;
            reset = 0x0;
        } x_start[15:0];
    } CH_CROP0_START @ 0x1110;

    reg {
        name = "Crop size configuration register for region 0";
        desc = "CH_CROP0_SIZE is a crop size configuration register for region 0.

Data sheet 10.1.6 CH_CROP0_SIZE (offset 0x1114, printed page 10-55, `hi3516cv100--Hi3516C-Datasheet.txt` line 39373).";

        field {
            name = "height";
            desc = "Height of the captured picture. Its unit is line. The configured value is the actual value minus 1.";
            sw = rw;
            hw = r;
            reset = 0xFFFF;
        } height[31:16];

        field {
            name = "width";
            desc = "Width of a line in the captured picture. Its unit is pixel. The configured value is the actual value minus 1.";
            sw = rw;
            hw = r;
            reset = 0xFFFF;
        } width[15:0];
    } CH_CROP0_SIZE @ 0x1114;

    reg {
        name = "CSC configuration register";
        desc = "CH_CSC_CFG is a CSC configuration register.

Data sheet 10.1.6 CH_CSC_CFG (offset 0x1200, printed page 10-56, `hi3516cv100--Hi3516C-Datasheet.txt` line 39405).";

        enum CH_CSC_CFG_enable_f_enum {
            DISABLED = 0 { name = "Disabled"; desc = "disabled"; };
            ENABLED = 1 { name = "Enabled"; desc = "enabled"; };
        };

        field {
            name = "enable";
            desc = "CSC enable.";
            sw = rw;
            hw = r;
            encode = CH_CSC_CFG_enable_f_enum;
            reset = 0x0;
        } enable_f[31:31];
    } CH_CSC_CFG @ 0x1200;

    reg {
        name = "CSC coefficient register 0";
        desc = "CH_CSC_COEF0 is CSC coefficient register 0.

Data sheet 10.1.6 CH_CSC_COEF0 (offset 0x1210, printed page 10-56, `hi3516cv100--Hi3516C-Datasheet.txt` line 39428).";

        field {
            name = "coef01";
            desc = "CSC coefficient. Its format is (s, 4, 8). The value consists of a 1-bit signed part, a 4- bit integral part, and an 8-bit fractional part.";
            sw = rw;
            hw = r;
            reset = 0x0;
        } coef01[31:19];

        field {
            name = "coef00";
            desc = "CSC coefficient. Its format is (s, 4, 8). The value consists of a 1-bit signed part, a 4- bit integral part, and an 8-bit fractional part.";
            sw = rw;
            hw = r;
            reset = 0x0;
        } coef00[15:3];
    } CH_CSC_COEF0 @ 0x1210;

    reg {
        name = "CSC coefficient register 1";
        desc = "CH_CSC_COEF1 is CSC coefficient register 1.

Data sheet 10.1.6 CH_CSC_COEF1 (offset 0x1214, printed page 10-57, `hi3516cv100--Hi3516C-Datasheet.txt` line 39467).";

        field {
            name = "coef10";
            desc = "CSC coefficient. Its format is (s, 4, 8). The value consists of a 1-bit signed part, a 4- bit integral part, and an 8-bit fractional part.";
            sw = rw;
            hw = r;
            reset = 0x0;
        } coef10[31:19];

        field {
            name = "coef02";
            desc = "CSC coefficient. Its format is (s, 4, 8). The value consists of a 1-bit signed part, a 4- bit integral part, and an 8-bit fractional part.";
            sw = rw;
            hw = r;
            reset = 0x0;
        } coef02[15:3];
    } CH_CSC_COEF1 @ 0x1214;

    reg {
        name = "CSC coefficient register 2";
        desc = "CH_CSC_COEF2 is CSC coefficient register 2.

Data sheet 10.1.6 CH_CSC_COEF2 (offset 0x1218, printed page 10-57, `hi3516cv100--Hi3516C-Datasheet.txt` line 39498).";

        field {
            name = "coef12";
            desc = "CSC coefficient. Its format is (s, 4, 8). The value consists of a 1-bit signed part, a 4- bit integral part, and an 8-bit fractional part.";
            sw = rw;
            hw = r;
            reset = 0x0;
        } coef12[31:19];

        field {
            name = "coef11";
            desc = "CSC coefficient. Its format is (s, 4, 8). The value consists of a 1-bit signed part, a 4- bit integral part, and an 8-bit fractional part.";
            sw = rw;
            hw = r;
            reset = 0x0;
        } coef11[15:3];
    } CH_CSC_COEF2 @ 0x1218;

    reg {
        name = "CSC coefficient register 3";
        desc = "CH_CSC_COEF3 is CSC coefficient register 3.

Data sheet 10.1.6 CH_CSC_COEF3 (offset 0x121C, printed page 10-58, `hi3516cv100--Hi3516C-Datasheet.txt` line 39555).";

        field {
            name = "coef21";
            desc = "CSC coefficient. Its format is (s, 4, 8). The value consists of a 1-bit signed part, a 4- bit integral part, and an 8-bit fractional part.";
            sw = rw;
            hw = r;
            reset = 0x0;
        } coef21[31:19];

        field {
            name = "coef20";
            desc = "CSC coefficient. Its format is (s, 4, 8). The value consists of a 1-bit signed part, a 4- bit integral part, and an 8-bit fractional part.";
            sw = rw;
            hw = r;
            reset = 0x0;
        } coef20[15:3];
    } CH_CSC_COEF3 @ 0x121C;

    reg {
        name = "CSC coefficient register 4";
        desc = "CH_CSC_COEF4 is CSC coefficient register 4.

Data sheet 10.1.6 CH_CSC_COEF4 (offset 0x1220, printed page 10-59, `hi3516cv100--Hi3516C-Datasheet.txt` line 39595).";

        field {
            name = "coef22";
            desc = "CSC coefficient. Its format is (s, 4, 8). The value consists of a 1-bit signed part, a 4- bit integral part, and an 8-bit fractional part.";
            sw = rw;
            hw = r;
            reset = 0x0;
        } coef22[15:3];
    } CH_CSC_COEF4 @ 0x1220;

    reg {
        name = "CSC input DC component register 0";
        desc = "CH_CSC_IN_DC0 is CSC input DC component register 0.

Data sheet 10.1.6 CH_CSC_IN_DC0 (offset 0x1230, printed page 10-59, `hi3516cv100--Hi3516C-Datasheet.txt` line 39626).";

        field {
            name = "in_dc1";
            desc = "DC offset of the input G component. It is a signed integer.";
            sw = rw;
            hw = r;
            reset = 0x0;
        } in_dc1[31:21];

        field {
            name = "in_dc0";
            desc = "DC offset of the input R component. It is a signed integer.";
            sw = rw;
            hw = r;
            reset = 0x0;
        } in_dc0[15:5];
    } CH_CSC_IN_DC0 @ 0x1230;

    reg {
        name = "CSC input DC component register 1";
        desc = "CH_CSC_IN_DC1 is CSC input DC component register 1.

Data sheet 10.1.6 CH_CSC_IN_DC1 (offset 0x1234, printed page 10-60, `hi3516cv100--Hi3516C-Datasheet.txt` line 39658).";

        field {
            name = "in_dc2";
            desc = "DC offset of the input B component. It is a signed integer.";
            sw = rw;
            hw = r;
            reset = 0x0;
        } in_dc2[15:5];
    } CH_CSC_IN_DC1 @ 0x1234;

    reg {
        name = "CSC output DC component register 0";
        desc = "CH_CSC_OUT_DC0 is CSC output DC component register 0.

Data sheet 10.1.6 CH_CSC_OUT_DC0 (offset 0x1238, printed page 10-60, `hi3516cv100--Hi3516C-Datasheet.txt` line 39682).";

        field {
            name = "out_dc1";
            desc = "DC offset of the input U component. It is a signed integer.";
            sw = rw;
            hw = r;
            reset = 0x0;
        } out_dc1[31:21];

        field {
            name = "out_dc0";
            desc = "DC offset of the output Y component. It is a signed integer.";
            sw = rw;
            hw = r;
            reset = 0x0;
        } out_dc0[15:5];
    } CH_CSC_OUT_DC0 @ 0x1238;

    reg {
        name = "CSC output DC component register 1";
        desc = "CH_CSC_OUT_DC1 is CSC output DC component register 1.

Data sheet 10.1.6 CH_CSC_OUT_DC1 (offset 0x123C, printed page 10-61, `hi3516cv100--Hi3516C-Datasheet.txt` line 39717).";

        field {
            name = "out_dc2";
            desc = "DC offset of the output V component. It is a signed integer.";
            sw = rw;
            hw = r;
            reset = 0x0;
        } out_dc2[15:5];
    } CH_CSC_OUT_DC1 @ 0x123C;

    reg {
        name = "Block mask configuration register";
        desc = "CH_MSC_CFG is a block mask configuration register.

Data sheet 10.1.6 CH_MSC_CFG (offset 0x1300, printed page 10-61, `hi3516cv100--Hi3516C-Datasheet.txt` line 39741).";

        enum CH_MSC_CFG_msc3_en_enum {
            DISABLED = 0 { name = "Disabled"; desc = "disabled"; };
            ENABLED = 1 { name = "Enabled"; desc = "enabled"; };
        };

        field {
            name = "msc3_en";
            desc = "Block 3 mask enable.";
            sw = rw;
            hw = r;
            encode = CH_MSC_CFG_msc3_en_enum;
            reset = 0x0;
        } msc3_en[3:3];

        enum CH_MSC_CFG_msc2_en_enum {
            DISABLED = 0 { name = "Disabled"; desc = "disabled"; };
            ENABLED = 1 { name = "Enabled"; desc = "enabled"; };
        };

        field {
            name = "msc2_en";
            desc = "Block 2 mask enable.";
            sw = rw;
            hw = r;
            encode = CH_MSC_CFG_msc2_en_enum;
            reset = 0x0;
        } msc2_en[2:2];

        enum CH_MSC_CFG_msc1_en_enum {
            DISABLED = 0 { name = "Disabled"; desc = "disabled"; };
            ENABLED = 1 { name = "Enabled"; desc = "enabled"; };
        };

        field {
            name = "msc1_en";
            desc = "Block 1 mask enable.";
            sw = rw;
            hw = r;
            encode = CH_MSC_CFG_msc1_en_enum;
            reset = 0x0;
        } msc1_en[1:1];

        field {
            name = "msc0_en";
            desc = "msc0_en";
            sw = rw;
            hw = r;
            reset = 0x0;
        } msc0_en[0:0];
    } CH_MSC_CFG @ 0x1300;

    reg {
        name = "Occlusion window register";
        desc = "CH_MSC_WIN is an occlusion window register.

Data sheet 10.1.6 CH_MSC_WIN (offset 0x1304, printed page 10-62, `hi3516cv100--Hi3516C-Datasheet.txt` line 39801).";

        field {
            name = "height";
            desc = "Window height. Its unit is pixel. The configured value is the actual value minus 1.";
            sw = rw;
            hw = r;
            reset = 0xFFFF;
        } height[31:16];

        field {
            name = "width";
            desc = "Window width. Its unit is pixel. The configured value is the actual value minus 1.";
            sw = rw;
            hw = r;
            reset = 0xFFFF;
        } width[15:0];
    } CH_MSC_WIN @ 0x1304;

    reg {
        name = "Mask start position register for block 0";
        desc = "CH_BLOCK0_START is a mask start position register for block 0.

Data sheet 10.1.6 CH_BLOCK0_START (offset 0x1310, printed page 10-62, `hi3516cv100--Hi3516C-Datasheet.txt` line 39824).";

        field {
            name = "y_start";
            desc = "Vertical start point for masking block 0.";
            sw = rw;
            hw = r;
            reset = 0x0;
        } y_start[27:16];

        field {
            name = "x_start";
            desc = "Horizontal start point for masking block 0.";
            sw = rw;
            hw = r;
            reset = 0x0;
        } x_start[11:0];
    } CH_BLOCK0_START @ 0x1310;

    reg {
        name = "Mask start position register for block 1";
        desc = "CH_BLOCK1_START is a mask start position register for block 1.

Data sheet 10.1.6 CH_BLOCK1_START (offset 0x1314, printed page 10-63, `hi3516cv100--Hi3516C-Datasheet.txt` line 39854).";

        field {
            name = "y_start";
            desc = "Vertical start point for masking block 1.";
            sw = rw;
            hw = r;
            reset = 0x0;
        } y_start[27:16];

        field {
            name = "x_start";
            desc = "Horizontal start point for masking block 1.";
            sw = rw;
            hw = r;
            reset = 0x0;
        } x_start[11:0];
    } CH_BLOCK1_START @ 0x1314;

    reg {
        name = "Mask start position register for block 2";
        desc = "CH_BLOCK2_START is a mask start position register for block 2.

Data sheet 10.1.6 CH_BLOCK2_START (offset 0x1318, printed page 10-63, `hi3516cv100--Hi3516C-Datasheet.txt` line 39876).";

        field {
            name = "y_start";
            desc = "Vertical start point for masking block 2.";
            sw = rw;
            hw = r;
            reset = 0x0;
        } y_start[27:16];

        field {
            name = "x_start";
            desc = "x_start";
            sw = rw;
            hw = r;
            reset = 0x0;
        } x_start[11:0];
    } CH_BLOCK2_START @ 0x1318;

    reg {
        name = "Mask start position register for block 3";
        desc = "CH_BLOCK3_START is a mask start position register for block 3.

Data sheet 10.1.6 CH_BLOCK3_START (offset 0x131C, printed page 10-64, `hi3516cv100--Hi3516C-Datasheet.txt` line 39917).";

        field {
            name = "y_start";
            desc = "Vertical start point for masking block 3.";
            sw = rw;
            hw = r;
            reset = 0x0;
        } y_start[27:16];

        field {
            name = "x_start";
            desc = "Horizontal start point for masking block 3.";
            sw = rw;
            hw = r;
            reset = 0x0;
        } x_start[11:0];
    } CH_BLOCK3_START @ 0x131C;

    reg {
        name = "Mask size register for block 0";
        desc = "CH_BLOCK0_SIZE is a mask size register for block 0.

Data sheet 10.1.6 CH_BLOCK0_SIZE (offset 0x1320, printed page 10-64, `hi3516cv100--Hi3516C-Datasheet.txt` line 39938).";

        field {
            name = "blk_height";
            desc = "blk_height";
            sw = rw;
            hw = r;
            reset = 0x0;
        } blk_height[27:16];

        field {
            name = "blk_width";
            desc = "blk_width";
            sw = rw;
            hw = r;
            reset = 0x0;
        } blk_width[11:0];
    } CH_BLOCK0_SIZE @ 0x1320;

    reg {
        name = "Mask size register for block 1";
        desc = "CH_BLOCK1_SIZE is a mask size register for block 1.

Data sheet 10.1.6 CH_BLOCK1_SIZE (offset 0x1324, printed page 10-65, `hi3516cv100--Hi3516C-Datasheet.txt` line 39985).";

        field {
            name = "blk_height";
            desc = "Vertical height for masking block 1. The configured value is the actual value minus 1.";
            sw = rw;
            hw = r;
            reset = 0x0;
        } blk_height[27:16];

        field {
            name = "blk_width";
            desc = "Horizontal width for making block 1. The configured value is the actual value minus 1.";
            sw = rw;
            hw = r;
            reset = 0x0;
        } blk_width[11:0];
    } CH_BLOCK1_SIZE @ 0x1324;

    reg {
        name = "Mask size register for block 2";
        desc = "CH_BLOCK2_SIZE is a mask size register for block 2.

Data sheet 10.1.6 CH_BLOCK2_SIZE (offset 0x1328, printed page 10-65, `hi3516cv100--Hi3516C-Datasheet.txt` line 40011).";

        field {
            name = "blk_height";
            desc = "Vertical height for masking block 2. The configured value is the actual value minus 1.";
            sw = rw;
            hw = r;
            reset = 0x0;
        } blk_height[27:16];

        field {
            name = "blk_width";
            desc = "Horizontal width for making block 2. The configured value is the actual value minus 1.";
            sw = rw;
            hw = r;
            reset = 0x0;
        } blk_width[11:0];
    } CH_BLOCK2_SIZE @ 0x1328;

    reg {
        name = "Mask size register for block 3";
        desc = "CH_BLOCK3_SIZE is a mask size register for block 3.

Data sheet 10.1.6 CH_BLOCK3_SIZE (offset 0x132C, printed page 10-66, `hi3516cv100--Hi3516C-Datasheet.txt` line 40044).";

        field {
            name = "blk_height";
            desc = "Vertical height for masking block 3. The configured value is the actual value minus 1.";
            sw = rw;
            hw = r;
            reset = 0x0;
        } blk_height[27:16];

        field {
            name = "blk_width";
            desc = "Horizontal width for making block 3. The configured value is the actual value minus 1.";
            sw = rw;
            hw = r;
            reset = 0x0;
        } blk_width[11:0];
    } CH_BLOCK3_SIZE @ 0x132C;

    reg {
        name = "Filling color register for block 0";
        desc = "CH_BLOCK0_COLOR is a filling color register for block 0.

Data sheet 10.1.6 CH_BLOCK0_COLOR (offset 0x1330, printed page 10-66, `hi3516cv100--Hi3516C-Datasheet.txt` line 40069).";

        field {
            name = "blk_cr";
            desc = "Cr component of the filling color of block 0.";
            sw = rw;
            hw = r;
            reset = 0x0;
        } blk_cr[23:16];

        field {
            name = "blk_cb";
            desc = "Cb component of the filling color of block 0.";
            sw = rw;
            hw = r;
            reset = 0x0;
        } blk_cb[15:8];

        field {
            name = "blc_y";
            desc = "Y component of the filling color of block 0.";
            sw = rw;
            hw = r;
            reset = 0x0;
        } blc_y[7:0];
    } CH_BLOCK0_COLOR @ 0x1330;

    reg {
        name = "Filling color register for block 1";
        desc = "CH_BLOCK1_COLOR is a filling color register for block 1.

Data sheet 10.1.6 CH_BLOCK1_COLOR (offset 0x1334, printed page 10-67, `hi3516cv100--Hi3516C-Datasheet.txt` line 40099).";

        field {
            name = "blk_cr";
            desc = "Cr component of the filling color of block 1.";
            sw = rw;
            hw = r;
            reset = 0x0;
        } blk_cr[23:16];

        field {
            name = "blk_cb";
            desc = "Cb component of the filling color of block 1.";
            sw = rw;
            hw = r;
            reset = 0x0;
        } blk_cb[15:8];

        field {
            name = "blc_y";
            desc = "Y component of the filling color of block 1.";
            sw = rw;
            hw = r;
            reset = 0x0;
        } blc_y[7:0];
    } CH_BLOCK1_COLOR @ 0x1334;

    reg {
        name = "Filling color register for block 2";
        desc = "CH_BLOCK2_COLOR is a filling color register for block 2.

Data sheet 10.1.6 CH_BLOCK2_COLOR (offset 0x1338, printed page 10-67, `hi3516cv100--Hi3516C-Datasheet.txt` line 40121).";

        field {
            name = "blk_cr";
            desc = "Cr component of the filling color of block 2.";
            sw = rw;
            hw = r;
            reset = 0x0;
        } blk_cr[23:16];

        field {
            name = "blk_cb";
            desc = "Cb component of the filling color of block 2.";
            sw = rw;
            hw = r;
            reset = 0x0;
        } blk_cb[15:8];

        field {
            name = "blc_y";
            desc = "blc_y";
            sw = rw;
            hw = r;
            reset = 0x0;
        } blc_y[7:0];
    } CH_BLOCK2_COLOR @ 0x1338;

    reg {
        name = "Filling color register for block 3";
        desc = "CH_BLOCK3_COLOR is a filling color register for block 3.

Data sheet 10.1.6 CH_BLOCK3_COLOR (offset 0x133C, printed page 10-68, `hi3516cv100--Hi3516C-Datasheet.txt` line 40162).";

        field {
            name = "blk_cr";
            desc = "Cr component of the filling color of block 3.";
            sw = rw;
            hw = r;
            reset = 0x0;
        } blk_cr[23:16];

        field {
            name = "blk_cb";
            desc = "Cb component of the filling color of block 3.";
            sw = rw;
            hw = r;
            reset = 0x0;
        } blk_cb[15:8];

        field {
            name = "blc_y";
            desc = "Y component of the filling color of block 3.";
            sw = rw;
            hw = r;
            reset = 0x0;
        } blc_y[7:0];
    } CH_BLOCK3_COLOR @ 0x133C;

    reg {
        name = "Y component skip configuration register";
        desc = "CH_SKIP_Y_CFG is a Y component skip configuration register.

Data sheet 10.1.6 CH_SKIP_Y_CFG (offset 0x1400, printed page 10-68, `hi3516cv100--Hi3516C-Datasheet.txt` line 40183).";

        field {
            name = "skip_cfg";
            desc = "Skip configuration.";
            sw = rw;
            hw = r;
            reset = 0xFFFFFFFF;
        } skip_cfg[31:0];
    } CH_SKIP_Y_CFG @ 0x1400;

    reg {
        name = "Y component skip window register";
        desc = "CH_SKIP_Y_WIN is a Y component skip window register.

Data sheet 10.1.6 CH_SKIP_Y_WIN (offset 0x1404, printed page 10-69, `hi3516cv100--Hi3516C-Datasheet.txt` line 40208).";

        field {
            name = "height";
            desc = "Window height. Its unit is pixel. The configured value is the actual value minus 1.";
            sw = rw;
            hw = r;
            reset = 0x3;
        } height[17:16];

        field {
            name = "width";
            desc = "Window width. Its unit is pixel. The configured value is the actual value minus 1.";
            sw = rw;
            hw = r;
            reset = 0x7;
        } width[2:0];
    } CH_SKIP_Y_WIN @ 0x1404;

    reg {
        name = "C component skip configuration register";
        desc = "CH_SKIP_C_CFG is a C component skip configuration register.

Data sheet 10.1.6 CH_SKIP_C_CFG (offset 0x1410, printed page 10-69, `hi3516cv100--Hi3516C-Datasheet.txt` line 40235).";

        field {
            name = "skip_cfg";
            desc = "Skip configuration.";
            sw = rw;
            hw = r;
            reset = 0xFFFFFFFF;
        } skip_cfg[31:0];
    } CH_SKIP_C_CFG @ 0x1410;

    reg {
        name = "C component skip window register";
        desc = "CH_SKIP_C_WIN is a C component skip window register.

Data sheet 10.1.6 CH_SKIP_C_WIN (offset 0x1414, printed page 10-70, `hi3516cv100--Hi3516C-Datasheet.txt` line 40263).";

        field {
            name = "height";
            desc = "Window height. Its unit is pixel. The configured value is the actual value minus 1.";
            sw = rw;
            hw = r;
            reset = 0x3;
        } height[17:16];

        field {
            name = "width";
            desc = "Window width. Its unit is pixel. The configured value is the actual value minus 1.";
            sw = rw;
            hw = r;
            reset = 0x7;
        } width[2:0];
    } CH_SKIP_C_WIN @ 0x1414;

    reg {
        name = "C component input size register for the zoom module";
        desc = "CH_ZME_C_SSIZE is a C component input size register for the zoom module.

Data sheet 10.1.6 CH_ZME_C_SSIZE (offset 0x1500, printed page 10-70, `hi3516cv100--Hi3516C-Datasheet.txt` line 40290).";

        field {
            name = "width";
            desc = "Picture width. Its unit is pixel. The configured value is the actual value minus 1.";
            sw = rw;
            hw = r;
            reset = 0x4FF;
        } width[15:0];
    } CH_ZME_C_SSIZE @ 0x1500;

    reg {
        name = "C component output size register for the zoom module";
        desc = "CH_ZME_C_DSIZE is a C component output size register for the zoom module.

Data sheet 10.1.6 CH_ZME_C_DSIZE (offset 0x1504, printed page 10-71, `hi3516cv100--Hi3516C-Datasheet.txt` line 40321).";

        field {
            name = "width";
            desc = "Picture width. Its unit is pixel. The configured value is the actual value minus 1.";
            sw = rw;
            hw = r;
            reset = 0x4FF;
        } width[15:0];
    } CH_ZME_C_DSIZE @ 0x1504;

    reg {
        name = "Chrominance horizontal scaling parameter configuration register";
        desc = "CH_HFIR_C_SPH is a chrominance horizontal scaling parameter configuration register.

Data sheet 10.1.6 CH_HFIR_C_SPH (offset 0x1510, printed page 10-71, `hi3516cv100--Hi3516C-Datasheet.txt` line 40343).";

        enum CH_HFIR_C_SPH_enable_f_enum {
            DISABLED = 0 { name = "Disabled"; desc = "disabled"; };
            ENABLED = 1 { name = "Enabled"; desc = "enabled"; };
        };

        field {
            name = "enable";
            desc = "Chrominance horizontal scaling enable.";
            sw = rw;
            hw = r;
            encode = CH_HFIR_C_SPH_enable_f_enum;
            reset = 0x0;
        } enable_f[31:31];

        field {
            name = "ratio";
            desc = "Chrominance horizontal scaling ratio. It is calculated by dividing the input width by the output width. If horizontal pre-processing is enabled, the input width after pre-processing is used. The ratio is in the format of (u, 4). That is, the ratio consists of a 1-bit unsigned bit and a 4-bit integral part.";
            sw = rw;
            hw = r;
            reset = 0x1;
        } ratio[15:12];
    } CH_HFIR_C_SPH @ 0x1510;

    reg {
        name = "Chrominance scaling horizontal offset register";
        desc = "CH_HFIR_C_OFFSET is a chrominance scaling horizontal offset register.

Data sheet 10.1.6 CH_HFIR_C_OFFSET (offset 0x1514, printed page 10-72, `hi3516cv100--Hi3516C-Datasheet.txt` line 40382).";

        field {
            name = "offset";
            desc = "Chrominance horizontal start position offset. It is in the format of (s, 5). That is, the offset consists of a 1-bit signed part and a 4-bit integral part. The offset is expressed as the complementary code and ranges from -4 to +15.";
            sw = rw;
            hw = r;
            reset = 0x0;
        } offset[16:12];
    } CH_HFIR_C_OFFSET @ 0x1514;

    reg {
        name = "Chrominance horizontal scaling coefficient register 0";
        desc = "CH_HFIR_C_COEF0 is chrominance horizontal scaling coefficient register 0.

Data sheet 10.1.6 CH_HFIR_C_COEF0 (offset 0x1520, printed page 10-72, `hi3516cv100--Hi3516C-Datasheet.txt` line 40407).";

        field {
            name = "coef2";
            desc = "Chrominance horizontal scaling and filtering coefficient 2.";
            sw = rw;
            hw = r;
            reset = 0x0;
        } coef2[29:20];

        field {
            name = "coef1";
            desc = "Chrominance horizontal scaling and filtering coefficient 1.";
            sw = rw;
            hw = r;
            reset = 0x0;
        } coef1[19:10];

        field {
            name = "coef0";
            desc = "Chrominance horizontal scaling and filtering coefficient 0. Only 8-tap horizontal scaling at an integral ratio is supported.";
            sw = rw;
            hw = r;
            reset = 0x0;
        } coef0[9:0];
    } CH_HFIR_C_COEF0 @ 0x1520;

    reg {
        name = "Chrominance horizontal scaling coefficient register 1";
        desc = "CH_HFIR_C_COEF1 is chrominance horizontal scaling coefficient register 1.

Data sheet 10.1.6 CH_HFIR_C_COEF1 (offset 0x1524, printed page 10-73, `hi3516cv100--Hi3516C-Datasheet.txt` line 40445).";

        field {
            name = "coef5";
            desc = "Chrominance horizontal scaling and filtering coefficient 5.";
            sw = rw;
            hw = r;
            reset = 0x0;
        } coef5[29:20];

        field {
            name = "coef4";
            desc = "Chrominance horizontal scaling and filtering coefficient 4.";
            sw = rw;
            hw = r;
            reset = 0x0;
        } coef4[19:10];

        field {
            name = "coef3";
            desc = "Chrominance horizontal scaling and filtering coefficient 3.";
            sw = rw;
            hw = r;
            reset = 0x1FF;
        } coef3[9:0];
    } CH_HFIR_C_COEF1 @ 0x1524;

    reg {
        name = "Chrominance horizontal scaling coefficient register 2";
        desc = "CH_HFIR_C_COEF2 is chrominance horizontal scaling coefficient register 2.

Data sheet 10.1.6 CH_HFIR_C_COEF2 (offset 0x1528, printed page 10-73, `hi3516cv100--Hi3516C-Datasheet.txt` line 40472).";

        field {
            name = "coef7";
            desc = "Chrominance horizontal scaling and filtering coefficient 7.";
            sw = rw;
            hw = r;
            reset = 0x0;
        } coef7[19:10];

        field {
            name = "coef6";
            desc = "Chrominance horizontal scaling and filtering coefficient 6.";
            sw = rw;
            hw = r;
            reset = 0x0;
        } coef6[9:0];
    } CH_HFIR_C_COEF2 @ 0x1528;

    reg {
        name = "Dither configuration register";
        desc = "CH_DITHER_CFG is a dither configuration register.

Data sheet 10.1.6 CH_DITHER_CFG (offset 0x1600, printed page 10-74, `hi3516cv100--Hi3516C-Datasheet.txt` line 40501).";

        enum CH_DITHER_CFG_dither_md_enum {
            V_12_BIT_INPUTS = 0 { name = "V 12 Bit Inputs"; desc = "12-bit inputs, 10-bit outputs, no dithering, and direct bit truncation"; };
            V_12_BIT_INPUTS_2 = 1 { name = "V 12 Bit Inputs 2"; desc = "12-bit inputs, 10-bit outputs, and time-domain dithering"; };
            V_12_BIT_INPUTS_3 = 2 { name = "V 12 Bit Inputs 3"; desc = "12-bit inputs, 10-bit outputs, and spatial-domain dithering"; };
            V_12_BIT_INPUTS_4 = 3 { name = "V 12 Bit Inputs 4"; desc = "12-bit inputs, 8-bit outputs, and time-domain and spatial- domain dithering"; };
            V_12_BIT_INPUTS_5 = 4 { name = "V 12 Bit Inputs 5"; desc = "12-bit inputs, 10-bit outputs, and round off"; };
            V_12_BIT_INPUTS_6 = 5 { name = "V 12 Bit Inputs 6"; desc = "12-bit inputs, 8-bit outputs, and round off"; };
            NO_OPERATION = 7 { name = "No Operation"; desc = "no operation"; };
        };

        field {
            name = "dither_md";
            desc = "Dither mode select.";
            sw = rw;
            hw = r;
            encode = CH_DITHER_CFG_dither_md_enum;
            reset = 0x7;
        } dither_md[31:29];
    } CH_DITHER_CFG @ 0x1600;

    reg {
        name = "Dither coefficient register 0";
        desc = "CH_DITHER_COEF0 is dither coefficient register 0.

Data sheet 10.1.6 CH_DITHER_COEF0 (offset 0x1604, printed page 10-74, `hi3516cv100--Hi3516C-Datasheet.txt` line 40536).";

        field {
            name = "dither_coef3";
            desc = "Dither coefficient in time-domain mode.";
            sw = rw;
            hw = r;
            reset = 0x38;
        } dither_coef3[31:24];

        field {
            name = "dither_coef2";
            desc = "Dither coefficient in time-domain mode.";
            sw = rw;
            hw = r;
            reset = 0x60;
        } dither_coef2[23:16];

        field {
            name = "dither_coef1";
            desc = "Dither coefficient in time-domain mode.";
            sw = rw;
            hw = r;
            reset = 0x80;
        } dither_coef1[15:8];

        field {
            name = "dither_coef0";
            desc = "Dither coefficient in time-domain mode.";
            sw = rw;
            hw = r;
            reset = 0x0;
        } dither_coef0[7:0];
    } CH_DITHER_COEF0 @ 0x1604;

    reg {
        name = "Dither coefficient register 1";
        desc = "CH_DITHER_COEF1 is dither coefficient register 1.

Data sheet 10.1.6 CH_DITHER_COEF1 (offset 0x1608, printed page 10-75, `hi3516cv100--Hi3516C-Datasheet.txt` line 40563).";

        field {
            name = "dither_coef7";
            desc = "Dither coefficient in time-domain mode.";
            sw = rw;
            hw = r;
            reset = 0xFB;
        } dither_coef7[31:24];

        field {
            name = "dither_coef6";
            desc = "Dither coefficient in time-domain mode.";
            sw = rw;
            hw = r;
            reset = 0xE7;
        } dither_coef6[23:16];

        field {
            name = "dither_coef5";
            desc = "Dither coefficient in time-domain mode.";
            sw = rw;
            hw = r;
            reset = 0xF;
        } dither_coef5[15:8];

        field {
            name = "dither_coef4";
            desc = "Dither coefficient in time-domain mode.";
            sw = rw;
            hw = r;
            reset = 0x1E;
        } dither_coef4[7:0];
    } CH_DITHER_COEF1 @ 0x1608;

    reg {
        name = "Y component input size register for the dither module";
        desc = "CH_DITHER_Y_SIZE is a Y component input size register for the dither module.

Data sheet 10.1.6 CH_DITHER_Y_SIZE (offset 0x1610, printed page 10-75, `hi3516cv100--Hi3516C-Datasheet.txt` line 40585).";

        field {
            name = "width";
            desc = "Width of a picture line. Its unit is pixel. The configured value is the actual value minus 1.";
            sw = rw;
            hw = r;
            reset = 0x4FF;
        } width[12:0];
    } CH_DITHER_Y_SIZE @ 0x1610;

    reg {
        name = "C component input size register for the dither module";
        desc = "CH_DITHER_C_SIZE is a C component input size register for the dither module.

Data sheet 10.1.6 CH_DITHER_C_SIZE (offset 0x1614, printed page 10-76, `hi3516cv100--Hi3516C-Datasheet.txt` line 40615).";

        field {
            name = "width";
            desc = "Width of a picture line. Its unit is pixel. The configured value is the actual value minus 1.";
            sw = rw;
            hw = r;
            reset = 0x4FF;
        } width[12:0];
    } CH_DITHER_C_SIZE @ 0x1614;

    reg {
        name = "Chrominance vertical down sampling configuration register";
        desc = "CH_VCDS_CFG is a chrominance vertical down sampling configuration register.

Data sheet 10.1.6 CH_VCDS_CFG (offset 0x1700, printed page 10-76, `hi3516cv100--Hi3516C-Datasheet.txt` line 40637).";

        enum CH_VCDS_CFG_enable_f_enum {
            DISABLED = 0 { name = "Disabled"; desc = "disabled"; };
            ENABLED = 1 { name = "Enabled"; desc = "enabled"; };
        };

        field {
            name = "enable";
            desc = "Down sampling enable.";
            sw = rw;
            hw = r;
            encode = CH_VCDS_CFG_enable_f_enum;
            reset = 0x0;
        } enable_f[31:31];
    } CH_VCDS_CFG @ 0x1700;

    reg {
        name = "Chrominance vertical down sampling coefficient register";
        desc = "CH_VCDS_COEF is a chrominance vertical down sampling coefficient register.

Data sheet 10.1.6 CH_VCDS_COEF (offset 0x1704, printed page 10-77, `hi3516cv100--Hi3516C-Datasheet.txt` line 40670).";

        field {
            name = "coef1";
            desc = "Down sampling coefficient 1.";
            sw = rw;
            hw = r;
            reset = 0x0;
        } coef1[20:16];

        field {
            name = "coef0";
            desc = "Down sampling coefficient 0.";
            sw = rw;
            hw = r;
            reset = 0x1F;
        } coef0[4:0];
    } CH_VCDS_COEF @ 0x1704;

    reg {
        name = "Horizontal lens distortion correction";
        desc = "CH_HLDC_CFG is a horizontal lens distortion correction (HLDC) configuration register.

Data sheet 10.1.6 CH_HLDC_CFG (offset 0x1800, printed page 10-77, `hi3516cv100--Hi3516C-Datasheet.txt` line 40692).";

        field {
            name = "enable";
            desc = "Lens distortion correction enable. 1: disabled 1: enabled";
            sw = rw;
            hw = r;
            reset = 0x0;
        } enable_f[31:31];

        field {
            name = "round_en";
            desc = "Round off enable. 1: disabled 1: enabled";
            sw = rw;
            hw = r;
            reset = 0x0;
        } round_en[0:0];
    } CH_HLDC_CFG @ 0x1800;

    reg {
        name = "HLDC input picture size register";
        desc = "CH_HLDC_SIZE is an HLDC input picture size register.

Data sheet 10.1.6 CH_HLDC_SIZE (offset 0x1804, printed page 10-78, `hi3516cv100--Hi3516C-Datasheet.txt` line 40730).";

        field {
            name = "height";
            desc = "Input picture height for HLDC. Its unit is pixel. The configured value is the actual value minus 1.";
            sw = rw;
            hw = r;
            reset = 0x0;
        } height[27:16];

        field {
            name = "width";
            desc = "Input picture width for HLDC. Its unit is pixel. The configured value is the actual value minus 1.";
            sw = rw;
            hw = r;
            reset = 0x0;
        } width[11:0];
    } CH_HLDC_SIZE @ 0x1804;

    reg {
        name = "HLDC output delay register";
        desc = "CH_HLDC_DEL is an HLDC output delay register.

Data sheet 10.1.6 CH_HLDC_DEL (offset 0x1808, printed page 10-78, `hi3516cv100--Hi3516C-Datasheet.txt` line 40756).";

        field {
            name = "delay";
            desc = "Output delay.";
            sw = rw;
            hw = r;
            reset = 0xF0;
        } delay[15:0];
    } CH_HLDC_DEL @ 0x1808;

    reg {
        name = "HLDC coefficient register 0";
        desc = "CH_HLDC_COEF0 is HLDC coefficient register 0.

Data sheet 10.1.6 CH_HLDC_COEF0 (offset 0x1810, printed page 10-79, `hi3516cv100--Hi3516C-Datasheet.txt` line 40785).";

        field {
            name = "c2";
            desc = "Vertical coordinate of the distortion center.";
            sw = rw;
            hw = r;
            reset = 0x0;
        } c2[25:16];

        field {
            name = "c1";
            desc = "Horizontal coordinate of the distortion center.";
            sw = rw;
            hw = r;
            reset = 0x0;
        } c1[10:0];
    } CH_HLDC_COEF0 @ 0x1810;

    reg {
        name = "HLDC coefficient register 1";
        desc = "CH_HLDC_COEF1 is HLDC coefficient register 1.

Data sheet 10.1.6 CH_HLDC_COEF1 (offset 0x1814, printed page 10-79, `hi3516cv100--Hi3516C-Datasheet.txt` line 40807).";

        field {
            name = "k2";
            desc = "Ellipse mapping coefficient k2.";
            sw = rw;
            hw = r;
            reset = 0x0;
        } k2[24:16];

        field {
            name = "k1";
            desc = "Ellipse mapping coefficient k1.";
            sw = rw;
            hw = r;
            reset = 0x0;
        } k1[10:0];
    } CH_HLDC_COEF1 @ 0x1814;

    reg {
        name = "HLDC coefficient register 2";
        desc = "CH_HLDC_COEF2 is HLDC coefficient register 2.

Data sheet 10.1.6 CH_HLDC_COEF2 (offset 0x1818, printed page 10-80, `hi3516cv100--Hi3516C-Datasheet.txt` line 40838).";

        field {
            name = "hc2";
            desc = "Trapezoid mapping coefficient hc2.";
            sw = rw;
            hw = r;
            reset = 0x0;
        } hc2[23:16];

        field {
            name = "hc1";
            desc = "Trapezoid mapping coefficient hc1.";
            sw = rw;
            hw = r;
            reset = 0x0;
        } hc1[7:0];
    } CH_HLDC_COEF2 @ 0x1818;

    reg {
        name = "HLDC coefficient register 3";
        desc = "CH_HLDC_COEF3 is HLDC coefficient register 3.

Data sheet 10.1.6 CH_HLDC_COEF3 (offset 0x181C, printed page 10-80, `hi3516cv100--Hi3516C-Datasheet.txt` line 40860).";

        field {
            name = "f_h";
            desc = "Coefficient f_h.";
            sw = rw;
            hw = r;
            reset = 0x0;
        } f_h[10:0];
    } CH_HLDC_COEF3 @ 0x181C;

    reg {
        name = "Y component configuration register for the clip module";
        desc = "CH_CLIP_Y_CFG is a Y component configuration register for the clip module.

Data sheet 10.1.6 CH_CLIP_Y_CFG (offset 0x1900, printed page 10-81, `hi3516cv100--Hi3516C-Datasheet.txt` line 40889).";

        field {
            name = "max";
            desc = "Maximum output value. The value format is (u, 8, 4). That is, the value consists of a 1-bit unsigned part, an 8-bit integral part, and a 4-bit fractional part.";
            sw = rw;
            hw = r;
            reset = 0xFFF;
        } max[31:20];

        field {
            name = "min";
            desc = "Minimum output value. The value format is (u, 8, 4). That is, the value consists of a 1-bit unsigned part, an 8-bit integral part, and a 4-bit fractional part.";
            sw = rw;
            hw = r;
            reset = 0x0;
        } min[15:4];
    } CH_CLIP_Y_CFG @ 0x1900;

    reg {
        name = "C component configuration register for the clip module";
        desc = "CH_CLIP_C_CFG is a C component configuration register for the clip module.

Data sheet 10.1.6 CH_CLIP_C_CFG (offset 0x1904, printed page 10-81, `hi3516cv100--Hi3516C-Datasheet.txt` line 40915).";

        field {
            name = "max";
            desc = "Maximum output value. The value format is (u, 8, 4). That is, the value consists of a 1-bit unsigned part, an 8-bit integral part, and a 4-bit fractional part.";
            sw = rw;
            hw = r;
            reset = 0xFFF;
        } max[31:20];

        field {
            name = "min";
            desc = "Minimum output value. The value format is (u, 8, 4). That is, the value consists of a 1-bit unsigned part, an 8-bit integral part, and a 4-bit fractional part.";
            sw = rw;
            hw = r;
            reset = 0x0;
        } min[15:4];
    } CH_CLIP_C_CFG @ 0x1904;

    reg {
        name = "Input picture luminance statistics register";
        desc = "CH_SUM_Y is an input picture luminance statistics register.

Data sheet 10.1.6 CH_SUM_Y (offset 0x1A00, printed page 10-82, `hi3516cv100--Hi3516C-Datasheet.txt` line 40947).";

        field {
            name = "sum_y";
            desc = "Luminance statistics.";
            sw = r;
            hw = w;
            reset = 0x0;
        } sum_y[31:0];
    } CH_SUM_Y @ 0x1A00;

    reg {
        name = "ISP interrupt indicator register";
        desc = "ISP_INT is an ISP interrupt indicator register.

Data sheet 10.1.6 ISP_INT (offset 0x100F0, printed page 10-82, `hi3516cv100--Hi3516C-Datasheet.txt` line 40966).";

        enum ISP_INT_int7_enum {
            NO_INTERRUPT_GENERATED = 0 { name = "No Interrupt Generated"; desc = "No interrupt is generated."; };
            INTERRUPT_GENERATED = 1 { name = "Interrupt Generated"; desc = "An interrupt is generated."; };
        };

        field {
            name = "int7";
            desc = "ISP interrupt 7 indicator. Writing 1 clears the indicator.";
            sw = rw;
            hw = w;
            onwrite = woclr;
            encode = ISP_INT_int7_enum;
            reset = 0x0;
        } int7[7:7];

        enum ISP_INT_int6_enum {
            NO_INTERRUPT_GENERATED = 0 { name = "No Interrupt Generated"; desc = "No interrupt is generated."; };
            INTERRUPT_GENERATED = 1 { name = "Interrupt Generated"; desc = "An interrupt is generated."; };
        };

        field {
            name = "int6";
            desc = "ISP interrupt 6 indicator. Writing 1 clears the indicator.";
            sw = rw;
            hw = w;
            onwrite = woclr;
            encode = ISP_INT_int6_enum;
            reset = 0x0;
        } int6[6:6];

        enum ISP_INT_int5_enum {
            NO_INTERRUPT_GENERATED = 0 { name = "No Interrupt Generated"; desc = "No interrupt is generated."; };
            INTERRUPT_GENERATED = 1 { name = "Interrupt Generated"; desc = "An interrupt is generated."; };
        };

        field {
            name = "int5";
            desc = "ISP interrupt 5 indicator. Writing 1 clears the indicator.";
            sw = rw;
            hw = w;
            onwrite = woclr;
            encode = ISP_INT_int5_enum;
            reset = 0x0;
        } int5[5:5];

        enum ISP_INT_int4_enum {
            NO_INTERRUPT_GENERATED = 0 { name = "No Interrupt Generated"; desc = "No interrupt is generated."; };
            INTERRUPT_GENERATED = 1 { name = "Interrupt Generated"; desc = "An interrupt is generated."; };
        };

        field {
            name = "int4";
            desc = "ISP interrupt 4 indicator. Writing 1 clears the indicator.";
            sw = rw;
            hw = w;
            onwrite = woclr;
            encode = ISP_INT_int4_enum;
            reset = 0x0;
        } int4[4:4];

        enum ISP_INT_int3_enum {
            NO_INTERRUPT_GENERATED = 0 { name = "No Interrupt Generated"; desc = "No interrupt is generated."; };
            INTERRUPT_GENERATED = 1 { name = "Interrupt Generated"; desc = "An interrupt is generated."; };
        };

        field {
            name = "int3";
            desc = "ISP interrupt 3 indicator. Writing 1 clears the indicator.";
            sw = rw;
            hw = w;
            onwrite = woclr;
            encode = ISP_INT_int3_enum;
            reset = 0x0;
        } int3[3:3];

        field {
            name = "int2";
            desc = "int2";
            sw = rw;
            hw = w;
            onwrite = woclr;
            reset = 0x0;
        } int2[2:2];

        field {
            name = "int1";
            desc = "int1";
            sw = rw;
            hw = w;
            onwrite = woclr;
            reset = 0x0;
        } int1[1:1];

        field {
            name = "int0";
            desc = "int0";
            sw = rw;
            hw = w;
            onwrite = woclr;
            reset = 0x0;
        } int0[0:0];
    } ISP_INT @ 0x100F0;

    reg {
        name = "ISP interrupt mask register";
        desc = "ISP_INT_MASK is an ISP interrupt mask register.

Data sheet 10.1.6 ISP_INT_MASK (offset 0x100F8, printed page 10-83, `hi3516cv100--Hi3516C-Datasheet.txt` line 41034).";

        enum ISP_INT_MASK_int7_en_enum {
            NO_INTERRUPT_GENERATED = 0 { name = "No Interrupt Generated"; desc = "No interrupt is generated."; };
            INTERRUPT_GENERATED = 1 { name = "Interrupt Generated"; desc = "An interrupt is generated."; };
        };

        field {
            name = "int7_en";
            desc = "ISP interrupt 7 mask.";
            sw = rw;
            hw = r;
            encode = ISP_INT_MASK_int7_en_enum;
            reset = 0x0;
        } int7_en[7:7];

        enum ISP_INT_MASK_int6_en_enum {
            NO_INTERRUPT_GENERATED = 0 { name = "No Interrupt Generated"; desc = "No interrupt is generated."; };
            INTERRUPT_GENERATED = 1 { name = "Interrupt Generated"; desc = "An interrupt is generated."; };
        };

        field {
            name = "int6_en";
            desc = "ISP interrupt 6 mask.";
            sw = rw;
            hw = r;
            encode = ISP_INT_MASK_int6_en_enum;
            reset = 0x0;
        } int6_en[6:6];

        field {
            name = "int5_en";
            desc = "int5_en";
            sw = rw;
            hw = r;
            reset = 0x0;
        } int5_en[5:5];

        field {
            name = "int4_en";
            desc = "int4_en";
            sw = rw;
            hw = r;
            reset = 0x0;
        } int4_en[4:4];

        field {
            name = "int3_en";
            desc = "int3_en";
            sw = rw;
            hw = r;
            reset = 0x0;
        } int3_en[3:3];

        field {
            name = "int2_en";
            desc = "int2_en";
            sw = rw;
            hw = r;
            reset = 0x0;
        } int2_en[2:2];

        field {
            name = "int1_en";
            desc = "int1_en";
            sw = rw;
            hw = r;
            reset = 0x0;
        } int1_en[1:1];

        field {
            name = "int0_en";
            desc = "int0_en";
            sw = rw;
            hw = r;
            reset = 0x0;
        } int0_en[0:0];
    } ISP_INT_MASK @ 0x100F8;
};

`endif
