`ifndef HISI_SIO_RDL
`define HISI_SIO_RDL

// SIO: the FIFO based I2S/PCM audio interface of the Hi3511/Hi3512, Hi3515 and Hi3520 V100 generation (2009-2010), fed by the CPU or the DMAC through
// the 32-bit CPU interface registers below (no own DMA engine, unlike the later AIO of the Hi3520D and the AIAO of the Hi3516A and newer).
// Transcribed from the Hi3515 data sheet issue 02 chapter 7 (`hi3515v100--Hi3515-Datasheet.txt` lines 38354-39560, SIO0 0x1004_0000 / SIO1 0x1005_0000,
// VIC interrupts 25/26, DMAC requests 0-3) and checked against the Hi3520 V100 Chinese data sheet chapter 7 (SIO0/1/2 at 0x1004_0000/0x1005_0000/0x1006_0000,
// interrupts 25/26, same registers and bits). The Hi3511/Hi3512 (Chinese data sheet chapter 7, SIO0 0x8008_0000, SIO1 0x900A_0000, interrupts 27/18) is an
// older edition of the IP with a different register set at 0x5C-0x78 (I2S_CT_SET/I2S_CT_CLR/I2S_ICD at 0x5C/0x60/0x64, PCM_CT_SET/PCM_CT_CLR at 0x70/0x74,
// I2S_LENGTH_CF at 0x78, no SIO_VERSION/SIO_PCM_XD/SIO_PCM_RD/SIO_INTMASK) and is NOT modelled here (needs its own audit before it is instantiated).
regfile eHISI_SIO {
    name = "HiSilicon SIO (I2S/PCM audio interface)";
    desc = "
    Serial audio interface (SIO) of the Hi3515 / Hi3520 V100 generation: one I2S (16/18/20/24/32-bit, left + right FIFOs) or PCM (8/16-bit, one FIFO)
    transmit path and one receive path, each with a 16-entry FIFO per channel; master or slave mode is selected in the system controller (SC_PERCTRL12 on the
    Hi3515) and the clocks come from the CRG. The CPU (or the DMAC, requests on the FIFO thresholds) writes samples to SIO_I2S_LEFT_XD / SIO_I2S_RIGHT_XD
    (PCM: SIO_PCM_XD = the same address as the right register) and reads them from SIO_I2S_LEFT_RD / SIO_I2S_RIGHT_RD (SIO_PCM_RD); with
    SIO_I2S_POS_MERGE_EN.merge_en both channels go through the single SIO_I2S_DUAL_RX_CHN / SIO_I2S_DUAL_TX_CHN address so one DMA channel serves both.
    The control bits (reset, interrupt enable, channel enables, FIFO thresholds) live in a set/clear pair: SIO_CT_SET (0x5C, read/write-1-to-set) and
    SIO_CT_CLR (0x60, write-1-to-clear); SIO_INTSTATUS / SIO_INTCLR / SIO_INTMASK handle the six interrupt sources.

    Registers from the Hi3515 data sheet issue 02 chapter 7.6/7.7 (`hi3515v100--Hi3515-Datasheet.txt` lines 38354-39560); the Hi3520 V100 Chinese data sheet
    chapter 7 gives the same tables. Not hardware verified; the only vendor code is in the closed Hi35xx SDK audio modules.
    ";

    reg {
        name = "SIO version register";
        desc = "SIO_VERSION is the SIO version register. It records the SIO version number and selects the self-test loop mode.

Data sheet 7.7 SIO_VERSION (offset 0x3C, printed page 7-12, `hi3515v100--Hi3515-Datasheet.txt` line 38427).";

        enum SIO_VERSION_sio_loop_enum {
            NORMAL = 0 { name = "Normal"; desc = "Normal mode."; };
            LOOP = 1 { name = "Loop"; desc = "Data transmit and receive loop mode (self-test): the SIO receive serial data line is connected directly to the SIO transmit serial data line at the external interface of the SIO."; };
        };

        field {
            name = "sio_loop";
            desc = "SIO loop or normal mode select.";
            sw = rw;
            hw = r;
            encode = SIO_VERSION_sio_loop_enum;
            reset = 0x0;
        } sio_loop[8:8];

        field {
            name = "version";
            desc = "Version number of the SIO (reset 0x13).";
            sw = r;
            hw = w;
            reset = 0x13;
        } version[7:0];
    } SIO_VERSION @ 0x3C;

    reg {
        name = "SIO mode register";
        desc = "SIO_MODE is the SIO mode register: basic operating mode of the SIO. In master mode the clock and sync signals to the codec and the SIO are generated by the CRG; in slave mode the external codec drives them. Master/slave is selected in the system control register (SC_PERCTRL12 on the Hi3515, section 3.10.5).

Data sheet 7.7 SIO_MODE (offset 0x40, printed page 7-13, `hi3515v100--Hi3515-Datasheet.txt` line 38470).";

        enum SIO_MODE_clk_edge_enum {
            FALLING = 0 { name = "Falling"; desc = "Falling edge."; };
            RISING = 1 { name = "Rising"; desc = "Rising edge."; };
        };

        field {
            name = "clk_edge";
            desc = "Clock edge on which data is sampled during multi-channel data receive in PCM mode.";
            sw = rw;
            hw = r;
            encode = SIO_MODE_clk_edge_enum;
            reset = 0x0;
        } clk_edge[6:6];

        enum SIO_MODE_chn_num_enum {
            CH_2 = 0 { name = "2 Channels"; desc = "2 channels"; };
            CH_4 = 1 { name = "4 Channels"; desc = "4 channels"; };
            CH_8 = 2 { name = "8 Channels"; desc = "8 channels"; };
            CH_16 = 3 { name = "16 Channels"; desc = "16 channels"; };
        };

        field {
            name = "chn_num";
            desc = "Number of channels during multi-channel data receive (ext_rec_en = 1).";
            sw = rw;
            hw = r;
            encode = SIO_MODE_chn_num_enum;
            reset = 0x0;
        } chn_num[5:4];

        enum SIO_MODE_ext_rec_en_enum {
            STANDARD = 0 { name = "Standard"; desc = "Standard data receive mode of the I2S/PCM interface."; };
            EXTENDED = 1 { name = "Extended"; desc = "Extended multi-channel data receive mode of the I2S/PCM interface."; };
        };

        field {
            name = "ext_rec_en";
            desc = "Extended multi-channel receive enable. In standard mode the I2S interface receives both the left and the right channel and the PCM interface one of them; in the extended multi-channel mode the number of channels is set by chn_num and the channel width must be 8 or 16 bits.";
            sw = rw;
            hw = r;
            encode = SIO_MODE_ext_rec_en_enum;
            reset = 0x0;
        } ext_rec_en[3:3];

        field {
            name = "reserved_b2";
            desc = "Reserved. This bit must be set to 0.";
            sw = rw;
            hw = r;
            reset = 0x0;
        } reserved_b2[2:2];

        enum SIO_MODE_pcm_mode_enum {
            STANDARD = 0 { name = "Standard"; desc = "Standard mode."; };
            CUSTOMIZED = 1 { name = "Customized"; desc = "Customized mode."; };
        };

        field {
            name = "pcm_mode";
            desc = "PCM timing mode.";
            sw = rw;
            hw = r;
            encode = SIO_MODE_pcm_mode_enum;
            reset = 0x0;
        } pcm_mode[1:1];

        enum SIO_MODE_sio_mode_enum {
            I2S = 0 { name = "I2S"; desc = "I2S mode."; };
            PCM = 1 { name = "PCM"; desc = "PCM mode."; };
        };

        field {
            name = "sio_mode";
            desc = "PCM/I2S mode select.";
            sw = rw;
            hw = r;
            encode = SIO_MODE_sio_mode_enum;
            reset = 0x0;
        } sio_mode[0:0];
    } SIO_MODE @ 0x40;

    reg {
        name = "SIO interrupt status register";
        desc = "SIO_INTSTATUS is the SIO (raw) interrupt status register: a bit is set whenever its condition is met even if the source is masked in SIO_INTMASK; a level condition (FIFO above/below threshold) is latched again in the next clock cycle after a clear. Recommended handling: write 1 to SIO_CT_CLR.intr_en (disable the global enable), read SIO_INTSTATUS, service the sources, write 1 to the SIO_INTCLR bits, write 1 to SIO_CT_SET.intr_en.

Data sheet 7.7 SIO_INTSTATUS (offset 0x44, printed page 7-14, `hi3515v100--Hi3515-Datasheet.txt` line 38517).";

        field {
            name = "tx_left_fifo_under";
            desc = "In I2S mode: left channel TX_FIFO underflow interrupt status. In PCM mode this bit is invalid. 0: no interrupt, 1: interrupt.";
            sw = r;
            hw = w;
            reset = 0x0;
        } tx_left_fifo_under[5:5];

        field {
            name = "tx_right_fifo_under";
            desc = "In I2S mode: right channel TX_FIFO underflow interrupt status. In PCM mode: PCM TX_FIFO underflow flag. 0: no interrupt, 1: interrupt.";
            sw = r;
            hw = w;
            reset = 0x0;
        } tx_right_fifo_under[4:4];

        field {
            name = "rx_left_fifo_over";
            desc = "In I2S mode: left channel RX_FIFO overflow interrupt status. In PCM mode this bit is invalid. 0: no interrupt, 1: interrupt.";
            sw = r;
            hw = w;
            reset = 0x0;
        } rx_left_fifo_over[3:3];

        field {
            name = "rx_right_fifo_over";
            desc = "In I2S mode: right channel RX_FIFO overflow interrupt status. In PCM mode: PCM RX_FIFO overflow flag (the data sheet says 'underflow'). 0: no interrupt, 1: interrupt.";
            sw = r;
            hw = w;
            reset = 0x0;
        } rx_right_fifo_over[2:2];

        field {
            name = "tx_intr";
            desc = "Interrupt status when the TX_FIFO level is below the threshold (SIO_CT_SET.tx_fifo_threshold). 0: no interrupt, 1: interrupt.";
            sw = r;
            hw = w;
            reset = 0x0;
        } tx_intr[1:1];

        field {
            name = "rx_intr";
            desc = "Interrupt status when the RX_FIFO level is above the threshold (SIO_CT_SET.rx_fifo_threshold). 0: no interrupt, 1: interrupt.";
            sw = r;
            hw = w;
            reset = 0x0;
        } rx_intr[0:0];
    } SIO_INTSTATUS @ 0x44;

    reg {
        name = "SIO interrupt clear register";
        desc = "SIO_INTCLR is the SIO interrupt clear register; each bit clears the SIO_INTSTATUS bit of the same position when written with 1 (writing 0 has no effect).

Data sheet 7.7 SIO_INTCLR (offset 0x48, printed page 7-16, `hi3515v100--Hi3515-Datasheet.txt` line 38577).";

        field {
            name = "tx_left_fifo_under";
            desc = "Clear the left channel TX_FIFO underflow interrupt (I2S mode; invalid in PCM mode).";
            sw = w;
            hw = r;
            onwrite = woclr;
        } tx_left_fifo_under[5:5];

        field {
            name = "tx_right_fifo_under";
            desc = "Clear the right channel TX_FIFO underflow interrupt (I2S mode) / the PCM TX_FIFO underflow interrupt.";
            sw = w;
            hw = r;
            onwrite = woclr;
        } tx_right_fifo_under[4:4];

        field {
            name = "rx_left_fifo_over";
            desc = "Clear the left channel RX_FIFO overflow interrupt (I2S mode; invalid in PCM mode).";
            sw = w;
            hw = r;
            onwrite = woclr;
        } rx_left_fifo_over[3:3];

        field {
            name = "rx_right_fifo_over";
            desc = "Clear the right channel RX_FIFO overflow interrupt (I2S mode) / the PCM RX_FIFO overflow interrupt.";
            sw = w;
            hw = r;
            onwrite = woclr;
        } rx_right_fifo_over[2:2];

        field {
            name = "tx_intr";
            desc = "Clear the TX_FIFO level below threshold interrupt.";
            sw = w;
            hw = r;
            onwrite = woclr;
        } tx_intr[1:1];

        field {
            name = "rx_intr";
            desc = "Clear the RX_FIFO level above threshold interrupt.";
            sw = w;
            hw = r;
            onwrite = woclr;
        } rx_intr[0:0];
    } SIO_INTCLR @ 0x48;

    reg {
        name = "I2S left channel data transmit register";
        desc = "SIO_I2S_LEFT_XD is the I2S left channel data transmit register (write into the left TX_FIFO). The valid data sits in the low bits (8-bit width: [7:0], 16-bit: [15:0], ...); the SIO ignores the bits above the configured width.

Data sheet 7.7 SIO_I2S_LEFT_XD (offset 0x4C, printed page 7-17, `hi3515v100--Hi3515-Datasheet.txt` line 38624).";

        field {
            name = "tx_left_data";
            desc = "Left channel transmit data.";
            sw = w;
            hw = r;
            reset = 0x0;
        } tx_left_data[31:0];
    } SIO_I2S_LEFT_XD @ 0x4C;

    reg {
        name = "I2S right channel / PCM data transmit register";
        desc = "SIO_I2S_RIGHT_XD is the I2S right channel data transmit register; the PCM data transmit register SIO_PCM_XD (16-bit, bits [31:16] reserved) is the same address. The valid data sits in the low bits of the configured width.

Data sheet 7.7 SIO_I2S_RIGHT_XD / SIO_PCM_XD (offset 0x50, printed pages 7-17/7-18, `hi3515v100--Hi3515-Datasheet.txt` lines 38638 and 38653).";

        field {
            name = "tx_right_data";
            desc = "Right channel transmit data (I2S mode) or PCM transmit data (PCM mode, bits [15:0]).";
            sw = w;
            hw = r;
            reset = 0x0;
        } tx_right_data[31:0];
    } SIO_I2S_RIGHT_XD @ 0x50;

    reg {
        name = "I2S left channel data receive register";
        desc = "SIO_I2S_LEFT_RD is the I2S left channel data receive register (read from the left RX_FIFO). The received data sits in the low bits of the configured width (sign-extended into the upper bits when SIO_SIGNED_EXT.signed_ext_en = 1). Note: when data receive is disabled in I2S mode the right channel data may not be written into the FIFO, so the left FIFO can hold one entry more than the right one; clear both FIFOs (SIO_CT_CLR.rst_n) before enabling the next receive.

Data sheet 7.7 SIO_I2S_LEFT_RD (offset 0x54, printed page 7-18, `hi3515v100--Hi3515-Datasheet.txt` line 38668).";

        field {
            name = "rx_left_data";
            desc = "I2S left channel receive data.";
            sw = r;
            hw = w;
            reset = 0x0;
        } rx_left_data[31:0];
    } SIO_I2S_LEFT_RD @ 0x54;

    reg {
        name = "I2S right channel / PCM data receive register";
        desc = "SIO_I2S_RIGHT_RD is the I2S right channel data receive register; the PCM data receive register SIO_PCM_RD (16-bit, bits [31:16] reserved) is the same address.

Data sheet 7.7 SIO_I2S_RIGHT_RD / SIO_PCM_RD (offset 0x58, printed pages 7-19/7-20, `hi3515v100--Hi3515-Datasheet.txt` lines 38689 and 38709).";

        field {
            name = "rx_right_data";
            desc = "I2S right channel receive data (I2S mode) or PCM receive data (PCM mode, bits [15:0]).";
            sw = r;
            hw = w;
            reset = 0x0;
        } rx_right_data[31:0];
    } SIO_I2S_RIGHT_RD @ 0x58;

    reg {
        name = "I2S/PCM control set register";
        desc = "SIO_CT_SET is the I2S/PCM control register in its set view: writing 1 to a bit sets it, writing 0 has no effect, reads return the control register. The same control bits are cleared through SIO_CT_CLR (0x60, write-only). Total reset value 0x0000_8000 (rst_n = 1, channel not in reset).

Data sheet 7.7 SIO_CT_SET (offset 0x5C, printed page 7-20, `hi3515v100--Hi3515-Datasheet.txt` line 38728).";

        field {
            name = "rst_n";
            desc = "I2S/PCM channel reset, active low. Resets the transmit and receive modules including the FIFOs (the RX_FIFO and TX_FIFO status registers go to 0); does not reset the CPU interface registers.";
            sw = rw;
            hw = r;
            onwrite = woset;
            reset = 0x1;
        } rst_n[15:15];

        field {
            name = "intr_en";
            desc = "Global interrupt enable. 0: disabled, 1: enabled.";
            sw = rw;
            hw = r;
            onwrite = woset;
            reset = 0x0;
        } intr_en[14:14];

        field {
            name = "rx_enable";
            desc = "Receive channel enable. 0: disabled, 1: enabled.";
            sw = rw;
            hw = r;
            onwrite = woset;
            reset = 0x0;
        } rx_enable[13:13];

        field {
            name = "tx_enable";
            desc = "Transmit channel enable. 0: disabled, 1: enabled.";
            sw = rw;
            hw = r;
            onwrite = woset;
            reset = 0x0;
        } tx_enable[12:12];

        field {
            name = "rx_fifo_disable";
            desc = "RX_FIFO disable. 0: FIFO enabled, 1: FIFO disabled.";
            sw = rw;
            hw = r;
            onwrite = woset;
            reset = 0x0;
        } rx_fifo_disable[11:11];

        field {
            name = "tx_fifo_disable";
            desc = "TX_FIFO disable. 0: FIFO enabled, 1: FIFO disabled.";
            sw = rw;
            hw = r;
            onwrite = woset;
            reset = 0x0;
        } tx_fifo_disable[10:10];

        field {
            name = "rx_data_merge_en";
            desc = "Data receive merging enable (only with 16-bit data in I2S mode). 1: the left and right 16-bit samples are merged into one 32-bit word (left in the 16 MSBs) before storage in the FIFO; the CPU then reads one 32-bit word from the left FIFO, one from the right FIFO, and so on.";
            sw = rw;
            hw = r;
            onwrite = woset;
            reset = 0x0;
        } rx_data_merge_en[9:9];

        field {
            name = "tx_data_merge_en";
            desc = "Data transmit merging enable (only with 16-bit data in I2S mode). 1: the CPU writes 32-bit words holding the left sample in the 16 MSBs and the right sample in the 16 LSBs, alternately to the left FIFO and the right FIFO.";
            sw = rw;
            hw = r;
            onwrite = woset;
            reset = 0x0;
        } tx_data_merge_en[8:8];

        field {
            name = "rx_fifo_threshold";
            desc = "RX_FIFO threshold: when rx_right_depth >= rx_fifo_threshold + 1 the receive interrupt and DMA request are raised.";
            sw = rw;
            hw = r;
            onwrite = woset;
            reset = 0x0;
        } rx_fifo_threshold[7:4];

        field {
            name = "tx_fifo_threshold";
            desc = "TX_FIFO threshold: when tx_right_depth < tx_fifo_threshold + 1 the transmit interrupt and DMA request are raised.";
            sw = rw;
            hw = r;
            onwrite = woset;
            reset = 0x0;
        } tx_fifo_threshold[3:0];
    } SIO_CT_SET @ 0x5C;

    reg {
        name = "I2S/PCM control clear register";
        desc = "SIO_CT_CLR is the clear view of the I2S/PCM control register: writing 1 to a bit clears the control bit of the same position in SIO_CT_SET, writing 0 has no effect; write-only (the data sheet prints the SIO_CT_SET table, offset '0x05C/0x060', for both views).

Data sheet 7.7 SIO_CT_CLR (offset 0x60, printed page 7-22, `hi3515v100--Hi3515-Datasheet.txt` line 38807).";

        field { name = "rst_n"; desc = "Write 1 to clear rst_n (put the I2S/PCM channel and its FIFOs in reset)."; sw = w; hw = r; onwrite = woclr; } rst_n[15:15];
        field { name = "intr_en"; desc = "Write 1 to clear the global interrupt enable."; sw = w; hw = r; onwrite = woclr; } intr_en[14:14];
        field { name = "rx_enable"; desc = "Write 1 to disable the receive channel."; sw = w; hw = r; onwrite = woclr; } rx_enable[13:13];
        field { name = "tx_enable"; desc = "Write 1 to disable the transmit channel."; sw = w; hw = r; onwrite = woclr; } tx_enable[12:12];
        field { name = "rx_fifo_disable"; desc = "Write 1 to clear rx_fifo_disable (enable the RX_FIFO)."; sw = w; hw = r; onwrite = woclr; } rx_fifo_disable[11:11];
        field { name = "tx_fifo_disable"; desc = "Write 1 to clear tx_fifo_disable (enable the TX_FIFO)."; sw = w; hw = r; onwrite = woclr; } tx_fifo_disable[10:10];
        field { name = "rx_data_merge_en"; desc = "Write 1 to clear rx_data_merge_en."; sw = w; hw = r; onwrite = woclr; } rx_data_merge_en[9:9];
        field { name = "tx_data_merge_en"; desc = "Write 1 to clear tx_data_merge_en."; sw = w; hw = r; onwrite = woclr; } tx_data_merge_en[8:8];
        field { name = "rx_fifo_threshold"; desc = "Write 1 to clear the corresponding bits of rx_fifo_threshold."; sw = w; hw = r; onwrite = woclr; } rx_fifo_threshold[7:4];
        field { name = "tx_fifo_threshold"; desc = "Write 1 to clear the corresponding bits of tx_fifo_threshold."; sw = w; hw = r; onwrite = woclr; } tx_fifo_threshold[3:0];
    } SIO_CT_CLR @ 0x60;

    reg {
        name = "SIO receive status register";
        desc = "SIO_RX_STA is the SIO receive status register (RX_FIFO fill levels).

Data sheet 7.7 SIO_RX_STA (offset 0x68, printed page 7-24, `hi3515v100--Hi3515-Datasheet.txt` line 38874).";

        field {
            name = "rx_left_depth";
            desc = "Left channel RX_FIFO depth indicator (valid only in I2S mode).";
            sw = r;
            hw = w;
            reset = 0x0;
        } rx_left_depth[9:5];

        field {
            name = "rx_right_depth";
            desc = "Right channel RX_FIFO depth indicator (I2S mode) / PCM RX_FIFO depth indicator (PCM mode).";
            sw = r;
            hw = w;
            reset = 0x0;
        } rx_right_depth[4:0];
    } SIO_RX_STA @ 0x68;

    reg {
        name = "SIO transmit status register";
        desc = "SIO_TX_STA is the SIO transmit status register (TX_FIFO fill levels).

Data sheet 7.7 SIO_TX_STA (offset 0x6C, printed page 7-25, `hi3515v100--Hi3515-Datasheet.txt` line 38892).";

        field {
            name = "tx_left_depth";
            desc = "Left channel TX_FIFO depth indicator (valid only in I2S mode).";
            sw = r;
            hw = w;
            reset = 0x0;
        } tx_left_depth[9:5];

        field {
            name = "tx_right_depth";
            desc = "Right channel TX_FIFO depth indicator (I2S mode) / PCM TX_FIFO depth indicator (PCM mode).";
            sw = r;
            hw = w;
            reset = 0x0;
        } tx_right_depth[4:0];
    } SIO_TX_STA @ 0x6C;

    reg {
        name = "I2S/PCM data width set register";
        desc = "SIO_DATA_WIDTH_SET is the I2S/PCM data width set register. Total reset value 0x9 (16 bits in both directions). I2S mode supports 16, 18, 20, 24 and 32 bits; PCM mode 8 and 16 bits; multi-channel receive (SIO_MODE.ext_rec_en) only 8 and 16 bits.

Data sheet 7.7 SIO_DATA_WIDTH_SET (offset 0x78, printed page 7-25, `hi3515v100--Hi3515-Datasheet.txt` line 38908).";

        enum SIO_DATA_WIDTH_SET_width_enum {
            W_8 = 0 { name = "8 Bits"; desc = "8 bits"; };
            W_16 = 1 { name = "16 Bits"; desc = "16 bits"; };
            W_18 = 2 { name = "18 Bits"; desc = "18 bits"; };
            W_20 = 3 { name = "20 Bits"; desc = "20 bits"; };
            W_24 = 4 { name = "24 Bits"; desc = "24 bits"; };
            W_32 = 5 { name = "32 Bits"; desc = "32 bits. 110-111: reserved"; };
        };

        field {
            name = "rx_mode";
            desc = "Length of the data to be received.";
            sw = rw;
            hw = r;
            encode = SIO_DATA_WIDTH_SET_width_enum;
            reset = 0x1;
        } rx_mode[5:3];

        field {
            name = "tx_mode";
            desc = "Length of the data to be transmitted.";
            sw = rw;
            hw = r;
            encode = SIO_DATA_WIDTH_SET_width_enum;
            reset = 0x1;
        } tx_mode[2:0];
    } SIO_DATA_WIDTH_SET @ 0x78;

    reg {
        name = "I2S left/right channel access start position register";
        desc = "SIO_I2S_START_POS controls whether the first access starts from the left or the right channel after the left/right data access address merging (SIO_I2S_POS_MERGE_EN) is enabled.

Data sheet 7.7 SIO_I2S_START_POS (offset 0x7C, printed page 7-26, `hi3515v100--Hi3515-Datasheet.txt` line 38938).";

        enum SIO_I2S_START_POS_pos_enum {
            LEFT = 0 { name = "Left"; desc = "Start the access from the left channel."; };
            RIGHT = 1 { name = "Right"; desc = "Start the access from the right channel."; };
        };

        field {
            name = "start_pos_write";
            desc = "Start channel when writing data into the TX_FIFO through SIO_I2S_DUAL_TX_CHN.";
            sw = rw;
            hw = r;
            encode = SIO_I2S_START_POS_pos_enum;
            reset = 0x0;
        } start_pos_write[1:1];

        field {
            name = "start_pos_read";
            desc = "Start channel when reading data from the RX_FIFO through SIO_I2S_DUAL_RX_CHN.";
            sw = rw;
            hw = r;
            encode = SIO_I2S_START_POS_pos_enum;
            reset = 0x0;
        } start_pos_read[0:0];
    } SIO_I2S_START_POS @ 0x7C;

    reg {
        name = "I2S left/right channel current position register";
        desc = "I2S_POS_FLAG is the current position status register of the I2S left and right channels: which channel the next merged access (SIO_I2S_DUAL_RX_CHN / SIO_I2S_DUAL_TX_CHN) will address.

Data sheet 7.7 I2S_POS_FLAG (offset 0x80, printed page 7-27, `hi3515v100--Hi3515-Datasheet.txt` line 38960).";

        enum I2S_POS_FLAG_pos_enum {
            LEFT = 0 { name = "Left"; desc = "The subsequent access starts from the left channel."; };
            RIGHT = 1 { name = "Right"; desc = "The subsequent access starts from the right channel."; };
        };

        field {
            name = "start_pos_write";
            desc = "Channel of the next write into the TX_FIFO.";
            sw = r;
            hw = w;
            encode = I2S_POS_FLAG_pos_enum;
            reset = 0x0;
        } start_pos_write[1:1];

        field {
            name = "start_pos_read";
            desc = "Channel of the next read from the RX_FIFO.";
            sw = r;
            hw = w;
            encode = I2S_POS_FLAG_pos_enum;
            reset = 0x0;
        } start_pos_read[0:0];
    } I2S_POS_FLAG @ 0x80;

    reg {
        name = "Upper-bit sign extend enable register";
        desc = "SIO_SIGNED_EXT enables sign extension of the received data (PCM and I2S modes, receive only): with a valid width of 8, 16, 18, 20 or 24 bits the invalid upper bits of the 32-bit word written into the RX_FIFO are filled with the MSB of the sample (e.g. 16 bits: data_rx[31:16] = data_rx[15] ? 0xFFFF : 0x0000).

Data sheet 7.7 SIO_SIGNED_EXT (offset 0x84, printed page 7-28, `hi3515v100--Hi3515-Datasheet.txt` line 38983).";

        field {
            name = "signed_ext_en";
            desc = "Upper-bit sign extend enable. 0: disabled, 1: enabled.";
            sw = rw;
            hw = r;
            reset = 0x0;
        } signed_ext_en[0:0];
    } SIO_SIGNED_EXT @ 0x84;

    reg {
        name = "I2S left/right channel access position merging enable register";
        desc = "SIO_I2S_POS_MERGE_EN enables the access position merging of the I2S left and right channels: when enabled, both channels are read through SIO_I2S_DUAL_RX_CHN and written through SIO_I2S_DUAL_TX_CHN (alternating channel, start channel from SIO_I2S_START_POS), so a DMA transfer needs a single address.

Data sheet 7.7 SIO_I2S_POS_MERGE_EN (offset 0x88, printed page 7-28, `hi3515v100--Hi3515-Datasheet.txt` line 39006).";

        field {
            name = "merge_en";
            desc = "Data access position merging enable of the I2S left and right channels. 0: disabled, 1: enabled.";
            sw = rw;
            hw = r;
            reset = 0x0;
        } merge_en[0:0];
    } SIO_I2S_POS_MERGE_EN @ 0x88;

    reg {
        name = "SIO interrupt mask register";
        desc = "SIO_INTMASK is the SIO interrupt mask register (1 = masked); total reset value 0x3F, all six sources masked (the bit-row reset of the Hi3515 and Hi3520 tables; both table headers print 0x0000_0000, which contradicts the bit row and is taken as the typo; not hardware verified). The SIO_INTSTATUS bits are set regardless of the mask.

Data sheet 7.7 SIO_INTMASK (offset 0x8C, printed page 7-29, `hi3515v100--Hi3515-Datasheet.txt` line 39033).";

        field { name = "tx_left_fifo_under"; desc = "Left channel TX_FIFO underflow interrupt mask (I2S mode; invalid in PCM mode). 0: not masked, 1: masked."; sw = rw; hw = r; reset = 0x1; } tx_left_fifo_under[5:5];
        field { name = "tx_right_fifo_under"; desc = "Right channel TX_FIFO underflow (I2S) / PCM TX_FIFO underflow interrupt mask. 0: not masked, 1: masked."; sw = rw; hw = r; reset = 0x1; } tx_right_fifo_under[4:4];
        field { name = "rx_left_fifo_over"; desc = "Left channel RX_FIFO overflow interrupt mask (I2S mode; invalid in PCM mode). 0: not masked, 1: masked."; sw = rw; hw = r; reset = 0x1; } rx_left_fifo_over[3:3];
        field { name = "rx_right_fifo_over"; desc = "Right channel RX_FIFO overflow (I2S) / PCM RX_FIFO overflow interrupt mask. 0: not masked, 1: masked."; sw = rw; hw = r; reset = 0x1; } rx_right_fifo_over[2:2];
        field { name = "tx_intr"; desc = "TX_FIFO level below threshold interrupt mask. 0: not masked, 1: masked."; sw = rw; hw = r; reset = 0x1; } tx_intr[1:1];
        field { name = "rx_intr"; desc = "RX_FIFO level above threshold interrupt mask. 0: not masked, 1: masked."; sw = rw; hw = r; reset = 0x1; } rx_intr[0:0];
    } SIO_INTMASK @ 0x8C;

    reg {
        name = "I2S merged data receive register";
        desc = "SIO_I2S_DUAL_RX_CHN is the data receive register used when the left/right access position merging (SIO_I2S_POS_MERGE_EN) is enabled: successive reads alternate between the left and the right RX_FIFO.

Data sheet 7.7 SIO_I2S_DUAL_RX_CHN (offset 0xA0, printed page 7-30, `hi3515v100--Hi3515-Datasheet.txt` line 39076).";

        field {
            name = "rx_data";
            desc = "Received data.";
            sw = r;
            hw = w;
            reset = 0x0;
        } rx_data[31:0];
    } SIO_I2S_DUAL_RX_CHN @ 0xA0;

    reg {
        name = "I2S merged data transmit register";
        desc = "SIO_I2S_DUAL_TX_CHN is the data transmit register used when the left/right access position merging (SIO_I2S_POS_MERGE_EN) is enabled: successive writes alternate between the left and the right TX_FIFO.

Data sheet 7.7 SIO_I2S_DUAL_TX_CHN (offset 0xC0, printed page 7-31, `hi3515v100--Hi3515-Datasheet.txt` line 39089).";

        field {
            name = "tx_data";
            desc = "Transmitted data.";
            sw = w;
            hw = r;
            reset = 0x0;
        } tx_data[31:0];
    } SIO_I2S_DUAL_TX_CHN @ 0xC0;
};

`endif
