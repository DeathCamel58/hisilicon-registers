`ifndef HISI_POWER_CTRL_RDL
`define HISI_POWER_CTRL_RDL


regfile eHISI_POWER_CTRL {
    name = "Power controller (always-on domain, Hi3516C V300 / Hi3516E V100)";
    desc = "
    Power controller of the Hi3516C V300 / Hi3516E V100 at 0x12098000 (32 KB window, data sheet Table 1-1; PWR_BUTTON / PWR_WAKEUP / PWR_EN_OUT / PWR_SEQ0-2 pins, power-off timing, wakeup source). Four registers, data sheet 3.10.2.4 (Table 3-23). The GPIO7_1..GPIO7_6 pins need the RTC running and PWR_CTRL0 = 0xE2 before their pinmux is touched (data sheet 12.7, note).
    Vendor cross-check: the vendor/OpenIPC U-Boot init table reg_info_hi3516cv300.bin (decoded: write 0x12098000 = 0xE0, all 32 bits) sets PWR_PAD_GPIO_EN (bit 7), wakeup_mask (bit 6) and rtc_int_mask (bit 5): PROVEN as an access, the purpose of the choice is INFERRED from the field names.
    
    PROVENANCE: PROVEN = register offsets, names, bit fields, access and reset values transcribed from the Hi3516C V300/Hi3516E V100 data sheet issue 05 (3.10.2.4); the description of every register and field is the data sheet text.  Nothing here is hardware verified (no CV300 board in the lab).


    Register sources: 4 registers from the data sheet (hi3516cv300--Hi3516CV300-Hi3516EV100-Datasheet.txt, section 3.10.2.4); 0 registers and 0 fields from - (-), each marked `[inferred]` in its desc (names from the header, meanings inferred from the names, reset/access unknown). ";

    reg {
        name = "PWR control register 0";
        desc = "PWR control register 0.

Data sheet 3.10.2.4 PWR_CTRL0 (offset 0x0, printed page 3-177, `hi3516cv300--Hi3516CV300-Hi3516EV100-Datasheet.txt` line 14678).";

        field {
            name = "PWR_PAD_GPIO_EN";
            desc = "If this bit is set to 0 when the core power supply is not turned on, the pins (PWR_BUTTON, PWR_WAKEUP, PWR_EN_OUT, PWR_SEQ0, PWR_SEQ1, and PWR_SEQ2) related to the power controller will be configured as the power control function. After the core power supply is turned on and becomes stable, if you need to configure these pins as the GPIO function, you need to set this bit to 1.";
            sw = rw;
            hw = r;
            reset = 0x0;
        } PWR_PAD_GPIO_EN[7:7];

        enum PWR_CTRL0_wakeup_mask_enum {
            NOT_MASKED = 0 { name = "Not Masked"; desc = "not masked"; };
            MASKED = 1 { name = "Masked"; desc = "masked"; };
        };

        field {
            name = "wakeup_mask";
            desc = "Wakeup mask";
            sw = rw;
            hw = r;
            encode = PWR_CTRL0_wakeup_mask_enum;
            reset = 0x1;
        } wakeup_mask[6:6];

        enum PWR_CTRL0_rtc_int_mask_enum {
            NOT_MASKED = 0 { name = "Not Masked"; desc = "not masked"; };
            MASKED = 1 { name = "Masked"; desc = "masked"; };
        };

        field {
            name = "rtc_int_mask";
            desc = "RTC interrupt wakeup mask";
            sw = rw;
            hw = r;
            encode = PWR_CTRL0_rtc_int_mask_enum;
            reset = 0x1;
        } rtc_int_mask[5:5];

        enum PWR_CTRL0_wakeup_act_mode_enum {
            ACTIVE_RISING_EDGE = 0 { name = "Active Rising Edge"; desc = "active on the rising edge"; };
            ACTIVE_FALLING_EDGE = 1 { name = "Active Falling Edge"; desc = "active on the falling edge"; };
            ACTIVE_HIGH = 2 { name = "Active High"; desc = "active high"; };
            ACTIVE_LOW = 3 { name = "Active Low"; desc = "active low"; };
        };

        field {
            name = "wakeup_act_mode";
            desc = "Wakeup valid mode select";
            sw = rw;
            hw = r;
            encode = PWR_CTRL0_wakeup_act_mode_enum;
            reset = 0x0;
        } wakeup_act_mode[4:3];

        enum PWR_CTRL0_pwr_pen_enum {
            OUTPUT_0 = 0 { name = "Output 0"; desc = "output 0"; };
            OUTPUT_1 = 1 { name = "Output 1"; desc = "output 1"; };
        };

        field {
            name = "pwr_pen";
            desc = "PWR_EN_OUT output control";
            sw = rw;
            hw = r;
            encode = PWR_CTRL0_pwr_pen_enum;
            reset = 0x0;
        } pwr_pen[2:2];

        field {
            name = "pwr_off_ctrl";
            desc = "Power-off control 10: powered off Other values: reserved Note: When the logic completes the power-off operation, this bit is automatically cleared.";
            sw = w;
            hw = r;
            reset = 0x0;
        } pwr_off_ctrl[1:0];
    } PWR_CTRL0 @ 0x0;

    reg {
        name = "PWR control register 1";
        desc = "PWR_CTRL1 is PWR control register 1.

Data sheet 3.10.2.4 PWR_CTRL1 (offset 0x4, printed page 3-178, `hi3516cv300--Hi3516CV300-Hi3516EV100-Datasheet.txt` line 14740).";

        field {
            name = "pwr_td3";
            desc = "Power timing parameter 3. The unit is ms, and the minimum value is 1.";
            sw = rw;
            hw = r;
            reset = 0x10;
        } pwr_td3[31:24];

        field {
            name = "pwr_td2";
            desc = "Power timing parameter 2. The unit is ms, and the minimum value is 1.";
            sw = rw;
            hw = r;
            reset = 0x10;
        } pwr_td2[23:16];

        field {
            name = "pwr_td1";
            desc = "Power timing parameter 1. The unit is ms, and the minimum value is 1.";
            sw = rw;
            hw = r;
            reset = 0x10;
        } pwr_td1[15:8];

        field {
            name = "pwr_td0";
            desc = "Power timing parameter 0. The unit is ms, and the minimum value is 1.";
            sw = rw;
            hw = r;
            reset = 0x10;
        } pwr_td0[7:0];
    } PWR_CTRL1 @ 0x4;

    reg {
        name = "PWR status register";
        desc = "PWR_STATUS is a PWR status register.

Data sheet 3.10.2.4 PWR_STATUS (offset 0x8, printed page 3-178, `hi3516cv300--Hi3516CV300-Hi3516EV100-Datasheet.txt` line 14770).";

        field {
            name = "wakeup_in";
            desc = "Input of the PWR_WAKEUP pin";
            sw = r;
            hw = w;
            reset = 0x0;
        } wakeup_in[8:8];

        field {
            name = "button_in";
            desc = "Input of the PWR_BUTTON pin";
            sw = r;
            hw = w;
            reset = 0x0;
        } button_in[7:7];

        field {
            name = "wakeup_source";
            desc = "Wakeup source bit6: RTC bit5: PWR_BUTTON";
            sw = r;
            hw = w;
            reset = 0x0;
        } wakeup_source[6:2];
    } PWR_STATUS @ 0x8;

    reg {
        name = "PWR power-off timing control register";
        desc = "PWR_PD_SEL is a PWR power-off timing control register.

Data sheet 3.10.2.4 PWR_PD_SEL (offset 0xC, printed page 3-179, `hi3516cv300--Hi3516CV300-Hi3516EV100-Datasheet.txt` line 14813).";

        enum PWR_PD_SEL_pd_seq_mode_sel_enum {
            MODE_1_POWER = 0 { name = "Mode 1 Power"; desc = "mode 1. The power-off timing is SEQ0->SEQ1->SEQ2."; };
            MODE_2_POWER = 1 { name = "Mode 2 Power"; desc = "mode 2. The power-off timing is SEQ1->SEQ0->SEQ2."; };
            MODE_3_POWER = 2 { name = "Mode 3 Power"; desc = "mode 3. The power-off timing is SEQ2->SEQ0->SEQ1."; };
            MODE_4_POWER = 3 { name = "Mode 4 Power"; desc = "mode 4. The power-off timing is SEQ2->SEQ1->SEQ0."; };
            MODE_5_POWER = 4 { name = "Mode 5 Power"; desc = "mode 5. The power-off timing is SEQ1->SEQ2->SEQ0."; };
            MODE_6_POWER = 5 { name = "Mode 6 Power"; desc = "mode 6. The power-off timing is SEQ0->SEQ2->SEQ1. Other values: mode 1. The power-off timing is SEQ0->SEQ1->SEQ2."; };
        };

        field {
            name = "pd_seq_mode_sel";
            desc = "Power-off timing select control";
            sw = rw;
            hw = r;
            encode = PWR_PD_SEL_pd_seq_mode_sel_enum;
            reset = 0x0;
        } pd_seq_mode_sel[2:0];
    } PWR_PD_SEL @ 0xC;
};

`endif
