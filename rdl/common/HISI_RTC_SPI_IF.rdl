`ifndef HISI_RTC_SPI_IF_RDL
`define HISI_RTC_SPI_IF_RDL
regfile eHISI_RTC_SPI_IF {
    name = "RTC SPI interface";
    desc = "RTC SPI interface (SPI_CLK_DIV and SPI_RW bridge registers; the SPI-attached RTC itself is described separately). 2 registers, identical in offsets, field bit ranges, names, access types and reset values on the Hi3536D V100 (base 0x120B_0000; data sheet Issue 00B04, 2017-12-13, Tables 3-19 and 3-20, section 3.10.6, printed pages 3-154 and 3-155), the Hi3521A/Hi3520D V300 (base 0x120B_0000; data sheet Issue 00B07, 2015-12-10, Table 3-18, PDF page 672, section 3.10.6) and the Hi3516E V300 (base 0x120E_0000; data sheet Issue 00B06, 2019-05-15, Table 3-14, PDF pages 176-177, section 3.9.6); extracted programmatically from these data sheets (the Hi3536D V100 one on 2026-11-22). Only descriptive text differs between the two data sheets (spi_clk_div, see the field). Field names, bit ranges, access types and offsets are exact; the free-text descriptions were checked by sampling only. Hardware not verified.";
    reg {
        name = "SPI_CLK_DIV";
        desc = "SPI_CLK_DIV is an SPI clock divider register. (offset 0x0; total reset 0x0000003B; PROVEN: Hi3521A/Hi3520D V300 data sheet (Issue 00B07, 2015-12-10), section 3.10.6, PDF page 672; Hi3516E V300 data sheet (Issue 00B06, 2019-05-15), section 3.9.6, PDF page 176 for SPI_CLK_DIV and 177 for SPI_RW; Hi3536D V100 data sheet (Issue 00B04, 2017-12-13), section 3.10.6, printed pages 3-154 and 3-155).";
        field {
            name = "reserved";
            desc = "Reserved";
            sw = r; hw = w;
            reset = 0x0;
        } reserved_31_8[31:8];
        field {
            name = "spi_clk_div";
            desc = "SPI clock divider. Hi3521A/Hi3520D V300 data sheet: the SPI clock frequency cannot be higher than 20 MHz. The value 12 MHz is recommended. The field value ranges from 1 to 255. The value of spi_clk_div is used to define the SPI RX and RX bit rates. The formula is as follows: FSPICLK = FAPBCLK/[2 x (spi_clk_div + 1)]. FAPBCLK is the clock frequency. If the clock is 120 MHz and the expected SPI clock is 12 MHz, the configured value of spi_clk_div is calculated as follows: (120/12)/2 - 1 = 4. Hi3516E V300 data sheet (PDF page 176): clock divider of the SPI; the SPI clock frequency cannot be higher than 5 MHz and 5 MHz is recommended. Hi3536D V100 data sheet (printed page 3-154): the SPI clock frequency cannot be higher than 5 MHz, 5 MHz is recommended; periapb bus clock 50 MHz, (50/5)/2 - 1 = 4.";
            sw = rw; hw = r;
            reset = 0x3b;
        } spi_clk_div[7:0];
    } SPI_CLK_DIV @ 0x0;
    reg {
        name = "SPI_RW";
        desc = "SPI_RW is an SPI read/write register. (offset 0x4; total reset 0x00000000; PROVEN: Hi3521A/Hi3520D V300 data sheet (Issue 00B07, 2015-12-10), section 3.10.6, PDF page 672; Hi3516E V300 data sheet (Issue 00B06, 2019-05-15), section 3.9.6, PDF page 176 for SPI_CLK_DIV and 177 for SPI_RW; Hi3536D V100 data sheet (Issue 00B04, 2017-12-13), section 3.10.6, printed pages 3-154 and 3-155).";
        field {
            name = "spi_busy";
            desc = "SPI read/write status indicator
- 0: The SPI is idle, and a new read/write operation can be initiated over the SPI.
- 1: A read/write operation is being performed over the SPI, and no new operation is allowed.";
            sw = r; hw = w;
            reset = 0x0;
        } spi_busy[31:31];
        field {
            name = "reserved";
            desc = "Reserved";
            sw = r; hw = w;
            reset = 0x0;
        } reserved_30_25[30:25];
        field {
            name = "spi_start";
            desc = "SPI read/write start. Writing 1 automatically clears this field. Writing has no effect when spi_busy is 1. That is, no new SPI operation is started before the previous read/write operation is complete. If a start request is sent, hardware ignores this request.

Access type W1_PULSE in the data sheet.";
            sw = w; hw = r; singlepulse;
            reset = 0x0;
        } spi_start[24:24];
        field {
            name = "spi_rw";
            desc = "SPI operation type
- 0: write
- 1: read";
            sw = rw; hw = r;
            reset = 0x0;
        } spi_rw[23:23];
        field {
            name = "spi_add";
            desc = "SPI operation address The address range is 0-127.";
            sw = rw; hw = r;
            reset = 0x0;
        } spi_add[22:16];
        field {
            name = "spi_rdata";
            desc = "Data read from the SPI";
            sw = r; hw = w;
            reset = 0x0;
        } spi_rdata[15:8];
        field {
            name = "spi_wdata";
            desc = "Data to be written to the SPI";
            sw = rw; hw = r;
            reset = 0x0;
        } spi_wdata[7:0];
    } SPI_RW @ 0x4;
};
`endif
