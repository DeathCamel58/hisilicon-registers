`ifndef HISI_VDP_AV300_RDL
`define HISI_VDP_AV300_RDL


regfile eHISI_VDP_AV300 {
    name = "VDP (video display processor, Hi3516A V300)";
    desc = "Video display processor (VDP) of the Hi3516A V300 at 0x11440000 (64 KB, data sheet chapter 9.2; interrupts VDP_INT0 = 90 and VDP_INT1 = 91 in the data sheet interrupt table). Video layers V0.., graphics G0.., HIPP colour-space blocks, display channels and BT/LCD interface registers. The data sheet of this chip is Chinese-only: this block transcribes register offsets, names, bit ranges, access types and reset values from the data sheet register tables; the Chinese description text and value encodings were NOT translated, so every description here is generated from the register or field name. Generated 2026-11-15 by scripts/rdl-extract/gen_m_cells.py from the data sheet register tables (ds_extract2 + description extraction from the PDF); PROVENANCE: PROVEN = offsets, names, bit fields, access and reset values from the data sheet tables; nothing here is hardware verified.

    Register sources: 120 registers from the data sheet (hi3516av300--Hi3516AV300-Datasheet.txt, section 9.2.6). ";

    reg {
        name = "VOCTRL";
        desc = "Data sheet 9.2.6 VOCTRL (offset 0x0, printed page 9-69, `hi3516av300--Hi3516AV300-Datasheet.txt` line 37743).";

        field {
            name = "vo_ck_gt_en";
            desc = "Vo ck gt enable. Chinese-only data sheet: description and value encoding not translated.";
            sw = rw;
            hw = r;
            reset = 0x0;
        } vo_ck_gt_en[31:31];
    } VOCTRL @ 0x0;

    reg {
        name = "VOINTSTA";
        desc = "Data sheet 9.2.6 VOINTSTA (offset 0x4, printed page 9-69, `hi3516av300--Hi3516AV300-Datasheet.txt` line 37768).";

        field {
            name = "dhd0uf_int";
            desc = "Dhd0uf interrupt. Chinese-only data sheet: description and value encoding not translated.";
            sw = r;
            hw = w;
            reset = 0x0;
        } dhd0uf_int[3:3];

        field {
            name = "dhd0vtthd1_int";
            desc = "Dhd0vtthd1 interrupt. Chinese-only data sheet: description and value encoding not translated.";
            sw = r;
            hw = w;
            reset = 0x0;
        } dhd0vtthd1_int[0:0];
    } VOINTSTA @ 0x4;

    reg {
        name = "VOMSKINTSTA";
        desc = "Data sheet 9.2.6 VOMSKINTSTA (offset 0x8, printed page 9-70, `hi3516av300--Hi3516AV300-Datasheet.txt` line 37802).";

        field {
            name = "dhd0uf_clr";
            desc = "Dhd0uf clear. Chinese-only data sheet: description and value encoding not translated.";
            sw = rw;
            hw = w;
            onwrite = woclr;
            reset = 0x0;
        } dhd0uf_clr[3:3];

        field {
            name = "dhd0vtthd1_clr";
            desc = "Dhd0vtthd1 clear. Chinese-only data sheet: description and value encoding not translated.";
            sw = rw;
            hw = w;
            onwrite = woclr;
            reset = 0x0;
        } dhd0vtthd1_clr[0:0];
    } VOMSKINTSTA @ 0x8;

    reg {
        name = "VOINTMSK";
        desc = "Data sheet 9.2.6 VOINTMSK (offset 0xC, printed page 9-70, `hi3516av300--Hi3516AV300-Datasheet.txt` line 37838).";

        field {
            name = "dhd0uf_intmask";
            desc = "Dhd0uf intmask. Chinese-only data sheet: description and value encoding not translated.";
            sw = rw;
            hw = r;
            reset = 0x0;
        } dhd0uf_intmask[3:3];

        field {
            name = "dhd0vtthd1_intmask";
            desc = "Dhd0vtthd1 intmask. Chinese-only data sheet: description and value encoding not translated.";
            sw = rw;
            hw = r;
            reset = 0x0;
        } dhd0vtthd1_intmask[0:0];
    } VOINTMSK @ 0xC;

    reg {
        name = "VOINTSTA1";
        desc = "Data sheet 9.2.6 VOINTSTA1 (offset 0x14, printed page 9-71, `hi3516av300--Hi3516AV300-Datasheet.txt` line 37871).";

        field {
            name = "dhd0uf_int";
            desc = "Dhd0uf interrupt. Chinese-only data sheet: description and value encoding not translated.";
            sw = r;
            hw = w;
            reset = 0x0;
        } dhd0uf_int[3:3];

        field {
            name = "dhd0vtthd1_int";
            desc = "Dhd0vtthd1 interrupt. Chinese-only data sheet: description and value encoding not translated.";
            sw = r;
            hw = w;
            reset = 0x0;
        } dhd0vtthd1_int[0:0];
    } VOINTSTA1 @ 0x14;

    reg {
        name = "VOMSKINTSTA1";
        desc = "Data sheet 9.2.6 VOMSKINTSTA1 (offset 0x18, printed page 9-71, `hi3516av300--Hi3516AV300-Datasheet.txt` line 37904).";

        field {
            name = "dhd0uf_clr";
            desc = "Dhd0uf clear. Chinese-only data sheet: description and value encoding not translated.";
            sw = rw;
            hw = w;
            onwrite = woclr;
            reset = 0x0;
        } dhd0uf_clr[3:3];

        field {
            name = "dhd0vtthd1_clr";
            desc = "Dhd0vtthd1 clear. Chinese-only data sheet: description and value encoding not translated.";
            sw = rw;
            hw = w;
            onwrite = woclr;
            reset = 0x0;
        } dhd0vtthd1_clr[0:0];
    } VOMSKINTSTA1 @ 0x18;

    reg {
        name = "VOINTMSK1";
        desc = "Data sheet 9.2.6 VOINTMSK1 (offset 0x1C, printed page 9-72, `hi3516av300--Hi3516AV300-Datasheet.txt` line 37938).";

        field {
            name = "dhd0uf_intmask";
            desc = "Dhd0uf intmask. Chinese-only data sheet: description and value encoding not translated.";
            sw = rw;
            hw = r;
            reset = 0x0;
        } dhd0uf_intmask[3:3];

        field {
            name = "dhd0vtthd1_intmask";
            desc = "Dhd0vtthd1 intmask. Chinese-only data sheet: description and value encoding not translated.";
            sw = rw;
            hw = r;
            reset = 0x0;
        } dhd0vtthd1_intmask[0:0];
    } VOINTMSK1 @ 0x1C;

    reg {
        name = "CBM_BKG1";
        desc = "Data sheet 9.2.6 CBM_BKG1 (offset 0x300, printed page 9-72, `hi3516av300--Hi3516AV300-Datasheet.txt` line 37970).";

        field {
            name = "cbm_bkgy1";
            desc = "Cbm bkgy1. Chinese-only data sheet: description and value encoding not translated.";
            sw = rw;
            hw = r;
            reset = 0x0;
        } cbm_bkgy1[29:20];

        field {
            name = "cbm_bkgcb1";
            desc = "Cbm bkgcb1. Chinese-only data sheet: description and value encoding not translated.";
            sw = rw;
            hw = r;
            reset = 0x0;
        } cbm_bkgcb1[19:10];

        field {
            name = "cbm_bkgcr1";
            desc = "Cbm bkgcr1. Chinese-only data sheet: description and value encoding not translated.";
            sw = rw;
            hw = r;
            reset = 0x0;
        } cbm_bkgcr1[9:0];
    } CBM_BKG1 @ 0x300;

    reg {
        name = "CBM_MIX1";
        desc = "Data sheet 9.2.6 CBM_MIX1 (offset 0x308, printed page 9-73, `hi3516av300--Hi3516AV300-Datasheet.txt` line 37994).";

        field {
            name = "mixer_prio1";
            desc = "Mixer prio1. Chinese-only data sheet: description and value encoding not translated.";
            sw = rw;
            hw = r;
            reset = 0x0;
        } mixer_prio1[7:4];

        field {
            name = "mixer_prio0";
            desc = "Mixer prio0. Chinese-only data sheet: description and value encoding not translated.";
            sw = rw;
            hw = r;
            reset = 0x1;
        } mixer_prio0[3:0];
    } CBM_MIX1 @ 0x308;

    reg {
        name = "V0_CTRL";
        desc = "Data sheet 9.2.6 V0_CTRL (offset 0x1000, printed page 9-73, `hi3516av300--Hi3516AV300-Datasheet.txt` line 38031).";

        field {
            name = "surface_en";
            desc = "Surface enable. Chinese-only data sheet: description and value encoding not translated.";
            sw = rw;
            hw = r;
            reset = 0x0;
        } surface_en[31:31];

        field {
            name = "galpha";
            desc = "Galpha. Chinese-only data sheet: description and value encoding not translated.";
            sw = rw;
            hw = r;
            reset = 0xFF;
        } galpha[7:0];
    } V0_CTRL @ 0x1000;

    reg {
        name = "V0_UPD";
        desc = "Data sheet 9.2.6 V0_UPD (offset 0x1004, printed page 9-74, `hi3516av300--Hi3516AV300-Datasheet.txt` line 38065).";

        field {
            name = "regup";
            desc = "Regup. Chinese-only data sheet: description and value encoding not translated.";
            sw = rw;
            hw = w;
            onwrite = woclr;
            reset = 0x0;
        } regup[0:0];
    } V0_UPD @ 0x1004;

    reg {
        name = "V0_0RESO_READ";
        desc = "Data sheet 9.2.6 V0_0RESO_READ (offset 0x1008, printed page 9-74, `hi3516av300--Hi3516AV300-Datasheet.txt` line 38080).";

        field {
            name = "oh";
            desc = "Oh. Chinese-only data sheet: description and value encoding not translated.";
            sw = r;
            hw = w;
            reset = 0x0;
        } oh[31:16];

        field {
            name = "ow";
            desc = "Ow. Chinese-only data sheet: description and value encoding not translated.";
            sw = r;
            hw = w;
            reset = 0x0;
        } ow[15:0];
    } V0_0RESO_READ @ 0x1008;

    reg {
        name = "V0_DFPOS";
        desc = "Data sheet 9.2.6 V0_DFPOS (offset 0x1080, printed page 9-74, `hi3516av300--Hi3516AV300-Datasheet.txt` line 38105).";

        field {
            name = "disp_yfpos";
            desc = "Disp yfpos. Chinese-only data sheet: description and value encoding not translated.";
            sw = rw;
            hw = r;
            reset = 0x0;
        } disp_yfpos[31:16];

        field {
            name = "disp_xfpos";
            desc = "Disp xfpos. Chinese-only data sheet: description and value encoding not translated.";
            sw = rw;
            hw = r;
            reset = 0x0;
        } disp_xfpos[15:0];
    } V0_DFPOS @ 0x1080;

    reg {
        name = "V0_DLPOS";
        desc = "Data sheet 9.2.6 V0_DLPOS (offset 0x1084, printed page 9-74, `hi3516av300--Hi3516AV300-Datasheet.txt` line 38127).";

        field {
            name = "disp_ylpos";
            desc = "Disp ylpos. Chinese-only data sheet: description and value encoding not translated.";
            sw = rw;
            hw = r;
            reset = 0x0;
        } disp_ylpos[31:16];

        field {
            name = "disp_xlpos";
            desc = "Disp xlpos. Chinese-only data sheet: description and value encoding not translated.";
            sw = rw;
            hw = r;
            reset = 0x0;
        } disp_xlpos[15:0];
    } V0_DLPOS @ 0x1084;

    reg {
        name = "V0_VFPOS";
        desc = "Data sheet 9.2.6 V0_VFPOS (offset 0x1088, printed page 9-75, `hi3516av300--Hi3516AV300-Datasheet.txt` line 38152).";

        field {
            name = "video_yfpos";
            desc = "Video yfpos. Chinese-only data sheet: description and value encoding not translated.";
            sw = rw;
            hw = r;
            reset = 0x0;
        } video_yfpos[31:16];

        field {
            name = "video_xfpos";
            desc = "Video xfpos. Chinese-only data sheet: description and value encoding not translated.";
            sw = rw;
            hw = r;
            reset = 0x0;
        } video_xfpos[15:0];
    } V0_VFPOS @ 0x1088;

    reg {
        name = "V0_VLPOS";
        desc = "Data sheet 9.2.6 V0_VLPOS (offset 0x108C, printed page 9-75, `hi3516av300--Hi3516AV300-Datasheet.txt` line 38175).";

        field {
            name = "video_ylpos";
            desc = "Video ylpos. Chinese-only data sheet: description and value encoding not translated.";
            sw = rw;
            hw = r;
            reset = 0x0;
        } video_ylpos[31:16];

        field {
            name = "video_xlpos";
            desc = "Video xlpos. Chinese-only data sheet: description and value encoding not translated.";
            sw = rw;
            hw = r;
            reset = 0x0;
        } video_xlpos[15:0];
    } V0_VLPOS @ 0x108C;

    reg {
        name = "V0_BK";
        desc = "Data sheet 9.2.6 V0_BK (offset 0x1090, printed page 9-75, `hi3516av300--Hi3516AV300-Datasheet.txt` line 38200).";

        field {
            name = "vbk_y";
            desc = "Vbk y. Chinese-only data sheet: description and value encoding not translated.";
            sw = rw;
            hw = r;
            reset = 0x0;
        } vbk_y[29:20];

        field {
            name = "vbk_cb";
            desc = "Vbk cb. Chinese-only data sheet: description and value encoding not translated.";
            sw = rw;
            hw = r;
            reset = 0x0;
        } vbk_cb[19:10];

        field {
            name = "vbk_cr";
            desc = "Vbk cr. Chinese-only data sheet: description and value encoding not translated.";
            sw = rw;
            hw = r;
            reset = 0x0;
        } vbk_cr[9:0];
    } V0_BK @ 0x1090;

    reg {
        name = "V0_ALPHA";
        desc = "Data sheet 9.2.6 V0_ALPHA (offset 0x1094, printed page 9-76, `hi3516av300--Hi3516AV300-Datasheet.txt` line 38225).";

        field {
            name = "vbk_alpha";
            desc = "Vbk alpha. Chinese-only data sheet: description and value encoding not translated.";
            sw = rw;
            hw = r;
            reset = 0x0;
        } vbk_alpha[7:0];
    } V0_ALPHA @ 0x1094;

    reg {
        name = "V0_HIPP_CSC_CTRL";
        desc = "Data sheet 9.2.6 V0_HIPP_CSC_CTRL (offset 0x1200, printed page 9-76, `hi3516av300--Hi3516AV300-Datasheet.txt` line 38241).";

        field {
            name = "hipp_csc_en";
            desc = "Hipp colour-space conversion enable. Chinese-only data sheet: description and value encoding not translated.";
            sw = rw;
            hw = r;
            reset = 0x0;
        } hipp_csc_en[0:0];
    } V0_HIPP_CSC_CTRL @ 0x1200;

    reg {
        name = "V0_HIPP_CSC_COEF00";
        desc = "Data sheet 9.2.6 V0_HIPP_CSC_COEF00 (offset 0x1204, printed page 9-76, `hi3516av300--Hi3516AV300-Datasheet.txt` line 38264).";

        field {
            name = "hipp_csc_coef00";
            desc = "Hipp colour-space conversion coef00. Chinese-only data sheet: description and value encoding not translated.";
            sw = rw;
            hw = r;
            reset = 0x0;
        } hipp_csc_coef00[15:0];
    } V0_HIPP_CSC_COEF00 @ 0x1204;

    reg {
        name = "V0_HIPP_CSC_COEF01";
        desc = "Data sheet 9.2.6 V0_HIPP_CSC_COEF01 (offset 0x1208, printed page 9-77, `hi3516av300--Hi3516AV300-Datasheet.txt` line 38287).";

        field {
            name = "hipp_csc_coef01";
            desc = "Hipp colour-space conversion coef01. Chinese-only data sheet: description and value encoding not translated.";
            sw = rw;
            hw = r;
            reset = 0x0;
        } hipp_csc_coef01[15:0];
    } V0_HIPP_CSC_COEF01 @ 0x1208;

    reg {
        name = "V0_HIPP_CSC_COEF02";
        desc = "Data sheet 9.2.6 V0_HIPP_CSC_COEF02 (offset 0x120C, printed page 9-77, `hi3516av300--Hi3516AV300-Datasheet.txt` line 38305).";

        field {
            name = "hipp_csc_coef02";
            desc = "Hipp colour-space conversion coef02. Chinese-only data sheet: description and value encoding not translated.";
            sw = rw;
            hw = r;
            reset = 0x0;
        } hipp_csc_coef02[15:0];
    } V0_HIPP_CSC_COEF02 @ 0x120C;

    reg {
        name = "V0_HIPP_CSC_COEF10";
        desc = "Data sheet 9.2.6 V0_HIPP_CSC_COEF10 (offset 0x1210, printed page 9-77, `hi3516av300--Hi3516AV300-Datasheet.txt` line 38328).";

        field {
            name = "hipp_csc_coef10";
            desc = "Hipp colour-space conversion coef10. Chinese-only data sheet: description and value encoding not translated.";
            sw = rw;
            hw = r;
            reset = 0x0;
        } hipp_csc_coef10[15:0];
    } V0_HIPP_CSC_COEF10 @ 0x1210;

    reg {
        name = "V0_HIPP_CSC_COEF11";
        desc = "Data sheet 9.2.6 V0_HIPP_CSC_COEF11 (offset 0x1214, printed page 9-78, `hi3516av300--Hi3516AV300-Datasheet.txt` line 38349).";

        field {
            name = "hipp_csc_coef11";
            desc = "Hipp colour-space conversion coef11. Chinese-only data sheet: description and value encoding not translated.";
            sw = rw;
            hw = r;
            reset = 0x0;
        } hipp_csc_coef11[15:0];
    } V0_HIPP_CSC_COEF11 @ 0x1214;

    reg {
        name = "V0_HIPP_CSC_COEF12";
        desc = "Data sheet 9.2.6 V0_HIPP_CSC_COEF12 (offset 0x1218, printed page 9-78, `hi3516av300--Hi3516AV300-Datasheet.txt` line 38364).";

        field {
            name = "hipp_csc_coef12";
            desc = "Hipp colour-space conversion coef12. Chinese-only data sheet: description and value encoding not translated.";
            sw = rw;
            hw = r;
            reset = 0x0;
        } hipp_csc_coef12[15:0];
    } V0_HIPP_CSC_COEF12 @ 0x1218;

    reg {
        name = "V0_HIPP_CSC_COEF20";
        desc = "Data sheet 9.2.6 V0_HIPP_CSC_COEF20 (offset 0x121C, printed page 9-78, `hi3516av300--Hi3516AV300-Datasheet.txt` line 38389).";

        field {
            name = "hipp_csc_coef20";
            desc = "Hipp colour-space conversion coef20. Chinese-only data sheet: description and value encoding not translated.";
            sw = rw;
            hw = r;
            reset = 0x0;
        } hipp_csc_coef20[15:0];
    } V0_HIPP_CSC_COEF20 @ 0x121C;

    reg {
        name = "V0_HIPP_CSC_COEF21";
        desc = "Data sheet 9.2.6 V0_HIPP_CSC_COEF21 (offset 0x1220, printed page 9-79, `hi3516av300--Hi3516AV300-Datasheet.txt` line 38412).";

        field {
            name = "hipp_csc_coef21";
            desc = "Hipp colour-space conversion coef21. Chinese-only data sheet: description and value encoding not translated.";
            sw = rw;
            hw = r;
            reset = 0x0;
        } hipp_csc_coef21[15:0];
    } V0_HIPP_CSC_COEF21 @ 0x1220;

    reg {
        name = "V0_HIPP_CSC_COEF22";
        desc = "Data sheet 9.2.6 V0_HIPP_CSC_COEF22 (offset 0x1224, printed page 9-79, `hi3516av300--Hi3516AV300-Datasheet.txt` line 38427).";

        field {
            name = "hipp_csc_coef22";
            desc = "Hipp colour-space conversion coef22. Chinese-only data sheet: description and value encoding not translated.";
            sw = rw;
            hw = r;
            reset = 0x0;
        } hipp_csc_coef22[15:0];
    } V0_HIPP_CSC_COEF22 @ 0x1224;

    reg {
        name = "V0_HIPP_CSC_SCALE";
        desc = "Data sheet 9.2.6 V0_HIPP_CSC_SCALE (offset 0x1228, printed page 9-79, `hi3516av300--Hi3516AV300-Datasheet.txt` line 38451).";

        field {
            name = "hipp_csc_scale";
            desc = "Hipp colour-space conversion scale. Chinese-only data sheet: description and value encoding not translated.";
            sw = rw;
            hw = r;
            reset = 0x0;
        } hipp_csc_scale[3:0];
    } V0_HIPP_CSC_SCALE @ 0x1228;

    reg {
        name = "V0_HIPP_CSC_IDC0";
        desc = "Data sheet 9.2.6 V0_HIPP_CSC_IDC0 (offset 0x122C, printed page 9-79, `hi3516av300--Hi3516AV300-Datasheet.txt` line 38471).";

        field {
            name = "hipp_csc_idc0";
            desc = "Hipp colour-space conversion idc0. Chinese-only data sheet: description and value encoding not translated.";
            sw = rw;
            hw = r;
            reset = 0x0;
        } hipp_csc_idc0[10:0];
    } V0_HIPP_CSC_IDC0 @ 0x122C;

    reg {
        name = "V0_HIPP_CSC_IDC1";
        desc = "Data sheet 9.2.6 V0_HIPP_CSC_IDC1 (offset 0x1230, printed page 9-80, `hi3516av300--Hi3516AV300-Datasheet.txt` line 38494).";

        field {
            name = "hipp_csc_idc1";
            desc = "Hipp colour-space conversion idc1. Chinese-only data sheet: description and value encoding not translated.";
            sw = rw;
            hw = r;
            reset = 0x0;
        } hipp_csc_idc1[10:0];
    } V0_HIPP_CSC_IDC1 @ 0x1230;

    reg {
        name = "V0_HIPP_CSC_IDC2";
        desc = "Data sheet 9.2.6 V0_HIPP_CSC_IDC2 (offset 0x1234, printed page 9-80, `hi3516av300--Hi3516AV300-Datasheet.txt` line 38510).";

        field {
            name = "hipp_csc_idc2";
            desc = "Hipp colour-space conversion idc2. Chinese-only data sheet: description and value encoding not translated.";
            sw = rw;
            hw = r;
            reset = 0x0;
        } hipp_csc_idc2[10:0];
    } V0_HIPP_CSC_IDC2 @ 0x1234;

    reg {
        name = "V0_HIPP_CSC_ODC0";
        desc = "Data sheet 9.2.6 V0_HIPP_CSC_ODC0 (offset 0x1238, printed page 9-80, `hi3516av300--Hi3516AV300-Datasheet.txt` line 38531).";

        field {
            name = "hipp_csc_odc0";
            desc = "Hipp colour-space conversion odc0. Chinese-only data sheet: description and value encoding not translated.";
            sw = rw;
            hw = r;
            reset = 0x0;
        } hipp_csc_odc0[10:0];
    } V0_HIPP_CSC_ODC0 @ 0x1238;

    reg {
        name = "V0_HIPP_CSC_ODC1";
        desc = "Data sheet 9.2.6 V0_HIPP_CSC_ODC1 (offset 0x123C, printed page 9-81, `hi3516av300--Hi3516AV300-Datasheet.txt` line 38550).";

        field {
            name = "hipp_csc_odc1";
            desc = "Hipp colour-space conversion odc1. Chinese-only data sheet: description and value encoding not translated.";
            sw = rw;
            hw = r;
            reset = 0x0;
        } hipp_csc_odc1[10:0];
    } V0_HIPP_CSC_ODC1 @ 0x123C;

    reg {
        name = "V0_HIPP_CSC_ODC2";
        desc = "Data sheet 9.2.6 V0_HIPP_CSC_ODC2 (offset 0x1240, printed page 9-81, `hi3516av300--Hi3516AV300-Datasheet.txt` line 38565).";

        field {
            name = "hipp_csc_odc2";
            desc = "Hipp colour-space conversion odc2. Chinese-only data sheet: description and value encoding not translated.";
            sw = rw;
            hw = r;
            reset = 0x0;
        } hipp_csc_odc2[10:0];
    } V0_HIPP_CSC_ODC2 @ 0x1240;

    reg {
        name = "V0_HIPP_CSC_MIN_Y";
        desc = "Data sheet 9.2.6 V0_HIPP_CSC_MIN_Y (offset 0x1244, printed page 9-81, `hi3516av300--Hi3516AV300-Datasheet.txt` line 38586).";

        field {
            name = "hipp_csc_min_y";
            desc = "Hipp colour-space conversion min y. Chinese-only data sheet: description and value encoding not translated.";
            sw = rw;
            hw = r;
            reset = 0x0;
        } hipp_csc_min_y[9:0];
    } V0_HIPP_CSC_MIN_Y @ 0x1244;

    reg {
        name = "V0_HIPP_CSC_MIN_C";
        desc = "Data sheet 9.2.6 V0_HIPP_CSC_MIN_C (offset 0x1248, printed page 9-81, `hi3516av300--Hi3516AV300-Datasheet.txt` line 38609).";

        field {
            name = "hipp_csc_min_c";
            desc = "Hipp colour-space conversion min c. Chinese-only data sheet: description and value encoding not translated.";
            sw = rw;
            hw = r;
            reset = 0x0;
        } hipp_csc_min_c[9:0];
    } V0_HIPP_CSC_MIN_C @ 0x1248;

    reg {
        name = "V0_HIPP_CSC_MAX_Y";
        desc = "Data sheet 9.2.6 V0_HIPP_CSC_MAX_Y (offset 0x124C, printed page 9-82, `hi3516av300--Hi3516AV300-Datasheet.txt` line 38632).";

        field {
            name = "hipp_csc_max_y";
            desc = "Hipp colour-space conversion max y. Chinese-only data sheet: description and value encoding not translated.";
            sw = rw;
            hw = r;
            reset = 0x0;
        } hipp_csc_max_y[9:0];
    } V0_HIPP_CSC_MAX_Y @ 0x124C;

    reg {
        name = "V0_HIPP_CSC_MAX_C";
        desc = "Data sheet 9.2.6 V0_HIPP_CSC_MAX_C (offset 0x1250, printed page 9-82, `hi3516av300--Hi3516AV300-Datasheet.txt` line 38648).";

        field {
            name = "hipp_csc_max_c";
            desc = "Hipp colour-space conversion max c. Chinese-only data sheet: description and value encoding not translated.";
            sw = rw;
            hw = r;
            reset = 0x0;
        } hipp_csc_max_c[9:0];
    } V0_HIPP_CSC_MAX_C @ 0x1250;

    reg {
        name = "V0_CVFIR_VINFO";
        desc = "Data sheet 9.2.6 V0_CVFIR_VINFO (offset 0x1400, printed page 9-82, `hi3516av300--Hi3516AV300-Datasheet.txt` line 38671).";

        field {
            name = "out_pro";
            desc = "Out pro. Chinese-only data sheet: description and value encoding not translated.";
            sw = rw;
            hw = r;
            reset = 0x0;
        } out_pro[18:18];

        field {
            name = "out_fmt";
            desc = "Out format. Chinese-only data sheet: description and value encoding not translated.";
            sw = rw;
            hw = r;
            reset = 0x0;
        } out_fmt[17:16];

        field {
            name = "out_height";
            desc = "Out height. Chinese-only data sheet: description and value encoding not translated.";
            sw = rw;
            hw = r;
            reset = 0x0;
        } out_height[15:0];
    } V0_CVFIR_VINFO @ 0x1400;

    reg {
        name = "V0_CVFIR_VSP";
        desc = "Data sheet 9.2.6 V0_CVFIR_VSP (offset 0x1404, printed page 9-83, `hi3516av300--Hi3516AV300-Datasheet.txt` line 38705).";

        field {
            name = "cvfir_en";
            desc = "Cvfir enable. Chinese-only data sheet: description and value encoding not translated.";
            sw = rw;
            hw = r;
            reset = 0x0;
        } cvfir_en[30:30];

        field {
            name = "cvmid_en";
            desc = "Cvmid enable. Chinese-only data sheet: description and value encoding not translated.";
            sw = rw;
            hw = r;
            reset = 0x0;
        } cvmid_en[28:28];

        field {
            name = "cvfir_mode";
            desc = "Cvfir mode. Chinese-only data sheet: description and value encoding not translated.";
            sw = rw;
            hw = r;
            reset = 0x0;
        } cvfir_mode[25:25];
    } V0_CVFIR_VSP @ 0x1404;

    reg {
        name = "V0_HFIR_CTRL";
        desc = "Data sheet 9.2.6 V0_HFIR_CTRL (offset 0x1500, printed page 9-83, `hi3516av300--Hi3516AV300-Datasheet.txt` line 38753).";

        field {
            name = "hfir_mode";
            desc = "Hfir mode. Chinese-only data sheet: description and value encoding not translated.";
            sw = rw;
            hw = r;
            reset = 0x0;
        } hfir_mode[2:1];
    } V0_HFIR_CTRL @ 0x1500;

    reg {
        name = "V0_HFIRCOEF01";
        desc = "Data sheet 9.2.6 V0_HFIRCOEF01 (offset 0x1504, printed page 9-84, `hi3516av300--Hi3516AV300-Datasheet.txt` line 38779).";

        field {
            name = "coef1";
            desc = "Coef1. Chinese-only data sheet: description and value encoding not translated.";
            sw = rw;
            hw = r;
            reset = 0x0;
        } coef1[25:16];

        field {
            name = "coef0";
            desc = "Coef0. Chinese-only data sheet: description and value encoding not translated.";
            sw = rw;
            hw = r;
            reset = 0x0;
        } coef0[9:0];
    } V0_HFIRCOEF01 @ 0x1504;

    reg {
        name = "V0_HFIRCOEF23";
        desc = "Data sheet 9.2.6 V0_HFIRCOEF23 (offset 0x1508, printed page 9-84, `hi3516av300--Hi3516AV300-Datasheet.txt` line 38804).";

        field {
            name = "coef3";
            desc = "Coef3. Chinese-only data sheet: description and value encoding not translated.";
            sw = rw;
            hw = r;
            reset = 0x0;
        } coef3[25:16];

        field {
            name = "coef2";
            desc = "Coef2. Chinese-only data sheet: description and value encoding not translated.";
            sw = rw;
            hw = r;
            reset = 0x0;
        } coef2[9:0];
    } V0_HFIRCOEF23 @ 0x1508;

    reg {
        name = "V0_HFIRCOEF45";
        desc = "Data sheet 9.2.6 V0_HFIRCOEF45 (offset 0x150C, printed page 9-84, `hi3516av300--Hi3516AV300-Datasheet.txt` line 38826).";

        field {
            name = "coef5";
            desc = "Coef5. Chinese-only data sheet: description and value encoding not translated.";
            sw = rw;
            hw = r;
            reset = 0x0;
        } coef5[25:16];

        field {
            name = "coef4";
            desc = "Coef4. Chinese-only data sheet: description and value encoding not translated.";
            sw = rw;
            hw = r;
            reset = 0x0;
        } coef4[9:0];
    } V0_HFIRCOEF45 @ 0x150C;

    reg {
        name = "V0_HFIRCOEF67";
        desc = "Data sheet 9.2.6 V0_HFIRCOEF67 (offset 0x1510, printed page 9-85, `hi3516av300--Hi3516AV300-Datasheet.txt` line 38851).";

        field {
            name = "coef7";
            desc = "Coef7. Chinese-only data sheet: description and value encoding not translated.";
            sw = rw;
            hw = r;
            reset = 0x0;
        } coef7[25:16];

        field {
            name = "coef6";
            desc = "Coef6. Chinese-only data sheet: description and value encoding not translated.";
            sw = rw;
            hw = r;
            reset = 0x0;
        } coef6[9:0];
    } V0_HFIRCOEF67 @ 0x1510;

    reg {
        name = "G0_CTRL";
        desc = "Data sheet 9.2.6 G0_CTRL (offset 0x7000, printed page 9-85, `hi3516av300--Hi3516AV300-Datasheet.txt` line 38873).";

        field {
            name = "surface_en";
            desc = "Surface enable. Chinese-only data sheet: description and value encoding not translated.";
            sw = rw;
            hw = r;
            reset = 0x0;
        } surface_en[31:31];

        field {
            name = "galpha";
            desc = "Galpha. Chinese-only data sheet: description and value encoding not translated.";
            sw = rw;
            hw = r;
            reset = 0xFF;
        } galpha[7:0];
    } G0_CTRL @ 0x7000;

    reg {
        name = "G0_UPD";
        desc = "Data sheet 9.2.6 G0_UPD (offset 0x7004, printed page 9-86, `hi3516av300--Hi3516AV300-Datasheet.txt` line 38907).";

        field {
            name = "regup";
            desc = "Regup. Chinese-only data sheet: description and value encoding not translated.";
            sw = rw;
            hw = w;
            onwrite = woclr;
            reset = 0x0;
        } regup[0:0];
    } G0_UPD @ 0x7004;

    reg {
        name = "G0_0RESO_READ";
        desc = "Data sheet 9.2.6 G0_0RESO_READ (offset 0x700C, printed page 9-86, `hi3516av300--Hi3516AV300-Datasheet.txt` line 38922).";

        field {
            name = "oh";
            desc = "Oh. Chinese-only data sheet: description and value encoding not translated.";
            sw = r;
            hw = w;
            reset = 0x0;
        } oh[31:16];

        field {
            name = "ow";
            desc = "Ow. Chinese-only data sheet: description and value encoding not translated.";
            sw = r;
            hw = w;
            reset = 0x77F;
        } ow[15:0];
    } G0_0RESO_READ @ 0x700C;

    reg {
        name = "G0_DFPOS";
        desc = "Data sheet 9.2.6 G0_DFPOS (offset 0x7080, printed page 9-86, `hi3516av300--Hi3516AV300-Datasheet.txt` line 38947).";

        field {
            name = "disp_yfpos";
            desc = "Disp yfpos. Chinese-only data sheet: description and value encoding not translated.";
            sw = rw;
            hw = r;
            reset = 0x0;
        } disp_yfpos[31:16];

        field {
            name = "disp_xfpos";
            desc = "Disp xfpos. Chinese-only data sheet: description and value encoding not translated.";
            sw = rw;
            hw = r;
            reset = 0x0;
        } disp_xfpos[15:0];
    } G0_DFPOS @ 0x7080;

    reg {
        name = "G0_DLPOS";
        desc = "Data sheet 9.2.6 G0_DLPOS (offset 0x7084, printed page 9-86, `hi3516av300--Hi3516AV300-Datasheet.txt` line 38969).";

        field {
            name = "disp_ylpos";
            desc = "Disp ylpos. Chinese-only data sheet: description and value encoding not translated.";
            sw = rw;
            hw = r;
            reset = 0x0;
        } disp_ylpos[31:16];

        field {
            name = "disp_xlpos";
            desc = "Disp xlpos. Chinese-only data sheet: description and value encoding not translated.";
            sw = rw;
            hw = r;
            reset = 0x0;
        } disp_xlpos[15:0];
    } G0_DLPOS @ 0x7084;

    reg {
        name = "G0_VFPOS";
        desc = "Data sheet 9.2.6 G0_VFPOS (offset 0x7088, printed page 9-87, `hi3516av300--Hi3516AV300-Datasheet.txt` line 38994).";

        field {
            name = "video_yfpos";
            desc = "Video yfpos. Chinese-only data sheet: description and value encoding not translated.";
            sw = rw;
            hw = r;
            reset = 0x0;
        } video_yfpos[31:16];

        field {
            name = "video_xfpos";
            desc = "Video xfpos. Chinese-only data sheet: description and value encoding not translated.";
            sw = rw;
            hw = r;
            reset = 0x0;
        } video_xfpos[15:0];
    } G0_VFPOS @ 0x7088;

    reg {
        name = "G0_VLPOS";
        desc = "Data sheet 9.2.6 G0_VLPOS (offset 0x708C, printed page 9-87, `hi3516av300--Hi3516AV300-Datasheet.txt` line 39017).";

        field {
            name = "video_ylpos";
            desc = "Video ylpos. Chinese-only data sheet: description and value encoding not translated.";
            sw = rw;
            hw = r;
            reset = 0x0;
        } video_ylpos[31:16];

        field {
            name = "video_xlpos";
            desc = "Video xlpos. Chinese-only data sheet: description and value encoding not translated.";
            sw = rw;
            hw = r;
            reset = 0x0;
        } video_xlpos[15:0];
    } G0_VLPOS @ 0x708C;

    reg {
        name = "G0_BK";
        desc = "Data sheet 9.2.6 G0_BK (offset 0x7090, printed page 9-87, `hi3516av300--Hi3516AV300-Datasheet.txt` line 39042).";

        field {
            name = "vbk_y";
            desc = "Vbk y. Chinese-only data sheet: description and value encoding not translated.";
            sw = rw;
            hw = r;
            reset = 0x0;
        } vbk_y[29:20];

        field {
            name = "vbk_cb";
            desc = "Vbk cb. Chinese-only data sheet: description and value encoding not translated.";
            sw = rw;
            hw = r;
            reset = 0x0;
        } vbk_cb[19:10];

        field {
            name = "vbk_cr";
            desc = "Vbk cr. Chinese-only data sheet: description and value encoding not translated.";
            sw = rw;
            hw = r;
            reset = 0x0;
        } vbk_cr[9:0];
    } G0_BK @ 0x7090;

    reg {
        name = "G0_ALPHA";
        desc = "Data sheet 9.2.6 G0_ALPHA (offset 0x7094, printed page 9-88, `hi3516av300--Hi3516AV300-Datasheet.txt` line 39067).";

        field {
            name = "vbk_alpha";
            desc = "Vbk alpha. Chinese-only data sheet: description and value encoding not translated.";
            sw = rw;
            hw = r;
            reset = 0x0;
        } vbk_alpha[7:0];
    } G0_ALPHA @ 0x7094;

    reg {
        name = "G0_HIPP_CSC_CTRL";
        desc = "Data sheet 9.2.6 G0_HIPP_CSC_CTRL (offset 0x7100, printed page 9-88, `hi3516av300--Hi3516AV300-Datasheet.txt` line 39083).";

        field {
            name = "hipp_csc_en";
            desc = "Hipp colour-space conversion enable. Chinese-only data sheet: description and value encoding not translated.";
            sw = rw;
            hw = r;
            reset = 0x0;
        } hipp_csc_en[0:0];
    } G0_HIPP_CSC_CTRL @ 0x7100;

    reg {
        name = "G0_HIPP_CSC_COEF00";
        desc = "Data sheet 9.2.6 G0_HIPP_CSC_COEF00 (offset 0x7104, printed page 9-88, `hi3516av300--Hi3516AV300-Datasheet.txt` line 39106).";

        field {
            name = "hipp_csc_coef00";
            desc = "Hipp colour-space conversion coef00. Chinese-only data sheet: description and value encoding not translated.";
            sw = rw;
            hw = r;
            reset = 0x0;
        } hipp_csc_coef00[15:0];
    } G0_HIPP_CSC_COEF00 @ 0x7104;

    reg {
        name = "G0_HIPP_CSC_COEF01";
        desc = "Data sheet 9.2.6 G0_HIPP_CSC_COEF01 (offset 0x7108, printed page 9-89, `hi3516av300--Hi3516AV300-Datasheet.txt` line 39127).";

        field {
            name = "hipp_csc_coef01";
            desc = "Hipp colour-space conversion coef01. Chinese-only data sheet: description and value encoding not translated.";
            sw = rw;
            hw = r;
            reset = 0x0;
        } hipp_csc_coef01[15:0];
    } G0_HIPP_CSC_COEF01 @ 0x7108;

    reg {
        name = "G0_HIPP_CSC_COEF02";
        desc = "Data sheet 9.2.6 G0_HIPP_CSC_COEF02 (offset 0x710C, printed page 9-89, `hi3516av300--Hi3516AV300-Datasheet.txt` line 39141).";

        field {
            name = "hipp_csc_coef02";
            desc = "Hipp colour-space conversion coef02. Chinese-only data sheet: description and value encoding not translated.";
            sw = rw;
            hw = r;
            reset = 0x0;
        } hipp_csc_coef02[15:0];
    } G0_HIPP_CSC_COEF02 @ 0x710C;

    reg {
        name = "G0_HIPP_CSC_COEF10";
        desc = "Data sheet 9.2.6 G0_HIPP_CSC_COEF10 (offset 0x7110, printed page 9-89, `hi3516av300--Hi3516AV300-Datasheet.txt` line 39164).";

        field {
            name = "hipp_csc_coef10";
            desc = "Hipp colour-space conversion coef10. Chinese-only data sheet: description and value encoding not translated.";
            sw = rw;
            hw = r;
            reset = 0x0;
        } hipp_csc_coef10[15:0];
    } G0_HIPP_CSC_COEF10 @ 0x7110;

    reg {
        name = "G0_HIPP_CSC_COEF11";
        desc = "Data sheet 9.2.6 G0_HIPP_CSC_COEF11 (offset 0x7114, printed page 9-89, `hi3516av300--Hi3516AV300-Datasheet.txt` line 39184).";

        field {
            name = "hipp_csc_coef11";
            desc = "Hipp colour-space conversion coef11. Chinese-only data sheet: description and value encoding not translated.";
            sw = rw;
            hw = r;
            reset = 0x0;
        } hipp_csc_coef11[15:0];
    } G0_HIPP_CSC_COEF11 @ 0x7114;

    reg {
        name = "G0_HIPP_CSC_COEF12";
        desc = "Data sheet 9.2.6 G0_HIPP_CSC_COEF12 (offset 0x7118, printed page 9-90, `hi3516av300--Hi3516AV300-Datasheet.txt` line 39207).";

        field {
            name = "hipp_csc_coef12";
            desc = "Hipp colour-space conversion coef12. Chinese-only data sheet: description and value encoding not translated.";
            sw = rw;
            hw = r;
            reset = 0x0;
        } hipp_csc_coef12[15:0];
    } G0_HIPP_CSC_COEF12 @ 0x7118;

    reg {
        name = "G0_HIPP_CSC_COEF20";
        desc = "Data sheet 9.2.6 G0_HIPP_CSC_COEF20 (offset 0x711C, printed page 9-90, `hi3516av300--Hi3516AV300-Datasheet.txt` line 39224).";

        field {
            name = "hipp_csc_coef20";
            desc = "Hipp colour-space conversion coef20. Chinese-only data sheet: description and value encoding not translated.";
            sw = rw;
            hw = r;
            reset = 0x0;
        } hipp_csc_coef20[15:0];
    } G0_HIPP_CSC_COEF20 @ 0x711C;

    reg {
        name = "G0_HIPP_CSC_COEF21";
        desc = "Data sheet 9.2.6 G0_HIPP_CSC_COEF21 (offset 0x7120, printed page 9-90, `hi3516av300--Hi3516AV300-Datasheet.txt` line 39245).";

        field {
            name = "hipp_csc_coef21";
            desc = "Hipp colour-space conversion coef21. Chinese-only data sheet: description and value encoding not translated.";
            sw = rw;
            hw = r;
            reset = 0x0;
        } hipp_csc_coef21[15:0];
    } G0_HIPP_CSC_COEF21 @ 0x7120;

    reg {
        name = "G0_HIPP_CSC_COEF22";
        desc = "Data sheet 9.2.6 G0_HIPP_CSC_COEF22 (offset 0x7124, printed page 9-91, `hi3516av300--Hi3516AV300-Datasheet.txt` line 39264).";

        field {
            name = "hipp_csc_coef22";
            desc = "Hipp colour-space conversion coef22. Chinese-only data sheet: description and value encoding not translated.";
            sw = rw;
            hw = r;
            reset = 0x0;
        } hipp_csc_coef22[15:0];
    } G0_HIPP_CSC_COEF22 @ 0x7124;

    reg {
        name = "G0_HIPP_CSC_SCALE";
        desc = "Data sheet 9.2.6 G0_HIPP_CSC_SCALE (offset 0x7128, printed page 9-91, `hi3516av300--Hi3516AV300-Datasheet.txt` line 39279).";

        field {
            name = "hipp_csc_scale";
            desc = "Hipp colour-space conversion scale. Chinese-only data sheet: description and value encoding not translated.";
            sw = rw;
            hw = r;
            reset = 0x0;
        } hipp_csc_scale[3:0];
    } G0_HIPP_CSC_SCALE @ 0x7128;

    reg {
        name = "G0_HIPP_CSC_IDC0";
        desc = "Data sheet 9.2.6 G0_HIPP_CSC_IDC0 (offset 0x712C, printed page 9-91, `hi3516av300--Hi3516AV300-Datasheet.txt` line 39297).";

        field {
            name = "hipp_csc_idc0";
            desc = "Hipp colour-space conversion idc0. Chinese-only data sheet: description and value encoding not translated.";
            sw = rw;
            hw = r;
            reset = 0x0;
        } hipp_csc_idc0[10:0];
    } G0_HIPP_CSC_IDC0 @ 0x712C;

    reg {
        name = "G0_HIPP_CSC_IDC1";
        desc = "Data sheet 9.2.6 G0_HIPP_CSC_IDC1 (offset 0x7130, printed page 9-91, `hi3516av300--Hi3516AV300-Datasheet.txt` line 39319).";

        field {
            name = "hipp_csc_idc1";
            desc = "Hipp colour-space conversion idc1. Chinese-only data sheet: description and value encoding not translated.";
            sw = rw;
            hw = r;
            reset = 0x0;
        } hipp_csc_idc1[10:0];
    } G0_HIPP_CSC_IDC1 @ 0x7130;

    reg {
        name = "G0_HIPP_CSC_IDC2";
        desc = "Data sheet 9.2.6 G0_HIPP_CSC_IDC2 (offset 0x7134, printed page 9-92, `hi3516av300--Hi3516AV300-Datasheet.txt` line 39342).";

        field {
            name = "hipp_csc_idc2";
            desc = "Hipp colour-space conversion idc2. Chinese-only data sheet: description and value encoding not translated.";
            sw = rw;
            hw = r;
            reset = 0x0;
        } hipp_csc_idc2[10:0];
    } G0_HIPP_CSC_IDC2 @ 0x7134;

    reg {
        name = "G0_HIPP_CSC_ODC0";
        desc = "Data sheet 9.2.6 G0_HIPP_CSC_ODC0 (offset 0x7138, printed page 9-92, `hi3516av300--Hi3516AV300-Datasheet.txt` line 39358).";

        field {
            name = "hipp_csc_odc0";
            desc = "Hipp colour-space conversion odc0. Chinese-only data sheet: description and value encoding not translated.";
            sw = rw;
            hw = r;
            reset = 0x0;
        } hipp_csc_odc0[10:0];
    } G0_HIPP_CSC_ODC0 @ 0x7138;

    reg {
        name = "G0_HIPP_CSC_ODC1";
        desc = "Data sheet 9.2.6 G0_HIPP_CSC_ODC1 (offset 0x713C, printed page 9-92, `hi3516av300--Hi3516AV300-Datasheet.txt` line 39382).";

        field {
            name = "hipp_csc_odc1";
            desc = "Hipp colour-space conversion odc1. Chinese-only data sheet: description and value encoding not translated.";
            sw = rw;
            hw = r;
            reset = 0x0;
        } hipp_csc_odc1[10:0];
    } G0_HIPP_CSC_ODC1 @ 0x713C;

    reg {
        name = "G0_HIPP_CSC_ODC2";
        desc = "Data sheet 9.2.6 G0_HIPP_CSC_ODC2 (offset 0x7140, printed page 9-92, `hi3516av300--Hi3516AV300-Datasheet.txt` line 39401).";

        field {
            name = "hipp_csc_odc2";
            desc = "Hipp colour-space conversion odc2. Chinese-only data sheet: description and value encoding not translated.";
            sw = rw;
            hw = r;
            reset = 0x0;
        } hipp_csc_odc2[10:0];
    } G0_HIPP_CSC_ODC2 @ 0x7140;

    reg {
        name = "G0_HIPP_CSC_MIN_Y";
        desc = "Data sheet 9.2.6 G0_HIPP_CSC_MIN_Y (offset 0x7144, printed page 9-93, `hi3516av300--Hi3516AV300-Datasheet.txt` line 39424).";

        field {
            name = "hipp_csc_min_y";
            desc = "Hipp colour-space conversion min y. Chinese-only data sheet: description and value encoding not translated.";
            sw = rw;
            hw = r;
            reset = 0x0;
        } hipp_csc_min_y[9:0];
    } G0_HIPP_CSC_MIN_Y @ 0x7144;

    reg {
        name = "G0_HIPP_CSC_MIN_C";
        desc = "Data sheet 9.2.6 G0_HIPP_CSC_MIN_C (offset 0x7148, printed page 9-93, `hi3516av300--Hi3516AV300-Datasheet.txt` line 39440).";

        field {
            name = "hipp_csc_min_c";
            desc = "Hipp colour-space conversion min c. Chinese-only data sheet: description and value encoding not translated.";
            sw = rw;
            hw = r;
            reset = 0x0;
        } hipp_csc_min_c[9:0];
    } G0_HIPP_CSC_MIN_C @ 0x7148;

    reg {
        name = "G0_HIPP_CSC_MAX_Y";
        desc = "Data sheet 9.2.6 G0_HIPP_CSC_MAX_Y (offset 0x714C, printed page 9-93, `hi3516av300--Hi3516AV300-Datasheet.txt` line 39462).";

        field {
            name = "hipp_csc_max_y";
            desc = "Hipp colour-space conversion max y. Chinese-only data sheet: description and value encoding not translated.";
            sw = rw;
            hw = r;
            reset = 0x0;
        } hipp_csc_max_y[9:0];
    } G0_HIPP_CSC_MAX_Y @ 0x714C;

    reg {
        name = "G0_HIPP_CSC_MAX_C";
        desc = "Data sheet 9.2.6 G0_HIPP_CSC_MAX_C (offset 0x7150, printed page 9-94, `hi3516av300--Hi3516AV300-Datasheet.txt` line 39479).";

        field {
            name = "hipp_csc_max_c";
            desc = "Hipp colour-space conversion max c. Chinese-only data sheet: description and value encoding not translated.";
            sw = rw;
            hw = r;
            reset = 0x0;
        } hipp_csc_max_c[9:0];
    } G0_HIPP_CSC_MAX_C @ 0x7150;

    reg {
        name = "G0_ZME_HINFO";
        desc = "Data sheet 9.2.6 G0_ZME_HINFO (offset 0x7300, printed page 9-94, `hi3516av300--Hi3516AV300-Datasheet.txt` line 39492).";

        field {
            name = "out_width";
            desc = "Out width. Chinese-only data sheet: description and value encoding not translated.";
            sw = rw;
            hw = r;
            reset = 0x0;
        } out_width[15:0];
    } G0_ZME_HINFO @ 0x7300;

    reg {
        name = "G0_ZME_HSP";
        desc = "Data sheet 9.2.6 G0_ZME_HSP (offset 0x7304, printed page 9-94, `hi3516av300--Hi3516AV300-Datasheet.txt` line 39509).";

        field {
            name = "hfir_en";
            desc = "Hfir enable. Chinese-only data sheet: description and value encoding not translated.";
            sw = rw;
            hw = r;
            reset = 0x0;
        } hfir_en[31:31];

        field {
            name = "ahfir_mid_en";
            desc = "Ahfir mid enable. Chinese-only data sheet: description and value encoding not translated.";
            sw = rw;
            hw = r;
            reset = 0x0;
        } ahfir_mid_en[30:30];

        field {
            name = "lhfir_mid_en";
            desc = "Lhfir mid enable. Chinese-only data sheet: description and value encoding not translated.";
            sw = rw;
            hw = r;
            reset = 0x0;
        } lhfir_mid_en[29:29];

        field {
            name = "chfir_mid_en";
            desc = "Chfir mid enable. Chinese-only data sheet: description and value encoding not translated.";
            sw = rw;
            hw = r;
            reset = 0x0;
        } chfir_mid_en[28:28];

        field {
            name = "lhfir_mode";
            desc = "Lhfir mode. Chinese-only data sheet: description and value encoding not translated.";
            sw = rw;
            hw = r;
            reset = 0x0;
        } lhfir_mode[26:26];

        field {
            name = "ahfir_mode";
            desc = "Ahfir mode. Chinese-only data sheet: description and value encoding not translated.";
            sw = rw;
            hw = r;
            reset = 0x0;
        } ahfir_mode[25:25];

        field {
            name = "hratio";
            desc = "Hratio. Chinese-only data sheet: description and value encoding not translated.";
            sw = rw;
            hw = r;
            reset = 0x00100000;
        } hratio[23:0];
    } G0_ZME_HSP @ 0x7304;

    reg {
        name = "G0_ZME_VINFO";
        desc = "Data sheet 9.2.6 G0_ZME_VINFO (offset 0x7380, printed page 9-95, `hi3516av300--Hi3516AV300-Datasheet.txt` line 39583).";

        field {
            name = "out_pro";
            desc = "Out pro. Chinese-only data sheet: description and value encoding not translated.";
            sw = rw;
            hw = r;
            reset = 0x0;
        } out_pro[18:18];

        field {
            name = "out_height";
            desc = "Out height. Chinese-only data sheet: description and value encoding not translated.";
            sw = rw;
            hw = r;
            reset = 0x0;
        } out_height[15:0];
    } G0_ZME_VINFO @ 0x7380;

    reg {
        name = "G0_ZME_VSP";
        desc = "Data sheet 9.2.6 G0_ZME_VSP (offset 0x7384, printed page 9-95, `hi3516av300--Hi3516AV300-Datasheet.txt` line 39612).";

        field {
            name = "vfir_en";
            desc = "Vfir enable. Chinese-only data sheet: description and value encoding not translated.";
            sw = rw;
            hw = r;
            reset = 0x0;
        } vfir_en[31:31];

        field {
            name = "avfir_mid_en";
            desc = "Avfir mid enable. Chinese-only data sheet: description and value encoding not translated.";
            sw = rw;
            hw = r;
            reset = 0x0;
        } avfir_mid_en[30:30];

        field {
            name = "lvfir_mid_en";
            desc = "Lvfir mid enable. Chinese-only data sheet: description and value encoding not translated.";
            sw = rw;
            hw = r;
            reset = 0x0;
        } lvfir_mid_en[29:29];

        field {
            name = "cvfir_mid_en";
            desc = "Cvfir mid enable. Chinese-only data sheet: description and value encoding not translated.";
            sw = rw;
            hw = r;
            reset = 0x0;
        } cvfir_mid_en[28:28];

        field {
            name = "lvfir_mode";
            desc = "Lvfir mode. Chinese-only data sheet: description and value encoding not translated.";
            sw = rw;
            hw = r;
            reset = 0x0;
        } lvfir_mode[26:26];

        field {
            name = "vafir_mode";
            desc = "Vafir mode. Chinese-only data sheet: description and value encoding not translated.";
            sw = rw;
            hw = r;
            reset = 0x0;
        } vafir_mode[25:25];

        field {
            name = "vratio";
            desc = "Vratio. Chinese-only data sheet: description and value encoding not translated.";
            sw = rw;
            hw = r;
            reset = 0x1000;
        } vratio[15:0];
    } G0_ZME_VSP @ 0x7384;

    reg {
        name = "DHD0_CTRL";
        desc = "Data sheet 9.2.6 DHD0_CTRL (offset 0xD000, printed page 9-96, `hi3516av300--Hi3516AV300-Datasheet.txt` line 39674).";

        field {
            name = "intf_en";
            desc = "Intf enable. Chinese-only data sheet: description and value encoding not translated.";
            sw = rw;
            hw = r;
            reset = 0x0;
        } intf_en[31:31];

        field {
            name = "cbar_en";
            desc = "Cbar enable. Chinese-only data sheet: description and value encoding not translated.";
            sw = rw;
            hw = r;
            reset = 0x0;
        } cbar_en[30:30];

        field {
            name = "cbar_sel";
            desc = "Cbar select. Chinese-only data sheet: description and value encoding not translated.";
            sw = rw;
            hw = r;
            reset = 0x0;
        } cbar_sel[29:29];

        field {
            name = "regup";
            desc = "Regup. Chinese-only data sheet: description and value encoding not translated.";
            sw = rw;
            hw = w;
            onwrite = woclr;
            reset = 0x0;
        } regup[0:0];
    } DHD0_CTRL @ 0xD000;

    reg {
        name = "DHD0_VSYNC1";
        desc = "Data sheet 9.2.6 DHD0_VSYNC1 (offset 0xD004, printed page 9-97, `hi3516av300--Hi3516AV300-Datasheet.txt` line 39716).";

        field {
            name = "vbb";
            desc = "Vbb. Chinese-only data sheet: description and value encoding not translated.";
            sw = rw;
            hw = r;
            reset = 0x28;
        } vbb[31:16];

        field {
            name = "vact";
            desc = "Vact. Chinese-only data sheet: description and value encoding not translated.";
            sw = rw;
            hw = r;
            reset = 0x437;
        } vact[15:0];
    } DHD0_VSYNC1 @ 0xD004;

    reg {
        name = "DHD0_VSYNC2";
        desc = "Data sheet 9.2.6 DHD0_VSYNC2 (offset 0xD008, printed page 9-97, `hi3516av300--Hi3516AV300-Datasheet.txt` line 39745).";

        field {
            name = "vfb";
            desc = "Vfb. Chinese-only data sheet: description and value encoding not translated.";
            sw = rw;
            hw = r;
            reset = 0x3;
        } vfb[15:0];
    } DHD0_VSYNC2 @ 0xD008;

    reg {
        name = "DHD0_HSYNC1";
        desc = "Data sheet 9.2.6 DHD0_HSYNC1 (offset 0xD00C, printed page 9-98, `hi3516av300--Hi3516AV300-Datasheet.txt` line 39768).";

        field {
            name = "hbb";
            desc = "Hbb. Chinese-only data sheet: description and value encoding not translated.";
            sw = rw;
            hw = r;
            reset = 0xBF;
        } hbb[31:16];

        field {
            name = "hact";
            desc = "Hact. Chinese-only data sheet: description and value encoding not translated.";
            sw = rw;
            hw = r;
            reset = 0x77F;
        } hact[15:0];
    } DHD0_HSYNC1 @ 0xD00C;

    reg {
        name = "DHD0_HSYNC2";
        desc = "Data sheet 9.2.6 DHD0_HSYNC2 (offset 0xD010, printed page 9-98, `hi3516av300--Hi3516AV300-Datasheet.txt` line 39782).";

        field {
            name = "hmid";
            desc = "Hmid. Chinese-only data sheet: description and value encoding not translated.";
            sw = rw;
            hw = r;
            reset = 0x0;
        } hmid[31:16];

        field {
            name = "hfb";
            desc = "Hfb. Chinese-only data sheet: description and value encoding not translated.";
            sw = rw;
            hw = r;
            reset = 0x57;
        } hfb[15:0];
    } DHD0_HSYNC2 @ 0xD010;

    reg {
        name = "DHD0_VPLUS1";
        desc = "Data sheet 9.2.6 DHD0_VPLUS1 (offset 0xD014, printed page 9-98, `hi3516av300--Hi3516AV300-Datasheet.txt` line 39805).";

        field {
            name = "bvbb";
            desc = "Bvbb. Chinese-only data sheet: description and value encoding not translated.";
            sw = rw;
            hw = r;
            reset = 0x0;
        } bvbb[31:16];

        field {
            name = "bvact";
            desc = "Bvact. Chinese-only data sheet: description and value encoding not translated.";
            sw = rw;
            hw = r;
            reset = 0x0;
        } bvact[15:0];
    } DHD0_VPLUS1 @ 0xD014;

    reg {
        name = "DHD0_VPLUS2";
        desc = "Data sheet 9.2.6 DHD0_VPLUS2 (offset 0xD018, printed page 9-98, `hi3516av300--Hi3516AV300-Datasheet.txt` line 39831).";

        field {
            name = "bvfb";
            desc = "Bvfb. Chinese-only data sheet: description and value encoding not translated.";
            sw = rw;
            hw = r;
            reset = 0x0;
        } bvfb[15:0];
    } DHD0_VPLUS2 @ 0xD018;

    reg {
        name = "DHD0_PWR";
        desc = "Data sheet 9.2.6 DHD0_PWR (offset 0xD01C, printed page 9-99, `hi3516av300--Hi3516AV300-Datasheet.txt` line 39855).";

        field {
            name = "multichn_en";
            desc = "Multichn enable. Chinese-only data sheet: description and value encoding not translated.";
            sw = rw;
            hw = r;
            reset = 0x1;
        } multichn_en[28:27];

        field {
            name = "vpw";
            desc = "Vpw. Chinese-only data sheet: description and value encoding not translated.";
            sw = rw;
            hw = r;
            reset = 0x4;
        } vpw[23:16];

        field {
            name = "hpw";
            desc = "Hpw. Chinese-only data sheet: description and value encoding not translated.";
            sw = rw;
            hw = r;
            reset = 0x2B;
        } hpw[15:0];
    } DHD0_PWR @ 0xD01C;

    reg {
        name = "DHD0_VTTHD";
        desc = "Data sheet 9.2.6 DHD0_VTTHD (offset 0xD024, printed page 9-99, `hi3516av300--Hi3516AV300-Datasheet.txt` line 39887).";

        field {
            name = "thd2_mode";
            desc = "Thd2 mode. Chinese-only data sheet: description and value encoding not translated.";
            sw = rw;
            hw = r;
            reset = 0x0;
        } thd2_mode[31:31];

        field {
            name = "vtmgthd2";
            desc = "Vtmgthd2. Chinese-only data sheet: description and value encoding not translated.";
            sw = rw;
            hw = r;
            reset = 0x1;
        } vtmgthd2[28:16];

        field {
            name = "thd1_mode";
            desc = "Thd1 mode. Chinese-only data sheet: description and value encoding not translated.";
            sw = rw;
            hw = r;
            reset = 0x0;
        } thd1_mode[15:15];

        field {
            name = "vtmgthd1";
            desc = "Vtmgthd1. Chinese-only data sheet: description and value encoding not translated.";
            sw = rw;
            hw = r;
            reset = 0x1;
        } vtmgthd1[12:0];
    } DHD0_VTTHD @ 0xD024;

    reg {
        name = "DHD0_PARATHD";
        desc = "Data sheet 9.2.6 DHD0_PARATHD (offset 0xD028, printed page 9-100, `hi3516av300--Hi3516AV300-Datasheet.txt` line 39932).";

        field {
            name = "dfs_en";
            desc = "Dfs enable. Chinese-only data sheet: description and value encoding not translated.";
            sw = rw;
            hw = r;
            reset = 0x0;
        } dfs_en[31:31];

        field {
            name = "para_thd";
            desc = "Para threshold. Chinese-only data sheet: description and value encoding not translated.";
            sw = rw;
            hw = r;
            reset = 0x2;
        } para_thd[7:0];
    } DHD0_PARATHD @ 0xD028;

    reg {
        name = "DHD0_START_POS";
        desc = "Data sheet 9.2.6 DHD0_START_POS (offset 0xD030, printed page 9-100, `hi3516av300--Hi3516AV300-Datasheet.txt` line 39963).";

        field {
            name = "timing_start_pos";
            desc = "Timing start position. Chinese-only data sheet: description and value encoding not translated.";
            sw = rw;
            hw = r;
            reset = 0x3;
        } timing_start_pos[15:8];

        field {
            name = "start_pos";
            desc = "Start position. Chinese-only data sheet: description and value encoding not translated.";
            sw = rw;
            hw = r;
            reset = 0xA;
        } start_pos[7:0];
    } DHD0_START_POS @ 0xD030;

    reg {
        name = "DHD0_STATE";
        desc = "Data sheet 9.2.6 DHD0_STATE (offset 0xD088, printed page 9-101, `hi3516av300--Hi3516AV300-Datasheet.txt` line 39992).";

        field {
            name = "count_int";
            desc = "Count interrupt. Chinese-only data sheet: description and value encoding not translated.";
            sw = r;
            hw = w;
            reset = 0x0;
        } count_int[23:16];

        field {
            name = "vcnt";
            desc = "Vcnt. Chinese-only data sheet: description and value encoding not translated.";
            sw = r;
            hw = w;
            reset = 0x0;
        } vcnt[15:3];

        field {
            name = "bottom_field";
            desc = "Bottom field. Chinese-only data sheet: description and value encoding not translated.";
            sw = r;
            hw = w;
            reset = 0x1;
        } bottom_field[2:2];

        field {
            name = "vblank";
            desc = "Vblank. Chinese-only data sheet: description and value encoding not translated.";
            sw = r;
            hw = w;
            reset = 0x1;
        } vblank[1:1];

        field {
            name = "vback_blank";
            desc = "Vback blank. Chinese-only data sheet: description and value encoding not translated.";
            sw = r;
            hw = w;
            reset = 0x0;
        } vback_blank[0:0];
    } DHD0_STATE @ 0xD088;

    reg {
        name = "VO_MUX";
        desc = "Data sheet 9.2.6 VO_MUX (offset 0xD090, printed page 9-101, `hi3516av300--Hi3516AV300-Datasheet.txt` line 40035).";

        field {
            name = "digital_sel";
            desc = "Digital select. Chinese-only data sheet: description and value encoding not translated.";
            sw = rw;
            hw = r;
            reset = 0x0;
        } digital_sel[31:28];

        field {
            name = "bt_sel";
            desc = "Bt select. Chinese-only data sheet: description and value encoding not translated.";
            sw = rw;
            hw = r;
            reset = 0x0;
        } bt_sel[11:8];

        field {
            name = "lcd_sel";
            desc = "Lcd select. Chinese-only data sheet: description and value encoding not translated.";
            sw = rw;
            hw = r;
            reset = 0x0;
        } lcd_sel[7:4];

        field {
            name = "mipi_sel";
            desc = "Mipi select. Chinese-only data sheet: description and value encoding not translated.";
            sw = rw;
            hw = r;
            reset = 0x0;
        } mipi_sel[3:0];
    } VO_MUX @ 0xD090;

    reg {
        name = "INTF0_DITHER_CTRL";
        desc = "Data sheet 9.2.6 INTF0_DITHER_CTRL (offset 0xD0B0, printed page 9-102, `hi3516av300--Hi3516AV300-Datasheet.txt` line 40074).";

        field {
            name = "o_data_width_dither";
            desc = "O data width dither. Chinese-only data sheet: description and value encoding not translated.";
            sw = rw;
            hw = r;
            reset = 0x5;
        } o_data_width_dither[12:10];

        field {
            name = "i_data_width_dither";
            desc = "I data width dither. Chinese-only data sheet: description and value encoding not translated.";
            sw = rw;
            hw = r;
            reset = 0x2;
        } i_data_width_dither[9:7];

        field {
            name = "dither_round_unlim";
            desc = "Dither round unlim. Chinese-only data sheet: description and value encoding not translated.";
            sw = rw;
            hw = r;
            reset = 0x0;
        } dither_round_unlim[6:6];

        field {
            name = "dither_en";
            desc = "Dither enable. Chinese-only data sheet: description and value encoding not translated.";
            sw = rw;
            hw = r;
            reset = 0x0;
        } dither_en[5:5];

        field {
            name = "dither_mode";
            desc = "Dither mode. Chinese-only data sheet: description and value encoding not translated.";
            sw = rw;
            hw = r;
            reset = 0x0;
        } dither_mode[4:4];

        field {
            name = "dither_round";
            desc = "Dither round. Chinese-only data sheet: description and value encoding not translated.";
            sw = rw;
            hw = r;
            reset = 0x0;
        } dither_round[3:3];

        field {
            name = "dither_domain_mode";
            desc = "Dither domain mode. Chinese-only data sheet: description and value encoding not translated.";
            sw = rw;
            hw = r;
            reset = 0x0;
        } dither_domain_mode[2:2];

        field {
            name = "dither_tap_mode";
            desc = "Dither tap mode. Chinese-only data sheet: description and value encoding not translated.";
            sw = rw;
            hw = r;
            reset = 0x0;
        } dither_tap_mode[1:0];
    } INTF0_DITHER_CTRL @ 0xD0B0;

    reg {
        name = "INTF_BT_CTRL";
        desc = "Data sheet 9.2.6 INTF_BT_CTRL (offset 0xD200, printed page 9-103, `hi3516av300--Hi3516AV300-Datasheet.txt` line 40161).";

        field {
            name = "yc_mode";
            desc = "BT.1120 YC output order. 0: Y in the high bits, C in the low bits. 1: C in the high bits, Y in the low bits. Translated from the Chinese data sheet (access column printed as WR, taken as RW).";
            sw = rw;
            hw = r;
            reset = 0x0;
        } yc_mode[24:24];
    } INTF_BT_CTRL @ 0xD200;

    reg {
        name = "INTF_BT_UPD";
        desc = "Data sheet 9.2.6 INTF_BT_UPD (offset 0xD204, printed page 9-103, `hi3516av300--Hi3516AV300-Datasheet.txt` line 40185).";

        field {
            name = "regup";
            desc = "Regup. Chinese-only data sheet: description and value encoding not translated.";
            sw = rw;
            hw = w;
            onwrite = woclr;
            reset = 0x0;
        } regup[0:0];
    } INTF_BT_UPD @ 0xD204;

    reg {
        name = "INTF_BT_SYNC_INV";
        desc = "Data sheet 9.2.6 INTF_BT_SYNC_INV (offset 0xD208, printed page 9-104, `hi3516av300--Hi3516AV300-Datasheet.txt` line 40207).";

        field {
            name = "f_inv";
            desc = "F invert. Chinese-only data sheet: description and value encoding not translated.";
            sw = rw;
            hw = r;
            reset = 0x0;
        } f_inv[3:3];

        field {
            name = "vs_inv";
            desc = "Vertical sync invert. Chinese-only data sheet: description and value encoding not translated.";
            sw = rw;
            hw = r;
            reset = 0x0;
        } vs_inv[2:2];

        field {
            name = "hs_inv";
            desc = "Horizontal sync invert. Chinese-only data sheet: description and value encoding not translated.";
            sw = rw;
            hw = r;
            reset = 0x0;
        } hs_inv[1:1];

        field {
            name = "dv_inv";
            desc = "Dv invert. Chinese-only data sheet: description and value encoding not translated.";
            sw = rw;
            hw = r;
            reset = 0x0;
        } dv_inv[0:0];
    } INTF_BT_SYNC_INV @ 0xD208;

    reg {
        name = "BT_CLIP0_L";
        desc = "Data sheet 9.2.6 BT_CLIP0_L (offset 0xD210, printed page 9-104, `hi3516av300--Hi3516AV300-Datasheet.txt` line 40254).";

        field {
            name = "clip_en";
            desc = "Clip enable. Chinese-only data sheet: description and value encoding not translated.";
            sw = rw;
            hw = r;
            reset = 0x0;
        } clip_en[31:31];

        field {
            name = "clip_cl2";
            desc = "Clip cl2. Chinese-only data sheet: description and value encoding not translated.";
            sw = rw;
            hw = r;
            reset = 0x0;
        } clip_cl2[29:20];

        field {
            name = "clip_cl1";
            desc = "Clip cl1. Chinese-only data sheet: description and value encoding not translated.";
            sw = rw;
            hw = r;
            reset = 0x0;
        } clip_cl1[19:10];

        field {
            name = "clip_cl0";
            desc = "Clip cl0. Chinese-only data sheet: description and value encoding not translated.";
            sw = rw;
            hw = r;
            reset = 0x0;
        } clip_cl0[9:0];
    } BT_CLIP0_L @ 0xD210;

    reg {
        name = "BT_CLIP0_H";
        desc = "Data sheet 9.2.6 BT_CLIP0_H (offset 0xD214, printed page 9-105, `hi3516av300--Hi3516AV300-Datasheet.txt` line 40283).";

        field {
            name = "clip_ch2";
            desc = "Clip ch2. Chinese-only data sheet: description and value encoding not translated.";
            sw = rw;
            hw = r;
            reset = 0x3FF;
        } clip_ch2[29:20];

        field {
            name = "clip_ch1";
            desc = "Clip ch1. Chinese-only data sheet: description and value encoding not translated.";
            sw = rw;
            hw = r;
            reset = 0x3FF;
        } clip_ch1[19:10];

        field {
            name = "clip_ch0";
            desc = "Clip ch0. Chinese-only data sheet: description and value encoding not translated.";
            sw = rw;
            hw = r;
            reset = 0x3FF;
        } clip_ch0[9:0];
    } BT_CLIP0_H @ 0xD214;

    reg {
        name = "INTF_LCD_CTRL";
        desc = "Data sheet 9.2.6 INTF_LCD_CTRL (offset 0xD300, printed page 9-105, `hi3516av300--Hi3516AV300-Datasheet.txt` line 40308).";

        field {
            name = "lcd_serial_mode";
            desc = "Lcd serial mode. Chinese-only data sheet: description and value encoding not translated.";
            sw = rw;
            hw = r;
            reset = 0x0;
        } lcd_serial_mode[29:29];

        field {
            name = "lcd_serial_perd";
            desc = "Lcd serial perd. Chinese-only data sheet: description and value encoding not translated.";
            sw = rw;
            hw = r;
            reset = 0x0;
        } lcd_serial_perd[28:28];

        field {
            name = "lcd_parallel_order";
            desc = "Lcd parallel order. Chinese-only data sheet: description and value encoding not translated.";
            sw = rw;
            hw = r;
            reset = 0x0;
        } lcd_parallel_order[27:27];

        field {
            name = "lcd_data_inv";
            desc = "Lcd data invert. Chinese-only data sheet: description and value encoding not translated.";
            sw = rw;
            hw = r;
            reset = 0x0;
        } lcd_data_inv[26:26];

        field {
            name = "lcd_parallel_mode";
            desc = "Lcd parallel mode. Chinese-only data sheet: description and value encoding not translated.";
            sw = rw;
            hw = r;
            reset = 0x0;
        } lcd_parallel_mode[25:25];
    } INTF_LCD_CTRL @ 0xD300;

    reg {
        name = "INTF_LCD_UPD";
        desc = "Data sheet 9.2.6 INTF_LCD_UPD (offset 0xD304, printed page 9-106, `hi3516av300--Hi3516AV300-Datasheet.txt` line 40358).";

        field {
            name = "regup";
            desc = "Regup. Chinese-only data sheet: description and value encoding not translated.";
            sw = rw;
            hw = w;
            onwrite = woclr;
            reset = 0x0;
        } regup[0:0];
    } INTF_LCD_UPD @ 0xD304;

    reg {
        name = "INTF_LCD_SYNC_INV";
        desc = "Data sheet 9.2.6 INTF_LCD_SYNC_INV (offset 0xD308, printed page 9-106, `hi3516av300--Hi3516AV300-Datasheet.txt` line 40382).";

        field {
            name = "f_inv";
            desc = "F invert. Chinese-only data sheet: description and value encoding not translated.";
            sw = rw;
            hw = r;
            reset = 0x0;
        } f_inv[3:3];

        field {
            name = "vs_inv";
            desc = "Vertical sync invert. Chinese-only data sheet: description and value encoding not translated.";
            sw = rw;
            hw = r;
            reset = 0x0;
        } vs_inv[2:2];

        field {
            name = "hs_inv";
            desc = "Horizontal sync invert. Chinese-only data sheet: description and value encoding not translated.";
            sw = rw;
            hw = r;
            reset = 0x0;
        } hs_inv[1:1];

        field {
            name = "dv_inv";
            desc = "Dv invert. Chinese-only data sheet: description and value encoding not translated.";
            sw = rw;
            hw = r;
            reset = 0x0;
        } dv_inv[0:0];
    } INTF_LCD_SYNC_INV @ 0xD308;

    reg {
        name = "MAC_OUTSTANDING";
        desc = "Data sheet 9.2.6 MAC_OUTSTANDING (offset 0x10000, printed page 9-107, `hi3516av300--Hi3516AV300-Datasheet.txt` line 40431).";

        field {
            name = "mstr0_woutstanding";
            desc = "Mstr0 woutstanding. Chinese-only data sheet: description and value encoding not translated.";
            sw = rw;
            hw = r;
            reset = 0x7;
        } mstr0_woutstanding[7:4];

        field {
            name = "mstr0_routstanding";
            desc = "Mstr0 routstanding. Chinese-only data sheet: description and value encoding not translated.";
            sw = rw;
            hw = r;
            reset = 0xF;
        } mstr0_routstanding[3:0];
    } MAC_OUTSTANDING @ 0x10000;

    reg {
        name = "VID_READ_CTRL";
        desc = "Data sheet 9.2.6 VID_READ_CTRL (offset 0x10200, printed page 9-107, `hi3516av300--Hi3516AV300-Datasheet.txt` line 40455).";

        field {
            name = "lm_rmode";
            desc = "Lm rmode. Chinese-only data sheet: description and value encoding not translated.";
            sw = rw;
            hw = r;
            reset = 0x0;
        } lm_rmode[6:4];

        field {
            name = "chm_rmode";
            desc = "Chm rmode. Chinese-only data sheet: description and value encoding not translated.";
            sw = rw;
            hw = r;
            reset = 0x0;
        } chm_rmode[2:0];
    } VID_READ_CTRL @ 0x10200;

    reg {
        name = "VID_OUT_CTRL";
        desc = "Data sheet 9.2.6 VID_OUT_CTRL (offset 0x10210, printed page 9-108, `hi3516av300--Hi3516AV300-Datasheet.txt` line 40497).";

        field {
            name = "uv_order_en";
            desc = "Uv order enable. Chinese-only data sheet: description and value encoding not translated.";
            sw = rw;
            hw = r;
            reset = 0x0;
        } uv_order_en[4:4];
    } VID_OUT_CTRL @ 0x10210;

    reg {
        name = "VID_SRC_INFO";
        desc = "Data sheet 9.2.6 VID_SRC_INFO (offset 0x10240, printed page 9-108, `hi3516av300--Hi3516AV300-Datasheet.txt` line 40526).";

        field {
            name = "dcmp_en";
            desc = "Decompression enable. Chinese-only data sheet: description and value encoding not translated.";
            sw = rw;
            hw = r;
            reset = 0x0;
        } dcmp_en[20:20];

        field {
            name = "data_fmt";
            desc = "Data format. Chinese-only data sheet: description and value encoding not translated.";
            sw = rw;
            hw = r;
            reset = 0x0;
        } data_fmt[4:3];

        field {
            name = "data_type";
            desc = "Data type. Chinese-only data sheet: description and value encoding not translated.";
            sw = rw;
            hw = r;
            reset = 0x0;
        } data_type[2:0];
    } VID_SRC_INFO @ 0x10240;

    reg {
        name = "VID_SRC_RESO";
        desc = "Data sheet 9.2.6 VID_SRC_RESO (offset 0x10244, printed page 9-109, `hi3516av300--Hi3516AV300-Datasheet.txt` line 40575).";

        field {
            name = "src_h";
            desc = "Source h. Chinese-only data sheet: description and value encoding not translated.";
            sw = rw;
            hw = r;
            reset = 0x0;
        } src_h[31:16];

        field {
            name = "src_w";
            desc = "Source w. Chinese-only data sheet: description and value encoding not translated.";
            sw = rw;
            hw = r;
            reset = 0x0;
        } src_w[15:0];
    } VID_SRC_RESO @ 0x10244;

    reg {
        name = "VID_SRC_CROP";
        desc = "Data sheet 9.2.6 VID_SRC_CROP (offset 0x10248, printed page 9-109, `hi3516av300--Hi3516AV300-Datasheet.txt` line 40600).";

        field {
            name = "src_crop_y";
            desc = "Source crop y. Chinese-only data sheet: description and value encoding not translated.";
            sw = rw;
            hw = r;
            reset = 0x0;
        } src_crop_y[31:16];

        field {
            name = "src_crop_x";
            desc = "Source crop x. Chinese-only data sheet: description and value encoding not translated.";
            sw = rw;
            hw = r;
            reset = 0x0;
        } src_crop_x[15:0];
    } VID_SRC_CROP @ 0x10248;

    reg {
        name = "VID_IN_RESO";
        desc = "Data sheet 9.2.6 VID_IN_RESO (offset 0x1024C, printed page 9-110, `hi3516av300--Hi3516AV300-Datasheet.txt` line 40624).";

        field {
            name = "ireso_h";
            desc = "Ireso h. Chinese-only data sheet: description and value encoding not translated.";
            sw = rw;
            hw = r;
            reset = 0x0;
        } ireso_h[31:16];

        field {
            name = "ireso_w";
            desc = "Ireso w. Chinese-only data sheet: description and value encoding not translated.";
            sw = rw;
            hw = r;
            reset = 0x0;
        } ireso_w[15:0];
    } VID_IN_RESO @ 0x1024C;

    reg {
        name = "ICE_V3R2_SEG_DCMP_GLB_INFO";
        desc = "Data sheet 9.2.6 ICE_V3R2_SEG_DCMP_GLB_INFO (offset 0x10380, printed page 9-110, `hi3516av300--Hi3516AV300-Datasheet.txt` line 40639).";

        field {
            name = "cmp_mode";
            desc = "Compare mode. Chinese-only data sheet: description and value encoding not translated.";
            sw = rw;
            hw = r;
            reset = 0x1;
        } cmp_mode[2:2];

        field {
            name = "is_lossless";
            desc = "Is lossless. Chinese-only data sheet: description and value encoding not translated.";
            sw = rw;
            hw = r;
            reset = 0x0;
        } is_lossless[1:1];

        field {
            name = "ice_en";
            desc = "Ice enable. Chinese-only data sheet: description and value encoding not translated.";
            sw = rw;
            hw = r;
            reset = 0x1;
        } ice_en[0:0];
    } ICE_V3R2_SEG_DCMP_GLB_INFO @ 0x10380;

    reg {
        name = "ICE_V3R2_SEG_DCMP_GLB_INFO_CHM";
        desc = "Data sheet 9.2.6 ICE_V3R2_SEG_DCMP_GLB_INFO_CHM (offset 0x103C0, printed page 9-110, `hi3516av300--Hi3516AV300-Datasheet.txt` line 40674).";

        field {
            name = "cmp_mode";
            desc = "Compare mode. Chinese-only data sheet: description and value encoding not translated.";
            sw = rw;
            hw = r;
            reset = 0x1;
        } cmp_mode[2:2];

        field {
            name = "is_lossless";
            desc = "Is lossless. Chinese-only data sheet: description and value encoding not translated.";
            sw = rw;
            hw = r;
            reset = 0x0;
        } is_lossless[1:1];

        field {
            name = "ice_en";
            desc = "Ice enable. Chinese-only data sheet: description and value encoding not translated.";
            sw = rw;
            hw = r;
            reset = 0x1;
        } ice_en[0:0];
    } ICE_V3R2_SEG_DCMP_GLB_INFO_CHM @ 0x103C0;

    reg {
        name = "GFX_OUT_CTRL";
        desc = "Data sheet 9.2.6 GFX_OUT_CTRL (offset 0x10E08, printed page 9-111, `hi3516av300--Hi3516AV300-Datasheet.txt` line 40705).";

        field {
            name = "premulti_en";
            desc = "Premulti enable. Chinese-only data sheet: description and value encoding not translated.";
            sw = rw;
            hw = r;
            reset = 0x0;
        } premulti_en[10:10];

        field {
            name = "bitext";
            desc = "Bitext. Chinese-only data sheet: description and value encoding not translated.";
            sw = rw;
            hw = r;
            reset = 0x0;
        } bitext[9:8];

        field {
            name = "key_en";
            desc = "Key enable. Chinese-only data sheet: description and value encoding not translated.";
            sw = rw;
            hw = r;
            reset = 0x0;
        } key_en[5:5];

        field {
            name = "key_mode";
            desc = "Key mode. Chinese-only data sheet: description and value encoding not translated.";
            sw = rw;
            hw = r;
            reset = 0x0;
        } key_mode[4:4];

        field {
            name = "palpha_en";
            desc = "Palpha enable. Chinese-only data sheet: description and value encoding not translated.";
            sw = rw;
            hw = r;
            reset = 0x0;
        } palpha_en[1:1];

        field {
            name = "palpha_range";
            desc = "Palpha range. Chinese-only data sheet: description and value encoding not translated.";
            sw = rw;
            hw = r;
            reset = 0x0;
        } palpha_range[0:0];
    } GFX_OUT_CTRL @ 0x10E08;

    reg {
        name = "GFX_1555_ALPHA";
        desc = "Data sheet 9.2.6 GFX_1555_ALPHA (offset 0x10E28, printed page 9-112, `hi3516av300--Hi3516AV300-Datasheet.txt` line 40771).";

        field {
            name = "alpha_1";
            desc = "Alpha 1. Chinese-only data sheet: description and value encoding not translated.";
            sw = rw;
            hw = r;
            reset = 0x0;
        } alpha_1[15:8];

        field {
            name = "alpha_0";
            desc = "Alpha 0. Chinese-only data sheet: description and value encoding not translated.";
            sw = rw;
            hw = r;
            reset = 0x0;
        } alpha_0[7:0];
    } GFX_1555_ALPHA @ 0x10E28;

    reg {
        name = "GFX_SRC_INFO";
        desc = "Data sheet 9.2.6 GFX_SRC_INFO (offset 0x10E40, printed page 9-112, `hi3516av300--Hi3516AV300-Datasheet.txt` line 40798).";

        field {
            name = "dcmp_en";
            desc = "Decompression enable. Chinese-only data sheet: description and value encoding not translated.";
            sw = rw;
            hw = r;
            reset = 0x0;
        } dcmp_en[20:20];

        field {
            name = "ifmt";
            desc = "Input format. Chinese-only data sheet: description and value encoding not translated.";
            sw = rw;
            hw = r;
            reset = 0x0;
        } ifmt[7:0];
    } GFX_SRC_INFO @ 0x10E40;

    reg {
        name = "GFX_SRC_RESO";
        desc = "Data sheet 9.2.6 GFX_SRC_RESO (offset 0x10E44, printed page 9-113, `hi3516av300--Hi3516AV300-Datasheet.txt` line 40876).";

        field {
            name = "src_h";
            desc = "Source h. Chinese-only data sheet: description and value encoding not translated.";
            sw = rw;
            hw = r;
            reset = 0x0;
        } src_h[31:16];

        field {
            name = "src_w";
            desc = "Source w. Chinese-only data sheet: description and value encoding not translated.";
            sw = rw;
            hw = r;
            reset = 0x0;
        } src_w[15:0];
    } GFX_SRC_RESO @ 0x10E44;

    reg {
        name = "GFX_SRC_CROP";
        desc = "Data sheet 9.2.6 GFX_SRC_CROP (offset 0x10E48, printed page 9-113, `hi3516av300--Hi3516AV300-Datasheet.txt` line 40895).";

        field {
            name = "src_crop_y";
            desc = "Source crop y. Chinese-only data sheet: description and value encoding not translated.";
            sw = rw;
            hw = r;
            reset = 0x0;
        } src_crop_y[31:16];

        field {
            name = "src_crop_x";
            desc = "Source crop x. Chinese-only data sheet: description and value encoding not translated.";
            sw = rw;
            hw = r;
            reset = 0x0;
        } src_crop_x[15:0];
    } GFX_SRC_CROP @ 0x10E48;

    reg {
        name = "GFX_IRESO";
        desc = "Data sheet 9.2.6 GFX_IRESO (offset 0x10E4C, printed page 9-114, `hi3516av300--Hi3516AV300-Datasheet.txt` line 40918).";

        field {
            name = "ireso_h";
            desc = "Ireso h. Chinese-only data sheet: description and value encoding not translated.";
            sw = rw;
            hw = r;
            reset = 0x0;
        } ireso_h[31:16];

        field {
            name = "ireso_w";
            desc = "Ireso w. Chinese-only data sheet: description and value encoding not translated.";
            sw = rw;
            hw = r;
            reset = 0x0;
        } ireso_w[15:0];
    } GFX_IRESO @ 0x10E4C;

    reg {
        name = "GFX_CKEY_MAX";
        desc = "Data sheet 9.2.6 GFX_CKEY_MAX (offset 0x10F00, printed page 9-114, `hi3516av300--Hi3516AV300-Datasheet.txt` line 40939).";

        field {
            name = "Cokey_r_max";
            desc = "Cokey r max. Chinese-only data sheet: description and value encoding not translated.";
            sw = rw;
            hw = r;
            reset = 0x0;
        } Cokey_r_max[23:16];

        field {
            name = "key_g_max";
            desc = "Key g max. Chinese-only data sheet: description and value encoding not translated.";
            sw = rw;
            hw = r;
            reset = 0x0;
        } key_g_max[15:8];

        field {
            name = "key_b_max";
            desc = "Key b max. Chinese-only data sheet: description and value encoding not translated.";
            sw = rw;
            hw = r;
            reset = 0x0;
        } key_b_max[7:0];
    } GFX_CKEY_MAX @ 0x10F00;

    reg {
        name = "GFX_CKEY_MIN";
        desc = "Data sheet 9.2.6 GFX_CKEY_MIN (offset 0x10F04, printed page 9-114, `hi3516av300--Hi3516AV300-Datasheet.txt` line 40964).";

        field {
            name = "key_r_min";
            desc = "Key r min. Chinese-only data sheet: description and value encoding not translated.";
            sw = rw;
            hw = r;
            reset = 0x0;
        } key_r_min[23:16];

        field {
            name = "key_g_min";
            desc = "Key g min. Chinese-only data sheet: description and value encoding not translated.";
            sw = rw;
            hw = r;
            reset = 0x0;
        } key_g_min[15:8];

        field {
            name = "key_b_min";
            desc = "Key b min. Chinese-only data sheet: description and value encoding not translated.";
            sw = rw;
            hw = r;
            reset = 0x0;
        } key_b_min[7:0];
    } GFX_CKEY_MIN @ 0x10F04;

    reg {
        name = "GFX_CKEY_MASK";
        desc = "Data sheet 9.2.6 GFX_CKEY_MASK (offset 0x10F08, printed page 9-115, `hi3516av300--Hi3516AV300-Datasheet.txt` line 40989).";

        field {
            name = "key_r_msk";
            desc = "Key r mask. Chinese-only data sheet: description and value encoding not translated.";
            sw = rw;
            hw = r;
            reset = 0xFF;
        } key_r_msk[23:16];

        field {
            name = "key_g_msk";
            desc = "Key g mask. Chinese-only data sheet: description and value encoding not translated.";
            sw = rw;
            hw = r;
            reset = 0xFF;
        } key_g_msk[15:8];

        field {
            name = "key_b_msk";
            desc = "Key b mask. Chinese-only data sheet: description and value encoding not translated.";
            sw = rw;
            hw = r;
            reset = 0xFF;
        } key_b_msk[7:0];
    } GFX_CKEY_MASK @ 0x10F08;
};

`endif
