`ifndef HISI_ISP_RDL
`define HISI_ISP_RDL

// ISP (image signal processor) of the Hi3518EV200 / Hi3516CV200 (data sheet chapter 10); offsets rebased by -0x20000, instantiate at 0x205A0000.
regfile eHISI_ISP {
    name = "ISP (image signal processor)";
    desc = "
    Image signal processor (ISP) of the Hi3518E V20X / Hi3516C V200 (data sheet chapter 10): the pipeline between the VICAP sensor input and the VPSS: black level, static/dynamic defect pixel
    correction, FPN removal, bayer denoising, demosaic, gamma, DRC, sensor built-in WDR, AWB/AE/AF statistics, lens shading and distortion correction, sharpening, DIS, anti-fog, colour management;
    up to 14-bit bayer input, 2048 x 1208 maximum / 480 x 240 minimum. The ISP interrupt is part of the VICAP interrupt (VIC 22, data sheet 10.3: ISP_INT_* registers at 0x20080..0x200A4
    of this block).

    **Address:** the data sheet lists the ISP registers in the VICAP window with offsets 0x20080-0x32324 from the VICAP base 0x20580000 (Table 10-10 'base address 0x2058_0000'). This regfile
    is written with those offsets minus 0x20000 and is meant to be instantiated at 0x205A0000, so that it does not overlap the VICAP regfile at 0x20580000 (register ISP_VERSION is then at
    0x205A0080 = data sheet 0x20080). Register groups (data sheet 10.5): 0x20080 global/interrupt/timing, 0x200E0 input and format, 0x201xx YUV444/422 timing, 0x22000 AE, 0x22200 AF, 0x23000
    RGBIR/WB/..., 0x24000 sharpen/NR/LSC, 0x25000 ..., up to 0x32324.

    Register table: data sheet 10.5 / 10.6 (`hi3518ev200--Hi3518EV20X-Hi3516CV200-Datasheet.txt` lines 60690-75460), 465 registers transcribed mechanically from the data sheet (fields, access types, reset values, descriptions); 4 registers have
    no field descriptions in the data sheet. The ISP firmware of the vendor SDK is binary; nothing is hardware verified. Many registers are indirect table accesses (`*_WADDR` / `*_WDATA` /
    `*_RADDR` / `*_RDATA` pairs) into internal memories (gamma, LSC, DRC, histogram ...).
    ";

    reg {
        name = "ISP version register";
        desc = "ISP_VERSION is an ISP version register.

Data sheet 10.6 ISP_VERSION (offset 0x20080, printed page 10-43, `hi3518ev200--Hi3518EV20X-Hi3516CV200-Datasheet.txt` line 61786).";

        enum ISP_VERSION_version_enum {
            V100 = 0x1 { name = "V100"; desc = "V100"; };
            V200 = 0x2 { name = "V200"; desc = "V200"; };
            V300_SAME_RULE = 0x3 { name = "V300 Same Rule"; desc = "V300 The same rule applies to other values."; };
        };

        field {
            name = "version";
            desc = "ISP version";
            sw = r;
            hw = w;
            encode = ISP_VERSION_version_enum;
            reset = 0x1;
        } version[31:20];

        enum ISP_VERSION_build_enum {
            B01 = 1 { name = "B01"; desc = "B01"; };
            B02_SAME_RULE = 2 { name = "B02 Same Rule"; desc = "B02 The same rule applies to other values."; };
        };

        field {
            name = "build";
            desc = "Subversion number";
            sw = r;
            hw = w;
            encode = ISP_VERSION_build_enum;
            reset = 0x0;
        } build[19:16];

        field {
            name = "sn";
            desc = "Sequence number of the ISP version";
            sw = r;
            hw = w;
            reset = 0x0;
        } sn[15:0];
    } ISP_VERSION @ 0x80;

    reg {
        name = "ISP internal module position select register";
        desc = "ISP_MODULE_POS is an ISP internal module position select register.

Data sheet 10.6 ISP_MODULE_POS (offset 0x20088, printed page 10-43, `hi3518ev200--Hi3518EV20X-Hi3516CV200-Datasheet.txt` line 61815).";

        enum ISP_MODULE_POS_af_sel_enum {
            AF_MODULE_AFTER = 0 { name = "Af Module After"; desc = "The AF module is after the DG module."; };
            AF_MODULE_Y = 1 { name = "Af Module Y"; desc = "The AF module is in the Y field after the CSC module."; };
        };

        field {
            name = "af_sel";
            desc = "AF position adjustment register";
            sw = rw;
            hw = r;
            encode = ISP_MODULE_POS_af_sel_enum;
            reset = 0x0;
        } af_sel[3:3];

        enum ISP_MODULE_POS_ae_sel_enum {
            AE_MODULE_AFTER = 0 { name = "Ae Module After"; desc = "The AE module is after the DG module."; };
            AE_MODULE_AFTER_2 = 1 { name = "Ae Module After 2"; desc = "The AE module is after the WB module."; };
            AE_MODULE_AFTER_3 = 2 { name = "Ae Module After 3"; desc = "The AE module is after the DRC module."; };
        };

        field {
            name = "ae_sel";
            desc = "AE position adjustment register";
            sw = rw;
            hw = r;
            encode = ISP_MODULE_POS_ae_sel_enum;
            reset = 0x1;
        } ae_sel[2:1];

        enum ISP_MODULE_POS_dcg_sel_enum {
            DPC_GE_MODULE = 0 { name = "Dpc Ge Module"; desc = "The DPC/GE module is after the BLC module."; };
            DPC_GE_MODULE_2 = 1 { name = "Dpc Ge Module 2"; desc = "The DPC/GE module is after the DRC module."; };
        };

        field {
            name = "dcg_sel";
            desc = "DPC/GE position adjustment register";
            sw = rw;
            hw = r;
            encode = ISP_MODULE_POS_dcg_sel_enum;
            reset = 0x0;
        } dcg_sel[0:0];
    } ISP_MODULE_POS @ 0x88;

    reg {
        name = "ISP input switch register";
        desc = "ISP_CH_SWITCH is an ISP input switch register.

Data sheet 10.6 ISP_CH_SWITCH (offset 0x2008C, printed page 10-44, `hi3518ev200--Hi3518EV20X-Hi3516CV200-Datasheet.txt` line 61860).";

        enum ISP_CH_SWITCH_isp_ch_switch_4_enum {
            CHANNEL_0_INPUT = 0 { name = "Channel 0 Input"; desc = "channel 0 input"; };
            CHANNEL_1_INPUT = 1 { name = "Channel 1 Input"; desc = "channel 1 input"; };
            CHANNEL_2_INPUT = 2 { name = "Channel 2 Input"; desc = "channel 2 input"; };
            CHANNEL_3_INPUT = 3 { name = "Channel 3 Input"; desc = "channel 3 input Other values: FPN black frame input"; };
        };

        field {
            name = "isp_ch_switch_4";
            desc = "ISP FPN black frame input data select";
            sw = rw;
            hw = r;
            encode = ISP_CH_SWITCH_isp_ch_switch_4_enum;
            reset = 0x0;
        } isp_ch_switch_4[22:20];

        enum ISP_CH_SWITCH_isp_ch_switch_3_enum {
            CHANNEL_0_INPUT = 0 { name = "Channel 0 Input"; desc = "channel 0 input"; };
            CHANNEL_1_INPUT = 1 { name = "Channel 1 Input"; desc = "channel 1 input"; };
            CHANNEL_2_INPUT = 2 { name = "Channel 2 Input"; desc = "channel 2 input"; };
            FPN_BLACK_FRAME = 4 { name = "Fpn Black Frame"; desc = "FPN black frame input Other values: channel 3 input"; };
        };

        field {
            name = "isp_ch_switch_3";
            desc = "Input data select for ISP channel 3";
            sw = rw;
            hw = r;
            encode = ISP_CH_SWITCH_isp_ch_switch_3_enum;
            reset = 0x0;
        } isp_ch_switch_3[18:16];

        enum ISP_CH_SWITCH_isp_ch_switch_2_enum {
            CHANNEL_0_INPUT = 0 { name = "Channel 0 Input"; desc = "channel 0 input"; };
            CHANNEL_1_INPUT = 1 { name = "Channel 1 Input"; desc = "channel 1 input"; };
            CHANNEL_3_INPUT = 3 { name = "Channel 3 Input"; desc = "channel 3 input"; };
            FPN_BLACK_FRAME = 4 { name = "Fpn Black Frame"; desc = "FPN black frame input Other values: channel 2 input"; };
        };

        field {
            name = "isp_ch_switch_2";
            desc = "Input data select for ISP channel 2";
            sw = rw;
            hw = r;
            encode = ISP_CH_SWITCH_isp_ch_switch_2_enum;
            reset = 0x0;
        } isp_ch_switch_2[14:12];

        enum ISP_CH_SWITCH_isp_ch_switch_1_enum {
            CHANNEL_0_INPUT = 0 { name = "Channel 0 Input"; desc = "channel 0 input"; };
            CHANNEL_2_INPUT = 2 { name = "Channel 2 Input"; desc = "channel 2 input"; };
            CHANNEL_3_INPUT = 3 { name = "Channel 3 Input"; desc = "channel 3 input"; };
            FPN_BLACK_FRAME = 4 { name = "Fpn Black Frame"; desc = "FPN black frame input Other values: channel 1 input"; };
        };

        field {
            name = "isp_ch_switch_1";
            desc = "Input data select for ISP channel 1";
            sw = rw;
            hw = r;
            encode = ISP_CH_SWITCH_isp_ch_switch_1_enum;
            reset = 0x0;
        } isp_ch_switch_1[10:8];

        enum ISP_CH_SWITCH_isp_ch_switch_0_enum {
            CHANNEL_1_INPUT = 1 { name = "Channel 1 Input"; desc = "channel 1 input"; };
            CHANNEL_2_INPUT = 2 { name = "Channel 2 Input"; desc = "channel 2 input"; };
            CHANNEL_3_INPUT = 3 { name = "Channel 3 Input"; desc = "channel 3 input"; };
            FPN_BLACK_FRAME = 4 { name = "Fpn Black Frame"; desc = "FPN black frame input Other values: channel 0 input"; };
        };

        field {
            name = "isp_ch_switch_0";
            desc = "Input data select for ISP channel 0";
            sw = rw;
            hw = r;
            encode = ISP_CH_SWITCH_isp_ch_switch_0_enum;
            reset = 0x0;
        } isp_ch_switch_0[6:4];

        field {
            name = "isp_ch_switch_en";
            desc = "ISP input switch enable";
            sw = rw;
            hw = r;
            reset = 0x0;
        } isp_ch_switch_en[0:0];
    } ISP_CH_SWITCH @ 0x8C;

    reg {
        name = "ISP adjustable interrupt trigger time configuration register";
        desc = "ISP_INT_TIMING_CTRL is an ISP adjustable interrupt trigger time configuration register.

Data sheet 10.6 ISP_INT_TIMING_CTRL (offset 0x20090, printed page 10-46, `hi3518ev200--Hi3518EV20X-Hi3516CV200-Datasheet.txt` line 61945).";

        field {
            name = "timing_cnt";
            desc = "Adjustable interrupt trigger time";
            sw = rw;
            hw = r;
            reset = 0x00254310;
        } timing_cnt[31:0];
    } ISP_INT_TIMING_CTRL @ 0x90;

    reg {
        name = "ISP bypass register";
        desc = "ISP_ISPBYPASS is an ISP bypass register.

Data sheet 10.6 ISP_ISPBYPASS (offset 0x20094, printed page 10-46, `hi3518ev200--Hi3518EV20X-Hi3516CV200-Datasheet.txt` line 61964).";

        enum ISP_ISPBYPASS_isp_bypass_enum {
            EMBEDDED_ISP_USED = 0 { name = "Embedded Isp Used"; desc = "The embedded ISP is used."; };
            ISP_BYPASSED_DATA = 1 { name = "Isp Bypassed Data"; desc = "The ISP is bypassed and data is transparently transmitted from the FPN module to the 2DNR/demosaic module"; };
        };

        field {
            name = "isp_bypass";
            desc = "ISP bypass register";
            sw = rw;
            hw = r;
            encode = ISP_ISPBYPASS_isp_bypass_enum;
            reset = 0x0;
        } isp_bypass[0:0];
    } ISP_ISPBYPASS @ 0x94;

    reg {
        name = "ISP interrupt indicator register";
        desc = "ISP_INT is an ISP interrupt indicator register.

Data sheet 10.6 ISP_INT (offset 0x200F0, printed page 10-47, `hi3518ev200--Hi3518EV20X-Hi3516CV200-Datasheet.txt` line 62003).";

        enum ISP_INT_update_cfg_yuv444_enum {
            NO_INTERRUPT_GENERATED = 0 { name = "No Interrupt Generated"; desc = "No interrupt is generated."; };
            INTERRUPT_GENERATED = 1 { name = "Interrupt Generated"; desc = "An interrupt is generated."; };
        };

        field {
            name = "update_cfg_yuv444";
            desc = "Reserved ISP YUV444 register update interrupt status. Writing 1 clears this interrupt.";
            sw = rw;
            hw = w;
            onwrite = woclr;
            encode = ISP_INT_update_cfg_yuv444_enum;
            reset = 0x0;
        } update_cfg_yuv444[14:14];

        enum ISP_INT_cfg_loss_yuv444_enum {
            NO_INTERRUPT_GENERATED = 0 { name = "No Interrupt Generated"; desc = "No interrupt is generated."; };
            INTERRUPT_GENERATED = 1 { name = "Interrupt Generated"; desc = "An interrupt is generated."; };
        };

        field {
            name = "cfg_loss_yuv444";
            desc = "ISP YUV444 register configuration loss interrupt status. Writing 1 clears this interrupt.";
            sw = rw;
            hw = w;
            onwrite = woclr;
            encode = ISP_INT_cfg_loss_yuv444_enum;
            reset = 0x0;
        } cfg_loss_yuv444[13:13];

        enum ISP_INT_update_cfg_yuv422_enum {
            NO_INTERRUPT_GENERATED = 0 { name = "No Interrupt Generated"; desc = "No interrupt is generated."; };
            INTERRUPT_GENERATED = 1 { name = "Interrupt Generated"; desc = "An interrupt is generated."; };
        };

        field {
            name = "update_cfg_yuv422";
            desc = "ISP YUV422 register update interrupt status. Writing 1 clears this interrupt.";
            sw = rw;
            hw = w;
            onwrite = woclr;
            encode = ISP_INT_update_cfg_yuv422_enum;
            reset = 0x0;
        } update_cfg_yuv422[12:12];

        enum ISP_INT_field_throw_yuv422_enum {
            NO_INTERRUPT_GENERATED = 0 { name = "No Interrupt Generated"; desc = "No interrupt is generated."; };
            INTERRUPT_GENERATED = 1 { name = "Interrupt Generated"; desc = "An interrupt is generated."; };
        };

        field {
            name = "field_throw_yuv422";
            desc = "ISP YUV422 field/frame loss interrupt status. Writing 1 clears this interrupt.";
            sw = rw;
            hw = w;
            onwrite = woclr;
            encode = ISP_INT_field_throw_yuv422_enum;
            reset = 0x0;
        } field_throw_yuv422[11:11];

        field {
            name = "int_disstat";
            desc = "DIS current frame statistics completion interrupt";
            sw = rw;
            hw = w;
            onwrite = woclr;
            reset = 0x0;
        } int_disstat[10:10];

        enum ISP_INT_int_fstart_yuv422_enum {
            NO_INTERRUPT_GENERATED = 0 { name = "No Interrupt Generated"; desc = "No interrupt is generated."; };
            INTERRUPT_GENERATED = 1 { name = "Interrupt Generated"; desc = "An interrupt is generated."; };
        };

        field {
            name = "int_fstart_yuv422";
            desc = "ISP YUV422 module frame start interrupt";
            sw = rw;
            hw = w;
            onwrite = woclr;
            encode = ISP_INT_int_fstart_yuv422_enum;
            reset = 0x0;
        } int_fstart_yuv422[9:9];

        enum ISP_INT_int_afstat_enum {
            NO_INTERRUPT_GENERATED = 0 { name = "No Interrupt Generated"; desc = "No interrupt is generated."; };
            INTERRUPT_GENERATED = 1 { name = "Interrupt Generated"; desc = "An interrupt is generated."; };
        };

        field {
            name = "int_afstat";
            desc = "AF current frame statistics TX completion interrupt";
            sw = rw;
            hw = w;
            onwrite = woclr;
            encode = ISP_INT_int_afstat_enum;
            reset = 0x0;
        } int_afstat[6:6];

        enum ISP_INT_int_aestat_enum {
            NO_INTERRUPT_GENERATED = 0 { name = "No Interrupt Generated"; desc = "No interrupt is generated."; };
            INTERRUPT_GENERATED = 1 { name = "Interrupt Generated"; desc = "An interrupt is generated."; };
        };

        field {
            name = "int_aestat";
            desc = "AE current frame statistics TX completion interrupt";
            sw = rw;
            hw = w;
            onwrite = woclr;
            encode = ISP_INT_int_aestat_enum;
            reset = 0x0;
        } int_aestat[5:5];

        enum ISP_INT_int_awbstat_enum {
            NO_INTERRUPT_GENERATED = 0 { name = "No Interrupt Generated"; desc = "No interrupt is generated."; };
            INTERRUPT_GENERATED = 1 { name = "Interrupt Generated"; desc = "An interrupt is generated."; };
        };

        field {
            name = "int_awbstat";
            desc = "AWB current frame statistics TX completion interrupt";
            sw = rw;
            hw = w;
            onwrite = woclr;
            encode = ISP_INT_int_awbstat_enum;
            reset = 0x0;
        } int_awbstat[4:4];

        enum ISP_INT_int_user_yuv444_enum {
            NO_INTERRUPT_GENERATED = 0 { name = "No Interrupt Generated"; desc = "No interrupt is generated."; };
            INTERRUPT_GENERATED = 1 { name = "Interrupt Generated"; desc = "An interrupt is generated."; };
        };

        field {
            name = "int_user_yuv444";
            desc = "ISP YUV444 configurable trigger position interrupt";
            sw = rw;
            hw = w;
            onwrite = woclr;
            encode = ISP_INT_int_user_yuv444_enum;
            reset = 0x0;
        } int_user_yuv444[3:3];

        enum ISP_INT_int_fstart2_yuv444_enum {
            NO_INTERRUPT_GENERATED = 0 { name = "No Interrupt Generated"; desc = "No interrupt is generated."; };
            INTERRUPT_GENERATED = 1 { name = "Interrupt Generated"; desc = "An interrupt is generated."; };
        };

        field {
            name = "int_fstart2_yuv444";
            desc = "ISP YUV444 frame start interrupt indicator 2. Writing 1 clears this interrupt.";
            sw = rw;
            hw = w;
            onwrite = woclr;
            encode = ISP_INT_int_fstart2_yuv444_enum;
            reset = 0x0;
        } int_fstart2_yuv444[2:2];

        enum ISP_INT_acm_para_finish_enum {
            NO_INTERRUPT_GENERATED = 0 { name = "No Interrupt Generated"; desc = "No interrupt is generated."; };
            INTERRUPT_GENERATED = 1 { name = "Interrupt Generated"; desc = "An interrupt is generated."; };
        };

        field {
            name = "acm_para_finish";
            desc = "ACM lookup table load completion interrupt. Writing 1 clears this interrupt.";
            sw = rw;
            hw = w;
            onwrite = woclr;
            encode = ISP_INT_acm_para_finish_enum;
            reset = 0x0;
        } acm_para_finish[1:1];

        enum ISP_INT_int_fstart_yuv444_enum {
            NO_INTERRUPT_GENERATED = 0 { name = "No Interrupt Generated"; desc = "No interrupt is generated."; };
            INTERRUPT_GENERATED = 1 { name = "Interrupt Generated"; desc = "An interrupt is generated."; };
        };

        field {
            name = "int_fstart_yuv444";
            desc = "ISP YUV444 frame start interrupt indicator. Writing 1 clears this interrupt.";
            sw = rw;
            hw = w;
            onwrite = woclr;
            encode = ISP_INT_int_fstart_yuv444_enum;
            reset = 0x0;
        } int_fstart_yuv444[0:0];
    } ISP_INT @ 0xF0;

    reg {
        name = "ISP interrupt mask register";
        desc = "ISP_INT_MASK is an ISP interrupt mask register.

Data sheet 10.6 ISP_INT_MASK (offset 0x200F8, printed page 10-48, `hi3518ev200--Hi3518EV20X-Hi3516CV200-Datasheet.txt` line 62090).";

        enum ISP_INT_MASK_update_cfg_yuv444_enum {
            NO_INTERRUPT_GENERATED = 0 { name = "No Interrupt Generated"; desc = "No interrupt is generated."; };
            INTERRUPT_GENERATED = 1 { name = "Interrupt Generated"; desc = "An interrupt is generated."; };
        };

        field {
            name = "update_cfg_yuv444";
            desc = "ISP YUV444 register update interrupt enable";
            sw = rw;
            hw = r;
            encode = ISP_INT_MASK_update_cfg_yuv444_enum;
            reset = 0x0;
        } update_cfg_yuv444[14:14];

        enum ISP_INT_MASK_cfg_loss_yuv444_enum {
            MASKED = 0 { name = "Masked"; desc = "masked"; };
            ENABLED = 1 { name = "Enabled"; desc = "enabled"; };
        };

        field {
            name = "cfg_loss_yuv444";
            desc = "ISP YUV444 configuration loss interrupt enable";
            sw = rw;
            hw = r;
            encode = ISP_INT_MASK_cfg_loss_yuv444_enum;
            reset = 0x0;
        } cfg_loss_yuv444[13:13];

        enum ISP_INT_MASK_update_cfg_yuv422_enum {
            NO_INTERRUPT_GENERATED = 0 { name = "No Interrupt Generated"; desc = "No interrupt is generated."; };
            INTERRUPT_GENERATED = 1 { name = "Interrupt Generated"; desc = "An interrupt is generated."; };
        };

        field {
            name = "update_cfg_yuv422";
            desc = "ISP YUV422 register update interrupt enable";
            sw = rw;
            hw = r;
            encode = ISP_INT_MASK_update_cfg_yuv422_enum;
            reset = 0x0;
        } update_cfg_yuv422[12:12];

        enum ISP_INT_MASK_field_throw_yuv422_enum {
            MASKED = 0 { name = "Masked"; desc = "masked"; };
            ENABLED = 1 { name = "Enabled"; desc = "enabled"; };
        };

        field {
            name = "field_throw_yuv422";
            desc = "ISP YUV422 field/frame loss interrupt enable";
            sw = rw;
            hw = r;
            encode = ISP_INT_MASK_field_throw_yuv422_enum;
            reset = 0x0;
        } field_throw_yuv422[11:11];

        enum ISP_INT_MASK_int_disstat_enum {
            MASKED = 0 { name = "Masked"; desc = "masked"; };
            ENABLED = 1 { name = "Enabled"; desc = "enabled"; };
        };

        field {
            name = "int_disstat";
            desc = "DIS current frame statistics completion interrupt mask";
            sw = rw;
            hw = r;
            encode = ISP_INT_MASK_int_disstat_enum;
            reset = 0x0;
        } int_disstat[10:10];

        enum ISP_INT_MASK_int_fstart_yuv422_enum {
            MASKED = 0 { name = "Masked"; desc = "masked"; };
            ENABLED = 1 { name = "Enabled"; desc = "enabled"; };
        };

        field {
            name = "int_fstart_yuv422";
            desc = "ISP YUV422 module frame start interrupt mask";
            sw = rw;
            hw = r;
            encode = ISP_INT_MASK_int_fstart_yuv422_enum;
            reset = 0x0;
        } int_fstart_yuv422[9:9];

        enum ISP_INT_MASK_int_afstat_enum {
            MASKED = 0 { name = "Masked"; desc = "masked"; };
            ENABLED = 1 { name = "Enabled"; desc = "enabled"; };
        };

        field {
            name = "int_afstat";
            desc = "AF current frame statistics TX completion interrupt mask";
            sw = rw;
            hw = r;
            encode = ISP_INT_MASK_int_afstat_enum;
            reset = 0x0;
        } int_afstat[6:6];

        enum ISP_INT_MASK_int_aestat_enum {
            MASKED = 0 { name = "Masked"; desc = "masked"; };
            ENABLED = 1 { name = "Enabled"; desc = "enabled"; };
        };

        field {
            name = "int_aestat";
            desc = "AE current frame statistics TX completion interrupt mask";
            sw = rw;
            hw = r;
            encode = ISP_INT_MASK_int_aestat_enum;
            reset = 0x0;
        } int_aestat[5:5];

        enum ISP_INT_MASK_int_awbstat_enum {
            MASKED = 0 { name = "Masked"; desc = "masked"; };
            ENABLED = 1 { name = "Enabled"; desc = "enabled"; };
        };

        field {
            name = "int_awbstat";
            desc = "AWB current frame statistics TX completion interrupt mask";
            sw = rw;
            hw = r;
            encode = ISP_INT_MASK_int_awbstat_enum;
            reset = 0x0;
        } int_awbstat[4:4];

        enum ISP_INT_MASK_int_user_yuv444_enum {
            MASKED = 0 { name = "Masked"; desc = "masked"; };
            ENABLED = 1 { name = "Enabled"; desc = "enabled"; };
        };

        field {
            name = "int_user_yuv444";
            desc = "ISP YUV444 configurable trigger position interrupt mask";
            sw = rw;
            hw = r;
            encode = ISP_INT_MASK_int_user_yuv444_enum;
            reset = 0x0;
        } int_user_yuv444[3:3];

        enum ISP_INT_MASK_int_fstart2_yuv444_enum {
            MASKED = 0 { name = "Masked"; desc = "masked"; };
            ENABLED = 1 { name = "Enabled"; desc = "enabled"; };
        };

        field {
            name = "int_fstart2_yuv444";
            desc = "ISP YUV444 frame start interrupt mask 2";
            sw = rw;
            hw = r;
            encode = ISP_INT_MASK_int_fstart2_yuv444_enum;
            reset = 0x0;
        } int_fstart2_yuv444[2:2];

        enum ISP_INT_MASK_acm_para_finish_enum {
            MASKED = 0 { name = "Masked"; desc = "masked"; };
            ENABLED = 1 { name = "Enabled"; desc = "enabled"; };
        };

        field {
            name = "acm_para_finish";
            desc = "ACM lookup table load completion interrupt mask";
            sw = rw;
            hw = r;
            encode = ISP_INT_MASK_acm_para_finish_enum;
            reset = 0x0;
        } acm_para_finish[1:1];

        enum ISP_INT_MASK_int_fstart_yuv444_enum {
            MASKED = 0 { name = "Masked"; desc = "masked"; };
            ENABLED = 1 { name = "Enabled"; desc = "enabled"; };
        };

        field {
            name = "int_fstart_yuv444";
            desc = "ISP YUV444 frame start interrupt mask";
            sw = rw;
            hw = r;
            encode = ISP_INT_MASK_int_fstart_yuv444_enum;
            reset = 0x0;
        } int_fstart_yuv444[0:0];
    } ISP_INT_MASK @ 0xF8;

    reg {
        name = "ISP general update control register";
        desc = "ISP_YUV444_CTRL_F is an ISP general update control register.

Data sheet 10.6 ISP_YUV444_CTRL_F (offset 0x201E0, printed page 10-50, `hi3518ev200--Hi3518EV20X-Hi3516CV200-Datasheet.txt` line 62178).";

        enum ISP_YUV444_CTRL_F_rggb_cfg_enum {
            R_GR_GB = 0 { name = "R Gr Gb"; desc = "R Gr Gb B"; };
            GR_R_B = 1 { name = "Gr R B"; desc = "Gr R B Gb"; };
            GB_B_R = 2 { name = "Gb B R"; desc = "Gb B R Gr"; };
            B_GB_GR = 3 { name = "B Gb Gr"; desc = "B Gb Gr R"; };
        };

        field {
            name = "rggb_cfg";
            desc = "ISP YUV444 RGGB start";
            sw = rw;
            hw = r;
            encode = ISP_YUV444_CTRL_F_rggb_cfg_enum;
            reset = 0x3;
        } rggb_cfg[1:0];
    } ISP_YUV444_CTRL_F @ 0x1E0;

    reg {
        name = "ISP immediate update control register";
        desc = "ISP_YUV444_CTRL_I is an ISP immediate update control register.

Data sheet 10.6 ISP_YUV444_CTRL_I (offset 0x201E4, printed page 10-51, `hi3518ev200--Hi3518EV20X-Hi3516CV200-Datasheet.txt` line 62217).";

        enum ISP_YUV444_CTRL_I_update_mode_enum {
            ISP_YUV444_REG = 0 { name = "Isp Yuv444 Reg"; desc = "ISP_YUV444_REG_UPDATE update mode"; };
            FRAME_UPDATE_MODE = 1 { name = "Frame Update Mode"; desc = "frame update mode"; };
        };

        field {
            name = "update_mode";
            desc = "ISP YUV444 register update mode";
            sw = rw;
            hw = r;
            encode = ISP_YUV444_CTRL_I_update_mode_enum;
            reset = 0x0;
        } update_mode[0:0];
    } ISP_YUV444_CTRL_I @ 0x1E4;

    reg {
        name = "Output timing configuration register G";
        desc = "ISP_YUV444_TIMING_CFG is an output timing configuration register.

Data sheet 10.6 ISP_YUV444_TIMING_CFG (offset 0x201E8, printed page 10-51, `hi3518ev200--Hi3518EV20X-Hi3516CV200-Datasheet.txt` line 62245).";

        field {
            name = "cpi_fix_timing_stat";
            desc = "ISP YUV444 manual timing parameter configuration. The length of the generated line blanking region is configured.";
            sw = rw;
            hw = r;
            reset = 0x40;
        } cpi_fix_timing_stat[13:1];
    } ISP_YUV444_TIMING_CFG @ 0x1E8;

    reg {
        name = "Register update register TE";
        desc = "ISP_YUV444_REG_UPDATE is a register update register.

Data sheet 10.6 ISP_YUV444_REG_UPDATE (offset 0x201EC, printed page 10-52, `hi3518ev200--Hi3518EV20X-Hi3516CV200-Datasheet.txt` line 62280).";

        field {
            name = "update";
            desc = "ISP YUV444 update register. This bit is automatically cleared for each frame.";
            sw = rw;
            hw = r;
            reset = 0x0;
        } update[0:0];
    } ISP_YUV444_REG_UPDATE @ 0x1EC;

    reg {
        name = "Picture width/height register";
        desc = "ISP_YUV444_SIZE is a picture width/height register.

Data sheet 10.6 ISP_YUV444_SIZE (offset 0x201F0, printed page 10-52, `hi3518ev200--Hi3518EV20X-Hi3516CV200-Datasheet.txt` line 62303).";

        field {
            name = "height";
            desc = "ISP YUV444 picture height. The configured value is the actual height minus 1. For example, if the actual picture height is 1080, this field needs to be set to 1079.";
            sw = rw;
            hw = r;
            reset = 0x437;
        } height[27:16];

        field {
            name = "width";
            desc = "ISP YUV444 picture width. The configured value is the actual width minus 1. For example, if the actual picture width is 1920, this field needs to be set to 1919.";
            sw = rw;
            hw = r;
            reset = 0x77F;
        } width[11:0];
    } ISP_YUV444_SIZE @ 0x1F0;

    reg {
        name = "ISP general update control register";
        desc = "ISP_YUV422_CTRL_F is an ISP general update control register.

Data sheet 10.6 ISP_YUV422_CTRL_F (offset 0x202E0, printed page 10-53, `hi3518ev200--Hi3518EV20X-Hi3516CV200-Datasheet.txt` line 62337).";

        enum ISP_YUV422_CTRL_F_rggb_cfg_enum {
            R_GR_GB = 0 { name = "R Gr Gb"; desc = "R Gr Gb B"; };
            GR_R_B = 1 { name = "Gr R B"; desc = "Gr R B Gb"; };
            GB_B_R = 2 { name = "Gb B R"; desc = "Gb B R Gr"; };
            B_GB_GR = 3 { name = "B Gb Gr"; desc = "B Gb Gr R"; };
        };

        field {
            name = "rggb_cfg";
            desc = "ISP YUV422 RGGB start";
            sw = rw;
            hw = r;
            encode = ISP_YUV422_CTRL_F_rggb_cfg_enum;
            reset = 0x3;
        } rggb_cfg[1:0];
    } ISP_YUV422_CTRL_F @ 0x2E0;

    reg {
        name = "ISP immediate update control register";
        desc = "ISP_YUV422_CTRL_I is an ISP immediate update control register.

Data sheet 10.6 ISP_YUV422_CTRL_I (offset 0x202E4, printed page 10-53, `hi3518ev200--Hi3518EV20X-Hi3516CV200-Datasheet.txt` line 62366).";

        enum ISP_YUV422_CTRL_I_update_mode_enum {
            ISP_YUV422_REG = 0 { name = "Isp Yuv422 Reg"; desc = "ISP_YUV422_REG_UPDATE update mode"; };
            FRAME_U_PDATE = 1 { name = "Frame U Pdate"; desc = "frame u pdate mode"; };
        };

        field {
            name = "update_mode";
            desc = "ISP YUV422 register update mode";
            sw = rw;
            hw = r;
            encode = ISP_YUV422_CTRL_I_update_mode_enum;
            reset = 0x0;
        } update_mode[0:0];
    } ISP_YUV422_CTRL_I @ 0x2E4;

    reg {
        name = "Output timing configuration register G";
        desc = "ISP_YUV422_TIMING_CFG is an output timing configuration register.

Data sheet 10.6 ISP_YUV422_TIMING_CFG (offset 0x202E8, printed page 10-54, `hi3518ev200--Hi3518EV20X-Hi3516CV200-Datasheet.txt` line 62402).";

        field {
            name = "cpi_fix_timing_stat";
            desc = "ISP YUV422 manual timing parameter configuration. The length of the generated line blanking region is configured.";
            sw = rw;
            hw = r;
            reset = 0x40;
        } cpi_fix_timing_stat[13:1];
    } ISP_YUV422_TIMING_CFG @ 0x2E8;

    reg {
        name = "Register update register TE";
        desc = "ISP_YUV422_REG_UPDATE is a register update register.

Data sheet 10.6 ISP_YUV422_REG_UPDATE (offset 0x202EC, printed page 10-54, `hi3518ev200--Hi3518EV20X-Hi3516CV200-Datasheet.txt` line 62427).";

        field {
            name = "update";
            desc = "ISP YUV422 update register. This bit is automatically cleared for each frame.";
            sw = rw;
            hw = r;
            reset = 0x0;
        } update[0:0];
    } ISP_YUV422_REG_UPDATE @ 0x2EC;

    reg {
        name = "Picture width/height register";
        desc = "ISP_YUV422_SIZE is a picture width/height register.

Data sheet 10.6 ISP_YUV422_SIZE (offset 0x202F0, printed page 10-55, `hi3518ev200--Hi3518EV20X-Hi3516CV200-Datasheet.txt` line 62459).";

        field {
            name = "height";
            desc = "ISP YUV422 picture height. The configured value is the actual height minus 1. For example, if the actual picture height is 1080, this field needs to be set to 1079.";
            sw = rw;
            hw = r;
            reset = 0x437;
        } height[27:16];

        field {
            name = "width";
            desc = "ISP YUV422 picture width. The configured value is the actual width minus 1. For example, if the actual picture width is 1920, this field needs to be set to 1919.";
            sw = rw;
            hw = r;
            reset = 0x77F;
        } width[11:0];
    } ISP_YUV422_SIZE @ 0x2F0;

    reg {
        name = "BLC control register";
        desc = "ISP_BLC_CFG is a BLC control register.

Data sheet 10.6 ISP_BLC_CFG (offset 0x21000, printed page 10-55, `hi3518ev200--Hi3518EV20X-Hi3516CV200-Datasheet.txt` line 62485).";

        enum ISP_BLC_CFG_en_enum {
            DISABLED = 0 { name = "Disabled"; desc = "disabled"; };
            ENABLED = 1 { name = "Enabled"; desc = "enabled"; };
        };

        field {
            name = "en";
            desc = "BLC enable";
            sw = rw;
            hw = r;
            encode = ISP_BLC_CFG_en_enum;
            reset = 0x0;
        } en[0:0];
    } ISP_BLC_CFG @ 0x1000;

    reg {
        name = "BLC offset register 1";
        desc = "ISP_BLC_OFFSET1 is BLC offset register 1.

Data sheet 10.6 ISP_BLC_OFFSET1 (offset 0x21010, printed page 10-56, `hi3518ev200--Hi3518EV20X-Hi3516CV200-Datasheet.txt` line 62516).";

        field {
            name = "ofsr";
            desc = "BLC offset of the R component, S14";
            sw = rw;
            hw = r;
            reset = 0x0;
        } ofsr[29:16];

        field {
            name = "ofsgr";
            desc = "BLC offset of the Gr component, S14";
            sw = rw;
            hw = r;
            reset = 0x0;
        } ofsgr[13:0];
    } ISP_BLC_OFFSET1 @ 0x1010;

    reg {
        name = "BLC offset register 2";
        desc = "ISP_BLC_OFFSET2 is BLC offset register 2.

Data sheet 10.6 ISP_BLC_OFFSET2 (offset 0x21014, printed page 10-56, `hi3518ev200--Hi3518EV20X-Hi3516CV200-Datasheet.txt` line 62541).";

        field {
            name = "ofsb";
            desc = "BLC offset of the B component, S14";
            sw = rw;
            hw = r;
            reset = 0x0;
        } ofsb[29:16];

        field {
            name = "ofsgb";
            desc = "BLC offset of the Gb component, S14";
            sw = rw;
            hw = r;
            reset = 0x0;
        } ofsgb[13:0];
    } ISP_BLC_OFFSET2 @ 0x1014;

    reg {
        name = "WB control register";
        desc = "ISP_WB_CFG is a WB control register.

Data sheet 10.6 ISP_WB_CFG (offset 0x21100, printed page 10-57, `hi3518ev200--Hi3518EV20X-Hi3516CV200-Datasheet.txt` line 62576).";

        enum ISP_WB_CFG_en_enum {
            DISABLED = 0 { name = "Disabled"; desc = "disabled"; };
            ENABLED = 1 { name = "Enabled"; desc = "enabled"; };
        };

        field {
            name = "en";
            desc = "WB enable";
            sw = rw;
            hw = r;
            encode = ISP_WB_CFG_en_enum;
            reset = 0x0;
        } en[0:0];
    } ISP_WB_CFG @ 0x1100;

    reg {
        name = "WB gain (R & Gr) register";
        desc = "ISP_WB_GAIN1 is a WB gain (R & Gr) register.

Data sheet 10.6 ISP_WB_GAIN1 (offset 0x21110, printed page 10-57, `hi3518ev200--Hi3518EV20X-Hi3516CV200-Datasheet.txt` line 62598).";

        field {
            name = "rgain";
            desc = "WB R gain, U4.8";
            sw = rw;
            hw = r;
            reset = 0x100;
        } rgain[27:16];

        field {
            name = "grgain";
            desc = "WB Gr gain, U4.8";
            sw = rw;
            hw = r;
            reset = 0x100;
        } grgain[11:0];
    } ISP_WB_GAIN1 @ 0x1110;

    reg {
        name = "WB gain (B & Gb) register";
        desc = "ISP_WB_GAIN2 is a WB gain (B & Gb) register.

Data sheet 10.6 ISP_WB_GAIN2 (offset 0x21114, printed page 10-58, `hi3518ev200--Hi3518EV20X-Hi3516CV200-Datasheet.txt` line 62629).";

        field {
            name = "bgain";
            desc = "WB B gain, U4.8";
            sw = rw;
            hw = r;
            reset = 0x100;
        } bgain[27:16];

        field {
            name = "gbgain";
            desc = "WB Gb gain, U4.8";
            sw = rw;
            hw = r;
            reset = 0x100;
        } gbgain[11:0];
    } ISP_WB_GAIN2 @ 0x1114;

    reg {
        name = "CCM enable register";
        desc = "ISP_CCM_CFG is a CCM enable register.

Data sheet 10.6 ISP_CCM_CFG (offset 0x21200, printed page 10-58, `hi3518ev200--Hi3518EV20X-Hi3516CV200-Datasheet.txt` line 62651).";

        enum ISP_CCM_CFG_en_enum {
            DISABLED = 0 { name = "Disabled"; desc = "disabled"; };
            ENABLED = 1 { name = "Enabled"; desc = "enabled"; };
        };

        field {
            name = "en";
            desc = "CCM enable";
            sw = rw;
            hw = r;
            encode = ISP_CCM_CFG_en_enum;
            reset = 0x0;
        } en[0:0];
    } ISP_CCM_CFG @ 0x1200;

    reg {
        name = "CCM coefficient register 0";
        desc = "ISP_CCM_COEF0 is CCM coefficient register 0.

Data sheet 10.6 ISP_CCM_COEF0 (offset 0x21210, printed page 10-59, `hi3518ev200--Hi3518EV20X-Hi3516CV200-Datasheet.txt` line 62682).";

        field {
            name = "coef01";
            desc = "CCM coefficient Its format is S5.10. The value is a signed number consisting of a 4- bit integral part and a 10-bit decimal part.";
            sw = rw;
            hw = r;
            reset = 0x0;
        } coef01[31:17];

        field {
            name = "coef00";
            desc = "CCM coefficient Its format is S5.10. The value is a signed number consisting of a 4- bit integral part and a 10-bit decimal part.";
            sw = rw;
            hw = r;
            reset = 0x0;
        } coef00[15:1];
    } ISP_CCM_COEF0 @ 0x1210;

    reg {
        name = "CCM coefficient register 1";
        desc = "ISP_CCM_COEF1 is CCM coefficient register 1.

Data sheet 10.6 ISP_CCM_COEF1 (offset 0x21214, printed page 10-59, `hi3518ev200--Hi3518EV20X-Hi3516CV200-Datasheet.txt` line 62710).";

        field {
            name = "coef10";
            desc = "CCM coefficient Its format is S5.10. The value is a signed number consisting of a 4- bit integral part and a 10-bit decimal part.";
            sw = rw;
            hw = r;
            reset = 0x0;
        } coef10[31:17];

        field {
            name = "coef02";
            desc = "CCM coefficient Its format is S5.10. The value is a signed number consisting of a 4- bit integral part and a 10-bit decimal part.";
            sw = rw;
            hw = r;
            reset = 0x0;
        } coef02[15:1];
    } ISP_CCM_COEF1 @ 0x1214;

    reg {
        name = "CCM coefficient register 2";
        desc = "ISP_CCM_COEF2 is CCM coefficient register 2.

Data sheet 10.6 ISP_CCM_COEF2 (offset 0x21218, printed page 10-60, `hi3518ev200--Hi3518EV20X-Hi3516CV200-Datasheet.txt` line 62749).";

        field {
            name = "coef12";
            desc = "CCM coefficient Its format is S5.10. The value is a signed number consisting of a 4- bit integral part and a 10-bit decimal part.";
            sw = rw;
            hw = r;
            reset = 0x0;
        } coef12[31:17];

        field {
            name = "coef11";
            desc = "CCM coefficient Its format is S5.10. The value is a signed number consisting of a 4- bit integral part and a 10-bit decimal part.";
            sw = rw;
            hw = r;
            reset = 0x0;
        } coef11[15:1];
    } ISP_CCM_COEF2 @ 0x1218;

    reg {
        name = "CCM coefficient register 3";
        desc = "ISP_CCM_COEF3 is CCM coefficient register 3.

Data sheet 10.6 ISP_CCM_COEF3 (offset 0x2121C, printed page 10-61, `hi3518ev200--Hi3518EV20X-Hi3516CV200-Datasheet.txt` line 62787).";

        field {
            name = "coef21";
            desc = "CCM coefficient Its format is S5.10. The value is a signed number consisting of a 4- bit integral part and a 10-bit decimal part.";
            sw = rw;
            hw = r;
            reset = 0x0;
        } coef21[31:17];

        field {
            name = "coef20";
            desc = "CCM coefficient Its format is S5.10. The value is a signed number consisting of a 4- bit integral part and a 10-bit decimal part.";
            sw = rw;
            hw = r;
            reset = 0x0;
        } coef20[15:1];
    } ISP_CCM_COEF3 @ 0x121C;

    reg {
        name = "CCM coefficient register 4";
        desc = "ISP_CCM_COEF4 is CCM coefficient register 4.

Data sheet 10.6 ISP_CCM_COEF4 (offset 0x21220, printed page 10-61, `hi3518ev200--Hi3518EV20X-Hi3516CV200-Datasheet.txt` line 62815).";

        field {
            name = "coef22";
            desc = "CCM coefficient Its format is S5.10. The value is a signed number consisting of a 4- bit integral part and a 10-bit decimal part.";
            sw = rw;
            hw = r;
            reset = 0x0;
        } coef22[15:1];
    } ISP_CCM_COEF4 @ 0x1220;

    reg {
        name = "CCM input direct current (DC) component register 0";
        desc = "ISP_CCM_IN_DC0 is CCM input DC component register 0.

Data sheet 10.6 ISP_CCM_IN_DC0 (offset 0x21230, printed page 10-62, `hi3518ev200--Hi3518EV20X-Hi3516CV200-Datasheet.txt` line 62849).";

        field {
            name = "in_dc1";
            desc = "DC offset of the input G component, signed integer";
            sw = rw;
            hw = r;
            reset = 0x0;
        } in_dc1[31:21];

        field {
            name = "in_dc0";
            desc = "DC offset of the input R component, signed integer";
            sw = rw;
            hw = r;
            reset = 0x0;
        } in_dc0[15:5];
    } ISP_CCM_IN_DC0 @ 0x1230;

    reg {
        name = "CCM input DC component register 1";
        desc = "ISP_CCM_IN_DC1 is CCM input DC component register 1.

Data sheet 10.6 ISP_CCM_IN_DC1 (offset 0x21234, printed page 10-62, `hi3518ev200--Hi3518EV20X-Hi3516CV200-Datasheet.txt` line 62871).";

        field {
            name = "in_dc2";
            desc = "DC offset of the input B component, signed integer";
            sw = rw;
            hw = r;
            reset = 0x0;
        } in_dc2[15:5];
    } ISP_CCM_IN_DC1 @ 0x1234;

    reg {
        name = "CCM output DC component register 0";
        desc = "ISP_CCM_OUT_DC0 is CCM output DC component register 0.

Data sheet 10.6 ISP_CCM_OUT_DC0 (offset 0x21240, printed page 10-63, `hi3518ev200--Hi3518EV20X-Hi3516CV200-Datasheet.txt` line 62901).";

        field {
            name = "out_dc1";
            desc = "DC offset of the output U component, signed integer";
            sw = rw;
            hw = r;
            reset = 0x0;
        } out_dc1[31:21];

        field {
            name = "out_dc0";
            desc = "DC offset of the output Y component, signed integer";
            sw = rw;
            hw = r;
            reset = 0x0;
        } out_dc0[15:5];
    } ISP_CCM_OUT_DC0 @ 0x1240;

    reg {
        name = "CCM output DC component register 1";
        desc = "ISP_CCM_OUT_DC1 is CCM output DC component register 1.

Data sheet 10.6 ISP_CCM_OUT_DC1 (offset 0x21244, printed page 10-63, `hi3518ev200--Hi3518EV20X-Hi3516CV200-Datasheet.txt` line 62923).";

        field {
            name = "out_dc2";
            desc = "DC offset of the output V component, signed integer";
            sw = rw;
            hw = r;
            reset = 0x0;
        } out_dc2[15:5];
    } ISP_CCM_OUT_DC1 @ 0x1244;

    reg {
        name = "CSC enable register";
        desc = "ISP_CSC_CFG is a CSC enable register.

Data sheet 10.6 ISP_CSC_CFG (offset 0x21300, printed page 10-64, `hi3518ev200--Hi3518EV20X-Hi3516CV200-Datasheet.txt` line 62954).";

        enum ISP_CSC_CFG_en_enum {
            DISABLED = 0 { name = "Disabled"; desc = "disabled"; };
            ENABLED = 1 { name = "Enabled"; desc = "enabled"; };
        };

        field {
            name = "en";
            desc = "CSC enable";
            sw = rw;
            hw = r;
            encode = ISP_CSC_CFG_en_enum;
            reset = 0x0;
        } en[0:0];
    } ISP_CSC_CFG @ 0x1300;

    reg {
        name = "CSC coefficient register 0";
        desc = "ISP_CSC_COEF0 is CSC coefficient register 0.

Data sheet 10.6 ISP_CSC_COEF0 (offset 0x21310, printed page 10-64, `hi3518ev200--Hi3518EV20X-Hi3516CV200-Datasheet.txt` line 62976).";

        field {
            name = "coef01";
            desc = "CSC coefficient Its format is S5.10. The value is a signed number consisting of a 4- bit integral part and a 10-bit decimal part.";
            sw = rw;
            hw = r;
            reset = 0x0;
        } coef01[31:17];

        field {
            name = "coef00";
            desc = "CSC coefficient Its format is S5.10. The value is a signed number consisting of a 4- bit integral part and a 10-bit decimal part.";
            sw = rw;
            hw = r;
            reset = 0x0;
        } coef00[15:1];
    } ISP_CSC_COEF0 @ 0x1310;

    reg {
        name = "CSC coefficient register 1";
        desc = "ISP_CSC_COEF1 is CSC coefficient register 1.

Data sheet 10.6 ISP_CSC_COEF1 (offset 0x21314, printed page 10-65, `hi3518ev200--Hi3518EV20X-Hi3516CV200-Datasheet.txt` line 63013).";

        field {
            name = "coef10";
            desc = "CSC coefficient Its format is S5.10. The value is a signed number consisting of a 4- bit integral part and a 10-bit decimal part.";
            sw = rw;
            hw = r;
            reset = 0x0;
        } coef10[31:17];

        field {
            name = "coef02";
            desc = "CSC coefficient Its format is S5.10. The value is a signed number consisting of a 4- bit integral part and a 10-bit decimal part.";
            sw = rw;
            hw = r;
            reset = 0x0;
        } coef02[15:1];
    } ISP_CSC_COEF1 @ 0x1314;

    reg {
        name = "CSC coefficient register 2";
        desc = "ISP_CSC_COEF2 is CSC coefficient register 2.

Data sheet 10.6 ISP_CSC_COEF2 (offset 0x21318, printed page 10-65, `hi3518ev200--Hi3518EV20X-Hi3516CV200-Datasheet.txt` line 63041).";

        field {
            name = "coef12";
            desc = "CSC coefficient Its format is S5.10. The value is a signed number consisting of a 4- bit integral part and a 10-bit decimal part.";
            sw = rw;
            hw = r;
            reset = 0x0;
        } coef12[31:17];

        field {
            name = "coef11";
            desc = "CSC coefficient Its format is S5.10. The value is a signed number consisting of a 4- bit integral part and a 10-bit decimal part.";
            sw = rw;
            hw = r;
            reset = 0x0;
        } coef11[15:1];
    } ISP_CSC_COEF2 @ 0x1318;

    reg {
        name = "CSC coefficient register 3";
        desc = "ISP_CSC_COEF3 is CSC coefficient register 3.

Data sheet 10.6 ISP_CSC_COEF3 (offset 0x2131C, printed page 10-66, `hi3518ev200--Hi3518EV20X-Hi3516CV200-Datasheet.txt` line 63080).";

        field {
            name = "coef21";
            desc = "CSC coefficient Its format is S5.10. The value is a signed number consisting of a 4- bit integral part and a 10-bit decimal part.";
            sw = rw;
            hw = r;
            reset = 0x0;
        } coef21[31:17];

        field {
            name = "coef20";
            desc = "CSC coefficient Its format is S5.10. The value is a signed number consisting of a 4- bit integral part and a 10-bit decimal part.";
            sw = rw;
            hw = r;
            reset = 0x0;
        } coef20[15:1];
    } ISP_CSC_COEF3 @ 0x131C;

    reg {
        name = "CSC coefficient register 4";
        desc = "ISP_CSC_COEF4 is CSC coefficient register 4.

Data sheet 10.6 ISP_CSC_COEF4 (offset 0x21320, printed page 10-66, `hi3518ev200--Hi3518EV20X-Hi3516CV200-Datasheet.txt` line 63109).";

        field {
            name = "coef22";
            desc = "CSC coefficient Its format is S5.10. The value is a signed number consisting of a 4- bit integral part and a 10-bit decimal part.";
            sw = rw;
            hw = r;
            reset = 0x0;
        } coef22[15:1];
    } ISP_CSC_COEF4 @ 0x1320;

    reg {
        name = "CSC input DC component register 0";
        desc = "ISP_CSC_IN_DC0 is CSC input DC component register 0.

Data sheet 10.6 ISP_CSC_IN_DC0 (offset 0x21330, printed page 10-67, `hi3518ev200--Hi3518EV20X-Hi3516CV200-Datasheet.txt` line 63146).";

        field {
            name = "in_dc1";
            desc = "DC offset of the input G component, signed integer";
            sw = rw;
            hw = r;
            reset = 0x0;
        } in_dc1[31:21];

        field {
            name = "in_dc0";
            desc = "DC offset of the input R component, signed integer";
            sw = rw;
            hw = r;
            reset = 0x0;
        } in_dc0[15:5];
    } ISP_CSC_IN_DC0 @ 0x1330;

    reg {
        name = "CSC input DC component register 1";
        desc = "ISP_CSC_IN_DC1 is CSC input DC component register 1.

Data sheet 10.6 ISP_CSC_IN_DC1 (offset 0x21334, printed page 10-67, `hi3518ev200--Hi3518EV20X-Hi3516CV200-Datasheet.txt` line 63168).";

        field {
            name = "in_dc2";
            desc = "DC offset of the input B component, signed integer";
            sw = rw;
            hw = r;
            reset = 0x0;
        } in_dc2[15:5];
    } ISP_CSC_IN_DC1 @ 0x1334;

    reg {
        name = "CSC output DC component register 0";
        desc = "ISP_CSC_OUT_DC0 is CSC output DC component register 0.

Data sheet 10.6 ISP_CSC_OUT_DC0 (offset 0x21340, printed page 10-68, `hi3518ev200--Hi3518EV20X-Hi3516CV200-Datasheet.txt` line 63199).";

        field {
            name = "out_dc1";
            desc = "DC offset of the output U component, signed integer";
            sw = rw;
            hw = r;
            reset = 0x0;
        } out_dc1[31:21];

        field {
            name = "out_dc0";
            desc = "DC offset of the output Y component, signed integer";
            sw = rw;
            hw = r;
            reset = 0x0;
        } out_dc0[15:5];
    } ISP_CSC_OUT_DC0 @ 0x1340;

    reg {
        name = "CSC output DC component register 1";
        desc = "ISP_CSC_OUT_DC1 is CSC output DC component register 1.

Data sheet 10.6 ISP_CSC_OUT_DC1 (offset 0x21344, printed page 10-68, `hi3518ev200--Hi3518EV20X-Hi3516CV200-Datasheet.txt` line 63220).";

        field {
            name = "out_dc2";
            desc = "DC offset of the output V component, signed integer";
            sw = rw;
            hw = r;
            reset = 0x0;
        } out_dc2[15:5];
    } ISP_CSC_OUT_DC1 @ 0x1344;

    reg {
        name = "DG control register";
        desc = "ISP_DG_CFG is a DG control register.

Data sheet 10.6 ISP_DG_CFG (offset 0x21400, printed page 10-69, `hi3518ev200--Hi3518EV20X-Hi3516CV200-Datasheet.txt` line 63250).";

        enum ISP_DG_CFG_en_enum {
            DISABLED = 0 { name = "Disabled"; desc = "disabled"; };
            ENABLED = 1 { name = "Enabled"; desc = "enabled"; };
        };

        field {
            name = "en";
            desc = "DG enable";
            sw = rw;
            hw = r;
            encode = ISP_DG_CFG_en_enum;
            reset = 0x0;
        } en[0:0];
    } ISP_DG_CFG @ 0x1400;

    reg {
        name = "DG gain (R & Gr) register";
        desc = "ISP_DG_GAIN1 is a DG gain (R & Gr) register.

Data sheet 10.6 ISP_DG_GAIN1 (offset 0x21410, printed page 10-69, `hi3518ev200--Hi3518EV20X-Hi3516CV200-Datasheet.txt` line 63272).";

        field {
            name = "rgain";
            desc = "DG R gain, U8.8";
            sw = rw;
            hw = r;
            reset = 0x100;
        } rgain[31:16];

        field {
            name = "grgain";
            desc = "DG Gr gain, U8.8";
            sw = rw;
            hw = r;
            reset = 0x100;
        } grgain[15:0];
    } ISP_DG_GAIN1 @ 0x1410;

    reg {
        name = "DG gain (B & Gb) register";
        desc = "ISP_DG_GAIN2 is a DG gain (B & Gb) register.

Data sheet 10.6 ISP_DG_GAIN2 (offset 0x21414, printed page 10-69, `hi3518ev200--Hi3518EV20X-Hi3516CV200-Datasheet.txt` line 63292).";

        field {
            name = "bgain";
            desc = "DG B gain, U8.8";
            sw = rw;
            hw = r;
            reset = 0x100;
        } bgain[31:16];

        field {
            name = "gbgain";
            desc = "DG Gb gain, U8.8";
            sw = rw;
            hw = r;
            reset = 0x100;
        } gbgain[15:0];
    } ISP_DG_GAIN2 @ 0x1414;

    reg {
        name = "UVNR control register";
        desc = "ISP_UVNR_CFG is a UVNR control register.

Data sheet 10.6 ISP_UVNR_CFG (offset 0x21600, printed page 10-70, `hi3518ev200--Hi3518EV20X-Hi3516CV200-Datasheet.txt` line 63322).";

        enum ISP_UVNR_CFG_uvnr_sel_enum {
            MIDF_CHANNEL = 0 { name = "Midf Channel"; desc = "MIDF channel"; };
            UNVR_CHANNEL = 1 { name = "Unvr Channel"; desc = "UNVR channel"; };
        };

        field {
            name = "uvnr_sel";
            desc = "UVNR denoising channel select";
            sw = rw;
            hw = r;
            encode = ISP_UVNR_CFG_uvnr_sel_enum;
            reset = 0x0;
        } uvnr_sel[12:12];

        enum ISP_UVNR_CFG_nr_en_enum {
            DISABLED = 0 { name = "Disabled"; desc = "disabled"; };
            ENABLED = 1 { name = "Enabled"; desc = "enabled"; };
        };

        field {
            name = "nr_en";
            desc = "UVNR denoising enable";
            sw = rw;
            hw = r;
            encode = ISP_UVNR_CFG_nr_en_enum;
            reset = 0x0;
        } nr_en[8:8];

        enum ISP_UVNR_CFG_midf_en_enum {
            DISABLED = 0 { name = "Disabled"; desc = "disabled"; };
            ENABLED = 1 { name = "Enabled"; desc = "enabled"; };
        };

        field {
            name = "midf_en";
            desc = "MIDFILTER enable";
            sw = rw;
            hw = r;
            encode = ISP_UVNR_CFG_midf_en_enum;
            reset = 0x0;
        } midf_en[4:4];

        enum ISP_UVNR_CFG_uv2c_mode_enum {
            U_COMPONENT_DATA = 0 { name = "U Component Data"; desc = "The U component data is output."; };
            V_COMPONENT_DATA = 1 { name = "V Component Data"; desc = "The V component data is output."; };
        };

        field {
            name = "uv2c_mode";
            desc = "UV2C bypass mode";
            sw = rw;
            hw = r;
            encode = ISP_UVNR_CFG_uv2c_mode_enum;
            reset = 0x0;
        } uv2c_mode[3:3];

        enum ISP_UVNR_CFG_uv2c_en_enum {
            DISABLED = 0 { name = "Disabled"; desc = "disabled"; };
            ENABLED = 1 { name = "Enabled"; desc = "enabled"; };
        };

        field {
            name = "uv2c_en";
            desc = "UV2C enable for converting the internal dual-component (U and V) data into the single C component data";
            sw = rw;
            hw = r;
            encode = ISP_UVNR_CFG_uv2c_en_enum;
            reset = 0x0;
        } uv2c_en[2:2];

        enum ISP_UVNR_CFG_vcds_en_enum {
            DISABLED = 0 { name = "Disabled"; desc = "disabled"; };
            ENABLED = 1 { name = "Enabled"; desc = "enabled"; };
        };

        field {
            name = "vcds_en";
            desc = "Vertical chrominance down sampling enable";
            sw = rw;
            hw = r;
            encode = ISP_UVNR_CFG_vcds_en_enum;
            reset = 0x0;
        } vcds_en[1:1];

        enum ISP_UVNR_CFG_hcds_en_enum {
            DISABLED = 0 { name = "Disabled"; desc = "disabled"; };
            ENABLED = 1 { name = "Enabled"; desc = "enabled"; };
        };

        field {
            name = "hcds_en";
            desc = "Horizontal chrominance down sampling enable";
            sw = rw;
            hw = r;
            encode = ISP_UVNR_CFG_hcds_en_enum;
            reset = 0x0;
        } hcds_en[0:0];
    } ISP_UVNR_CFG @ 0x1600;

    reg {
        name = "Horizontal chrominance down sampling input size configuration register";
        desc = "ISP_HCDS_SIZE is a horizontal chrominance down sampling input size configuration register.

Data sheet 10.6 ISP_HCDS_SIZE (offset 0x21614, printed page 10-71, `hi3518ev200--Hi3518EV20X-Hi3516CV200-Datasheet.txt` line 63382).";

        field {
            name = "width_out";
            desc = "U/V line width (in pixel) of the output picture during horizontal chrominance down sampling. The configured value is the actual value minus 1.";
            sw = rw;
            hw = r;
            reset = 0x77F;
        } width_out[28:16];

        field {
            name = "width_in";
            desc = "U/V line width (in pixel) of the input picture. The configured value is the actual value minus 1.";
            sw = rw;
            hw = r;
            reset = 0x77F;
        } width_in[12:0];
    } ISP_HCDS_SIZE @ 0x1614;

    reg {
        name = "Horizontal chrominance down sampling output size configuration register";
        desc = "ISP_DSUS_MODE is a horizontal chrominance down sampling output size configuration register.

Data sheet 10.6 ISP_DSUS_MODE (offset 0x21618, printed page 10-72, `hi3518ev200--Hi3518EV20X-Hi3516CV200-Datasheet.txt` line 63422).";

        enum ISP_DSUS_MODE_vcus_mode_enum {
            V_2 = 0 { name = "V 2"; desc = "2"; };
            V_4 = 1 { name = "V 4"; desc = "4"; };
        };

        field {
            name = "vcus_mode";
            desc = "Vertical UV up sampling multiple";
            sw = rw;
            hw = r;
            encode = ISP_DSUS_MODE_vcus_mode_enum;
            reset = 0x0;
        } vcus_mode[2:2];

        enum ISP_DSUS_MODE_vcds_mode_enum {
            V_2 = 0 { name = "V 2"; desc = "2"; };
            V_4 = 1 { name = "V 4"; desc = "4"; };
        };

        field {
            name = "vcds_mode";
            desc = "Vertical UV down sampling multiple";
            sw = rw;
            hw = r;
            encode = ISP_DSUS_MODE_vcds_mode_enum;
            reset = 0x0;
        } vcds_mode[1:1];

        enum ISP_DSUS_MODE_hcds_mode_enum {
            V_2 = 0 { name = "V 2"; desc = "2"; };
            V_4 = 1 { name = "V 4"; desc = "4"; };
        };

        field {
            name = "hcds_mode";
            desc = "Horizontal UV down sampling multiple";
            sw = rw;
            hw = r;
            encode = ISP_DSUS_MODE_hcds_mode_enum;
            reset = 0x0;
        } hcds_mode[0:0];
    } ISP_DSUS_MODE @ 0x1618;

    reg {
        name = "Horizontal chrominance down sampling coefficient register 0";
        desc = "ISP_HCDS_COEF0 is horizontal chrominance down sampling coefficient register 0.

Data sheet 10.6 ISP_HCDS_COEF0 (offset 0x2161C, printed page 10-72, `hi3518ev200--Hi3518EV20X-Hi3516CV200-Datasheet.txt` line 63455).";

        field {
            name = "coef2";
            desc = "Horizontal chrominance scaling and filtering coefficient 2";
            sw = rw;
            hw = r;
            reset = 0x0;
        } coef2[29:20];

        field {
            name = "coef1";
            desc = "Horizontal chrominance scaling and filtering coefficient 1";
            sw = rw;
            hw = r;
            reset = 0x0;
        } coef1[19:10];

        field {
            name = "coef0";
            desc = "Horizontal chrominance scaling and filtering coefficient 0, 10-bit signed number Horizontal scaling contains eight taps, and the sum of the eight coefficients is 512.";
            sw = rw;
            hw = r;
            reset = 0x0;
        } coef0[9:0];
    } ISP_HCDS_COEF0 @ 0x161C;

    reg {
        name = "Horizontal chrominance down sampling coefficient register 1";
        desc = "ISP_HCDS_COEF1 is horizontal chrominance down sampling coefficient register 1.

Data sheet 10.6 ISP_HCDS_COEF1 (offset 0x21620, printed page 10-73, `hi3518ev200--Hi3518EV20X-Hi3516CV200-Datasheet.txt` line 63495).";

        field {
            name = "coef5";
            desc = "Horizontal chrominance scaling and filtering coefficient 5";
            sw = rw;
            hw = r;
            reset = 0x0;
        } coef5[29:20];

        field {
            name = "coef4";
            desc = "Horizontal chrominance scaling and filtering coefficient 4";
            sw = rw;
            hw = r;
            reset = 0x0;
        } coef4[19:10];

        field {
            name = "coef3";
            desc = "Horizontal chrominance scaling and filtering coefficient 3";
            sw = rw;
            hw = r;
            reset = 0x0;
        } coef3[9:0];
    } ISP_HCDS_COEF1 @ 0x1620;

    reg {
        name = "Horizontal chrominance down sampling coefficient register 2";
        desc = "ISP_HCDS_COEF2 is horizontal chrominance down sampling coefficient register 2.

Data sheet 10.6 ISP_HCDS_COEF2 (offset 0x21624, printed page 10-73, `hi3518ev200--Hi3518EV20X-Hi3516CV200-Datasheet.txt` line 63520).";

        field {
            name = "coef7";
            desc = "Horizontal chrominance scaling and filtering coefficient 7";
            sw = rw;
            hw = r;
            reset = 0x0;
        } coef7[19:10];

        field {
            name = "coef6";
            desc = "Horizontal chrominance scaling and filtering coefficient 6";
            sw = rw;
            hw = r;
            reset = 0x0;
        } coef6[9:0];
    } ISP_HCDS_COEF2 @ 0x1624;

    reg {
        name = "Vertical chrominance down sampling coefficient register";
        desc = "ISP_VCDS_COEF is a vertical chrominance down sampling coefficient register.

Data sheet 10.6 ISP_VCDS_COEF (offset 0x21628, printed page 10-74, `hi3518ev200--Hi3518EV20X-Hi3516CV200-Datasheet.txt` line 63546).";

        field {
            name = "coef3";
            desc = "Down sampling coefficient 3. The value meanings are the same as those of coefficient 0.";
            sw = rw;
            hw = r;
            reset = 0x0;
        } coef3[26:24];

        field {
            name = "coef2";
            desc = "Down sampling coefficient 2. The value meanings are the same as those of coefficient 0.";
            sw = rw;
            hw = r;
            reset = 0x0;
        } coef2[18:16];

        field {
            name = "coef1";
            desc = "Down sampling coefficient 1. The value meanings are the same as those of coefficient 0.";
            sw = rw;
            hw = r;
            reset = 0x0;
        } coef1[10:8];

        enum ISP_VCDS_COEF_coef0_enum {
            MULTIPLIED_0X1 = 0 { name = "Multiplied 0X1"; desc = "multiplied by 0x1"; };
            MULTIPLIED_0X2 = 1 { name = "Multiplied 0X2"; desc = "multiplied by 0x2"; };
            MULTIPLIED_0X4 = 2 { name = "Multiplied 0X4"; desc = "multiplied by 0x4"; };
            MULTIPLIED_0X8 = 3 { name = "Multiplied 0X8"; desc = "multiplied by 0x8"; };
            MULTIPLIED_0X10 = 4 { name = "Multiplied 0X10"; desc = "multiplied by 0x10"; };
            MULTIPLIED_0X20 = 5 { name = "Multiplied 0X20"; desc = "multiplied by 0x20"; };
            MULTIPLIED_0X0 = 6 { name = "Multiplied 0X0"; desc = "multiplied by 0x0"; };
            MULTIPLIED_0X0_2 = 7 { name = "Multiplied 0X0 2"; desc = "multiplied by 0x0 (invalid)"; };
        };

        field {
            name = "coef0";
            desc = "Down sampling coefficient 0";
            sw = rw;
            hw = r;
            encode = ISP_VCDS_COEF_coef0_enum;
            reset = 0x0;
        } coef0[2:0];
    } ISP_VCDS_COEF @ 0x1628;

    reg {
        name = "Median filtering input picture chrominance width/height register";
        desc = "ISP_MIDF_SIZE is a median filtering input picture chrominance width/height register.

Data sheet 10.6 ISP_MIDF_SIZE (offset 0x2162C, printed page 10-75, `hi3518ev200--Hi3518EV20X-Hi3516CV200-Datasheet.txt` line 63597).";

        field {
            name = "height";
            desc = "Picture height after vertical chrominance down sampling. The configured value is the actual height minus 1. For example, if the actual picture height is 720, this field needs to be set to 719.";
            sw = rw;
            hw = r;
            reset = 0x437;
        } height[28:16];

        field {
            name = "width";
            desc = "Picture width after vertical chrominance down sampling (UV-to-C conversion). The configured value is the actual width minus 1. For example, if the actual picture width is 1280, this field needs to be set to 1279.";
            sw = rw;
            hw = r;
            reset = 0x77F;
        } width[12:0];
    } ISP_MIDF_SIZE @ 0x162C;

    reg {
        name = "NR input picture chrominance width/height register";
        desc = "ISP_NR_SIZE is an NR input picture chrominance width/height register.

Data sheet 10.6 ISP_NR_SIZE (offset 0x21630, printed page 10-75, `hi3518ev200--Hi3518EV20X-Hi3516CV200-Datasheet.txt` line 63628).";

        field {
            name = "height";
            desc = "Picture height after vertical chrominance down sampling. The configured value is the actual height minus 1. For example, if the actual picture height is 720, this field needs to be set to 719.";
            sw = rw;
            hw = r;
            reset = 0x437;
        } height[28:16];

        field {
            name = "width";
            desc = "Picture width after vertical chrominance down sampling (UV-to-C conversion). The configured value is the actual width minus 1. For example, if the actual picture width is 1280, this field needs to be set to 1279.";
            sw = rw;
            hw = r;
            reset = 0x77F;
        } width[12:0];
    } ISP_NR_SIZE @ 0x1630;

    reg {
        name = "Difference threshold register";
        desc = "ISP_UVNR_DIFFTHRES0 is a difference threshold register.

Data sheet 10.6 ISP_UVNR_DIFFTHRES0 (offset 0x21634, printed page 10-76, `hi3518ev200--Hi3518EV20X-Hi3516CV200-Datasheet.txt` line 63670).";

        field {
            name = "diffthres4";
            desc = "Threshold of the difference with the distance of 4, 8-bit unsigned number";
            sw = rw;
            hw = r;
            reset = 0x0;
        } diffthres4[31:24];

        field {
            name = "diffthres3";
            desc = "Threshold of the difference with the distance of 3, 8-bit unsigned number";
            sw = rw;
            hw = r;
            reset = 0x0;
        } diffthres3[23:16];

        field {
            name = "diffthres2";
            desc = "Threshold of the difference with the distance of 2, 8-bit unsigned number";
            sw = rw;
            hw = r;
            reset = 0x0;
        } diffthres2[15:8];

        field {
            name = "diffthres1";
            desc = "Threshold of the difference with the distance of 1, 8-bit unsigned number";
            sw = rw;
            hw = r;
            reset = 0x0;
        } diffthres1[7:0];
    } ISP_UVNR_DIFFTHRES0 @ 0x1634;

    reg {
        name = "Difference threshold register";
        desc = "ISP_UVNR_DIFFTHRES1 is a difference threshold register.

Data sheet 10.6 ISP_UVNR_DIFFTHRES1 (offset 0x21638, printed page 10-76, `hi3518ev200--Hi3518EV20X-Hi3516CV200-Datasheet.txt` line 63699).";

        field {
            name = "diffthres6";
            desc = "Threshold of the difference with the distance of 6, 8-bit unsigned number";
            sw = rw;
            hw = r;
            reset = 0x0;
        } diffthres6[15:8];

        field {
            name = "diffthres5";
            desc = "Threshold of the difference with the distance of 5, 8-bit unsigned number";
            sw = rw;
            hw = r;
            reset = 0x0;
        } diffthres5[7:0];
    } ISP_UVNR_DIFFTHRES1 @ 0x1638;

    reg {
        name = "Weight limit register";
        desc = "ISP_UVNR_RATIO0 is a weight limit register.

Data sheet 10.6 ISP_UVNR_RATIO0 (offset 0x2163C, printed page 10-77, `hi3518ev200--Hi3518EV20X-Hi3516CV200-Datasheet.txt` line 63734).";

        field {
            name = "ratiolimit3";
            desc = "Weight upper limit for distance 3, 7-bit unsigned number";
            sw = rw;
            hw = r;
            reset = 0x0;
        } ratiolimit3[30:24];

        field {
            name = "ratiolimit2";
            desc = "Weight upper limit for distance 2, 7-bit unsigned number";
            sw = rw;
            hw = r;
            reset = 0x0;
        } ratiolimit2[22:16];

        field {
            name = "ratiolimit1";
            desc = "Weight upper limit for distance 1, 7-bit unsigned number";
            sw = rw;
            hw = r;
            reset = 0x0;
        } ratiolimit1[14:8];

        field {
            name = "ratiolimit0";
            desc = "Weight upper limit for distance 0, 7-bit unsigned number";
            sw = rw;
            hw = r;
            reset = 0x0;
        } ratiolimit0[6:0];
    } ISP_UVNR_RATIO0 @ 0x163C;

    reg {
        name = "Weight limit register";
        desc = "ISP_UVNR_RATIO1 is a weight limit register.

Data sheet 10.6 ISP_UVNR_RATIO1 (offset 0x21640, printed page 10-78, `hi3518ev200--Hi3518EV20X-Hi3516CV200-Datasheet.txt` line 63772).";

        field {
            name = "ratiolimit6";
            desc = "Weight upper limit for distance 6, 7-bit unsigned number";
            sw = rw;
            hw = r;
            reset = 0x0;
        } ratiolimit6[22:16];

        field {
            name = "ratiolimit5";
            desc = "Weight upper limit for distance 5, 7-bit unsigned number";
            sw = rw;
            hw = r;
            reset = 0x0;
        } ratiolimit5[14:8];

        field {
            name = "ratiolimit4";
            desc = "Weight upper limit for distance 4, 7-bit unsigned number";
            sw = rw;
            hw = r;
            reset = 0x0;
        } ratiolimit4[6:0];
    } ISP_UVNR_RATIO1 @ 0x1640;

    reg {
        name = "NR blending ratio and shift register";
        desc = "ISP_UVNR_PARA is an NR blending ratio and shift register.

Data sheet 10.6 ISP_UVNR_PARA (offset 0x21644, printed page 10-78, `hi3518ev200--Hi3518EV20X-Hi3516CV200-Datasheet.txt` line 63799).";

        field {
            name = "limit";
            desc = "Limit for the coring function. The value range is 0-127.";
            sw = rw;
            hw = r;
            reset = 0x0;
        } limit[22:16];

        field {
            name = "diffshift";
            desc = "2-bit unsigned number. The value is 0, 1, 2, or 3.";
            sw = rw;
            hw = r;
            reset = 0x0;
        } diffshift[9:8];

        field {
            name = "blendratio";
            desc = "Blending ratio, 6-bit unsigned number. The value range is 0-32.";
            sw = rw;
            hw = r;
            reset = 0x0;
        } blendratio[5:0];
    } ISP_UVNR_PARA @ 0x1644;

    reg {
        name = "AE enable register";
        desc = "ISP_AE_CFG is an AE enable register.

Data sheet 10.6 ISP_AE_CFG (offset 0x22000, printed page 10-79, `hi3518ev200--Hi3518EV20X-Hi3516CV200-Datasheet.txt` line 63836).";

        enum ISP_AE_CFG_en_enum {
            DISABLED = 0 { name = "Disabled"; desc = "disabled"; };
            ENABLED = 1 { name = "Enabled"; desc = "enabled"; };
        };

        field {
            name = "en";
            desc = "AE enable";
            sw = rw;
            hw = r;
            encode = ISP_AE_CFG_en_enum;
            reset = 0x0;
        } en[0:0];
    } ISP_AE_CFG @ 0x2000;

    reg {
        name = "AE block configuration register";
        desc = "ISP_AE_ZONE is an AE block configuration register.

Data sheet 10.6 ISP_AE_ZONE (offset 0x22010, printed page 10-79, `hi3518ev200--Hi3518EV20X-Hi3516CV200-Datasheet.txt` line 63857).";

        field {
            name = "vnum";
            desc = "Number of vertical blocks";
            sw = rw;
            hw = r;
            reset = 0x0;
        } vnum[12:8];

        field {
            name = "hnum";
            desc = "Number of horizontal blocks";
            sw = rw;
            hw = r;
            reset = 0x0;
        } hnum[4:0];
    } ISP_AE_ZONE @ 0x2010;

    reg {
        name = "AE point select configuration register";
        desc = "ISP_AE_SKIP_CRG is an AE point select configuration register.

Data sheet 10.6 ISP_AE_SKIP_CRG (offset 0x22014, printed page 10-80, `hi3518ev200--Hi3518EV20X-Hi3516CV200-Datasheet.txt` line 63891).";

        enum ISP_AE_SKIP_CRG_offset_y_enum {
            COUNT_FROM_COLUMN = 0 { name = "Count From Column"; desc = "count from column 0"; };
            COUNT_FROM_COLUMN_2 = 1 { name = "Count From Column 2"; desc = "count from column 1"; };
        };

        field {
            name = "offset_y";
            desc = "offset_y";
            sw = rw;
            hw = r;
            encode = ISP_AE_SKIP_CRG_offset_y_enum;
            reset = 0x0;
        } offset_y[7:7];

        enum ISP_AE_SKIP_CRG_skip_y_enum {
            EACH_PIXEL_POINT = 0 { name = "Each Pixel Point"; desc = "Each pixel point is collected for statistics."; };
            STATISTICS_COLLECTED_EVERY = 1 { name = "Statistics Collected Every"; desc = "Statistics are collected on every two pixels."; };
            STATISTICS_COLLECTED_EVERY_2 = 2 { name = "Statistics Collected Every 2"; desc = "Statistics are collected on every three pixels."; };
            STATISTICS_COLLECTED_EVERY_3 = 3 { name = "Statistics Collected Every 3"; desc = "Statistics are collected on every four pixels."; };
            STATISTICS_COLLECTED_EVERY_4 = 4 { name = "Statistics Collected Every 4"; desc = "Statistics are collected on every five pixels."; };
            STATISTICS_COLLECTED_EVERY_5 = 5 { name = "Statistics Collected Every 5"; desc = "Statistics are collected on every eight pixels. 0x6 or larger values: Statistics are collected on every nine pixels."; };
        };

        field {
            name = "skip_y";
            desc = "Vertical jump point configuration for statistical points";
            sw = rw;
            hw = r;
            encode = ISP_AE_SKIP_CRG_skip_y_enum;
            reset = 0x0;
        } skip_y[6:4];

        enum ISP_AE_SKIP_CRG_offset_x_enum {
            COUNT_FROM_COLUMN = 0 { name = "Count From Column"; desc = "count from column 0"; };
            COUNT_FROM_COLUMN_2 = 1 { name = "Count From Column 2"; desc = "count from column 1"; };
        };

        field {
            name = "offset_x";
            desc = "offset_x";
            sw = rw;
            hw = r;
            encode = ISP_AE_SKIP_CRG_offset_x_enum;
            reset = 0x0;
        } offset_x[3:3];

        enum ISP_AE_SKIP_CRG_skip_x_enum {
            STATISTICS_COLLECTED_EVERY = 0 { name = "Statistics Collected Every"; desc = "Statistics are collected on every two pixels."; };
            STATISTICS_COLLECTED_EVERY_2 = 1 { name = "Statistics Collected Every 2"; desc = "Statistics are collected on every three pixels."; };
            STATISTICS_COLLECTED_EVERY_3 = 2 { name = "Statistics Collected Every 3"; desc = "Statistics are collected on every four pixels."; };
            STATISTICS_COLLECTED_EVERY_4 = 3 { name = "Statistics Collected Every 4"; desc = "Statistics are collected on every five pixels."; };
            STATISTICS_COLLECTED_EVERY_5 = 4 { name = "Statistics Collected Every 5"; desc = "Statistics are collected on every eight pixels. 0x5 or larger values: Statistics are collected on every nine pixels."; };
        };

        field {
            name = "skip_x";
            desc = "Horizontal jump point configuration for statistical points";
            sw = rw;
            hw = r;
            encode = ISP_AE_SKIP_CRG_skip_x_enum;
            reset = 0x0;
        } skip_x[2:0];
    } ISP_AE_SKIP_CRG @ 0x2014;

    reg {
        name = "Selected point total number register in a picture frame during 256- segment histogram statistics";
        desc = "ISP_AE_TOTAL_STAT is a selected point total number register in a picture frame during 256-segment histogram statistics.

Data sheet 10.6 ISP_AE_TOTAL_STAT (offset 0x22018, printed page 10-81, `hi3518ev200--Hi3518EV20X-Hi3516CV200-Datasheet.txt` line 63945).";

        field {
            name = "total_pixels";
            desc = "Number of selected points in a picture frame during 256-segment histogram statistics";
            sw = r;
            hw = w;
            reset = 0x0;
        } total_pixels[23:0];
    } ISP_AE_TOTAL_STAT @ 0x2018;

    reg {
        name = "Selected point total weight register in a picture frame during 256- segment histogram statistics";
        desc = "ISP_AE_COUNT_STAT is a selected point total weight register in a picture frame during 256-segment histogram statistics.

Data sheet 10.6 ISP_AE_COUNT_STAT (offset 0x2201C, printed page 10-81, `hi3518ev200--Hi3518EV20X-Hi3516CV200-Datasheet.txt` line 63968).";

        field {
            name = "count_pixels";
            desc = "Total weight of selected points in a picture frame during 256- segment histogram statistics";
            sw = r;
            hw = w;
            reset = 0x0;
        } count_pixels[27:0];
    } ISP_AE_COUNT_STAT @ 0x201C;

    reg {
        name = "R component average value register in a picture frame during average value statistics";
        desc = "ISP_AE_TOTAL_R_AVER is an R component average value register in a picture frame during average value statistics.

Data sheet 10.6 ISP_AE_TOTAL_R_AVER (offset 0x22020, printed page 10-81, `hi3518ev200--Hi3518EV20X-Hi3516CV200-Datasheet.txt` line 63991).";

        field {
            name = "total_r_aver";
            desc = "Global average value of the R component";
            sw = r;
            hw = w;
            reset = 0x0;
        } total_r_aver[31:0];
    } ISP_AE_TOTAL_R_AVER @ 0x2020;

    reg {
        name = "Gr component average value R register in a picture frame during average value statistics";
        desc = "ISP_AE_TOTAL_GR_AVER is a Gr component average value register in a picture frame during average value statistics.

Data sheet 10.6 ISP_AE_TOTAL_GR_AVER (offset 0x22024, printed page 10-82, `hi3518ev200--Hi3518EV20X-Hi3516CV200-Datasheet.txt` line 64018).";

        field {
            name = "total_gr_aver";
            desc = "Global average value of the Gr component";
            sw = r;
            hw = w;
            reset = 0x0;
        } total_gr_aver[31:0];
    } ISP_AE_TOTAL_GR_AVER @ 0x2024;

    reg {
        name = "Gb component average value R register in a picture frame during average value statistics";
        desc = "ISP_AE_TOTAL_GB_AVER is a Gb component average value register in a picture frame during average value statistics.

Data sheet 10.6 ISP_AE_TOTAL_GB_AVER (offset 0x22028, printed page 10-82, `hi3518ev200--Hi3518EV20X-Hi3516CV200-Datasheet.txt` line 64037).";

        field {
            name = "total_gb_aver";
            desc = "Global average value of the Gb component";
            sw = r;
            hw = w;
            reset = 0x0;
        } total_gb_aver[31:0];
    } ISP_AE_TOTAL_GB_AVER @ 0x2028;

    reg {
        name = "B component average value register in a picture frame during average value statistics";
        desc = "ISP_AE_TOTAL_B_AVER is a B component average value register in a picture frame during average value statistics.

Data sheet 10.6 ISP_AE_TOTAL_B_AVER (offset 0x2202C, printed page 10-83, `hi3518ev200--Hi3518EV20X-Hi3516CV200-Datasheet.txt` line 64065).";

        field {
            name = "total_b_aver";
            desc = "Global average value of the B component";
            sw = r;
            hw = w;
            reset = 0x0;
        } total_b_aver[31:0];
    } ISP_AE_TOTAL_B_AVER @ 0x202C;

    reg {
        name = "AE pixel shift value register";
        desc = "ISP_AE_BITMOVE is an AE pixel shift value register.

Data sheet 10.6 ISP_AE_BITMOVE (offset 0x22040, printed page 10-83, `hi3518ev200--Hi3518EV20X-Hi3516CV200-Datasheet.txt` line 64084).";

        field {
            name = "gamma_en";
            desc = "AE gamma enable";
            sw = rw;
            hw = r;
            reset = 0x0;
        } gamma_en[8:8];
    } ISP_AE_BITMOVE @ 0x2040;

    reg {
        name = "AE histogram statistics read address DR register";
        desc = "ISP_AE_MEM_HIST_RADDR is an AE histogram statistics read address register.

Data sheet 10.6 ISP_AE_MEM_HIST_RADDR (offset 0x22088, printed page 10-83, `hi3518ev200--Hi3518EV20X-Hi3516CV200-Datasheet.txt` line 64111).";

        field {
            name = "hist_raddr";
            desc = "Histogram statistics read address";
            sw = rw;
            hw = r;
            reset = 0x0;
        } hist_raddr[31:0];
    } ISP_AE_MEM_HIST_RADDR @ 0x2088;

    reg {
        name = "AE histogram statistics read data TA register";
        desc = "ISP_AE_MEM_HIST_RDATA is an AE histogram statistics read data register.

Data sheet 10.6 ISP_AE_MEM_HIST_RDATA (offset 0x2208C, printed page 10-84, `hi3518ev200--Hi3518EV20X-Hi3516CV200-Datasheet.txt` line 64138).";

        field {
            name = "hist_rdata";
            desc = "Histogram statistics read data";
            sw = r;
            hw = w;
            reset = 0x0;
        } hist_rdata[31:0];
    } ISP_AE_MEM_HIST_RDATA @ 0x208C;

    reg {
        name = "AE average value statistics read DDR address register";
        desc = "ISP_AE_MEM_AVER_RADDR is an AE average value statistics read address register.

Data sheet 10.6 ISP_AE_MEM_AVER_RADDR (offset 0x22098, printed page 10-84, `hi3518ev200--Hi3518EV20X-Hi3516CV200-Datasheet.txt` line 64156).";

        field {
            name = "aver_raddr";
            desc = "Read address of the average value statistics";
            sw = rw;
            hw = r;
            reset = 0x0;
        } aver_raddr[31:0];
    } ISP_AE_MEM_AVER_RADDR @ 0x2098;

    reg {
        name = "AE average value statistics read data ATA register";
        desc = "ISP_AE_MEM_AVER_RDATA is an AE average value statistics read data register.

Data sheet 10.6 ISP_AE_MEM_AVER_RDATA (offset 0x2209C, printed page 10-84, `hi3518ev200--Hi3518EV20X-Hi3516CV200-Datasheet.txt` line 64175).";

        field {
            name = "aver_rdata";
            desc = "Read data of the average value statistics";
            sw = r;
            hw = w;
            reset = 0x0;
        } aver_rdata[31:0];
    } ISP_AE_MEM_AVER_RDATA @ 0x209C;

    reg {
        name = "Zone weight register WADDR";
        desc = "ISP_AE_MEM_WEIGHT_WADDR is a zone weight register.

Data sheet 10.6 ISP_AE_MEM_WEIGHT_WADDR (offset 0x220A0, printed page 10-85, `hi3518ev200--Hi3518EV20X-Hi3516CV200-Datasheet.txt` line 64199).";

        field {
            name = "wei_waddr";
            desc = "Weight table write address";
            sw = rw;
            hw = r;
            reset = 0x0;
        } wei_waddr[31:0];
    } ISP_AE_MEM_WEIGHT_WADDR @ 0x20A0;

    reg {
        name = "Zone weight register WDATA";
        desc = "ISP_AE_MEM_WEIGHT_WDATA is a zone weight register.

Data sheet 10.6 ISP_AE_MEM_WEIGHT_WDATA (offset 0x220A4, printed page 10-85, `hi3518ev200--Hi3518EV20X-Hi3516CV200-Datasheet.txt` line 64218).";

        field {
            name = "wei_wdata";
            desc = "Weight table write data";
            sw = rw;
            hw = r;
            reset = 0x0;
        } wei_wdata[31:0];
    } ISP_AE_MEM_WEIGHT_WDATA @ 0x20A4;

    reg {
        name = "AWB enable register";
        desc = "ISP_AWB_CFG is an AWB enable register.

Data sheet 10.6 ISP_AWB_CFG (offset 0x22100, printed page 10-85, `hi3518ev200--Hi3518EV20X-Hi3516CV200-Datasheet.txt` line 64236).";

        enum ISP_AWB_CFG_work_en_enum {
            ENABLED = 1 { name = "Enabled"; desc = "enabled"; };
            DISABLED = 0 { name = "Disabled"; desc = "disabled"; };
        };

        field {
            name = "work_en";
            desc = "AWB enable";
            sw = rw;
            hw = r;
            encode = ISP_AWB_CFG_work_en_enum;
            reset = 0x0;
        } work_en[0:0];
    } ISP_AWB_CFG @ 0x2100;

    reg {
        name = "AWB block configuration register";
        desc = "ISP_AWB_ZONE is an AWB block configuration register.

Data sheet 10.6 ISP_AWB_ZONE (offset 0x22110, printed page 10-86, `hi3518ev200--Hi3518EV20X-Hi3516CV200-Datasheet.txt` line 64272).";

        field {
            name = "vnum";
            desc = "Number of vertical blocks";
            sw = rw;
            hw = r;
            reset = 0x0;
        } vnum[12:8];

        field {
            name = "hnum";
            desc = "Number of horizontal blocks";
            sw = rw;
            hw = r;
            reset = 0x0;
        } hnum[4:0];
    } ISP_AWB_ZONE @ 0x2110;

    reg {
        name = "AWB minimum RGB field value register";
        desc = "ISP_AWB_THD_MIN is an AWB minimum RGB field value register.

Data sheet 10.6 ISP_AWB_THD_MIN (offset 0x22118, printed page 10-86, `hi3518ev200--Hi3518EV20X-Hi3516CV200-Datasheet.txt` line 64298).";

        field {
            name = "threshold_min";
            desc = "Minimum RGB field value during AWB statistics";
            sw = rw;
            hw = r;
            reset = 0x0;
        } threshold_min[11:0];
    } ISP_AWB_THD_MIN @ 0x2118;

    reg {
        name = "AWB maximum RGB field value register";
        desc = "ISP_AWB_THD_MAX is an AWB maximum RGB field value register.

Data sheet 10.6 ISP_AWB_THD_MAX (offset 0x2211C, printed page 10-87, `hi3518ev200--Hi3518EV20X-Hi3516CV200-Datasheet.txt` line 64324).";

        field {
            name = "threshold_max";
            desc = "Maximum RGB field value during AWB statistics";
            sw = rw;
            hw = r;
            reset = 0x0;
        } threshold_max[11:0];
    } ISP_AWB_THD_MAX @ 0x211C;

    reg {
        name = "AWB reference maximum/minimum R/G value register";
        desc = "ISP_AWB_CR_MM is an AWB reference maximum/minimum R/G value register.

Data sheet 10.6 ISP_AWB_CR_MM (offset 0x22120, printed page 10-87, `hi3518ev200--Hi3518EV20X-Hi3516CV200-Datasheet.txt` line 64344).";

        field {
            name = "cr_ref_min";
            desc = "AWB reference minimum R/G value, 4.8-bit unsigned value consisting of a 4-bit integral part and an 8-bit decimal part";
            sw = rw;
            hw = r;
            reset = 0x40;
        } cr_ref_min[27:16];

        field {
            name = "cr_ref_max";
            desc = "AWB reference maximum R/G value, 4.8-bit unsigned value consisting of a 4-bit integral part and an 8-bit decimal part";
            sw = rw;
            hw = r;
            reset = 0x1FF;
        } cr_ref_max[11:0];
    } ISP_AWB_CR_MM @ 0x2120;

    reg {
        name = "AWB reference maximum/minimum B/G value register";
        desc = "ISP_AWB_CB_MM is an AWB reference maximum/minimum B/G value register.

Data sheet 10.6 ISP_AWB_CB_MM (offset 0x22124, printed page 10-88, `hi3518ev200--Hi3518EV20X-Hi3516CV200-Datasheet.txt` line 64378).";

        field {
            name = "cb_ref_min";
            desc = "AWB reference minimum B/G value, 4.8-bit unsigned value consisting of a 4-bit integral part and an 8-bit decimal part";
            sw = rw;
            hw = r;
            reset = 0x40;
        } cb_ref_min[27:16];

        field {
            name = "cb_ref_max";
            desc = "AWB reference maximum B/G value, 4.8-bit unsigned value consisting of a 4-bit integral part and an 8-bit decimal part";
            sw = rw;
            hw = r;
            reset = 0x1FF;
        } cb_ref_max[11:0];
    } ISP_AWB_CB_MM @ 0x2124;

    reg {
        name = "AWB gray area reference range top hypotenuse slope register";
        desc = "ISP_AWB_TOP_K is an AWB gray area reference range top hypotenuse slope register.

Data sheet 10.6 ISP_AWB_TOP_K (offset 0x22130, printed page 10-88, `hi3518ev200--Hi3518EV20X-Hi3516CV200-Datasheet.txt` line 64404).";

        field {
            name = "awb_top_k";
            desc = "Hypotenuse slope of the AWB gray area reference range, 13.12-bit signed number, configured by using complementary codes";
            sw = rw;
            hw = r;
            reset = 0x0;
        } awb_top_k[24:0];
    } ISP_AWB_TOP_K @ 0x2130;

    reg {
        name = "AWB gray area reference range top hypotenuse intercept register";
        desc = "ISP_AWB_TOP_B is an AWB gray area reference range top hypotenuse intercept register.

Data sheet 10.6 ISP_AWB_TOP_B (offset 0x22134, printed page 10-89, `hi3518ev200--Hi3518EV20X-Hi3516CV200-Datasheet.txt` line 64435).";

        field {
            name = "awb_top_b";
            desc = "Hypotenuse intercept of the AWB gray area reference range, 16.8- bit unsigned number";
            sw = rw;
            hw = r;
            reset = 0x0;
        } awb_top_b[23:0];
    } ISP_AWB_TOP_B @ 0x2134;

    reg {
        name = "AWB gray area reference range bottom hypotenuse slope register";
        desc = "ISP_AWB_BOT_K is an AWB gray area reference range bottom hypotenuse slope register.

Data sheet 10.6 ISP_AWB_BOT_K (offset 0x22138, printed page 10-89, `hi3518ev200--Hi3518EV20X-Hi3516CV200-Datasheet.txt` line 64457).";

        field {
            name = "awb_bot_k";
            desc = "Hypotenuse slope of the AWB gray area reference range, 13.12-bit signed number, configured by using complementary codes";
            sw = rw;
            hw = r;
            reset = 0x0;
        } awb_bot_k[24:0];
    } ISP_AWB_BOT_K @ 0x2138;

    reg {
        name = "AWB gray area reference range bottom hypotenuse intercept register";
        desc = "ISP_AWB_BOT_B is an AWB gray area reference range bottom hypotenuse intercept register.

Data sheet 10.6 ISP_AWB_BOT_B (offset 0x2213C, printed page 10-89, `hi3518ev200--Hi3518EV20X-Hi3516CV200-Datasheet.txt` line 64478).";

        field {
            name = "awb_bot_b";
            desc = "Hypotenuse intercept of the AWB gray area reference range, 16.8- bit unsigned number";
            sw = rw;
            hw = r;
            reset = 0x0;
        } awb_bot_b[23:0];
    } ISP_AWB_BOT_B @ 0x213C;

    reg {
        name = "R component average value register of an entire picture";
        desc = "ISP_AWB_AVG_R is an R component average value register of an entire picture.

Data sheet 10.6 ISP_AWB_AVG_R (offset 0x22140, printed page 10-90, `hi3518ev200--Hi3518EV20X-Hi3516CV200-Datasheet.txt` line 64509).";

        field {
            name = "avg_r";
            desc = "Average value of the R component for an entire picture";
            sw = r;
            hw = w;
            reset = 0x0;
        } avg_r[11:0];
    } ISP_AWB_AVG_R @ 0x2140;

    reg {
        name = "G component average value register of an entire picture";
        desc = "ISP_AWB_AVG_G is a G component average value register of an entire picture.

Data sheet 10.6 ISP_AWB_AVG_G (offset 0x22144, printed page 10-90, `hi3518ev200--Hi3518EV20X-Hi3516CV200-Datasheet.txt` line 64529).";

        field {
            name = "avg_g";
            desc = "Average value of the G component for an entire picture";
            sw = r;
            hw = w;
            reset = 0x0;
        } avg_g[11:0];
    } ISP_AWB_AVG_G @ 0x2144;

    reg {
        name = "B component average value register of an entire picture";
        desc = "ISP_AWB_AVG_B is a B component average value register of an entire picture.

Data sheet 10.6 ISP_AWB_AVG_B (offset 0x22148, printed page 10-91, `hi3518ev200--Hi3518EV20X-Hi3516CV200-Datasheet.txt` line 64557).";

        field {
            name = "avg_b";
            desc = "Average value of the B component for an entire picture";
            sw = r;
            hw = w;
            reset = 0x0;
        } avg_b[11:0];
    } ISP_AWB_AVG_B @ 0x2148;

    reg {
        name = "Statistical point number register of an entire picture";
        desc = "ISP_AWB_CNT_ALL is a statistical point number register of an entire picture.

Data sheet 10.6 ISP_AWB_CNT_ALL (offset 0x2214C, printed page 10-91, `hi3518ev200--Hi3518EV20X-Hi3516CV200-Datasheet.txt` line 64577).";

        field {
            name = "count_all";
            desc = "Number of statistical points in an entire picture";
            sw = r;
            hw = w;
            reset = 0x0;
        } count_all[15:0];
    } ISP_AWB_CNT_ALL @ 0x214C;

    reg {
        name = "Number register for points below the minimum threshold in an entire picture";
        desc = "ISP_AWB_CNT_MIN is a number register for points below the minimum threshold in an entire picture.

Data sheet 10.6 ISP_AWB_CNT_MIN (offset 0x22150, printed page 10-91, `hi3518ev200--Hi3518EV20X-Hi3516CV200-Datasheet.txt` line 64597).";

        field {
            name = "count_min";
            desc = "Number of points below the minimum threshold in an entire picture";
            sw = r;
            hw = w;
            reset = 0x0;
        } count_min[15:0];
    } ISP_AWB_CNT_MIN @ 0x2150;

    reg {
        name = "Number register for points above the maximum threshold in an entire picture";
        desc = "ISP_AWB_CNT_MAX is a number register for points above the maximum threshold in an entire picture.

Data sheet 10.6 ISP_AWB_CNT_MAX (offset 0x22154, printed page 10-92, `hi3518ev200--Hi3518EV20X-Hi3516CV200-Datasheet.txt` line 64628).";

        field {
            name = "count_max";
            desc = "Number of points above the maximum threshold in an entire picture";
            sw = r;
            hw = w;
            reset = 0x0;
        } count_max[15:0];
    } ISP_AWB_CNT_MAX @ 0x2154;

    reg {
        name = "AWB statistics read address register";
        desc = "ISP_AWB_STAT_RADDR is an AWB statistics read address register.

Data sheet 10.6 ISP_AWB_STAT_RADDR (offset 0x22188, printed page 10-92, `hi3518ev200--Hi3518EV20X-Hi3516CV200-Datasheet.txt` line 64649).";

        enum ISP_AWB_STAT_RADDR_stat_raddr_enum {
            AVG_G_AVG = 0x0 { name = "Avg G Avg"; desc = "AVG G+AVG R for block 0"; };
            COUNT_ALL_AVG = 0x1 { name = "Count All Avg"; desc = "Count ALL+AVG B for block 0"; };
            COUNT_MAX_COUNT = 0x2 { name = "Count Max Count"; desc = "Count Max+Count Min for block 0"; };
            AVG_G_AVG_2 = 0x3 { name = "Avg G Avg 2"; desc = "AVG G+AVG R for block 1 … The same rule applies to other values. There are 255 blocks, and the address value range is 0-754."; };
        };

        field {
            name = "stat_raddr";
            desc = "AWB statistics address The sequence is as follows:";
            sw = rw;
            hw = r;
            encode = ISP_AWB_STAT_RADDR_stat_raddr_enum;
            reset = 0x0;
        } stat_raddr[9:0];
    } ISP_AWB_STAT_RADDR @ 0x2188;

    reg {
        name = "AWB statistics read return data register";
        desc = "ISP_AWB_STAT_RDATA is an AWB statistics read return data register.

Data sheet 10.6 ISP_AWB_STAT_RDATA (offset 0x2218C, printed page 10-93, `hi3518ev200--Hi3518EV20X-Hi3516CV200-Datasheet.txt` line 64683).";

        field {
            name = "stat_rdata";
            desc = "Read return value of AWB statistics. Each statistical value occupies 16 bits.";
            sw = r;
            hw = w;
            reset = 0x0;
        } stat_rdata[31:0];
    } ISP_AWB_STAT_RDATA @ 0x218C;

    reg {
        name = "AF control register";
        desc = "ISP_AF_CFG is an AF control register.

Data sheet 10.6 ISP_AF_CFG (offset 0x22200, printed page 10-93, `hi3518ev200--Hi3518EV20X-Hi3516CV200-Datasheet.txt` line 64704).";

        field {
            name = "ck_gt_en";
            desc = "AF clock gating enable";
            sw = rw;
            hw = r;
            reset = 0x0;
        } ck_gt_en[31:31];

        enum ISP_AF_CFG_bayer_mode_enum {
            RGGB_BGGR = 0 { name = "Rggb Bggr"; desc = "RGGB or BGGR"; };
            GRBG_RBRG = 1 { name = "Grbg Rbrg"; desc = "GRBG or RBRG"; };
        };

        field {
            name = "bayer_mode";
            desc = "AF raw format";
            sw = rw;
            hw = r;
            encode = ISP_AF_CFG_bayer_mode_enum;
            reset = 0x0;
        } bayer_mode[15:15];

        enum ISP_AF_CFG_raw_mode_enum {
            YUV_DATA = 0 { name = "Yuv Data"; desc = "YUV data"; };
            RAW_DATA = 1 { name = "Raw Data"; desc = "raw data"; };
        };

        field {
            name = "raw_mode";
            desc = "AF data format";
            sw = rw;
            hw = r;
            encode = ISP_AF_CFG_raw_mode_enum;
            reset = 0x0;
        } raw_mode[14:14];

        field {
            name = "sqrt_en";
            desc = "AF gamma enable";
            sw = rw;
            hw = r;
            reset = 0x0;
        } sqrt_en[13:13];

        field {
            name = "mean_en";
            desc = "AF median filtering enable";
            sw = rw;
            hw = r;
            reset = 0x0;
        } mean_en[12:12];

        field {
            name = "lpf_en";
            desc = "AF low-pass filter enable";
            sw = rw;
            hw = r;
            reset = 0x0;
        } lpf_en[11:11];

        field {
            name = "crop_en";
            desc = "AF crop enable";
            sw = rw;
            hw = r;
            reset = 0x0;
        } crop_en[10:10];

        enum ISP_AF_CFG_data_mode_enum {
            FIVE_GROUPS_VALUES = 0 { name = "Five Groups Values"; desc = "five groups of values"; };
            NINE_GROUPS_VALUES = 1 { name = "Nine Groups Values"; desc = "nine groups of values"; };
        };

        field {
            name = "data_mode";
            desc = "AF statistical mode";
            sw = rw;
            hw = r;
            encode = ISP_AF_CFG_data_mode_enum;
            reset = 0x0;
        } data_mode[9:9];

        enum ISP_AF_CFG_squ_mode_enum {
            STATISTICS_DIRECTLY_ACCUMULATE = 0 { name = "Statistics Directly Accumulate"; desc = "Statistics are directly accumulated."; };
            STATISTICS_ACCUMULATED_AFTER = 1 { name = "Statistics Accumulated After"; desc = "Statistics are accumulated after the square operation."; };
        };

        field {
            name = "squ_mode";
            desc = "Square mode of AF statistics";
            sw = rw;
            hw = r;
            encode = ISP_AF_CFG_squ_mode_enum;
            reset = 0x1;
        } squ_mode[8:8];

        enum ISP_AF_CFG_peak_mode_enum {
            ALL_VALUES_BLOCK = 0 { name = "All Values Block"; desc = "All values of a block are selected for statistics."; };
            MAXIMUM_VALUE_EACH = 1 { name = "Maximum Value Each"; desc = "The maximum value in each line of a block is selected for statistics."; };
        };

        field {
            name = "peak_mode";
            desc = "Peak value mode of AF statistics";
            sw = rw;
            hw = r;
            encode = ISP_AF_CFG_peak_mode_enum;
            reset = 0x1;
        } peak_mode[7:7];

        enum ISP_AF_CFG_iir1_en2_enum {
            DISABLED = 0 { name = "Disabled"; desc = "disabled"; };
            ENABLED = 1 { name = "Enabled"; desc = "enabled"; };
        };

        field {
            name = "iir1_en2";
            desc = "Enable for IIR2 among the three cascaded IIRs in group 2";
            sw = rw;
            hw = r;
            encode = ISP_AF_CFG_iir1_en2_enum;
            reset = 0x1;
        } iir1_en2[6:6];

        enum ISP_AF_CFG_iir1_en1_enum {
            DISABLED = 0 { name = "Disabled"; desc = "disabled"; };
            ENABLED = 1 { name = "Enabled"; desc = "enabled"; };
        };

        field {
            name = "iir1_en1";
            desc = "Enable for IIR1 among the three cascaded IIRs in group 2";
            sw = rw;
            hw = r;
            encode = ISP_AF_CFG_iir1_en1_enum;
            reset = 0x0;
        } iir1_en1[5:5];

        enum ISP_AF_CFG_iir1_en0_enum {
            DISABLED = 0 { name = "Disabled"; desc = "disabled"; };
            ENABLED = 1 { name = "Enabled"; desc = "enabled"; };
        };

        field {
            name = "iir1_en0";
            desc = "Enable for IIR0 among the three cascaded IIRs in group 2";
            sw = rw;
            hw = r;
            encode = ISP_AF_CFG_iir1_en0_enum;
            reset = 0x1;
        } iir1_en0[4:4];

        enum ISP_AF_CFG_iir0_en2_enum {
            DISABLED = 0 { name = "Disabled"; desc = "disabled"; };
            ENABLED = 1 { name = "Enabled"; desc = "enabled"; };
        };

        field {
            name = "iir0_en2";
            desc = "Enable for IIR2 among the three cascaded IIRs in group 1";
            sw = rw;
            hw = r;
            encode = ISP_AF_CFG_iir0_en2_enum;
            reset = 0x1;
        } iir0_en2[3:3];

        enum ISP_AF_CFG_iir0_en1_enum {
            DISABLED = 0 { name = "Disabled"; desc = "disabled"; };
            ENABLED = 1 { name = "Enabled"; desc = "enabled"; };
        };

        field {
            name = "iir0_en1";
            desc = "Enable for IIR1 among the three cascaded IIRs in group 1";
            sw = rw;
            hw = r;
            encode = ISP_AF_CFG_iir0_en1_enum;
            reset = 0x0;
        } iir0_en1[2:2];

        enum ISP_AF_CFG_iir0_en0_enum {
            DISABLED = 0 { name = "Disabled"; desc = "disabled"; };
            ENABLED = 1 { name = "Enabled"; desc = "enabled"; };
        };

        field {
            name = "iir0_en0";
            desc = "Enable for IIR0 among the three cascaded IIRs in group 1";
            sw = rw;
            hw = r;
            encode = ISP_AF_CFG_iir0_en0_enum;
            reset = 0x1;
        } iir0_en0[1:1];

        enum ISP_AF_CFG_en_enum {
            DISABLED = 0 { name = "Disabled"; desc = "disabled"; };
            ENABLED = 1 { name = "Enabled"; desc = "enabled"; };
        };

        field {
            name = "en";
            desc = "AF enable";
            sw = rw;
            hw = r;
            encode = ISP_AF_CFG_en_enum;
            reset = 0x0;
        } en[0:0];
    } ISP_AF_CFG @ 0x2200;

    reg {
        name = "AF block configuration register";
        desc = "ISP_AF_ZONE is an AF block configuration register.

Data sheet 10.6 ISP_AF_ZONE (offset 0x22210, printed page 10-95, `hi3518ev200--Hi3518EV20X-Hi3516CV200-Datasheet.txt` line 64791).";

        field {
            name = "vnum";
            desc = "Number of vertical AF blocks (15 blocks at most) Blocks are in the CH_AF_CROP_SIZE region when crop_en is 1. Blocks are in the CH_AF_SIZE region when crop_en is 0.";
            sw = rw;
            hw = r;
            reset = 0xF;
        } vnum[12:8];

        field {
            name = "hnum";
            desc = "Number of horizontal AF blocks (17 blocks at most) Blocks are in the CH_AF_CROP_SIZE region when crop_en is 1. Blocks are in the CH_AF_SIZE region when crop_en is 0.";
            sw = rw;
            hw = r;
            reset = 0x11;
        } hnum[4:0];
    } ISP_AF_ZONE @ 0x2210;

    reg {
        name = "AF picture crop start coordinate register";
        desc = "ISP_AF_CROP_START is an AF picture crop start coordinate register.

Data sheet 10.6 ISP_AF_CROP_START (offset 0x22214, printed page 10-95, `hi3518ev200--Hi3518EV20X-Hi3516CV200-Datasheet.txt` line 64820).";

        field {
            name = "pos_y";
            desc = "Vertical coordinate of the crop start point";
            sw = rw;
            hw = r;
            reset = 0x0;
        } pos_y[28:16];

        field {
            name = "pos_x";
            desc = "Horizontal coordinate of the crop start point";
            sw = rw;
            hw = r;
            reset = 0x0;
        } pos_x[12:0];
    } ISP_AF_CROP_START @ 0x2214;

    reg {
        name = "AF picture crop size register";
        desc = "ISP_AF_CROP_SIZE is an AF picture crop size register.

Data sheet 10.6 ISP_AF_CROP_SIZE (offset 0x22218, printed page 10-96, `hi3518ev200--Hi3518EV20X-Hi3516CV200-Datasheet.txt` line 64851).";

        field {
            name = "vsize";
            desc = "Picture height after AF cropping";
            sw = rw;
            hw = r;
            reset = 0x0;
        } vsize[28:16];

        field {
            name = "hsize";
            desc = "Picture width after AF cropping";
            sw = rw;
            hw = r;
            reset = 0x0;
        } hsize[12:0];
    } ISP_AF_CROP_SIZE @ 0x2218;

    reg {
        name = "AF median filtering threshold register";
        desc = "ISP_AF_MEAN_THRES is an AF median filtering threshold register.

Data sheet 10.6 ISP_AF_MEAN_THRES (offset 0x2221C, printed page 10-96, `hi3518ev200--Hi3518EV20X-Hi3516CV200-Datasheet.txt` line 64881).";

        field {
            name = "mean_thres";
            desc = "Threshold for AF median filtering";
            sw = rw;
            hw = r;
            reset = 0x0;
        } mean_thres[15:0];
    } ISP_AF_MEAN_THRES @ 0x221C;

    reg {
        name = "AF IIR filtering parameter register 0";
        desc = "ISP_AF_IIRG0 is AF IIR filtering parameter register 0.

Data sheet 10.6 ISP_AF_IIRG0 (offset 0x22220, printed page 10-97, `hi3518ev200--Hi3518EV20X-Hi3516CV200-Datasheet.txt` line 64909).";

        field {
            name = "iirg0_1";
            desc = "g0 gain of AF IIR filtering group 2";
            sw = rw;
            hw = r;
            reset = 0xA1;
        } iirg0_1[23:16];

        field {
            name = "iirg0_0";
            desc = "g0 gain of AF IIR filtering group 1";
            sw = rw;
            hw = r;
            reset = 0xA0;
        } iirg0_0[7:0];
    } ISP_AF_IIRG0 @ 0x2220;

    reg {
        name = "AF IIR filtering parameter register 1";
        desc = "ISP_AF_IIRG1 is AF IIR filtering parameter register 1.

Data sheet 10.6 ISP_AF_IIRG1 (offset 0x22224, printed page 10-97, `hi3518ev200--Hi3518EV20X-Hi3516CV200-Datasheet.txt` line 64936).";

        field {
            name = "iirg1_1";
            desc = "g1 gain of AF IIR filtering group 2";
            sw = rw;
            hw = r;
            reset = 0x244;
        } iirg1_1[25:16];

        field {
            name = "iirg1_0";
            desc = "g1 gain of AF IIR filtering group 1";
            sw = rw;
            hw = r;
            reset = 0x1BC;
        } iirg1_0[9:0];
    } ISP_AF_IIRG1 @ 0x2224;

    reg {
        name = "AF IIR filtering parameter register 2";
        desc = "ISP_AF_IIRG2 is AF IIR filtering parameter register 2.

Data sheet 10.6 ISP_AF_IIRG2 (offset 0x22228, printed page 10-98, `hi3518ev200--Hi3518EV20X-Hi3516CV200-Datasheet.txt` line 64970).";

        field {
            name = "iirg2_1";
            desc = "g2 gain of AF IIR filtering group 2";
            sw = rw;
            hw = r;
            reset = 0x328;
        } iirg2_1[25:16];

        field {
            name = "iirg2_0";
            desc = "g2 gain of AF IIR filtering group 1";
            sw = rw;
            hw = r;
            reset = 0x328;
        } iirg2_0[9:0];
    } ISP_AF_IIRG2 @ 0x2228;

    reg {
        name = "AF IIR filtering parameter register 3";
        desc = "ISP_AF_IIRG3 is AF IIR filtering parameter register 3.

Data sheet 10.6 ISP_AF_IIRG3 (offset 0x2222C, printed page 10-98, `hi3518ev200--Hi3518EV20X-Hi3516CV200-Datasheet.txt` line 64999).";

        field {
            name = "iirg3_1";
            desc = "g3 gain of AF IIR filtering group 2";
            sw = rw;
            hw = r;
            reset = 0x0;
        } iirg3_1[25:16];

        field {
            name = "iirg3_0";
            desc = "g3 gain of AF IIR filtering group 1";
            sw = rw;
            hw = r;
            reset = 0x0;
        } iirg3_0[9:0];
    } ISP_AF_IIRG3 @ 0x222C;

    reg {
        name = "AF IIR filtering parameter register 4";
        desc = "ISP_AF_IIRG4 is AF IIR filtering parameter register 4.

Data sheet 10.6 ISP_AF_IIRG4 (offset 0x22230, printed page 10-99, `hi3518ev200--Hi3518EV20X-Hi3516CV200-Datasheet.txt` line 65038).";

        field {
            name = "iirg4_1";
            desc = "g4 gain of AF IIR filtering group 2";
            sw = rw;
            hw = r;
            reset = 0x0;
        } iirg4_1[25:16];

        field {
            name = "iirg4_0";
            desc = "g4 gain of AF IIR filtering group 1";
            sw = rw;
            hw = r;
            reset = 0x0;
        } iirg4_0[9:0];
    } ISP_AF_IIRG4 @ 0x2230;

    reg {
        name = "AF IIR filtering parameter register 5";
        desc = "ISP_AF_IIRG5 is AF IIR filtering parameter register 5.

Data sheet 10.6 ISP_AF_IIRG5 (offset 0x22234, printed page 10-99, `hi3518ev200--Hi3518EV20X-Hi3516CV200-Datasheet.txt` line 65067).";

        field {
            name = "iirg5_1";
            desc = "g5 gain of AF IIR filtering group 2";
            sw = rw;
            hw = r;
            reset = 0x284;
        } iirg5_1[25:16];

        field {
            name = "iirg5_0";
            desc = "g5 gain of AF IIR filtering group 1";
            sw = rw;
            hw = r;
            reset = 0x17C;
        } iirg5_0[9:0];
    } ISP_AF_IIRG5 @ 0x2234;

    reg {
        name = "AF IIR filtering parameter register 6";
        desc = "ISP_AF_IIRG6 is AF IIR filtering parameter register 6.

Data sheet 10.6 ISP_AF_IIRG6 (offset 0x22238, printed page 10-100, `hi3518ev200--Hi3518EV20X-Hi3516CV200-Datasheet.txt` line 65105).";

        field {
            name = "iirg6_1";
            desc = "g6 gain of AF IIR filtering group 2";
            sw = rw;
            hw = r;
            reset = 0x33C;
        } iirg6_1[25:16];

        field {
            name = "iirg6_0";
            desc = "g6 gain of AF IIR filtering group 1";
            sw = rw;
            hw = r;
            reset = 0x33C;
        } iirg6_0[9:0];
    } ISP_AF_IIRG6 @ 0x2238;

    reg {
        name = "AF IIR filtering shift parameter register";
        desc = "ISP_AF_SHIFT is an AF IIR filtering shift parameter register.

Data sheet 10.6 ISP_AF_SHIFT (offset 0x22240, printed page 10-101, `hi3518ev200--Hi3518EV20X-Hi3516CV200-Datasheet.txt` line 65143).";

        field {
            name = "iirshift1_3";
            desc = "Shift adjustment for IIR2 in AF IIR filtering group 2";
            sw = rw;
            hw = r;
            reset = 0x0;
        } iirshift1_3[31:28];

        field {
            name = "iirshift1_2";
            desc = "Shift adjustment for IIR1 in AF IIR filtering group 2";
            sw = rw;
            hw = r;
            reset = 0x0;
        } iirshift1_2[27:24];

        field {
            name = "iirshift1_1";
            desc = "Shift adjustment for IIR0 in AF IIR filtering group 2";
            sw = rw;
            hw = r;
            reset = 0x2;
        } iirshift1_1[23:20];

        field {
            name = "iirshift1_0";
            desc = "Input shift adjustment for AF IIR filtering group 2 Note the following: iirg0_1 >= 128, iirshift0_0 >= 4 iirg0_1 >= 64, iirshift0_0 >= 3 iirg0_1 >= 32, iirshift0_0 >= 2 iirg0_1 >= 16, iirshift0_0 >= 1";
            sw = rw;
            hw = r;
            reset = 0x7;
        } iirshift1_0[19:16];

        field {
            name = "iirshift0_3";
            desc = "Shift adjustment for IIR2 in AF IIR filtering group 1";
            sw = rw;
            hw = r;
            reset = 0x1;
        } iirshift0_3[15:12];

        field {
            name = "iirshift0_2";
            desc = "Shift adjustment for IIR1 in AF IIR filtering group 1";
            sw = rw;
            hw = r;
            reset = 0x0;
        } iirshift0_2[11:8];

        field {
            name = "iirshift0_1";
            desc = "Shift adjustment for IIR0 in AF IIR filtering group 1";
            sw = rw;
            hw = r;
            reset = 0x2;
        } iirshift0_1[7:4];

        field {
            name = "iirshift0_0";
            desc = "Input shift adjustment for AF IIR filtering group 1 Note the following: iirg0_0 >= 128, iirshift0_0 >= 4 iirg0_0 >= 64, iirshift0_0 >= 3 iirg0_0 >= 32, iirshift0_0 >= 2 iirg0_0 >= 16, iirshift0_0 >= 1";
            sw = rw;
            hw = r;
            reset = 0x7;
        } iirshift0_0[3:0];
    } ISP_AF_SHIFT @ 0x2240;

    reg {
        name = "AF FIR filtering parameter register 0";
        desc = "ISP_AF_FIRH0 is AF FIR filtering parameter register 0.

Data sheet 10.6 ISP_AF_FIRH0 (offset 0x22250, printed page 10-101, `hi3518ev200--Hi3518EV20X-Hi3516CV200-Datasheet.txt` line 65181).";

        field {
            name = "firh0_1";
            desc = "h0 gain of AF FIR filtering group 2";
            sw = rw;
            hw = r;
            reset = 0x30;
        } firh0_1[21:16];

        field {
            name = "firh0_0";
            desc = "h0 gain of AF FIR filtering group 1";
            sw = rw;
            hw = r;
            reset = 0x30;
        } firh0_0[5:0];
    } ISP_AF_FIRH0 @ 0x2250;

    reg {
        name = "AF FIR filtering parameter register 1";
        desc = "ISP_AF_FIRH1 is AF FIR filtering parameter register 1.

Data sheet 10.6 ISP_AF_FIRH1 (offset 0x22254, printed page 10-102, `hi3518ev200--Hi3518EV20X-Hi3516CV200-Datasheet.txt` line 65219).";

        field {
            name = "firh1_1";
            desc = "h1 gain of AF FIR filtering group 2";
            sw = rw;
            hw = r;
            reset = 0x15;
        } firh1_1[21:16];

        field {
            name = "firh1_0";
            desc = "h1 gain of AF FIR filtering group 1";
            sw = rw;
            hw = r;
            reset = 0x2B;
        } firh1_0[5:0];
    } ISP_AF_FIRH1 @ 0x2254;

    reg {
        name = "AF FIR filtering parameter register 2";
        desc = "ISP_AF_FIRH2 is AF FIR filtering parameter register 2.

Data sheet 10.6 ISP_AF_FIRH2 (offset 0x22258, printed page 10-103, `hi3518ev200--Hi3518EV20X-Hi3516CV200-Datasheet.txt` line 65257).";

        field {
            name = "firh2_1";
            desc = "h2 gain of AF FIR filtering group 2";
            sw = rw;
            hw = r;
            reset = 0x0;
        } firh2_1[21:16];

        field {
            name = "firh2_0";
            desc = "h2 gain of AF FIR filtering group 1";
            sw = rw;
            hw = r;
            reset = 0x0;
        } firh2_0[5:0];
    } ISP_AF_FIRH2 @ 0x2258;

    reg {
        name = "AF FIR filtering parameter register 3";
        desc = "ISP_AF_FIRH3 is AF FIR filtering parameter register 3.

Data sheet 10.6 ISP_AF_FIRH3 (offset 0x2225C, printed page 10-103, `hi3518ev200--Hi3518EV20X-Hi3516CV200-Datasheet.txt` line 65286).";

        field {
            name = "firh3_1";
            desc = "h3 gain of AF FIR filtering group 2";
            sw = rw;
            hw = r;
            reset = 0x2B;
        } firh3_1[21:16];

        field {
            name = "firh3_0";
            desc = "h3 gain of AF FIR filtering group 1";
            sw = rw;
            hw = r;
            reset = 0x15;
        } firh3_0[5:0];
    } ISP_AF_FIRH3 @ 0x225C;

    reg {
        name = "AF FIR filtering parameter register 4";
        desc = "ISP_AF_FIRH4 is AF FIR filtering parameter register 4.

Data sheet 10.6 ISP_AF_FIRH4 (offset 0x22260, printed page 10-104, `hi3518ev200--Hi3518EV20X-Hi3516CV200-Datasheet.txt` line 65320).";

        field {
            name = "firh4_1";
            desc = "h4 gain of AF FIR filtering group 2";
            sw = rw;
            hw = r;
            reset = 0x10;
        } firh4_1[21:16];

        field {
            name = "firh4_0";
            desc = "h4 gain of AF FIR filtering group 1";
            sw = rw;
            hw = r;
            reset = 0x10;
        } firh4_0[5:0];
    } ISP_AF_FIRH4 @ 0x2260;

    reg {
        name = "AF IIR filtering threshold register";
        desc = "ISP_AF_IIRTHRE is an AF IIR filtering threshold register.

Data sheet 10.6 ISP_AF_IIRTHRE (offset 0x22270, printed page 10-104, `hi3518ev200--Hi3518EV20X-Hi3516CV200-Datasheet.txt` line 65349).";

        field {
            name = "thre2_x";
            desc = "Statistics threshold of AF IIR filtering group 2";
            sw = rw;
            hw = r;
            reset = 0x14;
        } thre2_x[26:16];

        field {
            name = "thre1_x";
            desc = "Statistics threshold of AF IIR filtering group 1";
            sw = rw;
            hw = r;
            reset = 0x64;
        } thre1_x[10:0];
    } ISP_AF_IIRTHRE @ 0x2270;

    reg {
        name = "AF FIR filtering threshold register";
        desc = "ISP_AF_FIRTHRE is an AF FIR filtering threshold register.

Data sheet 10.6 ISP_AF_FIRTHRE (offset 0x22274, printed page 10-105, `hi3518ev200--Hi3518EV20X-Hi3516CV200-Datasheet.txt` line 65376).";

        field {
            name = "thre2_y";
            desc = "Statistics threshold of AF FIR filtering group 2";
            sw = rw;
            hw = r;
            reset = 0xA;
        } thre2_y[26:16];

        field {
            name = "thre1_y";
            desc = "Statistics threshold of AF FIR filtering group 1";
            sw = rw;
            hw = r;
            reset = 0x32;
        } thre1_y[10:0];
    } ISP_AF_FIRTHRE @ 0x2274;

    reg {
        name = "AF cumulative statistics shift register";
        desc = "ISP_AF_ACC_SHIFT is an AF cumulative statistics shift register.

Data sheet 10.6 ISP_AF_ACC_SHIFT (offset 0x22278, printed page 10-105, `hi3518ev200--Hi3518EV20X-Hi3516CV200-Datasheet.txt` line 65398).";

        field {
            name = "acc_shift_y";
            desc = "Luminance Y statistics shift (0-15). Y in CH_AF_STAT_RDATA is shifted.";
            sw = rw;
            hw = r;
            reset = 0x2;
        } acc_shift_y[19:16];

        field {
            name = "acc_shift2_v";
            desc = "Shift of vertical FIR filtering statistics in group 2 (0-15). V2 in CH_AF_STAT_RDATA is shifted.";
            sw = rw;
            hw = r;
            reset = 0x0;
        } acc_shift2_v[15:12];

        field {
            name = "acc_shift1_v";
            desc = "Shift of vertical FIR filtering statistics in group 1 (0-15). V1 in CH_AF_STAT_RDATA is shifted.";
            sw = rw;
            hw = r;
            reset = 0x2;
        } acc_shift1_v[11:8];

        field {
            name = "acc_shift2_h";
            desc = "Shift of horizontal IIR filtering statistics in group 2 (0-15). H2 in CH_AF_STAT_RDATA is shifted.";
            sw = rw;
            hw = r;
            reset = 0x0;
        } acc_shift2_h[7:4];

        field {
            name = "acc_shift1_h";
            desc = "Shift of horizontal IIR filtering statistics in group 1 (0-15). H1 in CH_AF_STAT_RDATA is shifted.";
            sw = rw;
            hw = r;
            reset = 0x0;
        } acc_shift1_h[3:0];
    } ISP_AF_ACC_SHIFT @ 0x2278;

    reg {
        name = "AF count statistics shift register";
        desc = "ISP_AF_CNT_SHIFT is an AF count statistics shift register.

Data sheet 10.6 ISP_AF_CNT_SHIFT (offset 0x2227C, printed page 10-106, `hi3518ev200--Hi3518EV20X-Hi3516CV200-Datasheet.txt` line 65437).";

        field {
            name = "cnt_shift2_v";
            desc = "Shift of the vertical FIR filtering statistics in group 2 (0-15). vcnt2 in CH_AF_STAT_RDATA is shifted.";
            sw = rw;
            hw = r;
            reset = 0x0;
        } cnt_shift2_v[15:12];

        field {
            name = "cnt_shift1_v";
            desc = "Shift of the vertical FIR filtering statistics in group 1 (0-15). vcnt1 in CH_AF_STAT_RDATA is shifted.";
            sw = rw;
            hw = r;
            reset = 0x2;
        } cnt_shift1_v[11:8];

        field {
            name = "cnt_shift2_h";
            desc = "Shift of the horizontal IIR filtering statistics in group 2 (0-15). hcnt2 in CH_AF_STAT_RDATA is shifted.";
            sw = rw;
            hw = r;
            reset = 0x0;
        } cnt_shift2_h[7:4];

        field {
            name = "cnt_shift1_h";
            desc = "Shift of the horizontal IIR filtering statistics in group 1 (0-15). hcnt1 in CH_AF_STAT_RDATA is shifted.";
            sw = rw;
            hw = r;
            reset = 0x0;
        } cnt_shift1_h[3:0];
    } ISP_AF_CNT_SHIFT @ 0x227C;

    reg {
        name = "Statistics indirect read address DR register for AF blocks";
        desc = "ISP_AF_STAT_IND_RADDR is a statistics indirect read address register for AF blocks.

Data sheet 10.6 ISP_AF_STAT_IND_RADDR (offset 0x22288, printed page 10-106, `hi3518ev200--Hi3518EV20X-Hi3516CV200-Datasheet.txt` line 65468).";

        field {
            name = "af_stat_ind_raddr";
            desc = "Statistics indirect read address register for AF blocks";
            sw = rw;
            hw = r;
            reset = 0x0;
        } af_stat_ind_raddr[31:0];
    } ISP_AF_STAT_IND_RADDR @ 0x2288;

    reg {
        name = "Statistics indirect read data register A for AF blocks";
        desc = "ISP_AF_STAT_IND_RDATA is a statistics indirect read data register for AF blocks.

Data sheet 10.6 ISP_AF_STAT_IND_RDATA (offset 0x2228C, printed page 10-107, `hi3518ev200--Hi3518EV20X-Hi3516CV200-Datasheet.txt` line 65496).";

        field {
            name = "af_stat_ind_rdata";
            desc = "Statistics indirect read data register for AF blocks V1[16], H1[16], V2[16], H2[16], Y[16], hcnt1, hcnt2, vcnt1, and vcnt2 information about each block is collected for statistics. The following is the information for each address: When data_mode is 0: 0x00: {V1 (16 bits), H1 (16 bits)} of block 1 0x04: {V2 (16 bits), H2 (16 bits)} of block 1 0x08: Y (16 bits) of block 1 … The same rule applies to other values. When data_mode is 1: 0x00: {Y_h (6 bits), V1 (13 bits), H1 (13 bits)} of block 1 0x04: {Y_l (6 bits), V2 (13 bits), H2 (13 bits)} of block 1 0x08: {vcnt2 (8 bits), vcnt1 (8 bits), hcnt2 (8 bits), cnt1 (8 bits)} of block 1 … The same rule applies to other values. Note the following: V1 indicates the vertical FIR filtering statistics of group 1. V2 indicates the vertical FIR filtering statistics of group 2. H1 indicates the horizontal IIR filtering statistics of group 1. H2 indicates the horizontal IIR filtering statistics of group 2. Y indicates luminance statistics. vcnt1 indicates the number of times that the FIR filtering value is above the threshold. vcnt2 indicates the number of times that the FIR filtering value is above the threshold. hcnt1 indicates the number of times that the IIR filtering value is above the threshold. hcnt2 indicates the number of times that the IIR filtering value is above the threshold.";
            sw = r;
            hw = w;
            reset = 0x0;
        } af_stat_ind_rdata[31:0];
    } ISP_AF_STAT_IND_RDATA @ 0x228C;

    reg {
        name = "Demosaic control register";
        desc = "ISP_DEMOSAIC_CFG is a demosaic control register.

Data sheet 10.6 ISP_DEMOSAIC_CFG (offset 0x23000, printed page 10-108, `hi3518ev200--Hi3518EV20X-Hi3516CV200-Datasheet.txt` line 65552).";

        enum ISP_DEMOSAIC_CFG_en_enum {
            DISABLED = 0 { name = "Disabled"; desc = "disabled"; };
            ENABLED = 1 { name = "Enabled"; desc = "enabled"; };
        };

        field {
            name = "en";
            desc = "Demosaic enable";
            sw = rw;
            hw = r;
            encode = ISP_DEMOSAIC_CFG_en_enum;
            reset = 0x0;
        } en[0:0];
    } ISP_DEMOSAIC_CFG @ 0x3000;

    reg {
        name = "Demosaic internal algorithm enable register";
        desc = "ISP_DEMOSAIC_CFG1 is a demosaic internal algorithm enable register.

Data sheet 10.6 ISP_DEMOSAIC_CFG1 (offset 0x23004, printed page 10-108, `hi3518ev200--Hi3518EV20X-Hi3516CV200-Datasheet.txt` line 65574).";

        enum ISP_DEMOSAIC_CFG1_fcr_en_enum {
            DISABLED = 0 { name = "Disabled"; desc = "disabled"; };
            ENABLED = 1 { name = "Enabled"; desc = "enabled"; };
        };

        field {
            name = "fcr_en";
            desc = "Demosaic FCR enable";
            sw = rw;
            hw = r;
            encode = ISP_DEMOSAIC_CFG1_fcr_en_enum;
            reset = 0x0;
        } fcr_en[16:16];

        enum ISP_DEMOSAIC_CFG1_ahd_en_enum {
            DISABLED = 0 { name = "Disabled"; desc = "disabled"; };
            ENABLED = 1 { name = "Enabled"; desc = "enabled"; };
        };

        field {
            name = "ahd_en";
            desc = "Demosaic AHD enable";
            sw = rw;
            hw = r;
            encode = ISP_DEMOSAIC_CFG1_ahd_en_enum;
            reset = 0x0;
        } ahd_en[0:0];
    } ISP_DEMOSAIC_CFG1 @ 0x3004;

    reg {
        name = "Demosaic parameter register";
        desc = "ISP_DEMOSAIC_COEF0 is a demosaic parameter register.

Data sheet 10.6 ISP_DEMOSAIC_COEF0 (offset 0x23010, printed page 10-109, `hi3518ev200--Hi3518EV20X-Hi3516CV200-Datasheet.txt` line 65607).";

        field {
            name = "bld_limit1";
            desc = "Demosaic gradient blending threshold (U8.0)";
            sw = rw;
            hw = r;
            reset = 0x0;
        } bld_limit1[23:16];

        field {
            name = "bld_limit2";
            desc = "Demosaic gradient blending threshold (U8.0)";
            sw = rw;
            hw = r;
            reset = 0x0;
        } bld_limit2[7:0];
    } ISP_DEMOSAIC_COEF0 @ 0x3010;

    reg {
        name = "Demosaic parameter register";
        desc = "ISP_DEMOSAIC_COEF1 is a demosaic parameter register.

Data sheet 10.6 ISP_DEMOSAIC_COEF1 (offset 0x23014, printed page 10-109, `hi3518ev200--Hi3518EV20X-Hi3516CV200-Datasheet.txt` line 65629).";

        field {
            name = "bld_ratio1";
            desc = "Demosaic gradient blending threshold (U9.0)";
            sw = rw;
            hw = r;
            reset = 0x0;
        } bld_ratio1[24:16];

        field {
            name = "bld_ratio2";
            desc = "Demosaic gradient blending threshold (U9.0)";
            sw = rw;
            hw = r;
            reset = 0x0;
        } bld_ratio2[8:0];
    } ISP_DEMOSAIC_COEF1 @ 0x3014;

    reg {
        name = "Demosaic parameter register";
        desc = "ISP_DEMOSAIC_COEF2 is a demosaic parameter register.

Data sheet 10.6 ISP_DEMOSAIC_COEF2 (offset 0x23018, printed page 10-110, `hi3518ev200--Hi3518EV20X-Hi3516CV200-Datasheet.txt` line 65659).";

        field {
            name = "fcr_limit1";
            desc = "Demosaic FCR threshold (U12.0)";
            sw = rw;
            hw = r;
            reset = 0x0;
        } fcr_limit1[27:16];

        field {
            name = "fcr_limit2";
            desc = "Demosaic FCR threshold (U12.0)";
            sw = rw;
            hw = r;
            reset = 0x0;
        } fcr_limit2[11:0];
    } ISP_DEMOSAIC_COEF2 @ 0x3018;

    reg {
        name = "Demosaic parameter register";
        desc = "ISP_DEMOSAIC_COEF3 is a demosaic parameter register.

Data sheet 10.6 ISP_DEMOSAIC_COEF3 (offset 0x2301C, printed page 10-110, `hi3518ev200--Hi3518EV20X-Hi3516CV200-Datasheet.txt` line 65681).";

        field {
            name = "ahd_par1";
            desc = "Demosaic AHD coefficient (U10.0)";
            sw = rw;
            hw = r;
            reset = 0x0;
        } ahd_par1[25:16];

        field {
            name = "ahd_par2";
            desc = "Demosaic AHD coefficient (U8.0)";
            sw = rw;
            hw = r;
            reset = 0x0;
        } ahd_par2[7:0];
    } ISP_DEMOSAIC_COEF3 @ 0x301C;

    reg {
        name = "Demosaic parameter register";
        desc = "ISP_DEMOSAIC_COEF4 is a demosaic parameter register.

Data sheet 10.6 ISP_DEMOSAIC_COEF4 (offset 0x23020, printed page 10-111, `hi3518ev200--Hi3518EV20X-Hi3516CV200-Datasheet.txt` line 65712).";

        field {
            name = "fcr_thr";
            desc = "Demosaic FCR threshold (U12.0)";
            sw = rw;
            hw = r;
            reset = 0x0;
        } fcr_thr[27:16];

        field {
            name = "fcr_gain";
            desc = "Demosaic FCR gain (U5.0)";
            sw = rw;
            hw = r;
            reset = 0x0;
        } fcr_gain[4:0];
    } ISP_DEMOSAIC_COEF4 @ 0x3020;

    reg {
        name = "Demosaic parameter register";
        desc = "ISP_DEMOSAIC_COEF5 is a demosaic parameter register.

Data sheet 10.6 ISP_DEMOSAIC_COEF5 (offset 0x23024, printed page 10-111, `hi3518ev200--Hi3518EV20X-Hi3516CV200-Datasheet.txt` line 65734).";

        field {
            name = "hv_ratio";
            desc = "Direction ratio (U8.0)";
            sw = rw;
            hw = r;
            reset = 0x0;
        } hv_ratio[7:0];
    } ISP_DEMOSAIC_COEF5 @ 0x3024;

    reg {
        name = "Demosaic parameter register";
        desc = "ISP_DEMOSAIC_COEF6 is a demosaic parameter register.

Data sheet 10.6 ISP_DEMOSAIC_COEF6 (offset 0x23028, printed page 10-111, `hi3518ev200--Hi3518EV20X-Hi3516CV200-Datasheet.txt` line 65754).";

        field {
            name = "fcr_ratio";
            desc = "FCR adjustment ratio (U6.0)";
            sw = rw;
            hw = r;
            reset = 0x0;
        } fcr_ratio[5:0];
    } ISP_DEMOSAIC_COEF6 @ 0x3028;

    reg {
        name = "Demosaic threshold register";
        desc = "ISP_DEMOSAIC_SEL is a demosaic threshold register.

Data sheet 10.6 ISP_DEMOSAIC_SEL (offset 0x23030, printed page 10-112, `hi3518ev200--Hi3518EV20X-Hi3516CV200-Datasheet.txt` line 65783).";

        field {
            name = "hv_sel";
            desc = "Direction select (U2.0)";
            sw = rw;
            hw = r;
            reset = 0x0;
        } hv_sel[1:0];
    } ISP_DEMOSAIC_SEL @ 0x3030;

    reg {
        name = "RGB IR enable register";
        desc = "ISP_RGBIR_CFG is an RGBIR enable register.

Data sheet 10.6 ISP_RGBIR_CFG (offset 0x23100, printed page 10-112, `hi3518ev200--Hi3518EV20X-Hi3516CV200-Datasheet.txt` line 65805).";

        enum ISP_RGBIR_CFG_en_enum {
            DISABLED = 0 { name = "Disabled"; desc = "disabled"; };
            ENABLED = 1 { name = "Enabled"; desc = "enabled"; };
        };

        field {
            name = "en";
            desc = "RGBIR enable";
            sw = rw;
            hw = r;
            encode = ISP_RGBIR_CFG_en_enum;
            reset = 0x0;
        } en[0:0];
    } ISP_RGBIR_CFG @ 0x3100;

    reg {
        name = "RGB IR enable register 0";
        desc = "ISP_RGBIR_CFG0 is RGBIR enable register 0.

Data sheet 10.6 ISP_RGBIR_CFG0 (offset 0x23104, printed page 10-113, `hi3518ev200--Hi3518EV20X-Hi3516CV200-Datasheet.txt` line 65835).";

        enum ISP_RGBIR_CFG0_ir_out_en_enum {
            DISABLED = 0 { name = "Disabled"; desc = "disabled"; };
            ENABLED = 1 { name = "Enabled"; desc = "enabled"; };
        };

        field {
            name = "ir_out_en";
            desc = "RGBIR IR component output enable";
            sw = rw;
            hw = r;
            encode = ISP_RGBIR_CFG0_ir_out_en_enum;
            reset = 0x0;
        } ir_out_en[19:19];

        enum ISP_RGBIR_CFG0_ir_filter_en_enum {
            DISABLED = 0 { name = "Disabled"; desc = "disabled"; };
            ENABLED = 1 { name = "Enabled"; desc = "enabled"; };
        };

        field {
            name = "ir_filter_en";
            desc = "RGBIR IR interpolation filtering enable";
            sw = rw;
            hw = r;
            encode = ISP_RGBIR_CFG0_ir_filter_en_enum;
            reset = 0x0;
        } ir_filter_en[18:18];

        enum ISP_RGBIR_CFG0_blc_off_en_enum {
            DISABLED = 0 { name = "Disabled"; desc = "disabled"; };
            ENABLED = 1 { name = "Enabled"; desc = "enabled"; };
        };

        field {
            name = "blc_off_en";
            desc = "RGBIR de-BLC component enable";
            sw = rw;
            hw = r;
            encode = ISP_RGBIR_CFG0_blc_off_en_enum;
            reset = 0x0;
        } blc_off_en[17:17];

        enum ISP_RGBIR_CFG0_ir_remove_en_enum {
            DISABLED = 0 { name = "Disabled"; desc = "disabled"; };
            ENABLED = 1 { name = "Enabled"; desc = "enabled"; };
        };

        field {
            name = "ir_remove_en";
            desc = "RGBIR de-IR component enable";
            sw = rw;
            hw = r;
            encode = ISP_RGBIR_CFG0_ir_remove_en_enum;
            reset = 0x0;
        } ir_remove_en[16:16];

        enum ISP_RGBIR_CFG0_auto_gain_en_enum {
            DISABLED = 0 { name = "Disabled"; desc = "disabled"; };
            ENABLED = 1 { name = "Enabled"; desc = "enabled"; };
        };

        field {
            name = "auto_gain_en";
            desc = "RGBIR automatic gain enable";
            sw = rw;
            hw = r;
            encode = ISP_RGBIR_CFG0_auto_gain_en_enum;
            reset = 0x0;
        } auto_gain_en[1:1];

        enum ISP_RGBIR_CFG0_manu_gain_en_enum {
            DISABLED = 0 { name = "Disabled"; desc = "disabled"; };
            ENABLED = 1 { name = "Enabled"; desc = "enabled"; };
        };

        field {
            name = "manu_gain_en";
            desc = "RGBIR manual gain enable";
            sw = rw;
            hw = r;
            encode = ISP_RGBIR_CFG0_manu_gain_en_enum;
            reset = 0x1;
        } manu_gain_en[0:0];
    } ISP_RGBIR_CFG0 @ 0x3104;

    reg {
        name = "RGB IR control register";
        desc = "ISP_RGBIR_CTRL is an RGBIR control register.

Data sheet 10.6 ISP_RGBIR_CTRL (offset 0x23110, printed page 10-114, `hi3518ev200--Hi3518EV20X-Hi3516CV200-Datasheet.txt` line 65889).";

        enum ISP_RGBIR_CTRL_ir_position_enum {
            IR_USES_GB = 1 { name = "Ir Uses Gb"; desc = "The IR uses the Gb channel."; };
            IR_USES_GR = 0 { name = "Ir Uses Gr"; desc = "The IR uses the Gr channel."; };
        };

        field {
            name = "ir_position";
            desc = "ir_position";
            sw = rw;
            hw = r;
            encode = ISP_RGBIR_CTRL_ir_position_enum;
            reset = 0x1;
        } ir_position[0:0];
    } ISP_RGBIR_CTRL @ 0x3110;

    reg {
        name = "RGB IR manual gain register";
        desc = "ISP_RGBIR_MANU_GAIN is an RGBIR manual gain register.

Data sheet 10.6 ISP_RGBIR_MANU_GAIN (offset 0x23120, printed page 10-114, `hi3518ev200--Hi3518EV20X-Hi3516CV200-Datasheet.txt` line 65917).";

        field {
            name = "manu_gain";
            desc = "RGBIR manual gain";
            sw = rw;
            hw = r;
            reset = 0x1;
        } manu_gain[9:0];
    } ISP_RGBIR_MANU_GAIN @ 0x3120;

    reg {
        name = "RGB IR G component minimum value register";
        desc = "ISP_RGBIR_MIN_G is an RGBIR G component minimum value register.

Data sheet 10.6 ISP_RGBIR_MIN_G (offset 0x23130, printed page 10-115, `hi3518ev200--Hi3518EV20X-Hi3516CV200-Datasheet.txt` line 65945).";

        field {
            name = "min_g";
            desc = "Minimum value of the G component";
            sw = rw;
            hw = r;
            reset = 0x3FF;
        } min_g[11:0];
    } ISP_RGBIR_MIN_G @ 0x3130;

    reg {
        name = "RGB IR R/B component maximum value register";
        desc = "ISP_RGBIR_MAX_RB is an RGBIR R/B component maximum value register.

Data sheet 10.6 ISP_RGBIR_MAX_RB (offset 0x23134, printed page 10-115, `hi3518ev200--Hi3518EV20X-Hi3516CV200-Datasheet.txt` line 65965).";

        field {
            name = "max_rb";
            desc = "Maximum value of the R/B component";
            sw = rw;
            hw = r;
            reset = 0x3FF;
        } max_rb[11:0];
    } ISP_RGBIR_MAX_RB @ 0x3134;

    reg {
        name = "RGB IR black level register EL";
        desc = "ISP_RGBIR_BLACK_LEVEL is an RGBIR black level register.

Data sheet 10.6 ISP_RGBIR_BLACK_LEVEL (offset 0x23138, printed page 10-115, `hi3518ev200--Hi3518EV20X-Hi3516CV200-Datasheet.txt` line 65984).";

        field {
            name = "black_level";
            desc = "RGBIR black level";
            sw = rw;
            hw = r;
            reset = 0x3FF;
        } black_level[11:0];
    } ISP_RGBIR_BLACK_LEVEL @ 0x3138;

    reg {
        name = "RGB IR filtering coefficient register 0";
        desc = "ISP_RGBIR_F0 is RGBIR filtering coefficient register 0.

Data sheet 10.6 ISP_RGBIR_F0 (offset 0x23140, printed page 10-116, `hi3518ev200--Hi3518EV20X-Hi3516CV200-Datasheet.txt` line 66010).";

        field {
            name = "coef02";
            desc = "RGBIR filtering coefficient";
            sw = rw;
            hw = r;
            reset = 0x0;
        } coef02[11:8];

        field {
            name = "coef01";
            desc = "RGBIR filtering coefficient";
            sw = rw;
            hw = r;
            reset = 0x0;
        } coef01[7:4];

        field {
            name = "coef00";
            desc = "RGBIR filtering coefficient";
            sw = rw;
            hw = r;
            reset = 0x0;
        } coef00[3:0];
    } ISP_RGBIR_F0 @ 0x3140;

    reg {
        name = "RGB IR filtering coefficient register 1";
        desc = "ISP_RGBIR_F1 is RGBIR filtering coefficient register 1.

Data sheet 10.6 ISP_RGBIR_F1 (offset 0x23144, printed page 10-116, `hi3518ev200--Hi3518EV20X-Hi3516CV200-Datasheet.txt` line 66032).";

        field {
            name = "coef12";
            desc = "RGBIR filtering coefficient";
            sw = rw;
            hw = r;
            reset = 0x0;
        } coef12[11:8];

        field {
            name = "coef11";
            desc = "RGBIR filtering coefficient";
            sw = rw;
            hw = r;
            reset = 0x0;
        } coef11[7:4];

        field {
            name = "coef10";
            desc = "RGBIR filtering coefficient";
            sw = rw;
            hw = r;
            reset = 0x0;
        } coef10[3:0];
    } ISP_RGBIR_F1 @ 0x3144;

    reg {
        name = "RGB IR filtering coefficient register 2";
        desc = "ISP_RGBIR_F2 is RGBIR filtering coefficient register 2.

Data sheet 10.6 ISP_RGBIR_F2 (offset 0x23148, printed page 10-117, `hi3518ev200--Hi3518EV20X-Hi3516CV200-Datasheet.txt` line 66062).";

        field {
            name = "coef22";
            desc = "RGBIR filtering coefficient";
            sw = rw;
            hw = r;
            reset = 0x0;
        } coef22[11:8];

        field {
            name = "coef21";
            desc = "RGBIR filtering coefficient";
            sw = rw;
            hw = r;
            reset = 0x0;
        } coef21[7:4];

        field {
            name = "coef20";
            desc = "RGBIR filtering coefficient";
            sw = rw;
            hw = r;
            reset = 0x0;
        } coef20[3:0];
    } ISP_RGBIR_F2 @ 0x3148;

    reg {
        name = "RGB IR threshold register";
        desc = "ISP_RGBIR_THRE is an RGBIR threshold register.

Data sheet 10.6 ISP_RGBIR_THRE (offset 0x23150, printed page 10-117, `hi3518ev200--Hi3518EV20X-Hi3516CV200-Datasheet.txt` line 66084).";

        field {
            name = "thre2";
            desc = "RGBIR direction determining threshold 2";
            sw = rw;
            hw = r;
            reset = 0x0;
        } thre2[23:16];

        field {
            name = "thre1";
            desc = "RGBIR direction determining threshold 1";
            sw = rw;
            hw = r;
            reset = 0x0;
        } thre1[7:0];
    } ISP_RGBIR_THRE @ 0x3150;

    reg {
        name = "RGB IR exposure value register";
        desc = "ISP_RGBIR_EXP_VALUE is an RGBIR exposure value register.

Data sheet 10.6 ISP_RGBIR_EXP_VALUE (offset 0x23160, printed page 10-118, `hi3518ev200--Hi3518EV20X-Hi3516CV200-Datasheet.txt` line 66115).";

        field {
            name = "exp_value";
            desc = "RGBIR overexposure threshold";
            sw = rw;
            hw = r;
            reset = 0x0;
        } exp_value[11:0];
    } ISP_RGBIR_EXP_VALUE @ 0x3160;

    reg {
        name = "RGB IR gain use value register";
        desc = "ISP_RGBIR_GAIN_USE is an RGBIR gain use value register.

Data sheet 10.6 ISP_RGBIR_GAIN_USE (offset 0x23164, printed page 10-118, `hi3518ev200--Hi3518EV20X-Hi3516CV200-Datasheet.txt` line 66135).";

        field {
            name = "gain_use";
            desc = "RGBIR gain_use statistics";
            sw = r;
            hw = w;
            reset = 0x0;
        } gain_use[11:0];
    } ISP_RGBIR_GAIN_USE @ 0x3164;

    reg {
        name = "RGB IR overexposure statistics register";
        desc = "ISP_RGBIR_EXP_CNT is an RGBIR overexposure statistics register.

Data sheet 10.6 ISP_RGBIR_EXP_CNT (offset 0x23168, printed page 10-118, `hi3518ev200--Hi3518EV20X-Hi3516CV200-Datasheet.txt` line 66154).";

        field {
            name = "exp_cnt";
            desc = "Number of times that RGBIR overexposure occurs";
            sw = r;
            hw = w;
            reset = 0x0;
        } exp_cnt[19:0];
    } ISP_RGBIR_EXP_CNT @ 0x3168;

    reg {
        name = "RGB IR filtering B coefficient register";
        desc = "ISP_RGBIR_SCALE_B is an RGBIR IR filtering B point coefficient register.

Data sheet 10.6 ISP_RGBIR_SCALE_B (offset 0x23170, printed page 10-119, `hi3518ev200--Hi3518EV20X-Hi3516CV200-Datasheet.txt` line 66180).";

        field {
            name = "b_b";
            desc = "B component coefficient for the B point during RGBIR matrix operation, 8-bit signed decimal";
            sw = rw;
            hw = r;
            reset = 0x0;
        } b_b[29:20];

        field {
            name = "b_g";
            desc = "G component coefficient for the B point during RGBIR matrix operation, 8-bit signed decimal";
            sw = rw;
            hw = r;
            reset = 0x0;
        } b_g[19:10];

        field {
            name = "b_r";
            desc = "R component coefficient for the B point during RGBIR matrix operation, 8-bit signed decimal";
            sw = rw;
            hw = r;
            reset = 0x0;
        } b_r[9:0];
    } ISP_RGBIR_SCALE_B @ 0x3170;

    reg {
        name = "RGB IR filtering G coefficient register";
        desc = "ISP_RGBIR_SCALE_G is an RGBIR IR filtering G point coefficient register.

Data sheet 10.6 ISP_RGBIR_SCALE_G (offset 0x23174, printed page 10-119, `hi3518ev200--Hi3518EV20X-Hi3516CV200-Datasheet.txt` line 66211).";

        field {
            name = "g_b";
            desc = "B component coefficient for the G point during RGBIR matrix operation, 8-bit signed decimal";
            sw = rw;
            hw = r;
            reset = 0x0;
        } g_b[29:20];

        field {
            name = "g_g";
            desc = "G component coefficient for the G point during RGBIR matrix operation, 8-bit signed decimal";
            sw = rw;
            hw = r;
            reset = 0x0;
        } g_g[19:10];

        field {
            name = "g_r";
            desc = "R component coefficient for the G point during RGBIR matrix operation, 8-bit signed decimal";
            sw = rw;
            hw = r;
            reset = 0x0;
        } g_r[9:0];
    } ISP_RGBIR_SCALE_G @ 0x3174;

    reg {
        name = "RGB IR filtering R coefficient register";
        desc = "ISP_RGBIR_SCALE_R is an RGBIR IR filtering R point coefficient register.

Data sheet 10.6 ISP_RGBIR_SCALE_R (offset 0x23178, printed page 10-120, `hi3518ev200--Hi3518EV20X-Hi3516CV200-Datasheet.txt` line 66253).";

        field {
            name = "r_b";
            desc = "B component coefficient for the R point during RGBIR matrix operation, 8-bit signed decimal";
            sw = rw;
            hw = r;
            reset = 0x0;
        } r_b[29:20];

        field {
            name = "r_g";
            desc = "G component coefficient for the R point during RGBIR matrix operation, 8-bit signed decimal";
            sw = rw;
            hw = r;
            reset = 0x0;
        } r_g[19:10];

        field {
            name = "r_r";
            desc = "R component coefficient for the R point during RGBIR matrix operation, 8-bit signed decimal";
            sw = rw;
            hw = r;
            reset = 0x0;
        } r_r[9:0];
    } ISP_RGBIR_SCALE_R @ 0x3178;

    reg {
        name = "RGB IR filtering IR coefficient register";
        desc = "ISP_RGBIR_SCALE_IR is an RGBIR IR filtering IR coefficient register.

Data sheet 10.6 ISP_RGBIR_SCALE_IR (offset 0x2317C, printed page 10-120, `hi3518ev200--Hi3518EV20X-Hi3516CV200-Datasheet.txt` line 66284).";

        field {
            name = "b_ir";
            desc = "IR component coefficient for the B point during RGBIR matrix operation, 8-bit signed decimal";
            sw = rw;
            hw = r;
            reset = 0x0;
        } b_ir[29:20];

        field {
            name = "g_ir";
            desc = "IR component coefficient for the G point during RGBIR matrix operation, 8-bit signed decimal";
            sw = rw;
            hw = r;
            reset = 0x0;
        } g_ir[19:10];

        field {
            name = "r_ir";
            desc = "IR component coefficient for the R point during RGBIR matrix operation, 8-bit signed decimal";
            sw = rw;
            hw = r;
            reset = 0x0;
        } r_ir[9:0];
    } ISP_RGBIR_SCALE_IR @ 0x317C;

    reg {
        name = "RGB IR filtering C coefficient register";
        desc = "ISP_RGBIR_SCALE_C is an RGBIR IR filtering C coefficient register.

Data sheet 10.6 ISP_RGBIR_SCALE_C (offset 0x23180, printed page 10-121, `hi3518ev200--Hi3518EV20X-Hi3516CV200-Datasheet.txt` line 66326).";

        field {
            name = "b_c";
            desc = "C component coefficient for the B point during RGBIR matrix operation, 8-bit signed decimal";
            sw = rw;
            hw = r;
            reset = 0x0;
        } b_c[29:20];

        field {
            name = "g_c";
            desc = "C component coefficient for the G point during RGBIR matrix operation, 8-bit signed decimal";
            sw = rw;
            hw = r;
            reset = 0x0;
        } g_c[19:10];

        field {
            name = "r_c";
            desc = "C component coefficient for the R point during RGBIR matrix operation, 8-bit signed decimal";
            sw = rw;
            hw = r;
            reset = 0x0;
        } r_c[9:0];
    } ISP_RGBIR_SCALE_C @ 0x3180;

    reg {
        name = "2DNR enable register";
        desc = "ISP_AWB_CFG is a 2DNR enable register.

Data sheet 10.6 ISP_2DNR_CFG (offset 0x24000, printed page 10-122, `hi3518ev200--Hi3518EV20X-Hi3516CV200-Datasheet.txt` line 66367).";

        enum ISP_2DNR_CFG_luma_nr_en_enum {
            DISABLED = 0 { name = "Disabled"; desc = "disabled"; };
            ENABLED = 1 { name = "Enabled"; desc = "enabled"; };
        };

        field {
            name = "luma_nr_en";
            desc = "2DNR luminance denoising enable";
            sw = rw;
            hw = r;
            encode = ISP_2DNR_CFG_luma_nr_en_enum;
            reset = 0x0;
        } luma_nr_en[1:1];

        enum ISP_2DNR_CFG_en_enum {
            DISABLED = 0 { name = "Disabled"; desc = "disabled"; };
            ENABLED = 1 { name = "Enabled"; desc = "enabled"; };
        };

        field {
            name = "en";
            desc = "2DNR enable";
            sw = rw;
            hw = r;
            encode = ISP_2DNR_CFG_en_enum;
            reset = 0x0;
        } en[0:0];
    } ISP_2DNR_CFG @ 0x4000;

    reg {
        name = "2DNR anti-false color configuration register";
        desc = "ISP_2DNR_FCR is a 2DNR anti-false color configuration register.

Data sheet 10.6 ISP_2DNR_FCR (offset 0x24010, printed page 10-122, `hi3518ev200--Hi3518EV20X-Hi3516CV200-Datasheet.txt` line 66398).";

        field {
            name = "falsecolorenable";
            desc = "Anti-false color enable";
            sw = rw;
            hw = r;
            reset = 0x0;
        } falsecolorenable[24:24];

        field {
            name = "falsecolorshift";
            desc = "False color offset";
            sw = rw;
            hw = r;
            reset = 0x0;
        } falsecolorshift[23:16];

        field {
            name = "falsecolorgain";
            desc = "False color gain";
            sw = rw;
            hw = r;
            reset = 0x0;
        } falsecolorgain[15:8];

        field {
            name = "falsecolorlimit";
            desc = "False color limit";
            sw = rw;
            hw = r;
            reset = 0x0;
        } falsecolorlimit[7:0];
    } ISP_2DNR_FCR @ 0x4010;

    reg {
        name = "Luminance denoising gain register";
        desc = "ISP_2DNR_LUMANR is a luminance denoising gain register.

Data sheet 10.6 ISP_2DNR_LUMANR (offset 0x24014, printed page 10-123, `hi3518ev200--Hi3518EV20X-Hi3516CV200-Datasheet.txt` line 66437).";

        field {
            name = "luma_nr_gain";
            desc = "Luminance denoising gain. The value range is [0, 16].";
            sw = rw;
            hw = r;
            reset = 0x0;
        } luma_nr_gain[4:0];
    } ISP_2DNR_LUMANR @ 0x4014;

    reg {
        name = "Current point luminance limit register";
        desc = "ISP_2DNR_LUMA is a current point luminance limit register.

Data sheet 10.6 ISP_2DNR_LUMA (offset 0x24018, printed page 10-123, `hi3518ev200--Hi3518EV20X-Hi3516CV200-Datasheet.txt` line 66457).";

        field {
            name = "luma_low";
            desc = "Luminance lower limit of the current point. The bit width is the same as that of the bayer data. The maximum width is 14 bits.";
            sw = rw;
            hw = r;
            reset = 0x0;
        } luma_low[29:16];

        field {
            name = "luma_high";
            desc = "Luminance upper limit of the current point. The bit width is the same as that of the bayer data. The maximum width is 14 bits.";
            sw = rw;
            hw = r;
            reset = 0x0;
        } luma_high[13:0];
    } ISP_2DNR_LUMA @ 0x4018;

    reg {
        name = "2DNR & demosaic blending ratio range limit register";
        desc = "ISP_2DNR_LIMIT is a 2DNR & demosaic blending ratio range limit register.

Data sheet 10.6 ISP_2DNR_LIMIT (offset 0x2401C, printed page 10-124, `hi3518ev200--Hi3518EV20X-Hi3516CV200-Datasheet.txt` line 66492).";

        field {
            name = "limit_low";
            desc = "Lower limit of the blending ratio, unsigned 9.0 number. The value range is [0, 0x100].";
            sw = rw;
            hw = r;
            reset = 0x0;
        } limit_low[24:16];

        field {
            name = "limit_high";
            desc = "Upper limit of the blending ratio, unsigned 9.0 number. The value range is [0, 0x100].";
            sw = rw;
            hw = r;
            reset = 0x0;
        } limit_high[8:0];
    } ISP_2DNR_LIMIT @ 0x401C;

    reg {
        name = "Blending ratio linear range threshold register 0";
        desc = "ISP_2DNR_THRES0 is blending ratio linear range threshold register 0.

Data sheet 10.6 ISP_2DNR_THRES0 (offset 0x24020, printed page 10-124, `hi3518ev200--Hi3518EV20X-Hi3516CV200-Datasheet.txt` line 66518).";

        field {
            name = "thres_low";
            desc = "Lower limit of the blending ratio linear range";
            sw = rw;
            hw = r;
            reset = 0x0;
        } thres_low[27:16];

        field {
            name = "thres_high";
            desc = "Upper limit of the blending ratio linear range";
            sw = rw;
            hw = r;
            reset = 0x0;
        } thres_high[11:0];
    } ISP_2DNR_THRES0 @ 0x4020;

    reg {
        name = "Blending ratio linear range threshold register 1";
        desc = "ISP_2DNR_THRES1 is blending ratio linear range threshold register 1.

Data sheet 10.6 ISP_2DNR_THRES1 (offset 0x24024, printed page 10-125, `hi3518ev200--Hi3518EV20X-Hi3516CV200-Datasheet.txt` line 66549).";

        field {
            name = "thres_low";
            desc = "Lower limit of the blending ratio linear range";
            sw = rw;
            hw = r;
            reset = 0x0;
        } thres_low[27:16];

        field {
            name = "thres_high";
            desc = "Upper limit of the blending ratio linear range";
            sw = rw;
            hw = r;
            reset = 0x0;
        } thres_high[11:0];
    } ISP_2DNR_THRES1 @ 0x4024;

    reg {
        name = "Blending ratio linear range threshold register 2";
        desc = "ISP_2DNR_THRES2 is blending ratio linear range threshold register 2.

Data sheet 10.6 ISP_2DNR_THRES2 (offset 0x24028, printed page 10-125, `hi3518ev200--Hi3518EV20X-Hi3516CV200-Datasheet.txt` line 66571).";

        field {
            name = "thres_low";
            desc = "Lower limit of the blending ratio linear range";
            sw = rw;
            hw = r;
            reset = 0x0;
        } thres_low[27:16];

        field {
            name = "thres_high";
            desc = "Upper limit of the blending ratio linear range";
            sw = rw;
            hw = r;
            reset = 0x0;
        } thres_high[11:0];
    } ISP_2DNR_THRES2 @ 0x4028;

    reg {
        name = "Blending ratio linear range threshold register 3";
        desc = "ISP_2DNR_THRES3 is blending ratio linear range threshold register 3.

Data sheet 10.6 ISP_2DNR_THRES3 (offset 0x2402C, printed page 10-126, `hi3518ev200--Hi3518EV20X-Hi3516CV200-Datasheet.txt` line 66602).";

        field {
            name = "thres_low";
            desc = "Lower limit of the blending ratio linear range";
            sw = rw;
            hw = r;
            reset = 0x0;
        } thres_low[27:16];

        field {
            name = "thres_high";
            desc = "Upper limit of the blending ratio linear range";
            sw = rw;
            hw = r;
            reset = 0x0;
        } thres_high[11:0];
    } ISP_2DNR_THRES3 @ 0x402C;

    reg {
        name = "Blending ratio linear range threshold register 4";
        desc = "ISP_2DNR_THRES4 is blending ratio linear range threshold register 4.

Data sheet 10.6 ISP_2DNR_THRES4 (offset 0x24030, printed page 10-126, `hi3518ev200--Hi3518EV20X-Hi3516CV200-Datasheet.txt` line 66624).";

        field {
            name = "thres_low";
            desc = "Lower limit of the blending ratio linear range";
            sw = rw;
            hw = r;
            reset = 0x0;
        } thres_low[27:16];

        field {
            name = "thres_high";
            desc = "Upper limit of the blending ratio linear range";
            sw = rw;
            hw = r;
            reset = 0x0;
        } thres_high[11:0];
    } ISP_2DNR_THRES4 @ 0x4030;

    reg {
        name = "Blending ratio linear range threshold register 5";
        desc = "ISP_2DNR_THRES5 is blending ratio linear range threshold register 5.

Data sheet 10.6 ISP_2DNR_THRES5 (offset 0x24034, printed page 10-127, `hi3518ev200--Hi3518EV20X-Hi3516CV200-Datasheet.txt` line 66655).";

        field {
            name = "thres_low";
            desc = "Lower limit of the blending ratio linear range";
            sw = rw;
            hw = r;
            reset = 0x0;
        } thres_low[27:16];

        field {
            name = "thres_high";
            desc = "Upper limit of the blending ratio linear range";
            sw = rw;
            hw = r;
            reset = 0x0;
        } thres_high[11:0];
    } ISP_2DNR_THRES5 @ 0x4034;

    reg {
        name = "Blending ratio linear range threshold register 6";
        desc = "ISP_2DNR_THRES6 is blending ratio linear range threshold register 6.

Data sheet 10.6 ISP_2DNR_THRES6 (offset 0x24038, printed page 10-127, `hi3518ev200--Hi3518EV20X-Hi3516CV200-Datasheet.txt` line 66677).";

        field {
            name = "thres_low";
            desc = "Lower limit of the blending ratio linear range";
            sw = rw;
            hw = r;
            reset = 0x0;
        } thres_low[27:16];

        field {
            name = "thres_high";
            desc = "Upper limit of the blending ratio linear range";
            sw = rw;
            hw = r;
            reset = 0x0;
        } thres_high[11:0];
    } ISP_2DNR_THRES6 @ 0x4038;

    reg {
        name = "Blending ratio linear range threshold register 7";
        desc = "ISP_2DNR_THRES7 is blending ratio linear range threshold register 7.

Data sheet 10.6 ISP_2DNR_THRES7 (offset 0x2403C, printed page 10-128, `hi3518ev200--Hi3518EV20X-Hi3516CV200-Datasheet.txt` line 66708).";

        field {
            name = "thres_low";
            desc = "Lower limit of the blending ratio linear range";
            sw = rw;
            hw = r;
            reset = 0x0;
        } thres_low[27:16];

        field {
            name = "thres_high";
            desc = "Upper limit of the blending ratio linear range";
            sw = rw;
            hw = r;
            reset = 0x0;
        } thres_high[11:0];
    } ISP_2DNR_THRES7 @ 0x403C;

    reg {
        name = "Blending ratio linear range threshold register 8";
        desc = "ISP_2DNR_THRES8 is blending ratio linear range threshold register 8.

Data sheet 10.6 ISP_2DNR_THRES8 (offset 0x24040, printed page 10-128, `hi3518ev200--Hi3518EV20X-Hi3516CV200-Datasheet.txt` line 66730).";

        field {
            name = "thres_low";
            desc = "Lower limit of the blending ratio linear range";
            sw = rw;
            hw = r;
            reset = 0x0;
        } thres_low[27:16];

        field {
            name = "thres_high";
            desc = "Upper limit of the blending ratio linear range";
            sw = rw;
            hw = r;
            reset = 0x0;
        } thres_high[11:0];
    } ISP_2DNR_THRES8 @ 0x4040;

    reg {
        name = "Blending ratio linear range threshold register 9";
        desc = "ISP_2DNR_THRES9 is blending ratio linear range threshold register 9.

Data sheet 10.6 ISP_2DNR_THRES9 (offset 0x24044, printed page 10-129, `hi3518ev200--Hi3518EV20X-Hi3516CV200-Datasheet.txt` line 66761).";

        field {
            name = "thres_low";
            desc = "Lower limit of the blending ratio linear range";
            sw = rw;
            hw = r;
            reset = 0x0;
        } thres_low[27:16];

        field {
            name = "thres_high";
            desc = "Upper limit of the blending ratio linear range";
            sw = rw;
            hw = r;
            reset = 0x0;
        } thres_high[11:0];
    } ISP_2DNR_THRES9 @ 0x4044;

    reg {
        name = "Blending ratio linear range threshold register 10";
        desc = "ISP_2DNR_THRES10 is blending ratio linear range threshold register 10.

Data sheet 10.6 ISP_2DNR_THRES10 (offset 0x24048, printed page 10-129, `hi3518ev200--Hi3518EV20X-Hi3516CV200-Datasheet.txt` line 66783).";

        field {
            name = "thres_low";
            desc = "Lower limit of the blending ratio linear range";
            sw = rw;
            hw = r;
            reset = 0x0;
        } thres_low[27:16];

        field {
            name = "thres_high";
            desc = "Upper limit of the blending ratio linear range";
            sw = rw;
            hw = r;
            reset = 0x0;
        } thres_high[11:0];
    } ISP_2DNR_THRES10 @ 0x4048;

    reg {
        name = "Blending ratio linear range threshold register 11";
        desc = "ISP_2DNR_THRES11 is blending ratio linear range threshold register 11.

Data sheet 10.6 ISP_2DNR_THRES11 (offset 0x2404C, printed page 10-130, `hi3518ev200--Hi3518EV20X-Hi3516CV200-Datasheet.txt` line 66814).";

        field {
            name = "thres_low";
            desc = "Lower limit of the blending ratio linear range";
            sw = rw;
            hw = r;
            reset = 0x0;
        } thres_low[27:16];

        field {
            name = "thres_high";
            desc = "Upper limit of the blending ratio linear range";
            sw = rw;
            hw = r;
            reset = 0x0;
        } thres_high[11:0];
    } ISP_2DNR_THRES11 @ 0x404C;

    reg {
        name = "Blending ratio linear range threshold register 12";
        desc = "ISP_2DNR_THRES12 is blending ratio linear range threshold register 12.

Data sheet 10.6 ISP_2DNR_THRES12 (offset 0x24050, printed page 10-130, `hi3518ev200--Hi3518EV20X-Hi3516CV200-Datasheet.txt` line 66836).";

        field {
            name = "thres_low";
            desc = "Lower limit of the blending ratio linear range";
            sw = rw;
            hw = r;
            reset = 0x0;
        } thres_low[27:16];

        field {
            name = "thres_high";
            desc = "Upper limit of the blending ratio linear range";
            sw = rw;
            hw = r;
            reset = 0x0;
        } thres_high[11:0];
    } ISP_2DNR_THRES12 @ 0x4050;

    reg {
        name = "Blending ratio linear range threshold register 13";
        desc = "ISP_2DNR_THRES13 is blending ratio linear range threshold register 13.

Data sheet 10.6 ISP_2DNR_THRES13 (offset 0x24054, printed page 10-131, `hi3518ev200--Hi3518EV20X-Hi3516CV200-Datasheet.txt` line 66867).";

        field {
            name = "thres_low";
            desc = "Lower limit of the blending ratio linear range";
            sw = rw;
            hw = r;
            reset = 0x0;
        } thres_low[27:16];

        field {
            name = "thres_high";
            desc = "Upper limit of the blending ratio linear range";
            sw = rw;
            hw = r;
            reset = 0x0;
        } thres_high[11:0];
    } ISP_2DNR_THRES13 @ 0x4054;

    reg {
        name = "Blending ratio linear range threshold register 14";
        desc = "ISP_2DNR_THRES14 is blending ratio linear range threshold register 14.

Data sheet 10.6 ISP_2DNR_THRES14 (offset 0x24058, printed page 10-131, `hi3518ev200--Hi3518EV20X-Hi3516CV200-Datasheet.txt` line 66889).";

        field {
            name = "thres_low";
            desc = "Lower limit of the blending ratio linear range";
            sw = rw;
            hw = r;
            reset = 0x0;
        } thres_low[27:16];

        field {
            name = "thres_high";
            desc = "Upper limit of the blending ratio linear range";
            sw = rw;
            hw = r;
            reset = 0x0;
        } thres_high[11:0];
    } ISP_2DNR_THRES14 @ 0x4058;

    reg {
        name = "Blending ratio linear range threshold register 15";
        desc = "ISP_2DNR_THRES15 is blending ratio linear range threshold register 15.

Data sheet 10.6 ISP_2DNR_THRES15 (offset 0x2405C, printed page 10-132, `hi3518ev200--Hi3518EV20X-Hi3516CV200-Datasheet.txt` line 66920).";

        field {
            name = "thres_low";
            desc = "Lower limit of the blending ratio linear range";
            sw = rw;
            hw = r;
            reset = 0x0;
        } thres_low[27:16];

        field {
            name = "thres_high";
            desc = "Upper limit of the blending ratio linear range";
            sw = rw;
            hw = r;
            reset = 0x0;
        } thres_high[11:0];
    } ISP_2DNR_THRES15 @ 0x405C;

    reg {
        name = "Blending ratio linear range threshold register 16";
        desc = "ISP_2DNR_THRES16 is blending ratio linear range threshold register 16.

Data sheet 10.6 ISP_2DNR_THRES16 (offset 0x24060, printed page 10-132, `hi3518ev200--Hi3518EV20X-Hi3516CV200-Datasheet.txt` line 66942).";

        field {
            name = "thres_low";
            desc = "Lower limit of the blending ratio linear range";
            sw = rw;
            hw = r;
            reset = 0x0;
        } thres_low[27:16];

        field {
            name = "thres_high";
            desc = "Upper limit of the blending ratio linear range";
            sw = rw;
            hw = r;
            reset = 0x0;
        } thres_high[11:0];
    } ISP_2DNR_THRES16 @ 0x4060;

    reg {
        name = "Sharpen control register";
        desc = "ISP_SHARPEN_CFG is a sharpen control register.

Data sheet 10.6 ISP_SHARPEN_CFG (offset 0x24200, printed page 10-133, `hi3518ev200--Hi3518EV20X-Hi3516CV200-Datasheet.txt` line 66973).";

        enum ISP_SHARPEN_CFG_en_enum {
            DISABLED = 0 { name = "Disabled"; desc = "disabled"; };
            ENABLED = 1 { name = "Enabled"; desc = "enabled"; };
        };

        field {
            name = "en";
            desc = "Sharpen enable";
            sw = rw;
            hw = r;
            encode = ISP_SHARPEN_CFG_en_enum;
            reset = 0x0;
        } en[0:0];
    } ISP_SHARPEN_CFG @ 0x4200;

    reg {
        name = "Sharpen strength register";
        desc = "ISP_SHARPEN_AMT is a sharpen strength register.

Data sheet 10.6 ISP_SHARPEN_AMT (offset 0x24210, printed page 10-133, `hi3518ev200--Hi3518EV20X-Hi3516CV200-Datasheet.txt` line 66995).";

        field {
            name = "edge_amt";
            desc = "Edge enhancement strength (u, 12.0). (u, 12.0) indicates that the value is an unsigned number consisting of a 12-bit integral part and a 0-bit decimal part. The same rule applies to the meanings of other fields of sharpen registers.";
            sw = rw;
            hw = r;
            reset = 0x0;
        } edge_amt[27:16];

        field {
            name = "sharp_amt";
            desc = "Detail enhancement strength (u, 12.0)";
            sw = rw;
            hw = r;
            reset = 0x0;
        } sharp_amt[11:0];
    } ISP_SHARPEN_AMT @ 0x4210;

    reg {
        name = "Sharpen threshold register 1";
        desc = "ISP_SHARPEN_THD1 is sharpen threshold register 1.

Data sheet 10.6 ISP_SHARPEN_THD1 (offset 0x24214, printed page 10-134, `hi3518ev200--Hi3518EV20X-Hi3516CV200-Datasheet.txt` line 67030).";

        field {
            name = "edge_thd1";
            desc = "Edge enhancement threshold (u, 10.0)";
            sw = rw;
            hw = r;
            reset = 0x0;
        } edge_thd1[25:16];

        field {
            name = "sharp_thd1";
            desc = "Detail enhancement threshold (u, 10.0)";
            sw = rw;
            hw = r;
            reset = 0x0;
        } sharp_thd1[9:0];
    } ISP_SHARPEN_THD1 @ 0x4214;

    reg {
        name = "Sharpen strength coefficient register";
        desc = "ISP_SHARPEN_COEF is a sharpen strength coefficient register.

Data sheet 10.6 ISP_SHARPEN_COEF (offset 0x24218, printed page 10-134, `hi3518ev200--Hi3518EV20X-Hi3516CV200-Datasheet.txt` line 67052).";

        field {
            name = "edge_coef";
            desc = "Edge enhancement coefficient (u, 12.0)";
            sw = rw;
            hw = r;
            reset = 0x0;
        } edge_coef[27:16];

        field {
            name = "sharp_coef";
            desc = "Detail enhancement coefficient (u, 12.0)";
            sw = rw;
            hw = r;
            reset = 0x0;
        } sharp_coef[11:0];
    } ISP_SHARPEN_COEF @ 0x4218;

    reg {
        name = "Sharpen shoot AMT control register MT";
        desc = "ISP_SHARPEN_SHOOTAMT is a sharpen shoot AMT control register.

Data sheet 10.6 ISP_SHARPEN_SHOOTAMT (offset 0x2421C, printed page 10-135, `hi3518ev200--Hi3518EV20X-Hi3516CV200-Datasheet.txt` line 67083).";

        field {
            name = "over_amt";
            desc = "Overshoot control coefficient (u, 8.0)";
            sw = rw;
            hw = r;
            reset = 0x0;
        } over_amt[23:16];

        field {
            name = "under_amt";
            desc = "Undershoot control coefficient (u, 8.0)";
            sw = rw;
            hw = r;
            reset = 0x0;
        } under_amt[7:0];
    } ISP_SHARPEN_SHOOTAMT @ 0x421C;

    reg {
        name = "Sharpen intermediate-frequency (IF) filtering coefficient register";
        desc = "ISP_SHARPEN_MID0 is a sharpen IF filtering coefficient register.

Data sheet 10.6 ISP_SHARPEN_MID0 (offset 0x24230, printed page 10-135, `hi3518ev200--Hi3518EV20X-Hi3516CV200-Datasheet.txt` line 67105).";

        field {
            name = "mid_tmp02";
            desc = "IF filtering coefficient 02 (s, 8.0). (s, 8.0) indicates that the value is a signed number consisting of an 8-bit integral part and a 0-bit decimal part. The same rule applies to the meanings of other fields of sharpen registers.";
            sw = rw;
            hw = r;
            reset = 0x0;
        } mid_tmp02[23:16];

        field {
            name = "mid_tmp01";
            desc = "IF filtering coefficient 01 (s, 8.0)";
            sw = rw;
            hw = r;
            reset = 0x0;
        } mid_tmp01[15:8];

        field {
            name = "mid_tmp00";
            desc = "IF filtering coefficient 00 (s, 8.0)";
            sw = rw;
            hw = r;
            reset = 0x0;
        } mid_tmp00[7:0];
    } ISP_SHARPEN_MID0 @ 0x4230;

    reg {
        name = "Sharpen IF filtering coefficient register";
        desc = "ISP_SHARPEN_MID1 is a sharpen IF filtering coefficient register.

Data sheet 10.6 ISP_SHARPEN_MID1 (offset 0x24234, printed page 10-136, `hi3518ev200--Hi3518EV20X-Hi3516CV200-Datasheet.txt` line 67140).";

        field {
            name = "mid_tmp12";
            desc = "IF filtering coefficient 12 (s, 8.0)";
            sw = rw;
            hw = r;
            reset = 0x0;
        } mid_tmp12[23:16];

        field {
            name = "mid_tmp11";
            desc = "IF filtering coefficient 11 (s, 8.0)";
            sw = rw;
            hw = r;
            reset = 0x0;
        } mid_tmp11[15:8];

        field {
            name = "mid_tmp10";
            desc = "IF filtering coefficient 10 (s, 8.0)";
            sw = rw;
            hw = r;
            reset = 0x0;
        } mid_tmp10[7:0];
    } ISP_SHARPEN_MID1 @ 0x4234;

    reg {
        name = "Sharpen IF filtering coefficient register";
        desc = "ISP_SHARPEN_MID2 is a sharpen IF filtering coefficient register.

Data sheet 10.6 ISP_SHARPEN_MID2 (offset 0x24238, printed page 10-136, `hi3518ev200--Hi3518EV20X-Hi3516CV200-Datasheet.txt` line 67162).";

        field {
            name = "mid_tmp22";
            desc = "IF filtering coefficient 22 (s, 8.0)";
            sw = rw;
            hw = r;
            reset = 0x0;
        } mid_tmp22[23:16];

        field {
            name = "mid_tmp21";
            desc = "IF filtering coefficient 21 (s, 8.0)";
            sw = rw;
            hw = r;
            reset = 0x0;
        } mid_tmp21[15:8];

        field {
            name = "mid_tmp20";
            desc = "IF filtering coefficient 20 (s, 8.0)";
            sw = rw;
            hw = r;
            reset = 0x0;
        } mid_tmp20[7:0];
    } ISP_SHARPEN_MID2 @ 0x4238;

    reg {
        name = "Sharpen line detection threshold register";
        desc = "ISP_SHARPEN_LINETHD is a sharpen line detection threshold register.

Data sheet 10.6 ISP_SHARPEN_LINETHD (offset 0x2423C, printed page 10-137, `hi3518ev200--Hi3518EV20X-Hi3516CV200-Datasheet.txt` line 67193).";

        field {
            name = "line_thd2";
            desc = "Line detection threshold 2 (u, 8.0)";
            sw = rw;
            hw = r;
            reset = 0x0;
        } line_thd2[23:16];

        field {
            name = "line_thd1";
            desc = "Line detection threshold 1 (u, 8.0)";
            sw = rw;
            hw = r;
            reset = 0x0;
        } line_thd1[7:0];
    } ISP_SHARPEN_LINETHD @ 0x423C;

    reg {
        name = "Sharpen threshold register 2";
        desc = "ISP_SHARPEN_THD2 is sharpen threshold register 2.

Data sheet 10.6 ISP_SHARPEN_THD2 (offset 0x24240, printed page 10-137, `hi3518ev200--Hi3518EV20X-Hi3516CV200-Datasheet.txt` line 67215).";

        field {
            name = "edge_thd2";
            desc = "Edge enhancement threshold (u, 10.0)";
            sw = rw;
            hw = r;
            reset = 0x0;
        } edge_thd2[25:16];

        field {
            name = "sharp_thd2";
            desc = "Detail enhancement threshold (u, 10.0)";
            sw = rw;
            hw = r;
            reset = 0x0;
        } sharp_thd2[9:0];
    } ISP_SHARPEN_THD2 @ 0x4240;

    reg {
        name = "Sharpen shoot THD control register D";
        desc = "ISP_SHARPEN_SHOOTTHD is a sharpen shoot THD control register.

Data sheet 10.6 ISP_SHARPEN_SHOOTTHD (offset 0x24244, printed page 10-138, `hi3518ev200--Hi3518EV20X-Hi3516CV200-Datasheet.txt` line 67246).";

        field {
            name = "over_thd2";
            desc = "Overshoot control coefficient 2 (u, 8.0)";
            sw = rw;
            hw = r;
            reset = 0x0;
        } over_thd2[31:24];

        field {
            name = "over_thd1";
            desc = "Overshoot control coefficient 1 (u, 8.0)";
            sw = rw;
            hw = r;
            reset = 0x0;
        } over_thd1[23:16];

        field {
            name = "under_thd2";
            desc = "Undershoot control coefficient 2 (u, 8.0)";
            sw = rw;
            hw = r;
            reset = 0x0;
        } under_thd2[15:8];

        field {
            name = "under_thd1";
            desc = "Undershoot control coefficient 1 (u, 8.0)";
            sw = rw;
            hw = r;
            reset = 0x0;
        } under_thd1[7:0];
    } ISP_SHARPEN_SHOOTTHD @ 0x4244;

    reg {
        name = "Sharpen shoot COEF control EF register";
        desc = "ISP_SHARPEN_SHOOTCOEF is a sharpen shoot COEF control register.

Data sheet 10.6 ISP_SHARPEN_SHOOTCOEF (offset 0x24248, printed page 10-138, `hi3518ev200--Hi3518EV20X-Hi3516CV200-Datasheet.txt` line 67268).";

        field {
            name = "over_coef";
            desc = "Overshoot control coefficient (u, 1.8)";
            sw = rw;
            hw = r;
            reset = 0x0;
        } over_coef[24:16];

        field {
            name = "under_coef";
            desc = "Undershoot control coefficient (u, 1.8)";
            sw = rw;
            hw = r;
            reset = 0x0;
        } under_coef[8:0];
    } ISP_SHARPEN_SHOOTCOEF @ 0x4248;

    reg {
        name = "Sharpen enpixsel control register";
        desc = "ISP_SHARPEN_ENPIXSEL is a sharpen enpixsel control register.

Data sheet 10.6 ISP_SHARPEN_ENPIXSEL (offset 0x2424C, printed page 10-139, `hi3518ev200--Hi3518EV20X-Hi3516CV200-Datasheet.txt` line 67299).";

        enum ISP_SHARPEN_ENPIXSEL_enpixsel_enum {
            ORIGINAL_VALUE_SELECTED = 0 { name = "Original Value Selected"; desc = "The original value is selected."; };
            MAXIMUM_MINIMUM_FIELD = 1 { name = "Maximum Minimum Field"; desc = "The maximum/minimum field value is selected."; };
        };

        field {
            name = "enpixsel";
            desc = "Overshoot suppression";
            sw = rw;
            hw = r;
            encode = ISP_SHARPEN_ENPIXSEL_enpixsel_enum;
            reset = 0x0;
        } enpixsel[0:0];
    } ISP_SHARPEN_ENPIXSEL @ 0x424C;

    reg {
        name = "NR LSC enable register";
        desc = "ISP_NR_LSC_CFG is an NR LSC enable register.

Data sheet 10.6 ISP_NR_LSC_CFG (offset 0x24800, printed page 10-139, `hi3518ev200--Hi3518EV20X-Hi3516CV200-Datasheet.txt` line 67324).";

        enum ISP_NR_LSC_CFG_en_enum {
            DISABLED = 0 { name = "Disabled"; desc = "disabled"; };
            ENABLED = 1 { name = "Enabled"; desc = "enabled"; };
        };

        field {
            name = "en";
            desc = "LSC enable";
            sw = rw;
            hw = r;
            encode = ISP_NR_LSC_CFG_en_enum;
            reset = 0x0;
        } en[0:0];
    } ISP_NR_LSC_CFG @ 0x4800;

    reg {
        name = "NR LSC picture segmentation window quantity configuration register";
        desc = "ISP_NR_LSC_WINNUM is an NR LSC picture segmentation window quantity configuration register.

Data sheet 10.6 ISP_NR_LSC_WINNUM (offset 0x24810, printed page 10-140, `hi3518ev200--Hi3518EV20X-Hi3516CV200-Datasheet.txt` line 67355).";

        field {
            name = "numv";
            desc = "Number of windows obtained after the picture is vertically segmented. The configured value is the actual value minus 1.";
            sw = rw;
            hw = r;
            reset = 0x0;
        } numv[20:16];

        field {
            name = "numh";
            desc = "Number of windows obtained after the picture is horizontally segmented. The configured value is the actual value minus 1.";
            sw = rw;
            hw = r;
            reset = 0x0;
        } numh[4:0];
    } ISP_NR_LSC_WINNUM @ 0x4810;

    reg {
        name = "NR LSC interpolation horizontal first window width information register";
        desc = "ISP_NR_LSC_WINX1 is an NR LSC interpolation horizontal first window width information register.

Data sheet 10.6 ISP_NR_LSC_WINX1 (offset 0x24814, printed page 10-140, `hi3518ev200--Hi3518EV20X-Hi3516CV200-Datasheet.txt` line 67382).";

        field {
            name = "invx1";
            desc = "Reciprocal value of the width of the LSC interpolation horizontal first window";
            sw = rw;
            hw = r;
            reset = 0x0;
        } invx1[27:16];

        field {
            name = "deltax1";
            desc = "Width of the LSC interpolation horizontal first window. The configured value is the actual value minus 1.";
            sw = rw;
            hw = r;
            reset = 0x0;
        } deltax1[9:0];
    } ISP_NR_LSC_WINX1 @ 0x4814;

    reg {
        name = "NR LSC interpolation horizontal second window width information register";
        desc = "ISP_NR_LSC_WINX2 is an NR LSC interpolation horizontal second window width information register.

Data sheet 10.6 ISP_NR_LSC_WINX2 (offset 0x24818, printed page 10-141, `hi3518ev200--Hi3518EV20X-Hi3516CV200-Datasheet.txt` line 67418).";

        field {
            name = "invx2";
            desc = "Reciprocal value of the width of the LSC interpolation horizontal second window";
            sw = rw;
            hw = r;
            reset = 0x0;
        } invx2[27:16];

        field {
            name = "deltax2";
            desc = "Width of the LSC interpolation horizontal second window";
            sw = rw;
            hw = r;
            reset = 0x0;
        } deltax2[9:0];
    } ISP_NR_LSC_WINX2 @ 0x4818;

    reg {
        name = "NR LSC interpolation horizontal third window width information register";
        desc = "ISP_NR_LSC_WINX3 is an NR LSC interpolation horizontal third window width information register.

Data sheet 10.6 ISP_NR_LSC_WINX3 (offset 0x2481C, printed page 10-141, `hi3518ev200--Hi3518EV20X-Hi3516CV200-Datasheet.txt` line 67443).";

        field {
            name = "invx3";
            desc = "Reciprocal value of the width of the LSC interpolation horizontal third window";
            sw = rw;
            hw = r;
            reset = 0x0;
        } invx3[27:16];

        field {
            name = "deltax3";
            desc = "Width of the LSC interpolation horizontal third window";
            sw = rw;
            hw = r;
            reset = 0x0;
        } deltax3[9:0];
    } ISP_NR_LSC_WINX3 @ 0x481C;

    reg {
        name = "NR LSC interpolation horizontal fourth window width information register";
        desc = "ISP_NR_LSC_WINX4 is an NR LSC interpolation horizontal fourth window width information register.

Data sheet 10.6 ISP_NR_LSC_WINX4 (offset 0x24820, printed page 10-142, `hi3518ev200--Hi3518EV20X-Hi3516CV200-Datasheet.txt` line 67477).";

        field {
            name = "invx4";
            desc = "Reciprocal value of the width of the LSC interpolation horizontal fourth window";
            sw = rw;
            hw = r;
            reset = 0x0;
        } invx4[27:16];

        field {
            name = "deltax4";
            desc = "Width of the LSC interpolation horizontal fourth window";
            sw = rw;
            hw = r;
            reset = 0x0;
        } deltax4[9:0];
    } ISP_NR_LSC_WINX4 @ 0x4820;

    reg {
        name = "NR LSC interpolation horizontal fifth window width information register";
        desc = "ISP_NR_LSC_WINX5 is an NR LSC interpolation horizontal fifth window width information register.

Data sheet 10.6 ISP_NR_LSC_WINX5 (offset 0x24824, printed page 10-142, `hi3518ev200--Hi3518EV20X-Hi3516CV200-Datasheet.txt` line 67502).";

        field {
            name = "invx5";
            desc = "Reciprocal value of the width of the LSC interpolation horizontal fifth window";
            sw = rw;
            hw = r;
            reset = 0x0;
        } invx5[27:16];

        field {
            name = "deltax5";
            desc = "Width of the LSC interpolation horizontal fifth window";
            sw = rw;
            hw = r;
            reset = 0x0;
        } deltax5[9:0];
    } ISP_NR_LSC_WINX5 @ 0x4824;

    reg {
        name = "NR LSC interpolation horizontal sixth window width information register";
        desc = "ISP_NR_LSC_WINX6 is an NR LSC interpolation horizontal sixth window width information register.

Data sheet 10.6 ISP_NR_LSC_WINX6 (offset 0x24828, printed page 10-143, `hi3518ev200--Hi3518EV20X-Hi3516CV200-Datasheet.txt` line 67536).";

        field {
            name = "invx6";
            desc = "Reciprocal value of the width of the LSC interpolation horizontal sixth window";
            sw = rw;
            hw = r;
            reset = 0x0;
        } invx6[27:16];

        field {
            name = "deltax6";
            desc = "Width of the LSC interpolation horizontal sixth window";
            sw = rw;
            hw = r;
            reset = 0x0;
        } deltax6[9:0];
    } ISP_NR_LSC_WINX6 @ 0x4828;

    reg {
        name = "NR LSC interpolation horizontal seventh window width information register";
        desc = "ISP_NR_LSC_WINX7 is an NR LSC interpolation horizontal seventh window width information register.

Data sheet 10.6 ISP_NR_LSC_WINX7 (offset 0x2482C, printed page 10-143, `hi3518ev200--Hi3518EV20X-Hi3516CV200-Datasheet.txt` line 67561).";

        field {
            name = "invx7";
            desc = "Reciprocal value of the width of the LSC interpolation horizontal seventh window";
            sw = rw;
            hw = r;
            reset = 0x0;
        } invx7[27:16];

        field {
            name = "deltax7";
            desc = "Width of the LSC interpolation horizontal seventh window";
            sw = rw;
            hw = r;
            reset = 0x0;
        } deltax7[9:0];
    } ISP_NR_LSC_WINX7 @ 0x482C;

    reg {
        name = "NR LSC interpolation horizontal eighth window width information register";
        desc = "ISP_NR_LSC_WINX8 is an NR LSC interpolation horizontal eighth window width information register.

Data sheet 10.6 ISP_NR_LSC_WINX8 (offset 0x24830, printed page 10-144, `hi3518ev200--Hi3518EV20X-Hi3516CV200-Datasheet.txt` line 67595).";

        field {
            name = "invx8";
            desc = "Reciprocal value of the width of the LSC interpolation horizontal eighth window";
            sw = rw;
            hw = r;
            reset = 0x0;
        } invx8[27:16];

        field {
            name = "deltax8";
            desc = "Width of the LSC interpolation horizontal eighth window";
            sw = rw;
            hw = r;
            reset = 0x0;
        } deltax8[9:0];
    } ISP_NR_LSC_WINX8 @ 0x4830;

    reg {
        name = "NR LSC interpolation vertical first window width information register";
        desc = "ISP_NR_LSC_WINY1 is an NR LSC interpolation vertical first window width information register.

Data sheet 10.6 ISP_NR_LSC_WINY1 (offset 0x24834, printed page 10-144, `hi3518ev200--Hi3518EV20X-Hi3516CV200-Datasheet.txt` line 67620).";

        field {
            name = "invy1";
            desc = "Reciprocal value of the width of the LSC interpolation vertical first window";
            sw = rw;
            hw = r;
            reset = 0x0;
        } invy1[27:16];

        field {
            name = "deltay1";
            desc = "Width of the LSC interpolation vertical first window";
            sw = rw;
            hw = r;
            reset = 0x0;
        } deltay1[9:0];
    } ISP_NR_LSC_WINY1 @ 0x4834;

    reg {
        name = "NR LSC interpolation vertical second window width information register";
        desc = "ISP_NR_LSC_WINY2 is an NR LSC interpolation vertical second window width information register.

Data sheet 10.6 ISP_NR_LSC_WINY2 (offset 0x24838, printed page 10-145, `hi3518ev200--Hi3518EV20X-Hi3516CV200-Datasheet.txt` line 67654).";

        field {
            name = "invy2";
            desc = "Reciprocal value of the width of the LSC interpolation vertical second window";
            sw = rw;
            hw = r;
            reset = 0x0;
        } invy2[27:16];

        field {
            name = "deltay2";
            desc = "Width of the LSC interpolation vertical second window";
            sw = rw;
            hw = r;
            reset = 0x0;
        } deltay2[9:0];
    } ISP_NR_LSC_WINY2 @ 0x4838;

    reg {
        name = "NR LSC interpolation vertical third window width information register";
        desc = "ISP_NR_LSC_WINY3 is an NR LSC interpolation vertical third window width information register.

Data sheet 10.6 ISP_NR_LSC_WINY3 (offset 0x2483C, printed page 10-145, `hi3518ev200--Hi3518EV20X-Hi3516CV200-Datasheet.txt` line 67679).";

        field {
            name = "invy3";
            desc = "Reciprocal value of the width of the LSC interpolation vertical third window";
            sw = rw;
            hw = r;
            reset = 0x0;
        } invy3[27:16];

        field {
            name = "deltay3";
            desc = "Width of the LSC interpolation vertical third window";
            sw = rw;
            hw = r;
            reset = 0x0;
        } deltay3[9:0];
    } ISP_NR_LSC_WINY3 @ 0x483C;

    reg {
        name = "NR LSC interpolation vertical fourth window width information register";
        desc = "ISP_NR_LSC_WINY4 is an NR LSC interpolation vertical fourth window width information register.

Data sheet 10.6 ISP_NR_LSC_WINY4 (offset 0x24840, printed page 10-146, `hi3518ev200--Hi3518EV20X-Hi3516CV200-Datasheet.txt` line 67713).";

        field {
            name = "invy4";
            desc = "Reciprocal value of the width of the LSC interpolation vertical fourth window";
            sw = rw;
            hw = r;
            reset = 0x0;
        } invy4[27:16];

        field {
            name = "deltay4";
            desc = "Width of the LSC interpolation vertical fourth window";
            sw = rw;
            hw = r;
            reset = 0x0;
        } deltay4[9:0];
    } ISP_NR_LSC_WINY4 @ 0x4840;

    reg {
        name = "NR LSC interpolation vertical fifth window width information register";
        desc = "ISP_NR_LSC_WINY5 is an NR LSC interpolation vertical fifth window width information register.

Data sheet 10.6 ISP_NR_LSC_WINY5 (offset 0x24844, printed page 10-146, `hi3518ev200--Hi3518EV20X-Hi3516CV200-Datasheet.txt` line 67738).";

        field {
            name = "invy5";
            desc = "Reciprocal value of the width of the LSC interpolation vertical fifth window";
            sw = rw;
            hw = r;
            reset = 0x0;
        } invy5[27:16];

        field {
            name = "deltay5";
            desc = "Width of the LSC interpolation vertical fifth window";
            sw = rw;
            hw = r;
            reset = 0x0;
        } deltay5[9:0];
    } ISP_NR_LSC_WINY5 @ 0x4844;

    reg {
        name = "NR LSC interpolation vertical sixth window width information register";
        desc = "ISP_NR_LSC_WINY6 is an NR LSC interpolation vertical sixth window width information register.

Data sheet 10.6 ISP_NR_LSC_WINY6 (offset 0x24848, printed page 10-147, `hi3518ev200--Hi3518EV20X-Hi3516CV200-Datasheet.txt` line 67772).";

        field {
            name = "invy6";
            desc = "Reciprocal value of the width of the LSC interpolation vertical sixth window";
            sw = rw;
            hw = r;
            reset = 0x0;
        } invy6[27:16];

        field {
            name = "deltay6";
            desc = "Width of the LSC interpolation vertical sixth window";
            sw = rw;
            hw = r;
            reset = 0x0;
        } deltay6[9:0];
    } ISP_NR_LSC_WINY6 @ 0x4848;

    reg {
        name = "NR LSC interpolation vertical seventh window width information register";
        desc = "ISP_NR_LSC_WINY7 is an NR LSC interpolation vertical seventh window width information register.

Data sheet 10.6 ISP_NR_LSC_WINY7 (offset 0x2484C, printed page 10-147, `hi3518ev200--Hi3518EV20X-Hi3516CV200-Datasheet.txt` line 67797).";

        field {
            name = "invy7";
            desc = "Reciprocal value of the width of the LSC interpolation vertical seventh window";
            sw = rw;
            hw = r;
            reset = 0x0;
        } invy7[27:16];

        field {
            name = "deltay7";
            desc = "Width of the LSC interpolation vertical seventh window";
            sw = rw;
            hw = r;
            reset = 0x0;
        } deltay7[9:0];
    } ISP_NR_LSC_WINY7 @ 0x484C;

    reg {
        name = "NR LSC interpolation vertical eighth window width information register";
        desc = "ISP_NR_LSC_WINY8 is an NR LSC interpolation vertical eighth window width information register.

Data sheet 10.6 ISP_NR_LSC_WINY8 (offset 0x24850, printed page 10-148, `hi3518ev200--Hi3518EV20X-Hi3516CV200-Datasheet.txt` line 67831).";

        field {
            name = "invy8";
            desc = "Reciprocal value of the width of the LSC interpolation vertical eighth window";
            sw = rw;
            hw = r;
            reset = 0x0;
        } invy8[27:16];

        field {
            name = "deltay8";
            desc = "Width of the LSC interpolation vertical eighth window";
            sw = rw;
            hw = r;
            reset = 0x0;
        } deltay8[9:0];
    } ISP_NR_LSC_WINY8 @ 0x4850;

    reg {
        name = "NR LSC interpolation R/Gr channel WADDR gain information write address register";
        desc = "ISP_NR_LSC_GRRGAIN_WADDR is an NR LSC interpolation R/Gr channel gain write address register.

Data sheet 10.6 ISP_NR_LSC_GRRGAIN_WADDR (offset 0x24880, printed page 10-148, `hi3518ev200--Hi3518EV20X-Hi3516CV200-Datasheet.txt` line 67856).";

        field {
            name = "rgain_waddr";
            desc = "Write address of the LSC interpolation R/Gr channel gain";
            sw = rw;
            hw = r;
            reset = 0x0;
        } rgain_waddr[31:0];
    } ISP_NR_LSC_GRRGAIN_WADDR @ 0x4880;

    reg {
        name = "NR LSC interpolation R/Gr channel WDATA gain information write data register";
        desc = "ISP_NR_LSC_GRRGAIN_WDATA is an NR LSC interpolation R/Gr channel gain write data register.

Data sheet 10.6 ISP_NR_LSC_GRRGAIN_WDATA (offset 0x24884, printed page 10-149, `hi3518ev200--Hi3518EV20X-Hi3516CV200-Datasheet.txt` line 67885).";

        field {
            name = "rgain_wdata";
            desc = "Write data of the LSC interpolation R/Gr channel gain";
            sw = rw;
            hw = r;
            reset = 0x0;
        } rgain_wdata[31:0];
    } ISP_NR_LSC_GRRGAIN_WDATA @ 0x4884;

    reg {
        name = "NR LSC interpolation R/Gr channel RADDR gain information read address register";
        desc = "ISP_NR_LSC_GRRGAIN_RADDR is an NR LSC interpolation R/Gr channel gain read address register.

Data sheet 10.6 ISP_NR_LSC_GRRGAIN_RADDR (offset 0x24888, printed page 10-149, `hi3518ev200--Hi3518EV20X-Hi3516CV200-Datasheet.txt` line 67905).";

        field {
            name = "rgain_raddr";
            desc = "Read address of the LSC interpolation R/Gr channel gain";
            sw = rw;
            hw = r;
            reset = 0x0;
        } rgain_raddr[31:0];
    } ISP_NR_LSC_GRRGAIN_RADDR @ 0x4888;

    reg {
        name = "NR LSC interpolation R/Gr channel RDATA gain information read data register";
        desc = "ISP_NR_LSC_GRRGAIN_RDATA is an NR LSC interpolation R/Gr channel gain read data register.

Data sheet 10.6 ISP_NR_LSC_GRRGAIN_RDATA (offset 0x2488C, printed page 10-149, `hi3518ev200--Hi3518EV20X-Hi3516CV200-Datasheet.txt` line 67925).";

        field {
            name = "grgain_rdata";
            desc = "Read data of the LSC interpolation R/Gr channel gain";
            sw = r;
            hw = w;
            reset = 0x0;
        } grgain_rdata[31:0];
    } ISP_NR_LSC_GRRGAIN_RDATA @ 0x488C;

    reg {
        name = "NR LSC interpolation B/Gb channel WADDR gain information write address register";
        desc = "ISP_NR_LSC_GBBGAIN_WADDR is an NR LSC interpolation B/Gb channel gain write address register.

Data sheet 10.6 ISP_NR_LSC_GBBGAIN_WADDR (offset 0x24890, printed page 10-150, `hi3518ev200--Hi3518EV20X-Hi3516CV200-Datasheet.txt` line 67950).";

        field {
            name = "grgain_waddr";
            desc = "Write address of the LSC interpolation B/Gb channel gain";
            sw = rw;
            hw = r;
            reset = 0x0;
        } grgain_waddr[31:0];
    } ISP_NR_LSC_GBBGAIN_WADDR @ 0x4890;

    reg {
        name = "NR LSC interpolation B/Gb channel WDATA gain information write data register";
        desc = "ISP_NR_LSC_GBBGAIN_WDATA is an NR LSC interpolation B/Gb channel gain write data register.

Data sheet 10.6 ISP_NR_LSC_GBBGAIN_WDATA (offset 0x24894, printed page 10-150, `hi3518ev200--Hi3518EV20X-Hi3516CV200-Datasheet.txt` line 67969).";

        field {
            name = "grgain_wdata";
            desc = "Write data of the LSC interpolation B/Gb channel gain";
            sw = rw;
            hw = r;
            reset = 0x0;
        } grgain_wdata[31:0];
    } ISP_NR_LSC_GBBGAIN_WDATA @ 0x4894;

    reg {
        name = "NR LSC interpolation B/Gb channel RADDR gain information read address register";
        desc = "ISP_NR_LSC_GBBGAIN_RADDR is an NR LSC interpolation B/Gb channel gain read address register.

Data sheet 10.6 ISP_NR_LSC_GBBGAIN_RADDR (offset 0x24898, printed page 10-150, `hi3518ev200--Hi3518EV20X-Hi3516CV200-Datasheet.txt` line 67989).";

        field {
            name = "grgain_raddr";
            desc = "Read address of the LSC interpolation B/Gb channel gain";
            sw = rw;
            hw = r;
            reset = 0x0;
        } grgain_raddr[31:0];
    } ISP_NR_LSC_GBBGAIN_RADDR @ 0x4898;

    reg {
        name = "NR LSC interpolation B/Gb channel RDATA gain information read data register";
        desc = "ISP_NR_LSC_GBBGAIN_RDATA is an NR LSC interpolation B/Gb channel gain read data register.

Data sheet 10.6 ISP_NR_LSC_GBBGAIN_RDATA (offset 0x2489C, printed page 10-151, `hi3518ev200--Hi3518EV20X-Hi3516CV200-Datasheet.txt` line 68017).";

        field {
            name = "grgain_rdata";
            desc = "Read data of the LSC interpolation B/Gb channel gain";
            sw = r;
            hw = w;
            reset = 0x0;
        } grgain_rdata[31:0];
    } ISP_NR_LSC_GBBGAIN_RDATA @ 0x489C;

    reg {
        name = "DPC control register";
        desc = "ISP_DPC_CFG is a DPC control register.

Data sheet 10.6 ISP_DPC_CFG (offset 0x25000, printed page 10-151, `hi3518ev200--Hi3518EV20X-Hi3516CV200-Datasheet.txt` line 68035).";

        enum ISP_DPC_CFG_en_enum {
            DISABLED = 0 { name = "Disabled"; desc = "disabled"; };
            ENABLED = 1 { name = "Enabled"; desc = "enabled"; };
        };

        field {
            name = "en";
            desc = "DPC enable";
            sw = rw;
            hw = r;
            encode = ISP_DPC_CFG_en_enum;
            reset = 0x0;
        } en[0:0];
    } ISP_DPC_CFG @ 0x5000;

    reg {
        name = "DPC blending ratio register";
        desc = "ISP_DPC_ALPHA is a DPC blending ratio register.

Data sheet 10.6 ISP_DPC_ALPHA (offset 0x25008, printed page 10-152, `hi3518ev200--Hi3518EV20X-Hi3516CV200-Datasheet.txt` line 68066).";

        field {
            name = "alpha0_rb";
            desc = "Blending ratio of the R/B component 5-point median filtering result to the 9-point median filtering result";
            sw = rw;
            hw = r;
            reset = 0x0;
        } alpha0_rb[31:24];

        field {
            name = "alpha0_g";
            desc = "Blending ratio of the G component 5-point median filtering result to the 9-point median filtering result";
            sw = rw;
            hw = r;
            reset = 0x0;
        } alpha0_g[23:16];

        field {
            name = "alpha1_rb";
            desc = "Blending ratio of the R/B component input to the median filtering result";
            sw = rw;
            hw = r;
            reset = 0x0;
        } alpha1_rb[15:8];

        field {
            name = "alpha1_g";
            desc = "Blending ratio of the G component input to the median filtering result";
            sw = rw;
            hw = r;
            reset = 0x0;
        } alpha1_g[7:0];
    } ISP_DPC_ALPHA @ 0x5008;

    reg {
        name = "DPC mode register";
        desc = "ISP_DPC_MODE is a DPC mode register.

Data sheet 10.6 ISP_DPC_MODE (offset 0x25010, printed page 10-152, `hi3518ev200--Hi3518EV20X-Hi3516CV200-Datasheet.txt` line 68096).";

        enum ISP_DPC_MODE_ir_channel_enum {
            BAYER_FORMAT = 0 { name = "Bayer Format"; desc = "bayer format"; };
            RGBIR_FORMAT = 1 { name = "Rgbir Format"; desc = "RGBIR format"; };
        };

        field {
            name = "ir_channel";
            desc = "Format select";
            sw = rw;
            hw = r;
            encode = ISP_DPC_MODE_ir_channel_enum;
            reset = 0x0;
        } ir_channel[9:9];

        enum ISP_DPC_MODE_ir_position_enum {
            IR_USES_GB = 0 { name = "Ir Uses Gb"; desc = "The IR uses the Gb channel."; };
            IR_USES_GR = 1 { name = "Ir Uses Gr"; desc = "The IR uses the Gr channel."; };
        };

        field {
            name = "ir_position";
            desc = "Channel select";
            sw = rw;
            hw = r;
            encode = ISP_DPC_MODE_ir_position_enum;
            reset = 0x0;
        } ir_position[8:8];

        enum ISP_DPC_MODE_dp_hightlight_en_enum {
            DISABLED = 0 { name = "Disabled"; desc = "disabled"; };
            ENABLED = 1 { name = "Enabled"; desc = "enabled"; };
        };

        field {
            name = "dp_hightlight_en";
            desc = "Defect pixel highlight enable";
            sw = rw;
            hw = r;
            encode = ISP_DPC_MODE_dp_hightlight_en_enum;
            reset = 0x0;
        } dp_hightlight_en[7:7];

        enum ISP_DPC_MODE_dpt_det_sel_enum {
            BRIGHT_DOTS_DETECTED = 0 { name = "Bright Dots Detected"; desc = "The bright dots are detected."; };
            DARK_DOTS_DETECTED = 1 { name = "Dark Dots Detected"; desc = "The dark dots are detected."; };
        };

        field {
            name = "dpt_det_sel";
            desc = "Defect pixel table detection select";
            sw = rw;
            hw = r;
            encode = ISP_DPC_MODE_dpt_det_sel_enum;
            reset = 0x0;
        } dpt_det_sel[6:6];

        enum ISP_DPC_MODE_bpt_cor_en_enum {
            DISABLED = 0 { name = "Disabled"; desc = "disabled"; };
            ENABLED = 1 { name = "Enabled"; desc = "enabled"; };
        };

        field {
            name = "bpt_cor_en";
            desc = "Defect pixel table correction enable";
            sw = rw;
            hw = r;
            encode = ISP_DPC_MODE_bpt_cor_en_enum;
            reset = 0x0;
        } bpt_cor_en[5:5];

        enum ISP_DPC_MODE_grayscale_mode_enum {
            RAW_DATA = 0 { name = "Raw Data"; desc = "raw data"; };
            GRAY_SCALE_IMAGE = 1 { name = "Gray Scale Image"; desc = "gray scale image"; };
        };

        field {
            name = "grayscale_mode";
            desc = "Mode of the gray scale image";
            sw = rw;
            hw = r;
            encode = ISP_DPC_MODE_grayscale_mode_enum;
            reset = 0x0;
        } grayscale_mode[4:4];

        enum ISP_DPC_MODE_bpt_update_enum {
            DISABLED = 0 { name = "Disabled"; desc = "disabled"; };
            ENABLED = 1 { name = "Enabled"; desc = "enabled"; };
        };

        field {
            name = "bpt_update";
            desc = "Defect pixel table calibration enable";
            sw = rw;
            hw = r;
            encode = ISP_DPC_MODE_bpt_update_enum;
            reset = 0x0;
        } bpt_update[3:3];

        enum ISP_DPC_MODE_six_det_en_enum {
            DISABLED = 0 { name = "Disabled"; desc = "disabled"; };
            ENABLED = 1 { name = "Enabled"; desc = "enabled"; };
        };

        field {
            name = "six_det_en";
            desc = "Maximum/Minimum value detection, used only during defect pixel table calibration";
            sw = rw;
            hw = r;
            encode = ISP_DPC_MODE_six_det_en_enum;
            reset = 0x0;
        } six_det_en[2:2];

        enum ISP_DPC_MODE_cor_en_enum {
            DISABLED = 0 { name = "Disabled"; desc = "disabled"; };
            ENABLED = 1 { name = "Enabled"; desc = "enabled"; };
        };

        field {
            name = "cor_en";
            desc = "Dynamic correction enable";
            sw = rw;
            hw = r;
            encode = ISP_DPC_MODE_cor_en_enum;
            reset = 0x0;
        } cor_en[1:1];

        enum ISP_DPC_MODE_det_en_enum {
            DISABLED = 0 { name = "Disabled"; desc = "disabled"; };
            ENABLED = 1 { name = "Enabled"; desc = "enabled"; };
        };

        field {
            name = "det_en";
            desc = "Dynamic detection enable";
            sw = rw;
            hw = r;
            encode = ISP_DPC_MODE_det_en_enum;
            reset = 0x0;
        } det_en[0:0];
    } ISP_DPC_MODE @ 0x5010;

    reg {
        name = "Dynamic correction mode register E";
        desc = "ISP_DPC_OUTPUT_MODE is a dynamic correction mode register.

Data sheet 10.6 ISP_DPC_OUTPUT_MODE (offset 0x25014, printed page 10-154, `hi3518ev200--Hi3518EV20X-Hi3516CV200-Datasheet.txt` line 68173).";

        enum ISP_DPC_OUTPUT_MODE_stage1_incl_rb_3x3_enum {
            NO = 0 { name = "No"; desc = "no"; };
            YES = 1 { name = "Yes"; desc = "yes"; };
        };

        field {
            name = "stage1_incl_rb_3x3";
            desc = "Whether the R/B point correction uses the 9-point median";
            sw = rw;
            hw = r;
            encode = ISP_DPC_OUTPUT_MODE_stage1_incl_rb_3x3_enum;
            reset = 0x0;
        } stage1_incl_rb_3x3[3:3];

        enum ISP_DPC_OUTPUT_MODE_stage1_incl_g_3x3_enum {
            NO = 0 { name = "No"; desc = "no"; };
            YES = 1 { name = "Yes"; desc = "yes"; };
        };

        field {
            name = "stage1_incl_g_3x3";
            desc = "Whether the G point correction uses the 9-point median";
            sw = rw;
            hw = r;
            encode = ISP_DPC_OUTPUT_MODE_stage1_incl_g_3x3_enum;
            reset = 0x0;
        } stage1_incl_g_3x3[2:2];

        enum ISP_DPC_OUTPUT_MODE_stage1_incl_rb_center_enum {
            NO = 0 { name = "No"; desc = "no"; };
            YES = 1 { name = "Yes"; desc = "yes"; };
        };

        field {
            name = "stage1_incl_rb_center";
            desc = "Whether the R/B point correction contains the central point";
            sw = rw;
            hw = r;
            encode = ISP_DPC_OUTPUT_MODE_stage1_incl_rb_center_enum;
            reset = 0x0;
        } stage1_incl_rb_center[1:1];

        enum ISP_DPC_OUTPUT_MODE_stage1_incl_gr_center_enum {
            NO = 0 { name = "No"; desc = "no"; };
            YES = 1 { name = "Yes"; desc = "yes"; };
        };

        field {
            name = "stage1_incl_gr_center";
            desc = "Whether the G point correction contains the central point";
            sw = rw;
            hw = r;
            encode = ISP_DPC_OUTPUT_MODE_stage1_incl_gr_center_enum;
            reset = 0x0;
        } stage1_incl_gr_center[0:0];
    } ISP_DPC_OUTPUT_MODE @ 0x5014;

    reg {
        name = "Dynamic detection level register";
        desc = "ISP_DPC_SET_USE is a dynamic detection level register.

Data sheet 10.6 ISP_DPC_SET_USE (offset 0x25018, printed page 10-155, `hi3518ev200--Hi3518EV20X-Hi3516CV200-Datasheet.txt` line 68223).";

        enum ISP_DPC_SET_USE_stage1_use_fix_set_enum {
            NO = 0 { name = "No"; desc = "no"; };
            YES = 1 { name = "Yes"; desc = "yes"; };
        };

        field {
            name = "stage1_use_fix_set";
            desc = "Whether other detection levels are valid";
            sw = rw;
            hw = r;
            encode = ISP_DPC_SET_USE_stage1_use_fix_set_enum;
            reset = 0x0;
        } stage1_use_fix_set[3:3];

        enum ISP_DPC_SET_USE_stage1_use_set3_enum {
            NO = 0 { name = "No"; desc = "no"; };
            YES = 1 { name = "Yes"; desc = "yes"; };
        };

        field {
            name = "stage1_use_set3";
            desc = "Whether detection level 3 is valid";
            sw = rw;
            hw = r;
            encode = ISP_DPC_SET_USE_stage1_use_set3_enum;
            reset = 0x0;
        } stage1_use_set3[2:2];

        enum ISP_DPC_SET_USE_stage1_use_set2_enum {
            NO = 0 { name = "No"; desc = "no"; };
            YES = 1 { name = "Yes"; desc = "yes"; };
        };

        field {
            name = "stage1_use_set2";
            desc = "Whether detection level 2 is valid";
            sw = rw;
            hw = r;
            encode = ISP_DPC_SET_USE_stage1_use_set2_enum;
            reset = 0x0;
        } stage1_use_set2[1:1];

        enum ISP_DPC_SET_USE_stage1_use_set1_enum {
            NO = 0 { name = "No"; desc = "no"; };
            YES = 1 { name = "Yes"; desc = "yes"; };
        };

        field {
            name = "stage1_use_set1";
            desc = "Whether detection level 1 is valid";
            sw = rw;
            hw = r;
            encode = ISP_DPC_SET_USE_stage1_use_set1_enum;
            reset = 0x0;
        } stage1_use_set1[0:0];
    } ISP_DPC_SET_USE @ 0x5018;

    reg {
        name = "Detection switch register 1 _1";
        desc = "ISP_DPC_METHODS_SET_1 is detection switch register 1.

Data sheet 10.6 ISP_DPC_METHODS_SET_1 (offset 0x2501C, printed page 10-156, `hi3518ev200--Hi3518EV20X-Hi3516CV200-Datasheet.txt` line 68269).";

        enum ISP_DPC_METHODS_SET_1_rg_red_blue1_enable_enum {
            DISABLED = 0 { name = "Disabled"; desc = "disabled"; };
            ENABLED = 1 { name = "Enabled"; desc = "enabled"; };
        };

        field {
            name = "rg_red_blue1_enable";
            desc = "R/B point level 1 gradient sorting detection enable";
            sw = rw;
            hw = r;
            encode = ISP_DPC_METHODS_SET_1_rg_red_blue1_enable_enum;
            reset = 0x0;
        } rg_red_blue1_enable[12:12];

        enum ISP_DPC_METHODS_SET_1_rnd_red_blue1_enable_enum {
            DISABLED = 0 { name = "Disabled"; desc = "disabled"; };
            ENABLED = 1 { name = "Enabled"; desc = "enabled"; };
        };

        field {
            name = "rnd_red_blue1_enable";
            desc = "R/B point level 1 adjacent difference sorting detection enable";
            sw = rw;
            hw = r;
            encode = ISP_DPC_METHODS_SET_1_rnd_red_blue1_enable_enum;
            reset = 0x0;
        } rnd_red_blue1_enable[11:11];

        enum ISP_DPC_METHODS_SET_1_ro_red_blue1_enable_enum {
            DISABLED = 0 { name = "Disabled"; desc = "disabled"; };
            ENABLED = 1 { name = "Enabled"; desc = "enabled"; };
        };

        field {
            name = "ro_red_blue1_enable";
            desc = "R/B point level 1 sorting detection enable";
            sw = rw;
            hw = r;
            encode = ISP_DPC_METHODS_SET_1_ro_red_blue1_enable_enum;
            reset = 0x0;
        } ro_red_blue1_enable[10:10];

        enum ISP_DPC_METHODS_SET_1_lc_red_blue1_enable_enum {
            DISABLED = 0 { name = "Disabled"; desc = "disabled"; };
            ENABLED = 1 { name = "Enabled"; desc = "enabled"; };
        };

        field {
            name = "lc_red_blue1_enable";
            desc = "R/B point level 1 linear detection enable";
            sw = rw;
            hw = r;
            encode = ISP_DPC_METHODS_SET_1_lc_red_blue1_enable_enum;
            reset = 0x0;
        } lc_red_blue1_enable[9:9];

        enum ISP_DPC_METHODS_SET_1_pg_red_blue1_enable_enum {
            DISABLED = 0 { name = "Disabled"; desc = "disabled"; };
            ENABLED = 1 { name = "Enabled"; desc = "enabled"; };
        };

        field {
            name = "pg_red_blue1_enable";
            desc = "R/B point level 1 peak value gradient detection enable";
            sw = rw;
            hw = r;
            encode = ISP_DPC_METHODS_SET_1_pg_red_blue1_enable_enum;
            reset = 0x0;
        } pg_red_blue1_enable[8:8];

        enum ISP_DPC_METHODS_SET_1_rg_green1_enable_enum {
            DISABLED = 0 { name = "Disabled"; desc = "disabled"; };
            ENABLED = 1 { name = "Enabled"; desc = "enabled"; };
        };

        field {
            name = "rg_green1_enable";
            desc = "G point level 1 gradient sorting detection enable";
            sw = rw;
            hw = r;
            encode = ISP_DPC_METHODS_SET_1_rg_green1_enable_enum;
            reset = 0x0;
        } rg_green1_enable[4:4];

        enum ISP_DPC_METHODS_SET_1_rnd_green1_enable_enum {
            DISABLED = 0 { name = "Disabled"; desc = "disabled"; };
            ENABLED = 1 { name = "Enabled"; desc = "enabled"; };
        };

        field {
            name = "rnd_green1_enable";
            desc = "G point level 1 adjacent difference sorting detection enable";
            sw = rw;
            hw = r;
            encode = ISP_DPC_METHODS_SET_1_rnd_green1_enable_enum;
            reset = 0x0;
        } rnd_green1_enable[3:3];

        enum ISP_DPC_METHODS_SET_1_ro_green1_enable_enum {
            DISABLED = 0 { name = "Disabled"; desc = "disabled"; };
            ENABLED = 1 { name = "Enabled"; desc = "enabled"; };
        };

        field {
            name = "ro_green1_enable";
            desc = "G point level 1 sorting detection enable";
            sw = rw;
            hw = r;
            encode = ISP_DPC_METHODS_SET_1_ro_green1_enable_enum;
            reset = 0x0;
        } ro_green1_enable[2:2];

        enum ISP_DPC_METHODS_SET_1_lc_green1_enable_enum {
            DISABLED = 0 { name = "Disabled"; desc = "disabled"; };
            ENABLED = 1 { name = "Enabled"; desc = "enabled"; };
        };

        field {
            name = "lc_green1_enable";
            desc = "G point level 1 linear detection enable";
            sw = rw;
            hw = r;
            encode = ISP_DPC_METHODS_SET_1_lc_green1_enable_enum;
            reset = 0x0;
        } lc_green1_enable[1:1];

        enum ISP_DPC_METHODS_SET_1_pg_green1_enable_enum {
            DISABLED = 0 { name = "Disabled"; desc = "disabled"; };
            ENABLED = 1 { name = "Enabled"; desc = "enabled"; };
        };

        field {
            name = "pg_green1_enable";
            desc = "G point level 1 peak value gradient detection enable";
            sw = rw;
            hw = r;
            encode = ISP_DPC_METHODS_SET_1_pg_green1_enable_enum;
            reset = 0x0;
        } pg_green1_enable[0:0];
    } ISP_DPC_METHODS_SET_1 @ 0x501C;

    reg {
        name = "Detection switch register 2 _2";
        desc = "ISP_DPC_METHODS_SET_2 is detection switch register 2.

Data sheet 10.6 ISP_DPC_METHODS_SET_2 (offset 0x25020, printed page 10-157, `hi3518ev200--Hi3518EV20X-Hi3516CV200-Datasheet.txt` line 68347).";

        enum ISP_DPC_METHODS_SET_2_rg_red_blue2_enable_enum {
            DISABLED = 0 { name = "Disabled"; desc = "disabled"; };
            ENABLED = 1 { name = "Enabled"; desc = "enabled"; };
        };

        field {
            name = "rg_red_blue2_enable";
            desc = "R/B point level 2 gradient sorting detection enable";
            sw = rw;
            hw = r;
            encode = ISP_DPC_METHODS_SET_2_rg_red_blue2_enable_enum;
            reset = 0x0;
        } rg_red_blue2_enable[12:12];

        enum ISP_DPC_METHODS_SET_2_rnd_red_blue2_enable_enum {
            DISABLED = 0 { name = "Disabled"; desc = "disabled"; };
            ENABLED = 1 { name = "Enabled"; desc = "enabled"; };
        };

        field {
            name = "rnd_red_blue2_enable";
            desc = "R/B point level 2 adjacent difference sorting detection enable";
            sw = rw;
            hw = r;
            encode = ISP_DPC_METHODS_SET_2_rnd_red_blue2_enable_enum;
            reset = 0x0;
        } rnd_red_blue2_enable[11:11];

        enum ISP_DPC_METHODS_SET_2_ro_red_blue2_enable_enum {
            DISABLED = 0 { name = "Disabled"; desc = "disabled"; };
            ENABLED = 1 { name = "Enabled"; desc = "enabled"; };
        };

        field {
            name = "ro_red_blue2_enable";
            desc = "R/B point level 2 sorting detection enable";
            sw = rw;
            hw = r;
            encode = ISP_DPC_METHODS_SET_2_ro_red_blue2_enable_enum;
            reset = 0x0;
        } ro_red_blue2_enable[10:10];

        enum ISP_DPC_METHODS_SET_2_lc_red_blue2_enable_enum {
            DISABLED = 0 { name = "Disabled"; desc = "disabled"; };
            ENABLED = 1 { name = "Enabled"; desc = "enabled"; };
        };

        field {
            name = "lc_red_blue2_enable";
            desc = "R/B point level 2 linear detection enable";
            sw = rw;
            hw = r;
            encode = ISP_DPC_METHODS_SET_2_lc_red_blue2_enable_enum;
            reset = 0x0;
        } lc_red_blue2_enable[9:9];

        enum ISP_DPC_METHODS_SET_2_pg_red_blue2_enable_enum {
            DISABLED = 0 { name = "Disabled"; desc = "disabled"; };
            ENABLED = 1 { name = "Enabled"; desc = "enabled"; };
        };

        field {
            name = "pg_red_blue2_enable";
            desc = "R/B point level 2 peak value gradient detection enable";
            sw = rw;
            hw = r;
            encode = ISP_DPC_METHODS_SET_2_pg_red_blue2_enable_enum;
            reset = 0x0;
        } pg_red_blue2_enable[8:8];

        enum ISP_DPC_METHODS_SET_2_rg_green2_enable_enum {
            DISABLED = 0 { name = "Disabled"; desc = "disabled"; };
            ENABLED = 1 { name = "Enabled"; desc = "enabled"; };
        };

        field {
            name = "rg_green2_enable";
            desc = "G point level 2 gradient sorting detection enable";
            sw = rw;
            hw = r;
            encode = ISP_DPC_METHODS_SET_2_rg_green2_enable_enum;
            reset = 0x0;
        } rg_green2_enable[4:4];

        enum ISP_DPC_METHODS_SET_2_rnd_green2_enable_enum {
            DISABLED = 0 { name = "Disabled"; desc = "disabled"; };
            ENABLED = 1 { name = "Enabled"; desc = "enabled"; };
        };

        field {
            name = "rnd_green2_enable";
            desc = "G point level 2 adjacent difference sorting detection enable";
            sw = rw;
            hw = r;
            encode = ISP_DPC_METHODS_SET_2_rnd_green2_enable_enum;
            reset = 0x0;
        } rnd_green2_enable[3:3];

        enum ISP_DPC_METHODS_SET_2_ro_green2_enable_enum {
            DISABLED = 0 { name = "Disabled"; desc = "disabled"; };
            ENABLED = 1 { name = "Enabled"; desc = "enabled"; };
        };

        field {
            name = "ro_green2_enable";
            desc = "G point level 2 sorting detection enable";
            sw = rw;
            hw = r;
            encode = ISP_DPC_METHODS_SET_2_ro_green2_enable_enum;
            reset = 0x0;
        } ro_green2_enable[2:2];

        enum ISP_DPC_METHODS_SET_2_lc_green2_enable_enum {
            DISABLED = 0 { name = "Disabled"; desc = "disabled"; };
            ENABLED = 1 { name = "Enabled"; desc = "enabled"; };
        };

        field {
            name = "lc_green2_enable";
            desc = "G point level 2 linear detection enable";
            sw = rw;
            hw = r;
            encode = ISP_DPC_METHODS_SET_2_lc_green2_enable_enum;
            reset = 0x0;
        } lc_green2_enable[1:1];

        enum ISP_DPC_METHODS_SET_2_pg_green2_enable_enum {
            DISABLED = 0 { name = "Disabled"; desc = "disabled"; };
            ENABLED = 1 { name = "Enabled"; desc = "enabled"; };
        };

        field {
            name = "pg_green2_enable";
            desc = "G point level 2 peak value gradient detection enable";
            sw = rw;
            hw = r;
            encode = ISP_DPC_METHODS_SET_2_pg_green2_enable_enum;
            reset = 0x0;
        } pg_green2_enable[0:0];
    } ISP_DPC_METHODS_SET_2 @ 0x5020;

    reg {
        name = "Detection switch register 3 _3";
        desc = "ISP_DPC_METHODS_SET_3 is detection switch register 3.

Data sheet 10.6 ISP_DPC_METHODS_SET_3 (offset 0x25024, printed page 10-159, `hi3518ev200--Hi3518EV20X-Hi3516CV200-Datasheet.txt` line 68434).";

        enum ISP_DPC_METHODS_SET_3_rg_red_blue3_enable_enum {
            DISABLED = 0 { name = "Disabled"; desc = "disabled"; };
            ENABLED = 1 { name = "Enabled"; desc = "enabled"; };
        };

        field {
            name = "rg_red_blue3_enable";
            desc = "R/B point level 3 gradient sorting detection enable";
            sw = rw;
            hw = r;
            encode = ISP_DPC_METHODS_SET_3_rg_red_blue3_enable_enum;
            reset = 0x0;
        } rg_red_blue3_enable[12:12];

        enum ISP_DPC_METHODS_SET_3_rnd_red_blue3_enable_enum {
            DISABLED = 0 { name = "Disabled"; desc = "disabled"; };
            ENABLED = 1 { name = "Enabled"; desc = "enabled"; };
        };

        field {
            name = "rnd_red_blue3_enable";
            desc = "R/B point level 3 adjacent difference sorting detection enable";
            sw = rw;
            hw = r;
            encode = ISP_DPC_METHODS_SET_3_rnd_red_blue3_enable_enum;
            reset = 0x0;
        } rnd_red_blue3_enable[11:11];

        enum ISP_DPC_METHODS_SET_3_ro_red_blue3_enable_enum {
            DISABLED = 0 { name = "Disabled"; desc = "disabled"; };
            ENABLED = 1 { name = "Enabled"; desc = "enabled"; };
        };

        field {
            name = "ro_red_blue3_enable";
            desc = "R/B point level 3 sorting detection enable";
            sw = rw;
            hw = r;
            encode = ISP_DPC_METHODS_SET_3_ro_red_blue3_enable_enum;
            reset = 0x0;
        } ro_red_blue3_enable[10:10];

        enum ISP_DPC_METHODS_SET_3_lc_red_blue3_enable_enum {
            DISABLED = 0 { name = "Disabled"; desc = "disabled"; };
            ENABLED = 1 { name = "Enabled"; desc = "enabled"; };
        };

        field {
            name = "lc_red_blue3_enable";
            desc = "R/B point level 3 linear detection enable";
            sw = rw;
            hw = r;
            encode = ISP_DPC_METHODS_SET_3_lc_red_blue3_enable_enum;
            reset = 0x0;
        } lc_red_blue3_enable[9:9];

        enum ISP_DPC_METHODS_SET_3_pg_red_blue3_enable_enum {
            DISABLED = 0 { name = "Disabled"; desc = "disabled"; };
            ENABLED = 1 { name = "Enabled"; desc = "enabled"; };
        };

        field {
            name = "pg_red_blue3_enable";
            desc = "R/B point level 3 peak value gradient detection enable";
            sw = rw;
            hw = r;
            encode = ISP_DPC_METHODS_SET_3_pg_red_blue3_enable_enum;
            reset = 0x0;
        } pg_red_blue3_enable[8:8];

        enum ISP_DPC_METHODS_SET_3_rg_green3_enable_enum {
            DISABLED = 0 { name = "Disabled"; desc = "disabled"; };
            ENABLED = 1 { name = "Enabled"; desc = "enabled"; };
        };

        field {
            name = "rg_green3_enable";
            desc = "G point level 3 gradient sorting detection enable";
            sw = rw;
            hw = r;
            encode = ISP_DPC_METHODS_SET_3_rg_green3_enable_enum;
            reset = 0x0;
        } rg_green3_enable[4:4];

        enum ISP_DPC_METHODS_SET_3_rnd_green3_enable_enum {
            DISABLED = 0 { name = "Disabled"; desc = "disabled"; };
            ENABLED = 1 { name = "Enabled"; desc = "enabled"; };
        };

        field {
            name = "rnd_green3_enable";
            desc = "G point level 3 adjacent difference sorting detection enable";
            sw = rw;
            hw = r;
            encode = ISP_DPC_METHODS_SET_3_rnd_green3_enable_enum;
            reset = 0x0;
        } rnd_green3_enable[3:3];

        enum ISP_DPC_METHODS_SET_3_ro_green3_enable_enum {
            DISABLED = 0 { name = "Disabled"; desc = "disabled"; };
            ENABLED = 1 { name = "Enabled"; desc = "enabled"; };
        };

        field {
            name = "ro_green3_enable";
            desc = "G point level 3 sorting detection enable";
            sw = rw;
            hw = r;
            encode = ISP_DPC_METHODS_SET_3_ro_green3_enable_enum;
            reset = 0x0;
        } ro_green3_enable[2:2];

        enum ISP_DPC_METHODS_SET_3_lc_green3_enable_enum {
            DISABLED = 0 { name = "Disabled"; desc = "disabled"; };
            ENABLED = 1 { name = "Enabled"; desc = "enabled"; };
        };

        field {
            name = "lc_green3_enable";
            desc = "G point level 3 linear detection enable";
            sw = rw;
            hw = r;
            encode = ISP_DPC_METHODS_SET_3_lc_green3_enable_enum;
            reset = 0x0;
        } lc_green3_enable[1:1];

        enum ISP_DPC_METHODS_SET_3_pg_green3_enable_enum {
            DISABLED = 0 { name = "Disabled"; desc = "disabled"; };
            ENABLED = 1 { name = "Enabled"; desc = "enabled"; };
        };

        field {
            name = "pg_green3_enable";
            desc = "G point level 3 peak value gradient detection enable";
            sw = rw;
            hw = r;
            encode = ISP_DPC_METHODS_SET_3_pg_green3_enable_enum;
            reset = 0x0;
        } pg_green3_enable[0:0];
    } ISP_DPC_METHODS_SET_3 @ 0x5024;

    reg {
        name = "Linear detection parameter 1 1 register";
        desc = "ISP_DPC_LINE_THRESH_1 is a linear detection parameter 1 register.

Data sheet 10.6 ISP_DPC_LINE_THRESH_1 (offset 0x25028, printed page 10-160, `hi3518ev200--Hi3518EV20X-Hi3516CV200-Datasheet.txt` line 68512).";

        field {
            name = "line_thr1_rb";
            desc = "R/B point detection parameter";
            sw = rw;
            hw = r;
            reset = 0x0;
        } line_thr1_rb[15:8];

        field {
            name = "line_thr1_g";
            desc = "G point detection parameter";
            sw = rw;
            hw = r;
            reset = 0x0;
        } line_thr1_g[7:0];
    } ISP_DPC_LINE_THRESH_1 @ 0x5028;

    reg {
        name = "Linear detection parameter 1 C_1 register";
        desc = "ISP_DPC_LINE_MAD_FAC_1 is a linear detection parameter 1 register.

Data sheet 10.6 ISP_DPC_LINE_MAD_FAC_1 (offset 0x2502C, printed page 10-161, `hi3518ev200--Hi3518EV20X-Hi3516CV200-Datasheet.txt` line 68542).";

        field {
            name = "line_mad_fac_1_rb";
            desc = "R/B point detection parameter";
            sw = rw;
            hw = r;
            reset = 0x0;
        } line_mad_fac_1_rb[13:8];

        field {
            name = "line_mad_fac_1_g";
            desc = "G point detection parameter";
            sw = rw;
            hw = r;
            reset = 0x0;
        } line_mad_fac_1_g[5:0];
    } ISP_DPC_LINE_MAD_FAC_1 @ 0x502C;

    reg {
        name = "Peak gradient parameter 1 register";
        desc = "ISP_DPC_PG_FAC_1 is a peak gradient parameter 1 register.

Data sheet 10.6 ISP_DPC_PG_FAC_1 (offset 0x25030, printed page 10-161, `hi3518ev200--Hi3518EV20X-Hi3516CV200-Datasheet.txt` line 68567).";

        field {
            name = "pg_fac_1_rb";
            desc = "R/B point detection parameter";
            sw = rw;
            hw = r;
            reset = 0x0;
        } pg_fac_1_rb[13:8];

        field {
            name = "pg_fac_1_g";
            desc = "G point detection parameter";
            sw = rw;
            hw = r;
            reset = 0x0;
        } pg_fac_1_g[5:0];
    } ISP_DPC_PG_FAC_1 @ 0x5030;

    reg {
        name = "Adjacent difference value sorting 1 parameter 1 register";
        desc = "ISP_DPC_RND_THRESH_1 is an adjacent difference value sorting parameter 1 register.

Data sheet 10.6 ISP_DPC_RND_THRESH_1 (offset 0x25034, printed page 10-162, `hi3518ev200--Hi3518EV20X-Hi3516CV200-Datasheet.txt` line 68602).";

        field {
            name = "rnd_thr1_rb";
            desc = "R/B point detection parameter";
            sw = rw;
            hw = r;
            reset = 0x0;
        } rnd_thr1_rb[15:8];

        field {
            name = "rnd_thr1_g";
            desc = "G point detection parameter";
            sw = rw;
            hw = r;
            reset = 0x0;
        } rnd_thr1_g[7:0];
    } ISP_DPC_RND_THRESH_1 @ 0x5034;

    reg {
        name = "Gradient sorting parameter 1 register";
        desc = "ISP_DPC_RG_FAC_1 is a gradient sorting parameter 1 register.

Data sheet 10.6 ISP_DPC_RG_FAC_1 (offset 0x25038, printed page 10-162, `hi3518ev200--Hi3518EV20X-Hi3516CV200-Datasheet.txt` line 68623).";

        field {
            name = "rg_fac_1_rb";
            desc = "R/B point detection parameter";
            sw = rw;
            hw = r;
            reset = 0x0;
        } rg_fac_1_rb[13:8];

        field {
            name = "rg_fac_1_g";
            desc = "G point detection parameter";
            sw = rw;
            hw = r;
            reset = 0x0;
        } rg_fac_1_g[5:0];
    } ISP_DPC_RG_FAC_1 @ 0x5038;

    reg {
        name = "Linear detection parameter 2 2 register";
        desc = "ISP_DPC_LINE_THRESH_2 is a linear detection parameter 2 register.

Data sheet 10.6 ISP_DPC_LINE_THRESH_2 (offset 0x2503C, printed page 10-163, `hi3518ev200--Hi3518EV20X-Hi3516CV200-Datasheet.txt` line 68657).";

        field {
            name = "line_thr2_rb";
            desc = "R/B point detection parameter";
            sw = rw;
            hw = r;
            reset = 0x0;
        } line_thr2_rb[15:8];

        field {
            name = "line_thr2_g";
            desc = "G point detection parameter";
            sw = rw;
            hw = r;
            reset = 0x0;
        } line_thr2_g[7:0];
    } ISP_DPC_LINE_THRESH_2 @ 0x503C;

    reg {
        name = "Linear detection parameter 2 C_2 register";
        desc = "ISP_DPC_LINE_MAD_FAC_2 is a linear detection parameter 2 register.

Data sheet 10.6 ISP_DPC_LINE_MAD_FAC_2 (offset 0x25040, printed page 10-163, `hi3518ev200--Hi3518EV20X-Hi3516CV200-Datasheet.txt` line 68678).";

        field {
            name = "line_mad_fac_2_rb";
            desc = "R/B point detection parameter";
            sw = rw;
            hw = r;
            reset = 0x0;
        } line_mad_fac_2_rb[13:8];

        field {
            name = "line_mad_fac_2_g";
            desc = "G point detection parameter";
            sw = rw;
            hw = r;
            reset = 0x0;
        } line_mad_fac_2_g[5:0];
    } ISP_DPC_LINE_MAD_FAC_2 @ 0x5040;

    reg {
        name = "Peak gradient parameter 2 register";
        desc = "ISP_DPC_PG_FAC_2 is a peak gradient parameter 2 register.

Data sheet 10.6 ISP_DPC_PG_FAC_2 (offset 0x25044, printed page 10-164, `hi3518ev200--Hi3518EV20X-Hi3516CV200-Datasheet.txt` line 68712).";

        field {
            name = "pg_fac_2_rb";
            desc = "R/B point detection parameter";
            sw = rw;
            hw = r;
            reset = 0x0;
        } pg_fac_2_rb[13:8];

        field {
            name = "pg_fac_2_g";
            desc = "G point detection parameter";
            sw = rw;
            hw = r;
            reset = 0x0;
        } pg_fac_2_g[5:0];
    } ISP_DPC_PG_FAC_2 @ 0x5044;

    reg {
        name = "Adjacent difference value sorting 2 parameter 2 register";
        desc = "ISP_DPC_RND_THRESH_2 is an adjacent difference value sorting parameter 2 register.

Data sheet 10.6 ISP_DPC_RND_THRESH_2 (offset 0x25048, printed page 10-164, `hi3518ev200--Hi3518EV20X-Hi3516CV200-Datasheet.txt` line 68737).";

        field {
            name = "rnd_thr2_rb";
            desc = "R/B point detection parameter";
            sw = rw;
            hw = r;
            reset = 0x0;
        } rnd_thr2_rb[15:8];

        field {
            name = "rnd_thr2_g";
            desc = "G point detection parameter";
            sw = rw;
            hw = r;
            reset = 0x0;
        } rnd_thr2_g[7:0];
    } ISP_DPC_RND_THRESH_2 @ 0x5048;

    reg {
        name = "Gradient sorting parameter 2 register";
        desc = "ISP_DPC_RG_FAC_2 is a gradient sorting parameter 2 register.

Data sheet 10.6 ISP_DPC_RG_FAC_2 (offset 0x2504C, printed page 10-165, `hi3518ev200--Hi3518EV20X-Hi3516CV200-Datasheet.txt` line 68766).";

        field {
            name = "rg_fac_2_rb";
            desc = "R/B point detection parameter";
            sw = rw;
            hw = r;
            reset = 0x0;
        } rg_fac_2_rb[13:8];

        field {
            name = "rg_fac_2_g";
            desc = "G point detection parameter";
            sw = rw;
            hw = r;
            reset = 0x0;
        } rg_fac_2_g[5:0];
    } ISP_DPC_RG_FAC_2 @ 0x504C;

    reg {
        name = "Linear detection parameter 3 3 register";
        desc = "ISP_DPC_LINE_THRESH_3 is a linear detection parameter 3 register.

Data sheet 10.6 ISP_DPC_LINE_THRESH_3 (offset 0x25050, printed page 10-165, `hi3518ev200--Hi3518EV20X-Hi3516CV200-Datasheet.txt` line 68791).";

        field {
            name = "line_thr3_rb";
            desc = "R/B point detection parameter";
            sw = rw;
            hw = r;
            reset = 0x0;
        } line_thr3_rb[15:8];

        field {
            name = "line_thr3_g";
            desc = "G point detection parameter";
            sw = rw;
            hw = r;
            reset = 0x0;
        } line_thr3_g[7:0];
    } ISP_DPC_LINE_THRESH_3 @ 0x5050;

    reg {
        name = "Linear detection parameter 3 C_3 register";
        desc = "ISP_DPC_LINE_MAD_FAC_3 is a linear detection parameter 3 register.

Data sheet 10.6 ISP_DPC_LINE_MAD_FAC_3 (offset 0x25054, printed page 10-166, `hi3518ev200--Hi3518EV20X-Hi3516CV200-Datasheet.txt` line 68820).";

        field {
            name = "line_mad_fac_3_rb";
            desc = "R/B point detection parameter";
            sw = rw;
            hw = r;
            reset = 0x0;
        } line_mad_fac_3_rb[13:8];

        field {
            name = "line_mad_fac_3_g";
            desc = "G point detection parameter";
            sw = rw;
            hw = r;
            reset = 0x0;
        } line_mad_fac_3_g[5:0];
    } ISP_DPC_LINE_MAD_FAC_3 @ 0x5054;

    reg {
        name = "Peak gradient parameter 3 register";
        desc = "ISP_DPC_PG_FAC_3 is a peak gradient parameter 3 register.

Data sheet 10.6 ISP_DPC_PG_FAC_3 (offset 0x25058, printed page 10-166, `hi3518ev200--Hi3518EV20X-Hi3516CV200-Datasheet.txt` line 68845).";

        field {
            name = "pg_fac_3_rb";
            desc = "R/B point detection parameter";
            sw = rw;
            hw = r;
            reset = 0x0;
        } pg_fac_3_rb[13:8];

        field {
            name = "pg_fac_3_g";
            desc = "G point detection parameter";
            sw = rw;
            hw = r;
            reset = 0x0;
        } pg_fac_3_g[5:0];
    } ISP_DPC_PG_FAC_3 @ 0x5058;

    reg {
        name = "Adjacent difference value sorting 3 parameter 3 register";
        desc = "ISP_DPC_RND_THRESH_3 is an adjacent difference value sorting parameter 3 register.

Data sheet 10.6 ISP_DPC_RND_THRESH_3 (offset 0x2505C, printed page 10-167, `hi3518ev200--Hi3518EV20X-Hi3516CV200-Datasheet.txt` line 68880).";

        field {
            name = "rnd_thr3_rb";
            desc = "R/B point detection parameter";
            sw = rw;
            hw = r;
            reset = 0x0;
        } rnd_thr3_rb[15:8];

        field {
            name = "rnd_thr3_g";
            desc = "G point detection parameter";
            sw = rw;
            hw = r;
            reset = 0x0;
        } rnd_thr3_g[7:0];
    } ISP_DPC_RND_THRESH_3 @ 0x505C;

    reg {
        name = "Gradient sorting parameter 3 register";
        desc = "ISP_DPC_RG_FAC_3 is a gradient sorting parameter 3 register.

Data sheet 10.6 ISP_DPC_RG_FAC_3 (offset 0x25060, printed page 10-167, `hi3518ev200--Hi3518EV20X-Hi3516CV200-Datasheet.txt` line 68901).";

        field {
            name = "rg_fac_3_rb";
            desc = "R/B point detection parameter";
            sw = rw;
            hw = r;
            reset = 0x0;
        } rg_fac_3_rb[13:8];

        field {
            name = "rg_fac_3_g";
            desc = "G point detection parameter";
            sw = rw;
            hw = r;
            reset = 0x0;
        } rg_fac_3_g[5:0];
    } ISP_DPC_RG_FAC_3 @ 0x5060;

    reg {
        name = "Sorting parameter 3 register";
        desc = "ISP_DPC_RO_LIMITS is a sorting parameter 3 register.

Data sheet 10.6 ISP_DPC_RO_LIMITS (offset 0x25064, printed page 10-168, `hi3518ev200--Hi3518EV20X-Hi3516CV200-Datasheet.txt` line 68935).";

        field {
            name = "ro_3_rb";
            desc = "R/B point detection parameter";
            sw = rw;
            hw = r;
            reset = 0x0;
        } ro_3_rb[11:10];

        field {
            name = "ro_3_g";
            desc = "G point detection parameter";
            sw = rw;
            hw = r;
            reset = 0x0;
        } ro_3_g[9:8];

        field {
            name = "ro_2_rb";
            desc = "R/B point detection parameter";
            sw = rw;
            hw = r;
            reset = 0x0;
        } ro_2_rb[7:6];

        field {
            name = "ro_2_g";
            desc = "G point detection parameter";
            sw = rw;
            hw = r;
            reset = 0x0;
        } ro_2_g[5:4];

        field {
            name = "ro_1_rb";
            desc = "R/B point detection parameter";
            sw = rw;
            hw = r;
            reset = 0x0;
        } ro_1_rb[3:2];

        field {
            name = "ro_1_g";
            desc = "G point detection parameter";
            sw = rw;
            hw = r;
            reset = 0x0;
        } ro_1_g[1:0];
    } ISP_DPC_RO_LIMITS @ 0x5064;

    reg {
        name = "Adjacent difference value sorting parameter 3 register";
        desc = "ISP_DPC_RND_OFFS is an adjacent difference value sorting parameter 3 register.

Data sheet 10.6 ISP_DPC_RND_OFFS (offset 0x25068, printed page 10-168, `hi3518ev200--Hi3518EV20X-Hi3516CV200-Datasheet.txt` line 68962).";

        field {
            name = "rnd_offs_3_rb";
            desc = "R/B point detection parameter";
            sw = rw;
            hw = r;
            reset = 0x0;
        } rnd_offs_3_rb[11:10];

        field {
            name = "rnd_offs_3_g";
            desc = "G point detection parameter";
            sw = rw;
            hw = r;
            reset = 0x0;
        } rnd_offs_3_g[9:8];

        field {
            name = "rnd_offs_2_rb";
            desc = "R/B point detection parameter";
            sw = rw;
            hw = r;
            reset = 0x0;
        } rnd_offs_2_rb[7:6];

        field {
            name = "rnd_offs_2_g";
            desc = "G point detection parameter";
            sw = rw;
            hw = r;
            reset = 0x0;
        } rnd_offs_2_g[5:4];

        field {
            name = "rnd_offs_1_rb";
            desc = "R/B point detection parameter";
            sw = rw;
            hw = r;
            reset = 0x0;
        } rnd_offs_1_rb[3:2];

        field {
            name = "rnd_offs_1_g";
            desc = "G point detection parameter";
            sw = rw;
            hw = r;
            reset = 0x0;
        } rnd_offs_1_g[1:0];
    } ISP_DPC_RND_OFFS @ 0x5068;

    reg {
        name = "Defect pixel table control register";
        desc = "ISP_DPC_BPT_CTRL is a defect pixel table control register.

Data sheet 10.6 ISP_DPC_BPT_CTRL (offset 0x2506C, printed page 10-169, `hi3518ev200--Hi3518EV20X-Hi3516CV200-Datasheet.txt` line 69003).";

        field {
            name = "bp_data";
            desc = "Defect pixel highlight value";
            sw = rw;
            hw = r;
            reset = 0x0;
        } bp_data[31:16];

        enum ISP_DPC_BPT_CTRL_rb_3x3_enum {
            NO = 0 { name = "No"; desc = "no"; };
            YES = 1 { name = "Yes"; desc = "yes"; };
        };

        field {
            name = "rb_3x3";
            desc = "Whether the R/B point correction uses the 9-point median";
            sw = rw;
            hw = r;
            encode = ISP_DPC_BPT_CTRL_rb_3x3_enum;
            reset = 0x0;
        } rb_3x3[11:11];

        enum ISP_DPC_BPT_CTRL_g_3x3_enum {
            NO = 0 { name = "No"; desc = "no"; };
            YES = 1 { name = "Yes"; desc = "yes"; };
        };

        field {
            name = "g_3x3";
            desc = "Whether the G point correction uses the 9-point median";
            sw = rw;
            hw = r;
            encode = ISP_DPC_BPT_CTRL_g_3x3_enum;
            reset = 0x0;
        } g_3x3[10:10];

        enum ISP_DPC_BPT_CTRL_bpt_incl_rb_center_enum {
            NO = 0 { name = "No"; desc = "no"; };
            YES = 1 { name = "Yes"; desc = "yes"; };
        };

        field {
            name = "bpt_incl_rb_center";
            desc = "Whether the R/B point correction contains the central point";
            sw = rw;
            hw = r;
            encode = ISP_DPC_BPT_CTRL_bpt_incl_rb_center_enum;
            reset = 0x0;
        } bpt_incl_rb_center[9:9];

        enum ISP_DPC_BPT_CTRL_bpt_incl_green_center_enum {
            NO = 0 { name = "No"; desc = "no"; };
            YES = 1 { name = "Yes"; desc = "yes"; };
        };

        field {
            name = "bpt_incl_green_center";
            desc = "Whether the G point correction contains the central point";
            sw = rw;
            hw = r;
            encode = ISP_DPC_BPT_CTRL_bpt_incl_green_center_enum;
            reset = 0x0;
        } bpt_incl_green_center[8:8];

        enum ISP_DPC_BPT_CTRL_bpt_use_fix_set_enum {
            NO = 0 { name = "No"; desc = "no"; };
            YES = 1 { name = "Yes"; desc = "yes"; };
        };

        field {
            name = "bpt_use_fix_set";
            desc = "Whether other detection levels are valid";
            sw = rw;
            hw = r;
            encode = ISP_DPC_BPT_CTRL_bpt_use_fix_set_enum;
            reset = 0x0;
        } bpt_use_fix_set[7:7];

        enum ISP_DPC_BPT_CTRL_bpt_use_set_3_enum {
            NO = 0 { name = "No"; desc = "no"; };
            YES = 1 { name = "Yes"; desc = "yes"; };
        };

        field {
            name = "bpt_use_set_3";
            desc = "Whether detection level 3 is valid";
            sw = rw;
            hw = r;
            encode = ISP_DPC_BPT_CTRL_bpt_use_set_3_enum;
            reset = 0x0;
        } bpt_use_set_3[6:6];

        enum ISP_DPC_BPT_CTRL_bpt_use_set_2_enum {
            NO = 0 { name = "No"; desc = "no"; };
            YES = 1 { name = "Yes"; desc = "yes"; };
        };

        field {
            name = "bpt_use_set_2";
            desc = "Whether detection level 2 is valid";
            sw = rw;
            hw = r;
            encode = ISP_DPC_BPT_CTRL_bpt_use_set_2_enum;
            reset = 0x0;
        } bpt_use_set_2[5:5];

        enum ISP_DPC_BPT_CTRL_bpt_use_set_1_enum {
            NO = 0 { name = "No"; desc = "no"; };
            YES = 1 { name = "Yes"; desc = "yes"; };
        };

        field {
            name = "bpt_use_set_1";
            desc = "Whether detection level 1 is valid";
            sw = rw;
            hw = r;
            encode = ISP_DPC_BPT_CTRL_bpt_use_set_1_enum;
            reset = 0x0;
        } bpt_use_set_1[4:4];
    } ISP_DPC_BPT_CTRL @ 0x506C;

    reg {
        name = "Defect pixel number register";
        desc = "ISP_DPC_BPT_NUMBER is a defect pixel number register.

Data sheet 10.6 ISP_DPC_BPT_NUMBER (offset 0x25070, printed page 10-170, `hi3518ev200--Hi3518EV20X-Hi3516CV200-Datasheet.txt` line 69068).";

        field {
            name = "bpt_number";
            desc = "Number of defect pixels. The value range is 0-2048.";
            sw = rw;
            hw = r;
            reset = 0x0;
        } bpt_number[11:0];
    } ISP_DPC_BPT_NUMBER @ 0x5070;

    reg {
        name = "Calibrated defect pixel number MBER register";
        desc = "ISP_DPC_BPT_CALIB_NUMBER is a calibrated defect pixel number register.

Data sheet 10.6 ISP_DPC_BPT_CALIB_NUMBER (offset 0x25074, printed page 10-171, `hi3518ev200--Hi3518EV20X-Hi3516CV200-Datasheet.txt` line 69096).";

        field {
            name = "bpt_calib_number";
            desc = "Number of calibrated defect pixels. The value range is 0-2048.";
            sw = r;
            hw = w;
            reset = 0x0;
        } bpt_calib_number[11:0];
    } ISP_DPC_BPT_CALIB_NUMBER @ 0x5074;

    reg {
        name = "Calibrated defect pixel parameter register";
        desc = "ISP_DPC_BPT_THRD is a calibrated defect pixel parameter register.

Data sheet 10.6 ISP_DPC_BPT_THRD (offset 0x2507C, printed page 10-171, `hi3518ev200--Hi3518EV20X-Hi3516CV200-Datasheet.txt` line 69116).";

        field {
            name = "abs_hot_thresh";
            desc = "abs_hot_thresh";
            sw = rw;
            hw = r;
            reset = 0x0;
        } abs_hot_thresh[31:24];

        field {
            name = "dev_hot_thresh";
            desc = "dev_hot_thresh";
            sw = rw;
            hw = r;
            reset = 0x0;
        } dev_hot_thresh[23:16];

        field {
            name = "abs_dead_thresh";
            desc = "abs_dead_thresh";
            sw = rw;
            hw = r;
            reset = 0x0;
        } abs_dead_thresh[15:8];

        field {
            name = "dev_dead_thresh";
            desc = "dev_dead_thresh";
            sw = rw;
            hw = r;
            reset = 0x0;
        } dev_dead_thresh[7:0];
    } ISP_DPC_BPT_THRD @ 0x507C;

    reg {
        name = "Defect pixel table write address register";
        desc = "ISP_DPC_BPT_WADDR is a defect pixel table write address register.

Data sheet 10.6 ISP_DPC_BPT_WADDR (offset 0x25080, printed page 10-172, `hi3518ev200--Hi3518EV20X-Hi3516CV200-Datasheet.txt` line 69159).";

        field {
            name = "bpt_waddr";
            desc = "Write address of the defect pixel table (bit [10:0])";
            sw = rw;
            hw = r;
            reset = 0x0;
        } bpt_waddr[31:0];
    } ISP_DPC_BPT_WADDR @ 0x5080;

    reg {
        name = "Defect pixel table write data register";
        desc = "ISP_DPC_BPT_WDATA is a defect pixel table write data register.

Data sheet 10.6 ISP_DPC_BPT_WDATA (offset 0x25084, printed page 10-172, `hi3518ev200--Hi3518EV20X-Hi3516CV200-Datasheet.txt` line 69178).";

        field {
            name = "bpt_wdata";
            desc = "Write data of the defect pixel table. Bit [24:0] indicate the defect pixel coordinate.";
            sw = rw;
            hw = r;
            reset = 0x0;
        } bpt_wdata[31:0];
    } ISP_DPC_BPT_WDATA @ 0x5084;

    reg {
        name = "Defect pixel table read address register";
        desc = "ISP_DPC_BPT_RADDR is a defect pixel table read address register.

Data sheet 10.6 ISP_DPC_BPT_RADDR (offset 0x25088, printed page 10-172, `hi3518ev200--Hi3518EV20X-Hi3516CV200-Datasheet.txt` line 69198).";

        field {
            name = "bpt_raddr";
            desc = "Read address of the defect pixel table (bit [10:0])";
            sw = rw;
            hw = r;
            reset = 0x0;
        } bpt_raddr[31:0];
    } ISP_DPC_BPT_RADDR @ 0x5088;

    reg {
        name = "Defect pixel table read data register";
        desc = "ISP_DPC_BPT_RDATA is a defect pixel table read data register.

Data sheet 10.6 ISP_DPC_BPT_RDATA (offset 0x2508C, printed page 10-173, `hi3518ev200--Hi3518EV20X-Hi3516CV200-Datasheet.txt` line 69222).";

        field {
            name = "bpt_rdata";
            desc = "Read data of the defect pixel table. Bit [24:0] indicate the defect pixel coordinate.";
            sw = rw;
            hw = r;
            reset = 0x0;
        } bpt_rdata[31:0];
    } ISP_DPC_BPT_RDATA @ 0x508C;

    reg {
        name = "GE control register";
        desc = "ISP_GE_CFG is a GE control register.

Data sheet 10.6 ISP_GE_CFG (offset 0x25100, printed page 10-173, `hi3518ev200--Hi3518EV20X-Hi3516CV200-Datasheet.txt` line 69243).";

        enum ISP_GE_CFG_isp_ge_enum {
            DISABLED = 0 { name = "Disabled"; desc = "disabled"; };
            ENABLED = 1 { name = "Enabled"; desc = "enabled"; };
        };

        field {
            name = "isp_ge";
            desc = "GE correction enable";
            sw = rw;
            hw = r;
            encode = ISP_GE_CFG_isp_ge_enum;
            reset = 0x0;
        } isp_ge[8:8];

        enum ISP_GE_CFG_isp_ge_aver_enum {
            DISABLED = 0 { name = "Disabled"; desc = "disabled"; };
            ENABLED = 1 { name = "Enabled"; desc = "enabled"; };
        };

        field {
            name = "isp_ge_aver";
            desc = "GE_AVER enable";
            sw = rw;
            hw = r;
            encode = ISP_GE_CFG_isp_ge_aver_enum;
            reset = 0x0;
        } isp_ge_aver[4:4];

        enum ISP_GE_CFG_en_enum {
            DISABLED = 0 { name = "Disabled"; desc = "disabled"; };
            ENABLED = 1 { name = "Enabled"; desc = "enabled"; };
        };

        field {
            name = "en";
            desc = "GE enable";
            sw = rw;
            hw = r;
            encode = ISP_GE_CFG_en_enum;
            reset = 0x0;
        } en[0:0];
    } ISP_GE_CFG @ 0x5100;

    reg {
        name = "GE configuration register";
        desc = "ISP_GE_CT_TH1 is a GE configuration register.

Data sheet 10.6 ISP_GE_CT_TH1 (offset 0x25110, printed page 10-174, `hi3518ev200--Hi3518EV20X-Hi3516CV200-Datasheet.txt` line 69290).";

        field {
            name = "ct_th1";
            desc = "Threshold";
            sw = rw;
            hw = r;
            reset = 0x0;
        } ct_th1[13:0];
    } ISP_GE_CT_TH1 @ 0x5110;

    reg {
        name = "GE configuration register";
        desc = "ISP_GE_CT_TH2 is a GE configuration register.

Data sheet 10.6 ISP_GE_CT_TH2 (offset 0x25114, printed page 10-174, `hi3518ev200--Hi3518EV20X-Hi3516CV200-Datasheet.txt` line 69310).";

        field {
            name = "ct_th2";
            desc = "Threshold";
            sw = rw;
            hw = r;
            reset = 0x0;
        } ct_th2[13:0];
    } ISP_GE_CT_TH2 @ 0x5114;

    reg {
        name = "GE configuration register";
        desc = "ISP_GE_CT_TH3 is a GE configuration register.

Data sheet 10.6 ISP_GE_CT_TH3 (offset 0x25118, printed page 10-175, `hi3518ev200--Hi3518EV20X-Hi3516CV200-Datasheet.txt` line 69339).";

        field {
            name = "ct_th3";
            desc = "Threshold";
            sw = rw;
            hw = r;
            reset = 0x0;
        } ct_th3[13:0];
    } ISP_GE_CT_TH3 @ 0x5118;

    reg {
        name = "GE configuration register";
        desc = "ISP_GE_CT_SLOPE1 is a GE configuration register.

Data sheet 10.6 ISP_GE_CT_SLOPE1 (offset 0x2511C, printed page 10-175, `hi3518ev200--Hi3518EV20X-Hi3516CV200-Datasheet.txt` line 69359).";

        enum ISP_GE_CT_SLOPE1_ct_slope1_enum {
            V_1 = 0 { name = "V 1"; desc = "1"; };
            V_2 = 1 { name = "V 2"; desc = "2"; };
            V_4 = 2 { name = "V 4"; desc = "4"; };
            V_8_THIS_FIELD = 3 { name = "V 8 This Field"; desc = "8 … This field can be set to 14 at most, and the value 14 indicates 2 ."; };
        };

        field {
            name = "ct_slope1";
            desc = "ct_slope1";
            sw = rw;
            hw = r;
            encode = ISP_GE_CT_SLOPE1_ct_slope1_enum;
            reset = 0x0;
        } ct_slope1[3:0];
    } ISP_GE_CT_SLOPE1 @ 0x511C;

    reg {
        name = "GE configuration register";
        desc = "ISP_GE_CT_SLOPE2 is a GE configuration register.

Data sheet 10.6 ISP_GE_CT_SLOPE2 (offset 0x25120, printed page 10-176, `hi3518ev200--Hi3518EV20X-Hi3516CV200-Datasheet.txt` line 69393).";

        enum ISP_GE_CT_SLOPE2_ct_slope2_enum {
            V_1 = 0 { name = "V 1"; desc = "1"; };
            V_2 = 1 { name = "V 2"; desc = "2"; };
            V_4 = 2 { name = "V 4"; desc = "4"; };
            V_8_THIS_FIELD = 3 { name = "V 8 This Field"; desc = "8 … This field can be set to 14 at most, and the value 14 indicates 2 ."; };
        };

        field {
            name = "ct_slope2";
            desc = "ct_slope2";
            sw = rw;
            hw = r;
            encode = ISP_GE_CT_SLOPE2_ct_slope2_enum;
            reset = 0x0;
        } ct_slope2[3:0];
    } ISP_GE_CT_SLOPE2 @ 0x5120;

    reg {
        name = "GE block configuration register";
        desc = "ISP_GE_ZONE is a GE block configuration register.

Data sheet 10.6 ISP_GE_ZONE (offset 0x25130, printed page 10-176, `hi3518ev200--Hi3518EV20X-Hi3516CV200-Datasheet.txt` line 69419).";

        field {
            name = "vnum";
            desc = "Number of vertical blocks";
            sw = rw;
            hw = r;
            reset = 0x0;
        } vnum[12:8];

        field {
            name = "hnum";
            desc = "Number of horizontal blocks";
            sw = rw;
            hw = r;
            reset = 0x0;
        } hnum[4:0];
    } ISP_GE_ZONE @ 0x5130;

    reg {
        name = "GE average value statistics read DDR address register";
        desc = "ISP_GE_MEM_AVER_RADDR is a GE average value statistics read address register.

Data sheet 10.6 ISP_GE_MEM_AVER_RADDR (offset 0x25188, printed page 10-177, `hi3518ev200--Hi3518EV20X-Hi3516CV200-Datasheet.txt` line 69454).";

        field {
            name = "aver_raddr";
            desc = "Read address of the average value statistics";
            sw = rw;
            hw = r;
            reset = 0x0;
        } aver_raddr[31:0];
    } ISP_GE_MEM_AVER_RADDR @ 0x5188;

    reg {
        name = "GE average value statistics read data ATA register";
        desc = "ISP_GE_MEM_AVER_RDATA is a GE average value statistics read data register.

Data sheet 10.6 ISP_GE_MEM_AVER_RDATA (offset 0x2518C, printed page 10-177, `hi3518ev200--Hi3518EV20X-Hi3516CV200-Datasheet.txt` line 69473).";

        field {
            name = "aver_rdata";
            desc = "Read data of the average value statistics";
            sw = r;
            hw = w;
            reset = 0x0;
        } aver_rdata[31:0];
    } ISP_GE_MEM_AVER_RDATA @ 0x518C;

    reg {
        name = "FPN configuration register";
        desc = "ISP_FPN_CFG is an FPN configuration register.

Data sheet 10.6 ISP_FPN_CFG (offset 0x25200, printed page 10-177, `hi3518ev200--Hi3518EV20X-Hi3516CV200-Datasheet.txt` line 69491).";

        enum ISP_FPN_CFG_line_frame_enum {
            FRAME_MODE = 0 { name = "Frame Mode"; desc = "frame mode"; };
            LINE_MODE = 1 { name = "Line Mode"; desc = "line mode"; };
        };

        field {
            name = "line_frame";
            desc = "FPN frame/line mode";
            sw = rw;
            hw = r;
            encode = ISP_FPN_CFG_line_frame_enum;
            reset = 0x0;
        } line_frame[9:9];

        enum ISP_FPN_CFG_calib_corr_enum {
            CORRECTION_MODE = 0 { name = "Correction Mode"; desc = "correction mode"; };
            CALIBRATION_MODE = 1 { name = "Calibration Mode"; desc = "calibration mode"; };
        };

        field {
            name = "calib_corr";
            desc = "FPN correction/calibration mode";
            sw = rw;
            hw = r;
            encode = ISP_FPN_CFG_calib_corr_enum;
            reset = 0x0;
        } calib_corr[8:8];

        enum ISP_FPN_CFG_enable_f_enum {
            DISABLED = 0 { name = "Disabled"; desc = "disabled"; };
            ENABLED = 1 { name = "Enabled"; desc = "enabled"; };
        };

        field {
            name = "enable";
            desc = "FPN enable";
            sw = rw;
            hw = r;
            encode = ISP_FPN_CFG_enable_f_enum;
            reset = 0x0;
        } enable_f[0:0];
    } ISP_FPN_CFG @ 0x5200;

    reg {
        name = "FPN calibration start signal register";
        desc = "ISP_FPN_CALIB_START is an FPN calibration start signal register.

Data sheet 10.6 ISP_FPN_CALIB_START (offset 0x25204, printed page 10-178, `hi3518ev200--Hi3518EV20X-Hi3516CV200-Datasheet.txt` line 69536).";

        field {
            name = "calib_start";
            desc = "FPN calibration start. This bit is automatically cleared.";
            sw = rw;
            hw = r;
            reset = 0x0;
        } calib_start[0:0];
    } ISP_FPN_CALIB_START @ 0x5204;

    reg {
        name = "FPN correction enable register";
        desc = "ISP_FPN_CORR_CFG is an FPN correction enable register.

Data sheet 10.6 ISP_FPN_CORR_CFG (offset 0x25208, printed page 10-179, `hi3518ev200--Hi3518EV20X-Hi3516CV200-Datasheet.txt` line 69571).";

        enum ISP_FPN_CORR_CFG_correct3_en_enum {
            DISABLED = 0 { name = "Disabled"; desc = "disabled"; };
            ENABLED = 1 { name = "Enabled"; desc = "enabled"; };
        };

        field {
            name = "correct3_en";
            desc = "FPN correction enable for channel 3";
            sw = rw;
            hw = r;
            encode = ISP_FPN_CORR_CFG_correct3_en_enum;
            reset = 0x1;
        } correct3_en[3:3];

        enum ISP_FPN_CORR_CFG_correct2_en_enum {
            DISABLED = 0 { name = "Disabled"; desc = "disabled"; };
            ENABLED = 1 { name = "Enabled"; desc = "enabled"; };
        };

        field {
            name = "correct2_en";
            desc = "FPN correction enable for channel 2";
            sw = rw;
            hw = r;
            encode = ISP_FPN_CORR_CFG_correct2_en_enum;
            reset = 0x1;
        } correct2_en[2:2];

        enum ISP_FPN_CORR_CFG_correct1_en_enum {
            DISABLED = 0 { name = "Disabled"; desc = "disabled"; };
            ENABLED = 1 { name = "Enabled"; desc = "enabled"; };
        };

        field {
            name = "correct1_en";
            desc = "FPN correction enable for channel 1";
            sw = rw;
            hw = r;
            encode = ISP_FPN_CORR_CFG_correct1_en_enum;
            reset = 0x1;
        } correct1_en[1:1];

        enum ISP_FPN_CORR_CFG_correct0_en_enum {
            DISABLED = 0 { name = "Disabled"; desc = "disabled"; };
            ENABLED = 1 { name = "Enabled"; desc = "enabled"; };
        };

        field {
            name = "correct0_en";
            desc = "FPN correction enable for channel 0";
            sw = rw;
            hw = r;
            encode = ISP_FPN_CORR_CFG_correct0_en_enum;
            reset = 0x1;
        } correct0_en[0:0];
    } ISP_FPN_CORR_CFG @ 0x5208;

    reg {
        name = "FPN calibration status register";
        desc = "ISP_FPN_STAT is an FPN calibration status register.

Data sheet 10.6 ISP_FPN_STAT (offset 0x2520C, printed page 10-180, `hi3518ev200--Hi3518EV20X-Hi3516CV200-Datasheet.txt` line 69617).";

        field {
            name = "hcnt";
            desc = "Number of lines";
            sw = r;
            hw = w;
            reset = 0x1FFF;
        } hcnt[28:16];

        field {
            name = "vcnt";
            desc = "Number of calibrated frames";
            sw = r;
            hw = w;
            reset = 0x0;
        } vcnt[13:8];

        enum ISP_FPN_STAT_busy_enum {
            IDLE = 0 { name = "Idle"; desc = "idle"; };
            BEING_CALIBRATED = 1 { name = "Being Calibrated"; desc = "being calibrated"; };
        };

        field {
            name = "busy";
            desc = "FPN calibration status";
            sw = r;
            hw = w;
            encode = ISP_FPN_STAT_busy_enum;
            reset = 0x0;
        } busy[0:0];
    } ISP_FPN_STAT @ 0x520C;

    reg {
        name = "FPN calibration white point configuration register";
        desc = "ISP_FPN_WHITE_LEVEL is an FPN calibration white point configuration register.

Data sheet 10.6 ISP_FPN_WHITE_LEVEL (offset 0x25210, printed page 10-180, `hi3518ev200--Hi3518EV20X-Hi3516CV200-Datasheet.txt` line 69646).";

        field {
            name = "white_level";
            desc = "FPN calibration white point configuration";
            sw = rw;
            hw = r;
            reset = 0x0;
        } white_level[13:0];
    } ISP_FPN_WHITE_LEVEL @ 0x5210;

    reg {
        name = "FPN calibration division coefficient register";
        desc = "ISP_FPN_DIVCOEF is an FPN calibration division coefficient register.

Data sheet 10.6 ISP_FPN_DIVCOEF (offset 0x25218, printed page 10-181, `hi3518ev200--Hi3518EV20X-Hi3516CV200-Datasheet.txt` line 69675).";

        field {
            name = "divcoef";
            desc = "FPN calibration division coefficient";
            sw = rw;
            hw = r;
            reset = 0x0;
        } divcoef[11:0];
    } ISP_FPN_DIVCOEF @ 0x5218;

    reg {
        name = "FPN calibrated frame number register";
        desc = "ISP_FPN_FRAMELOG2 is an FPN calibrated frame number register.

Data sheet 10.6 ISP_FPN_FRAMELOG2 (offset 0x2521C, printed page 10-181, `hi3518ev200--Hi3518EV20X-Hi3516CV200-Datasheet.txt` line 69695).";

        field {
            name = "cpi_fpn_framelog2";
            desc = "Number of FPN calibrated frames. The configured value is obtained by taking the logarithm of the number of frames to 2.";
            sw = rw;
            hw = r;
            reset = 0x0;
        } cpi_fpn_framelog2[2:0];
    } ISP_FPN_FRAMELOG2 @ 0x521C;

    reg {
        name = "FPN calibration accumulated sum low bits register";
        desc = "ISP_FPN_SUM0 is an FPN calibration accumulated sum lower bits register.

Data sheet 10.6 ISP_FPN_SUM0 (offset 0x25220, printed page 10-182, `hi3518ev200--Hi3518EV20X-Hi3516CV200-Datasheet.txt` line 69732).";

        field {
            name = "sum";
            desc = "Lower bits of the FPN calibration accumulated sum";
            sw = r;
            hw = w;
            reset = 0x0;
        } sum[31:0];
    } ISP_FPN_SUM0 @ 0x5220;

    reg {
        name = "FPN calibration accumulated sum upper bits register";
        desc = "ISP_FPN_SUM1 is an FPN calibration accumulated sum upper bits register.

Data sheet 10.6 ISP_FPN_SUM1 (offset 0x25224, printed page 10-182, `hi3518ev200--Hi3518EV20X-Hi3516CV200-Datasheet.txt` line 69751).";

        field {
            name = "sum";
            desc = "Upper bits of the FPN calibration accumulated sum";
            sw = r;
            hw = w;
            reset = 0x0;
        } sum[31:0];
    } ISP_FPN_SUM1 @ 0x5224;

    reg {
        name = "FPN correction configuration register 0";
        desc = "ISP_FPN_CORR0 is FPN correction configuration register 0.

Data sheet 10.6 ISP_FPN_CORR0 (offset 0x25230, printed page 10-182, `hi3518ev200--Hi3518EV20X-Hi3516CV200-Datasheet.txt` line 69769).";

        field {
            name = "strength";
            desc = "FPN correction strength, U8.8";
            sw = rw;
            hw = r;
            reset = 0x0;
        } strength[31:16];

        field {
            name = "offset";
            desc = "FPN correction bias";
            sw = rw;
            hw = r;
            reset = 0x0;
        } offset[11:0];
    } ISP_FPN_CORR0 @ 0x5230;

    reg {
        name = "FPN correction configuration register 1";
        desc = "ISP_FPN_CORR1 is FPN correction configuration register 1.

Data sheet 10.6 ISP_FPN_CORR1 (offset 0x25234, printed page 10-183, `hi3518ev200--Hi3518EV20X-Hi3516CV200-Datasheet.txt` line 69796).";

        field {
            name = "strength";
            desc = "FPN correction strength, U8.8";
            sw = rw;
            hw = r;
            reset = 0x0;
        } strength[31:16];

        field {
            name = "offset";
            desc = "FPN correction bias";
            sw = rw;
            hw = r;
            reset = 0x0;
        } offset[11:0];
    } ISP_FPN_CORR1 @ 0x5234;

    reg {
        name = "FPN correction configuration register 2";
        desc = "ISP_FPN_CORR2 is FPN correction configuration register 2.

Data sheet 10.6 ISP_FPN_CORR2 (offset 0x25238, printed page 10-183, `hi3518ev200--Hi3518EV20X-Hi3516CV200-Datasheet.txt` line 69817).";

        field {
            name = "strength";
            desc = "FPN correction strength, U8.8";
            sw = rw;
            hw = r;
            reset = 0x0;
        } strength[31:16];

        field {
            name = "offset";
            desc = "FPN correction bias";
            sw = rw;
            hw = r;
            reset = 0x0;
        } offset[11:0];
    } ISP_FPN_CORR2 @ 0x5238;

    reg {
        name = "FPN correction configuration register 3";
        desc = "ISP_FPN_CORR3 is FPN correction configuration register 3.

Data sheet 10.6 ISP_FPN_CORR3 (offset 0x2523C, printed page 10-184, `hi3518ev200--Hi3518EV20X-Hi3516CV200-Datasheet.txt` line 69846).";

        field {
            name = "strength";
            desc = "FPN correction strength, U8.8";
            sw = rw;
            hw = r;
            reset = 0x0;
        } strength[31:16];

        field {
            name = "offset";
            desc = "FPN correction bias";
            sw = rw;
            hw = r;
            reset = 0x0;
        } offset[11:0];
    } ISP_FPN_CORR3 @ 0x523C;

    reg {
        name = "FPN shift configuration register";
        desc = "ISP_FPN_SHIFT is an FPN shift configuration register.

Data sheet 10.6 ISP_FPN_SHIFT (offset 0x25240, printed page 10-184, `hi3518ev200--Hi3518EV20X-Hi3516CV200-Datasheet.txt` line 69867).";

        field {
            name = "frame_calib_shift";
            desc = "Number of left shift bits for the last output frame during frame calibration";
            sw = rw;
            hw = r;
            reset = 0x0;
        } frame_calib_shift[27:24];

        field {
            name = "out_shift";
            desc = "Number of left shift bits for the output";
            sw = rw;
            hw = r;
            reset = 0x0;
        } out_shift[19:16];

        field {
            name = "in_shift";
            desc = "Number of right shift bits for the input";
            sw = rw;
            hw = r;
            reset = 0x0;
        } in_shift[11:8];

        field {
            name = "fpn_shift";
            desc = "Number of right shift bits for the input FPN";
            sw = rw;
            hw = r;
            reset = 0x0;
        } fpn_shift[3:0];
    } ISP_FPN_SHIFT @ 0x5240;

    reg {
        name = "FPN maximum output value register";
        desc = "ISP_FPN_MAX_O is an FPN maximum output value register.

Data sheet 10.6 ISP_FPN_MAX_O (offset 0x25250, printed page 10-185, `hi3518ev200--Hi3518EV20X-Hi3516CV200-Datasheet.txt` line 69905).";

        field {
            name = "max_o";
            desc = "Maximum value of the FPN output";
            sw = rw;
            hw = r;
            reset = 0x3FFF;
        } max_o[15:0];
    } ISP_FPN_MAX_O @ 0x5250;

    reg {
        name = "FPN correction threshold register R";
        desc = "ISP_FPN_OVERFLOWTHR is an FPN correction threshold register.

Data sheet 10.6 ISP_FPN_OVERFLOWTHR (offset 0x25254, printed page 10-185, `hi3518ev200--Hi3518EV20X-Hi3516CV200-Datasheet.txt` line 69925).";

        field {
            name = "overflowthr";
            desc = "FPN correction threshold";
            sw = rw;
            hw = r;
            reset = 0x3FFF;
        } overflowthr[13:0];
    } ISP_FPN_OVERFLOWTHR @ 0x5254;

    reg {
        name = "FPN line mode black line write address register";
        desc = "ISP_FPN_LINE_WADDR is an FPN line mode black line write address register.

Data sheet 10.6 ISP_FPN_LINE_WADDR (offset 0x25280, printed page 10-185, `hi3518ev200--Hi3518EV20X-Hi3516CV200-Datasheet.txt` line 69944).";

        field {
            name = "fpn_line_waddr";
            desc = "Write address of the black line in FPN line mode";
            sw = rw;
            hw = r;
            reset = 0x0;
        } fpn_line_waddr[31:0];
    } ISP_FPN_LINE_WADDR @ 0x5280;

    reg {
        name = "FPN line mode black line write data register";
        desc = "ISP_FPN_LINE_WDATA is an FPN line mode black line write data register.

Data sheet 10.6 ISP_FPN_LINE_WDATA (offset 0x25284, printed page 10-186, `hi3518ev200--Hi3518EV20X-Hi3516CV200-Datasheet.txt` line 69969).";

        field {
            name = "fpn_line_wdata";
            desc = "Write data of the black line in FPN line mode";
            sw = rw;
            hw = r;
            reset = 0x0;
        } fpn_line_wdata[31:0];
    } ISP_FPN_LINE_WDATA @ 0x5284;

    reg {
        name = "FPN line mode black line read address register";
        desc = "ISP_FPN_LINE_RADDR is an FPN line mode black line read address register.

Data sheet 10.6 ISP_FPN_LINE_RADDR (offset 0x25288, printed page 10-186, `hi3518ev200--Hi3518EV20X-Hi3516CV200-Datasheet.txt` line 69988).";

        field {
            name = "fpn_line_raddr";
            desc = "Read address of the black line in FPN line mode";
            sw = rw;
            hw = r;
            reset = 0x0;
        } fpn_line_raddr[31:0];
    } ISP_FPN_LINE_RADDR @ 0x5288;

    reg {
        name = "FPN line mode black line read data register";
        desc = "ISP_FPN_LINE_RDATA is an FPN line mode black line read data register.

Data sheet 10.6 ISP_FPN_LINE_RDATA (offset 0x2528C, printed page 10-186, `hi3518ev200--Hi3518EV20X-Hi3516CV200-Datasheet.txt` line 70006).";

        field {
            name = "fpn_line_rdata";
            desc = "Read data of the black line in FPN line mode";
            sw = rw;
            hw = r;
            reset = 0x0;
        } fpn_line_rdata[31:0];
    } ISP_FPN_LINE_RDATA @ 0x528C;

    reg {
        name = "LSC enable register";
        desc = "ISP_LSC_CFG is an LSC enable register.

Data sheet 10.6 ISP_LSC_CFG (offset 0x25800, printed page 10-187, `hi3518ev200--Hi3518EV20X-Hi3516CV200-Datasheet.txt` line 70031).";

        enum ISP_LSC_CFG_en_enum {
            DISABLED = 0 { name = "Disabled"; desc = "disabled"; };
            ENABLED = 1 { name = "Enabled"; desc = "enabled"; };
        };

        field {
            name = "en";
            desc = "LSC enable";
            sw = rw;
            hw = r;
            encode = ISP_LSC_CFG_en_enum;
            reset = 0x0;
        } en[0:0];
    } ISP_LSC_CFG @ 0x5800;

    reg {
        name = "LSC picture segmentation window quantity configuration register";
        desc = "ISP_LSC_WINNUM is an LSC picture segmentation window quantity configuration register.

Data sheet 10.6 ISP_LSC_WINNUM (offset 0x25810, printed page 10-187, `hi3518ev200--Hi3518EV20X-Hi3516CV200-Datasheet.txt` line 70053).";

        field {
            name = "numv";
            desc = "Number of windows obtained after the picture is vertically segmented. The configured value is the actual value minus 1.";
            sw = rw;
            hw = r;
            reset = 0x0;
        } numv[20:16];

        field {
            name = "numh";
            desc = "Number of windows obtained after the picture is horizontally segmented. The configured value is the actual value minus 1.";
            sw = rw;
            hw = r;
            reset = 0x0;
        } numh[4:0];
    } ISP_LSC_WINNUM @ 0x5810;

    reg {
        name = "LSC interpolation horizontal first window width information register";
        desc = "ISP_LSC_WINX1 is an LSC interpolation horizontal first window width information register.

Data sheet 10.6 ISP_LSC_WINX1 (offset 0x25814, printed page 10-188, `hi3518ev200--Hi3518EV20X-Hi3516CV200-Datasheet.txt` line 70087).";

        field {
            name = "invx1";
            desc = "Reciprocal value of the width of the LSC interpolation horizontal first window";
            sw = rw;
            hw = r;
            reset = 0x0;
        } invx1[27:16];

        field {
            name = "deltax1";
            desc = "Width of the LSC interpolation horizontal first window. The configured value is the actual value minus 1.";
            sw = rw;
            hw = r;
            reset = 0x0;
        } deltax1[9:0];
    } ISP_LSC_WINX1 @ 0x5814;

    reg {
        name = "LSC interpolation horizontal second window width information register";
        desc = "ISP_LSC_WINX2 is an LSC interpolation horizontal second window width information register.

Data sheet 10.6 ISP_LSC_WINX2 (offset 0x25818, printed page 10-188, `hi3518ev200--Hi3518EV20X-Hi3516CV200-Datasheet.txt` line 70114).";

        field {
            name = "invx2";
            desc = "Reciprocal value of the width of the LSC interpolation horizontal second window";
            sw = rw;
            hw = r;
            reset = 0x0;
        } invx2[27:16];

        field {
            name = "deltax2";
            desc = "Width of the LSC interpolation horizontal second window";
            sw = rw;
            hw = r;
            reset = 0x0;
        } deltax2[9:0];
    } ISP_LSC_WINX2 @ 0x5818;

    reg {
        name = "LSC interpolation horizontal third window width information register";
        desc = "ISP_LSC_WINX3 is an LSC interpolation horizontal third window width information register.

Data sheet 10.6 ISP_LSC_WINX3 (offset 0x2581C, printed page 10-189, `hi3518ev200--Hi3518EV20X-Hi3516CV200-Datasheet.txt` line 70147).";

        field {
            name = "invx3";
            desc = "Reciprocal value of the width of the LSC interpolation horizontal third window";
            sw = rw;
            hw = r;
            reset = 0x0;
        } invx3[27:16];

        field {
            name = "deltax3";
            desc = "Width of the LSC interpolation horizontal third window";
            sw = rw;
            hw = r;
            reset = 0x0;
        } deltax3[9:0];
    } ISP_LSC_WINX3 @ 0x581C;

    reg {
        name = "LSC interpolation horizontal fourth window width information register";
        desc = "ISP_LSC_WINX4 is an LSC interpolation horizontal fourth window width information register.

Data sheet 10.6 ISP_LSC_WINX4 (offset 0x25820, printed page 10-189, `hi3518ev200--Hi3518EV20X-Hi3516CV200-Datasheet.txt` line 70172).";

        field {
            name = "invx4";
            desc = "Reciprocal value of the width of the LSC interpolation horizontal fourth window";
            sw = rw;
            hw = r;
            reset = 0x0;
        } invx4[27:16];

        field {
            name = "deltax4";
            desc = "Width of the LSC interpolation horizontal fourth window";
            sw = rw;
            hw = r;
            reset = 0x0;
        } deltax4[9:0];
    } ISP_LSC_WINX4 @ 0x5820;

    reg {
        name = "LSC interpolation horizontal fifth window width information register";
        desc = "ISP_LSC_WINX5 is an LSC interpolation horizontal fifth window width information register.

Data sheet 10.6 ISP_LSC_WINX5 (offset 0x25824, printed page 10-190, `hi3518ev200--Hi3518EV20X-Hi3516CV200-Datasheet.txt` line 70205).";

        field {
            name = "invx5";
            desc = "Reciprocal value of the width of the LSC interpolation horizontal fifth window";
            sw = rw;
            hw = r;
            reset = 0x0;
        } invx5[27:16];

        field {
            name = "deltax5";
            desc = "Width of the LSC interpolation horizontal fifth window";
            sw = rw;
            hw = r;
            reset = 0x0;
        } deltax5[9:0];
    } ISP_LSC_WINX5 @ 0x5824;

    reg {
        name = "LSC interpolation horizontal sixth window width information register";
        desc = "ISP_LSC_WINX6 is an LSC interpolation horizontal sixth window width information register.

Data sheet 10.6 ISP_LSC_WINX6 (offset 0x25828, printed page 10-190, `hi3518ev200--Hi3518EV20X-Hi3516CV200-Datasheet.txt` line 70229).";

        field {
            name = "invx6";
            desc = "Reciprocal value of the width of the LSC interpolation horizontal sixth window";
            sw = rw;
            hw = r;
            reset = 0x0;
        } invx6[27:16];

        field {
            name = "deltax6";
            desc = "Width of the LSC interpolation horizontal sixth window";
            sw = rw;
            hw = r;
            reset = 0x0;
        } deltax6[9:0];
    } ISP_LSC_WINX6 @ 0x5828;

    reg {
        name = "LSC interpolation horizontal seventh window width information register";
        desc = "ISP_LSC_WINX7 is an LSC interpolation horizontal seventh window width information register.

Data sheet 10.6 ISP_LSC_WINX7 (offset 0x2582C, printed page 10-191, `hi3518ev200--Hi3518EV20X-Hi3516CV200-Datasheet.txt` line 70262).";

        field {
            name = "invx7";
            desc = "Reciprocal value of the width of the LSC interpolation horizontal seventh window";
            sw = rw;
            hw = r;
            reset = 0x0;
        } invx7[27:16];

        field {
            name = "deltax7";
            desc = "Width of the LSC interpolation horizontal seventh window";
            sw = rw;
            hw = r;
            reset = 0x0;
        } deltax7[9:0];
    } ISP_LSC_WINX7 @ 0x582C;

    reg {
        name = "LSC interpolation horizontal eighth window width information register";
        desc = "ISP_LSC_WINX8 is an LSC interpolation horizontal eighth window width information register.

Data sheet 10.6 ISP_LSC_WINX8 (offset 0x25830, printed page 10-191, `hi3518ev200--Hi3518EV20X-Hi3516CV200-Datasheet.txt` line 70287).";

        field {
            name = "invx8";
            desc = "Reciprocal value of the width of the LSC interpolation horizontal eighth window";
            sw = rw;
            hw = r;
            reset = 0x0;
        } invx8[27:16];

        field {
            name = "deltax8";
            desc = "Width of the LSC interpolation horizontal eighth window";
            sw = rw;
            hw = r;
            reset = 0x0;
        } deltax8[9:0];
    } ISP_LSC_WINX8 @ 0x5830;

    reg {
        name = "LSC interpolation vertical first window width information register";
        desc = "ISP_LSC_WINY1 is an LSC interpolation vertical first window width information register.

Data sheet 10.6 ISP_LSC_WINY1 (offset 0x25834, printed page 10-192, `hi3518ev200--Hi3518EV20X-Hi3516CV200-Datasheet.txt` line 70320).";

        field {
            name = "invy1";
            desc = "Reciprocal value of the width of the LSC interpolation vertical first window";
            sw = rw;
            hw = r;
            reset = 0x0;
        } invy1[27:16];

        field {
            name = "deltay1";
            desc = "Width of the LSC interpolation vertical first window";
            sw = rw;
            hw = r;
            reset = 0x0;
        } deltay1[9:0];
    } ISP_LSC_WINY1 @ 0x5834;

    reg {
        name = "LSC interpolation vertical second window width information register";
        desc = "ISP_LSC_WINY2 is an LSC interpolation vertical second window width information register.

Data sheet 10.6 ISP_LSC_WINY2 (offset 0x25838, printed page 10-192, `hi3518ev200--Hi3518EV20X-Hi3516CV200-Datasheet.txt` line 70344).";

        field {
            name = "invy2";
            desc = "Reciprocal value of the width of the LSC interpolation vertical second window";
            sw = rw;
            hw = r;
            reset = 0x0;
        } invy2[27:16];

        field {
            name = "deltay2";
            desc = "Width of the LSC interpolation vertical second window";
            sw = rw;
            hw = r;
            reset = 0x0;
        } deltay2[9:0];
    } ISP_LSC_WINY2 @ 0x5838;

    reg {
        name = "LSC interpolation vertical third window width information register";
        desc = "ISP_LSC_WINY3 is an LSC interpolation vertical third window width information register.

Data sheet 10.6 ISP_LSC_WINY3 (offset 0x2583C, printed page 10-193, `hi3518ev200--Hi3518EV20X-Hi3516CV200-Datasheet.txt` line 70376).";

        field {
            name = "invy3";
            desc = "Reciprocal value of the width of the LSC interpolation vertical third window";
            sw = rw;
            hw = r;
            reset = 0x0;
        } invy3[27:16];

        field {
            name = "deltay3";
            desc = "Width of the LSC interpolation vertical third window";
            sw = rw;
            hw = r;
            reset = 0x0;
        } deltay3[9:0];
    } ISP_LSC_WINY3 @ 0x583C;

    reg {
        name = "LSC interpolation vertical fourth window width information register";
        desc = "ISP_LSC_WINY4 is an LSC interpolation vertical fourth window width information register.

Data sheet 10.6 ISP_LSC_WINY4 (offset 0x25840, printed page 10-193, `hi3518ev200--Hi3518EV20X-Hi3516CV200-Datasheet.txt` line 70400).";

        field {
            name = "invy4";
            desc = "Reciprocal value of the width of the LSC interpolation vertical fourth window";
            sw = rw;
            hw = r;
            reset = 0x0;
        } invy4[27:16];

        field {
            name = "deltay4";
            desc = "Width of the LSC interpolation vertical fourth window";
            sw = rw;
            hw = r;
            reset = 0x0;
        } deltay4[9:0];
    } ISP_LSC_WINY4 @ 0x5840;

    reg {
        name = "LSC interpolation vertical fifth window width information register";
        desc = "ISP_LSC_WINY5 is an LSC interpolation vertical fifth window width information register.

Data sheet 10.6 ISP_LSC_WINY5 (offset 0x25844, printed page 10-194, `hi3518ev200--Hi3518EV20X-Hi3516CV200-Datasheet.txt` line 70432).";

        field {
            name = "invy5";
            desc = "Reciprocal value of the width of the LSC interpolation vertical fifth window";
            sw = rw;
            hw = r;
            reset = 0x0;
        } invy5[27:16];

        field {
            name = "deltay5";
            desc = "Width of the LSC interpolation vertical fifth window";
            sw = rw;
            hw = r;
            reset = 0x0;
        } deltay5[9:0];
    } ISP_LSC_WINY5 @ 0x5844;

    reg {
        name = "LSC interpolation vertical sixth window width information register";
        desc = "ISP_LSC_WINY6 is an LSC interpolation vertical sixth window width information register.

Data sheet 10.6 ISP_LSC_WINY6 (offset 0x25848, printed page 10-194, `hi3518ev200--Hi3518EV20X-Hi3516CV200-Datasheet.txt` line 70456).";

        field {
            name = "invy6";
            desc = "Reciprocal value of the width of the LSC interpolation vertical sixth window";
            sw = rw;
            hw = r;
            reset = 0x0;
        } invy6[27:16];

        field {
            name = "deltay6";
            desc = "Width of the LSC interpolation vertical sixth window";
            sw = rw;
            hw = r;
            reset = 0x0;
        } deltay6[9:0];
    } ISP_LSC_WINY6 @ 0x5848;

    reg {
        name = "LSC interpolation vertical seventh window width information register";
        desc = "ISP_LSC_WINY7 is an LSC interpolation vertical seventh window width information register.

Data sheet 10.6 ISP_LSC_WINY7 (offset 0x2584C, printed page 10-195, `hi3518ev200--Hi3518EV20X-Hi3516CV200-Datasheet.txt` line 70488).";

        field {
            name = "invy7";
            desc = "Reciprocal value of the width of the LSC interpolation vertical seventh window";
            sw = rw;
            hw = r;
            reset = 0x0;
        } invy7[27:16];

        field {
            name = "deltay7";
            desc = "Width of the LSC interpolation vertical seventh window";
            sw = rw;
            hw = r;
            reset = 0x0;
        } deltay7[9:0];
    } ISP_LSC_WINY7 @ 0x584C;

    reg {
        name = "LSC interpolation vertical eighth window width information register";
        desc = "ISP_LSC_WINY8 is an LSC interpolation vertical eighth window width information register.

Data sheet 10.6 ISP_LSC_WINY8 (offset 0x25850, printed page 10-195, `hi3518ev200--Hi3518EV20X-Hi3516CV200-Datasheet.txt` line 70512).";

        field {
            name = "invy8";
            desc = "Reciprocal value of the width of the LSC interpolation vertical eighth window";
            sw = rw;
            hw = r;
            reset = 0x0;
        } invy8[27:16];

        field {
            name = "deltay8";
            desc = "Width of the LSC interpolation vertical eighth window";
            sw = rw;
            hw = r;
            reset = 0x0;
        } deltay8[9:0];
    } ISP_LSC_WINY8 @ 0x5850;

    reg {
        name = "LSC interpolation R/Gr channel DR gain information write address register";
        desc = "ISP_LSC_GRRGAIN_WADDR is an LSC interpolation R/Gr channel gain write address register.

Data sheet 10.6 ISP_LSC_GRRGAIN_WADDR (offset 0x25880, printed page 10-196, `hi3518ev200--Hi3518EV20X-Hi3516CV200-Datasheet.txt` line 70545).";

        field {
            name = "rgain_waddr";
            desc = "Write address of the LSC interpolation R/Gr channel gain";
            sw = rw;
            hw = r;
            reset = 0x0;
        } rgain_waddr[31:0];
    } ISP_LSC_GRRGAIN_WADDR @ 0x5880;

    reg {
        name = "LSC interpolation R/Gr channel TA gain information write data register";
        desc = "ISP_LSC_GRRGAIN_WDATA is an LSC interpolation R/Gr channel gain write data register.

Data sheet 10.6 ISP_LSC_GRRGAIN_WDATA (offset 0x25884, printed page 10-196, `hi3518ev200--Hi3518EV20X-Hi3516CV200-Datasheet.txt` line 70564).";

        field {
            name = "rgain_wdata";
            desc = "Write data of the LSC interpolation R/Gr channel gain";
            sw = rw;
            hw = r;
            reset = 0x0;
        } rgain_wdata[31:0];
    } ISP_LSC_GRRGAIN_WDATA @ 0x5884;

    reg {
        name = "LSC interpolation R/Gr channel DR gain information read address register";
        desc = "ISP_LSC_GRRGAIN_RADDR is an LSC interpolation R/Gr channel gain read address register.

Data sheet 10.6 ISP_LSC_GRRGAIN_RADDR (offset 0x25888, printed page 10-196, `hi3518ev200--Hi3518EV20X-Hi3516CV200-Datasheet.txt` line 70583).";

        field {
            name = "rgain_raddr";
            desc = "Read address of the LSC interpolation R/Gr channel gain";
            sw = rw;
            hw = r;
            reset = 0x0;
        } rgain_raddr[31:0];
    } ISP_LSC_GRRGAIN_RADDR @ 0x5888;

    reg {
        name = "LSC interpolation R/Gr channel TA gain information read data register";
        desc = "ISP_LSC_GRRGAIN_RDATA is an LSC interpolation R/Gr channel gain read data register.

Data sheet 10.6 ISP_LSC_GRRGAIN_RDATA (offset 0x2588C, printed page 10-197, `hi3518ev200--Hi3518EV20X-Hi3516CV200-Datasheet.txt` line 70610).";

        field {
            name = "grgain_rdata";
            desc = "Read data of the LSC interpolation R/Gr channel gain";
            sw = r;
            hw = w;
            reset = 0x0;
        } grgain_rdata[31:0];
    } ISP_LSC_GRRGAIN_RDATA @ 0x588C;

    reg {
        name = "LSC interpolation B/Gb channel DR gain information write address register";
        desc = "ISP_LSC_GBBGAIN_WADDR is an LSC interpolation B/Gb channel gain write address register.

Data sheet 10.6 ISP_LSC_GBBGAIN_WADDR (offset 0x25890, printed page 10-197, `hi3518ev200--Hi3518EV20X-Hi3516CV200-Datasheet.txt` line 70630).";

        field {
            name = "grgain_waddr";
            desc = "Write address of the LSC interpolation B/Gb channel gain";
            sw = rw;
            hw = r;
            reset = 0x0;
        } grgain_waddr[31:0];
    } ISP_LSC_GBBGAIN_WADDR @ 0x5890;

    reg {
        name = "LSC interpolation B/Gb channel TA gain information write data register";
        desc = "ISP_LSC_GBBGAIN_WDATA is an LSC interpolation B/Gb channel gain write data register.

Data sheet 10.6 ISP_LSC_GBBGAIN_WDATA (offset 0x25894, printed page 10-197, `hi3518ev200--Hi3518EV20X-Hi3516CV200-Datasheet.txt` line 70649).";

        field {
            name = "grgain_wdata";
            desc = "Write data of the LSC interpolation B/Gb channel gain";
            sw = rw;
            hw = r;
            reset = 0x0;
        } grgain_wdata[31:0];
    } ISP_LSC_GBBGAIN_WDATA @ 0x5894;

    reg {
        name = "LSC interpolation B/Gb channel DR gain information read address register";
        desc = "ISP_LSC_GBBGAIN_RADDR is an LSC interpolation B/Gb channel gain read address register.

Data sheet 10.6 ISP_LSC_GBBGAIN_RADDR (offset 0x25898, printed page 10-198, `hi3518ev200--Hi3518EV20X-Hi3516CV200-Datasheet.txt` line 70675).";

        field {
            name = "grgain_raddr";
            desc = "Read address of the LSC interpolation B/Gb channel gain";
            sw = rw;
            hw = r;
            reset = 0x0;
        } grgain_raddr[31:0];
    } ISP_LSC_GBBGAIN_RADDR @ 0x5898;

    reg {
        name = "LSC interpolation B/Gb channel TA gain information read data register";
        desc = "ISP_LSC_GBBGAIN_RDATA is an LSC interpolation B/Gb channel gain read data register.

Data sheet 10.6 ISP_LSC_GBBGAIN_RDATA (offset 0x2589C, printed page 10-198, `hi3518ev200--Hi3518EV20X-Hi3516CV200-Datasheet.txt` line 70693).";

        field {
            name = "grgain_rdata";
            desc = "Read data of the LSC interpolation B/Gb channel gain";
            sw = r;
            hw = w;
            reset = 0x0;
        } grgain_rdata[31:0];
    } ISP_LSC_GBBGAIN_RDATA @ 0x589C;

    reg {
        name = "DRC configuration register";
        desc = "ISP_DRC_CFG is a DRC configuration register.

Data sheet 10.6 ISP_DRC_CFG (offset 0x26200, printed page 10-198, `hi3518ev200--Hi3518EV20X-Hi3516CV200-Datasheet.txt` line 70712).";

        enum ISP_DRC_CFG_drc_en_enum {
            DISABLED = 0 { name = "Disabled"; desc = "disabled"; };
            ENABLED = 1 { name = "Enabled"; desc = "enabled"; };
        };

        field {
            name = "drc_en";
            desc = "DRC module enable";
            sw = rw;
            hw = r;
            encode = ISP_DRC_CFG_drc_en_enum;
            reset = 0x0;
        } drc_en[0:0];
    } ISP_DRC_CFG @ 0x6200;

    reg {
        name = "DRC zone configuration register";
        desc = "ISP_DRC_ZONE is a DRC zone configuration register.

Data sheet 10.6 ISP_DRC_ZONE (offset 0x26210, printed page 10-199, `hi3518ev200--Hi3518EV20X-Hi3516CV200-Datasheet.txt` line 70745).";

        field {
            name = "vnum";
            desc = "DRC vertical zone configuration";
            sw = rw;
            hw = r;
            reset = 0x12;
        } vnum[13:8];

        field {
            name = "hnum";
            desc = "DRC horizontal zone configuration";
            sw = rw;
            hw = r;
            reset = 0x20;
        } hnum[5:0];
    } ISP_DRC_ZONE @ 0x6210;

    reg {
        name = "DRC block size register";
        desc = "ISP_DRC_ZONE_SIZE is a DRC block size register.

Data sheet 10.6 ISP_DRC_ZONE_SIZE (offset 0x26214, printed page 10-200, `hi3518ev200--Hi3518EV20X-Hi3516CV200-Datasheet.txt` line 70785).";

        field {
            name = "chk_y";
            desc = "The block sizes are unequal. chk_y = vsize%vnum";
            sw = rw;
            hw = r;
            reset = 0x0;
        } chk_y[29:24];

        field {
            name = "vsize";
            desc = "Height of each DRC block";
            sw = rw;
            hw = r;
            reset = 0x3B;
        } vsize[23:16];

        field {
            name = "chk_x";
            desc = "The block sizes are unequal. chk_x = hsize%hnum";
            sw = rw;
            hw = r;
            reset = 0x0;
        } chk_x[13:8];

        field {
            name = "hsize";
            desc = "Width of each DRC block";
            sw = rw;
            hw = r;
            reset = 0x3B;
        } hsize[7:0];
    } ISP_DRC_ZONE_SIZE @ 0x6214;

    reg {
        name = "DRC block division coefficient register";
        desc = "ISP_DRC_ZONE_DIV0 is a DRC block division coefficient register.

Data sheet 10.6 ISP_DRC_ZONE_DIV0 (offset 0x26218, printed page 10-200, `hi3518ev200--Hi3518EV20X-Hi3516CV200-Datasheet.txt` line 70821).";

        field {
            name = "div_y";
            desc = "Reciprocal value of the height of each DRC block div_y = 32768/vsize";
            sw = rw;
            hw = r;
            reset = 0x222;
        } div_y[30:16];

        field {
            name = "div_x";
            desc = "Reciprocal value of the width of each DRC block div_x = 32768/hsize";
            sw = rw;
            hw = r;
            reset = 0x222;
        } div_x[14:0];
    } ISP_DRC_ZONE_DIV0 @ 0x6218;

    reg {
        name = "DRC block division coefficient register";
        desc = "ISP_DRC_ZONE_DIV1 is a DRC block division coefficient register.

Data sheet 10.6 ISP_DRC_ZONE_DIV1 (offset 0x2621C, printed page 10-201, `hi3518ev200--Hi3518EV20X-Hi3516CV200-Datasheet.txt` line 70859).";

        field {
            name = "div_y";
            desc = "Reciprocal value of the height of each DRC block div_y = 32768/vsize";
            sw = rw;
            hw = r;
            reset = 0x222;
        } div_y[30:16];

        field {
            name = "div_x";
            desc = "Reciprocal value of the width of each DRC block div_x = 32768/hsize";
            sw = rw;
            hw = r;
            reset = 0x222;
        } div_x[14:0];
    } ISP_DRC_ZONE_DIV1 @ 0x621C;

    reg {
        name = "DRC block histogram segment number register";
        desc = "ISP_DRC_BIN is a DRC block histogram segment number register.

Data sheet 10.6 ISP_DRC_BIN (offset 0x26220, printed page 10-201, `hi3518ev200--Hi3518EV20X-Hi3516CV200-Datasheet.txt` line 70889).";

        field {
            name = "bin";
            desc = "Number of required histogram segments for each DRC block";
            sw = rw;
            hw = r;
            reset = 0x10;
        } bin[4:0];
    } ISP_DRC_BIN @ 0x6220;

    reg {
        name = "DRC histogram division coefficient register";
        desc = "ISP_DRC_BIN_DIV is a DRC histogram division coefficient register.

Data sheet 10.6 ISP_DRC_BIN_DIV (offset 0x26224, printed page 10-202, `hi3518ev200--Hi3518EV20X-Hi3516CV200-Datasheet.txt` line 70921).";

        field {
            name = "div_z";
            desc = "Reciprocal value of the number of layers of each DRC block div_z = 32768/bin";
            sw = rw;
            hw = r;
            reset = 0x800;
        } div_z[14:0];
    } ISP_DRC_BIN_DIV @ 0x6224;

    reg {
        name = "DRC histogram scaling ratio register";
        desc = "ISP_DRC_BIN_SCALE is a DRC histogram scaling ratio register.

Data sheet 10.6 ISP_DRC_BIN_SCALE (offset 0x26228, printed page 10-202, `hi3518ev200--Hi3518EV20X-Hi3516CV200-Datasheet.txt` line 70942).";

        field {
            name = "bin_scale";
            desc = "Histogram statistics weight";
            sw = rw;
            hw = r;
            reset = 0x0;
        } bin_scale[2:0];
    } ISP_DRC_BIN_SCALE @ 0x6228;

    reg {
        name = "DRC value domain filtering OEF coefficient register";
        desc = "ISP_DRC_RANGE_FLT_COEF is a DRC value domain filtering coefficient register.

Data sheet 10.6 ISP_DRC_RANGE_FLT_COEF (offset 0x2622C, printed page 10-203, `hi3518ev200--Hi3518EV20X-Hi3516CV200-Datasheet.txt` line 70976).";

        field {
            name = "range_flt_coef";
            desc = "The value range is 0-8.";
            sw = rw;
            hw = r;
            reset = 0x4;
        } range_flt_coef[3:0];
    } ISP_DRC_RANGE_FLT_COEF @ 0x622C;

    reg {
        name = "DRC current frame exposure value register";
        desc = "ISP_DRC_EXPOSURE is a DRC current frame exposure value register.

Data sheet 10.6 ISP_DRC_EXPOSURE (offset 0x26230, printed page 10-203, `hi3518ev200--Hi3518EV20X-Hi3516CV200-Datasheet.txt` line 70996).";

        field {
            name = "exposure";
            desc = "Exposure value of the current DRC frame, for compensating bright-to-dark switching";
            sw = rw;
            hw = r;
            reset = 0x0;
        } exposure[15:0];
    } ISP_DRC_EXPOSURE @ 0x6230;

    reg {
        name = "DRC local limit register LMT";
        desc = "ISP_DRC_LOCAL_EDGE_LMT is a DRC local limit register.

Data sheet 10.6 ISP_DRC_LOCAL_EDGE_LMT (offset 0x26234, printed page 10-204, `hi3518ev200--Hi3518EV20X-Hi3516CV200-Datasheet.txt` line 71026).";

        field {
            name = "local_edge_lmt";
            desc = "Limit on the input/output luminance difference of the dual-edge filter";
            sw = rw;
            hw = r;
            reset = 0x9B;
        } local_edge_lmt[7:0];
    } ISP_DRC_LOCAL_EDGE_LMT @ 0x6234;

    reg {
        name = "DRC strength adjustment register";
        desc = "ISP_DRC_STRENGTH is a DRC strength adjustment register.

Data sheet 10.6 ISP_DRC_STRENGTH (offset 0x26238, printed page 10-204, `hi3518ev200--Hi3518EV20X-Hi3516CV200-Datasheet.txt` line 71048).";

        field {
            name = "strength";
            desc = "DRC strength";
            sw = rw;
            hw = r;
            reset = 0x80;
        } strength[7:0];
    } ISP_DRC_STRENGTH @ 0x6238;

    reg {
        name = "DRC detail gain adjustment register";
        desc = "ISP_DRC_DETAIL_GAIN is a DRC detail gain adjustment register.

Data sheet 10.6 ISP_DRC_DETAIL_GAIN (offset 0x2623C, printed page 10-204, `hi3518ev200--Hi3518EV20X-Hi3516CV200-Datasheet.txt` line 71067).";

        field {
            name = "detail_mixing_thres";
            desc = "Detail enhancement threshold (the data sheet table row runs the name into its description; the bit diagram names it detail_mixing_thres).";
            sw = rw;
            hw = r;
            reset = 0x60;
        } detail_mixing_thres[23:16];

        field {
            name = "detail_mixing_dark";
            desc = "Enhancement strength of the detail in dark regions";
            sw = rw;
            hw = r;
            reset = 0x80;
        } detail_mixing_dark[15:8];

        field {
            name = "detail_mixing_bright";
            desc = "Enhancement strength of the detail in bright regions";
            sw = rw;
            hw = r;
            reset = 0x10;
        } detail_mixing_bright[7:0];
    } ISP_DRC_DETAIL_GAIN @ 0x623C;

    reg {
        name = "DRC dark region luminance limit MT_Y register";
        desc = "ISP_DRC_DARK_GAIN_LMT_Y is a DRC dark region luminance limit register.

Data sheet 10.6 ISP_DRC_DARK_GAIN_LMT_Y (offset 0x26240, printed page 10-205, `hi3518ev200--Hi3518EV20X-Hi3516CV200-Datasheet.txt` line 71101).";

        field {
            name = "sft2";
            desc = "Limit on the luminance gain of the dark region";
            sw = rw;
            hw = r;
            reset = 0x2;
        } sft2[15:14];

        field {
            name = "val2";
            desc = "Limit on the luminance gain of the dark region";
            sw = rw;
            hw = r;
            reset = 0x1;
        } val2[13:10];

        field {
            name = "sft1";
            desc = "Limit on the luminance gain of the dark region";
            sw = rw;
            hw = r;
            reset = 0x5;
        } sft1[9:7];

        field {
            name = "val1";
            desc = "Limit on the luminance gain of the dark region";
            sw = rw;
            hw = r;
            reset = 0x4E;
        } val1[6:0];
    } ISP_DRC_DARK_GAIN_LMT_Y @ 0x6240;

    reg {
        name = "DRC dark region chrominance limit MT_C register";
        desc = "ISP_DRC_DARK_GAIN_LMT_C is a DRC dark region chrominance limit register.

Data sheet 10.6 ISP_DRC_DARK_GAIN_LMT_C (offset 0x26244, printed page 10-205, `hi3518ev200--Hi3518EV20X-Hi3516CV200-Datasheet.txt` line 71126).";

        field {
            name = "sft2";
            desc = "Limit on the chrominance gain of the dark region";
            sw = rw;
            hw = r;
            reset = 0x2;
        } sft2[15:14];

        field {
            name = "val2";
            desc = "Limit on the chrominance gain of the dark region";
            sw = rw;
            hw = r;
            reset = 0x1;
        } val2[13:10];

        field {
            name = "sft1";
            desc = "Limit on the chrominance gain of the dark region";
            sw = rw;
            hw = r;
            reset = 0x5;
        } sft1[9:7];

        field {
            name = "val1";
            desc = "Limit on the chrominance gain of the dark region";
            sw = rw;
            hw = r;
            reset = 0x4E;
        } val1[6:0];
    } ISP_DRC_DARK_GAIN_LMT_C @ 0x6244;

    reg {
        name = "DRC bright region limit register LMT";
        desc = "ISP_DRC_BRIGHT_GAIN_LMT is a DRC bright region limit register.

Data sheet 10.6 ISP_DRC_BRIGHT_GAIN_LMT (offset 0x26248, printed page 10-206, `hi3518ev200--Hi3518EV20X-Hi3516CV200-Datasheet.txt` line 71161).";

        field {
            name = "sft";
            desc = "Limit on the bright region gain";
            sw = rw;
            hw = r;
            reset = 0x4;
        } sft[9:7];

        field {
            name = "val";
            desc = "Limit on the bright region gain";
            sw = rw;
            hw = r;
            reset = 0x38;
        } val[6:0];
    } ISP_DRC_BRIGHT_GAIN_LMT @ 0x6248;

    reg {
        name = "DRC filtering strength register H";
        desc = "ISP_DRC_FLT_STRENGTH is a DRC filtering strength register.

Data sheet 10.6 ISP_DRC_FLT_STRENGTH (offset 0x26250, printed page 10-206, `hi3518ev200--Hi3518EV20X-Hi3516CV200-Datasheet.txt` line 71182).";

        field {
            name = "var_range";
            desc = "Value domain strength of dual-edge filtering";
            sw = rw;
            hw = r;
            reset = 0x0;
        } var_range[7:4];

        field {
            name = "var_spatial";
            desc = "Spatial domain strength of dual-edge filtering";
            sw = rw;
            hw = r;
            reset = 0x0;
        } var_spatial[3:0];
    } ISP_DRC_FLT_STRENGTH @ 0x6250;

    reg {
        name = "DRC TMLUT mix register L";
        desc = "ISP_DRC_LUT_MIX_CRTL is a DRC TMLUT mix register.

Data sheet 10.6 ISP_DRC_LUT_MIX_CRTL (offset 0x26254, printed page 10-207, `hi3518ev200--Hi3518EV20X-Hi3516CV200-Datasheet.txt` line 71212).";

        field {
            name = "lut_mix_ctrl";
            desc = "Mix ratio of LUT0 to LUT1";
            sw = rw;
            hw = r;
            reset = 0xFF;
        } lut_mix_ctrl[7:0];
    } ISP_DRC_LUT_MIX_CRTL @ 0x6254;

    reg {
        name = "DRC gain limit register";
        desc = "ISP_DRC_GAIN_CLIP is a DRC gain limit register.

Data sheet 10.6 ISP_DRC_GAIN_CLIP (offset 0x26258, printed page 10-207, `hi3518ev200--Hi3518EV20X-Hi3516CV200-Datasheet.txt` line 71232).";

        field {
            name = "gain_clip_knee";
            desc = "Limit start point of the bright region gain";
            sw = rw;
            hw = r;
            reset = 0xB;
        } gain_clip_knee[7:4];

        field {
            name = "gain_clip_step";
            desc = "Limit range of the bright region gain";
            sw = rw;
            hw = r;
            reset = 0x8;
        } gain_clip_step[3:0];
    } ISP_DRC_GAIN_CLIP @ 0x6258;

    reg {
        name = "DRC tone mapping table indirect DDR0 write address 0 register";
        desc = "ISP_DRC_STAT_IND_WADDR0 is a DRC tone mapping table indirect write address 0 register.

Data sheet 10.6 ISP_DRC_STAT_IND_WADDR0 (offset 0x26280, printed page 10-207, `hi3518ev200--Hi3518EV20X-Hi3516CV200-Datasheet.txt` line 71253).";

        field {
            name = "drc_stat_ind_waddr";
            desc = "Tone mapping entry 0";
            sw = rw;
            hw = r;
            reset = 0x0;
        } drc_stat_ind_waddr[31:0];
    } ISP_DRC_STAT_IND_WADDR0 @ 0x6280;

    reg {
        name = "DRC tone mapping table indirect ATA0 write data 0 register";
        desc = "ISP_DRC_STAT_IND_WDATA0 is a DRC tone mapping table indirect write data 0 register.

Data sheet 10.6 ISP_DRC_STAT_IND_WDATA0 (offset 0x26284, printed page 10-208, `hi3518ev200--Hi3518EV20X-Hi3516CV200-Datasheet.txt` line 71282).";

        field {
            name = "drc_stat_ind_wdata";
            desc = "Tone mapping entry 0";
            sw = w;
            hw = r;
            reset = 0x0;
        } drc_stat_ind_wdata[31:0];
    } ISP_DRC_STAT_IND_WDATA0 @ 0x6284;

    reg {
        name = "DRC tone mapping table indirect DDR0 read address 0 register";
        desc = "ISP_DRC_STAT_IND_RADDR0 is a DRC tone mapping table indirect read address 0 register.

Data sheet 10.6 ISP_DRC_STAT_IND_RADDR0 (offset 0x26288, printed page 10-208, `hi3518ev200--Hi3518EV20X-Hi3516CV200-Datasheet.txt` line 71303).";

        field {
            name = "drc_stat_ind_raddr";
            desc = "Tone mapping entry 0";
            sw = rw;
            hw = r;
            reset = 0x0;
        } drc_stat_ind_raddr[31:0];
    } ISP_DRC_STAT_IND_RADDR0 @ 0x6288;

    reg {
        name = "DRC tone mapping table indirect ATA0 read data 0 register";
        desc = "ISP_DRC_STAT_IND_RDATA0 is a DRC tone mapping table indirect read data 0 register.

Data sheet 10.6 ISP_DRC_STAT_IND_RDATA0 (offset 0x2628C, printed page 10-209, `hi3518ev200--Hi3518EV20X-Hi3516CV200-Datasheet.txt` line 71332).";

        field {
            name = "drc_stat_ind_rdata0";
            desc = "Tone mapping entry 0";
            sw = r;
            hw = w;
            reset = 0x0;
        } drc_stat_ind_rdata0[31:0];
    } ISP_DRC_STAT_IND_RDATA0 @ 0x628C;

    reg {
        name = "DRC tone mapping table indirect DDR1 write address 1 register";
        desc = "ISP_DRC_STAT_IND_WADDR1 is a DRC tone mapping table indirect write address 1 register.

Data sheet 10.6 ISP_DRC_STAT_IND_WADDR1 (offset 0x26290, printed page 10-209, `hi3518ev200--Hi3518EV20X-Hi3516CV200-Datasheet.txt` line 71352).";

        field {
            name = "drc_stat_ind_waddr";
            desc = "Tone mapping entry 1";
            sw = rw;
            hw = r;
            reset = 0x0;
        } drc_stat_ind_waddr[31:0];
    } ISP_DRC_STAT_IND_WADDR1 @ 0x6290;

    reg {
        name = "DRC tone mapping table indirect ATA1 write data 1 register";
        desc = "ISP_DRC_STAT_IND_WDATA1 is a DRC tone mapping table indirect write data 1 register.

Data sheet 10.6 ISP_DRC_STAT_IND_WDATA1 (offset 0x26294, printed page 10-209, `hi3518ev200--Hi3518EV20X-Hi3516CV200-Datasheet.txt` line 71373).";

        field {
            name = "drc_stat_ind_wdata";
            desc = "Tone mapping entry 1";
            sw = w;
            hw = r;
            reset = 0x0;
        } drc_stat_ind_wdata[31:0];
    } ISP_DRC_STAT_IND_WDATA1 @ 0x6294;

    reg {
        name = "DRC tone mapping table indirect DDR1 read address 1 register";
        desc = "ISP_DRC_STAT_IND_RADDR1 is a DRC tone mapping table indirect read address 1 register.

Data sheet 10.6 ISP_DRC_STAT_IND_RADDR1 (offset 0x26298, printed page 10-210, `hi3518ev200--Hi3518EV20X-Hi3516CV200-Datasheet.txt` line 71400).";

        field {
            name = "drc_stat_ind_raddr";
            desc = "Tone mapping entry 1";
            sw = rw;
            hw = r;
            reset = 0x0;
        } drc_stat_ind_raddr[31:0];
    } ISP_DRC_STAT_IND_RADDR1 @ 0x6298;

    reg {
        name = "DRC tone mapping table indirect ATA1 read data 1 register";
        desc = "ISP_DRC_STAT_IND_RDATA1 is a DRC tone mapping table indirect read data 1 register.

Data sheet 10.6 ISP_DRC_STAT_IND_RDATA1 (offset 0x2629C, printed page 10-210, `hi3518ev200--Hi3518EV20X-Hi3516CV200-Datasheet.txt` line 71420).";

        field {
            name = "drc_stat_ind_rdata1";
            desc = "Tone mapping entry 1";
            sw = r;
            hw = w;
            reset = 0x0;
        } drc_stat_ind_rdata1[31:0];
    } ISP_DRC_STAT_IND_RDATA1 @ 0x629C;

    reg {
        name = "DRC color correct table indirect DDR2 write address 2 register";
        desc = "ISP_DRC_STAT_IND_WADDR2 is a DRC color correct table indirect write address 2 register.

Data sheet 10.6 ISP_DRC_STAT_IND_WADDR2 (offset 0x262A0, printed page 10-210, `hi3518ev200--Hi3518EV20X-Hi3516CV200-Datasheet.txt` line 71440).";

        field {
            name = "drc_stat_ind_waddr";
            desc = "Color correct entry";
            sw = rw;
            hw = r;
            reset = 0x0;
        } drc_stat_ind_waddr[31:0];
    } ISP_DRC_STAT_IND_WADDR2 @ 0x62A0;

    reg {
        name = "DRC color correct table indirect ATA2 write data 2 register";
        desc = "ISP_DRC_STAT_IND_WDATA2 is a DRC color correct table indirect write data 2 register.

Data sheet 10.6 ISP_DRC_STAT_IND_WDATA2 (offset 0x262A4, printed page 10-211, `hi3518ev200--Hi3518EV20X-Hi3516CV200-Datasheet.txt` line 71468).";

        field {
            name = "drc_stat_ind_wdata";
            desc = "Color correct entry";
            sw = w;
            hw = r;
            reset = 0x0;
        } drc_stat_ind_wdata[31:0];
    } ISP_DRC_STAT_IND_WDATA2 @ 0x62A4;

    reg {
        name = "DRC color correct table indirect DDR2 read address 2 register";
        desc = "ISP_DRC_STAT_IND_RADDR2 is a DRC color correct table indirect read address 2 register.

Data sheet 10.6 ISP_DRC_STAT_IND_RADDR2 (offset 0x262A8, printed page 10-211, `hi3518ev200--Hi3518EV20X-Hi3516CV200-Datasheet.txt` line 71488).";

        field {
            name = "drc_stat_ind_raddr";
            desc = "Color correct entry";
            sw = rw;
            hw = r;
            reset = 0x0;
        } drc_stat_ind_raddr[31:0];
    } ISP_DRC_STAT_IND_RADDR2 @ 0x62A8;

    reg {
        name = "DRC color correct table indirect ATA2 read data 2 register";
        desc = "ISP_DRC_STAT_IND_RDATA2 is a DRC color correct table indirect read data 2 register.

Data sheet 10.6 ISP_DRC_STAT_IND_RDATA2 (offset 0x262AC, printed page 10-212, `hi3518ev200--Hi3518EV20X-Hi3516CV200-Datasheet.txt` line 71518).";

        field {
            name = "drc_stat_ind_rdata2";
            desc = "Color correct entry";
            sw = r;
            hw = w;
            reset = 0x0;
        } drc_stat_ind_rdata2[31:0];
    } ISP_DRC_STAT_IND_RDATA2 @ 0x62AC;

    reg {
        name = "Dehaze enable register";
        desc = "ISP_DEHAZE_CFG is a dehaze enable register.

Data sheet 10.6 ISP_DEHAZE_CFG (offset 0x27000, printed page 10-212, `hi3518ev200--Hi3518EV20X-Hi3516CV200-Datasheet.txt` line 71537).";

        enum ISP_DEHAZE_CFG_en_enum {
            DISABLED = 0 { name = "Disabled"; desc = "disabled"; };
            ENABLED = 1 { name = "Enabled"; desc = "enabled"; };
        };

        field {
            name = "en";
            desc = "Dehaze enable";
            sw = rw;
            hw = r;
            encode = ISP_DEHAZE_CFG_en_enum;
            reset = 0x0;
        } en[0:0];
    } ISP_DEHAZE_CFG @ 0x7000;

    reg {
        name = "Dehaze statistical result update TE register";
        desc = "ISP_DEHAZE_PRE_UPDATE is a dehaze statistical result update register.

Data sheet 10.6 ISP_DEHAZE_PRE_UPDATE (offset 0x27010, printed page 10-213, `hi3518ev200--Hi3518EV20X-Hi3516CV200-Datasheet.txt` line 71567).";

        field {
            name = "pre_update";
            desc = "Dehaze statistical result update. This bit is automatically cleared for each frame.";
            sw = rw;
            hw = r;
            reset = 0x0;
        } pre_update[0:0];
    } ISP_DEHAZE_PRE_UPDATE @ 0x7010;

    reg {
        name = "Dehaze block size configuration register";
        desc = "ISP_DEHAZE_BLK_SIZE is a dehaze block size configuration register.

Data sheet 10.6 ISP_DEHAZE_BLK_SIZE (offset 0x27014, printed page 10-213, `hi3518ev200--Hi3518EV20X-Hi3516CV200-Datasheet.txt` line 71595).";

        field {
            name = "block_sizeh";
            desc = "Horizontal block size. The configured value is the actual value minus 1.";
            sw = rw;
            hw = r;
            reset = 0x0;
        } block_sizeh[24:16];

        field {
            name = "block_sizev";
            desc = "Vertical block size. The configured value is the actual value minus 1.";
            sw = rw;
            hw = r;
            reset = 0x0;
        } block_sizev[8:0];
    } ISP_DEHAZE_BLK_SIZE @ 0x7014;

    reg {
        name = "Dehaze block quantity configuration register";
        desc = "ISP_DEHAZE_BLK_NUM is a dehaze block quantity configuration register.

Data sheet 10.6 ISP_DEHAZE_BLK_NUM (offset 0x27018, printed page 10-214, `hi3518ev200--Hi3518EV20X-Hi3516CV200-Datasheet.txt` line 71629).";

        field {
            name = "block_numh";
            desc = "Horizontal block size. The configured value is the actual value minus 1.";
            sw = rw;
            hw = r;
            reset = 0x0;
        } block_numh[20:16];

        field {
            name = "block_numv";
            desc = "Vertical block size. The configured value is the actual value minus 1.";
            sw = rw;
            hw = r;
            reset = 0x0;
        } block_numv[4:0];
    } ISP_DEHAZE_BLK_NUM @ 0x7018;

    reg {
        name = "Dehaze bilinear interpolation point quantity configuration register";
        desc = "ISP_DEHAZE_DC_SIZE is a dehaze bilinear interpolation point quantity configuration register.

Data sheet 10.6 ISP_DEHAZE_DC_SIZE (offset 0x2701C, printed page 10-214, `hi3518ev200--Hi3518EV20X-Hi3516CV200-Datasheet.txt` line 71656).";

        field {
            name = "dc_numh";
            desc = "Number of bilinear interpolation horizontal points. The configured value is the actual value minus 1.";
            sw = rw;
            hw = r;
            reset = 0x0;
        } dc_numh[9:5];

        field {
            name = "dc_numv";
            desc = "Number of bilinear interpolation vertical points. The configured value is the actual value minus 1.";
            sw = rw;
            hw = r;
            reset = 0x0;
        } dc_numv[4:0];
    } ISP_DEHAZE_DC_SIZE @ 0x701C;

    reg {
        name = "Configuration register for the horizontal phase difference between the pixels of the dehaze enlarged picture";
        desc = "ISP_DEHAZE_X is a configuration register for the horizontal phase difference between the pixels of the dehaze enlarged picture.

Data sheet 10.6 ISP_DEHAZE_X (offset 0x27020, printed page 10-215, `hi3518ev200--Hi3518EV20X-Hi3516CV200-Datasheet.txt` line 71691).";

        field {
            name = "phase_x";
            desc = "Horizontal phase difference between the pixels of the enlarged picture, unsigned integer";
            sw = rw;
            hw = r;
            reset = 0x0;
        } phase_x[21:0];
    } ISP_DEHAZE_X @ 0x7020;

    reg {
        name = "Configuration register for the vertical phase difference between the pixels of the dehaze enlarged picture";
        desc = "ISP_DEHAZE_Y is a configuration register for the vertical phase difference between the pixels of the dehaze enlarged picture.

Data sheet 10.6 ISP_DEHAZE_Y (offset 0x27024, printed page 10-215, `hi3518ev200--Hi3518EV20X-Hi3516CV200-Datasheet.txt` line 71714).";

        field {
            name = "phase_y";
            desc = "Vertical phase difference between the pixels of the enlarged picture, unsigned integer";
            sw = rw;
            hw = r;
            reset = 0x0;
        } phase_y[21:0];
    } ISP_DEHAZE_Y @ 0x7024;

    reg {
        name = "Dehaze statistics module control DE register";
        desc = "ISP_DEHAZE_STAT_MODE is a dehaze statistics module control register.

Data sheet 10.6 ISP_DEHAZE_STAT_MODE (offset 0x27028, printed page 10-216, `hi3518ev200--Hi3518EV20X-Hi3516CV200-Datasheet.txt` line 71745).";

        enum ISP_DEHAZE_STAT_MODE_max_mode_enum {
            MEAN_FILTERING_PERFORMED = 0 { name = "Mean Filtering Performed"; desc = "Mean filtering is performed on RGB components, and then the RGB components corresponding to the maximum RGB sum of each window are counted."; };
            RGB_COMPONENTS_CORRESPONDING = 1 { name = "Rgb Components Corresponding"; desc = "The RGB components corresponding to the maximum RGB sum of each window are counted."; };
        };

        field {
            name = "max_mode";
            desc = "Maximum value statistics control";
            sw = rw;
            hw = r;
            encode = ISP_DEHAZE_STAT_MODE_max_mode_enum;
            reset = 0x0;
        } max_mode[2:2];

        enum ISP_DEHAZE_STAT_MODE_min_mode_enum {
            MINIMUM_VALUE_AMONG = 0 { name = "Minimum Value Among"; desc = "The minimum value among RGB components is selected for mean filtering, and the minimum value of each window is counted."; };
            MINIMUM_VALUE_AMONG_2 = 1 { name = "Minimum Value Among 2"; desc = "The minimum value among RGB components is selected, and the minimum value of each window is counted."; };
            MINIMUM_VALUE_RGB = 2 { name = "Minimum Value Rgb"; desc = "The minimum value of the RGB mean filtering results is selected for mean filtering, and the minimum value of each window is counted. Other values: reserved"; };
        };

        field {
            name = "min_mode";
            desc = "Minimum value statistics control";
            sw = rw;
            hw = r;
            encode = ISP_DEHAZE_STAT_MODE_min_mode_enum;
            reset = 0x0;
        } min_mode[1:0];
    } ISP_DEHAZE_STAT_MODE @ 0x7028;

    reg {
        name = "Dehaze inversion control register E";
        desc = "ISP_DEHAZE_NEG_MODE is a dehaze inversion control register.

Data sheet 10.6 ISP_DEHAZE_NEG_MODE (offset 0x2702C, printed page 10-216, `hi3518ev200--Hi3518EV20X-Hi3516CV200-Datasheet.txt` line 71785).";

        enum ISP_DEHAZE_NEG_MODE_neg_mode_enum {
            NORMAL_MODE = 0 { name = "Normal Mode"; desc = "normal mode"; };
            INVERSION_MODE = 1 { name = "Inversion Mode"; desc = "inversion mode"; };
        };

        field {
            name = "neg_mode";
            desc = "Inversion mode control";
            sw = rw;
            hw = r;
            encode = ISP_DEHAZE_NEG_MODE_neg_mode_enum;
            reset = 0x0;
        } neg_mode[0:0];
    } ISP_DEHAZE_NEG_MODE @ 0x702C;

    reg {
        name = "Dehaze airglow configuration register";
        desc = "ISP_DEHAZE_AIR is a dehaze airglow configuration register.

Data sheet 10.6 ISP_DEHAZE_AIR (offset 0x27030, printed page 10-217, `hi3518ev200--Hi3518EV20X-Hi3516CV200-Datasheet.txt` line 71822).";

        field {
            name = "air_r";
            desc = "Airglow A corresponding to the R channel";
            sw = rw;
            hw = r;
            reset = 0x0;
        } air_r[23:16];

        field {
            name = "air_g";
            desc = "Airglow A corresponding to the G channel";
            sw = rw;
            hw = r;
            reset = 0x0;
        } air_g[15:8];

        field {
            name = "air_b";
            desc = "Airglow A corresponding to the B channel";
            sw = rw;
            hw = r;
            reset = 0x0;
        } air_b[7:0];
    } ISP_DEHAZE_AIR @ 0x7030;

    reg {
        name = "Dehaze T threshold coefficient configuration register";
        desc = "ISP_DEHAZE_THLD is a dehaze T threshold coefficient configuration register.

Data sheet 10.6 ISP_DEHAZE_THLD (offset 0x27034, printed page 10-217, `hi3518ev200--Hi3518EV20X-Hi3516CV200-Datasheet.txt` line 71844).";

        field {
            name = "thld";
            desc = "T threshold coefficient, unsigned integer";
            sw = rw;
            hw = r;
            reset = 0x0;
        } thld[7:0];
    } ISP_DEHAZE_THLD @ 0x7034;

    reg {
        name = "Dehaze global strength coefficient register";
        desc = "ISP_DEHAZE_GSTRTH is a dehaze global strength coefficient register.

Data sheet 10.6 ISP_DEHAZE_GSTRTH (offset 0x27038, printed page 10-218, `hi3518ev200--Hi3518EV20X-Hi3516CV200-Datasheet.txt` line 71873).";

        field {
            name = "gstrth";
            desc = "G calculation coefficient, unsigned integer";
            sw = rw;
            hw = r;
            reset = 0x0;
        } gstrth[7:0];
    } ISP_DEHAZE_GSTRTH @ 0x7038;

    reg {
        name = "Dehaze minimum value filtering threshold coefficient configuration register";
        desc = "ISP_DEHAZE_BLTHLD is a dehaze minimum value filtering threshold coefficient configuration register.

Data sheet 10.6 ISP_DEHAZE_BLTHLD (offset 0x2703C, printed page 10-218, `hi3518ev200--Hi3518EV20X-Hi3516CV200-Datasheet.txt` line 71894).";

        field {
            name = "blthld";
            desc = "Minimum value filtering threshold coefficient, unsigned integer";
            sw = rw;
            hw = r;
            reset = 0x0;
        } blthld[7:0];
    } ISP_DEHAZE_BLTHLD @ 0x703C;

    reg {
        name = "DIS enable register";
        desc = "ISP_DIS_CFG is a DIS enable register.

Data sheet 10.6 ISP_DIS_CFG (offset 0x27100, printed page 10-218, `hi3518ev200--Hi3518EV20X-Hi3516CV200-Datasheet.txt` line 71913).";

        enum ISP_DIS_CFG_work_en_enum {
            DISABLED = 0 { name = "Disabled"; desc = "disabled"; };
            ENABLED = 1 { name = "Enabled"; desc = "enabled"; };
        };

        field {
            name = "work_en";
            desc = "DIS enable";
            sw = rw;
            hw = r;
            encode = ISP_DIS_CFG_work_en_enum;
            reset = 0x0;
        } work_en[0:0];
    } ISP_DIS_CFG @ 0x7100;

    reg {
        name = "Block configuration register";
        desc = "ISP_DIS_BLK is a block configuration register.

Data sheet 10.6 ISP_DIS_BLK (offset 0x27104, printed page 10-219, `hi3518ev200--Hi3518EV20X-Hi3516CV200-Datasheet.txt` line 71948).";

        field {
            name = "srch_range";
            desc = "Upper six bits of the search range. The value range is 4-32.";
            sw = rw;
            hw = r;
            reset = 0x0;
        } srch_range[22:17];

        field {
            name = "srch_range_0";
            desc = "Least significant bit (LSB) of the search range. This bit is fixed at 0.";
            sw = r;
            hw = w;
            reset = 0x0;
        } srch_range_0[16:16];

        field {
            name = "blk_size";
            desc = "Upper seven bits of the side length of the square block. The value range is 8-64.";
            sw = rw;
            hw = r;
            reset = 0x0;
        } blk_size[7:1];

        field {
            name = "blk_size_0";
            desc = "LSB of the side length of the square block. This bit is fixed at 0.";
            sw = r;
            hw = w;
            reset = 0x0;
        } blk_size_0[0:0];
    } ISP_DIS_BLK @ 0x7104;

    reg {
        name = "Vertical PRJ0 block address register";
        desc = "ISP_DIS_V0POS is a vertical PRJ0 block address register.

Data sheet 10.6 ISP_DIS_V0POS (offset 0x27110, printed page 10-220, `hi3518ev200--Hi3518EV20X-Hi3516CV200-Datasheet.txt` line 71992).";

        field {
            name = "ver";
            desc = "Vertical coordinate of the vertical PRJ0 block. The LSB of the coordinate value is excluded, and one bit is subtracted.";
            sw = rw;
            hw = r;
            reset = 0x0;
        } ver[26:16];

        field {
            name = "hor";
            desc = "Horizontal coordinate of the vertical PRJ0 block. The LSB of the coordinate value is excluded, and one bit is subtracted.";
            sw = rw;
            hw = r;
            reset = 0x0;
        } hor[10:0];
    } ISP_DIS_V0POS @ 0x7110;

    reg {
        name = "Vertical PRJ4 block address register";
        desc = "ISP_DIS_V4POS is a vertical PRJ4 block address register.

Data sheet 10.6 ISP_DIS_V4POS (offset 0x27114, printed page 10-220, `hi3518ev200--Hi3518EV20X-Hi3516CV200-Datasheet.txt` line 72018).";

        field {
            name = "ver";
            desc = "Vertical coordinate of the vertical PRJ4 block. The LSB of the coordinate value is excluded, and one bit is subtracted.";
            sw = rw;
            hw = r;
            reset = 0x0;
        } ver[26:16];

        field {
            name = "hor";
            desc = "Horizontal coordinate of the vertical PRJ4 block. The LSB of the coordinate value is excluded, and one bit is subtracted.";
            sw = rw;
            hw = r;
            reset = 0x0;
        } hor[10:0];
    } ISP_DIS_V4POS @ 0x7114;

    reg {
        name = "Vertical PRJ8 block address register";
        desc = "ISP_DIS_V8POS is a vertical PRJ8 block address register.

Data sheet 10.6 ISP_DIS_V8POS (offset 0x27118, printed page 10-221, `hi3518ev200--Hi3518EV20X-Hi3516CV200-Datasheet.txt` line 72053).";

        field {
            name = "ver";
            desc = "Vertical coordinate of the vertical PRJ8 block. The LSB of the coordinate value is excluded, and one bit is subtracted.";
            sw = rw;
            hw = r;
            reset = 0x0;
        } ver[26:16];

        field {
            name = "hor";
            desc = "Horizontal coordinate of the vertical PRJ8 block. The LSB of the coordinate value is excluded, and one bit is subtracted.";
            sw = rw;
            hw = r;
            reset = 0x0;
        } hor[10:0];
    } ISP_DIS_V8POS @ 0x7118;

    reg {
        name = "Vertical PRJ0 block address register";
        desc = "ISP_DIS_V0POSE is a vertical PRJ0 block address register.

Data sheet 10.6 ISP_DIS_V0POSE (offset 0x27120, printed page 10-221, `hi3518ev200--Hi3518EV20X-Hi3516CV200-Datasheet.txt` line 72079).";

        field {
            name = "ver";
            desc = "Vertical coordinate of the end point of the vertical PRJ0 block. The LSB of the coordinate value is excluded, and one bit is subtracted.";
            sw = rw;
            hw = r;
            reset = 0x0;
        } ver[26:16];

        field {
            name = "hor";
            desc = "Horizontal coordinate of the end point of the vertical PRJ0 block. The LSB of the coordinate value is excluded, and one bit is subtracted.";
            sw = rw;
            hw = r;
            reset = 0x0;
        } hor[10:0];
    } ISP_DIS_V0POSE @ 0x7120;

    reg {
        name = "Vertical PRJ4 block address register";
        desc = "ISP_DIS_V4POSE is a vertical PRJ4 block address register.

Data sheet 10.6 ISP_DIS_V4POSE (offset 0x27124, printed page 10-222, `hi3518ev200--Hi3518EV20X-Hi3516CV200-Datasheet.txt` line 72114).";

        field {
            name = "ver";
            desc = "Vertical coordinate of the end point of the vertical PRJ4 block. The LSB of the coordinate value is excluded, and one bit is subtracted.";
            sw = rw;
            hw = r;
            reset = 0x0;
        } ver[26:16];

        field {
            name = "hor";
            desc = "Horizontal coordinate of the end point of the vertical PRJ4 block. The LSB of the coordinate value is excluded, and one bit is subtracted.";
            sw = rw;
            hw = r;
            reset = 0x0;
        } hor[10:0];
    } ISP_DIS_V4POSE @ 0x7124;

    reg {
        name = "Vertical PRJ8 block address register";
        desc = "ISP_DIS_V8POSE is a vertical PRJ8 block address register.

Data sheet 10.6 ISP_DIS_V8POSE (offset 0x27128, printed page 10-222, `hi3518ev200--Hi3518EV20X-Hi3516CV200-Datasheet.txt` line 72140).";

        field {
            name = "ver";
            desc = "Vertical coordinate of the end point of the vertical PRJ8 block. The LSB of the coordinate value is excluded, and one bit is subtracted.";
            sw = rw;
            hw = r;
            reset = 0x0;
        } ver[26:16];

        field {
            name = "hor";
            desc = "Horizontal coordinate of the end point of the vertical PRJ8 block. The LSB of the coordinate value is excluded, and one bit is subtracted.";
            sw = rw;
            hw = r;
            reset = 0x0;
        } hor[10:0];
    } ISP_DIS_V8POSE @ 0x7128;

    reg {
        name = "Horizontal PRJ0 block address register";
        desc = "ISP_DIS_H0POS is a horizontal PRJ0 block address register.

Data sheet 10.6 ISP_DIS_H0POS (offset 0x27130, printed page 10-223, `hi3518ev200--Hi3518EV20X-Hi3516CV200-Datasheet.txt` line 72175).";

        field {
            name = "ver";
            desc = "Vertical coordinate of the horizontal PRJ0 block. The LSB of the coordinate value is excluded, and one bit is subtracted.";
            sw = rw;
            hw = r;
            reset = 0x0;
        } ver[26:16];

        field {
            name = "hor";
            desc = "Horizontal coordinate of the horizontal PRJ0 block. The LSB of the coordinate value is excluded, and one bit is subtracted.";
            sw = rw;
            hw = r;
            reset = 0x0;
        } hor[10:0];
    } ISP_DIS_H0POS @ 0x7130;

    reg {
        name = "Horizontal PRJ4 block address register";
        desc = "ISP_DIS_H4POS is a horizontal PRJ4 block address register.

Data sheet 10.6 ISP_DIS_H4POS (offset 0x27134, printed page 10-223, `hi3518ev200--Hi3518EV20X-Hi3516CV200-Datasheet.txt` line 72201).";

        field {
            name = "ver";
            desc = "Vertical coordinate of the horizontal PRJ4 block. The LSB of the coordinate value is excluded, and one bit is subtracted.";
            sw = rw;
            hw = r;
            reset = 0x0;
        } ver[26:16];

        field {
            name = "hor";
            desc = "Horizontal coordinate of the horizontal PRJ4 block. The LSB of the coordinate value is excluded, and one bit is subtracted.";
            sw = rw;
            hw = r;
            reset = 0x0;
        } hor[10:0];
    } ISP_DIS_H4POS @ 0x7134;

    reg {
        name = "Horizontal PRJ8 block address register";
        desc = "ISP_DIS_H8POS is a horizontal PRJ8 block address register.

Data sheet 10.6 ISP_DIS_H8POS (offset 0x27138, printed page 10-224, `hi3518ev200--Hi3518EV20X-Hi3516CV200-Datasheet.txt` line 72236).";

        field {
            name = "ver";
            desc = "Vertical coordinate of the horizontal PRJ8 block. The LSB of the coordinate value is excluded, and one bit is subtracted.";
            sw = rw;
            hw = r;
            reset = 0x0;
        } ver[26:16];

        field {
            name = "hor";
            desc = "Horizontal coordinate of the horizontal PRJ8 block. The LSB of the coordinate value is excluded, and one bit is subtracted.";
            sw = rw;
            hw = r;
            reset = 0x0;
        } hor[10:0];
    } ISP_DIS_H8POS @ 0x7138;

    reg {
        name = "Horizontal PRJ0 block address register";
        desc = "ISP_DIS_H0POSE is a horizontal PRJ0 block address register.

Data sheet 10.6 ISP_DIS_H0POSE (offset 0x27140, printed page 10-224, `hi3518ev200--Hi3518EV20X-Hi3516CV200-Datasheet.txt` line 72262).";

        field {
            name = "ver";
            desc = "Vertical coordinate of the end point of the horizontal PRJ0 block. The LSB of the coordinate value is excluded, and one bit is subtracted.";
            sw = rw;
            hw = r;
            reset = 0x0;
        } ver[26:16];

        field {
            name = "hor";
            desc = "Horizontal coordinate of the end point of the horizontal PRJ0 block. The LSB of the coordinate value is excluded, and one bit is subtracted.";
            sw = rw;
            hw = r;
            reset = 0x0;
        } hor[10:0];
    } ISP_DIS_H0POSE @ 0x7140;

    reg {
        name = "Horizontal PRJ4 block address register";
        desc = "ISP_DIS_H4POSE is a horizontal PRJ4 block address register.

Data sheet 10.6 ISP_DIS_H4POSE (offset 0x27144, printed page 10-225, `hi3518ev200--Hi3518EV20X-Hi3516CV200-Datasheet.txt` line 72297).";

        field {
            name = "ver";
            desc = "Vertical coordinate of the end point of the horizontal PRJ4 block. The LSB of the coordinate value is excluded, and one bit is subtracted.";
            sw = rw;
            hw = r;
            reset = 0x0;
        } ver[26:16];

        field {
            name = "hor";
            desc = "Horizontal coordinate of the end point of the horizontal PRJ4 block. The LSB of the coordinate value is excluded, and one bit is subtracted.";
            sw = rw;
            hw = r;
            reset = 0x0;
        } hor[10:0];
    } ISP_DIS_H4POSE @ 0x7144;

    reg {
        name = "Horizontal PRJ8 block address register";
        desc = "ISP_DIS_H8POSE is a horizontal PRJ8 block address register.

Data sheet 10.6 ISP_DIS_H8POSE (offset 0x27148, printed page 10-225, `hi3518ev200--Hi3518EV20X-Hi3516CV200-Datasheet.txt` line 72323).";

        field {
            name = "ver";
            desc = "Vertical coordinate of the end point of the horizontal PRJ8 block. The LSB of the coordinate value is excluded, and one bit is subtracted.";
            sw = rw;
            hw = r;
            reset = 0x0;
        } ver[26:16];

        field {
            name = "hor";
            desc = "Horizontal coordinate of the end point of the horizontal PRJ8 block. The LSB of the coordinate value is excluded, and one bit is subtracted.";
            sw = rw;
            hw = r;
            reset = 0x0;
        } hor[10:0];
    } ISP_DIS_H8POSE @ 0x7148;

    reg {
        name = "Gamma enable register";
        desc = "ISP_DIS_GAMMA_EN is a gamma enable register.

Data sheet 10.6 ISP_DIS_GAMMA_EN (offset 0x27154, printed page 10-226, `hi3518ev200--Hi3518EV20X-Hi3516CV200-Datasheet.txt` line 72358).";

        enum ISP_DIS_GAMMA_EN_gamma_en_enum {
            DISABLED = 0 { name = "Disabled"; desc = "disabled"; };
            ENABLED = 1 { name = "Enabled"; desc = "enabled"; };
        };

        field {
            name = "gamma_en";
            desc = "Gamma enable";
            sw = rw;
            hw = r;
            encode = ISP_DIS_GAMMA_EN_gamma_en_enum;
            reset = 0x0;
        } gamma_en[0:0];
    } ISP_DIS_GAMMA_EN @ 0x7154;

    reg {
        name = "Horizontal statistics read address R register";
        desc = "ISP_DIS_H_STAT_RADDR is a horizontal statistics read address register.

Data sheet 10.6 ISP_DIS_H_STAT_RADDR (offset 0x27188, printed page 10-226, `hi3518ev200--Hi3518EV20X-Hi3516CV200-Datasheet.txt` line 72385).";

        enum ISP_DIS_H_STAT_RADDR_h_stat_raddr_enum {
            H_DELTA_14 = 0x0 { name = "H Delta 14"; desc = "h_delta[14:0] of block 0"; };
            H_SAD_21 = 0x1 { name = "H Sad 21"; desc = "h_sad[21:0] of block 0"; };
            H_MV_7 = 0x2 { name = "H Mv 7"; desc = "h_mv[7:0] of block 0 … The same rule applies to other values."; };
        };

        field {
            name = "h_stat_raddr";
            desc = "h_delta, h_sad, and h_mv information about each block. Each address contains only one piece of information. For example:";
            sw = rw;
            hw = r;
            encode = ISP_DIS_H_STAT_RADDR_h_stat_raddr_enum;
            reset = 0x0;
        } h_stat_raddr[31:0];
    } ISP_DIS_H_STAT_RADDR @ 0x7188;

    reg {
        name = "Horizontal statistics read data register";
        desc = "ISP_DIS_H_STAT_RDATA is a horizontal statistics read data register.

Data sheet 10.6 ISP_DIS_H_STAT_RDATA (offset 0x2718C, printed page 10-227, `hi3518ev200--Hi3518EV20X-Hi3516CV200-Datasheet.txt` line 72418).";

        field {
            name = "h_stat_rdata";
            desc = "Horizontal statistics";
            sw = r;
            hw = w;
            reset = 0x0;
        } h_stat_rdata[31:0];
    } ISP_DIS_H_STAT_RDATA @ 0x718C;

    reg {
        name = "Vertical statistics read address R register";
        desc = "ISP_DIS_V_STAT_RADDR is a vertical statistics read address register.

Data sheet 10.6 ISP_DIS_V_STAT_RADDR (offset 0x27198, printed page 10-227, `hi3518ev200--Hi3518EV20X-Hi3516CV200-Datasheet.txt` line 72437).";

        enum ISP_DIS_V_STAT_RADDR_v_stat_raddr_enum {
            V_DELTA_14 = 0x0 { name = "V Delta 14"; desc = "v_delta[14:0] of block 0"; };
            V_SAD_21 = 0x1 { name = "V Sad 21"; desc = "v_sad[21:0] of block 0"; };
            V_MV_7 = 0x2 { name = "V Mv 7"; desc = "v_mv[7:0] of block 0 … The same rule applies to other values."; };
        };

        field {
            name = "v_stat_raddr";
            desc = "v_delta, v_sad, and v_mv information about each block. Each address contains only one piece of information. For example:";
            sw = rw;
            hw = r;
            encode = ISP_DIS_V_STAT_RADDR_v_stat_raddr_enum;
            reset = 0x0;
        } v_stat_raddr[31:0];
    } ISP_DIS_V_STAT_RADDR @ 0x7198;

    reg {
        name = "Vertical statistics read data register";
        desc = "ISP_DIS_V_STAT_RDATA is a vertical statistics read data register.

Data sheet 10.6 ISP_DIS_V_STAT_RDATA (offset 0x2719C, printed page 10-228, `hi3518ev200--Hi3518EV20X-Hi3516CV200-Datasheet.txt` line 72470).";

        field {
            name = "v_stat_rdata";
            desc = "Vertical statistics";
            sw = r;
            hw = w;
            reset = 0x0;
        } v_stat_rdata[31:0];
    } ISP_DIS_V_STAT_RDATA @ 0x719C;

    reg {
        name = "Gamma control register";
        desc = "ISP_GAMMA_CFG is a gamma control register.

Data sheet 10.6 ISP_GAMMA_CFG (offset 0x27300, printed page 10-228, `hi3518ev200--Hi3518EV20X-Hi3516CV200-Datasheet.txt` line 72489).";

        enum ISP_GAMMA_CFG_en_enum {
            DISABLED = 0 { name = "Disabled"; desc = "disabled"; };
            ENABLED = 1 { name = "Enabled"; desc = "enabled"; };
        };

        field {
            name = "en";
            desc = "Gamma enable";
            sw = rw;
            hw = r;
            encode = ISP_GAMMA_CFG_en_enum;
            reset = 0x0;
        } en[0:0];
    } ISP_GAMMA_CFG @ 0x7300;

    reg {
        name = "Gamma lookup table update register TE";
        desc = "ISP_GAMMA_LUT_UPDATE is a gamma lookup table update register.

Data sheet 10.6 ISP_GAMMA_LUT_UPDATE (offset 0x27310, printed page 10-228, `hi3518ev200--Hi3518EV20X-Hi3516CV200-Datasheet.txt` line 72510).";

        field {
            name = "update";
            desc = "Gamma lookup table update. This bit is automatically cleared for each frame.";
            sw = rw;
            hw = r;
            reset = 0x0;
        } update[0:0];
    } ISP_GAMMA_LUT_UPDATE @ 0x7310;

    reg {
        name = "Gamma lookup table write address register";
        desc = "ISP_GAMMA_WADDR is a gamma lookup table write address register.

Data sheet 10.6 ISP_GAMMA_WADDR (offset 0x27380, printed page 10-229, `hi3518ev200--Hi3518EV20X-Hi3516CV200-Datasheet.txt` line 72543).";

        field {
            name = "gamma_waddr";
            desc = "Write address of the 257-entry gamma lookup table";
            sw = rw;
            hw = r;
            reset = 0x0;
        } gamma_waddr[31:0];
    } ISP_GAMMA_WADDR @ 0x7380;

    reg {
        name = "Gamma lookup table write data register";
        desc = "ISP_GAMMA_WDATA is a gamma lookup table write data register.

Data sheet 10.6 ISP_GAMMA_WDATA (offset 0x27384, printed page 10-229, `hi3518ev200--Hi3518EV20X-Hi3516CV200-Datasheet.txt` line 72562).";

        field {
            name = "gamma_wdata";
            desc = "Write data of the 257-entry gamma lookup table";
            sw = rw;
            hw = r;
            reset = 0x0;
        } gamma_wdata[31:0];
    } ISP_GAMMA_WDATA @ 0x7384;

    reg {
        name = "Gamma FE configuration register";
        desc = "ISP_GAMMAFE_CFG is a gamma FE configuration register.

Data sheet 10.6 ISP_GAMMAFE_CFG (offset 0x27400, printed page 10-230, `hi3518ev200--Hi3518EV20X-Hi3516CV200-Datasheet.txt` line 72589).";

        enum ISP_GAMMAFE_CFG_en_enum {
            DISABLED = 0 { name = "Disabled"; desc = "disabled"; };
            ENABLED = 1 { name = "Enabled"; desc = "enabled"; };
        };

        field {
            name = "en";
            desc = "Gamma enable";
            sw = rw;
            hw = r;
            encode = ISP_GAMMAFE_CFG_en_enum;
            reset = 0x0;
        } en[0:0];
    } ISP_GAMMAFE_CFG @ 0x7400;

    reg {
        name = "Data bit width configuration register TW";
        desc = "ISP_GAMMAFE_CTRL_BITW is a data bit width configuration register.

Data sheet 10.6 ISP_GAMMAFE_CTRL_BITW (offset 0x27410, printed page 10-230, `hi3518ev200--Hi3518EV20X-Hi3516CV200-Datasheet.txt` line 72611).";

        enum ISP_GAMMAFE_CTRL_BITW_bitw_in_enum {
            V_14_BITS = 0xE { name = "V 14 Bits"; desc = "14 bits"; };
            V_16_BITS = 0x10 { name = "V 16 Bits"; desc = "16 bits"; };
            V_18_BITS = 0x12 { name = "V 18 Bits"; desc = "18 bits"; };
            V_20_BITS_OTHER = 0x14 { name = "V 20 Bits Other"; desc = "20 bits Other values: reserved"; };
        };

        field {
            name = "bitw_in";
            desc = "Bit width of the gamma FE input data";
            sw = rw;
            hw = r;
            encode = ISP_GAMMAFE_CTRL_BITW_bitw_in_enum;
            reset = 0x0;
        } bitw_in[20:16];

        enum ISP_GAMMAFE_CTRL_BITW_bitw_out_enum {
            V_12_BITS = 0xC { name = "V 12 Bits"; desc = "12 bits"; };
            V_14_BITS = 0xE { name = "V 14 Bits"; desc = "14 bits"; };
            V_16_BITS_OTHER = 0x10 { name = "V 16 Bits Other"; desc = "16 bits Other values: reserved"; };
        };

        field {
            name = "bitw_out";
            desc = "Bit width of the gamma FE output data";
            sw = rw;
            hw = r;
            encode = ISP_GAMMAFE_CTRL_BITW_bitw_out_enum;
            reset = 0x0;
        } bitw_out[4:0];
    } ISP_GAMMAFE_CTRL_BITW @ 0x7410;

    reg {
        name = "Gamma FE mix control register RL";
        desc = "ISP_GAMMAFE_MIX_CTRL is a gamma FE mix control register.

Data sheet 10.6 ISP_GAMMAFE_MIX_CTRL (offset 0x27414, printed page 10-231, `hi3518ev200--Hi3518EV20X-Hi3516CV200-Datasheet.txt` line 72649).";

        enum ISP_GAMMAFE_MIX_CTRL_mix_ctrl_enum {
            DATA_OUTPUT_AFTER = 0x0 { name = "Data Output After"; desc = "Data is output after direct bit truncation."; };
            INTERPOLATION_RESULT_OUTPUT = 0xFF { name = "Interpolation Result Output"; desc = "The interpolation result is output. Other values: Data is blended according to a linear ratio."; };
        };

        field {
            name = "mix_ctrl";
            desc = "Output data blending ratio controlled by the gamma FE";
            sw = rw;
            hw = r;
            encode = ISP_GAMMAFE_MIX_CTRL_mix_ctrl_enum;
            reset = 0xFF;
        } mix_ctrl[7:0];
    } ISP_GAMMAFE_MIX_CTRL @ 0x7414;

    reg {
        name = "Indirect write address register 0 0";
        desc = "ISP_GAMMAFE_WADDR0 is indirect write address register 0.

Data sheet 10.6 ISP_GAMMAFE_WADDR0 (offset 0x27480, printed page 10-231, `hi3518ev200--Hi3518EV20X-Hi3516CV200-Datasheet.txt` line 72673).";

        field {
            name = "gamma_waddr0";
            desc = "Write address of the 257-entry gamma FE LUT0";
            sw = rw;
            hw = r;
            reset = 0x0;
        } gamma_waddr0[31:0];
    } ISP_GAMMAFE_WADDR0 @ 0x7480;

    reg {
        name = "Indirect write data register 0 0";
        desc = "ISP_GAMMAFE_WDATA0 is indirect write data register 0.

Data sheet 10.6 ISP_GAMMAFE_WDATA0 (offset 0x27484, printed page 10-232, `hi3518ev200--Hi3518EV20X-Hi3516CV200-Datasheet.txt` line 72701).";

        field {
            name = "gamma_wdata0";
            desc = "Write data of the 257-entry gamma FE LUT0";
            sw = rw;
            hw = r;
            reset = 0x0;
        } gamma_wdata0[31:0];
    } ISP_GAMMAFE_WDATA0 @ 0x7484;

    reg {
        name = "Indirect read address register 0";
        desc = "ISP_GAMMAFE_RADDR0 is indirect read address register 0.

Data sheet 10.6 ISP_GAMMAFE_RADDR0 (offset 0x27488, printed page 10-232, `hi3518ev200--Hi3518EV20X-Hi3516CV200-Datasheet.txt` line 72720).";

        field {
            name = "gamma_waddr0";
            desc = "Read address of the 257-entry gamma FE LUT0";
            sw = rw;
            hw = r;
            reset = 0x0;
        } gamma_waddr0[31:0];
    } ISP_GAMMAFE_RADDR0 @ 0x7488;

    reg {
        name = "Indirect read data register 0";
        desc = "ISP_GAMMAFE_RDATA0 is indirect read data register 0.

Data sheet 10.6 ISP_GAMMAFE_RDATA0 (offset 0x2748C, printed page 10-232, `hi3518ev200--Hi3518EV20X-Hi3516CV200-Datasheet.txt` line 72738).";

        field {
            name = "gamma_wdata0";
            desc = "Read data of the 257-entry gamma FE LUT0";
            sw = r;
            hw = w;
            reset = 0x0;
        } gamma_wdata0[31:0];
    } ISP_GAMMAFE_RDATA0 @ 0x748C;

    reg {
        name = "Indirect write address register 1 1";
        desc = "ISP_GAMMAFE_WADDR1 is indirect write address register 1.

Data sheet 10.6 ISP_GAMMAFE_WADDR1 (offset 0x27490, printed page 10-233, `hi3518ev200--Hi3518EV20X-Hi3516CV200-Datasheet.txt` line 72766).";

        field {
            name = "gamma_waddr1";
            desc = "Write address of the 33-entry gamma FE LUT1";
            sw = rw;
            hw = r;
            reset = 0x0;
        } gamma_waddr1[31:0];
    } ISP_GAMMAFE_WADDR1 @ 0x7490;

    reg {
        name = "Indirect write data register 1 1";
        desc = "ISP_GAMMAFE_WDATA1 is indirect write data register 1.

Data sheet 10.6 ISP_GAMMAFE_WDATA1 (offset 0x27494, printed page 10-233, `hi3518ev200--Hi3518EV20X-Hi3516CV200-Datasheet.txt` line 72785).";

        field {
            name = "gamma_wdata1";
            desc = "Write data of the 33-entry gamma FE LUT1";
            sw = rw;
            hw = r;
            reset = 0x0;
        } gamma_wdata1[31:0];
    } ISP_GAMMAFE_WDATA1 @ 0x7494;

    reg {
        name = "Indirect read address register 1";
        desc = "ISP_GAMMAFE_RADDR1 is indirect read address register 1.

Data sheet 10.6 ISP_GAMMAFE_RADDR1 (offset 0x27498, printed page 10-233, `hi3518ev200--Hi3518EV20X-Hi3516CV200-Datasheet.txt` line 72803).";

        field {
            name = "gamma_waddr1";
            desc = "Read address of the 33-entry gamma FE LUT1";
            sw = rw;
            hw = r;
            reset = 0x0;
        } gamma_waddr1[31:0];
    } ISP_GAMMAFE_RADDR1 @ 0x7498;

    reg {
        name = "Indirect read data register 1";
        desc = "ISP_GAMMAFE_RDATA1 is indirect read data register 1.

Data sheet 10.6 ISP_GAMMAFE_RDATA1 (offset 0x2749C, printed page 10-234, `hi3518ev200--Hi3518EV20X-Hi3516CV200-Datasheet.txt` line 72831).";

        field {
            name = "gamma_wdata1";
            desc = "Read data of the 33-entry gamma FE LUT1";
            sw = r;
            hw = w;
            reset = 0x0;
        } gamma_wdata1[31:0];
    } ISP_GAMMAFE_RDATA1 @ 0x749C;

    reg {
        name = "Expander configuration register";
        desc = "ISP_EXPANDER_CFG is an expander configuration register.

Data sheet 10.6 ISP_EXPANDER_CFG (offset 0x27500, printed page 10-234, `hi3518ev200--Hi3518EV20X-Hi3516CV200-Datasheet.txt` line 72850).";

        enum ISP_EXPANDER_CFG_en_enum {
            DISABLED = 0 { name = "Disabled"; desc = "disabled"; };
            ENABLED = 1 { name = "Enabled"; desc = "enabled"; };
        };

        field {
            name = "en";
            desc = "Expander enable";
            sw = rw;
            hw = r;
            encode = ISP_EXPANDER_CFG_en_enum;
            reset = 0x0;
        } en[0:0];
    } ISP_EXPANDER_CFG @ 0x7500;

    reg {
        name = "Data bit width configuration register";
        desc = "ISP_EXPANDER_BITW is a data bit width configuration register.

Data sheet 10.6 ISP_EXPANDER_BITW (offset 0x27510, printed page 10-234, `hi3518ev200--Hi3518EV20X-Hi3516CV200-Datasheet.txt` line 72871).";

        enum ISP_EXPANDER_BITW_bitw_in_enum {
            V_12_BITS = 0xC { name = "V 12 Bits"; desc = "12 bits"; };
            V_14_BITS_OTHER = 0xE { name = "V 14 Bits Other"; desc = "14 bits Other values: reserved"; };
        };

        field {
            name = "bitw_in";
            desc = "Bit width of the expander input data";
            sw = rw;
            hw = r;
            encode = ISP_EXPANDER_BITW_bitw_in_enum;
            reset = 0x0;
        } bitw_in[20:16];

        enum ISP_EXPANDER_BITW_bitw_out_enum {
            V_14_BITS = 0xE { name = "V 14 Bits"; desc = "14 bits"; };
            V_16_BITS = 0x10 { name = "V 16 Bits"; desc = "16 bits"; };
            V_18_BITS = 0x12 { name = "V 18 Bits"; desc = "18 bits"; };
            V_20_BITS_OTHER = 0x14 { name = "V 20 Bits Other"; desc = "20 bits Other values: reserved"; };
        };

        field {
            name = "bitw_out";
            desc = "Bit width of the expander output data";
            sw = rw;
            hw = r;
            encode = ISP_EXPANDER_BITW_bitw_out_enum;
            reset = 0x0;
        } bitw_out[4:0];
    } ISP_EXPANDER_BITW @ 0x7510;

    reg {
        name = "R channel data offset configuration R register";
        desc = "ISP_EXPANDER_OFFSETR is an R channel data offset configuration register.

Data sheet 10.6 ISP_EXPANDER_OFFSETR (offset 0x27514, printed page 10-235, `hi3518ev200--Hi3518EV20X-Hi3516CV200-Datasheet.txt` line 72913).";

        field {
            name = "offset_r";
            desc = "R channel data offset configuration";
            sw = rw;
            hw = r;
            reset = 0x0;
        } offset_r[19:0];
    } ISP_EXPANDER_OFFSETR @ 0x7514;

    reg {
        name = "Gr channel data offset configuration GR register";
        desc = "ISP_EXPANDER_OFFSETGR is a Gr channel data offset configuration register.

Data sheet 10.6 ISP_EXPANDER_OFFSETGR (offset 0x27518, printed page 10-235, `hi3518ev200--Hi3518EV20X-Hi3516CV200-Datasheet.txt` line 72933).";

        field {
            name = "offset_gr";
            desc = "Gr channel data offset configuration";
            sw = rw;
            hw = r;
            reset = 0x0;
        } offset_gr[19:0];
    } ISP_EXPANDER_OFFSETGR @ 0x7518;

    reg {
        name = "Gb channel data offset configuration GB register";
        desc = "ISP_EXPANDER_OFFSETGB is a Gb channel data offset configuration register.

Data sheet 10.6 ISP_EXPANDER_OFFSETGB (offset 0x2751C, printed page 10-236, `hi3518ev200--Hi3518EV20X-Hi3516CV200-Datasheet.txt` line 72962).";

        field {
            name = "offset_gb";
            desc = "Gb channel data offset configuration";
            sw = rw;
            hw = r;
            reset = 0x0;
        } offset_gb[19:0];
    } ISP_EXPANDER_OFFSETGB @ 0x751C;

    reg {
        name = "B channel data offset configuration B register";
        desc = "ISP_EXPANDER_OFFSETB is a B channel data offset configuration register.

Data sheet 10.6 ISP_EXPANDER_OFFSETB (offset 0x27520, printed page 10-236, `hi3518ev200--Hi3518EV20X-Hi3516CV200-Datasheet.txt` line 72982).";

        field {
            name = "offset_b";
            desc = "B channel data offset configuration";
            sw = rw;
            hw = r;
            reset = 0x0;
        } offset_b[19:0];
    } ISP_EXPANDER_OFFSETB @ 0x7520;

    reg {
        name = "Indirect write address register";
        desc = "ISP_EXPANDER_WADDR is an indirect write address register.

Data sheet 10.6 ISP_EXPANDER_WADDR (offset 0x27580, printed page 10-237, `hi3518ev200--Hi3518EV20X-Hi3516CV200-Datasheet.txt` line 73010).";

        field {
            name = "expander_waddr";
            desc = "Write address of the 129-entry expander LUT";
            sw = rw;
            hw = r;
            reset = 0x0;
        } expander_waddr[31:0];
    } ISP_EXPANDER_WADDR @ 0x7580;

    reg {
        name = "Indirect write data register";
        desc = "ISP_EXPANDER_WDATA is indirect write data register.

Data sheet 10.6 ISP_EXPANDER_WDATA (offset 0x27584, printed page 10-237, `hi3518ev200--Hi3518EV20X-Hi3516CV200-Datasheet.txt` line 73029).";

        field {
            name = "expander_wdata";
            desc = "Write data of the 129-entry expander LUT";
            sw = rw;
            hw = r;
            reset = 0x0;
        } expander_wdata[31:0];
    } ISP_EXPANDER_WDATA @ 0x7584;

    reg {
        name = "Indirect read address register";
        desc = "ISP_EXPANDER_RADDR is an indirect read address register.

Data sheet 10.6 ISP_EXPANDER_RADDR (offset 0x27588, printed page 10-237, `hi3518ev200--Hi3518EV20X-Hi3516CV200-Datasheet.txt` line 73047).";

        field {
            name = "expander_waddr";
            desc = "Read address of the 129-entry expander LUT";
            sw = rw;
            hw = r;
            reset = 0x0;
        } expander_waddr[31:0];
    } ISP_EXPANDER_RADDR @ 0x7588;

    reg {
        name = "Indirect read data register";
        desc = "ISP_EXPANDER_RDATA is indirect read data register.

Data sheet 10.6 ISP_EXPANDER_RDATA (offset 0x2758C, printed page 10-238, `hi3518ev200--Hi3518EV20X-Hi3516CV200-Datasheet.txt` line 73075).";

        field {
            name = "expander_wdata";
            desc = "Read data of the 129-entry expander LUT";
            sw = r;
            hw = w;
            reset = 0x0;
        } expander_wdata[31:0];
    } ISP_EXPANDER_RDATA @ 0x758C;

    reg {
        name = "Color bar control register";
        desc = "ISP_COLORBAR_CFG is a color bar control register.

Data sheet 10.6 ISP_COLORBAR_CFG (offset 0x28100, printed page 10-238, `hi3518ev200--Hi3518EV20X-Hi3516CV200-Datasheet.txt` line 73094).";

        enum ISP_COLORBAR_CFG_en_enum {
            DISABLED = 0 { name = "Disabled"; desc = "disabled"; };
            ENABLED = 1 { name = "Enabled"; desc = "enabled"; };
        };

        field {
            name = "en";
            desc = "Color bar enable";
            sw = rw;
            hw = r;
            encode = ISP_COLORBAR_CFG_en_enum;
            reset = 0x0;
        } en[0:0];
    } ISP_COLORBAR_CFG @ 0x8100;

    reg {
        name = "Color bar type register N";
        desc = "ISP_COLORBAR_PATTERN is a color bar type register.

Data sheet 10.6 ISP_COLORBAR_PATTERN (offset 0x28110, printed page 10-238, `hi3518ev200--Hi3518EV20X-Hi3516CV200-Datasheet.txt` line 73115).";

        enum ISP_COLORBAR_PATTERN_pattern_enum {
            PURE_COLOR_PICTURE = 0 { name = "Pure Color Picture"; desc = "pure color picture"; };
            PICTURE_CONSISTING_FOUR = 1 { name = "Picture Consisting Four"; desc = "picture consisting of four horizontal color stripes"; };
            PICTURE_CONSISTING_FOUR_2 = 2 { name = "Picture Consisting Four 2"; desc = "picture consisting of four vertical color stripes"; };
            PICTURE_CONSISTING_EIGHT = 3 { name = "Picture Consisting Eight"; desc = "picture consisting of eight vertical color stripes"; };
            RECTANGULAR_PURE_COLOR = 4 { name = "Rectangular Pure Color"; desc = "A rectangular pure color target area is generated on the pure color background. Other values: reserved"; };
        };

        field {
            name = "pattern";
            desc = "Color bar type";
            sw = rw;
            hw = r;
            encode = ISP_COLORBAR_PATTERN_pattern_enum;
            reset = 0x0;
        } pattern[2:0];
    } ISP_COLORBAR_PATTERN @ 0x8110;

    reg {
        name = "Color bar background color register GND";
        desc = "ISP_COLORBAR_RBACKGND is a color bar background color register.

Data sheet 10.6 ISP_COLORBAR_RBACKGND (offset 0x28114, printed page 10-239, `hi3518ev200--Hi3518EV20X-Hi3516CV200-Datasheet.txt` line 73155).";

        field {
            name = "rbackgnd";
            desc = "Background color of the R component";
            sw = rw;
            hw = r;
            reset = 0x0;
        } rbackgnd[15:0];
    } ISP_COLORBAR_RBACKGND @ 0x8114;

    reg {
        name = "Color bar background color register GND";
        desc = "ISP_COLORBAR_GBACKGND is a color bar background color register.

Data sheet 10.6 ISP_COLORBAR_GBACKGND (offset 0x28118, printed page 10-239, `hi3518ev200--Hi3518EV20X-Hi3516CV200-Datasheet.txt` line 73174).";

        field {
            name = "gbackgnd";
            desc = "Background color of the G component";
            sw = rw;
            hw = r;
            reset = 0x0;
        } gbackgnd[15:0];
    } ISP_COLORBAR_GBACKGND @ 0x8118;

    reg {
        name = "Color bar background color register GND";
        desc = "ISP_COLORBAR_BBACKGND is a color bar background color register.

Data sheet 10.6 ISP_COLORBAR_BBACKGND (offset 0x2811C, printed page 10-240, `hi3518ev200--Hi3518EV20X-Hi3516CV200-Datasheet.txt` line 73200).";

        field {
            name = "bbackgnd";
            desc = "Background color of the B component";
            sw = rw;
            hw = r;
            reset = 0x0;
        } bbackgnd[15:0];
    } ISP_COLORBAR_BBACKGND @ 0x811C;

    reg {
        name = "Color bar foreground color register GND";
        desc = "ISP_COLORBAR_RFOREGND is a color bar foreground color register.

Data sheet 10.6 ISP_COLORBAR_RFOREGND (offset 0x28120, printed page 10-240, `hi3518ev200--Hi3518EV20X-Hi3516CV200-Datasheet.txt` line 73220).";

        field {
            name = "rforegnd";
            desc = "Foreground color of the R component";
            sw = rw;
            hw = r;
            reset = 0x0;
        } rforegnd[15:0];
    } ISP_COLORBAR_RFOREGND @ 0x8120;

    reg {
        name = "Color bar foreground color register GND";
        desc = "ISP_COLORBAR_GFOREGND is a color bar foreground color register.

Data sheet 10.6 ISP_COLORBAR_GFOREGND (offset 0x28124, printed page 10-240, `hi3518ev200--Hi3518EV20X-Hi3516CV200-Datasheet.txt` line 73239).";

        field {
            name = "gforegnd";
            desc = "Foreground color of the G component";
            sw = rw;
            hw = r;
            reset = 0x0;
        } gforegnd[15:0];
    } ISP_COLORBAR_GFOREGND @ 0x8124;

    reg {
        name = "Color bar foreground color register GND";
        desc = "ISP_COLORBAR_BFOREGND is a color bar foreground color register.

Data sheet 10.6 ISP_COLORBAR_BFOREGND (offset 0x28128, printed page 10-241, `hi3518ev200--Hi3518EV20X-Hi3516CV200-Datasheet.txt` line 73268).";

        field {
            name = "bforegnd";
            desc = "Foreground color of the B component";
            sw = rw;
            hw = r;
            reset = 0x0;
        } bforegnd[15:0];
    } ISP_COLORBAR_BFOREGND @ 0x8128;

    reg {
        name = "Color bar initial value register";
        desc = "ISP_COLORBAR_INIT is a color bar initial value register.

Data sheet 10.6 ISP_COLORBAR_INIT (offset 0x2812C, printed page 10-241, `hi3518ev200--Hi3518EV20X-Hi3516CV200-Datasheet.txt` line 73288).";

        field {
            name = "rgbinit";
            desc = "Initial value of the R/G/B component";
            sw = rw;
            hw = r;
            reset = 0x0;
        } rgbinit[15:0];
    } ISP_COLORBAR_INIT @ 0x812C;

    reg {
        name = "Color bar increasing value register";
        desc = "ISP_COLORBAR_GRAD is a color bar increasing value register.

Data sheet 10.6 ISP_COLORBAR_GRAD (offset 0x28130, printed page 10-242, `hi3518ev200--Hi3518EV20X-Hi3516CV200-Datasheet.txt` line 73316).";

        field {
            name = "rgbgrad";
            desc = "Increasing value of the R/G/B component";
            sw = rw;
            hw = r;
            reset = 0x0;
        } rgbgrad[15:0];
    } ISP_COLORBAR_GRAD @ 0x8130;

    reg {
        name = "Color bar rectangle coordinate register";
        desc = "ISP_COLORBAR_POS1 is a color bar rectangle coordinate register.

Data sheet 10.6 ISP_COLORBAR_POS1 (offset 0x28134, printed page 10-242, `hi3518ev200--Hi3518EV20X-Hi3516CV200-Datasheet.txt` line 73336).";

        field {
            name = "pos_y1";
            desc = "Vertical start coordinate (y1) of the rectangle";
            sw = rw;
            hw = r;
            reset = 0x0;
        } pos_y1[28:16];

        field {
            name = "pos_x1";
            desc = "Horizontal start coordinate (x1) of the rectangle";
            sw = rw;
            hw = r;
            reset = 0x0;
        } pos_x1[12:0];
    } ISP_COLORBAR_POS1 @ 0x8134;

    reg {
        name = "Color bar rectangle coordinate register";
        desc = "ISP_COLORBAR_POS2 is a color bar rectangle coordinate register.

Data sheet 10.6 ISP_COLORBAR_POS2 (offset 0x28138, printed page 10-243, `hi3518ev200--Hi3518EV20X-Hi3516CV200-Datasheet.txt` line 73370).";

        field {
            name = "pos_y2";
            desc = "Vertical end coordinate (y2) of the rectangle";
            sw = rw;
            hw = r;
            reset = 0x0;
        } pos_y2[28:16];

        field {
            name = "pos_x2";
            desc = "Horizontal end coordinate (x2) of the rectangle";
            sw = rw;
            hw = r;
            reset = 0x0;
        } pos_x2[12:0];
    } ISP_COLORBAR_POS2 @ 0x8138;

    reg {
        name = "RGGB sequence register";
        desc = "ISP_COLORBAR_RGGB is an RGGB sequence register.

Data sheet 10.6 ISP_COLORBAR_RGGB (offset 0x2813C, printed page 10-243, `hi3518ev200--Hi3518EV20X-Hi3516CV200-Datasheet.txt` line 73395).";

        enum ISP_COLORBAR_RGGB_rggb_enum {
            R_GR_GB = 0 { name = "R Gr Gb"; desc = "R Gr Gb B"; };
            GR_R_B = 1 { name = "Gr R B"; desc = "Gr R B Gb"; };
            GB_B_R = 2 { name = "Gb B R"; desc = "Gb B R Gr"; };
            B_GB_GR = 3 { name = "B Gb Gr"; desc = "B Gb Gr R"; };
        };

        field {
            name = "rggb";
            desc = "RGGB sequence";
            sw = rw;
            hw = r;
            encode = ISP_COLORBAR_RGGB_rggb_enum;
            reset = 0x3;
        } rggb[1:0];
    } ISP_COLORBAR_RGGB @ 0x813C;

    reg {
        name = "YUV444 sum control register";
        desc = "ISP_YUV444SUM_CFG is a YUV444 sum control register.

Data sheet 10.6 ISP_YUV444SUM_CFG (offset 0x28200, printed page 10-244, `hi3518ev200--Hi3518EV20X-Hi3516CV200-Datasheet.txt` line 73429).";

        enum ISP_YUV444SUM_CFG_en_enum {
            DISABLED = 0 { name = "Disabled"; desc = "disabled"; };
            ENABLED = 1 { name = "Enabled"; desc = "enabled"; };
        };

        field {
            name = "en";
            desc = "FPGA sum enable";
            sw = rw;
            hw = r;
            encode = ISP_YUV444SUM_CFG_en_enum;
            reset = 0x1;
        } en[0:0];
    } ISP_YUV444SUM_CFG @ 0x8200;

    reg {
        name = "Data 0 sum lower 32 bits register";
        desc = "ISP_CROP_DATA0_0 is a data 0 sum lower 32 bits register.

Data sheet 10.6 ISP_CROP_DATA0_0 (offset 0x28210, printed page 10-244, `hi3518ev200--Hi3518EV20X-Hi3516CV200-Datasheet.txt` line 73451).";

        field {
            name = "data0_0";
            desc = "Lower 32 bits of the data 0 sum";
            sw = r;
            hw = w;
            reset = 0x0;
        } data0_0[31:0];
    } ISP_CROP_DATA0_0 @ 0x8210;

    reg {
        name = "Data 0 sum upper 32 bits register";
        desc = "ISP_CROP_DATA0_1 is a data 0 sum upper 32 bits register.

Data sheet 10.6 ISP_CROP_DATA0_1 (offset 0x28214, printed page 10-244, `hi3518ev200--Hi3518EV20X-Hi3516CV200-Datasheet.txt` line 73470).";

        field {
            name = "data0_1";
            desc = "Upper 32 bits of the data 0 sum";
            sw = r;
            hw = w;
            reset = 0x0;
        } data0_1[31:0];
    } ISP_CROP_DATA0_1 @ 0x8214;

    reg {
        name = "Data 1 sum lower 32 bits register";
        desc = "ISP_CROP_DATA1_0 is a data 1 sum lower 32 bits register.

Data sheet 10.6 ISP_CROP_DATA1_0 (offset 0x28218, printed page 10-245, `hi3518ev200--Hi3518EV20X-Hi3516CV200-Datasheet.txt` line 73495).";

        field {
            name = "data1_0";
            desc = "Lower 32 bits of the data 1 sum";
            sw = r;
            hw = w;
            reset = 0x0;
        } data1_0[31:0];
    } ISP_CROP_DATA1_0 @ 0x8218;

    reg {
        name = "Data 1 sum upper 32 bits register";
        desc = "ISP_CROP_DATA1_1 is a data 1 sum upper 32 bits register.

Data sheet 10.6 ISP_CROP_DATA1_1 (offset 0x2821C, printed page 10-245, `hi3518ev200--Hi3518EV20X-Hi3516CV200-Datasheet.txt` line 73514).";

        field {
            name = "data1_1";
            desc = "Upper 32 bits of the data 1 sum";
            sw = r;
            hw = w;
            reset = 0x0;
        } data1_1[31:0];
    } ISP_CROP_DATA1_1 @ 0x821C;

    reg {
        name = "Data 2 sum lower 32 bits register";
        desc = "ISP_CROP_DATA2_0 is a data 2 sum lower 32 bits register.

Data sheet 10.6 ISP_CROP_DATA2_0 (offset 0x28220, printed page 10-245, `hi3518ev200--Hi3518EV20X-Hi3516CV200-Datasheet.txt` line 73532).";

        field {
            name = "data2_0";
            desc = "Lower 32 bits of the data 2 sum";
            sw = r;
            hw = w;
            reset = 0x0;
        } data2_0[31:0];
    } ISP_CROP_DATA2_0 @ 0x8220;

    reg {
        name = "Data 2 sum upper 32 bits register";
        desc = "ISP_CROP_DATA2_1 is a data 2 sum upper 32 bits register.

Data sheet 10.6 ISP_CROP_DATA2_1 (offset 0x28224, printed page 10-246, `hi3518ev200--Hi3518EV20X-Hi3516CV200-Datasheet.txt` line 73557).";

        field {
            name = "data2_1";
            desc = "Upper 32 bits of the data 2 sum";
            sw = r;
            hw = w;
            reset = 0x0;
        } data2_1[31:0];
    } ISP_CROP_DATA2_1 @ 0x8224;

    reg {
        name = "Data FPN sum lower 32 bits register";
        desc = "ISP_CROP_DATAFPN_0 is a data FPN sum lower 32 bits register.

Data sheet 10.6 ISP_CROP_DATAFPN_0 (offset 0x28228, printed page 10-246, `hi3518ev200--Hi3518EV20X-Hi3516CV200-Datasheet.txt` line 73576).";

        field {
            name = "datafpn_0";
            desc = "Lower 32 bits of the data FPN sum";
            sw = r;
            hw = w;
            reset = 0x0;
        } datafpn_0[31:0];
    } ISP_CROP_DATAFPN_0 @ 0x8228;

    reg {
        name = "Data FPN sum upper 32 bits register";
        desc = "ISP_CROP_DATAFPN_1 is a data FPN sum upper 32 bits register.

Data sheet 10.6 ISP_CROP_DATAFPN_1 (offset 0x2822C, printed page 10-246, `hi3518ev200--Hi3518EV20X-Hi3516CV200-Datasheet.txt` line 73594).";

        field {
            name = "datafpn_1";
            desc = "Upper 32 bits of the data FPN sum";
            sw = r;
            hw = w;
            reset = 0x0;
        } datafpn_1[31:0];
    } ISP_CROP_DATAFPN_1 @ 0x822C;

    reg {
        name = "Data 0 sum lower 32 bits register";
        desc = "ISP_WB_DATA0_0 is a data 0 sum lower 32 bits register.

Data sheet 10.6 ISP_WB_DATA0_0 (offset 0x28230, printed page 10-247, `hi3518ev200--Hi3518EV20X-Hi3516CV200-Datasheet.txt` line 73619).";

        field {
            name = "data0_0";
            desc = "Lower 32 bits of the data 0 sum";
            sw = r;
            hw = w;
            reset = 0x0;
        } data0_0[31:0];
    } ISP_WB_DATA0_0 @ 0x8230;

    reg {
        name = "Data 0 sum upper 32 bits register";
        desc = "ISP_WB_DATA0_1 is a data 0 sum upper 32 bits register.

Data sheet 10.6 ISP_WB_DATA0_1 (offset 0x28234, printed page 10-247, `hi3518ev200--Hi3518EV20X-Hi3516CV200-Datasheet.txt` line 73638).";

        field {
            name = "data0_1";
            desc = "Upper 32 bits of the data 0 sum";
            sw = r;
            hw = w;
            reset = 0x0;
        } data0_1[31:0];
    } ISP_WB_DATA0_1 @ 0x8234;

    reg {
        name = "FPGA sum control register";
        desc = "ISP_YUV422SUM_CFG is an FPGA sum control register.

Data sheet 10.6 ISP_YUV422SUM_CFG (offset 0x28300, printed page 10-247, `hi3518ev200--Hi3518EV20X-Hi3516CV200-Datasheet.txt` line 73656).";

        enum ISP_YUV422SUM_CFG_en_enum {
            DISABLED = 0 { name = "Disabled"; desc = "disabled"; };
            ENABLED = 1 { name = "Enabled"; desc = "enabled"; };
        };

        field {
            name = "en";
            desc = "FPGA sum enable";
            sw = rw;
            hw = r;
            encode = ISP_YUV422SUM_CFG_en_enum;
            reset = 0x1;
        } en[0:0];
    } ISP_YUV422SUM_CFG @ 0x8300;

    reg {
        name = "Y component data sum lower 32 bits register";
        desc = "ISP_CLIP_Y_DATA0_0 is a Y component data sum lower 32 bits register.

Data sheet 10.6 ISP_CLIP_Y_DATA0_0 (offset 0x28310, printed page 10-248, `hi3518ev200--Hi3518EV20X-Hi3516CV200-Datasheet.txt` line 73688).";

        field {
            name = "data_y_0";
            desc = "Lower 32 bits of the Y component data sum";
            sw = r;
            hw = w;
            reset = 0x0;
        } data_y_0[31:0];
    } ISP_CLIP_Y_DATA0_0 @ 0x8310;

    reg {
        name = "Y component data sum upper 32 bits register";
        desc = "ISP_CLIP_Y_DATA0_1 is a Y component data sum upper 32 bits register.

Data sheet 10.6 ISP_CLIP_Y_DATA0_1 (offset 0x28314, printed page 10-248, `hi3518ev200--Hi3518EV20X-Hi3516CV200-Datasheet.txt` line 73707).";

        field {
            name = "data_y_1";
            desc = "Upper 32 bits of the Y component data sum";
            sw = r;
            hw = w;
            reset = 0x0;
        } data_y_1[31:0];
    } ISP_CLIP_Y_DATA0_1 @ 0x8314;

    reg {
        name = "C component data sum lower 32 bits register";
        desc = "ISP_CLIP_C_DATA0_0 is a C component data sum lower 32 bits register.

Data sheet 10.6 ISP_CLIP_C_DATA0_0 (offset 0x28318, printed page 10-249, `hi3518ev200--Hi3518EV20X-Hi3516CV200-Datasheet.txt` line 73735).";

        field {
            name = "data_c_0";
            desc = "Lower 32 bits of the C component data sum";
            sw = r;
            hw = w;
            reset = 0x0;
        } data_c_0[31:0];
    } ISP_CLIP_C_DATA0_0 @ 0x8318;

    reg {
        name = "C component data sum upper 32 bits register";
        desc = "ISP_CLIP_C_DATA0_1 is a C component data sum upper 32 bits register.

Data sheet 10.6 ISP_CLIP_C_DATA0_1 (offset 0x2831C, printed page 10-249, `hi3518ev200--Hi3518EV20X-Hi3516CV200-Datasheet.txt` line 73754).";

        field {
            name = "data_c_1";
            desc = "Upper 32 bits of the C component data sum";
            sw = r;
            hw = w;
            reset = 0x0;
        } data_c_1[31:0];
    } ISP_CLIP_C_DATA0_1 @ 0x831C;

    reg {
        name = "Data 0 sum lower 32 bits register ATA0_0";
        desc = "ISP_YUV422_SWITCH_DATA0_0 is a data 0 sum lower 32 bits register.

Data sheet 10.6 ISP_YUV422_SWITCH_DATA0_0 (offset 0x28320, printed page 10-249, `hi3518ev200--Hi3518EV20X-Hi3516CV200-Datasheet.txt` line 73772).";

        field {
            name = "data0_0";
            desc = "Lower 32 bits of the data 0 sum";
            sw = r;
            hw = w;
            reset = 0x0;
        } data0_0[31:0];
    } ISP_YUV422_SWITCH_DATA0_0 @ 0x8320;

    reg {
        name = "Data 0 sum upper 32 bits register ATA0_1";
        desc = "ISP_YUV422_SWITCH_DATA0_1 is a data 0 sum upper 32 bits register.

Data sheet 10.6 ISP_YUV422_SWITCH_DATA0_1 (offset 0x28324, printed page 10-250, `hi3518ev200--Hi3518EV20X-Hi3516CV200-Datasheet.txt` line 73800).";

        field {
            name = "data0_1";
            desc = "Upper 32 bits of the data 0 sum";
            sw = r;
            hw = w;
            reset = 0x0;
        } data0_1[31:0];
    } ISP_YUV422_SWITCH_DATA0_1 @ 0x8324;

    reg {
        name = "Data 1 sum lower 32 bits register ATA1_0";
        desc = "ISP_YUV422_SWITCH_DATA1_0 is a data 1 sum lower 32 bits register.

Data sheet 10.6 ISP_YUV422_SWITCH_DATA1_0 (offset 0x28328, printed page 10-250, `hi3518ev200--Hi3518EV20X-Hi3516CV200-Datasheet.txt` line 73819).";

        field {
            name = "data1_0";
            desc = "Lower 32 bits of the data 1 sum";
            sw = r;
            hw = w;
            reset = 0x0;
        } data1_0[31:0];
    } ISP_YUV422_SWITCH_DATA1_0 @ 0x8328;

    reg {
        name = "Data 1 sum upper 32 bits register ATA1_1";
        desc = "ISP_YUV422_SWITCH_DATA1_1 is a data 1 sum upper 32 bits register.

Data sheet 10.6 ISP_YUV422_SWITCH_DATA1_1 (offset 0x2832C, printed page 10-250, `hi3518ev200--Hi3518EV20X-Hi3516CV200-Datasheet.txt` line 73837).";

        field {
            name = "data1_1";
            desc = "Upper 32 bits of the data 1 sum";
            sw = r;
            hw = w;
            reset = 0x0;
        } data1_1[31:0];
    } ISP_YUV422_SWITCH_DATA1_1 @ 0x832C;

    reg {
        name = "Data 2 sum lower 32 bits register ATA2_0";
        desc = "ISP_YUV422_SWITCH_DATA2_0 is a data 2 sum lower 32 bits register.

Data sheet 10.6 ISP_YUV422_SWITCH_DATA2_0 (offset 0x28330, printed page 10-251, `hi3518ev200--Hi3518EV20X-Hi3516CV200-Datasheet.txt` line 73865).";

        field {
            name = "data2_0";
            desc = "Lower 32 bits of the data 2 sum";
            sw = r;
            hw = w;
            reset = 0x0;
        } data2_0[31:0];
    } ISP_YUV422_SWITCH_DATA2_0 @ 0x8330;

    reg {
        name = "Data 2 sum upper 32 bits register ATA2_1";
        desc = "ISP_YUV422_SWITCH_DATA2_1 is a data 2 sum upper 32 bits register.

Data sheet 10.6 ISP_YUV422_SWITCH_DATA2_1 (offset 0x28334, printed page 10-251, `hi3518ev200--Hi3518EV20X-Hi3516CV200-Datasheet.txt` line 73884).";

        field {
            name = "data2_1";
            desc = "Upper 32 bits of the data 2 sum";
            sw = r;
            hw = w;
            reset = 0x0;
        } data2_1[31:0];
    } ISP_YUV422_SWITCH_DATA2_1 @ 0x8334;

    reg {
        name = "YUV444 timing adaptation register";
        desc = "ISP_ADAPTER444_CFG is a YUV444 timing adaptation register.

Data sheet 10.6 ISP_ADAPTER444_CFG (offset 0x31010, printed page 10-251, `hi3518ev200--Hi3518EV20X-Hi3516CV200-Datasheet.txt` line 73902).";

        enum ISP_ADAPTER444_CFG_vsync_mode_enum {
            NO = 0 { name = "No"; desc = "no"; };
            YES = 1 { name = "Yes"; desc = "yes"; };
        };

        field {
            name = "vsync_mode";
            desc = "Whether to perform delay processing on the vsync signal";
            sw = rw;
            hw = r;
            encode = ISP_ADAPTER444_CFG_vsync_mode_enum;
            reset = 0x0;
        } vsync_mode[1:1];

        enum ISP_ADAPTER444_CFG_hsync_mode_enum {
            NO = 0 { name = "No"; desc = "no"; };
            YES = 1 { name = "Yes"; desc = "yes"; };
        };

        field {
            name = "hsync_mode";
            desc = "Whether to perform delay processing on the hsync signal";
            sw = rw;
            hw = r;
            encode = ISP_ADAPTER444_CFG_hsync_mode_enum;
            reset = 0x0;
        } hsync_mode[0:0];
    } ISP_ADAPTER444_CFG @ 0x11010;

    reg {
        name = "Input picture luminance statistics register";
        desc = "ISP_SUM_Y is an input picture luminance statistics register.

Data sheet 10.6 ISP_SUM_Y (offset 0x31020, printed page 10-252, `hi3518ev200--Hi3518EV20X-Hi3516CV200-Datasheet.txt` line 73943).";

        field {
            name = "sum_y";
            desc = "Luminance statistics";
            sw = r;
            hw = w;
            reset = 0x0;
        } sum_y[31:0];
    } ISP_SUM_Y @ 0x11020;

    reg {
        name = "Crop enable register";
        desc = "ISP_CROP_CFG is a crop enable register.

Data sheet 10.6 ISP_CROP_CFG (offset 0x31100, printed page 10-252, `hi3518ev200--Hi3518EV20X-Hi3516CV200-Datasheet.txt` line 73961).";

        field {
            name = "n0_en";
            desc = "Region 0 enable";
            sw = rw;
            hw = r;
            reset = 0x0;
        } n0_en[0:0];
    } ISP_CROP_CFG @ 0x11100;

    reg {
        name = "Crop start position register for region 0";
        desc = "ISP_CROP0_START is a crop start position register for region 0.

Data sheet 10.6 ISP_CROP0_START (offset 0x31110, printed page 10-253, `hi3518ev200--Hi3518EV20X-Hi3516CV200-Datasheet.txt` line 73989).";

        field {
            name = "y_start";
            desc = "ID of the line from which the picture starts to be captured";
            sw = rw;
            hw = r;
            reset = 0x0;
        } y_start[28:16];

        field {
            name = "x_start";
            desc = "ID of the pixel from which the picture starts to be captured";
            sw = rw;
            hw = r;
            reset = 0x0;
        } x_start[12:0];
    } ISP_CROP0_START @ 0x11110;

    reg {
        name = "Crop size configuration register for region 0";
        desc = "ISP_CROP0_SIZE is a crop size configuration register for region 0.

Data sheet 10.6 ISP_CROP0_SIZE (offset 0x31114, printed page 10-253, `hi3518ev200--Hi3518EV20X-Hi3516CV200-Datasheet.txt` line 74014).";

        field {
            name = "height";
            desc = "Height (in line) of the obtained picture. The configured value is the actual value minus 1.";
            sw = rw;
            hw = r;
            reset = 0x0;
        } height[28:16];

        field {
            name = "width";
            desc = "Width (in pixel) of the obtained picture. The configured value is the actual value minus 1.";
            sw = rw;
            hw = r;
            reset = 0x0;
        } width[12:0];
    } ISP_CROP0_SIZE @ 0x11114;

    reg {
        name = "ACM control register";
        desc = "ISP_ACM_CTRL is an ACM control register.

Data sheet 10.6 ISP_ACM_CTRL (offset 0x31400, printed page 10-254, `hi3518ev200--Hi3518EV20X-Hi3516CV200-Datasheet.txt` line 74052).";

        enum ISP_ACM_CTRL_acm_en_enum {
            DISABLED = 0 { name = "Disabled"; desc = "disabled (data output bypassed)"; };
            ENABLED = 1 { name = "Enabled"; desc = "enabled (implementing luminance and contrast adjustment)"; };
        };

        field {
            name = "acm_en";
            desc = "ACM enable";
            sw = rw;
            hw = r;
            encode = ISP_ACM_CTRL_acm_en_enum;
            reset = 0x0;
        } acm_en[31:31];

        field {
            name = "acm_dbg_en";
            desc = "ACM debugging enable. When acm_dbg_en is valid, the original picture is displayed on the left part of the screen, and the picture processed by ABC is displayed on the right part of the screen.";
            sw = rw;
            hw = r;
            reset = 0x0;
        } acm_dbg_en[30:30];

        enum ISP_ACM_CTRL_acm_stretch_enum {
            Y_64_940 = 0 { name = "Y 64 940"; desc = "Y 64-940, C 64-960"; };
            Y_0_1023 = 1 { name = "Y 0 1023"; desc = "Y 0-1023, C 0-1023"; };
        };

        field {
            name = "acm_stretch";
            desc = "Input pixel range";
            sw = rw;
            hw = r;
            encode = ISP_ACM_CTRL_acm_stretch_enum;
            reset = 0x0;
        } acm_stretch[29:29];

        enum ISP_ACM_CTRL_acm_cliprange_enum {
            Y_64_940 = 0 { name = "Y 64 940"; desc = "Y 64-940, C 64-960"; };
            Y_0_1023 = 1 { name = "Y 0 1023"; desc = "Y 0-1023, C 0-1023"; };
        };

        field {
            name = "acm_cliprange";
            desc = "Output pixel range";
            sw = rw;
            hw = r;
            encode = ISP_ACM_CTRL_acm_cliprange_enum;
            reset = 0x0;
        } acm_cliprange[28:28];

        enum ISP_ACM_CTRL_acm_cliporwrap_enum {
            HUE_COMPONENT_WRAPPED = 0 { name = "Hue Component Wrapped"; desc = "The hue component is wrapped around to fall within [0, 1023]."; };
            HUE_COMPONENT_CLIPPED = 1 { name = "Hue Component Clipped"; desc = "The hue component is clipped to fall within [0, 1023]."; };
        };

        field {
            name = "acm_cliporwrap";
            desc = "Hue component value limit after ACM";
            sw = rw;
            hw = r;
            encode = ISP_ACM_CTRL_acm_cliporwrap_enum;
            reset = 0x0;
        } acm_cliporwrap[27:27];

        field {
            name = "acm_cbcrthr";
            desc = "ACM algorithm adjustment enable threshold. It is a 9-bit unsigned number and ranges from 0 to 255.";
            sw = rw;
            hw = r;
            reset = 0x0;
        } acm_cbcrthr[7:0];
    } ISP_ACM_CTRL @ 0x11400;

    reg {
        name = "ACM processed pixel change register";
        desc = "ISP_ACM_ADJ is an ACM processed pixel change register.

Data sheet 10.6 ISP_ACM_ADJ (offset 0x31404, printed page 10-255, `hi3518ev200--Hi3518EV20X-Hi3516CV200-Datasheet.txt` line 74104).";

        field {
            name = "acm_gain0";
            desc = "Control coefficient of the luminance adjustment range. The value range is 0-512.";
            sw = rw;
            hw = r;
            reset = 0x0;
        } acm_gain0[29:20];

        field {
            name = "acm_gain1";
            desc = "Control coefficient of the hue adjustment range. The value range is 0-512.";
            sw = rw;
            hw = r;
            reset = 0x0;
        } acm_gain1[19:10];

        field {
            name = "acm_gain2";
            desc = "Control coefficient of the saturation adjustment range. The value range is 0-512.";
            sw = rw;
            hw = r;
            reset = 0x0;
        } acm_gain2[9:0];
    } ISP_ACM_ADJ @ 0x11404;

    reg {
        name = "ACM processed picture size register";
        desc = "ISP_ACM_SIZE is an ACM processed picture size register.

Data sheet 10.6 ISP_ACM_SIZE (offset 0x31410, printed page 10-255, `hi3518ev200--Hi3518EV20X-Hi3516CV200-Datasheet.txt` line 74135).";

        field {
            name = "height";
            desc = "Picture height (in pixel). The configured value is the actual value minus 1.";
            sw = rw;
            hw = r;
            reset = 0x0;
        } height[28:16];

        field {
            name = "width";
            desc = "Picture width (in pixel). The configured value is the actual value minus 1.";
            sw = rw;
            hw = r;
            reset = 0x0;
        } width[12:0];
    } ISP_ACM_SIZE @ 0x11410;

    reg {
        name = "ACM coefficient configuration loading address register";
        desc = "ISP_ACM_PARA_ADDR is an ACM coefficient configuration loading address register.

Data sheet 10.6 ISP_ACM_PARA_ADDR (offset 0x31414, printed page 10-256, `hi3518ev200--Hi3518EV20X-Hi3516CV200-Datasheet.txt` line 74170).";

        field {
            name = "acm_para_addr";
            desc = "Address for loading ACM coefficients";
            sw = rw;
            hw = r;
            reset = 0x0;
        } acm_para_addr[31:0];
    } ISP_ACM_PARA_ADDR @ 0x11414;

    reg {
        name = "ACM coefficient configuration update register";
        desc = "ISP_ACM_PARA_UP is an ACM coefficient configuration update register.

Data sheet 10.6 ISP_ACM_PARA_UP (offset 0x31420, printed page 10-256, `hi3518ev200--Hi3518EV20X-Hi3516CV200-Datasheet.txt` line 74189).";

        field {
            name = "para_up";
            desc = "Parameter update. This bit is automatically cleared for each frame.";
            sw = rw;
            hw = r;
            reset = 0x0;
        } para_up[0:0];
    } ISP_ACM_PARA_UP @ 0x11420;

    reg {
        name = "DCI control register";
        desc = "ISP_VPDCICTRL is a DCI control register.

Data sheet 10.6 ISP_VPDCICTRL (offset 0x31C00, printed page 10-257, `hi3518ev200--Hi3518EV20X-Hi3516CV200-Datasheet.txt` line 74220).";

        enum ISP_VPDCICTRL_dci_en_enum {
            DISABLED = 0 { name = "Disabled"; desc = "disabled (data output bypassed)"; };
            ENABLED = 1 { name = "Enabled"; desc = "enabled (implementing luminance and contrast adjustment)"; };
        };

        field {
            name = "dci_en";
            desc = "DCI enable";
            sw = rw;
            hw = r;
            encode = ISP_VPDCICTRL_dci_en_enum;
            reset = 0x0;
        } dci_en[31:31];

        enum ISP_VPDCICTRL_dci_dbg_en_enum {
            DISABLED = 0 { name = "Disabled"; desc = "disabled"; };
            ORIGINAL_PICTURE_DISPLAYED = 1 { name = "Original Picture Displayed"; desc = "The original picture is displayed on the left part of the screen, and the picture processed by the DCI is displayed on the right part of the screen."; };
        };

        field {
            name = "dci_dbg_en";
            desc = "DCI demo mode enable";
            sw = rw;
            hw = r;
            encode = ISP_VPDCICTRL_dci_dbg_en_enum;
            reset = 0x0;
        } dci_dbg_en[30:30];

        enum ISP_VPDCICTRL_dci_scene_flg_enum {
            DISABLED = 0 { name = "Disabled"; desc = "disabled"; };
            ENABLED = 1 { name = "Enabled"; desc = "enabled"; };
        };

        field {
            name = "dci_scene_flg";
            desc = "DCI scenario switch enable";
            sw = rw;
            hw = r;
            encode = ISP_VPDCICTRL_dci_scene_flg_enum;
            reset = 0x0;
        } dci_scene_flg[29:29];

        enum ISP_VPDCICTRL_dci_man_adj0_enum {
            AUTOMATIC_MODE_RESULT = 0 { name = "Automatic Mode Result"; desc = "automatic mode. The result calculated by hardware is used."; };
            MANUAL_MODE_RESULT = 1 { name = "Manual Mode Result"; desc = "manual mode. The result configured by software is used."; };
        };

        field {
            name = "dci_man_adj0";
            desc = "Adjustment mode of curve 0";
            sw = rw;
            hw = r;
            encode = ISP_VPDCICTRL_dci_man_adj0_enum;
            reset = 0x0;
        } dci_man_adj0[28:28];

        enum ISP_VPDCICTRL_dci_man_adj1_enum {
            AUTOMATIC_MODE_RESULT = 0 { name = "Automatic Mode Result"; desc = "automatic mode. The result calculated by hardware is used."; };
            MANUAL_MODE_RESULT = 1 { name = "Manual Mode Result"; desc = "manual mode. The result configured by software is used."; };
        };

        field {
            name = "dci_man_adj1";
            desc = "Adjustment mode of curve 1";
            sw = rw;
            hw = r;
            encode = ISP_VPDCICTRL_dci_man_adj1_enum;
            reset = 0x0;
        } dci_man_adj1[27:27];

        enum ISP_VPDCICTRL_dci_man_adj2_enum {
            AUTOMATIC_MODE_RESULT = 0 { name = "Automatic Mode Result"; desc = "automatic mode. The result calculated by hardware is used."; };
            MANUAL_MODE_RESULT = 1 { name = "Manual Mode Result"; desc = "manual mode. The result configured by software is used."; };
        };

        field {
            name = "dci_man_adj2";
            desc = "Adjustment mode of curve 2";
            sw = rw;
            hw = r;
            encode = ISP_VPDCICTRL_dci_man_adj2_enum;
            reset = 0x0;
        } dci_man_adj2[26:26];

        enum ISP_VPDCICTRL_dci_cbcrcmp_en_enum {
            DCI_ALGORITHM_DOES = 0 { name = "Dci Algorithm Does"; desc = "The DCI algorithm does not adjust the chrominance component."; };
            DCI_ALGORITHM_ADJUSTS = 1 { name = "Dci Algorithm Adjusts"; desc = "The DCI algorithm adjusts the chrominance component."; };
        };

        field {
            name = "dci_cbcrcmp_en";
            desc = "DCI chrominance compensation enable";
            sw = rw;
            hw = r;
            encode = ISP_VPDCICTRL_dci_cbcrcmp_en_enum;
            reset = 0x0;
        } dci_cbcrcmp_en[25:25];

        enum ISP_VPDCICTRL_dci_cbcrsta_en_enum {
            HISTOGRAM_STATISTICS_COLLECTED = 0 { name = "Histogram Statistics Collected"; desc = "Histogram statistics are collected only on the luminance component."; };
            HISTOGRAM_STATISTICS_COLLECTED_2 = 1 { name = "Histogram Statistics Collected 2"; desc = "Histogram statistics are collected on the weighted Y, Cb, and Cr components."; };
        };

        field {
            name = "dci_cbcrsta_en";
            desc = "Histogram statistics select";
            sw = rw;
            hw = r;
            encode = ISP_VPDCICTRL_dci_cbcrsta_en_enum;
            reset = 0x0;
        } dci_cbcrsta_en[24:24];

        enum ISP_VPDCICTRL_dci_in_range_enum {
            LIMITED_RANGE = 0 { name = "Limited Range"; desc = "limited range (Y ranges from 64 to 940 and C ranges from 64 to 960 for the input 10-bit pixel data)"; };
            FULL_RANGE = 1 { name = "Full Range"; desc = "full range (Y ranges from 0 to 1023 and C ranges from 0 to 1023 for the input 10-bit pixel data)"; };
        };

        field {
            name = "dci_in_range";
            desc = "Input range";
            sw = rw;
            hw = r;
            encode = ISP_VPDCICTRL_dci_in_range_enum;
            reset = 0x0;
        } dci_in_range[23:23];

        enum ISP_VPDCICTRL_dci_out_range_enum {
            LIMITED_RANGE = 0 { name = "Limited Range"; desc = "limited range (Y ranges from 64 to 940 and C ranges from 64 to 960 for the output 10-bit pixel data)"; };
            FULL_RANGE = 1 { name = "Full Range"; desc = "full range (Y ranges from 0 to 1023 and C ranges from 0 to 1023 for the output 10-bit pixel data)"; };
        };

        field {
            name = "dci_out_range";
            desc = "Output range";
            sw = rw;
            hw = r;
            encode = ISP_VPDCICTRL_dci_out_range_enum;
            reset = 0x0;
        } dci_out_range[22:22];

        enum ISP_VPDCICTRL_dci_shift_ctrl_enum {
            SHIFTED_RIGHTWARDS_6 = 0 { name = "Shifted Rightwards 6"; desc = "shifted rightwards by 6 bits"; };
            SHIFTED_RIGHTWARDS_7 = 1 { name = "Shifted Rightwards 7"; desc = "shifted rightwards by 7 bits"; };
            SHIFTED_RIGHTWARDS_8 = 2 { name = "Shifted Rightwards 8"; desc = "shifted rightwards by 8 bits"; };
            SHIFTED_RIGHTWARDS_9 = 3 { name = "Shifted Rightwards 9"; desc = "shifted rightwards by 9 bits"; };
        };

        field {
            name = "dci_shift_ctrl";
            desc = "DCI histogram statistics shift control";
            sw = rw;
            hw = r;
            encode = ISP_VPDCICTRL_dci_shift_ctrl_enum;
            reset = 0x0;
        } dci_shift_ctrl[21:20];

        enum ISP_VPDCICTRL_dci_histlpf_en_enum {
            DISABLED = 0 { name = "Disabled"; desc = "disabled"; };
            ENABLED = 1 { name = "Enabled"; desc = "enabled"; };
        };

        field {
            name = "dci_histlpf_en";
            desc = "Histogram low-pass filtering enable";
            sw = rw;
            hw = r;
            encode = ISP_VPDCICTRL_dci_histlpf_en_enum;
            reset = 0x0;
        } dci_histlpf_en[19:19];
    } ISP_VPDCICTRL @ 0x11C00;

    reg {
        name = "DCI algorithm horizontal adjustment region register";
        desc = "ISP_VPDCIHPOS is a DCI algorithm horizontal adjustment region register.

Data sheet 10.6 ISP_VPDCIHPOS (offset 0x31C04, printed page 10-258, `hi3518ev200--Hi3518EV20X-Hi3516CV200-Datasheet.txt` line 74302).";

        field {
            name = "dci_hstart";
            desc = "Start value of the DCI algorithm horizontal active region";
            sw = rw;
            hw = r;
            reset = 0x0;
        } dci_hstart[31:20];

        field {
            name = "dci_hend";
            desc = "End value of the DCI algorithm horizontal active region";
            sw = rw;
            hw = r;
            reset = 0x0;
        } dci_hend[19:8];
    } ISP_VPDCIHPOS @ 0x11C04;

    reg {
        name = "DCI algorithm vertical adjustment region register";
        desc = "ISP_VPDCIVPOS is a DCI algorithm vertical adjustment region register.

Data sheet 10.6 ISP_VPDCIVPOS (offset 0x31C08, printed page 10-259, `hi3518ev200--Hi3518EV20X-Hi3516CV200-Datasheet.txt` line 74331).";

        field {
            name = "dci_vstart";
            desc = "Start value of the DCI algorithm vertical active region";
            sw = rw;
            hw = r;
            reset = 0x0;
        } dci_vstart[31:20];

        field {
            name = "dci_vend";
            desc = "End value of the DCI algorithm vertical active region";
            sw = rw;
            hw = r;
            reset = 0x0;
        } dci_vend[19:8];
    } ISP_VPDCIVPOS @ 0x11C08;

    reg {
        name = "DCI histogram statistics weighted coefficient register";
        desc = "ISP_VPDCIHISBLD is a DCI histogram statistics weighted coefficient register.

Data sheet 10.6 ISP_VPDCIHISBLD (offset 0x31C0C, printed page 10-259, `hi3518ev200--Hi3518EV20X-Hi3516CV200-Datasheet.txt` line 74351).";

        field {
            name = "dci_cbcrsta_y";
            desc = "Weighted coefficient of the Y component when histogram statistics are added. It is an 8-bit signed number and the most significant bit (MSB) is the sign bit.";
            sw = rw;
            hw = r;
            reset = 0x0;
        } dci_cbcrsta_y[31:24];

        field {
            name = "dci_cbcrsta_cb";
            desc = "Weighted coefficient of the Cb component when histogram statistics are added. It is an 8-bit signed number and the MSB is the sign bit.";
            sw = rw;
            hw = r;
            reset = 0x0;
        } dci_cbcrsta_cb[23:16];

        field {
            name = "dci_cbcrsta_cr";
            desc = "Weighted coefficient of the Cr component when histogram statistics are added. It is an 8-bit signed number and the MSB is the sign bit.";
            sw = rw;
            hw = r;
            reset = 0x0;
        } dci_cbcrsta_cr[15:8];
    } ISP_VPDCIHISBLD @ 0x11C0C;

    reg {
        name = "DCI histogram statistics offset register";
        desc = "ISP_VPDCIHISOFT is a DCI histogram statistics offset register.

Data sheet 10.6 ISP_VPDCIHISOFT (offset 0x31C10, printed page 10-260, `hi3518ev200--Hi3518EV20X-Hi3516CV200-Datasheet.txt` line 74384).";

        field {
            name = "dci_cbcrsta_oft";
            desc = "dci_cbcrsta_oft";
            sw = rw;
            hw = r;
            reset = 0x0;
        } dci_cbcrsta_oft[31:23];
    } ISP_VPDCIHISOFT @ 0x11C10;

    reg {
        name = "DCI histogram coring register";
        desc = "ISP_VPDCIHISCOR is a DCI histogram coring register.

Data sheet 10.6 ISP_VPDCIHISCOR (offset 0x31C14, printed page 10-260, `hi3518ev200--Hi3518EV20X-Hi3516CV200-Datasheet.txt` line 74406).";

        field {
            name = "dci_histcor_thr0";
            desc = "Coring threshold for histogram 0";
            sw = rw;
            hw = r;
            reset = 0x0;
        } dci_histcor_thr0[31:24];

        field {
            name = "dci_histcor_thr1";
            desc = "Coring threshold for histogram 1";
            sw = rw;
            hw = r;
            reset = 0x0;
        } dci_histcor_thr1[23:16];

        field {
            name = "dci_histcor_thr2";
            desc = "Coring threshold for histogram 2";
            sw = rw;
            hw = r;
            reset = 0x0;
        } dci_histcor_thr2[15:8];
    } ISP_VPDCIHISCOR @ 0x11C14;

    reg {
        name = "DCI adjustment unit blend value register";
        desc = "ISP_VPDCIMERBLD is a DCI adjustment unit blend value register.

Data sheet 10.6 ISP_VPDCIMERBLD (offset 0x31C18, printed page 10-261, `hi3518ev200--Hi3518EV20X-Hi3516CV200-Datasheet.txt` line 74437).";

        field {
            name = "dci_metrc_abld0";
            desc = "Weighted alpha blend value of the current frame for metric 0";
            sw = rw;
            hw = r;
            reset = 0x0;
        } dci_metrc_abld0[31:26];

        field {
            name = "dci_metrc_abld1";
            desc = "Weighted alpha blend value of the current frame for metric 1";
            sw = rw;
            hw = r;
            reset = 0x0;
        } dci_metrc_abld1[25:20];

        field {
            name = "dci_metrc_abld2";
            desc = "Weighted alpha blend value of the current frame for metric 2";
            sw = rw;
            hw = r;
            reset = 0x0;
        } dci_metrc_abld2[19:14];

        field {
            name = "dci_hist_abld";
            desc = "Weighted alpha blend value of the current histogram and the previous histogram";
            sw = rw;
            hw = r;
            reset = 0x0;
        } dci_hist_abld[13:8];

        field {
            name = "dci_org_abld";
            desc = "Alpha blend value when the luminance component is adjusted";
            sw = rw;
            hw = r;
            reset = 0x0;
        } dci_org_abld[7:2];
    } ISP_VPDCIMERBLD @ 0x11C18;

    reg {
        name = "DCI manually configured curve weight register";
        desc = "ISP_VPDCIADJWGT is a DCI manually configured curve weight register.

Data sheet 10.6 ISP_VPDCIADJWGT (offset 0x31C1C, printed page 10-261, `hi3518ev200--Hi3518EV20X-Hi3516CV200-Datasheet.txt` line 74465).";

        field {
            name = "dci_man_adjwgt0";
            desc = "Weighted value of curve 0 in manual mode";
            sw = rw;
            hw = r;
            reset = 0x0;
        } dci_man_adjwgt0[31:24];

        field {
            name = "dci_man_adjwgt1";
            desc = "Weighted value of curve 1 in manual mode";
            sw = rw;
            hw = r;
            reset = 0x0;
        } dci_man_adjwgt1[23:16];

        field {
            name = "dci_man_adjwgt2";
            desc = "Weighted value of curve 2 in manual mode";
            sw = rw;
            hw = r;
            reset = 0x0;
        } dci_man_adjwgt2[15:8];
    } ISP_VPDCIADJWGT @ 0x11C1C;

    reg {
        name = "DCI curve 0 weight range register";
        desc = "ISP_VPDCICLIP0 is a DCI curve 0 weight range register.

Data sheet 10.6 ISP_VPDCICLIP0 (offset 0x31C20, printed page 10-262, `hi3518ev200--Hi3518EV20X-Hi3516CV200-Datasheet.txt` line 74495).";

        field {
            name = "dci_wgt_cliplow0";
            desc = "Lower limit of the weighted value of curve 0";
            sw = rw;
            hw = r;
            reset = 0x0;
        } dci_wgt_cliplow0[31:24];

        field {
            name = "dci_wgt_cliphigh0";
            desc = "Upper limit of the weighted value of curve 0";
            sw = rw;
            hw = r;
            reset = 0x0;
        } dci_wgt_cliphigh0[23:16];
    } ISP_VPDCICLIP0 @ 0x11C20;

    reg {
        name = "DCI curve 1 weight range register";
        desc = "ISP_VPDCICLIP1 is a DCI curve 1 weight range register.

Data sheet 10.6 ISP_VPDCICLIP1 (offset 0x31C24, printed page 10-262, `hi3518ev200--Hi3518EV20X-Hi3516CV200-Datasheet.txt` line 74516).";

        field {
            name = "dci_wgt_cliplow1";
            desc = "Lower limit of the weighted value of curve 1";
            sw = rw;
            hw = r;
            reset = 0x0;
        } dci_wgt_cliplow1[31:24];

        field {
            name = "dci_wgt_cliphigh1";
            desc = "Upper limit of the weighted value of curve 1";
            sw = rw;
            hw = r;
            reset = 0x0;
        } dci_wgt_cliphigh1[23:16];
    } ISP_VPDCICLIP1 @ 0x11C24;

    reg {
        name = "DCI curve 2 weight range register";
        desc = "ISP_VPDCICLIP2 is a DCI curve 2 weight range register.

Data sheet 10.6 ISP_VPDCICLIP2 (offset 0x31C28, printed page 10-262, `hi3518ev200--Hi3518EV20X-Hi3516CV200-Datasheet.txt` line 74536).";

        field {
            name = "dci_wgt_cliplow2";
            desc = "Lower limit of the weighted value of curve 2";
            sw = rw;
            hw = r;
            reset = 0x0;
        } dci_wgt_cliplow2[31:24];

        field {
            name = "dci_wgt_cliphigh2";
            desc = "Upper limit of the weighted value of curve 2";
            sw = rw;
            hw = r;
            reset = 0x0;
        } dci_wgt_cliphigh2[23:16];
    } ISP_VPDCICLIP2 @ 0x11C28;

    reg {
        name = "DCI luminance adjustment unit global gain register";
        desc = "ISP_VPDCIGLBGAIN is a DCI luminance adjustment unit global gain register.

Data sheet 10.6 ISP_VPDCIGLBGAIN (offset 0x31C2C, printed page 10-263, `hi3518ev200--Hi3518EV20X-Hi3516CV200-Datasheet.txt` line 74566).";

        field {
            name = "dci_glb_gain0";
            desc = "Global gain 0 when the luminance component is adjusted";
            sw = rw;
            hw = r;
            reset = 0x0;
        } dci_glb_gain0[31:26];

        field {
            name = "dci_glb_gain1";
            desc = "Global gain 1 when the luminance component is adjusted";
            sw = rw;
            hw = r;
            reset = 0x0;
        } dci_glb_gain1[25:20];

        field {
            name = "dci_glb_gain2";
            desc = "Global gain 2 when the luminance component is adjusted";
            sw = rw;
            hw = r;
            reset = 0x0;
        } dci_glb_gain2[19:14];
    } ISP_VPDCIGLBGAIN @ 0x11C2C;

    reg {
        name = "DCI adjustment unit threshold register 0 during positive adjustment";
        desc = "ISP_VPDCIPOSTHR0 is DCI adjustment unit threshold register 0 during positive adjustment.

Data sheet 10.6 ISP_VPDCIPOSTHR0 (offset 0x31C30, printed page 10-263, `hi3518ev200--Hi3518EV20X-Hi3516CV200-Datasheet.txt` line 74588).";

        field {
            name = "dci_gainpos_thr1";
            desc = "Threshold 1 for luminance Y when the picture is adjusted from dark to bright";
            sw = rw;
            hw = r;
            reset = 0x0;
        } dci_gainpos_thr1[31:24];

        field {
            name = "dci_gainpos_thr2";
            desc = "Threshold 2 for luminance Y when the picture is adjusted from dark to bright";
            sw = rw;
            hw = r;
            reset = 0x0;
        } dci_gainpos_thr2[23:16];

        field {
            name = "dci_gainpos_thr3";
            desc = "Threshold 3 for luminance Y when the picture is adjusted from dark to bright";
            sw = rw;
            hw = r;
            reset = 0x0;
        } dci_gainpos_thr3[15:8];

        field {
            name = "dci_gainpos_thr4";
            desc = "Threshold 4 for luminance Y when the picture is adjusted from dark to bright";
            sw = rw;
            hw = r;
            reset = 0x0;
        } dci_gainpos_thr4[7:0];
    } ISP_VPDCIPOSTHR0 @ 0x11C30;

    reg {
        name = "DCI adjustment unit threshold register 1 during positive adjustment";
        desc = "ISP_VPDCIPOSTHR1 is DCI adjustment unit threshold register 1 during positive adjustment.

Data sheet 10.6 ISP_VPDCIPOSTHR1 (offset 0x31C34, printed page 10-264, `hi3518ev200--Hi3518EV20X-Hi3516CV200-Datasheet.txt` line 74627).";

        field {
            name = "dci_gainpos_thr5";
            desc = "Threshold 5 for luminance Y when the picture is adjusted from dark to bright";
            sw = rw;
            hw = r;
            reset = 0x0;
        } dci_gainpos_thr5[31:24];

        field {
            name = "dci_gainpos_thr6";
            desc = "Threshold 6 for luminance Y when the picture is adjusted from dark to bright";
            sw = rw;
            hw = r;
            reset = 0x0;
        } dci_gainpos_thr6[23:16];

        field {
            name = "dci_gainpos_thr7";
            desc = "Threshold 7 for luminance Y when the picture is adjusted from dark to bright";
            sw = rw;
            hw = r;
            reset = 0x0;
        } dci_gainpos_thr7[15:8];
    } ISP_VPDCIPOSTHR1 @ 0x11C34;

    reg {
        name = "DCI adjustment unit gain register 0 during positive adjustment";
        desc = "ISP_VPDCIPOSGAIN0 is DCI adjustment unit gain register 0 during positive adjustment

Data sheet 10.6 ISP_VPDCIPOSGAIN0 (offset 0x31C38, printed page 10-264, `hi3518ev200--Hi3518EV20X-Hi3516CV200-Datasheet.txt` line 74654).";

        field {
            name = "dci_gainpos_cbcr0";
            desc = "Chrominance compensation gain of threshold 0 when the picture is adjusted from dark to bright";
            sw = rw;
            hw = r;
            reset = 0x0;
        } dci_gainpos_cbcr0[31:28];

        field {
            name = "dci_gainpos_cbcr1";
            desc = "Chrominance compensation gain of threshold 1 when the picture is adjusted from dark to bright";
            sw = rw;
            hw = r;
            reset = 0x0;
        } dci_gainpos_cbcr1[27:24];

        field {
            name = "dci_gainpos_cbcr2";
            desc = "Chrominance compensation gain of threshold 2 when the picture is adjusted from dark to bright";
            sw = rw;
            hw = r;
            reset = 0x0;
        } dci_gainpos_cbcr2[23:20];

        field {
            name = "dci_gainpos_cbcr3";
            desc = "Chrominance compensation gain of threshold 3 when the picture is adjusted from dark to bright";
            sw = rw;
            hw = r;
            reset = 0x0;
        } dci_gainpos_cbcr3[19:16];

        field {
            name = "dci_gainpos_cbcr4";
            desc = "Chrominance compensation gain of threshold 4 when the picture is adjusted from dark to bright";
            sw = rw;
            hw = r;
            reset = 0x0;
        } dci_gainpos_cbcr4[15:12];

        field {
            name = "dci_gainpos_cbcr5";
            desc = "Chrominance compensation gain of threshold 5 when the picture is adjusted from dark to bright";
            sw = rw;
            hw = r;
            reset = 0x0;
        } dci_gainpos_cbcr5[11:8];

        field {
            name = "dci_gainpos_cbcr6";
            desc = "Chrominance compensation gain of threshold 6 when the picture is adjusted from dark to bright";
            sw = rw;
            hw = r;
            reset = 0x0;
        } dci_gainpos_cbcr6[7:4];

        field {
            name = "dci_gainpos_cbcr7";
            desc = "Chrominance compensation gain of threshold 7 when the picture is adjusted from dark to bright";
            sw = rw;
            hw = r;
            reset = 0x0;
        } dci_gainpos_cbcr7[3:0];
    } ISP_VPDCIPOSGAIN0 @ 0x11C38;

    reg {
        name = "DCI adjustment unit gain register 1 during positive adjustment";
        desc = "ISP_VPDCIPOSGAIN1 is DCI adjustment unit gain register 1 during positive adjustment.

Data sheet 10.6 ISP_VPDCIPOSGAIN1 (offset 0x31C3C, printed page 10-265, `hi3518ev200--Hi3518EV20X-Hi3516CV200-Datasheet.txt` line 74708).";

        field {
            name = "dci_gainpos_cbcr8";
            desc = "Chrominance compensation gain of threshold 8 when the picture is adjusted from dark to bright";
            sw = rw;
            hw = r;
            reset = 0x0;
        } dci_gainpos_cbcr8[31:28];
    } ISP_VPDCIPOSGAIN1 @ 0x11C3C;

    reg {
        name = "DCI adjustment unit slope register 0 during positive adjustment";
        desc = "ISP_VPDCIPOSSLP0 is DCI adjustment unit slope register 0 during positive adjustment.

Data sheet 10.6 ISP_VPDCIPOSSLP0 (offset 0x31C40, printed page 10-265, `hi3518ev200--Hi3518EV20X-Hi3516CV200-Datasheet.txt` line 74731).";

        field {
            name = "dci_gainpos_slp0";
            desc = "Slope of region 1 when the picture is adjusted from dark to bright, 10-bit signed number";
            sw = rw;
            hw = r;
            reset = 0x0;
        } dci_gainpos_slp0[31:22];

        field {
            name = "dci_gainpos_slp1";
            desc = "Slope of region 2 when the picture is adjusted from dark to bright, 10-bit signed number";
            sw = rw;
            hw = r;
            reset = 0x0;
        } dci_gainpos_slp1[21:12];

        field {
            name = "dci_gainpos_slp2";
            desc = "Slope of region 3 when the picture is adjusted from dark to bright, 10-bit signed number";
            sw = rw;
            hw = r;
            reset = 0x0;
        } dci_gainpos_slp2[11:2];
    } ISP_VPDCIPOSSLP0 @ 0x11C40;

    reg {
        name = "DCI adjustment unit slope register 1 during positive adjustment";
        desc = "ISP_VPDCIPOSSLP1 is DCI adjustment unit slope register 1 during positive adjustment.

Data sheet 10.6 ISP_VPDCIPOSSLP1 (offset 0x31C44, printed page 10-266, `hi3518ev200--Hi3518EV20X-Hi3516CV200-Datasheet.txt` line 74769).";

        field {
            name = "dci_gainpos_slp3";
            desc = "Slope of region 4 when the picture is adjusted from dark to bright, 10-bit signed number";
            sw = rw;
            hw = r;
            reset = 0x0;
        } dci_gainpos_slp3[31:22];

        field {
            name = "dci_gainpos_slp4";
            desc = "Slope of region 5 when the picture is adjusted from dark to bright, 10-bit signed number";
            sw = rw;
            hw = r;
            reset = 0x0;
        } dci_gainpos_slp4[21:12];

        field {
            name = "dci_gainpos_slp5";
            desc = "Slope of region 6 when the picture is adjusted from dark to bright, 10-bit signed number";
            sw = rw;
            hw = r;
            reset = 0x0;
        } dci_gainpos_slp5[11:2];
    } ISP_VPDCIPOSSLP1 @ 0x11C44;

    reg {
        name = "DCI adjustment unit slope register 2during positive adjustment";
        desc = "ISP_VPDCIPOSSLP2 is DCI adjustment unit slope register 2 during positive adjustment.

Data sheet 10.6 ISP_VPDCIPOSSLP2 (offset 0x31C48, printed page 10-267, `hi3518ev200--Hi3518EV20X-Hi3516CV200-Datasheet.txt` line 74808).";

        field {
            name = "dci_gainpos_slp6";
            desc = "Slope of region 7 when the picture is adjusted from dark to bright, 10-bit signed number";
            sw = rw;
            hw = r;
            reset = 0x0;
        } dci_gainpos_slp6[31:22];

        field {
            name = "dci_gainpos_slp7";
            desc = "Slope of region 8 when the picture is adjusted from dark to bright, 10-bit signed number";
            sw = rw;
            hw = r;
            reset = 0x0;
        } dci_gainpos_slp7[21:12];
    } ISP_VPDCIPOSSLP2 @ 0x11C48;

    reg {
        name = "DCI adjustment unit threshold register 0 during negative adjustment";
        desc = "ISP_VPDCINEGTHR0 is DCI adjustment unit threshold register 0 during negative adjustment.

Data sheet 10.6 ISP_VPDCINEGTHR0 (offset 0x31C4C, printed page 10-267, `hi3518ev200--Hi3518EV20X-Hi3516CV200-Datasheet.txt` line 74834).";

        field {
            name = "dci_gainneg_thr1";
            desc = "Threshold 1 for luminance Y when the picture is adjusted from bright to dark";
            sw = rw;
            hw = r;
            reset = 0x0;
        } dci_gainneg_thr1[31:24];

        field {
            name = "dci_gainneg_thr2";
            desc = "Threshold 2 for luminance Y when the picture is adjusted from bright to dark";
            sw = rw;
            hw = r;
            reset = 0x0;
        } dci_gainneg_thr2[23:16];

        field {
            name = "dci_gainneg_thr3";
            desc = "Threshold 3 for luminance Y when the picture is adjusted from bright to dark";
            sw = rw;
            hw = r;
            reset = 0x0;
        } dci_gainneg_thr3[15:8];

        field {
            name = "dci_gainneg_thr4";
            desc = "Threshold 4 for luminance Y when the picture is adjusted from bright to dark";
            sw = rw;
            hw = r;
            reset = 0x0;
        } dci_gainneg_thr4[7:0];
    } ISP_VPDCINEGTHR0 @ 0x11C4C;

    reg {
        name = "DCI adjustment unit threshold register 1 during negative adjustment";
        desc = "ISP_VPDCINEGTHR1 is DCI adjustment unit threshold register 1 during negative adjustment.

Data sheet 10.6 ISP_VPDCINEGTHR1 (offset 0x31C50, printed page 10-268, `hi3518ev200--Hi3518EV20X-Hi3516CV200-Datasheet.txt` line 74874).";

        field {
            name = "dci_gainneg_thr5";
            desc = "Threshold 5 for luminance Y when the picture is adjusted from bright to dark";
            sw = rw;
            hw = r;
            reset = 0x0;
        } dci_gainneg_thr5[31:24];

        field {
            name = "dci_gainneg_thr6";
            desc = "Threshold 6 for luminance Y when the picture is adjusted from bright to dark";
            sw = rw;
            hw = r;
            reset = 0x0;
        } dci_gainneg_thr6[23:16];

        field {
            name = "dci_gainneg_thr7";
            desc = "Threshold 7 for luminance Y when the picture is adjusted from bright to dark";
            sw = rw;
            hw = r;
            reset = 0x0;
        } dci_gainneg_thr7[15:8];
    } ISP_VPDCINEGTHR1 @ 0x11C50;

    reg {
        name = "DCI adjustment unit gain register 0 during negative adjustment";
        desc = "ISP_VPDCINEGGAIN0 is DCI adjustment unit gain register 0 during negative adjustment.

Data sheet 10.6 ISP_VPDCINEGGAIN0 (offset 0x31C54, printed page 10-268, `hi3518ev200--Hi3518EV20X-Hi3516CV200-Datasheet.txt` line 74902).";

        field {
            name = "dci_gainneg_cbcr0";
            desc = "Chrominance compensation gain of threshold 0 when the picture is adjusted from bright to dark";
            sw = rw;
            hw = r;
            reset = 0x0;
        } dci_gainneg_cbcr0[31:28];

        field {
            name = "dci_gainneg_cbcr1";
            desc = "Chrominance compensation gain of threshold 1 when the picture is adjusted from bright to dark";
            sw = rw;
            hw = r;
            reset = 0x0;
        } dci_gainneg_cbcr1[27:24];

        field {
            name = "dci_gainneg_cbcr2";
            desc = "Chrominance compensation gain of threshold 2 when the picture is adjusted from bright to dark";
            sw = rw;
            hw = r;
            reset = 0x0;
        } dci_gainneg_cbcr2[23:20];

        field {
            name = "dci_gainneg_cbcr3";
            desc = "Chrominance compensation gain of threshold 3 when the picture is adjusted from bright to dark";
            sw = rw;
            hw = r;
            reset = 0x0;
        } dci_gainneg_cbcr3[19:16];

        field {
            name = "dci_gainneg_cbcr4";
            desc = "Chrominance compensation gain of threshold 4 when the picture is adjusted from bright to dark";
            sw = rw;
            hw = r;
            reset = 0x0;
        } dci_gainneg_cbcr4[15:12];

        field {
            name = "dci_gainneg_cbcr5";
            desc = "Chrominance compensation gain of threshold 5 when the picture is adjusted from bright to dark";
            sw = rw;
            hw = r;
            reset = 0x0;
        } dci_gainneg_cbcr5[11:8];

        field {
            name = "dci_gainneg_cbcr6";
            desc = "Chrominance compensation gain of threshold 6 when the picture is adjusted from bright to dark";
            sw = rw;
            hw = r;
            reset = 0x0;
        } dci_gainneg_cbcr6[7:4];

        field {
            name = "dci_gainneg_cbcr7";
            desc = "Chrominance compensation gain of threshold 7 when the picture is adjusted from bright to dark";
            sw = rw;
            hw = r;
            reset = 0x0;
        } dci_gainneg_cbcr7[3:0];
    } ISP_VPDCINEGGAIN0 @ 0x11C54;

    reg {
        name = "DCI adjustment unit gain register 1 during negative adjustment";
        desc = "ISP_VPDCINEGGAIN1 is DCI adjustment unit gain register 1 during negative adjustment.

Data sheet 10.6 ISP_VPDCINEGGAIN1 (offset 0x31C58, printed page 10-269, `hi3518ev200--Hi3518EV20X-Hi3516CV200-Datasheet.txt` line 74956).";

        field {
            name = "dci_gainneg_cbcr8";
            desc = "Chrominance compensation gain of threshold 8 when the picture is adjusted from bright to dark";
            sw = rw;
            hw = r;
            reset = 0x0;
        } dci_gainneg_cbcr8[31:28];
    } ISP_VPDCINEGGAIN1 @ 0x11C58;

    reg {
        name = "DCI adjustment unit slope register 0 during negative adjustment";
        desc = "ISP_VPDCINEGSLP0 is DCI adjustment unit slope register 0 during negative adjustment.

Data sheet 10.6 ISP_VPDCINEGSLP0 (offset 0x31C5C, printed page 10-269, `hi3518ev200--Hi3518EV20X-Hi3516CV200-Datasheet.txt` line 74980).";

        field {
            name = "dci_gainneg_slp0";
            desc = "Slope of region 1 when the picture is adjusted from bright to dark, 10-bit signed number";
            sw = rw;
            hw = r;
            reset = 0x0;
        } dci_gainneg_slp0[31:22];

        field {
            name = "dci_gainneg_slp1";
            desc = "Slope of region 2 when the picture is adjusted from bright to dark, 10-bit signed number";
            sw = rw;
            hw = r;
            reset = 0x0;
        } dci_gainneg_slp1[21:12];

        field {
            name = "dci_gainneg_slp2";
            desc = "Slope of region 3 when the picture is adjusted from bright to dark, 10-bit signed number";
            sw = rw;
            hw = r;
            reset = 0x0;
        } dci_gainneg_slp2[11:2];
    } ISP_VPDCINEGSLP0 @ 0x11C5C;

    reg {
        name = "DCI adjustment unit slope register 1 during negative adjustment";
        desc = "ISP_VPDCINEGSLP1 is DCI adjustment unit slope register 1 during negative adjustment.

Data sheet 10.6 ISP_VPDCINEGSLP1 (offset 0x31C60, printed page 10-270, `hi3518ev200--Hi3518EV20X-Hi3516CV200-Datasheet.txt` line 75020).";

        field {
            name = "dci_gainneg_slp3";
            desc = "Slope of region 4 when the picture is adjusted from bright to dark, 10-bit signed number";
            sw = rw;
            hw = r;
            reset = 0x0;
        } dci_gainneg_slp3[31:22];

        field {
            name = "dci_gainneg_slp4";
            desc = "Slope of region 5 when the picture is adjusted from bright to dark, 10-bit signed number";
            sw = rw;
            hw = r;
            reset = 0x0;
        } dci_gainneg_slp4[21:12];

        field {
            name = "dci_gainneg_slp5";
            desc = "Slope of region 6 when the picture is adjusted from bright to dark, 10-bit signed number";
            sw = rw;
            hw = r;
            reset = 0x0;
        } dci_gainneg_slp5[11:2];
    } ISP_VPDCINEGSLP1 @ 0x11C60;

    reg {
        name = "DCI adjustment unit slope register 2 during negative adjustment";
        desc = "ISP_VPDCINEGSLP2 is DCI adjustment unit slope register 2 during negative adjustment.

Data sheet 10.6 ISP_VPDCINEGSLP2 (offset 0x31C64, printed page 10-270, `hi3518ev200--Hi3518EV20X-Hi3516CV200-Datasheet.txt` line 75052).";

        field {
            name = "dci_gainneg_slp6";
            desc = "Slope of region 7 when the picture is adjusted from bright to dark, 10-bit signed number";
            sw = rw;
            hw = r;
            reset = 0x0;
        } dci_gainneg_slp6[31:22];

        field {
            name = "dci_gainneg_slp7";
            desc = "Slope of region 8 when the picture is adjusted from bright to dark, 10-bit signed number";
            sw = rw;
            hw = r;
            reset = 0x0;
        } dci_gainneg_slp7[21:12];
    } ISP_VPDCINEGSLP2 @ 0x11C64;

    reg {
        name = "Frame discarding module control register";
        desc = "ISP_SWITCH422_CTRL is a frame discarding module control register.

Data sheet 10.6 ISP_SWITCH422_CTRL (offset 0x32000, printed page 10-271, `hi3518ev200--Hi3518EV20X-Hi3516CV200-Datasheet.txt` line 75085).";

        enum ISP_SWITCH422_CTRL_enable_f_enum {
            FRAMES_DISCARDED = 0 { name = "Frames Discarded"; desc = "Frames are discarded."; };
            ISP_YUV422_REG = 1 { name = "Isp Yuv422 Reg"; desc = "ISP_YUV422_REG_UPDATE controls whether to discard frames."; };
        };

        field {
            name = "enable";
            desc = "Frame discarding control";
            sw = rw;
            hw = r;
            encode = ISP_SWITCH422_CTRL_enable_f_enum;
            reset = 0x0;
        } enable_f[31:31];
    } ISP_SWITCH422_CTRL @ 0x12000;

    reg {
        name = "YUV422 timing adaptation register";
        desc = "ISP_ADAPTER422_CFG is a YUV422 timing adaptation register.

Data sheet 10.6 ISP_ADAPTER422_CFG (offset 0x32010, printed page 10-271, `hi3518ev200--Hi3518EV20X-Hi3516CV200-Datasheet.txt` line 75110).";

        enum ISP_ADAPTER422_CFG_vsync_mode_enum {
            NO = 0 { name = "No"; desc = "no"; };
            YES = 1 { name = "Yes"; desc = "yes"; };
        };

        field {
            name = "vsync_mode";
            desc = "Whether to perform delay processing on the vsync signal";
            sw = rw;
            hw = r;
            encode = ISP_ADAPTER422_CFG_vsync_mode_enum;
            reset = 0x1;
        } vsync_mode[1:1];

        enum ISP_ADAPTER422_CFG_hsync_mode_enum {
            NO = 0 { name = "No"; desc = "no"; };
            YES = 1 { name = "Yes"; desc = "yes"; };
        };

        field {
            name = "hsync_mode";
            desc = "Whether to perform delay processing on the hsync signal";
            sw = rw;
            hw = r;
            encode = ISP_ADAPTER422_CFG_hsync_mode_enum;
            reset = 0x1;
        } hsync_mode[0:0];
    } ISP_ADAPTER422_CFG @ 0x12010;

    reg {
        name = "Y skip configuration register";
        desc = "ISP_SKIP_Y_CFG is a Y skip configuration register.

Data sheet 10.6 ISP_SKIP_Y_CFG (offset 0x32100, printed page 10-272, `hi3518ev200--Hi3518EV20X-Hi3516CV200-Datasheet.txt` line 75151).";

        field {
            name = "skip_cfg";
            desc = "Skip configuration";
            sw = rw;
            hw = r;
            reset = 0xFFFFFFFF;
        } skip_cfg[31:0];
    } ISP_SKIP_Y_CFG @ 0x12100;

    reg {
        name = "C skip configuration register";
        desc = "ISP_SKIP_C_CFG is a C skip configuration register.

Data sheet 10.6 ISP_SKIP_C_CFG (offset 0x32110, printed page 10-272, `hi3518ev200--Hi3518EV20X-Hi3516CV200-Datasheet.txt` line 75170).";

        field {
            name = "skip_cfg";
            desc = "Skip configuration";
            sw = rw;
            hw = r;
            reset = 0xFFFFFFFF;
        } skip_cfg[31:0];
    } ISP_SKIP_C_CFG @ 0x12110;

    reg {
        name = "Luminance clamping configuration register";
        desc = "ISP_CLIP_Y_CFG is a luminance clamping configuration register.

Data sheet 10.6 ISP_CLIP_Y_CFG (offset 0x32200, printed page 10-273, `hi3518ev200--Hi3518EV20X-Hi3516CV200-Datasheet.txt` line 75198).";

        field {
            name = "max";
            desc = "Maximum luminance clamping value. When the data bit width is less than 16 bits, the upper bits are valid.";
            sw = rw;
            hw = r;
            reset = 0xFFFF;
        } max[31:16];

        field {
            name = "min";
            desc = "Minimum luminance clamping value. When the data bit width is less than 16 bits, the upper bits are valid.";
            sw = rw;
            hw = r;
            reset = 0x0;
        } min[15:0];
    } ISP_CLIP_Y_CFG @ 0x12200;

    reg {
        name = "Chrominance clamping configuration register";
        desc = "ISP_CLIP_C_CFG is a chrominance clamping configuration register.

Data sheet 10.6 ISP_CLIP_C_CFG (offset 0x32204, printed page 10-273, `hi3518ev200--Hi3518EV20X-Hi3516CV200-Datasheet.txt` line 75222).";

        field {
            name = "max";
            desc = "Maximum chrominance clamping value. When the data bit width is less than 16 bits, the upper bits are valid.";
            sw = rw;
            hw = r;
            reset = 0xFFFF;
        } max[31:16];

        field {
            name = "min";
            desc = "Minimum chrominance clamping value. When the data bit width is less than 16 bits, the upper bits are valid.";
            sw = rw;
            hw = r;
            reset = 0x0;
        } min[15:0];
    } ISP_CLIP_C_CFG @ 0x12204;

    reg {
        name = "HLDC enable register";
        desc = "ISP_HLDC_CFG is an HLDC enable register.

Data sheet 10.6 ISP_HLDC_CFG (offset 0x32300, printed page 10-274, `hi3518ev200--Hi3518EV20X-Hi3516CV200-Datasheet.txt` line 75255).";

        enum ISP_HLDC_CFG_hldc_l_en_enum {
            DISABLED = 0 { name = "Disabled"; desc = "disabled"; };
            ENABLED = 1 { name = "Enabled"; desc = "enabled"; };
        };

        field {
            name = "hldc_l_en";
            desc = "HLDC luminance enable";
            sw = rw;
            hw = r;
            encode = ISP_HLDC_CFG_hldc_l_en_enum;
            reset = 0x0;
        } hldc_l_en[31:31];

        enum ISP_HLDC_CFG_hldc_c_en_enum {
            DISABLED = 0 { name = "Disabled"; desc = "disabled"; };
            ENABLED = 1 { name = "Enabled"; desc = "enabled"; };
        };

        field {
            name = "hldc_c_en";
            desc = "HLDC chrominance enable";
            sw = rw;
            hw = r;
            encode = ISP_HLDC_CFG_hldc_c_en_enum;
            reset = 0x0;
        } hldc_c_en[30:30];

        enum ISP_HLDC_CFG_hldc_in_b422_enum {
            YUV420 = 0 { name = "Yuv420"; desc = "yuv420"; };
            YUV422 = 1 { name = "Yuv422"; desc = "yuv422"; };
        };

        field {
            name = "hldc_in_b422";
            desc = "Format of data processed by the HLDC";
            sw = rw;
            hw = r;
            encode = ISP_HLDC_CFG_hldc_in_b422_enum;
            reset = 0x0;
        } hldc_in_b422[0:0];
    } ISP_HLDC_CFG @ 0x12300;

    reg {
        name = "HLDC luminance size configuration register";
        desc = "ISP_HLDC_SIZE is an HLDC luminance size configuration register.

Data sheet 10.6 ISP_HLDC_SIZE (offset 0x32310, printed page 10-274, `hi3518ev200--Hi3518EV20X-Hi3516CV200-Datasheet.txt` line 75289).";

        field {
            name = "height";
            desc = "Height of a picture luminance column (in pixel). The configured value is the actual value minus 1.";
            sw = rw;
            hw = r;
            reset = 0x0;
        } height[28:16];

        field {
            name = "width";
            desc = "Width of a picture luminance row (in pixel). The configured value is the actual value minus 1.";
            sw = rw;
            hw = r;
            reset = 0x0;
        } width[12:0];
    } ISP_HLDC_SIZE @ 0x12310;

    reg {
        name = "HLDC center coordinate parameter register";
        desc = "ISP_HLDC_CENTER is an HLDC center coordinate parameter register.

Data sheet 10.6 ISP_HLDC_CENTER (offset 0x32320, printed page 10-275, `hi3518ev200--Hi3518EV20X-Hi3516CV200-Datasheet.txt` line 75328).";

        field {
            name = "ldc_norcoef";
            desc = "Normalization parameter";
            sw = rw;
            hw = r;
            reset = 0x0;
        } ldc_norcoef[31:24];

        field {
            name = "ldc_y_center";
            desc = "Vertical central coordinate";
            sw = rw;
            hw = r;
            reset = 0x0;
        } ldc_y_center[23:12];

        field {
            name = "ldc_x_center";
            desc = "Horizontal central coordinate";
            sw = rw;
            hw = r;
            reset = 0x0;
        } ldc_x_center[11:0];
    } ISP_HLDC_CENTER @ 0x12320;

    reg {
        name = "HLDC configuration parameter register";
        desc = "ISP_HLDC_PARA is an HLDC configuration parameter register.

Data sheet 10.6 ISP_HLDC_PARA (offset 0x32324, printed page 10-275, `hi3518ev200--Hi3518EV20X-Hi3516CV200-Datasheet.txt` line 75349).";

        enum ISP_HLDC_PARA_ldc_black_mode_enum {
            NORMAL_MODE = 0 { name = "Normal Mode"; desc = "normal mode"; };
            BLACK_BORDER_MODE = 1 { name = "Black Border Mode"; desc = "black border mode"; };
        };

        field {
            name = "ldc_black_mode";
            desc = "Mode select";
            sw = rw;
            hw = r;
            encode = ISP_HLDC_PARA_ldc_black_mode_enum;
            reset = 0x0;
        } ldc_black_mode[21:21];

        field {
            name = "shift_right";
            desc = "Number of right shift bits for the denominator";
            sw = rw;
            hw = r;
            reset = 0x0;
        } shift_right[20:16];

        field {
            name = "ratio";
            desc = "Distortion coefficient";
            sw = rw;
            hw = r;
            reset = 0x0;
        } ratio[15:7];

        field {
            name = "scale";
            desc = "Scaling ratio";
            sw = rw;
            hw = r;
            reset = 0x0;
        } scale[6:0];
    } ISP_HLDC_PARA @ 0x12324;
};

`endif
