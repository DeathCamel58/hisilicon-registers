`ifndef HISI_IO_CONFIG_CV300_RDL
`define HISI_IO_CONFIG_CV300_RDL

regfile eHISI_IO_CONFIG_CV300 {
    name = "IO configuration: pin multiplexing (0x0..0x104) and pad control (0x800..0x92F), Hi3516C V300 / Hi3516E V100";
    desc = "
    Window 0x12040000 (mux, 66 registers, one per pin, function field [2:0]) and 0x12040800 (pad control, 76 registers). The data sheet gives only the memory-map rows for these windows and no register table (Table 1-1): this file is built from VENDOR DEVICE TREE data, not from the data sheet.
    PROVENANCE. Source: OpenIPC linux-openipc-upstream arch/arm/boot/dts/hisilicon/hi3516cv300.dtsi (pinctrl-single node: reg 0x12040000 size 0x108, function-mask 7, register-width 32; pinconf-single node: reg 0x12040800 size 0x130) and hi3516cv300-demb.dts (HiSilicon demo board pin groups). PROVEN (vendor dts, the vendor kernel programs exactly this): the window sizes, the 3-bit function field, and every (register offset, function value, signal) triple listed in the enums below. The dts gpio-range says pins 0-53 and 61-65 are GPIO at function 0 and pins 55-60 are GPIO at function 1 (pin 54 has no GPIO); the pin index of a register is offset/4 (INFERRED from the range arithmetic). The dts lists only the functions the demo board uses, so a function value that is missing in an enum is UNKNOWN, not reserved. Pad names are not given by any source except the signal comments of the dts (taken verbatim as enum names); register names are muxctrl_regN with N = offset/4 (GUESS, the vendor does not name them). Not hardware verified.
    Pad control registers (0x800 + offset of the pin, 76 registers): the dts writes drive-strength groups with mask 0xFF and the values 0x00, 0x10, 0x20, 0x30, 0x31, 0x40, 0x50, 0x70 (PROVEN as written values); a 3-bit drive-strength code in bits [6:4] is INFERRED from those values and bit 0 (set in 0x31 once) is a GUESS; the other bits are not described.
    ";

    reg {
        name = "Pin 0 multiplexing register (muxctrl_reg0)";
        desc = "Pin multiplexing control, offset 0x0. PROVENANCE: PROVEN functions from the vendor dts: 0=GPIO. Reset value: UNKNOWN (not in any source; GUESS 0)."; 

        enum muxctrl_reg0_func_enum {

            GPIO = 0 { name = "GPIO"; desc = "GPIO function (dts gpio-range: pin 0)"; };

        };

        field {
            name = "func";
            desc = "Function select (3 bits). INFERRED from the pinctrl-single function-mask 7.";
            sw = rw;
            hw = r;
            encode = muxctrl_reg0_func_enum;
        } func[2:0];
    } muxctrl_reg0 @ 0x0;

    reg {
        name = "Pin 1 multiplexing register (muxctrl_reg1)";
        desc = "Pin multiplexing control, offset 0x4. PROVENANCE: PROVEN functions from the vendor dts: 0=GPIO, 1=pwm_pmux. Reset value: UNKNOWN (not in any source; GUESS 0)."; 

        enum muxctrl_reg1_func_enum {

            GPIO = 0 { name = "GPIO"; desc = "GPIO function (dts gpio-range: pin 1)"; };

            pwm_pmux = 1 { name = "pwm_pmux"; desc = "signal pwm_pmux (dts group pwm_pmux)"; };

        };

        field {
            name = "func";
            desc = "Function select (3 bits). INFERRED from the pinctrl-single function-mask 7.";
            sw = rw;
            hw = r;
            encode = muxctrl_reg1_func_enum;
        } func[2:0];
    } muxctrl_reg1 @ 0x4;

    reg {
        name = "Pin 2 multiplexing register (muxctrl_reg2)";
        desc = "Pin multiplexing control, offset 0x8. PROVENANCE: PROVEN functions from the vendor dts: 0=GPIO, 1=pwm_pmux. Reset value: UNKNOWN (not in any source; GUESS 0)."; 

        enum muxctrl_reg2_func_enum {

            GPIO = 0 { name = "GPIO"; desc = "GPIO function (dts gpio-range: pin 2)"; };

            pwm_pmux = 1 { name = "pwm_pmux"; desc = "signal pwm_pmux (dts group pwm_pmux)"; };

        };

        field {
            name = "func";
            desc = "Function select (3 bits). INFERRED from the pinctrl-single function-mask 7.";
            sw = rw;
            hw = r;
            encode = muxctrl_reg2_func_enum;
        } func[2:0];
    } muxctrl_reg2 @ 0x8;

    reg {
        name = "Pin 3 multiplexing register (muxctrl_reg3)";
        desc = "Pin multiplexing control, offset 0xC. PROVENANCE: PROVEN functions from the vendor dts: 0=GPIO, 1=pwm_pmux. Reset value: UNKNOWN (not in any source; GUESS 0)."; 

        enum muxctrl_reg3_func_enum {

            GPIO = 0 { name = "GPIO"; desc = "GPIO function (dts gpio-range: pin 3)"; };

            pwm_pmux = 1 { name = "pwm_pmux"; desc = "signal pwm_pmux (dts group pwm_pmux)"; };

        };

        field {
            name = "func";
            desc = "Function select (3 bits). INFERRED from the pinctrl-single function-mask 7.";
            sw = rw;
            hw = r;
            encode = muxctrl_reg3_func_enum;
        } func[2:0];
    } muxctrl_reg3 @ 0xC;

    reg {
        name = "Pin 4 multiplexing register (muxctrl_reg4)";
        desc = "Pin multiplexing control, offset 0x10. PROVENANCE: PROVEN functions from the vendor dts: 0=GPIO. Reset value: UNKNOWN (not in any source; GUESS 0)."; 

        enum muxctrl_reg4_func_enum {

            GPIO = 0 { name = "GPIO"; desc = "GPIO function (dts gpio-range: pin 4)"; };

        };

        field {
            name = "func";
            desc = "Function select (3 bits). INFERRED from the pinctrl-single function-mask 7.";
            sw = rw;
            hw = r;
            encode = muxctrl_reg4_func_enum;
        } func[2:0];
    } muxctrl_reg4 @ 0x10;

    reg {
        name = "Pin 5 multiplexing register (muxctrl_reg5)";
        desc = "Pin multiplexing control, offset 0x14. PROVENANCE: PROVEN functions from the vendor dts: 0=GPIO. Reset value: UNKNOWN (not in any source; GUESS 0)."; 

        enum muxctrl_reg5_func_enum {

            GPIO = 0 { name = "GPIO"; desc = "GPIO function (dts gpio-range: pin 5)"; };

        };

        field {
            name = "func";
            desc = "Function select (3 bits). INFERRED from the pinctrl-single function-mask 7.";
            sw = rw;
            hw = r;
            encode = muxctrl_reg5_func_enum;
        } func[2:0];
    } muxctrl_reg5 @ 0x14;

    reg {
        name = "Pin 6 multiplexing register (muxctrl_reg6)";
        desc = "Pin multiplexing control, offset 0x18. PROVENANCE: PROVEN functions from the vendor dts: 0=GPIO, 1=SHUTTER_TRIG. Reset value: UNKNOWN (not in any source; GUESS 0)."; 

        enum muxctrl_reg6_func_enum {

            GPIO = 0 { name = "GPIO"; desc = "GPIO function (dts gpio-range: pin 6)"; };

            SHUTTER_TRIG = 1 { name = "SHUTTER_TRIG"; desc = "signal SHUTTER_TRIG (dts group vi_shutter_trig_pmux)"; };

        };

        field {
            name = "func";
            desc = "Function select (3 bits). INFERRED from the pinctrl-single function-mask 7.";
            sw = rw;
            hw = r;
            encode = muxctrl_reg6_func_enum;
        } func[2:0];
    } muxctrl_reg6 @ 0x18;

    reg {
        name = "Pin 7 multiplexing register (muxctrl_reg7)";
        desc = "Pin multiplexing control, offset 0x1C. PROVENANCE: PROVEN functions from the vendor dts: 0=GPIO, 1=FLASH_TRIG. Reset value: UNKNOWN (not in any source; GUESS 0)."; 

        enum muxctrl_reg7_func_enum {

            GPIO = 0 { name = "GPIO"; desc = "GPIO function (dts gpio-range: pin 7)"; };

            FLASH_TRIG = 1 { name = "FLASH_TRIG"; desc = "signal FLASH_TRIG (dts group vi_flash_trig_pmux)"; };

        };

        field {
            name = "func";
            desc = "Function select (3 bits). INFERRED from the pinctrl-single function-mask 7.";
            sw = rw;
            hw = r;
            encode = muxctrl_reg7_func_enum;
        } func[2:0];
    } muxctrl_reg7 @ 0x1C;

    reg {
        name = "Pin 8 multiplexing register (muxctrl_reg8)";
        desc = "Pin multiplexing control, offset 0x20. PROVENANCE: PROVEN functions from the vendor dts: 0=GPIO, 1=I2C1_SDA. Reset value: UNKNOWN (not in any source; GUESS 0)."; 

        enum muxctrl_reg8_func_enum {

            GPIO = 0 { name = "GPIO"; desc = "GPIO function (dts gpio-range: pin 8)"; };

            I2C1_SDA = 1 { name = "I2C1_SDA"; desc = "signal I2C1_SDA (dts group i2c1_pmux)"; };

        };

        field {
            name = "func";
            desc = "Function select (3 bits). INFERRED from the pinctrl-single function-mask 7.";
            sw = rw;
            hw = r;
            encode = muxctrl_reg8_func_enum;
        } func[2:0];
    } muxctrl_reg8 @ 0x20;

    reg {
        name = "Pin 9 multiplexing register (muxctrl_reg9)";
        desc = "Pin multiplexing control, offset 0x24. PROVENANCE: PROVEN functions from the vendor dts: 0=GPIO, 1=I2C1_SCL. Reset value: UNKNOWN (not in any source; GUESS 0)."; 

        enum muxctrl_reg9_func_enum {

            GPIO = 0 { name = "GPIO"; desc = "GPIO function (dts gpio-range: pin 9)"; };

            I2C1_SCL = 1 { name = "I2C1_SCL"; desc = "signal I2C1_SCL (dts group i2c1_pmux)"; };

        };

        field {
            name = "func";
            desc = "Function select (3 bits). INFERRED from the pinctrl-single function-mask 7.";
            sw = rw;
            hw = r;
            encode = muxctrl_reg9_func_enum;
        } func[2:0];
    } muxctrl_reg9 @ 0x24;

    reg {
        name = "Pin 10 multiplexing register (muxctrl_reg10)";
        desc = "Pin multiplexing control, offset 0x28. PROVENANCE: PROVEN functions from the vendor dts: 0=GPIO, 1=SPI0_SDI. Reset value: UNKNOWN (not in any source; GUESS 0)."; 

        enum muxctrl_reg10_func_enum {

            GPIO = 0 { name = "GPIO"; desc = "GPIO function (dts gpio-range: pin 10)"; };

            SPI0_SDI = 1 { name = "SPI0_SDI"; desc = "signal SPI0_SDI (dts group spi0_pmux)"; };

        };

        field {
            name = "func";
            desc = "Function select (3 bits). INFERRED from the pinctrl-single function-mask 7.";
            sw = rw;
            hw = r;
            encode = muxctrl_reg10_func_enum;
        } func[2:0];
    } muxctrl_reg10 @ 0x28;

    reg {
        name = "Pin 11 multiplexing register (muxctrl_reg11)";
        desc = "Pin multiplexing control, offset 0x2C. PROVENANCE: PROVEN functions from the vendor dts: 0=GPIO, 1=SPI0_SDO, 2=SPI_3LINE_SDATA, 3=I2C0_SDA. Reset value: UNKNOWN (not in any source; GUESS 0)."; 

        enum muxctrl_reg11_func_enum {

            GPIO = 0 { name = "GPIO"; desc = "GPIO function (dts gpio-range: pin 11)"; };

            SPI0_SDO = 1 { name = "SPI0_SDO"; desc = "signal SPI0_SDO (dts group spi0_pmux)"; };

            SPI_3LINE_SDATA = 2 { name = "SPI_3LINE_SDATA"; desc = "signal SPI_3LINE_SDATA (dts group spi_3wire_pmux)"; };

            I2C0_SDA = 3 { name = "I2C0_SDA"; desc = "signal I2C0_SDA (dts group i2c0_pmux)"; };

        };

        field {
            name = "func";
            desc = "Function select (3 bits). INFERRED from the pinctrl-single function-mask 7.";
            sw = rw;
            hw = r;
            encode = muxctrl_reg11_func_enum;
        } func[2:0];
    } muxctrl_reg11 @ 0x2C;

    reg {
        name = "Pin 12 multiplexing register (muxctrl_reg12)";
        desc = "Pin multiplexing control, offset 0x30. PROVENANCE: PROVEN functions from the vendor dts: 0=GPIO, 1=SPI0_SCLK, 2=SPI_3LINE_SCLK, 3=I2C0_SCL. Reset value: UNKNOWN (not in any source; GUESS 0)."; 

        enum muxctrl_reg12_func_enum {

            GPIO = 0 { name = "GPIO"; desc = "GPIO function (dts gpio-range: pin 12)"; };

            SPI0_SCLK = 1 { name = "SPI0_SCLK"; desc = "signal SPI0_SCLK (dts group spi0_pmux)"; };

            SPI_3LINE_SCLK = 2 { name = "SPI_3LINE_SCLK"; desc = "signal SPI_3LINE_SCLK (dts group spi_3wire_pmux)"; };

            I2C0_SCL = 3 { name = "I2C0_SCL"; desc = "signal I2C0_SCL (dts group i2c0_pmux)"; };

        };

        field {
            name = "func";
            desc = "Function select (3 bits). INFERRED from the pinctrl-single function-mask 7.";
            sw = rw;
            hw = r;
            encode = muxctrl_reg12_func_enum;
        } func[2:0];
    } muxctrl_reg12 @ 0x30;

    reg {
        name = "Pin 13 multiplexing register (muxctrl_reg13)";
        desc = "Pin multiplexing control, offset 0x34. PROVENANCE: PROVEN functions from the vendor dts: 0=GPIO, 1=SPI0_CSN, 2=SPI_3LINE_CSN. Reset value: UNKNOWN (not in any source; GUESS 0)."; 

        enum muxctrl_reg13_func_enum {

            GPIO = 0 { name = "GPIO"; desc = "GPIO function (dts gpio-range: pin 13)"; };

            SPI0_CSN = 1 { name = "SPI0_CSN"; desc = "signal SPI0_CSN (dts group spi0_pmux)"; };

            SPI_3LINE_CSN = 2 { name = "SPI_3LINE_CSN"; desc = "signal SPI_3LINE_CSN (dts group spi_3wire_pmux)"; };

        };

        field {
            name = "func";
            desc = "Function select (3 bits). INFERRED from the pinctrl-single function-mask 7.";
            sw = rw;
            hw = r;
            encode = muxctrl_reg13_func_enum;
        } func[2:0];
    } muxctrl_reg13 @ 0x34;

    reg {
        name = "Pin 14 multiplexing register (muxctrl_reg14)";
        desc = "Pin multiplexing control, offset 0x38. PROVENANCE: PROVEN functions from the vendor dts: 0=GPIO, 1=SENSOR_RSTN. Reset value: UNKNOWN (not in any source; GUESS 0)."; 

        enum muxctrl_reg14_func_enum {

            GPIO = 0 { name = "GPIO"; desc = "GPIO function (dts gpio-range: pin 14)"; };

            SENSOR_RSTN = 1 { name = "SENSOR_RSTN"; desc = "signal SENSOR_RSTN (dts group sensor_pmux)"; };

        };

        field {
            name = "func";
            desc = "Function select (3 bits). INFERRED from the pinctrl-single function-mask 7.";
            sw = rw;
            hw = r;
            encode = muxctrl_reg14_func_enum;
        } func[2:0];
    } muxctrl_reg14 @ 0x38;

    reg {
        name = "Pin 15 multiplexing register (muxctrl_reg15)";
        desc = "Pin multiplexing control, offset 0x3C. PROVENANCE: PROVEN functions from the vendor dts: 0=GPIO, 1=SENSOR_CLK. Reset value: UNKNOWN (not in any source; GUESS 0)."; 

        enum muxctrl_reg15_func_enum {

            GPIO = 0 { name = "GPIO"; desc = "GPIO function (dts gpio-range: pin 15)"; };

            SENSOR_CLK = 1 { name = "SENSOR_CLK"; desc = "signal SENSOR_CLK (dts group sensor_pmux)"; };

        };

        field {
            name = "func";
            desc = "Function select (3 bits). INFERRED from the pinctrl-single function-mask 7.";
            sw = rw;
            hw = r;
            encode = muxctrl_reg15_func_enum;
        } func[2:0];
    } muxctrl_reg15 @ 0x3C;

    reg {
        name = "Pin 16 multiplexing register (muxctrl_reg16)";
        desc = "Pin multiplexing control, offset 0x40. PROVENANCE: PROVEN functions from the vendor dts: 0=GPIO, 1=VI_DATA13, 2=VOU656_CLK, 3=LCD_CLK, 4=I2S_MCLK. Reset value: UNKNOWN (not in any source; GUESS 0)."; 

        enum muxctrl_reg16_func_enum {

            GPIO = 0 { name = "GPIO"; desc = "GPIO function (dts gpio-range: pin 16)"; };

            VI_DATA13 = 1 { name = "VI_DATA13"; desc = "signal VI_DATA13 (dts group sensor_dc_pmux/vi_bt1120_pmux)"; };

            VOU656_CLK = 2 { name = "VOU656_CLK"; desc = "signal VOU656_CLK (dts group vo_bt656_pmux)"; };

            LCD_CLK = 3 { name = "LCD_CLK"; desc = "signal LCD_CLK (dts group vo_lcd_pmux)"; };

            I2S_MCLK = 4 { name = "I2S_MCLK"; desc = "signal I2S_MCLK (dts group i2s_with_vi_pmux)"; };

        };

        field {
            name = "func";
            desc = "Function select (3 bits). INFERRED from the pinctrl-single function-mask 7.";
            sw = rw;
            hw = r;
            encode = muxctrl_reg16_func_enum;
        } func[2:0];
    } muxctrl_reg16 @ 0x40;

    reg {
        name = "Pin 17 multiplexing register (muxctrl_reg17)";
        desc = "Pin multiplexing control, offset 0x44. PROVENANCE: PROVEN functions from the vendor dts: 0=GPIO, 1=VI_DATA10, 2=VOU656_DATA3, 3=LCD_DATA1, 4=I2S_SD_TX. Reset value: UNKNOWN (not in any source; GUESS 0)."; 

        enum muxctrl_reg17_func_enum {

            GPIO = 0 { name = "GPIO"; desc = "GPIO function (dts gpio-range: pin 17)"; };

            VI_DATA10 = 1 { name = "VI_DATA10"; desc = "signal VI_DATA10 (dts group sensor_dc_pmux/vi_bt1120_pmux)"; };

            VOU656_DATA3 = 2 { name = "VOU656_DATA3"; desc = "signal VOU656_DATA3 (dts group vo_bt656_pmux)"; };

            LCD_DATA1 = 3 { name = "LCD_DATA1"; desc = "signal LCD_DATA1 (dts group vo_lcd_pmux)"; };

            I2S_SD_TX = 4 { name = "I2S_SD_TX"; desc = "signal I2S_SD_TX (dts group i2s_with_vi_pmux)"; };

        };

        field {
            name = "func";
            desc = "Function select (3 bits). INFERRED from the pinctrl-single function-mask 7.";
            sw = rw;
            hw = r;
            encode = muxctrl_reg17_func_enum;
        } func[2:0];
    } muxctrl_reg17 @ 0x44;

    reg {
        name = "Pin 18 multiplexing register (muxctrl_reg18)";
        desc = "Pin multiplexing control, offset 0x48. PROVENANCE: PROVEN functions from the vendor dts: 0=GPIO, 1=VI_DATA12, 2=VOU656_DATA7, 3=LCD_DATA3, 4=I2S_BCLK_TX. Reset value: UNKNOWN (not in any source; GUESS 0)."; 

        enum muxctrl_reg18_func_enum {

            GPIO = 0 { name = "GPIO"; desc = "GPIO function (dts gpio-range: pin 18)"; };

            VI_DATA12 = 1 { name = "VI_DATA12"; desc = "signal VI_DATA12 (dts group sensor_dc_pmux/vi_bt1120_pmux)"; };

            VOU656_DATA7 = 2 { name = "VOU656_DATA7"; desc = "signal VOU656_DATA7 (dts group vo_bt656_pmux)"; };

            LCD_DATA3 = 3 { name = "LCD_DATA3"; desc = "signal LCD_DATA3 (dts group vo_lcd_pmux)"; };

            I2S_BCLK_TX = 4 { name = "I2S_BCLK_TX"; desc = "signal I2S_BCLK_TX (dts group i2s_with_vi_pmux)"; };

        };

        field {
            name = "func";
            desc = "Function select (3 bits). INFERRED from the pinctrl-single function-mask 7.";
            sw = rw;
            hw = r;
            encode = muxctrl_reg18_func_enum;
        } func[2:0];
    } muxctrl_reg18 @ 0x48;

    reg {
        name = "Pin 19 multiplexing register (muxctrl_reg19)";
        desc = "Pin multiplexing control, offset 0x4C. PROVENANCE: PROVEN functions from the vendor dts: 0=GPIO, 1=VI_DATA11, 2=VOU656_DATA2, 3=LCD_DATA2, 4=I2S_WS_TX. Reset value: UNKNOWN (not in any source; GUESS 0)."; 

        enum muxctrl_reg19_func_enum {

            GPIO = 0 { name = "GPIO"; desc = "GPIO function (dts gpio-range: pin 19)"; };

            VI_DATA11 = 1 { name = "VI_DATA11"; desc = "signal VI_DATA11 (dts group sensor_dc_pmux/vi_bt1120_pmux)"; };

            VOU656_DATA2 = 2 { name = "VOU656_DATA2"; desc = "signal VOU656_DATA2 (dts group vo_bt656_pmux)"; };

            LCD_DATA2 = 3 { name = "LCD_DATA2"; desc = "signal LCD_DATA2 (dts group vo_lcd_pmux)"; };

            I2S_WS_TX = 4 { name = "I2S_WS_TX"; desc = "signal I2S_WS_TX (dts group i2s_with_vi_pmux)"; };

        };

        field {
            name = "func";
            desc = "Function select (3 bits). INFERRED from the pinctrl-single function-mask 7.";
            sw = rw;
            hw = r;
            encode = muxctrl_reg19_func_enum;
        } func[2:0];
    } muxctrl_reg19 @ 0x4C;

    reg {
        name = "Pin 20 multiplexing register (muxctrl_reg20)";
        desc = "Pin multiplexing control, offset 0x50. PROVENANCE: PROVEN functions from the vendor dts: 0=GPIO, 1=VI_DATA9, 2=VOU656_DATA6, 3=LCD_DATA4. Reset value: UNKNOWN (not in any source; GUESS 0)."; 

        enum muxctrl_reg20_func_enum {

            GPIO = 0 { name = "GPIO"; desc = "GPIO function (dts gpio-range: pin 20)"; };

            VI_DATA9 = 1 { name = "VI_DATA9"; desc = "signal VI_DATA9 (dts group sensor_dc_pmux/vi_bt1120_pmux)"; };

            VOU656_DATA6 = 2 { name = "VOU656_DATA6"; desc = "signal VOU656_DATA6 (dts group vo_bt656_pmux)"; };

            LCD_DATA4 = 3 { name = "LCD_DATA4"; desc = "signal LCD_DATA4 (dts group vo_lcd_pmux)"; };

        };

        field {
            name = "func";
            desc = "Function select (3 bits). INFERRED from the pinctrl-single function-mask 7.";
            sw = rw;
            hw = r;
            encode = muxctrl_reg20_func_enum;
        } func[2:0];
    } muxctrl_reg20 @ 0x50;

    reg {
        name = "Pin 21 multiplexing register (muxctrl_reg21)";
        desc = "Pin multiplexing control, offset 0x54. PROVENANCE: PROVEN functions from the vendor dts: 0=GPIO, 1=VI_DATA14, 2=VOU656_DATA5, 3=LCD_DATA5. Reset value: UNKNOWN (not in any source; GUESS 0)."; 

        enum muxctrl_reg21_func_enum {

            GPIO = 0 { name = "GPIO"; desc = "GPIO function (dts gpio-range: pin 21)"; };

            VI_DATA14 = 1 { name = "VI_DATA14"; desc = "signal VI_DATA14 (dts group sensor_dc_pmux/vi_bt1120_pmux)"; };

            VOU656_DATA5 = 2 { name = "VOU656_DATA5"; desc = "signal VOU656_DATA5 (dts group vo_bt656_pmux)"; };

            LCD_DATA5 = 3 { name = "LCD_DATA5"; desc = "signal LCD_DATA5 (dts group vo_lcd_pmux)"; };

        };

        field {
            name = "func";
            desc = "Function select (3 bits). INFERRED from the pinctrl-single function-mask 7.";
            sw = rw;
            hw = r;
            encode = muxctrl_reg21_func_enum;
        } func[2:0];
    } muxctrl_reg21 @ 0x54;

    reg {
        name = "Pin 22 multiplexing register (muxctrl_reg22)";
        desc = "Pin multiplexing control, offset 0x58. PROVENANCE: PROVEN functions from the vendor dts: 0=GPIO, 1=VI_DATA15, 2=VOU656_DATA4, 3=LCD_DATA0, 4=I2S_SD_RX. Reset value: UNKNOWN (not in any source; GUESS 0)."; 

        enum muxctrl_reg22_func_enum {

            GPIO = 0 { name = "GPIO"; desc = "GPIO function (dts gpio-range: pin 22)"; };

            VI_DATA15 = 1 { name = "VI_DATA15"; desc = "signal VI_DATA15 (dts group sensor_dc_pmux/vi_bt1120_pmux)"; };

            VOU656_DATA4 = 2 { name = "VOU656_DATA4"; desc = "signal VOU656_DATA4 (dts group vo_bt656_pmux)"; };

            LCD_DATA0 = 3 { name = "LCD_DATA0"; desc = "signal LCD_DATA0 (dts group vo_lcd_pmux)"; };

            I2S_SD_RX = 4 { name = "I2S_SD_RX"; desc = "signal I2S_SD_RX (dts group i2s_with_vi_pmux)"; };

        };

        field {
            name = "func";
            desc = "Function select (3 bits). INFERRED from the pinctrl-single function-mask 7.";
            sw = rw;
            hw = r;
            encode = muxctrl_reg22_func_enum;
        } func[2:0];
    } muxctrl_reg22 @ 0x58;

    reg {
        name = "Pin 23 multiplexing register (muxctrl_reg23)";
        desc = "Pin multiplexing control, offset 0x5C. PROVENANCE: PROVEN functions from the vendor dts: 0=GPIO, 1=VI_VS, 2=VOU656_DATA1, 3=LCD_HSYNC. Reset value: UNKNOWN (not in any source; GUESS 0)."; 

        enum muxctrl_reg23_func_enum {

            GPIO = 0 { name = "GPIO"; desc = "GPIO function (dts gpio-range: pin 23)"; };

            VI_VS = 1 { name = "VI_VS"; desc = "signal VI_VS (dts group sensor_dc_pmux/vi_bt1120_pmux)"; };

            VOU656_DATA1 = 2 { name = "VOU656_DATA1"; desc = "signal VOU656_DATA1 (dts group vo_bt656_pmux)"; };

            LCD_HSYNC = 3 { name = "LCD_HSYNC"; desc = "signal LCD_HSYNC (dts group vo_lcd_pmux)"; };

        };

        field {
            name = "func";
            desc = "Function select (3 bits). INFERRED from the pinctrl-single function-mask 7.";
            sw = rw;
            hw = r;
            encode = muxctrl_reg23_func_enum;
        } func[2:0];
    } muxctrl_reg23 @ 0x5C;

    reg {
        name = "Pin 24 multiplexing register (muxctrl_reg24)";
        desc = "Pin multiplexing control, offset 0x60. PROVENANCE: PROVEN functions from the vendor dts: 0=GPIO, 1=VI_HS, 2=VOU656_DATA0, 3=LCD_VSYNC. Reset value: UNKNOWN (not in any source; GUESS 0)."; 

        enum muxctrl_reg24_func_enum {

            GPIO = 0 { name = "GPIO"; desc = "GPIO function (dts gpio-range: pin 24)"; };

            VI_HS = 1 { name = "VI_HS"; desc = "signal VI_HS (dts group sensor_dc_pmux/vi_bt1120_pmux)"; };

            VOU656_DATA0 = 2 { name = "VOU656_DATA0"; desc = "signal VOU656_DATA0 (dts group vo_bt656_pmux)"; };

            LCD_VSYNC = 3 { name = "LCD_VSYNC"; desc = "signal LCD_VSYNC (dts group vo_lcd_pmux)"; };

        };

        field {
            name = "func";
            desc = "Function select (3 bits). INFERRED from the pinctrl-single function-mask 7.";
            sw = rw;
            hw = r;
            encode = muxctrl_reg24_func_enum;
        } func[2:0];
    } muxctrl_reg24 @ 0x60;

    reg {
        name = "Pin 25 multiplexing register (muxctrl_reg25)";
        desc = "Pin multiplexing control, offset 0x64. PROVENANCE: PROVEN functions from the vendor dts: 0=GPIO, 3=LCD_DE. Reset value: UNKNOWN (not in any source; GUESS 0)."; 

        enum muxctrl_reg25_func_enum {

            GPIO = 0 { name = "GPIO"; desc = "GPIO function (dts gpio-range: pin 25)"; };

            LCD_DE = 3 { name = "LCD_DE"; desc = "signal LCD_DE (dts group vo_lcd_pmux)"; };

        };

        field {
            name = "func";
            desc = "Function select (3 bits). INFERRED from the pinctrl-single function-mask 7.";
            sw = rw;
            hw = r;
            encode = muxctrl_reg25_func_enum;
        } func[2:0];
    } muxctrl_reg25 @ 0x64;

    reg {
        name = "Pin 26 multiplexing register (muxctrl_reg26)";
        desc = "Pin multiplexing control, offset 0x68. PROVENANCE: PROVEN functions from the vendor dts: 0=GPIO. Reset value: UNKNOWN (not in any source; GUESS 0)."; 

        enum muxctrl_reg26_func_enum {

            GPIO = 0 { name = "GPIO"; desc = "GPIO function (dts gpio-range: pin 26)"; };

        };

        field {
            name = "func";
            desc = "Function select (3 bits). INFERRED from the pinctrl-single function-mask 7.";
            sw = rw;
            hw = r;
            encode = muxctrl_reg26_func_enum;
        } func[2:0];
    } muxctrl_reg26 @ 0x68;

    reg {
        name = "Pin 27 multiplexing register (muxctrl_reg27)";
        desc = "Pin multiplexing control, offset 0x6C. PROVENANCE: PROVEN functions from the vendor dts: 0=GPIO. Reset value: UNKNOWN (not in any source; GUESS 0)."; 

        enum muxctrl_reg27_func_enum {

            GPIO = 0 { name = "GPIO"; desc = "GPIO function (dts gpio-range: pin 27)"; };

        };

        field {
            name = "func";
            desc = "Function select (3 bits). INFERRED from the pinctrl-single function-mask 7.";
            sw = rw;
            hw = r;
            encode = muxctrl_reg27_func_enum;
        } func[2:0];
    } muxctrl_reg27 @ 0x6C;

    reg {
        name = "Pin 28 multiplexing register (muxctrl_reg28)";
        desc = "Pin multiplexing control, offset 0x70. PROVENANCE: PROVEN functions from the vendor dts: 0=GPIO. Reset value: UNKNOWN (not in any source; GUESS 0)."; 

        enum muxctrl_reg28_func_enum {

            GPIO = 0 { name = "GPIO"; desc = "GPIO function (dts gpio-range: pin 28)"; };

        };

        field {
            name = "func";
            desc = "Function select (3 bits). INFERRED from the pinctrl-single function-mask 7.";
            sw = rw;
            hw = r;
            encode = muxctrl_reg28_func_enum;
        } func[2:0];
    } muxctrl_reg28 @ 0x70;

    reg {
        name = "Pin 29 multiplexing register (muxctrl_reg29)";
        desc = "Pin multiplexing control, offset 0x74. PROVENANCE: PROVEN functions from the vendor dts: 0=GPIO. Reset value: UNKNOWN (not in any source; GUESS 0)."; 

        enum muxctrl_reg29_func_enum {

            GPIO = 0 { name = "GPIO"; desc = "GPIO function (dts gpio-range: pin 29)"; };

        };

        field {
            name = "func";
            desc = "Function select (3 bits). INFERRED from the pinctrl-single function-mask 7.";
            sw = rw;
            hw = r;
            encode = muxctrl_reg29_func_enum;
        } func[2:0];
    } muxctrl_reg29 @ 0x74;

    reg {
        name = "Pin 30 multiplexing register (muxctrl_reg30)";
        desc = "Pin multiplexing control, offset 0x78. PROVENANCE: PROVEN functions from the vendor dts: 0=GPIO. Reset value: UNKNOWN (not in any source; GUESS 0)."; 

        enum muxctrl_reg30_func_enum {

            GPIO = 0 { name = "GPIO"; desc = "GPIO function (dts gpio-range: pin 30)"; };

        };

        field {
            name = "func";
            desc = "Function select (3 bits). INFERRED from the pinctrl-single function-mask 7.";
            sw = rw;
            hw = r;
            encode = muxctrl_reg30_func_enum;
        } func[2:0];
    } muxctrl_reg30 @ 0x78;

    reg {
        name = "Pin 31 multiplexing register (muxctrl_reg31)";
        desc = "Pin multiplexing control, offset 0x7C. PROVENANCE: PROVEN functions from the vendor dts: 0=GPIO. Reset value: UNKNOWN (not in any source; GUESS 0)."; 

        enum muxctrl_reg31_func_enum {

            GPIO = 0 { name = "GPIO"; desc = "GPIO function (dts gpio-range: pin 31)"; };

        };

        field {
            name = "func";
            desc = "Function select (3 bits). INFERRED from the pinctrl-single function-mask 7.";
            sw = rw;
            hw = r;
            encode = muxctrl_reg31_func_enum;
        } func[2:0];
    } muxctrl_reg31 @ 0x7C;

    reg {
        name = "Pin 32 multiplexing register (muxctrl_reg32)";
        desc = "Pin multiplexing control, offset 0x80. PROVENANCE: PROVEN functions from the vendor dts: 0=GPIO. Reset value: UNKNOWN (not in any source; GUESS 0)."; 

        enum muxctrl_reg32_func_enum {

            GPIO = 0 { name = "GPIO"; desc = "GPIO function (dts gpio-range: pin 32)"; };

        };

        field {
            name = "func";
            desc = "Function select (3 bits). INFERRED from the pinctrl-single function-mask 7.";
            sw = rw;
            hw = r;
            encode = muxctrl_reg32_func_enum;
        } func[2:0];
    } muxctrl_reg32 @ 0x80;

    reg {
        name = "Pin 33 multiplexing register (muxctrl_reg33)";
        desc = "Pin multiplexing control, offset 0x84. PROVENANCE: PROVEN functions from the vendor dts: 0=GPIO. Reset value: UNKNOWN (not in any source; GUESS 0)."; 

        enum muxctrl_reg33_func_enum {

            GPIO = 0 { name = "GPIO"; desc = "GPIO function (dts gpio-range: pin 33)"; };

        };

        field {
            name = "func";
            desc = "Function select (3 bits). INFERRED from the pinctrl-single function-mask 7.";
            sw = rw;
            hw = r;
            encode = muxctrl_reg33_func_enum;
        } func[2:0];
    } muxctrl_reg33 @ 0x84;

    reg {
        name = "Pin 34 multiplexing register (muxctrl_reg34)";
        desc = "Pin multiplexing control, offset 0x88. PROVENANCE: PROVEN functions from the vendor dts: 0=GPIO. Reset value: UNKNOWN (not in any source; GUESS 0)."; 

        enum muxctrl_reg34_func_enum {

            GPIO = 0 { name = "GPIO"; desc = "GPIO function (dts gpio-range: pin 34)"; };

        };

        field {
            name = "func";
            desc = "Function select (3 bits). INFERRED from the pinctrl-single function-mask 7.";
            sw = rw;
            hw = r;
            encode = muxctrl_reg34_func_enum;
        } func[2:0];
    } muxctrl_reg34 @ 0x88;

    reg {
        name = "Pin 35 multiplexing register (muxctrl_reg35)";
        desc = "Pin multiplexing control, offset 0x8C. PROVENANCE: PROVEN functions from the vendor dts: 0=GPIO. Reset value: UNKNOWN (not in any source; GUESS 0)."; 

        enum muxctrl_reg35_func_enum {

            GPIO = 0 { name = "GPIO"; desc = "GPIO function (dts gpio-range: pin 35)"; };

        };

        field {
            name = "func";
            desc = "Function select (3 bits). INFERRED from the pinctrl-single function-mask 7.";
            sw = rw;
            hw = r;
            encode = muxctrl_reg35_func_enum;
        } func[2:0];
    } muxctrl_reg35 @ 0x8C;

    reg {
        name = "Pin 36 multiplexing register (muxctrl_reg36)";
        desc = "Pin multiplexing control, offset 0x90. PROVENANCE: PROVEN functions from the vendor dts: 0=GPIO. Reset value: UNKNOWN (not in any source; GUESS 0)."; 

        enum muxctrl_reg36_func_enum {

            GPIO = 0 { name = "GPIO"; desc = "GPIO function (dts gpio-range: pin 36)"; };

        };

        field {
            name = "func";
            desc = "Function select (3 bits). INFERRED from the pinctrl-single function-mask 7.";
            sw = rw;
            hw = r;
            encode = muxctrl_reg36_func_enum;
        } func[2:0];
    } muxctrl_reg36 @ 0x90;

    reg {
        name = "Pin 37 multiplexing register (muxctrl_reg37)";
        desc = "Pin multiplexing control, offset 0x94. PROVENANCE: PROVEN functions from the vendor dts: 0=GPIO. Reset value: UNKNOWN (not in any source; GUESS 0)."; 

        enum muxctrl_reg37_func_enum {

            GPIO = 0 { name = "GPIO"; desc = "GPIO function (dts gpio-range: pin 37)"; };

        };

        field {
            name = "func";
            desc = "Function select (3 bits). INFERRED from the pinctrl-single function-mask 7.";
            sw = rw;
            hw = r;
            encode = muxctrl_reg37_func_enum;
        } func[2:0];
    } muxctrl_reg37 @ 0x94;

    reg {
        name = "Pin 38 multiplexing register (muxctrl_reg38)";
        desc = "Pin multiplexing control, offset 0x98. PROVENANCE: PROVEN functions from the vendor dts: 0=GPIO. Reset value: UNKNOWN (not in any source; GUESS 0)."; 

        enum muxctrl_reg38_func_enum {

            GPIO = 0 { name = "GPIO"; desc = "GPIO function (dts gpio-range: pin 38)"; };

        };

        field {
            name = "func";
            desc = "Function select (3 bits). INFERRED from the pinctrl-single function-mask 7.";
            sw = rw;
            hw = r;
            encode = muxctrl_reg38_func_enum;
        } func[2:0];
    } muxctrl_reg38 @ 0x98;

    reg {
        name = "Pin 39 multiplexing register (muxctrl_reg39)";
        desc = "Pin multiplexing control, offset 0x9C. PROVENANCE: PROVEN functions from the vendor dts: 0=GPIO. Reset value: UNKNOWN (not in any source; GUESS 0)."; 

        enum muxctrl_reg39_func_enum {

            GPIO = 0 { name = "GPIO"; desc = "GPIO function (dts gpio-range: pin 39)"; };

        };

        field {
            name = "func";
            desc = "Function select (3 bits). INFERRED from the pinctrl-single function-mask 7.";
            sw = rw;
            hw = r;
            encode = muxctrl_reg39_func_enum;
        } func[2:0];
    } muxctrl_reg39 @ 0x9C;

    reg {
        name = "Pin 40 multiplexing register (muxctrl_reg40)";
        desc = "Pin multiplexing control, offset 0xA0. PROVENANCE: PROVEN functions from the vendor dts: 0=GPIO. Reset value: UNKNOWN (not in any source; GUESS 0)."; 

        enum muxctrl_reg40_func_enum {

            GPIO = 0 { name = "GPIO"; desc = "GPIO function (dts gpio-range: pin 40)"; };

        };

        field {
            name = "func";
            desc = "Function select (3 bits). INFERRED from the pinctrl-single function-mask 7.";
            sw = rw;
            hw = r;
            encode = muxctrl_reg40_func_enum;
        } func[2:0];
    } muxctrl_reg40 @ 0xA0;

    reg {
        name = "Pin 41 multiplexing register (muxctrl_reg41)";
        desc = "Pin multiplexing control, offset 0xA4. PROVENANCE: PROVEN functions from the vendor dts: 0=GPIO. Reset value: UNKNOWN (not in any source; GUESS 0)."; 

        enum muxctrl_reg41_func_enum {

            GPIO = 0 { name = "GPIO"; desc = "GPIO function (dts gpio-range: pin 41)"; };

        };

        field {
            name = "func";
            desc = "Function select (3 bits). INFERRED from the pinctrl-single function-mask 7.";
            sw = rw;
            hw = r;
            encode = muxctrl_reg41_func_enum;
        } func[2:0];
    } muxctrl_reg41 @ 0xA4;

    reg {
        name = "Pin 42 multiplexing register (muxctrl_reg42)";
        desc = "Pin multiplexing control, offset 0xA8. PROVENANCE: PROVEN functions from the vendor dts: 0=GPIO. Reset value: UNKNOWN (not in any source; GUESS 0)."; 

        enum muxctrl_reg42_func_enum {

            GPIO = 0 { name = "GPIO"; desc = "GPIO function (dts gpio-range: pin 42)"; };

        };

        field {
            name = "func";
            desc = "Function select (3 bits). INFERRED from the pinctrl-single function-mask 7.";
            sw = rw;
            hw = r;
            encode = muxctrl_reg42_func_enum;
        } func[2:0];
    } muxctrl_reg42 @ 0xA8;

    reg {
        name = "Pin 43 multiplexing register (muxctrl_reg43)";
        desc = "Pin multiplexing control, offset 0xAC. PROVENANCE: PROVEN functions from the vendor dts: 0=GPIO. Reset value: UNKNOWN (not in any source; GUESS 0)."; 

        enum muxctrl_reg43_func_enum {

            GPIO = 0 { name = "GPIO"; desc = "GPIO function (dts gpio-range: pin 43)"; };

        };

        field {
            name = "func";
            desc = "Function select (3 bits). INFERRED from the pinctrl-single function-mask 7.";
            sw = rw;
            hw = r;
            encode = muxctrl_reg43_func_enum;
        } func[2:0];
    } muxctrl_reg43 @ 0xAC;

    reg {
        name = "Pin 44 multiplexing register (muxctrl_reg44)";
        desc = "Pin multiplexing control, offset 0xB0. PROVENANCE: PROVEN functions from the vendor dts: 0=GPIO. Reset value: UNKNOWN (not in any source; GUESS 0)."; 

        enum muxctrl_reg44_func_enum {

            GPIO = 0 { name = "GPIO"; desc = "GPIO function (dts gpio-range: pin 44)"; };

        };

        field {
            name = "func";
            desc = "Function select (3 bits). INFERRED from the pinctrl-single function-mask 7.";
            sw = rw;
            hw = r;
            encode = muxctrl_reg44_func_enum;
        } func[2:0];
    } muxctrl_reg44 @ 0xB0;

    reg {
        name = "Pin 45 multiplexing register (muxctrl_reg45)";
        desc = "Pin multiplexing control, offset 0xB4. PROVENANCE: PROVEN functions from the vendor dts: 0=GPIO. Reset value: UNKNOWN (not in any source; GUESS 0)."; 

        enum muxctrl_reg45_func_enum {

            GPIO = 0 { name = "GPIO"; desc = "GPIO function (dts gpio-range: pin 45)"; };

        };

        field {
            name = "func";
            desc = "Function select (3 bits). INFERRED from the pinctrl-single function-mask 7.";
            sw = rw;
            hw = r;
            encode = muxctrl_reg45_func_enum;
        } func[2:0];
    } muxctrl_reg45 @ 0xB4;

    reg {
        name = "Pin 46 multiplexing register (muxctrl_reg46)";
        desc = "Pin multiplexing control, offset 0xB8. PROVENANCE: PROVEN functions from the vendor dts: 0=GPIO. Reset value: UNKNOWN (not in any source; GUESS 0)."; 

        enum muxctrl_reg46_func_enum {

            GPIO = 0 { name = "GPIO"; desc = "GPIO function (dts gpio-range: pin 46)"; };

        };

        field {
            name = "func";
            desc = "Function select (3 bits). INFERRED from the pinctrl-single function-mask 7.";
            sw = rw;
            hw = r;
            encode = muxctrl_reg46_func_enum;
        } func[2:0];
    } muxctrl_reg46 @ 0xB8;

    reg {
        name = "Pin 47 multiplexing register (muxctrl_reg47)";
        desc = "Pin multiplexing control, offset 0xBC. PROVENANCE: PROVEN functions from the vendor dts: 0=GPIO. Reset value: UNKNOWN (not in any source; GUESS 0)."; 

        enum muxctrl_reg47_func_enum {

            GPIO = 0 { name = "GPIO"; desc = "GPIO function (dts gpio-range: pin 47)"; };

        };

        field {
            name = "func";
            desc = "Function select (3 bits). INFERRED from the pinctrl-single function-mask 7.";
            sw = rw;
            hw = r;
            encode = muxctrl_reg47_func_enum;
        } func[2:0];
    } muxctrl_reg47 @ 0xBC;

    reg {
        name = "Pin 48 multiplexing register (muxctrl_reg48)";
        desc = "Pin multiplexing control, offset 0xC0. PROVENANCE: PROVEN functions from the vendor dts: 0=GPIO. Reset value: UNKNOWN (not in any source; GUESS 0)."; 

        enum muxctrl_reg48_func_enum {

            GPIO = 0 { name = "GPIO"; desc = "GPIO function (dts gpio-range: pin 48)"; };

        };

        field {
            name = "func";
            desc = "Function select (3 bits). INFERRED from the pinctrl-single function-mask 7.";
            sw = rw;
            hw = r;
            encode = muxctrl_reg48_func_enum;
        } func[2:0];
    } muxctrl_reg48 @ 0xC0;

    reg {
        name = "Pin 49 multiplexing register (muxctrl_reg49)";
        desc = "Pin multiplexing control, offset 0xC4. PROVENANCE: PROVEN functions from the vendor dts: 0=GPIO, 1=SPI1_CSN1, 4=I2S_SD_TX. Reset value: UNKNOWN (not in any source; GUESS 0)."; 

        enum muxctrl_reg49_func_enum {

            GPIO = 0 { name = "GPIO"; desc = "GPIO function (dts gpio-range: pin 49)"; };

            SPI1_CSN1 = 1 { name = "SPI1_CSN1"; desc = "signal SPI1_CSN1 (dts group spi1_pmux)"; };

            I2S_SD_TX = 4 { name = "I2S_SD_TX"; desc = "signal I2S_SD_TX (dts group i2s_with_jtag_pmux)"; };

        };

        field {
            name = "func";
            desc = "Function select (3 bits). INFERRED from the pinctrl-single function-mask 7.";
            sw = rw;
            hw = r;
            encode = muxctrl_reg49_func_enum;
        } func[2:0];
    } muxctrl_reg49 @ 0xC4;

    reg {
        name = "Pin 50 multiplexing register (muxctrl_reg50)";
        desc = "Pin multiplexing control, offset 0xC8. PROVENANCE: PROVEN functions from the vendor dts: 0=GPIO, 1=SPI1_CSN0, 4=I2S_WS_TX. Reset value: UNKNOWN (not in any source; GUESS 0)."; 

        enum muxctrl_reg50_func_enum {

            GPIO = 0 { name = "GPIO"; desc = "GPIO function (dts gpio-range: pin 50)"; };

            SPI1_CSN0 = 1 { name = "SPI1_CSN0"; desc = "signal SPI1_CSN0 (dts group spi1_pmux)"; };

            I2S_WS_TX = 4 { name = "I2S_WS_TX"; desc = "signal I2S_WS_TX (dts group i2s_with_jtag_pmux)"; };

        };

        field {
            name = "func";
            desc = "Function select (3 bits). INFERRED from the pinctrl-single function-mask 7.";
            sw = rw;
            hw = r;
            encode = muxctrl_reg50_func_enum;
        } func[2:0];
    } muxctrl_reg50 @ 0xC8;

    reg {
        name = "Pin 51 multiplexing register (muxctrl_reg51)";
        desc = "Pin multiplexing control, offset 0xCC. PROVENANCE: PROVEN functions from the vendor dts: 0=GPIO, 1=SPI1_SDO, 4=I2S_BCLK_TX. Reset value: UNKNOWN (not in any source; GUESS 0)."; 

        enum muxctrl_reg51_func_enum {

            GPIO = 0 { name = "GPIO"; desc = "GPIO function (dts gpio-range: pin 51)"; };

            SPI1_SDO = 1 { name = "SPI1_SDO"; desc = "signal SPI1_SDO (dts group spi1_pmux)"; };

            I2S_BCLK_TX = 4 { name = "I2S_BCLK_TX"; desc = "signal I2S_BCLK_TX (dts group i2s_with_jtag_pmux)"; };

        };

        field {
            name = "func";
            desc = "Function select (3 bits). INFERRED from the pinctrl-single function-mask 7.";
            sw = rw;
            hw = r;
            encode = muxctrl_reg51_func_enum;
        } func[2:0];
    } muxctrl_reg51 @ 0xCC;

    reg {
        name = "Pin 52 multiplexing register (muxctrl_reg52)";
        desc = "Pin multiplexing control, offset 0xD0. PROVENANCE: PROVEN functions from the vendor dts: 0=GPIO, 1=SPI1_SDI, 4=I2S_MCLK. Reset value: UNKNOWN (not in any source; GUESS 0)."; 

        enum muxctrl_reg52_func_enum {

            GPIO = 0 { name = "GPIO"; desc = "GPIO function (dts gpio-range: pin 52)"; };

            SPI1_SDI = 1 { name = "SPI1_SDI"; desc = "signal SPI1_SDI (dts group spi1_pmux)"; };

            I2S_MCLK = 4 { name = "I2S_MCLK"; desc = "signal I2S_MCLK (dts group i2s_with_jtag_pmux)"; };

        };

        field {
            name = "func";
            desc = "Function select (3 bits). INFERRED from the pinctrl-single function-mask 7.";
            sw = rw;
            hw = r;
            encode = muxctrl_reg52_func_enum;
        } func[2:0];
    } muxctrl_reg52 @ 0xD0;

    reg {
        name = "Pin 53 multiplexing register (muxctrl_reg53)";
        desc = "Pin multiplexing control, offset 0xD4. PROVENANCE: PROVEN functions from the vendor dts: 0=GPIO, 1=SPI1_SCLK, 4=I2S_SD_RX. Reset value: UNKNOWN (not in any source; GUESS 0)."; 

        enum muxctrl_reg53_func_enum {

            GPIO = 0 { name = "GPIO"; desc = "GPIO function (dts gpio-range: pin 53)"; };

            SPI1_SCLK = 1 { name = "SPI1_SCLK"; desc = "signal SPI1_SCLK (dts group spi1_pmux)"; };

            I2S_SD_RX = 4 { name = "I2S_SD_RX"; desc = "signal I2S_SD_RX (dts group i2s_with_jtag_pmux)"; };

        };

        field {
            name = "func";
            desc = "Function select (3 bits). INFERRED from the pinctrl-single function-mask 7.";
            sw = rw;
            hw = r;
            encode = muxctrl_reg53_func_enum;
        } func[2:0];
    } muxctrl_reg53 @ 0xD4;

    reg {
        name = "Pin 54 multiplexing register (muxctrl_reg54)";
        desc = "Pin multiplexing control, offset 0xD8. PROVENANCE: no function is named by any vendor dts for this pin: UNKNOWN. Reset value: UNKNOWN (not in any source; GUESS 0)."; 

        field {
            name = "func";
            desc = "Function select (3 bits). INFERRED from the pinctrl-single function-mask 7.";
            sw = rw;
            hw = r;
        } func[2:0];
    } muxctrl_reg54 @ 0xD8;

    reg {
        name = "Pin 55 multiplexing register (muxctrl_reg55)";
        desc = "Pin multiplexing control, offset 0xDC. PROVENANCE: PROVEN functions from the vendor dts: 1=GPIO. Reset value: UNKNOWN (not in any source; GUESS 0)."; 

        enum muxctrl_reg55_func_enum {

            GPIO = 1 { name = "GPIO"; desc = "GPIO function (dts gpio-range: pin 55)"; };

        };

        field {
            name = "func";
            desc = "Function select (3 bits). INFERRED from the pinctrl-single function-mask 7.";
            sw = rw;
            hw = r;
            encode = muxctrl_reg55_func_enum;
        } func[2:0];
    } muxctrl_reg55 @ 0xDC;

    reg {
        name = "Pin 56 multiplexing register (muxctrl_reg56)";
        desc = "Pin multiplexing control, offset 0xE0. PROVENANCE: PROVEN functions from the vendor dts: 1=GPIO. Reset value: UNKNOWN (not in any source; GUESS 0)."; 

        enum muxctrl_reg56_func_enum {

            GPIO = 1 { name = "GPIO"; desc = "GPIO function (dts gpio-range: pin 56)"; };

        };

        field {
            name = "func";
            desc = "Function select (3 bits). INFERRED from the pinctrl-single function-mask 7.";
            sw = rw;
            hw = r;
            encode = muxctrl_reg56_func_enum;
        } func[2:0];
    } muxctrl_reg56 @ 0xE0;

    reg {
        name = "Pin 57 multiplexing register (muxctrl_reg57)";
        desc = "Pin multiplexing control, offset 0xE4. PROVENANCE: PROVEN functions from the vendor dts: 1=GPIO. Reset value: UNKNOWN (not in any source; GUESS 0)."; 

        enum muxctrl_reg57_func_enum {

            GPIO = 1 { name = "GPIO"; desc = "GPIO function (dts gpio-range: pin 57)"; };

        };

        field {
            name = "func";
            desc = "Function select (3 bits). INFERRED from the pinctrl-single function-mask 7.";
            sw = rw;
            hw = r;
            encode = muxctrl_reg57_func_enum;
        } func[2:0];
    } muxctrl_reg57 @ 0xE4;

    reg {
        name = "Pin 58 multiplexing register (muxctrl_reg58)";
        desc = "Pin multiplexing control, offset 0xE8. PROVENANCE: PROVEN functions from the vendor dts: 1=GPIO. Reset value: UNKNOWN (not in any source; GUESS 0)."; 

        enum muxctrl_reg58_func_enum {

            GPIO = 1 { name = "GPIO"; desc = "GPIO function (dts gpio-range: pin 58)"; };

        };

        field {
            name = "func";
            desc = "Function select (3 bits). INFERRED from the pinctrl-single function-mask 7.";
            sw = rw;
            hw = r;
            encode = muxctrl_reg58_func_enum;
        } func[2:0];
    } muxctrl_reg58 @ 0xE8;

    reg {
        name = "Pin 59 multiplexing register (muxctrl_reg59)";
        desc = "Pin multiplexing control, offset 0xEC. PROVENANCE: PROVEN functions from the vendor dts: 1=GPIO. Reset value: UNKNOWN (not in any source; GUESS 0)."; 

        enum muxctrl_reg59_func_enum {

            GPIO = 1 { name = "GPIO"; desc = "GPIO function (dts gpio-range: pin 59)"; };

        };

        field {
            name = "func";
            desc = "Function select (3 bits). INFERRED from the pinctrl-single function-mask 7.";
            sw = rw;
            hw = r;
            encode = muxctrl_reg59_func_enum;
        } func[2:0];
    } muxctrl_reg59 @ 0xEC;

    reg {
        name = "Pin 60 multiplexing register (muxctrl_reg60)";
        desc = "Pin multiplexing control, offset 0xF0. PROVENANCE: PROVEN functions from the vendor dts: 1=GPIO. Reset value: UNKNOWN (not in any source; GUESS 0)."; 

        enum muxctrl_reg60_func_enum {

            GPIO = 1 { name = "GPIO"; desc = "GPIO function (dts gpio-range: pin 60)"; };

        };

        field {
            name = "func";
            desc = "Function select (3 bits). INFERRED from the pinctrl-single function-mask 7.";
            sw = rw;
            hw = r;
            encode = muxctrl_reg60_func_enum;
        } func[2:0];
    } muxctrl_reg60 @ 0xF0;

    reg {
        name = "Pin 61 multiplexing register (muxctrl_reg61)";
        desc = "Pin multiplexing control, offset 0xF4. PROVENANCE: PROVEN functions from the vendor dts: 0=GPIO. Reset value: UNKNOWN (not in any source; GUESS 0)."; 

        enum muxctrl_reg61_func_enum {

            GPIO = 0 { name = "GPIO"; desc = "GPIO function (dts gpio-range: pin 61)"; };

        };

        field {
            name = "func";
            desc = "Function select (3 bits). INFERRED from the pinctrl-single function-mask 7.";
            sw = rw;
            hw = r;
            encode = muxctrl_reg61_func_enum;
        } func[2:0];
    } muxctrl_reg61 @ 0xF4;

    reg {
        name = "Pin 62 multiplexing register (muxctrl_reg62)";
        desc = "Pin multiplexing control, offset 0xF8. PROVENANCE: PROVEN functions from the vendor dts: 0=GPIO. Reset value: UNKNOWN (not in any source; GUESS 0)."; 

        enum muxctrl_reg62_func_enum {

            GPIO = 0 { name = "GPIO"; desc = "GPIO function (dts gpio-range: pin 62)"; };

        };

        field {
            name = "func";
            desc = "Function select (3 bits). INFERRED from the pinctrl-single function-mask 7.";
            sw = rw;
            hw = r;
            encode = muxctrl_reg62_func_enum;
        } func[2:0];
    } muxctrl_reg62 @ 0xF8;

    reg {
        name = "Pin 63 multiplexing register (muxctrl_reg63)";
        desc = "Pin multiplexing control, offset 0xFC. PROVENANCE: PROVEN functions from the vendor dts: 0=GPIO. Reset value: UNKNOWN (not in any source; GUESS 0)."; 

        enum muxctrl_reg63_func_enum {

            GPIO = 0 { name = "GPIO"; desc = "GPIO function (dts gpio-range: pin 63)"; };

        };

        field {
            name = "func";
            desc = "Function select (3 bits). INFERRED from the pinctrl-single function-mask 7.";
            sw = rw;
            hw = r;
            encode = muxctrl_reg63_func_enum;
        } func[2:0];
    } muxctrl_reg63 @ 0xFC;

    reg {
        name = "Pin 64 multiplexing register (muxctrl_reg64)";
        desc = "Pin multiplexing control, offset 0x100. PROVENANCE: PROVEN functions from the vendor dts: 0=GPIO. Reset value: UNKNOWN (not in any source; GUESS 0)."; 

        enum muxctrl_reg64_func_enum {

            GPIO = 0 { name = "GPIO"; desc = "GPIO function (dts gpio-range: pin 64)"; };

        };

        field {
            name = "func";
            desc = "Function select (3 bits). INFERRED from the pinctrl-single function-mask 7.";
            sw = rw;
            hw = r;
            encode = muxctrl_reg64_func_enum;
        } func[2:0];
    } muxctrl_reg64 @ 0x100;

    reg {
        name = "Pin 65 multiplexing register (muxctrl_reg65)";
        desc = "Pin multiplexing control, offset 0x104. PROVENANCE: PROVEN functions from the vendor dts: 0=GPIO. Reset value: UNKNOWN (not in any source; GUESS 0)."; 

        enum muxctrl_reg65_func_enum {

            GPIO = 0 { name = "GPIO"; desc = "GPIO function (dts gpio-range: pin 65)"; };

        };

        field {
            name = "func";
            desc = "Function select (3 bits). INFERRED from the pinctrl-single function-mask 7.";
            sw = rw;
            hw = r;
            encode = muxctrl_reg65_func_enum;
        } func[2:0];
    } muxctrl_reg65 @ 0x104;

    reg {
        name = "Pad control register 0 (padctrl_reg0)";
        desc = "Pad control, offset 0x800 (pin 0 for n < 66). PROVENANCE: no vendor dts entry for this register: UNKNOWN. Bits [6:4] drive strength code INFERRED, bit 0 GUESS."; 
        field {
            name = "drive";
            desc = "Drive strength code (INFERRED from the dts values 0x00..0x70).";
            sw = rw;
            hw = r;
        } drive[6:4];
    } padctrl_reg0 @ 0x800;

    reg {
        name = "Pad control register 1 (padctrl_reg1)";
        desc = "Pad control, offset 0x804 (pin 1 for n < 66). PROVENANCE: no vendor dts entry for this register: UNKNOWN. Bits [6:4] drive strength code INFERRED, bit 0 GUESS."; 
        field {
            name = "drive";
            desc = "Drive strength code (INFERRED from the dts values 0x00..0x70).";
            sw = rw;
            hw = r;
        } drive[6:4];
    } padctrl_reg1 @ 0x804;

    reg {
        name = "Pad control register 2 (padctrl_reg2)";
        desc = "Pad control, offset 0x808 (pin 2 for n < 66). PROVENANCE: no vendor dts entry for this register: UNKNOWN. Bits [6:4] drive strength code INFERRED, bit 0 GUESS."; 
        field {
            name = "drive";
            desc = "Drive strength code (INFERRED from the dts values 0x00..0x70).";
            sw = rw;
            hw = r;
        } drive[6:4];
    } padctrl_reg2 @ 0x808;

    reg {
        name = "Pad control register 3 (padctrl_reg3)";
        desc = "Pad control, offset 0x80C (pin 3 for n < 66). PROVENANCE: no vendor dts entry for this register: UNKNOWN. Bits [6:4] drive strength code INFERRED, bit 0 GUESS."; 
        field {
            name = "drive";
            desc = "Drive strength code (INFERRED from the dts values 0x00..0x70).";
            sw = rw;
            hw = r;
        } drive[6:4];
    } padctrl_reg3 @ 0x80C;

    reg {
        name = "Pad control register 4 (padctrl_reg4)";
        desc = "Pad control, offset 0x810 (pin 4 for n < 66). PROVENANCE: no vendor dts entry for this register: UNKNOWN. Bits [6:4] drive strength code INFERRED, bit 0 GUESS."; 
        field {
            name = "drive";
            desc = "Drive strength code (INFERRED from the dts values 0x00..0x70).";
            sw = rw;
            hw = r;
        } drive[6:4];
    } padctrl_reg4 @ 0x810;

    reg {
        name = "Pad control register 5 (padctrl_reg5)";
        desc = "Pad control, offset 0x814 (pin 5 for n < 66). PROVENANCE: no vendor dts entry for this register: UNKNOWN. Bits [6:4] drive strength code INFERRED, bit 0 GUESS."; 
        field {
            name = "drive";
            desc = "Drive strength code (INFERRED from the dts values 0x00..0x70).";
            sw = rw;
            hw = r;
        } drive[6:4];
    } padctrl_reg5 @ 0x814;

    reg {
        name = "Pad control register 6 (padctrl_reg6)";
        desc = "Pad control, offset 0x818 (pin 6 for n < 66). PROVENANCE: no vendor dts entry for this register: UNKNOWN. Bits [6:4] drive strength code INFERRED, bit 0 GUESS."; 
        field {
            name = "drive";
            desc = "Drive strength code (INFERRED from the dts values 0x00..0x70).";
            sw = rw;
            hw = r;
        } drive[6:4];
    } padctrl_reg6 @ 0x818;

    reg {
        name = "Pad control register 7 (padctrl_reg7)";
        desc = "Pad control, offset 0x81C (pin 7 for n < 66). PROVENANCE: no vendor dts entry for this register: UNKNOWN. Bits [6:4] drive strength code INFERRED, bit 0 GUESS."; 
        field {
            name = "drive";
            desc = "Drive strength code (INFERRED from the dts values 0x00..0x70).";
            sw = rw;
            hw = r;
        } drive[6:4];
    } padctrl_reg7 @ 0x81C;

    reg {
        name = "Pad control register 8 (padctrl_reg8)";
        desc = "Pad control, offset 0x820 (pin 8 for n < 66). PROVENANCE: PROVEN: the vendor dts writes drive-strength value(s) 0x30 (mask 0xFF) for this pin. Bits [6:4] drive strength code INFERRED, bit 0 GUESS."; 
        field {
            name = "drive";
            desc = "Drive strength code (INFERRED from the dts values 0x00..0x70).";
            sw = rw;
            hw = r;
        } drive[6:4];
    } padctrl_reg8 @ 0x820;

    reg {
        name = "Pad control register 9 (padctrl_reg9)";
        desc = "Pad control, offset 0x824 (pin 9 for n < 66). PROVENANCE: PROVEN: the vendor dts writes drive-strength value(s) 0x30 (mask 0xFF) for this pin. Bits [6:4] drive strength code INFERRED, bit 0 GUESS."; 
        field {
            name = "drive";
            desc = "Drive strength code (INFERRED from the dts values 0x00..0x70).";
            sw = rw;
            hw = r;
        } drive[6:4];
    } padctrl_reg9 @ 0x824;

    reg {
        name = "Pad control register 10 (padctrl_reg10)";
        desc = "Pad control, offset 0x828 (pin 10 for n < 66). PROVENANCE: PROVEN: the vendor dts writes drive-strength value(s) 0x20 (mask 0xFF) for this pin. Bits [6:4] drive strength code INFERRED, bit 0 GUESS."; 
        field {
            name = "drive";
            desc = "Drive strength code (INFERRED from the dts values 0x00..0x70).";
            sw = rw;
            hw = r;
        } drive[6:4];
    } padctrl_reg10 @ 0x828;

    reg {
        name = "Pad control register 11 (padctrl_reg11)";
        desc = "Pad control, offset 0x82C (pin 11 for n < 66). PROVENANCE: PROVEN: the vendor dts writes drive-strength value(s) 0x20, 0x70 (mask 0xFF) for this pin. Bits [6:4] drive strength code INFERRED, bit 0 GUESS."; 
        field {
            name = "drive";
            desc = "Drive strength code (INFERRED from the dts values 0x00..0x70).";
            sw = rw;
            hw = r;
        } drive[6:4];
    } padctrl_reg11 @ 0x82C;

    reg {
        name = "Pad control register 12 (padctrl_reg12)";
        desc = "Pad control, offset 0x830 (pin 12 for n < 66). PROVENANCE: PROVEN: the vendor dts writes drive-strength value(s) 0x50, 0x70 (mask 0xFF) for this pin. Bits [6:4] drive strength code INFERRED, bit 0 GUESS."; 
        field {
            name = "drive";
            desc = "Drive strength code (INFERRED from the dts values 0x00..0x70).";
            sw = rw;
            hw = r;
        } drive[6:4];
    } padctrl_reg12 @ 0x830;

    reg {
        name = "Pad control register 13 (padctrl_reg13)";
        desc = "Pad control, offset 0x834 (pin 13 for n < 66). PROVENANCE: PROVEN: the vendor dts writes drive-strength value(s) 0x30, 0x70 (mask 0xFF) for this pin. Bits [6:4] drive strength code INFERRED, bit 0 GUESS."; 
        field {
            name = "drive";
            desc = "Drive strength code (INFERRED from the dts values 0x00..0x70).";
            sw = rw;
            hw = r;
        } drive[6:4];
    } padctrl_reg13 @ 0x834;

    reg {
        name = "Pad control register 14 (padctrl_reg14)";
        desc = "Pad control, offset 0x838 (pin 14 for n < 66). PROVENANCE: PROVEN: the vendor dts writes drive-strength value(s) 0x31 (mask 0xFF) for this pin. Bits [6:4] drive strength code INFERRED, bit 0 GUESS."; 
        field {
            name = "drive";
            desc = "Drive strength code (INFERRED from the dts values 0x00..0x70).";
            sw = rw;
            hw = r;
        } drive[6:4];
    } padctrl_reg14 @ 0x838;

    reg {
        name = "Pad control register 15 (padctrl_reg15)";
        desc = "Pad control, offset 0x83C (pin 15 for n < 66). PROVENANCE: PROVEN: the vendor dts writes drive-strength value(s) 0x20 (mask 0xFF) for this pin. Bits [6:4] drive strength code INFERRED, bit 0 GUESS."; 
        field {
            name = "drive";
            desc = "Drive strength code (INFERRED from the dts values 0x00..0x70).";
            sw = rw;
            hw = r;
        } drive[6:4];
    } padctrl_reg15 @ 0x83C;

    reg {
        name = "Pad control register 16 (padctrl_reg16)";
        desc = "Pad control, offset 0x840 (pin 16 for n < 66). PROVENANCE: PROVEN: the vendor dts writes drive-strength value(s) 0x40, 0x70 (mask 0xFF) for this pin. Bits [6:4] drive strength code INFERRED, bit 0 GUESS."; 
        field {
            name = "drive";
            desc = "Drive strength code (INFERRED from the dts values 0x00..0x70).";
            sw = rw;
            hw = r;
        } drive[6:4];
    } padctrl_reg16 @ 0x840;

    reg {
        name = "Pad control register 17 (padctrl_reg17)";
        desc = "Pad control, offset 0x844 (pin 17 for n < 66). PROVENANCE: PROVEN: the vendor dts writes drive-strength value(s) 0x10, 0x20, 0x70 (mask 0xFF) for this pin. Bits [6:4] drive strength code INFERRED, bit 0 GUESS."; 
        field {
            name = "drive";
            desc = "Drive strength code (INFERRED from the dts values 0x00..0x70).";
            sw = rw;
            hw = r;
        } drive[6:4];
    } padctrl_reg17 @ 0x844;

    reg {
        name = "Pad control register 18 (padctrl_reg18)";
        desc = "Pad control, offset 0x848 (pin 18 for n < 66). PROVENANCE: PROVEN: the vendor dts writes drive-strength value(s) 0x10, 0x20, 0x70 (mask 0xFF) for this pin. Bits [6:4] drive strength code INFERRED, bit 0 GUESS."; 
        field {
            name = "drive";
            desc = "Drive strength code (INFERRED from the dts values 0x00..0x70).";
            sw = rw;
            hw = r;
        } drive[6:4];
    } padctrl_reg18 @ 0x848;

    reg {
        name = "Pad control register 19 (padctrl_reg19)";
        desc = "Pad control, offset 0x84C (pin 19 for n < 66). PROVENANCE: PROVEN: the vendor dts writes drive-strength value(s) 0x10, 0x20, 0x70 (mask 0xFF) for this pin. Bits [6:4] drive strength code INFERRED, bit 0 GUESS."; 
        field {
            name = "drive";
            desc = "Drive strength code (INFERRED from the dts values 0x00..0x70).";
            sw = rw;
            hw = r;
        } drive[6:4];
    } padctrl_reg19 @ 0x84C;

    reg {
        name = "Pad control register 20 (padctrl_reg20)";
        desc = "Pad control, offset 0x850 (pin 20 for n < 66). PROVENANCE: PROVEN: the vendor dts writes drive-strength value(s) 0x10, 0x20, 0x70 (mask 0xFF) for this pin. Bits [6:4] drive strength code INFERRED, bit 0 GUESS."; 
        field {
            name = "drive";
            desc = "Drive strength code (INFERRED from the dts values 0x00..0x70).";
            sw = rw;
            hw = r;
        } drive[6:4];
    } padctrl_reg20 @ 0x850;

    reg {
        name = "Pad control register 21 (padctrl_reg21)";
        desc = "Pad control, offset 0x854 (pin 21 for n < 66). PROVENANCE: PROVEN: the vendor dts writes drive-strength value(s) 0x10, 0x20, 0x70 (mask 0xFF) for this pin. Bits [6:4] drive strength code INFERRED, bit 0 GUESS."; 
        field {
            name = "drive";
            desc = "Drive strength code (INFERRED from the dts values 0x00..0x70).";
            sw = rw;
            hw = r;
        } drive[6:4];
    } padctrl_reg21 @ 0x854;

    reg {
        name = "Pad control register 22 (padctrl_reg22)";
        desc = "Pad control, offset 0x858 (pin 22 for n < 66). PROVENANCE: PROVEN: the vendor dts writes drive-strength value(s) 0x10, 0x20, 0x70 (mask 0xFF) for this pin. Bits [6:4] drive strength code INFERRED, bit 0 GUESS."; 
        field {
            name = "drive";
            desc = "Drive strength code (INFERRED from the dts values 0x00..0x70).";
            sw = rw;
            hw = r;
        } drive[6:4];
    } padctrl_reg22 @ 0x858;

    reg {
        name = "Pad control register 23 (padctrl_reg23)";
        desc = "Pad control, offset 0x85C (pin 23 for n < 66). PROVENANCE: PROVEN: the vendor dts writes drive-strength value(s) 0x10, 0x20, 0x70 (mask 0xFF) for this pin. Bits [6:4] drive strength code INFERRED, bit 0 GUESS."; 
        field {
            name = "drive";
            desc = "Drive strength code (INFERRED from the dts values 0x00..0x70).";
            sw = rw;
            hw = r;
        } drive[6:4];
    } padctrl_reg23 @ 0x85C;

    reg {
        name = "Pad control register 24 (padctrl_reg24)";
        desc = "Pad control, offset 0x860 (pin 24 for n < 66). PROVENANCE: PROVEN: the vendor dts writes drive-strength value(s) 0x10, 0x20, 0x70 (mask 0xFF) for this pin. Bits [6:4] drive strength code INFERRED, bit 0 GUESS."; 
        field {
            name = "drive";
            desc = "Drive strength code (INFERRED from the dts values 0x00..0x70).";
            sw = rw;
            hw = r;
        } drive[6:4];
    } padctrl_reg24 @ 0x860;

    reg {
        name = "Pad control register 25 (padctrl_reg25)";
        desc = "Pad control, offset 0x864 (pin 25 for n < 66). PROVENANCE: PROVEN: the vendor dts writes drive-strength value(s) 0x10 (mask 0xFF) for this pin. Bits [6:4] drive strength code INFERRED, bit 0 GUESS."; 
        field {
            name = "drive";
            desc = "Drive strength code (INFERRED from the dts values 0x00..0x70).";
            sw = rw;
            hw = r;
        } drive[6:4];
    } padctrl_reg25 @ 0x864;

    reg {
        name = "Pad control register 26 (padctrl_reg26)";
        desc = "Pad control, offset 0x868 (pin 26 for n < 66). PROVENANCE: no vendor dts entry for this register: UNKNOWN. Bits [6:4] drive strength code INFERRED, bit 0 GUESS."; 
        field {
            name = "drive";
            desc = "Drive strength code (INFERRED from the dts values 0x00..0x70).";
            sw = rw;
            hw = r;
        } drive[6:4];
    } padctrl_reg26 @ 0x868;

    reg {
        name = "Pad control register 27 (padctrl_reg27)";
        desc = "Pad control, offset 0x86C (pin 27 for n < 66). PROVENANCE: no vendor dts entry for this register: UNKNOWN. Bits [6:4] drive strength code INFERRED, bit 0 GUESS."; 
        field {
            name = "drive";
            desc = "Drive strength code (INFERRED from the dts values 0x00..0x70).";
            sw = rw;
            hw = r;
        } drive[6:4];
    } padctrl_reg27 @ 0x86C;

    reg {
        name = "Pad control register 28 (padctrl_reg28)";
        desc = "Pad control, offset 0x870 (pin 28 for n < 66). PROVENANCE: no vendor dts entry for this register: UNKNOWN. Bits [6:4] drive strength code INFERRED, bit 0 GUESS."; 
        field {
            name = "drive";
            desc = "Drive strength code (INFERRED from the dts values 0x00..0x70).";
            sw = rw;
            hw = r;
        } drive[6:4];
    } padctrl_reg28 @ 0x870;

    reg {
        name = "Pad control register 29 (padctrl_reg29)";
        desc = "Pad control, offset 0x874 (pin 29 for n < 66). PROVENANCE: no vendor dts entry for this register: UNKNOWN. Bits [6:4] drive strength code INFERRED, bit 0 GUESS."; 
        field {
            name = "drive";
            desc = "Drive strength code (INFERRED from the dts values 0x00..0x70).";
            sw = rw;
            hw = r;
        } drive[6:4];
    } padctrl_reg29 @ 0x874;

    reg {
        name = "Pad control register 30 (padctrl_reg30)";
        desc = "Pad control, offset 0x878 (pin 30 for n < 66). PROVENANCE: no vendor dts entry for this register: UNKNOWN. Bits [6:4] drive strength code INFERRED, bit 0 GUESS."; 
        field {
            name = "drive";
            desc = "Drive strength code (INFERRED from the dts values 0x00..0x70).";
            sw = rw;
            hw = r;
        } drive[6:4];
    } padctrl_reg30 @ 0x878;

    reg {
        name = "Pad control register 31 (padctrl_reg31)";
        desc = "Pad control, offset 0x87C (pin 31 for n < 66). PROVENANCE: no vendor dts entry for this register: UNKNOWN. Bits [6:4] drive strength code INFERRED, bit 0 GUESS."; 
        field {
            name = "drive";
            desc = "Drive strength code (INFERRED from the dts values 0x00..0x70).";
            sw = rw;
            hw = r;
        } drive[6:4];
    } padctrl_reg31 @ 0x87C;

    reg {
        name = "Pad control register 32 (padctrl_reg32)";
        desc = "Pad control, offset 0x880 (pin 32 for n < 66). PROVENANCE: no vendor dts entry for this register: UNKNOWN. Bits [6:4] drive strength code INFERRED, bit 0 GUESS."; 
        field {
            name = "drive";
            desc = "Drive strength code (INFERRED from the dts values 0x00..0x70).";
            sw = rw;
            hw = r;
        } drive[6:4];
    } padctrl_reg32 @ 0x880;

    reg {
        name = "Pad control register 33 (padctrl_reg33)";
        desc = "Pad control, offset 0x884 (pin 33 for n < 66). PROVENANCE: no vendor dts entry for this register: UNKNOWN. Bits [6:4] drive strength code INFERRED, bit 0 GUESS."; 
        field {
            name = "drive";
            desc = "Drive strength code (INFERRED from the dts values 0x00..0x70).";
            sw = rw;
            hw = r;
        } drive[6:4];
    } padctrl_reg33 @ 0x884;

    reg {
        name = "Pad control register 34 (padctrl_reg34)";
        desc = "Pad control, offset 0x888 (pin 34 for n < 66). PROVENANCE: no vendor dts entry for this register: UNKNOWN. Bits [6:4] drive strength code INFERRED, bit 0 GUESS."; 
        field {
            name = "drive";
            desc = "Drive strength code (INFERRED from the dts values 0x00..0x70).";
            sw = rw;
            hw = r;
        } drive[6:4];
    } padctrl_reg34 @ 0x888;

    reg {
        name = "Pad control register 35 (padctrl_reg35)";
        desc = "Pad control, offset 0x88C (pin 35 for n < 66). PROVENANCE: no vendor dts entry for this register: UNKNOWN. Bits [6:4] drive strength code INFERRED, bit 0 GUESS."; 
        field {
            name = "drive";
            desc = "Drive strength code (INFERRED from the dts values 0x00..0x70).";
            sw = rw;
            hw = r;
        } drive[6:4];
    } padctrl_reg35 @ 0x88C;

    reg {
        name = "Pad control register 36 (padctrl_reg36)";
        desc = "Pad control, offset 0x890 (pin 36 for n < 66). PROVENANCE: no vendor dts entry for this register: UNKNOWN. Bits [6:4] drive strength code INFERRED, bit 0 GUESS."; 
        field {
            name = "drive";
            desc = "Drive strength code (INFERRED from the dts values 0x00..0x70).";
            sw = rw;
            hw = r;
        } drive[6:4];
    } padctrl_reg36 @ 0x890;

    reg {
        name = "Pad control register 37 (padctrl_reg37)";
        desc = "Pad control, offset 0x894 (pin 37 for n < 66). PROVENANCE: no vendor dts entry for this register: UNKNOWN. Bits [6:4] drive strength code INFERRED, bit 0 GUESS."; 
        field {
            name = "drive";
            desc = "Drive strength code (INFERRED from the dts values 0x00..0x70).";
            sw = rw;
            hw = r;
        } drive[6:4];
    } padctrl_reg37 @ 0x894;

    reg {
        name = "Pad control register 38 (padctrl_reg38)";
        desc = "Pad control, offset 0x898 (pin 38 for n < 66). PROVENANCE: no vendor dts entry for this register: UNKNOWN. Bits [6:4] drive strength code INFERRED, bit 0 GUESS."; 
        field {
            name = "drive";
            desc = "Drive strength code (INFERRED from the dts values 0x00..0x70).";
            sw = rw;
            hw = r;
        } drive[6:4];
    } padctrl_reg38 @ 0x898;

    reg {
        name = "Pad control register 39 (padctrl_reg39)";
        desc = "Pad control, offset 0x89C (pin 39 for n < 66). PROVENANCE: no vendor dts entry for this register: UNKNOWN. Bits [6:4] drive strength code INFERRED, bit 0 GUESS."; 
        field {
            name = "drive";
            desc = "Drive strength code (INFERRED from the dts values 0x00..0x70).";
            sw = rw;
            hw = r;
        } drive[6:4];
    } padctrl_reg39 @ 0x89C;

    reg {
        name = "Pad control register 40 (padctrl_reg40)";
        desc = "Pad control, offset 0x8A0 (pin 40 for n < 66). PROVENANCE: no vendor dts entry for this register: UNKNOWN. Bits [6:4] drive strength code INFERRED, bit 0 GUESS."; 
        field {
            name = "drive";
            desc = "Drive strength code (INFERRED from the dts values 0x00..0x70).";
            sw = rw;
            hw = r;
        } drive[6:4];
    } padctrl_reg40 @ 0x8A0;

    reg {
        name = "Pad control register 41 (padctrl_reg41)";
        desc = "Pad control, offset 0x8A4 (pin 41 for n < 66). PROVENANCE: no vendor dts entry for this register: UNKNOWN. Bits [6:4] drive strength code INFERRED, bit 0 GUESS."; 
        field {
            name = "drive";
            desc = "Drive strength code (INFERRED from the dts values 0x00..0x70).";
            sw = rw;
            hw = r;
        } drive[6:4];
    } padctrl_reg41 @ 0x8A4;

    reg {
        name = "Pad control register 42 (padctrl_reg42)";
        desc = "Pad control, offset 0x8A8 (pin 42 for n < 66). PROVENANCE: no vendor dts entry for this register: UNKNOWN. Bits [6:4] drive strength code INFERRED, bit 0 GUESS."; 
        field {
            name = "drive";
            desc = "Drive strength code (INFERRED from the dts values 0x00..0x70).";
            sw = rw;
            hw = r;
        } drive[6:4];
    } padctrl_reg42 @ 0x8A8;

    reg {
        name = "Pad control register 43 (padctrl_reg43)";
        desc = "Pad control, offset 0x8AC (pin 43 for n < 66). PROVENANCE: no vendor dts entry for this register: UNKNOWN. Bits [6:4] drive strength code INFERRED, bit 0 GUESS."; 
        field {
            name = "drive";
            desc = "Drive strength code (INFERRED from the dts values 0x00..0x70).";
            sw = rw;
            hw = r;
        } drive[6:4];
    } padctrl_reg43 @ 0x8AC;

    reg {
        name = "Pad control register 44 (padctrl_reg44)";
        desc = "Pad control, offset 0x8B0 (pin 44 for n < 66). PROVENANCE: no vendor dts entry for this register: UNKNOWN. Bits [6:4] drive strength code INFERRED, bit 0 GUESS."; 
        field {
            name = "drive";
            desc = "Drive strength code (INFERRED from the dts values 0x00..0x70).";
            sw = rw;
            hw = r;
        } drive[6:4];
    } padctrl_reg44 @ 0x8B0;

    reg {
        name = "Pad control register 45 (padctrl_reg45)";
        desc = "Pad control, offset 0x8B4 (pin 45 for n < 66). PROVENANCE: no vendor dts entry for this register: UNKNOWN. Bits [6:4] drive strength code INFERRED, bit 0 GUESS."; 
        field {
            name = "drive";
            desc = "Drive strength code (INFERRED from the dts values 0x00..0x70).";
            sw = rw;
            hw = r;
        } drive[6:4];
    } padctrl_reg45 @ 0x8B4;

    reg {
        name = "Pad control register 46 (padctrl_reg46)";
        desc = "Pad control, offset 0x8B8 (pin 46 for n < 66). PROVENANCE: no vendor dts entry for this register: UNKNOWN. Bits [6:4] drive strength code INFERRED, bit 0 GUESS."; 
        field {
            name = "drive";
            desc = "Drive strength code (INFERRED from the dts values 0x00..0x70).";
            sw = rw;
            hw = r;
        } drive[6:4];
    } padctrl_reg46 @ 0x8B8;

    reg {
        name = "Pad control register 47 (padctrl_reg47)";
        desc = "Pad control, offset 0x8BC (pin 47 for n < 66). PROVENANCE: no vendor dts entry for this register: UNKNOWN. Bits [6:4] drive strength code INFERRED, bit 0 GUESS."; 
        field {
            name = "drive";
            desc = "Drive strength code (INFERRED from the dts values 0x00..0x70).";
            sw = rw;
            hw = r;
        } drive[6:4];
    } padctrl_reg47 @ 0x8BC;

    reg {
        name = "Pad control register 48 (padctrl_reg48)";
        desc = "Pad control, offset 0x8C0 (pin 48 for n < 66). PROVENANCE: no vendor dts entry for this register: UNKNOWN. Bits [6:4] drive strength code INFERRED, bit 0 GUESS."; 
        field {
            name = "drive";
            desc = "Drive strength code (INFERRED from the dts values 0x00..0x70).";
            sw = rw;
            hw = r;
        } drive[6:4];
    } padctrl_reg48 @ 0x8C0;

    reg {
        name = "Pad control register 49 (padctrl_reg49)";
        desc = "Pad control, offset 0x8C4 (pin 49 for n < 66). PROVENANCE: no vendor dts entry for this register: UNKNOWN. Bits [6:4] drive strength code INFERRED, bit 0 GUESS."; 
        field {
            name = "drive";
            desc = "Drive strength code (INFERRED from the dts values 0x00..0x70).";
            sw = rw;
            hw = r;
        } drive[6:4];
    } padctrl_reg49 @ 0x8C4;

    reg {
        name = "Pad control register 50 (padctrl_reg50)";
        desc = "Pad control, offset 0x8C8 (pin 50 for n < 66). PROVENANCE: no vendor dts entry for this register: UNKNOWN. Bits [6:4] drive strength code INFERRED, bit 0 GUESS."; 
        field {
            name = "drive";
            desc = "Drive strength code (INFERRED from the dts values 0x00..0x70).";
            sw = rw;
            hw = r;
        } drive[6:4];
    } padctrl_reg50 @ 0x8C8;

    reg {
        name = "Pad control register 51 (padctrl_reg51)";
        desc = "Pad control, offset 0x8CC (pin 51 for n < 66). PROVENANCE: no vendor dts entry for this register: UNKNOWN. Bits [6:4] drive strength code INFERRED, bit 0 GUESS."; 
        field {
            name = "drive";
            desc = "Drive strength code (INFERRED from the dts values 0x00..0x70).";
            sw = rw;
            hw = r;
        } drive[6:4];
    } padctrl_reg51 @ 0x8CC;

    reg {
        name = "Pad control register 52 (padctrl_reg52)";
        desc = "Pad control, offset 0x8D0 (pin 52 for n < 66). PROVENANCE: no vendor dts entry for this register: UNKNOWN. Bits [6:4] drive strength code INFERRED, bit 0 GUESS."; 
        field {
            name = "drive";
            desc = "Drive strength code (INFERRED from the dts values 0x00..0x70).";
            sw = rw;
            hw = r;
        } drive[6:4];
    } padctrl_reg52 @ 0x8D0;

    reg {
        name = "Pad control register 53 (padctrl_reg53)";
        desc = "Pad control, offset 0x8D4 (pin 53 for n < 66). PROVENANCE: no vendor dts entry for this register: UNKNOWN. Bits [6:4] drive strength code INFERRED, bit 0 GUESS."; 
        field {
            name = "drive";
            desc = "Drive strength code (INFERRED from the dts values 0x00..0x70).";
            sw = rw;
            hw = r;
        } drive[6:4];
    } padctrl_reg53 @ 0x8D4;

    reg {
        name = "Pad control register 54 (padctrl_reg54)";
        desc = "Pad control, offset 0x8D8 (pin 54 for n < 66). PROVENANCE: no vendor dts entry for this register: UNKNOWN. Bits [6:4] drive strength code INFERRED, bit 0 GUESS."; 
        field {
            name = "drive";
            desc = "Drive strength code (INFERRED from the dts values 0x00..0x70).";
            sw = rw;
            hw = r;
        } drive[6:4];
    } padctrl_reg54 @ 0x8D8;

    reg {
        name = "Pad control register 55 (padctrl_reg55)";
        desc = "Pad control, offset 0x8DC (pin 55 for n < 66). PROVENANCE: no vendor dts entry for this register: UNKNOWN. Bits [6:4] drive strength code INFERRED, bit 0 GUESS."; 
        field {
            name = "drive";
            desc = "Drive strength code (INFERRED from the dts values 0x00..0x70).";
            sw = rw;
            hw = r;
        } drive[6:4];
    } padctrl_reg55 @ 0x8DC;

    reg {
        name = "Pad control register 56 (padctrl_reg56)";
        desc = "Pad control, offset 0x8E0 (pin 56 for n < 66). PROVENANCE: no vendor dts entry for this register: UNKNOWN. Bits [6:4] drive strength code INFERRED, bit 0 GUESS."; 
        field {
            name = "drive";
            desc = "Drive strength code (INFERRED from the dts values 0x00..0x70).";
            sw = rw;
            hw = r;
        } drive[6:4];
    } padctrl_reg56 @ 0x8E0;

    reg {
        name = "Pad control register 57 (padctrl_reg57)";
        desc = "Pad control, offset 0x8E4 (pin 57 for n < 66). PROVENANCE: PROVEN: the vendor dts writes drive-strength value(s) 0x30 (mask 0xFF) for this pin. Bits [6:4] drive strength code INFERRED, bit 0 GUESS."; 
        field {
            name = "drive";
            desc = "Drive strength code (INFERRED from the dts values 0x00..0x70).";
            sw = rw;
            hw = r;
        } drive[6:4];
    } padctrl_reg57 @ 0x8E4;

    reg {
        name = "Pad control register 58 (padctrl_reg58)";
        desc = "Pad control, offset 0x8E8 (pin 58 for n < 66). PROVENANCE: PROVEN: the vendor dts writes drive-strength value(s) 0x30 (mask 0xFF) for this pin. Bits [6:4] drive strength code INFERRED, bit 0 GUESS."; 
        field {
            name = "drive";
            desc = "Drive strength code (INFERRED from the dts values 0x00..0x70).";
            sw = rw;
            hw = r;
        } drive[6:4];
    } padctrl_reg58 @ 0x8E8;

    reg {
        name = "Pad control register 59 (padctrl_reg59)";
        desc = "Pad control, offset 0x8EC (pin 59 for n < 66). PROVENANCE: PROVEN: the vendor dts writes drive-strength value(s) 0x20, 0x30 (mask 0xFF) for this pin. Bits [6:4] drive strength code INFERRED, bit 0 GUESS."; 
        field {
            name = "drive";
            desc = "Drive strength code (INFERRED from the dts values 0x00..0x70).";
            sw = rw;
            hw = r;
        } drive[6:4];
    } padctrl_reg59 @ 0x8EC;

    reg {
        name = "Pad control register 60 (padctrl_reg60)";
        desc = "Pad control, offset 0x8F0 (pin 60 for n < 66). PROVENANCE: PROVEN: the vendor dts writes drive-strength value(s) 0x20, 0x30 (mask 0xFF) for this pin. Bits [6:4] drive strength code INFERRED, bit 0 GUESS."; 
        field {
            name = "drive";
            desc = "Drive strength code (INFERRED from the dts values 0x00..0x70).";
            sw = rw;
            hw = r;
        } drive[6:4];
    } padctrl_reg60 @ 0x8F0;

    reg {
        name = "Pad control register 61 (padctrl_reg61)";
        desc = "Pad control, offset 0x8F4 (pin 61 for n < 66). PROVENANCE: PROVEN: the vendor dts writes drive-strength value(s) 0x00, 0x30 (mask 0xFF) for this pin. Bits [6:4] drive strength code INFERRED, bit 0 GUESS."; 
        field {
            name = "drive";
            desc = "Drive strength code (INFERRED from the dts values 0x00..0x70).";
            sw = rw;
            hw = r;
        } drive[6:4];
    } padctrl_reg61 @ 0x8F4;

    reg {
        name = "Pad control register 62 (padctrl_reg62)";
        desc = "Pad control, offset 0x8F8 (pin 62 for n < 66). PROVENANCE: no vendor dts entry for this register: UNKNOWN. Bits [6:4] drive strength code INFERRED, bit 0 GUESS."; 
        field {
            name = "drive";
            desc = "Drive strength code (INFERRED from the dts values 0x00..0x70).";
            sw = rw;
            hw = r;
        } drive[6:4];
    } padctrl_reg62 @ 0x8F8;

    reg {
        name = "Pad control register 63 (padctrl_reg63)";
        desc = "Pad control, offset 0x8FC (pin 63 for n < 66). PROVENANCE: no vendor dts entry for this register: UNKNOWN. Bits [6:4] drive strength code INFERRED, bit 0 GUESS."; 
        field {
            name = "drive";
            desc = "Drive strength code (INFERRED from the dts values 0x00..0x70).";
            sw = rw;
            hw = r;
        } drive[6:4];
    } padctrl_reg63 @ 0x8FC;

    reg {
        name = "Pad control register 64 (padctrl_reg64)";
        desc = "Pad control, offset 0x900 (pin 64 for n < 66). PROVENANCE: no vendor dts entry for this register: UNKNOWN. Bits [6:4] drive strength code INFERRED, bit 0 GUESS."; 
        field {
            name = "drive";
            desc = "Drive strength code (INFERRED from the dts values 0x00..0x70).";
            sw = rw;
            hw = r;
        } drive[6:4];
    } padctrl_reg64 @ 0x900;

    reg {
        name = "Pad control register 65 (padctrl_reg65)";
        desc = "Pad control, offset 0x904 (pin 65 for n < 66). PROVENANCE: no vendor dts entry for this register: UNKNOWN. Bits [6:4] drive strength code INFERRED, bit 0 GUESS."; 
        field {
            name = "drive";
            desc = "Drive strength code (INFERRED from the dts values 0x00..0x70).";
            sw = rw;
            hw = r;
        } drive[6:4];
    } padctrl_reg65 @ 0x904;

    reg {
        name = "Pad control register 66 (padctrl_reg66)";
        desc = "Pad control, offset 0x908 (pin 66 for n < 66). PROVENANCE: no vendor dts entry for this register: UNKNOWN. Bits [6:4] drive strength code INFERRED, bit 0 GUESS."; 
        field {
            name = "drive";
            desc = "Drive strength code (INFERRED from the dts values 0x00..0x70).";
            sw = rw;
            hw = r;
        } drive[6:4];
    } padctrl_reg66 @ 0x908;

    reg {
        name = "Pad control register 67 (padctrl_reg67)";
        desc = "Pad control, offset 0x90C (pin 67 for n < 66). PROVENANCE: no vendor dts entry for this register: UNKNOWN. Bits [6:4] drive strength code INFERRED, bit 0 GUESS."; 
        field {
            name = "drive";
            desc = "Drive strength code (INFERRED from the dts values 0x00..0x70).";
            sw = rw;
            hw = r;
        } drive[6:4];
    } padctrl_reg67 @ 0x90C;

    reg {
        name = "Pad control register 68 (padctrl_reg68)";
        desc = "Pad control, offset 0x910 (pin 68 for n < 66). PROVENANCE: no vendor dts entry for this register: UNKNOWN. Bits [6:4] drive strength code INFERRED, bit 0 GUESS."; 
        field {
            name = "drive";
            desc = "Drive strength code (INFERRED from the dts values 0x00..0x70).";
            sw = rw;
            hw = r;
        } drive[6:4];
    } padctrl_reg68 @ 0x910;

    reg {
        name = "Pad control register 69 (padctrl_reg69)";
        desc = "Pad control, offset 0x914 (pin 69 for n < 66). PROVENANCE: no vendor dts entry for this register: UNKNOWN. Bits [6:4] drive strength code INFERRED, bit 0 GUESS."; 
        field {
            name = "drive";
            desc = "Drive strength code (INFERRED from the dts values 0x00..0x70).";
            sw = rw;
            hw = r;
        } drive[6:4];
    } padctrl_reg69 @ 0x914;

    reg {
        name = "Pad control register 70 (padctrl_reg70)";
        desc = "Pad control, offset 0x918 (pin 70 for n < 66). PROVENANCE: no vendor dts entry for this register: UNKNOWN. Bits [6:4] drive strength code INFERRED, bit 0 GUESS."; 
        field {
            name = "drive";
            desc = "Drive strength code (INFERRED from the dts values 0x00..0x70).";
            sw = rw;
            hw = r;
        } drive[6:4];
    } padctrl_reg70 @ 0x918;

    reg {
        name = "Pad control register 71 (padctrl_reg71)";
        desc = "Pad control, offset 0x91C (pin 71 for n < 66). PROVENANCE: no vendor dts entry for this register: UNKNOWN. Bits [6:4] drive strength code INFERRED, bit 0 GUESS."; 
        field {
            name = "drive";
            desc = "Drive strength code (INFERRED from the dts values 0x00..0x70).";
            sw = rw;
            hw = r;
        } drive[6:4];
    } padctrl_reg71 @ 0x91C;

    reg {
        name = "Pad control register 72 (padctrl_reg72)";
        desc = "Pad control, offset 0x920 (pin 72 for n < 66). PROVENANCE: no vendor dts entry for this register: UNKNOWN. Bits [6:4] drive strength code INFERRED, bit 0 GUESS."; 
        field {
            name = "drive";
            desc = "Drive strength code (INFERRED from the dts values 0x00..0x70).";
            sw = rw;
            hw = r;
        } drive[6:4];
    } padctrl_reg72 @ 0x920;

    reg {
        name = "Pad control register 73 (padctrl_reg73)";
        desc = "Pad control, offset 0x924 (pin 73 for n < 66). PROVENANCE: no vendor dts entry for this register: UNKNOWN. Bits [6:4] drive strength code INFERRED, bit 0 GUESS."; 
        field {
            name = "drive";
            desc = "Drive strength code (INFERRED from the dts values 0x00..0x70).";
            sw = rw;
            hw = r;
        } drive[6:4];
    } padctrl_reg73 @ 0x924;

    reg {
        name = "Pad control register 74 (padctrl_reg74)";
        desc = "Pad control, offset 0x928 (pin 74 for n < 66). PROVENANCE: no vendor dts entry for this register: UNKNOWN. Bits [6:4] drive strength code INFERRED, bit 0 GUESS."; 
        field {
            name = "drive";
            desc = "Drive strength code (INFERRED from the dts values 0x00..0x70).";
            sw = rw;
            hw = r;
        } drive[6:4];
    } padctrl_reg74 @ 0x928;

    reg {
        name = "Pad control register 75 (padctrl_reg75)";
        desc = "Pad control, offset 0x92C (pin 75 for n < 66). PROVENANCE: no vendor dts entry for this register: UNKNOWN. Bits [6:4] drive strength code INFERRED, bit 0 GUESS."; 
        field {
            name = "drive";
            desc = "Drive strength code (INFERRED from the dts values 0x00..0x70).";
            sw = rw;
            hw = r;
        } drive[6:4];
    } padctrl_reg75 @ 0x92C;

};

`endif
