`ifndef HISI_VDP_RDL
`define HISI_VDP_RDL

regfile eHISI_VDP_VHDP {
    name = "VHD video layer region m registers";
    desc = "The six per-region registers of the VHD layer; region m (m = 0..15) is at 0x400 + m x 0x20 (data sheet: VHDPmRESO 0x0400+m x 0x20, VHDPmLADDR 0x0404+..., VHDPmCADDR 0x0408+..., VHDPmSTRIDE 0x040C+..., VHDPmVFPOS 0x0410+..., VHDPmVLPOS 0x0414+...). Offsets here are relative to the region.";

    reg {
        name = "VHD region 0 resolution register (non-instant register)";
        desc = "VHDPmRESO is a VHD region 0 resolution register (non-instant register).

Data sheet 11.2.4 VHDPmRESO (offset 0x400, printed page 11-100, `datasheet.txt` line 38238).";

        field {
            name = "w";
            desc = "Width (in pixel). The value is the actual width minus 1. Note: The actual width must be an even number.";
            sw = rw;
            hw = r;
            reset = 0x0;
        } w_f[11:0];
    } VHDPRESO @ 0x0;

    reg {
        name = "VHD region m address register";
        desc = "VHDPmLADDR is a VHD region m address register.

Data sheet 11.2.4 VHDPmLADDR (offset 0x404, printed page 11-101, `datasheet.txt` line 38273).";

        field {
            name = "surface_addr";
            desc = "Start address of VHD region m.";
            sw = rw;
            hw = r;
            reset = 0x0;
        } surface_addr[31:0];
    } VHDPLADDR @ 0x4;

    reg {
        name = "VHD region m chrominance address register";
        desc = "VHDPmCADDR is a VHD region m chrominance address register.

Data sheet 11.2.4 VHDPmCADDR (offset 0x408, printed page 11-101, `datasheet.txt` line 38295).";

        field {
            name = "surface_addr";
            desc = "Chrominance start address of VHD region m.";
            sw = rw;
            hw = r;
            reset = 0x0;
        } surface_addr[31:0];
    } VHDPCADDR @ 0x8;

    reg {
        name = "VHD region m stride register";
        desc = "VHDPmSTRIDE is a VHD region m stride register.

Data sheet 11.2.4 VHDPmSTRIDE (offset 0x40C, printed page 11-101, `datasheet.txt` line 38317).";

        field {
            name = "surface_cstride";
            desc = "Stride of the chrominance buffer of VHD region m (valid in semi- planar format), 128-bit alignment.";
            sw = rw;
            hw = r;
            reset = 0x0;
        } surface_cstride[31:16];

        field {
            name = "surface_stride";
            desc = "Stride of the buffer of VHD region m (valid in semi-planar format, luminance stride), 128-bit alignment.";
            sw = rw;
            hw = r;
            reset = 0x0;
        } surface_stride[15:0];
    } VHDPSTRIDE @ 0xC;

    reg {
        name = "VHD region m video start position register (non-instant register)";
        desc = "VHDPmVFPOS is a VHD region m video start position register (non-instant register). The start position is in the unit of pixel.

Data sheet 11.2.4 VHDPmVFPOS (offset 0x410, printed page 11-102, `datasheet.txt` line 38356).";

        field {
            name = "video_yfpos";
            desc = "Start coordinates of the video column. The frame height is referenced and the unit is line.";
            sw = rw;
            hw = r;
            reset = 0x0;
        } video_yfpos[23:12];

        field {
            name = "video_xfpos";
            desc = "Start coordinates of the video row.";
            sw = rw;
            hw = r;
            reset = 0x0;
        } video_xfpos[11:0];
    } VHDPVFPOS @ 0x10;

    reg {
        name = "VHD region m video end position register (non-instant register)";
        desc = "VHDPmVLPOS is the VHD region m video end position register (non-instant register). The end position is in the unit of pixel.

Data sheet 11.2.4 VHDPmVLPOS (offset 0x414, printed page 11-102, `datasheet.txt` line 38383).";

        field {
            name = "video_ylpos";
            desc = "Start coordinates of the video column. The frame height is referenced and the unit is line.";
            sw = rw;
            hw = r;
            reset = 0x0;
        } video_ylpos[23:12];

        field {
            name = "video_xlpos";
            desc = "Start coordinates of the video row.";
            sw = rw;
            hw = r;
            reset = 0x0;
        } video_xlpos[11:0];
    } VHDPVLPOS @ 0x14;

};

regfile eHISI_VDP_VSD {
    name = "VSD video layer registers";
    desc = "Registers of one standard-definition video layer; VSDi (i = 0..1) is at 0x3000 + i x 0x1000 (data sheet VSDiXXX registers, offsets 0x3000+i x 0x1000 ...). Offsets here are relative to the layer start (0x000 = VSDiCTRL ... 0xC04 = VSDi16REGIONEN).";

    reg {
        name = "VSD control register (non-instant register)";
        desc = "VSDiCTRL is a VSD control register (non-instant register). It is used to configure the layer information

Data sheet 11.2.4 VSDiCTRL (offset 0x3000, printed page 11-105, `datasheet.txt` line 38507).";

        enum VSDCTRL_surface_en_enum {
            DISABLED = 0 { name = "Disabled"; desc = "disabled"; };
            ENABLED = 1 { name = "Enabled"; desc = "enabled"; };
        };

        field {
            name = "surface_en";
            desc = "Surface enable (non-instant register).";
            sw = rw;
            hw = r;
            encode = VSDCTRL_surface_en_enum;
            reset = 0x0;
        } surface_en[31:31];

        enum VSDCTRL_ifir_mode_enum {
            RESERVED = 0 { name = "Reserved"; desc = "reserved"; };
            CHROMINANCE_IFIR_COPY = 1 { name = "Chrominance Ifir Copy"; desc = "chrominance IFIR copy mode"; };
            BILINEAR_INTERPOLATION = 2 { name = "Bilinear Interpolation"; desc = "bilinear interpolation"; };
            V_6_TAP_FIR = 3 { name = "V 6 Tap Fir"; desc = "6-tap FIR"; };
        };

        field {
            name = "ifir_mode";
            desc = "Horizontal chrominance IFIR mode.";
            sw = rw;
            hw = r;
            encode = VSDCTRL_ifir_mode_enum;
            reset = 0x0;
        } ifir_mode[19:18];

        enum VSDCTRL_vup_mode_enum {
            UPDATE_FIELD = 0 { name = "Update Field"; desc = "update by field"; };
            UPDATE_FRAME = 1 { name = "Update Frame"; desc = "update by frame"; };
        };

        field {
            name = "vup_mode";
            desc = "Register update mode.";
            sw = rw;
            hw = r;
            encode = VSDCTRL_vup_mode_enum;
            reset = 0x0;
        } vup_mode[17:17];

        enum VSDCTRL_ifmt_enum {
            SPYCBCR420 = 3 { name = "Spycbcr420"; desc = "SPYCbCr420"; };
            SPYCBCR422_OTHER_VALUES = 4 { name = "Spycbcr422 Other Values"; desc = "SPYCbCr422 Other values: reserved"; };
        };

        field {
            name = "ifmt";
            desc = "Input data format.";
            sw = rw;
            hw = r;
            encode = VSDCTRL_ifmt_enum;
            reset = 0x0;
        } ifmt[3:0];
    } VSDCTRL @ 0x0;

    reg {
        name = "VSD channel update enable register";
        desc = "VSDiUPD is a VSD channel update enable register.

Data sheet 11.2.4 VSDiUPD (offset 0x3004, printed page 11-106, `datasheet.txt` line 38563).";

        field {
            name = "regup";
            desc = "Surface register update. After the registers at this layer are configured, the registers are updated when the value 1 is written to this bit. After updates, this bit is cleared automatically by the hardware.";
            sw = rw;
            hw = r;
            reset = 0x0;
        } regup[0:0];
    } VSDUPD @ 0x4;

    reg {
        name = "VSD current frame address register";
        desc = "VSDiCADDR is a VSD current frame address register. In package pixel format, the address is the address of the frame buffer; in semi-planar pixel format, the address is the address of the luminance frame buffer.

Data sheet 11.2.4 VSDiCADDR (offset 0x3010, printed page 11-106, `datasheet.txt` line 38594).";

        field {
            name = "surface_caddr";
            desc = "Address of the current frame.";
            sw = rw;
            hw = r;
            reset = 0x0;
        } surface_caddr[31:0];
    } VSDCADDR @ 0x10;

    reg {
        name = "VSDCCADDR";
        desc = "Data sheet 11.2.4 VSDiCCADDR (offset 0x3014, printed page 11-107, `datasheet.txt` line 38628).";

        field {
            name = "surface_ccaddr";
            desc = "Chrominance address of the current frame.";
            sw = rw;
            hw = r;
            reset = 0x0;
        } surface_ccaddr[31:0];
    } VSDCCADDR @ 0x14;

    reg {
        name = "VSD surface stride register";
        desc = "VSDiSTRIDE is a VSD surface stride register.

Data sheet 11.2.4 VSDiSTRIDE (offset 0x3024, printed page 11-107, `datasheet.txt` line 38650).";

        field {
            name = "surface_cstride";
            desc = "Stride of the chrominance frame buffer (valid in semi-planar format), 128-bit alignment.";
            sw = rw;
            hw = r;
            reset = 0x0;
        } surface_cstride[31:16];

        field {
            name = "surface_stride";
            desc = "Stride of the frame buffer (valid in semi-planar format, luminance stride), 128-bit alignment.";
            sw = rw;
            hw = r;
            reset = 0x0;
        } surface_stride[15:0];
    } VSDSTRIDE @ 0x24;

    reg {
        name = "VSD input resolution register (non-instant register)";
        desc = "VSDiIRESO is a VSD input resolution register (non-instant register).

Data sheet 11.2.4 VSDiIRESO (offset 0x3028, printed page 11-108, `datasheet.txt` line 38687).";

        field {
            name = "ih";
            desc = "Height (in line). The value is the actual height minus 1. The frame height is referenced.";
            sw = rw;
            hw = r;
            reset = 0x0;
        } ih[23:12];

        field {
            name = "iw";
            desc = "Width (in pixel). The value is the actual width minus 1.";
            sw = rw;
            hw = r;
            reset = 0x0;
        } iw[11:0];
    } VSDIRESO @ 0x28;

    reg {
        name = "VSD overlay parameter register (non-instant register)";
        desc = "VSDiCBMPARA is a VSD overlay parameter register (non-instant register).

Data sheet 11.2.4 VSDiCBMPARA (offset 0x3034, printed page 11-108, `datasheet.txt` line 38713).";

        field {
            name = "galpha";
            desc = "Overlay global alpha value. The value ranges from 0 to 128. The value 128 indicates opaque, and the value 0 indicates full transparent.";
            sw = rw;
            hw = r;
            reset = 0x0;
        } galpha[7:0];
    } VSDCBMPARA @ 0x34;

    reg {
        name = "VSD surface start position (in the display window) register (non-instant register)";
        desc = "VSDiDFPOS is a VSD surface start position (in the display window) register (non-instant register).

Data sheet 11.2.4 VSDiDFPOS (offset 0x3060, printed page 11-109, `datasheet.txt` line 38749).";

        field {
            name = "disp_yfpos";
            desc = "Start coordinates of the display column. The frame height is referenced and the unit is line.";
            sw = rw;
            hw = r;
            reset = 0x0;
        } disp_yfpos[23:12];

        field {
            name = "disp_xfpos";
            desc = "Start coordinates of the display row.";
            sw = rw;
            hw = r;
            reset = 0x0;
        } disp_xfpos[11:0];
    } VSDDFPOS @ 0x60;

    reg {
        name = "VSD surface end position (in the display window) register (non-instant register)";
        desc = "VSDiDLPOS is VSD surface end position (in the display window) register (non-instant register). The end position is in the unit of pixel.

Data sheet 11.2.4 VSDiDLPOS (offset 0x3064, printed page 11-109, `datasheet.txt` line 38776).";

        field {
            name = "disp_ylpos";
            desc = "End coordinates of the display column. The frame height is referenced and the unit is line.";
            sw = rw;
            hw = r;
            reset = 0x0;
        } disp_ylpos[23:12];

        field {
            name = "disp_xlpos";
            desc = "End coordinates of the display row.";
            sw = rw;
            hw = r;
            reset = 0x0;
        } disp_xlpos[11:0];
    } VSDDLPOS @ 0x64;

    reg {
        name = "Video layer background color register";
        desc = "VSDIBK is a video layer background color register.

Data sheet 11.2.4 VSDIBK (offset 0x3070, printed page 11-110, `datasheet.txt` line 38812).";

        field {
            name = "vbk_alpha";
            desc = "Levels 0-128 of the background filling color of the video layer.";
            sw = rw;
            hw = r;
            reset = 0x0;
        } vbk_alpha[31:24];

        field {
            name = "vbk_y";
            desc = "Y component.";
            sw = rw;
            hw = r;
            reset = 0x0;
        } vbk_y[23:16];

        field {
            name = "vbk_cb";
            desc = "Cb component.";
            sw = rw;
            hw = r;
            reset = 0x0;
        } vbk_cb[15:8];

        field {
            name = "vbk_cr";
            desc = "Cr component.";
            sw = rw;
            hw = r;
            reset = 0x0;
        } vbk_cr[7:0];
    } VSDBK @ 0x70;

    reg {
        name = "VSD input DC component register for CSC (instant register)";
        desc = "VSDiCSCIDC is a VSD input DC component register for CSC (instant register).

Data sheet 11.2.4 VSDiCSCIDC (offset 0x3080, printed page 11-110, `datasheet.txt` line 38836).";

        enum VSDCSCIDC_csc_en_enum {
            DISABLED = 0 { name = "Disabled"; desc = "disabled"; };
            ENABLED = 1 { name = "Enabled"; desc = "enabled"; };
        };

        field {
            name = "csc_en";
            desc = "CSC enable.";
            sw = rw;
            hw = r;
            encode = VSDCSCIDC_csc_en_enum;
            reset = 0x0;
        } csc_en[27:27];

        field {
            name = "cscidc2";
            desc = "DC parameter of input component 2. The MSB is the signed bit. The value is expressed as the complement.";
            sw = rw;
            hw = r;
            reset = 0x0;
        } cscidc2[26:18];

        field {
            name = "cscidc1";
            desc = "DC parameter of input component 1. The MSB is the signed bit. The value is expressed as the complement.";
            sw = rw;
            hw = r;
            reset = 0x0;
        } cscidc1[17:9];

        field {
            name = "cscidc0";
            desc = "DC parameter of input component 0. The MSB is the signed bit. The value is expressed as the complement.";
            sw = rw;
            hw = r;
            reset = 0x0;
        } cscidc0[8:0];
    } VSDCSCIDC @ 0x80;

    reg {
        name = "VSD output DC component register for CSC (instant register)";
        desc = "VSDiCSCODC is a VSD output DC component register for CSC (instant register).

Data sheet 11.2.4 VSDiCSCODC (offset 0x3084, printed page 11-111, `datasheet.txt` line 38879).";

        field {
            name = "cscodc2";
            desc = "DC parameter of output component 2. The MSB is the signed bit. The value is expressed as the complement.";
            sw = rw;
            hw = r;
            reset = 0x0;
        } cscodc2[26:18];

        field {
            name = "cscodc1";
            desc = "DC parameter of output component 1. The MSB is the signed bit. The value is expressed as the complement.";
            sw = rw;
            hw = r;
            reset = 0x0;
        } cscodc1[17:9];

        field {
            name = "cscodc0";
            desc = "DC parameter of output component 0. The MSB is the signed bit. The value is expressed as the complement.";
            sw = rw;
            hw = r;
            reset = 0x0;
        } cscodc0[8:0];
    } VSDCSCODC @ 0x84;

    reg {
        name = "VSD CSC parameter 0 register (instant register)";
        desc = "VSDiCSCP0 is VSD CSC parameter 0 register (instant register).

Data sheet 11.2.4 VSDiCSCP0 (offset 0x3088, printed page 11-111, `datasheet.txt` line 38910).";

        field {
            name = "cscp01";
            desc = "5.8 data format that consists of a 1-bit signed bit, a 4-bit integral part, and an 8-bit fractional part. The value is expressed as the complement.";
            sw = rw;
            hw = r;
            reset = 0x0;
        } cscp01[28:16];

        field {
            name = "cscp00";
            desc = "5.8 data format that consists of a 1-bit signed bit, a 4-bit integral part, and an 8-bit fractional part. The value is expressed as the complement.";
            sw = rw;
            hw = r;
            reset = 0x0;
        } cscp00[12:0];
    } VSDCSCP0 @ 0x88;

    reg {
        name = "VSD CSC parameter 1 register (instant register)";
        desc = "VSDiCSCP1 is VSD CSC parameter 1 register (instant register).

Data sheet 11.2.4 VSDiCSCP1 (offset 0x308C, printed page 11-112, `datasheet.txt` line 38956).";

        field {
            name = "cscp10";
            desc = "5.8 data format that consists of a 1-bit signed bit, a 4-bit integral part, and an 8-bit fractional part. The value is expressed as the complement.";
            sw = rw;
            hw = r;
            reset = 0x0;
        } cscp10[28:16];

        field {
            name = "cscp02";
            desc = "5.8 data format that consists of a 1-bit signed bit, a 4-bit integral part, and an 8-bit fractional part. The value is expressed as the complement.";
            sw = rw;
            hw = r;
            reset = 0x0;
        } cscp02[12:0];
    } VSDCSCP1 @ 0x8C;

    reg {
        name = "VSD CSC parameter 2 register (instant register)";
        desc = "VSDiCSCP2 is VSD CSC parameter 2 register (instant register).

Data sheet 11.2.4 VSDiCSCP2 (offset 0x3090, printed page 11-113, `datasheet.txt` line 39001).";

        field {
            name = "cscp12";
            desc = "5.8 data format that consists of a 1-bit signed bit, a 4-bit integral part, and an 8-bit fractional part. The value is expressed as the complement.";
            sw = rw;
            hw = r;
            reset = 0x0;
        } cscp12[28:16];

        field {
            name = "cscp11";
            desc = "5.8 data format that consists of a 1-bit signed bit, a 4-bit integral part, and an 8-bit fractional part. The value is expressed as the complement.";
            sw = rw;
            hw = r;
            reset = 0x0;
        } cscp11[12:0];
    } VSDCSCP2 @ 0x90;

    reg {
        name = "VSD CSC parameter 3 register (instant register)";
        desc = "VSDiCSCP3 is VSD CSC parameter 3 register (instant register).

Data sheet 11.2.4 VSDiCSCP3 (offset 0x3094, printed page 11-113, `datasheet.txt` line 39036).";

        field {
            name = "cscp21";
            desc = "5.8 data format that consists of a 1-bit signed bit, a 4-bit integral part, and an 8-bit fractional part. The value is expressed as the complement.";
            sw = rw;
            hw = r;
            reset = 0x0;
        } cscp21[28:16];

        field {
            name = "cscp20";
            desc = "5.8 data format that consists of a 1-bit signed bit, a 4-bit integral part, and an 8-bit fractional part. The value is expressed as the complement.";
            sw = rw;
            hw = r;
            reset = 0x0;
        } cscp20[12:0];
    } VSDCSCP3 @ 0x94;

    reg {
        name = "VSD CSC parameter 4 register (instant register)";
        desc = "VSDiCSCP4 is VSD CSC parameter 4 register (instant register).

Data sheet 11.2.4 VSDiCSCP4 (offset 0x3098, printed page 11-114, `datasheet.txt` line 39082).";

        field {
            name = "cscp22";
            desc = "5.8 data format that consists of a 1-bit signed bit, a 4-bit integral part, and an 8-bit fractional part. The value is expressed as the complement.";
            sw = rw;
            hw = r;
            reset = 0x0;
        } cscp22[12:0];
    } VSDCSCP4 @ 0x98;

    reg {
        name = "VSD IFIR filtering coefficients 0-1 register";
        desc = "VSDiIFIRCOEF01 is a VSD IFIR filtering coefficients 0-1 register.

Data sheet 11.2.4 VSDiIFIRCOEF01 (offset 0x3180, printed page 11-114, `datasheet.txt` line 39107).";

        field {
            name = "coef1";
            desc = "IFIR filtering coefficient 1.";
            sw = rw;
            hw = r;
            reset = 0xD;
        } coef1[25:16];

        field {
            name = "coef0";
            desc = "IFIR filtering coefficient 0.";
            sw = rw;
            hw = r;
            reset = 0x0;
        } coef0[9:0];
    } VSDIFIRCOEF01 @ 0x180;

    reg {
        name = "VSD IFIR filtering coefficients 2-3 register";
        desc = "VSDiIFIRCOEF23 is a VSD IFIR filtering coefficients 2-3 register.

Data sheet 11.2.4 VSDiIFIRCOEF23 (offset 0x3184, printed page 11-115, `datasheet.txt` line 39139).";

        field {
            name = "coef3";
            desc = "IFIR filtering coefficient 3.";
            sw = rw;
            hw = r;
            reset = 0x132;
        } coef3[25:16];

        field {
            name = "coef2";
            desc = "IFIR filtering coefficients 21.";
            sw = rw;
            hw = r;
            reset = 0x3C1;
        } coef2[9:0];
    } VSDIFIRCOEF23 @ 0x184;

    reg {
        name = "VSD IFIR filtering coefficients 4-5 register";
        desc = "VSDiIFIRCOEF45 is a VSD IFIR filtering coefficients 4-5 register.

Data sheet 11.2.4 VSDiIFIRCOEF45 (offset 0x3188, printed page 11-115, `datasheet.txt` line 39164).";

        field {
            name = "coef5";
            desc = "IFIR filtering coefficient 5.";
            sw = rw;
            hw = r;
            reset = 0x3C;
        } coef5[25:16];

        field {
            name = "coef4";
            desc = "IFIR filtering coefficient 4.";
            sw = rw;
            hw = r;
            reset = 0x132;
        } coef4[9:0];
    } VSDIFIRCOEF45 @ 0x188;

    reg {
        name = "VSD IFIR filtering coefficients 6-7 register";
        desc = "VSDiIFIRCOEF67 is a VSD IFIR filtering coefficients 6-7 register.

Data sheet 11.2.4 VSDiIFIRCOEF67 (offset 0x318C, printed page 11-116, `datasheet.txt` line 39199).";

        field {
            name = "coef7";
            desc = "IFIR filtering coefficient 7.";
            sw = rw;
            hw = r;
            reset = 0x0;
        } coef7[25:16];

        field {
            name = "coef6";
            desc = "IFIR filtering coefficient 6.";
            sw = rw;
            hw = r;
            reset = 0xD;
        } coef6[9:0];
    } VSDIFIRCOEF67 @ 0x18C;

    reg {
        name = "VSD region 0 resolution register (non-instant register)";
        desc = "VSDiP0RESO is a VSD region 0 resolution register (non-instant register).

Data sheet 11.2.4 VSDiP0RESO (offset 0x3400, printed page 11-116, `datasheet.txt` line 39224).";

        field {
            name = "h";
            desc = "Height (in line). The frame height is referenced. The value is the actual height minus 1. Note: The actual height must be an even number.";
            sw = rw;
            hw = r;
            reset = 0x0;
        } h[23:12];

        field {
            name = "w";
            desc = "Width (in pixel). The value is the actual width minus 1. Note: The actual width must be an even number.";
            sw = rw;
            hw = r;
            reset = 0x0;
        } w_f[11:0];
    } VSDP0RESO @ 0x400;

    reg {
        name = "VSD region 0 address register";
        desc = "VSDiP0LADDR is a VSD region 0 address register.

Data sheet 11.2.4 VSDiP0LADDR (offset 0x3404, printed page 11-117, `datasheet.txt` line 39262).";

        field {
            name = "surface_addr";
            desc = "Start address of VSD region 0.";
            sw = rw;
            hw = r;
            reset = 0x0;
        } surface_addr[31:0];
    } VSDP0LADDR @ 0x404;

    reg {
        name = "VSD region 0 chrominance address register";
        desc = "VSDiP0CADDR is a VSD region 0 chrominance address register.

Data sheet 11.2.4 VSDiP0CADDR (offset 0x3408, printed page 11-117, `datasheet.txt` line 39284).";

        field {
            name = "surface_addr";
            desc = "Chrominance start address of VSD region 0.";
            sw = rw;
            hw = r;
            reset = 0x0;
        } surface_addr[31:0];
    } VSDP0CADDR @ 0x408;

    reg {
        name = "VSD region 0 stride register";
        desc = "VSDiP0STRIDE is a VSD region 0 stride register.

Data sheet 11.2.4 VSDiP0STRIDE (offset 0x340C, printed page 11-117, `datasheet.txt` line 39306).";

        field {
            name = "surface_cstride";
            desc = "Stride of the chrominance buffer of VSD region 0 (valid in semi- planar format), 128-bit alignment.";
            sw = rw;
            hw = r;
            reset = 0x0;
        } surface_cstride[31:16];

        field {
            name = "surface_stride";
            desc = "Stride of the buffer of VSD region 0 (valid in semi-planar format, luminance stride), 128-bit alignment.";
            sw = rw;
            hw = r;
            reset = 0x0;
        } surface_stride[15:0];
    } VSDP0STRIDE @ 0x40C;

    reg {
        name = "VSD region 0 video start position register";
        desc = "VSDiP0VFPOS is a VSD region 0 video start position register. The start position is in the unit of pixel.

Data sheet 11.2.4 VSDiP0VFPOS (offset 0x3410, printed page 11-118, `datasheet.txt` line 39345).";

        field {
            name = "video_yfpos";
            desc = "Start coordinates of the video column. The frame height is referenced and the unit is line.";
            sw = rw;
            hw = r;
            reset = 0x0;
        } video_yfpos[23:12];

        field {
            name = "video_xfpos";
            desc = "Start coordinates of the video row.";
            sw = rw;
            hw = r;
            reset = 0x0;
        } video_xfpos[11:0];
    } VSDP0VFPOS @ 0x410;

    reg {
        name = "VSD region 0 video end position register (non-instant register)";
        desc = "VSDiP0VLPOS is a VSD region 0 video end position register (non-instant register). The end position is in the unit of pixel.

Data sheet 11.2.4 VSDiP0VLPOS (offset 0x3414, printed page 11-118, `datasheet.txt` line 39372).";

        field {
            name = "video_ylpos";
            desc = "Start coordinates of the video column. The frame height is referenced and the unit is line.";
            sw = rw;
            hw = r;
            reset = 0x0;
        } video_ylpos[23:12];

        field {
            name = "video_xlpos";
            desc = "Start coordinates of the video row.";
            sw = rw;
            hw = r;
            reset = 0x0;
        } video_xlpos[11:0];
    } VSDP0VLPOS @ 0x414;

    reg {
        name = "VSD16REGIONEN";
        desc = "Data sheet 11.2.4 VSDi16REGIONEN (offset 0x3C04, printed page 11-119, `datasheet.txt` line 39405).";

        enum VSD16REGIONEN_p0_en_enum {
            DISABLED = 0 { name = "Disabled"; desc = "disabled"; };
            ENABLED = 1 { name = "Enabled"; desc = "enabled"; };
        };

        field {
            name = "p0_en";
            desc = "VSD region 0 enable.";
            sw = rw;
            hw = r;
            encode = VSD16REGIONEN_p0_en_enum;
            reset = 0x0;
        } p0_en[0:0];
    } VSD16REGIONEN @ 0xC04;

};

regfile eHISI_VDP {
    name = "HiSilicon video display processor";
    desc = "
    HiSilicon video display processor (VDP) at 0x205C0000, GIC interrupt ID 67. Reads video and graphics layers from DDR over AXI, overlays them (crossbar/mixer CBM) and drives the display channels: video layers VHD0 (HD, scaler ZME, 16 \"regions\" per layer: VHDPmxxx), VSD0/VSD1 (SD), graphics layers G0, G2, G3 (G0 with decompression DCMP registers), cursor layer HC0, write-back channel WBC2, display channels DHD0 (HD: HDMI/VGA), DSD0 and DSD1 (SD/CVBS with the DATE and DATE1 TV encoders), plus a PARA block that loads the ZME coefficient tables (VHD H/V luma/chroma coefficients at 0xD000.., WBC coefficients at 0xE000..). Registers and reset values are from Hi3520D/Hi3515A/Hi3515C data sheet issue 07, chapter 11.2 (`datasheet.txt` lines 35754-48186; the data sheet notes the Hi3520D VDP base 0x205C0000 and the register addressing at line 35930). The VDP is almost entirely \"non-instant\" registers: write the register, then pulse the layer or channel `*UPD` (update) bit; the register groups are updated on the vertical blanking of the display channel. Arrays: VHDPm* m = 0..15 stride 0x20 (`VHDP*` below), VSDi* i = 0..1 stride 0x1000 (`VSD*`). The vendor U-Boot VO code (`product/hiosd/vo/hi3520d/vou_reg.h`, \"Created file for 3520D\") has the same register set as C unions; offsets and names were not cross-checked field by field (that header is generated from the same RTL tables) but the layer/channel structure agrees. Not hardware verified.
    ";

    reg {
        name = "VHD control register";
        desc = "VHDCTRL is a VHD control register (non-instant register). It is used to configure the layer information

Data sheet 11.2.4 VHDCTRL (offset 0x0, printed page 11-84, `datasheet.txt` line 37272).";

        enum VHDCTRL_surface_en_enum {
            DISABLED = 0 { name = "Disabled"; desc = "disabled"; };
            ENABLED = 1 { name = "Enabled"; desc = "enabled"; };
        };

        field {
            name = "surface_en";
            desc = "Surface enable (non-instant field).";
            sw = rw;
            hw = r;
            encode = VHDCTRL_surface_en_enum;
            reset = 0x0;
        } surface_en[31:31];

        enum VHDCTRL_ifir_mode_enum {
            RESERVED = 0 { name = "Reserved"; desc = "reserved"; };
            CHROMINANCE_IFIR_COPY = 1 { name = "Chrominance Ifir Copy"; desc = "chrominance IFIR copy mode"; };
            BILINEAR_INTERPOLATION = 2 { name = "Bilinear Interpolation"; desc = "bilinear interpolation"; };
            V_6_TAP_FIR = 3 { name = "V 6 Tap Fir"; desc = "6-tap FIR"; };
        };

        field {
            name = "ifir_mode";
            desc = "Horizontal chrominance IFIR mode.";
            sw = rw;
            hw = r;
            encode = VHDCTRL_ifir_mode_enum;
            reset = 0x0;
        } ifir_mode[19:18];

        enum VHDCTRL_vup_mode_enum {
            UPDATE_FIELD = 0 { name = "Update Field"; desc = "update by field"; };
            UPDATE_FRAME = 1 { name = "Update Frame"; desc = "update by frame"; };
        };

        field {
            name = "vup_mode";
            desc = "Register update mode.";
            sw = rw;
            hw = r;
            encode = VHDCTRL_vup_mode_enum;
            reset = 0x0;
        } vup_mode[17:17];

        enum VHDCTRL_ifmt_enum {
            SPYCBCR420 = 3 { name = "Spycbcr420"; desc = "SPYCbCr420"; };
            SPYCBCR422_OTHER_VALUES = 4 { name = "Spycbcr422 Other Values"; desc = "SPYCbCr422 Other values: reserved"; };
        };

        field {
            name = "ifmt";
            desc = "Input data format.";
            sw = rw;
            hw = r;
            encode = VHDCTRL_ifmt_enum;
            reset = 0x0;
        } ifmt[3:0];
    } VHDCTRL @ 0x0;

    reg {
        name = "VHD channel update enable register";
        desc = "VHDUPD is a VHD channel update enable register.

Data sheet 11.2.4 VHDUPD (offset 0x4, printed page 11-85, `datasheet.txt` line 37325).";

        field {
            name = "regup";
            desc = "Surface register update. After the registers at this layer are configured, the registers are updated when the value 1 is written to this bit. After updates, this bit is cleared automatically by the hardware.";
            sw = rw;
            hw = r;
            reset = 0x0;
        } regup[0:0];
    } VHDUPD @ 0x4;

    reg {
        name = "VHD current frame address register";
        desc = "VHDCADDR is a VHD current frame address register. In package pixel format, the address is the address of the frame buffer; in semi-planar pixel format, the address is the address of the luminance frame buffer.

Data sheet 11.2.4 VHDCADDR (offset 0x10, printed page 11-85, `datasheet.txt` line 37353).";

        field {
            name = "surface_caddr";
            desc = "Address of the current frame.";
            sw = rw;
            hw = r;
            reset = 0x0;
        } surface_caddr[31:0];
    } VHDCADDR @ 0x10;

    reg {
        name = "VHD current frame chrominance address register";
        desc = "VHD current frame chrominance address register.

Data sheet 11.2.4 VHDCCADDR (offset 0x14, printed page 11-86, `datasheet.txt` line 37384).";

        field {
            name = "surface_ccaddr";
            desc = "Chrominance address of the current frame.";
            sw = rw;
            hw = r;
            reset = 0x0;
        } surface_ccaddr[31:0];
    } VHDCCADDR @ 0x14;

    reg {
        name = "VHD surface stride register";
        desc = "VHDSTRIDE is a VHD surface stride register.

Data sheet 11.2.4 VHDSTRIDE (offset 0x24, printed page 11-86, `datasheet.txt` line 37403).";

        field {
            name = "surface_cstride";
            desc = "Stride of the chrominance frame buffer (valid in semi-planar format), 128-bit alignment.";
            sw = rw;
            hw = r;
            reset = 0x0;
        } surface_cstride[31:16];

        field {
            name = "surface_stride";
            desc = "Stride of the frame buffer (valid in semi-planar format, luminance stride), 128-bit alignment.";
            sw = rw;
            hw = r;
            reset = 0x0;
        } surface_stride[15:0];
    } VHDSTRIDE @ 0x24;

    reg {
        name = "VHD input resolution register";
        desc = "VHDIRESO is a VHD input resolution register (non-instant register).

Data sheet 11.2.4 VHDIRESO (offset 0x28, printed page 11-86, `datasheet.txt` line 37427).";

        field {
            name = "ih";
            desc = "Height (in line). The value is the actual height minus 1. The frame height is referenced.";
            sw = rw;
            hw = r;
            reset = 0x0;
        } ih[23:12];

        field {
            name = "iw";
            desc = "Width (in pixel). The value is the actual width minus 1.";
            sw = rw;
            hw = r;
            reset = 0x0;
        } iw[11:0];
    } VHDIRESO @ 0x28;

    reg {
        name = "VHD overlay parameter register";
        desc = "VHDCBMPARA is a VHD overlay parameter register (non-instant register).

Data sheet 11.2.4 VHDCBMPARA (offset 0x34, printed page 11-87, `datasheet.txt` line 37460).";

        field {
            name = "galpha";
            desc = "Overlay global alpha value. The value ranges from 0 to 128. The value 128 indicates opaque, and the value 0 indicates full transparent.";
            sw = rw;
            hw = r;
            reset = 0x0;
        } galpha[7:0];
    } VHDCBMPARA @ 0x34;

    reg {
        name = "VHD surface start position (in the display window) register";
        desc = "VHDDFPOS is a VHD surface start position (in the display window) register (non-instant register). The start position is in the unit of pixel.

Data sheet 11.2.4 VHDDFPOS (offset 0x60, printed page 11-87, `datasheet.txt` line 37483).";

        field {
            name = "disp_yfpos";
            desc = "Start coordinates of the display column. The frame height is referenced and the unit is line.";
            sw = rw;
            hw = r;
            reset = 0x0;
        } disp_yfpos[23:12];

        field {
            name = "disp_xfpos";
            desc = "Start coordinates of the display row.";
            sw = rw;
            hw = r;
            reset = 0x0;
        } disp_xfpos[11:0];
    } VHDDFPOS @ 0x60;

    reg {
        name = "VHD surface end position (in the display window) register";
        desc = "VHDDLPOS is VHD surface end position (in the display window) register (non-instant register). The end position is in the unit of pixel.

Data sheet 11.2.4 VHDDLPOS (offset 0x64, printed page 11-88, `datasheet.txt` line 37516).";

        field {
            name = "disp_ylpos";
            desc = "End coordinates of the display column. The frame height is referenced and the unit is line.";
            sw = rw;
            hw = r;
            reset = 0x0;
        } disp_ylpos[23:12];

        field {
            name = "disp_xlpos";
            desc = "End coordinates of the display row.";
            sw = rw;
            hw = r;
            reset = 0x0;
        } disp_xlpos[11:0];
    } VHDDLPOS @ 0x64;

    reg {
        name = "Video layer background color register";
        desc = "VHDBK is a video layer background color register.

Data sheet 11.2.4 VHDBK (offset 0x70, printed page 11-88, `datasheet.txt` line 37539).";

        field {
            name = "vbk_alpha";
            desc = "Levels 0-128 of the background filling color of the video layer.";
            sw = rw;
            hw = r;
            reset = 0x0;
        } vbk_alpha[31:24];

        field {
            name = "vbk_y";
            desc = "Y component.";
            sw = rw;
            hw = r;
            reset = 0x0;
        } vbk_y[23:16];

        field {
            name = "vbk_cb";
            desc = "Cb component.";
            sw = rw;
            hw = r;
            reset = 0x0;
        } vbk_cb[15:8];

        field {
            name = "vbk_cr";
            desc = "Cr component.";
            sw = rw;
            hw = r;
            reset = 0x0;
        } vbk_cr[7:0];
    } VHDBK @ 0x70;

    reg {
        name = "VHD input DC component register for CSC";
        desc = "VHDCSCIDC is a VHD input DC component register for CSC (instant register).

Data sheet 11.2.4 VHDCSCIDC (offset 0x80, printed page 11-89, `datasheet.txt` line 37570).";

        enum VHDCSCIDC_csc_en_enum {
            DISABLED = 0 { name = "Disabled"; desc = "disabled"; };
            ENABLED = 1 { name = "Enabled"; desc = "enabled"; };
        };

        field {
            name = "csc_en";
            desc = "CSC enable.";
            sw = rw;
            hw = r;
            encode = VHDCSCIDC_csc_en_enum;
            reset = 0x0;
        } csc_en[27:27];

        field {
            name = "cscidc2";
            desc = "DC parameter of input component 2. The MSB is the signed bit. The value is expressed as the complement.";
            sw = rw;
            hw = r;
            reset = 0x0;
        } cscidc2[26:18];

        field {
            name = "cscidc1";
            desc = "DC parameter of input component 1. The MSB is the signed bit. The value is expressed as the complement.";
            sw = rw;
            hw = r;
            reset = 0x0;
        } cscidc1[17:9];

        field {
            name = "cscidc0";
            desc = "DC parameter of input component 0. The MSB is the signed bit. The value is expressed as the complement.";
            sw = rw;
            hw = r;
            reset = 0x0;
        } cscidc0[8:0];
    } VHDCSCIDC @ 0x80;

    reg {
        name = "VHD output DC component register for CSC";
        desc = "VHDCSCODC is a VHD output DC component register for CSC (instant register).

Data sheet 11.2.4 VHDCSCODC (offset 0x84, printed page 11-89, `datasheet.txt` line 37603).";

        field {
            name = "cscodc2";
            desc = "DC parameter of output component 2. The MSB is the signed bit. The value is expressed as the complement.";
            sw = rw;
            hw = r;
            reset = 0x0;
        } cscodc2[26:18];

        field {
            name = "cscodc1";
            desc = "DC parameter of output component 1. The MSB is the signed bit. The value is expressed as the complement.";
            sw = rw;
            hw = r;
            reset = 0x0;
        } cscodc1[17:9];

        field {
            name = "cscodc0";
            desc = "DC parameter of output component 0. The MSB is the signed bit. The value is expressed as the complement.";
            sw = rw;
            hw = r;
            reset = 0x0;
        } cscodc0[8:0];
    } VHDCSCODC @ 0x84;

    reg {
        name = "VHD CSC parameter 0 register";
        desc = "VHDCSCP0 is VHD CSC parameter 0 register (instant register).

Data sheet 11.2.4 VHDCSCP0 (offset 0x88, printed page 11-90, `datasheet.txt` line 37638).";

        field {
            name = "cscp01";
            desc = "5.8 data format that consists of a 1-bit signed bit, a 4-bit integral part, and an 8-bit fractional part. The value is expressed as the complement.";
            sw = rw;
            hw = r;
            reset = 0x0;
        } cscp01[28:16];

        field {
            name = "cscp00";
            desc = "5.8 data format that consists of a 1-bit signed bit, a 4-bit integral part, and an 8-bit fractional part. The value is expressed as the complement.";
            sw = rw;
            hw = r;
            reset = 0x0;
        } cscp00[12:0];
    } VHDCSCP0 @ 0x88;

    reg {
        name = "VHD CSC parameter 1 register";
        desc = "VHDCSCP1 is VHD CSC parameter 1 register (instant register).

Data sheet 11.2.4 VHDCSCP1 (offset 0x8C, printed page 11-90, `datasheet.txt` line 37670).";

        field {
            name = "cscp10";
            desc = "5.8 data format that consists of a 1-bit signed bit, a 4-bit integral part, and an 8-bit fractional part. The value is expressed as the complement.";
            sw = rw;
            hw = r;
            reset = 0x0;
        } cscp10[28:16];

        field {
            name = "cscp02";
            desc = "5.8 data format that consists of a 1-bit signed bit, a 4-bit integral part, and an 8-bit fractional part. The value is expressed as the complement.";
            sw = rw;
            hw = r;
            reset = 0x0;
        } cscp02[12:0];
    } VHDCSCP1 @ 0x8C;

    reg {
        name = "VHD CSC parameter 2 register";
        desc = "VHDCSCP2 is VHD CSC parameter 2 register (instant register).

Data sheet 11.2.4 VHDCSCP2 (offset 0x90, printed page 11-91, `datasheet.txt` line 37712).";

        field {
            name = "cscp12";
            desc = "5.8 data format that consists of a 1-bit signed bit, a 4-bit integral part, and an 8-bit fractional part. The value is expressed as the complement.";
            sw = rw;
            hw = r;
            reset = 0x0;
        } cscp12[28:16];

        field {
            name = "cscp11";
            desc = "5.8 data format that consists of a 1-bit signed bit, a 4-bit integral part, and an 8-bit fractional part. The value is expressed as the complement.";
            sw = rw;
            hw = r;
            reset = 0x0;
        } cscp11[12:0];
    } VHDCSCP2 @ 0x90;

    reg {
        name = "VHD CSC parameter 3 register";
        desc = "VHDCSCP3 is VHD CSC parameter 3 register (instant register).

Data sheet 11.2.4 VHDCSCP3 (offset 0x94, printed page 11-92, `datasheet.txt` line 37754).";

        field {
            name = "cscp21";
            desc = "5.8 data format that consists of a 1-bit signed bit, a 4-bit integral part, and an 8-bit fractional part. The value is expressed as the complement.";
            sw = rw;
            hw = r;
            reset = 0x0;
        } cscp21[28:16];

        field {
            name = "cscp20";
            desc = "5.8 data format that consists of a 1-bit signed bit, a 4-bit integral part, and an 8-bit fractional part. The value is expressed as the complement.";
            sw = rw;
            hw = r;
            reset = 0x0;
        } cscp20[12:0];
    } VHDCSCP3 @ 0x94;

    reg {
        name = "VHD CSC parameter 4 register";
        desc = "VHDCSCP4 is VHD CSC parameter 4 register (instant register).

Data sheet 11.2.4 VHDCSCP4 (offset 0x98, printed page 11-92, `datasheet.txt` line 37786).";

        field {
            name = "cscp22";
            desc = "5.8 data format that consists of a 1-bit signed bit, a 4-bit integral part, and an 8-bit fractional part. The value is expressed as the complement.";
            sw = rw;
            hw = r;
            reset = 0x0;
        } cscp22[12:0];
    } VHDCSCP4 @ 0x98;

    reg {
        name = "VHD horizontal scaling parameter register";
        desc = "VHDHSP is a VHD horizontal scaling parameter register. The scaling ratio is calculated as follows: Scaling ratio = Input width/Output width

Data sheet 11.2.4 VHDHSP (offset 0xC0, printed page 11-93, `datasheet.txt` line 37818).";

        enum VHDHSP_hlmsc_en_enum {
            DISABLED = 0 { name = "Disabled"; desc = "disabled"; };
            ENABLED = 1 { name = "Enabled"; desc = "enabled"; };
        };

        field {
            name = "hlmsc_en";
            desc = "Horizontal luminance scaling enable.";
            sw = rw;
            hw = r;
            encode = VHDHSP_hlmsc_en_enum;
            reset = 0x0;
        } hlmsc_en[31:31];

        enum VHDHSP_hchmsc_en_enum {
            DISABLED = 0 { name = "Disabled"; desc = "disabled"; };
            ENABLED = 1 { name = "Enabled"; desc = "enabled"; };
        };

        field {
            name = "hchmsc_en";
            desc = "Horizontal chrominance scaling enable.";
            sw = rw;
            hw = r;
            encode = VHDHSP_hchmsc_en_enum;
            reset = 0x0;
        } hchmsc_en[30:30];

        enum VHDHSP_hlmid_en_enum {
            DISABLED = 0 { name = "Disabled"; desc = "disabled"; };
            ENABLED = 1 { name = "Enabled"; desc = "enabled"; };
        };

        field {
            name = "hlmid_en";
            desc = "Median filtering enable for horizontal luminance scaling. This bit is invalid when hlfir_en is invalid.";
            sw = rw;
            hw = r;
            encode = VHDHSP_hlmid_en_enum;
            reset = 0x0;
        } hlmid_en[29:29];

        enum VHDHSP_hchmid_en_enum {
            DISABLED = 0 { name = "Disabled"; desc = "disabled"; };
            ENABLED = 1 { name = "Enabled"; desc = "enabled"; };
        };

        field {
            name = "hchmid_en";
            desc = "Median filtering enable for horizontal chrominance scaling. This bit is invalid when hchfir_en is invalid.";
            sw = rw;
            hw = r;
            encode = VHDHSP_hchmid_en_enum;
            reset = 0x0;
        } hchmid_en[28:28];

        enum VHDHSP_hlfir_en_enum {
            REPLICATION_MODE = 0 { name = "Replication Mode"; desc = "replication mode (filtering disabled)"; };
            FILTERING_MODE = 1 { name = "Filtering Mode"; desc = "filtering mode (filtering enabled)"; };
        };

        field {
            name = "hlfir_en";
            desc = "Horizontal luminance scaling mode.";
            sw = rw;
            hw = r;
            encode = VHDHSP_hlfir_en_enum;
            reset = 0x0;
        } hlfir_en[26:26];

        enum VHDHSP_hchfir_en_enum {
            REPLICATION_MODE = 0 { name = "Replication Mode"; desc = "replication mode (filtering disabled)"; };
            FILTERING_MODE = 1 { name = "Filtering Mode"; desc = "filtering mode (filtering enabled)"; };
        };

        field {
            name = "hchfir_en";
            desc = "Horizontal chrominance scaling mode.";
            sw = rw;
            hw = r;
            encode = VHDHSP_hchfir_en_enum;
            reset = 0x0;
        } hchfir_en[25:25];

        field {
            name = "hratio";
            desc = "Horizontal scaling ratio, in (u, 4, 20) format.";
            sw = rw;
            hw = r;
            reset = 0x0;
        } hratio[23:0];
    } VHDHSP @ 0xC0;

    reg {
        name = "VHD horizontal luminance offset register";
        desc = "VHDHLOFFSET is a VHD horizontal luminance offset register.

Data sheet 11.2.4 VHDHLOFFSET (offset 0xC4, printed page 11-94, `datasheet.txt` line 37878).";

        field {
            name = "hor_loffset";
            desc = "Horizontal luminance offset, in (s, 8, 20) format. The value is expressed as the complement.";
            sw = rw;
            hw = r;
            reset = 0x0;
        } hor_loffset[27:0];
    } VHDHLOFFSET @ 0xC4;

    reg {
        name = "VHD horizontal chrominance offset register";
        desc = "VHDHCOFFSET is a VHD horizontal chrominance offset register.

Data sheet 11.2.4 VHDHCOFFSET (offset 0xC8, printed page 11-94, `datasheet.txt` line 37900).";

        field {
            name = "hor_coffset";
            desc = "Horizontal chrominance offset, in (s, 8, 20) format. The value is expressed as the complement.";
            sw = rw;
            hw = r;
            reset = 0x0;
        } hor_coffset[27:0];
    } VHDHCOFFSET @ 0xC8;

    reg {
        name = "VHD vertical scaling parameter register";
        desc = "VHDVSP is a VHD vertical scaling parameter register.

Data sheet 11.2.4 VHDVSP (offset 0xCC, printed page 11-95, `datasheet.txt` line 37932).";

        enum VHDVSP_vlmsc_en_enum {
            DISABLED = 0 { name = "Disabled"; desc = "disabled"; };
            ENABLED = 1 { name = "Enabled"; desc = "enabled"; };
        };

        field {
            name = "vlmsc_en";
            desc = "Vertical luminance scaling enable.";
            sw = rw;
            hw = r;
            encode = VHDVSP_vlmsc_en_enum;
            reset = 0x0;
        } vlmsc_en[31:31];

        enum VHDVSP_vchmsc_en_enum {
            DISABLED = 0 { name = "Disabled"; desc = "disabled"; };
            ENABLED = 1 { name = "Enabled"; desc = "enabled"; };
        };

        field {
            name = "vchmsc_en";
            desc = "Vertical chrominance scaling enable.";
            sw = rw;
            hw = r;
            encode = VHDVSP_vchmsc_en_enum;
            reset = 0x0;
        } vchmsc_en[30:30];

        enum VHDVSP_vlmid_en_enum {
            DISABLED = 0 { name = "Disabled"; desc = "disabled"; };
            ENABLED = 1 { name = "Enabled"; desc = "enabled"; };
        };

        field {
            name = "vlmid_en";
            desc = "Median filtering enable for vertical luminance scaling. This bit is invalid when vlfir_en is invalid.";
            sw = rw;
            hw = r;
            encode = VHDVSP_vlmid_en_enum;
            reset = 0x0;
        } vlmid_en[29:29];

        enum VHDVSP_vchmid_en_enum {
            DISABLED = 0 { name = "Disabled"; desc = "disabled"; };
            ENABLED = 1 { name = "Enabled"; desc = "enabled"; };
        };

        field {
            name = "vchmid_en";
            desc = "Median filtering enable for vertical chrominance scaling. This bit is invalid when vchfir_en is invalid.";
            sw = rw;
            hw = r;
            encode = VHDVSP_vchmid_en_enum;
            reset = 0x0;
        } vchmid_en[28:28];

        enum VHDVSP_vsc_chroma_tap_enum {
            V_4_TAP_FIR = 0 { name = "V 4 Tap Fir"; desc = "4-tap FIR"; };
            V_2_TAP_FIR = 1 { name = "V 2 Tap Fir"; desc = "2-tap FIR"; };
        };

        field {
            name = "vsc_chroma_tap";
            desc = "Vertical chrominance scaling tap.";
            sw = rw;
            hw = r;
            encode = VHDVSP_vsc_chroma_tap_enum;
            reset = 0x0;
        } vsc_chroma_tap[26:26];

        enum VHDVSP_vlfir_en_enum {
            REPLICATION_MODE = 0 { name = "Replication Mode"; desc = "replication mode (filtering disabled)"; };
            FILTERING_MODE = 1 { name = "Filtering Mode"; desc = "filtering mode (filtering enabled)"; };
        };

        field {
            name = "vlfir_en";
            desc = "Vertical luminance scaling mode.";
            sw = rw;
            hw = r;
            encode = VHDVSP_vlfir_en_enum;
            reset = 0x0;
        } vlfir_en[24:24];

        enum VHDVSP_vchfir_en_enum {
            REPLICATION_MODE = 0 { name = "Replication Mode"; desc = "replication mode (filtering disabled)"; };
            FILTERING_MODE = 1 { name = "Filtering Mode"; desc = "filtering mode (filtering enabled)"; };
        };

        field {
            name = "vchfir_en";
            desc = "Vertical chrominance scaling mode.";
            sw = rw;
            hw = r;
            encode = VHDVSP_vchfir_en_enum;
            reset = 0x0;
        } vchfir_en[23:23];

        field {
            name = "zme_out_fmt";
            desc = "Output data format for scaling. 0: 422 Other values: reserved";
            sw = rw;
            hw = r;
            reset = 0x0;
        } zme_out_fmt[22:21];

        enum VHDVSP_zme_in_fmt_enum {
            V_422 = 0 { name = "V 422"; desc = "422"; };
            V_420 = 1 { name = "V 420"; desc = "420"; };
        };

        field {
            name = "zme_in_fmt";
            desc = "Input data format for scaling.";
            sw = rw;
            hw = r;
            encode = VHDVSP_zme_in_fmt_enum;
            reset = 0x0;
        } zme_in_fmt[20:19];
    } VHDVSP @ 0xCC;

    reg {
        name = "VHD vertical scaling ratio register";
        desc = "VHDVSR is a VHD vertical scaling ratio register (non-instant register). The scaling ratio is calculated as follows: Scaling ratio = Input height/Output height

Data sheet 11.2.4 VHDVSR (offset 0xD0, printed page 11-96, `datasheet.txt` line 38006).";

        field {
            name = "vratio";
            desc = "Vertical scaling ratio, in (u, 4, 12) format.";
            sw = rw;
            hw = r;
            reset = 0x1000;
        } vratio[15:0];
    } VHDVSR @ 0xD0;

    reg {
        name = "VHD vertical scaling offset register";
        desc = "VHD vertical scaling offset register.

Data sheet 11.2.4 VHDVOFFSET (offset 0xD4, printed page 11-97, `datasheet.txt` line 38044).";

        field {
            name = "vluma_offset";
            desc = "Vertical luminance offset, in (s, 4, 12) format. The value is expressed as the complement.";
            sw = rw;
            hw = r;
            reset = 0x0;
        } vluma_offset[31:16];

        field {
            name = "vchroma_offset";
            desc = "Vertical chrominance offset, in (s, 4, 12) format. The value is expressed as the complement.";
            sw = rw;
            hw = r;
            reset = 0x0;
        } vchroma_offset[15:0];
    } VHDVOFFSET @ 0xD4;

    reg {
        name = "VHD zoom engine output resolution register";
        desc = "VHDZMEORESO is a VHD zoom engine output resolution register.

Data sheet 11.2.4 VHDZMEORESO (offset 0xD8, printed page 11-97, `datasheet.txt` line 38068).";

        field {
            name = "oh";
            desc = "Height (in line). The value is the actual height minus 1. In progressive mode, the frame height is referenced; in interlaced mode, the field height is referenced.";
            sw = rw;
            hw = r;
            reset = 0x0;
        } oh[23:12];

        field {
            name = "ow";
            desc = "Width (in pixel). The value is the actual width minus 1. Note: The actual layer width must be an even number.";
            sw = rw;
            hw = r;
            reset = 0x0;
        } ow[11:0];
    } VHDZMEORESO @ 0xD8;

    reg {
        name = "VHD zoom engine input resolution register";
        desc = "VHDZMEIRESO is a VHD zoom engine input resolution register.

Data sheet 11.2.4 VHDZMEIRESO (offset 0xDC, printed page 11-98, `datasheet.txt` line 38103).";

        field {
            name = "ih";
            desc = "Height (in line). The value is the actual height minus 1. In progressive mode, the frame height is referenced; in interlaced mode, the field height is referenced.";
            sw = rw;
            hw = r;
            reset = 0x0;
        } ih[23:12];

        field {
            name = "iw";
            desc = "Width (in pixel). The value is the actual width minus 1. Note: The actual layer width must be an even number.";
            sw = rw;
            hw = r;
            reset = 0x0;
        } iw[11:0];
    } VHDZMEIRESO @ 0xDC;

    reg {
        name = "VHD IFIR filtering coefficients 0-1 register";
        desc = "VHDIFIRCOEF01 is a VHD IFIR filtering coefficients 0-1 register.

Data sheet 11.2.4 VHDIFIRCOEF01 (offset 0x180, printed page 11-98, `datasheet.txt` line 38128).";

        field {
            name = "coef1";
            desc = "IFIR filtering coefficient 1.";
            sw = rw;
            hw = r;
            reset = 0xD;
        } coef1[25:16];

        field {
            name = "coef0";
            desc = "IFIR filtering coefficient 0.";
            sw = rw;
            hw = r;
            reset = 0x0;
        } coef0[9:0];
    } VHDIFIRCOEF01 @ 0x180;

    reg {
        name = "VHD IFIR filtering coefficients 2-3 register";
        desc = "VHDIFIRCOEF23 is a VHD IFIR filtering coefficients 2-3 register.

Data sheet 11.2.4 VHDIFIRCOEF23 (offset 0x184, printed page 11-99, `datasheet.txt` line 38160).";

        field {
            name = "coef3";
            desc = "IFIR filtering coefficient 3.";
            sw = rw;
            hw = r;
            reset = 0x132;
        } coef3[25:16];

        field {
            name = "coef2";
            desc = "IFIR filtering coefficient 2.";
            sw = rw;
            hw = r;
            reset = 0x3C1;
        } coef2[9:0];
    } VHDIFIRCOEF23 @ 0x184;

    reg {
        name = "VHD IFIR filtering coefficients 4-5 register";
        desc = "VHDIFIRCOEF45 is a VHD IFIR filtering coefficients 4-5 register.

Data sheet 11.2.4 VHDIFIRCOEF45 (offset 0x188, printed page 11-99, `datasheet.txt` line 38182).";

        field {
            name = "coef5";
            desc = "IFIR filtering coefficient 5.";
            sw = rw;
            hw = r;
            reset = 0x3C1;
        } coef5[25:16];

        field {
            name = "coef4";
            desc = "IFIR filtering coefficient 4.";
            sw = rw;
            hw = r;
            reset = 0x132;
        } coef4[9:0];
    } VHDIFIRCOEF45 @ 0x188;

    reg {
        name = "VHD IFIR filtering coefficients 6-7 register";
        desc = "VHDIFIRCOEF67 is a VHD IFIR filtering coefficients 6-7 register.

Data sheet 11.2.4 VHDIFIRCOEF67 (offset 0x18C, printed page 11-100, `datasheet.txt` line 38214).";

        field {
            name = "coef7";
            desc = "IFIR filtering coefficient 7.";
            sw = rw;
            hw = r;
            reset = 0x0;
        } coef7[25:16];

        field {
            name = "coef6";
            desc = "IFIR filtering coefficient 6.";
            sw = rw;
            hw = r;
            reset = 0xD;
        } coef6[9:0];
    } VHDIFIRCOEF67 @ 0x18C;

    reg {
        name = "VHD regions 0-15 enable register";
        desc = "VHD64REGIONENL is the VHD regions 0-15 enable register (non-instant register).

Data sheet 11.2.4 VHD64REGIONENL (offset 0xC04, printed page 11-103, `datasheet.txt` line 38414).";

        enum VHD64REGIONENL_p15_en_enum {
            DISABLED = 0 { name = "Disabled"; desc = "disabled"; };
            ENABLED = 1 { name = "Enabled"; desc = "enabled"; };
        };

        field {
            name = "p15_en";
            desc = "VHD region 15 enable.";
            sw = rw;
            hw = r;
            encode = VHD64REGIONENL_p15_en_enum;
            reset = 0x0;
        } p15_en[15:15];

        enum VHD64REGIONENL_p14_en_enum {
            DISABLED = 0 { name = "Disabled"; desc = "disabled"; };
            ENABLED = 1 { name = "Enabled"; desc = "enabled"; };
        };

        field {
            name = "p14_en";
            desc = "VHD region 14 enable.";
            sw = rw;
            hw = r;
            encode = VHD64REGIONENL_p14_en_enum;
            reset = 0x0;
        } p14_en[14:14];

        enum VHD64REGIONENL_p13_en_enum {
            DISABLED = 0 { name = "Disabled"; desc = "disabled"; };
            ENABLED = 1 { name = "Enabled"; desc = "enabled"; };
        };

        field {
            name = "p13_en";
            desc = "VHD region 13 enable.";
            sw = rw;
            hw = r;
            encode = VHD64REGIONENL_p13_en_enum;
            reset = 0x0;
        } p13_en[13:13];

        enum VHD64REGIONENL_p12_en_enum {
            DISABLED = 0 { name = "Disabled"; desc = "disabled"; };
            ENABLED = 1 { name = "Enabled"; desc = "enabled"; };
        };

        field {
            name = "p12_en";
            desc = "VHD region 12 enable.";
            sw = rw;
            hw = r;
            encode = VHD64REGIONENL_p12_en_enum;
            reset = 0x0;
        } p12_en[12:12];

        enum VHD64REGIONENL_p11_en_enum {
            DISABLED = 0 { name = "Disabled"; desc = "disabled"; };
            ENABLED = 1 { name = "Enabled"; desc = "enabled"; };
        };

        field {
            name = "p11_en";
            desc = "VHD region 11 enable.";
            sw = rw;
            hw = r;
            encode = VHD64REGIONENL_p11_en_enum;
            reset = 0x0;
        } p11_en[11:11];

        enum VHD64REGIONENL_p10_en_enum {
            DISABLED = 0 { name = "Disabled"; desc = "disabled"; };
            ENABLED = 1 { name = "Enabled"; desc = "enabled"; };
        };

        field {
            name = "p10_en";
            desc = "VHD region 10 enable.";
            sw = rw;
            hw = r;
            encode = VHD64REGIONENL_p10_en_enum;
            reset = 0x0;
        } p10_en[10:10];

        enum VHD64REGIONENL_p9_en_enum {
            DISABLED = 0 { name = "Disabled"; desc = "disabled"; };
            ENABLED = 1 { name = "Enabled"; desc = "enabled"; };
        };

        field {
            name = "p9_en";
            desc = "VHD region 9 enable.";
            sw = rw;
            hw = r;
            encode = VHD64REGIONENL_p9_en_enum;
            reset = 0x0;
        } p9_en[9:9];

        enum VHD64REGIONENL_p8_en_enum {
            DISABLED = 0 { name = "Disabled"; desc = "disabled"; };
            ENABLED = 1 { name = "Enabled"; desc = "enabled"; };
        };

        field {
            name = "p8_en";
            desc = "VHD region 8 enable.";
            sw = rw;
            hw = r;
            encode = VHD64REGIONENL_p8_en_enum;
            reset = 0x0;
        } p8_en[8:8];

        enum VHD64REGIONENL_p7_en_enum {
            DISABLED = 0 { name = "Disabled"; desc = "disabled"; };
            ENABLED = 1 { name = "Enabled"; desc = "enabled"; };
        };

        field {
            name = "p7_en";
            desc = "VHD region 7 enable.";
            sw = rw;
            hw = r;
            encode = VHD64REGIONENL_p7_en_enum;
            reset = 0x0;
        } p7_en[7:7];

        enum VHD64REGIONENL_p6_en_enum {
            DISABLED = 0 { name = "Disabled"; desc = "disabled"; };
            ENABLED = 1 { name = "Enabled"; desc = "enabled"; };
        };

        field {
            name = "p6_en";
            desc = "VHD region 6 enable.";
            sw = rw;
            hw = r;
            encode = VHD64REGIONENL_p6_en_enum;
            reset = 0x0;
        } p6_en[6:6];

        enum VHD64REGIONENL_p5_en_enum {
            DISABLED = 0 { name = "Disabled"; desc = "disabled"; };
            ENABLED = 1 { name = "Enabled"; desc = "enabled"; };
        };

        field {
            name = "p5_en";
            desc = "VHD region 5 enable.";
            sw = rw;
            hw = r;
            encode = VHD64REGIONENL_p5_en_enum;
            reset = 0x0;
        } p5_en[5:5];

        enum VHD64REGIONENL_p4_en_enum {
            DISABLED = 0 { name = "Disabled"; desc = "disabled"; };
            ENABLED = 1 { name = "Enabled"; desc = "enabled"; };
        };

        field {
            name = "p4_en";
            desc = "VHD region 4 enable.";
            sw = rw;
            hw = r;
            encode = VHD64REGIONENL_p4_en_enum;
            reset = 0x0;
        } p4_en[4:4];

        enum VHD64REGIONENL_p3_en_enum {
            DISABLED = 0 { name = "Disabled"; desc = "disabled"; };
            ENABLED = 1 { name = "Enabled"; desc = "enabled"; };
        };

        field {
            name = "p3_en";
            desc = "VHD region 3 enable.";
            sw = rw;
            hw = r;
            encode = VHD64REGIONENL_p3_en_enum;
            reset = 0x0;
        } p3_en[3:3];

        enum VHD64REGIONENL_p2_en_enum {
            DISABLED = 0 { name = "Disabled"; desc = "disabled"; };
            ENABLED = 1 { name = "Enabled"; desc = "enabled"; };
        };

        field {
            name = "p2_en";
            desc = "VHD region 2 enable.";
            sw = rw;
            hw = r;
            encode = VHD64REGIONENL_p2_en_enum;
            reset = 0x0;
        } p2_en[2:2];

        enum VHD64REGIONENL_p1_en_enum {
            DISABLED = 0 { name = "Disabled"; desc = "disabled"; };
            ENABLED = 1 { name = "Enabled"; desc = "enabled"; };
        };

        field {
            name = "p1_en";
            desc = "VHD region 1 enable.";
            sw = rw;
            hw = r;
            encode = VHD64REGIONENL_p1_en_enum;
            reset = 0x0;
        } p1_en[1:1];

        enum VHD64REGIONENL_p0_en_enum {
            DISABLED = 0 { name = "Disabled"; desc = "disabled"; };
            ENABLED = 1 { name = "Enabled"; desc = "enabled"; };
        };

        field {
            name = "p0_en";
            desc = "VHD region 0 enable.";
            sw = rw;
            hw = r;
            encode = VHD64REGIONENL_p0_en_enum;
            reset = 0x0;
        } p0_en[0:0];
    } VHD64REGIONENL @ 0xC04;

    reg {
        name = "WBC2 control register";
        desc = "WBC2CTRL is a WBC2 control register (non-instant register).

Data sheet 11.2.4 WBC2CTRL (offset 0x8200, printed page 11-119, `datasheet.txt` line 39430).";

        enum WBC2CTRL_wbc2_en_enum {
            DISABLED = 0 { name = "Disabled"; desc = "disabled"; };
            ENABLED = 1 { name = "Enabled"; desc = "enabled"; };
        };

        field {
            name = "wbc2_en";
            desc = "WBC2 enable. The register is WBC2CTRL; this bit is called wbc2_en in the data sheet bit table.";
            sw = rw;
            hw = r;
            encode = WBC2CTRL_wbc2_en_enum;
            reset = 0x0;
        } wbc2_en[31:31];

        enum WBC2CTRL_wb_stp_en_enum {
            DISABLED = 0 { name = "Disabled"; desc = "disabled"; };
            ENABLED = 1 { name = "Enabled"; desc = "enabled"; };
        };

        field {
            name = "wb_stp_en";
            desc = "Writeback stop. When the interface timing passes through active regions, if WBC2 does not complete the writeback operation, the remaining data is not written back any more.";
            sw = rw;
            hw = r;
            encode = WBC2CTRL_wb_stp_en_enum;
            reset = 0x0;
        } wb_stp_en[28:28];

        field {
            name = "dfp_sel";
            desc = "Data extraction position select. 01: data extraction position 1 (from VHD.LBOX) 10: data extraction position 2 (from CBM.Mixer1) Other values: reserved";
            sw = rw;
            hw = r;
            reset = 0x0;
        } dfp_sel[26:24];

        enum WBC2CTRL_wbc0_dft_enum {
            SPYCBCR422 = 0 { name = "Spycbcr422"; desc = "SPYCbCr422"; };
            SPYCBCR420_OTHER_VALUES = 1 { name = "Spycbcr420 Other Values"; desc = "SPYCbCr420 Other values: reserved"; };
        };

        field {
            name = "wbc0_dft";
            desc = "Output data format of WBC0.";
            sw = rw;
            hw = r;
            encode = WBC2CTRL_wbc0_dft_enum;
            reset = 0x0;
        } wbc0_dft[13:12];
    } WBC2CTRL @ 0x8200;

    reg {
        name = "WBC2 channel update enable register";
        desc = "WBC2UPD is a WBC2 channel update enable register.

Data sheet 11.2.4 WBC2UPD (offset 0x8204, printed page 11-120, `datasheet.txt` line 39488).";

        field {
            name = "regup";
            desc = "Capture register update. After the registers at this layer are configured, the registers are updated when the value 1 is written to this bit. After updates, this bit is cleared automatically by the hardware.";
            sw = rw;
            hw = r;
            reset = 0x0;
        } regup[0:0];
    } WBC2UPD @ 0x8204;

    reg {
        name = "WBC2 capture address register";
        desc = "WBC2ADDR is a WBC2 capture address register.

Data sheet 11.2.4 WBC2ADDR (offset 0x8208, printed page 11-121, `datasheet.txt` line 39521).";

        field {
            name = "wbcaddr";
            desc = "Frame buffer address. It is 4-byte-aligned and the lower two bits are invalid (seamless combination is supported).";
            sw = rw;
            hw = r;
            reset = 0x0;
        } wbcaddr[31:0];
    } WBC2ADDR @ 0x8208;

    reg {
        name = "Capture stride register";
        desc = "WBC2STRIDE is a WBC2 capture stride register.

Data sheet 11.2.4 WBC2STRIDE (offset 0x820C, printed page 11-121, `datasheet.txt` line 39542).";

        field {
            name = "wbc0stride";
            desc = "Frame buffer stride, 128-bit alignment.";
            sw = rw;
            hw = r;
            reset = 0x0;
        } wbc0stride[15:0];
    } WBC2STRIDE @ 0x820C;

    reg {
        name = "Output resolution register";
        desc = "WBC2ORESO is a WBC2 output resolution register (non-instant register).

Data sheet 11.2.4 WBC2ORESO (offset 0x8210, printed page 11-121, `datasheet.txt` line 39562).";

        field {
            name = "oh";
            desc = "Height (in line). The value is the actual height minus 1. Note: In interlaced output mode, the actual layer height must be an even number. There is no such limitation in progressive output mode.";
            sw = rw;
            hw = r;
            reset = 0x0;
        } oh[23:12];

        field {
            name = "ow";
            desc = "Width (in pixel). The value is the actual width minus 1. Note: The actual layer width must be an even number.";
            sw = rw;
            hw = r;
            reset = 0x0;
        } ow[11:0];
    } WBC2ORESO @ 0x8210;

    reg {
        name = "WBC2 capture write chrominance address register";
        desc = "WBC2CADDR is a WBC2 write chrominance address register.

Data sheet 11.2.4 WBC2CADDR (offset 0x8220, printed page 11-122, `datasheet.txt` line 39598).";

        field {
            name = "wbccaddr";
            desc = "Address of the frame chrominance buffer. It is 4-byte-aligned and the lower two bits are invalid (seamless combination is supported).";
            sw = rw;
            hw = r;
            reset = 0x0;
        } wbccaddr[31:0];
    } WBC2CADDR @ 0x8220;

    reg {
        name = "WBC2 capture chrominance stride register";
        desc = "WBC2CSTRIDE is a WBC2 capture chrominance stride register.

Data sheet 11.2.4 WBC2CSTRIDE (offset 0x8224, printed page 11-122, `datasheet.txt` line 39619).";

        field {
            name = "wbc0cstride";
            desc = "Stride of the frame chrominance buffer, 16-byte alignment.";
            sw = rw;
            hw = r;
            reset = 0x0;
        } wbc0cstride[15:0];
    } WBC2CSTRIDE @ 0x8224;

    reg {
        name = "WBC2 horizontal scaling parameter register";
        desc = "WBC2HSP is a WBC2 horizontal scaling parameter register (non-instant register). The scaling ratio is calculated as follows: Scaling ratio = Input width/Output width

Data sheet 11.2.4 WBC2HSP (offset 0x82C0, printed page 11-123, `datasheet.txt` line 39650).";

        enum WBC2HSP_hlmsc_en_enum {
            DISABLED = 0 { name = "Disabled"; desc = "disabled"; };
            ENABLED = 1 { name = "Enabled"; desc = "enabled"; };
        };

        field {
            name = "hlmsc_en";
            desc = "Horizontal luminance scaling enable.";
            sw = rw;
            hw = r;
            encode = WBC2HSP_hlmsc_en_enum;
            reset = 0x0;
        } hlmsc_en[31:31];

        enum WBC2HSP_hchmsc_en_enum {
            DISABLED = 0 { name = "Disabled"; desc = "disabled"; };
            ENABLED = 1 { name = "Enabled"; desc = "enabled"; };
        };

        field {
            name = "hchmsc_en";
            desc = "Horizontal chrominance scaling enable.";
            sw = rw;
            hw = r;
            encode = WBC2HSP_hchmsc_en_enum;
            reset = 0x0;
        } hchmsc_en[30:30];

        enum WBC2HSP_hlmid_en_enum {
            DISABLED = 0 { name = "Disabled"; desc = "disabled"; };
            ENABLED = 1 { name = "Enabled"; desc = "enabled"; };
        };

        field {
            name = "hlmid_en";
            desc = "Median filtering enable for horizontal luminance scaling. This bit is invalid when hlfir_en is invalid.";
            sw = rw;
            hw = r;
            encode = WBC2HSP_hlmid_en_enum;
            reset = 0x0;
        } hlmid_en[29:29];

        enum WBC2HSP_hchmid_en_enum {
            DISABLED = 0 { name = "Disabled"; desc = "disabled"; };
            ENABLED = 1 { name = "Enabled"; desc = "enabled"; };
        };

        field {
            name = "hchmid_en";
            desc = "Median filtering enable for horizontal chrominance scaling. This bit is invalid when hchfir_en is invalid.";
            sw = rw;
            hw = r;
            encode = WBC2HSP_hchmid_en_enum;
            reset = 0x0;
        } hchmid_en[28:28];

        enum WBC2HSP_hlfir_en_enum {
            REPLICATION_MODE = 0 { name = "Replication Mode"; desc = "replication mode (filtering disabled)"; };
            FILTERING_MODE = 1 { name = "Filtering Mode"; desc = "filtering mode (filtering enabled)"; };
        };

        field {
            name = "hlfir_en";
            desc = "Horizontal luminance scaling mode.";
            sw = rw;
            hw = r;
            encode = WBC2HSP_hlfir_en_enum;
            reset = 0x0;
        } hlfir_en[26:26];

        enum WBC2HSP_hchfir_en_enum {
            REPLICATION_MODE = 0 { name = "Replication Mode"; desc = "replication mode (filtering disabled)"; };
            FILTERING_MODE = 1 { name = "Filtering Mode"; desc = "filtering mode (filtering enabled)"; };
        };

        field {
            name = "hchfir_en";
            desc = "Horizontal chrominance scaling mode.";
            sw = rw;
            hw = r;
            encode = WBC2HSP_hchfir_en_enum;
            reset = 0x0;
        } hchfir_en[25:25];

        field {
            name = "hratio";
            desc = "Horizontal scaling ratio, in (u, 4, 12) format.";
            sw = rw;
            hw = r;
            reset = 0x0;
        } hratio[23:0];
    } WBC2HSP @ 0x82C0;

    reg {
        name = "WBC2 horizontal luminance offset register";
        desc = "WBC2HLOFFSET is a WBC2 horizontal luminance offset register (non-instant register). It is used for pan-scan.

Data sheet 11.2.4 WBC2HLOFFSET (offset 0x82C4, printed page 11-124, `datasheet.txt` line 39708).";

        field {
            name = "hor_loffset";
            desc = "Horizontal luminance offset, in (s, 8, 20) format. The value is expressed as the complement.";
            sw = rw;
            hw = r;
            reset = 0x0;
        } hor_loffset[27:0];
    } WBC2HLOFFSET @ 0x82C4;

    reg {
        name = "WBC2 horizontal chrominance offset register";
        desc = "WBC2HCOFFSET is a WBC2 horizontal chrominance offset register (non-instant register). It is used for pan-scan.

Data sheet 11.2.4 WBC2HCOFFSET (offset 0x82C8, printed page 11-124, `datasheet.txt` line 39731).";

        field {
            name = "hor_coffset";
            desc = "Horizontal chrominance offset, in (s, 8, 20) format. The value is expressed as the complement.";
            sw = rw;
            hw = r;
            reset = 0x0;
        } hor_coffset[27:0];
    } WBC2HCOFFSET @ 0x82C8;

    reg {
        name = "WBC2 vertical scaling parameter register";
        desc = "WBC2VSP is a WBC2 vertical scaling parameter register.

Data sheet 11.2.4 WBC2VSP (offset 0x82CC, printed page 11-125, `datasheet.txt` line 39763).";

        enum WBC2VSP_vlmsc_en_enum {
            DISABLED = 0 { name = "Disabled"; desc = "disabled"; };
            ENABLED = 1 { name = "Enabled"; desc = "enabled"; };
        };

        field {
            name = "vlmsc_en";
            desc = "Vertical luminance scaling enable.";
            sw = rw;
            hw = r;
            encode = WBC2VSP_vlmsc_en_enum;
            reset = 0x0;
        } vlmsc_en[31:31];

        enum WBC2VSP_vchmsc_en_enum {
            DISABLED = 0 { name = "Disabled"; desc = "disabled"; };
            ENABLED = 1 { name = "Enabled"; desc = "enabled"; };
        };

        field {
            name = "vchmsc_en";
            desc = "Vertical chrominance scaling enable.";
            sw = rw;
            hw = r;
            encode = WBC2VSP_vchmsc_en_enum;
            reset = 0x0;
        } vchmsc_en[30:30];

        enum WBC2VSP_vlmid_en_enum {
            DISABLED = 0 { name = "Disabled"; desc = "disabled"; };
            ENABLED = 1 { name = "Enabled"; desc = "enabled"; };
        };

        field {
            name = "vlmid_en";
            desc = "Median filtering enable for vertical luminance scaling. This bit is invalid when vlfir_en is invalid.";
            sw = rw;
            hw = r;
            encode = WBC2VSP_vlmid_en_enum;
            reset = 0x0;
        } vlmid_en[29:29];

        enum WBC2VSP_vchmid_en_enum {
            DISABLED = 0 { name = "Disabled"; desc = "disabled"; };
            ENABLED = 1 { name = "Enabled"; desc = "enabled"; };
        };

        field {
            name = "vchmid_en";
            desc = "Median filtering enable for vertical chrominance scaling. This bit is invalid when vchfir_en is invalid.";
            sw = rw;
            hw = r;
            encode = WBC2VSP_vchmid_en_enum;
            reset = 0x0;
        } vchmid_en[28:28];

        enum WBC2VSP_vsc_chroma_tap_enum {
            V_4_TAP_FIR = 0 { name = "V 4 Tap Fir"; desc = "4-tap FIR"; };
            V_2_TAP_FIR = 1 { name = "V 2 Tap Fir"; desc = "2-tap FIR"; };
        };

        field {
            name = "vsc_chroma_tap";
            desc = "Vertical chrominance scaling tap.";
            sw = rw;
            hw = r;
            encode = WBC2VSP_vsc_chroma_tap_enum;
            reset = 0x0;
        } vsc_chroma_tap[26:26];

        enum WBC2VSP_vlfir_en_enum {
            REPLICATION_MODE = 0 { name = "Replication Mode"; desc = "replication mode (filtering disabled)"; };
            FILTERING_MODE = 1 { name = "Filtering Mode"; desc = "filtering mode (filtering enabled)"; };
        };

        field {
            name = "vlfir_en";
            desc = "Vertical luminance scaling mode.";
            sw = rw;
            hw = r;
            encode = WBC2VSP_vlfir_en_enum;
            reset = 0x0;
        } vlfir_en[24:24];

        enum WBC2VSP_vchfir_en_enum {
            REPLICATION_MODE = 0 { name = "Replication Mode"; desc = "replication mode (filtering disabled)"; };
            FILTERING_MODE = 1 { name = "Filtering Mode"; desc = "filtering mode (filtering enabled)"; };
        };

        field {
            name = "vchfir_en";
            desc = "Vertical chrominance scaling mode.";
            sw = rw;
            hw = r;
            encode = WBC2VSP_vchfir_en_enum;
            reset = 0x0;
        } vchfir_en[23:23];

        enum WBC2VSP_zme_out_fmt_enum {
            V_420 = 0 { name = "V 420"; desc = "420"; };
            V_422 = 1 { name = "V 422"; desc = "422"; };
        };

        field {
            name = "zme_out_fmt";
            desc = "Output data format for scaling.";
            sw = rw;
            hw = r;
            encode = WBC2VSP_zme_out_fmt_enum;
            reset = 0x0;
        } zme_out_fmt[22:21];

        field {
            name = "zme_in_fmt";
            desc = "Input data format for scaling. 0: 422 Other values: reserved";
            sw = rw;
            hw = r;
            reset = 0x0;
        } zme_in_fmt[20:19];
    } WBC2VSP @ 0x82CC;

    reg {
        name = "WBC2 vertical scaling ratio register";
        desc = "WBC2VSR is a WBC2 vertical scaling ratio register (non-instant register). The scaling ratio is calculated as follows: Scaling ratio = Input height/Output height

Data sheet 11.2.4 WBC2VSR (offset 0x82D0, printed page 11-126, `datasheet.txt` line 39837).";

        field {
            name = "vratio";
            desc = "Vertical scaling ratio, in (u, 4, 12) format.";
            sw = rw;
            hw = r;
            reset = 0x1000;
        } vratio[15:0];
    } WBC2VSR @ 0x82D0;

    reg {
        name = "WBC2 vertical luminance offset register";
        desc = "WBC2 vertical luminance offset register.

Data sheet 11.2.4 WBC2VOFFSET (offset 0x82D4, printed page 11-127, `datasheet.txt` line 39875).";

        field {
            name = "vluma_offset";
            desc = "Vertical luminance offset, in (s, 4, 12) format. The value is expressed as the complement.";
            sw = rw;
            hw = r;
            reset = 0x0;
        } vluma_offset[31:16];

        field {
            name = "vchroma_offset";
            desc = "Vertical chrominance offset, in (s, 4, 12) format. The value is expressed as the complement.";
            sw = rw;
            hw = r;
            reset = 0x0;
        } vchroma_offset[15:0];
    } WBC2VOFFSET @ 0x82D4;

    reg {
        name = "WBC2 zoom engine output resolution register";
        desc = "WBC2ZMEORESO is a WBC2 zoom engine output resolution register (non-instant register).

Data sheet 11.2.4 WBC2ZMEORESO (offset 0x82D8, printed page 11-127, `datasheet.txt` line 39899).";

        field {
            name = "oh";
            desc = "Height (in line). The value is the actual height minus 1. In progressive mode, the frame height is referenced; in interlaced mode, the field height is referenced.";
            sw = rw;
            hw = r;
            reset = 0x0;
        } oh[23:12];

        field {
            name = "ow";
            desc = "Width (in pixel). The value is the actual width minus 1. Note: The actual layer width must be an even number.";
            sw = rw;
            hw = r;
            reset = 0x0;
        } ow[11:0];
    } WBC2ZMEORESO @ 0x82D8;

    reg {
        name = "WBC2 zoom engine input resolution register";
        desc = "WBC2ZMEIRESO is a WBC2 zoom engine input resolution register (non-instant register).

Data sheet 11.2.4 WBC2ZMEIRESO (offset 0x82DC, printed page 11-128, `datasheet.txt` line 39934).";

        field {
            name = "ih";
            desc = "Height (in line). The value is the actual height minus 1. In progressive mode, the frame height is referenced; in interlaced mode, the field height is referenced.";
            sw = rw;
            hw = r;
            reset = 0x0;
        } ih[23:12];

        field {
            name = "iw";
            desc = "Width (in pixel). The value is the actual width minus 1. Note: The actual layer width must be an even number.";
            sw = rw;
            hw = r;
            reset = 0x0;
        } iw[11:0];
    } WBC2ZMEIRESO @ 0x82DC;

    reg {
        name = "G0 control register";
        desc = "G0CTRL is a G0 control register (non-instant register). It is used to configure the layer information

Data sheet 11.2.4 G0CTRL (offset 0x9000, printed page 11-128, `datasheet.txt` line 39960).";

        enum G0CTRL_surface_en_enum {
            DISABLED = 0 { name = "Disabled"; desc = "disabled"; };
            ENABLED = 1 { name = "Enabled"; desc = "enabled"; };
        };

        field {
            name = "surface_en";
            desc = "Surface enable (non-instant register).";
            sw = rw;
            hw = r;
            encode = G0CTRL_surface_en_enum;
            reset = 0x0;
        } surface_en[31:31];

        enum G0CTRL_upd_mode_enum {
            UPDATE_FRAME = 0 { name = "Update Frame"; desc = "update by frame"; };
            UPDATE_FIELD = 1 { name = "Update Field"; desc = "update by field"; };
        };

        field {
            name = "upd_mode";
            desc = "Update mode.";
            sw = rw;
            hw = r;
            encode = G0CTRL_upd_mode_enum;
            reset = 0x0;
        } upd_mode[27:27];

        enum G0CTRL_read_mode_enum {
            READ_MODE_AUTOMATICALLY = 0 { name = "Read Mode Automatically"; desc = "The read mode is automatically selected based on the interface read mode. That is, the progressive read mode is selected in progressive display mode, and the interlaced read mode is selected in interlaced display mode."; };
            PROGRESSIVE_READ_MODE = 1 { name = "Progressive Read Mode"; desc = "The progressive read mode is selected forcibly."; };
        };

        field {
            name = "read_mode";
            desc = "Data read mode.";
            sw = rw;
            hw = r;
            encode = G0CTRL_read_mode_enum;
            reset = 0x0;
        } read_mode[26:26];

        enum G0CTRL_dcmp_mode_enum {
            NON_DECOMPRESSION_MODE = 0 { name = "Non Decompression Mode"; desc = "non-decompression mode"; };
            DECOMPRESSION_MODE = 1 { name = "Decompression Mode"; desc = "decompression mode"; };
        };

        field {
            name = "dcmp_mode";
            desc = "Decompression mode (non-instant register).";
            sw = rw;
            hw = r;
            encode = G0CTRL_dcmp_mode_enum;
            reset = 0x0;
        } dcmp_mode[25:25];

        enum G0CTRL_dcmp_inter_enum {
            PROGRESSIVE_DECOMPRESSION = 0 { name = "Progressive Decompression"; desc = "progressive decompression"; };
            INTERLACED_DECOMPRESSION = 1 { name = "Interlaced Decompression"; desc = "interlaced decompression"; };
        };

        field {
            name = "dcmp_inter";
            desc = "Interlaced decompression control (non-instant register).";
            sw = rw;
            hw = r;
            encode = G0CTRL_dcmp_inter_enum;
            reset = 0x0;
        } dcmp_inter[24:24];

        enum G0CTRL_bitext_enum {
            LOWER_BITS_STUFFED = 2 { name = "Lower Bits Stuffed"; desc = "lower bits stuffed with the MSB"; };
            LOWER_BITS_STUFFED_2 = 3 { name = "Lower Bits Stuffed 2"; desc = "lower bits stuffed with upper bits"; };
        };

        field {
            name = "bitext";
            desc = "Bit extend mode of the input bitmap. 0X: lower bits stuffed with 0s";
            sw = rw;
            hw = r;
            encode = G0CTRL_bitext_enum;
            reset = 0x0;
        } bitext[9:8];

        enum G0CTRL_ifmt_enum {
            ARGB1555 = 0x49 { name = "Argb1555"; desc = "ARGB1555"; };
            ARGB8888_OTHER_VALUES = 0x68 { name = "Argb8888 Other Values"; desc = "ARGB8888 Other values: reserved"; };
        };

        field {
            name = "ifmt";
            desc = "Input data format.";
            sw = rw;
            hw = r;
            encode = G0CTRL_ifmt_enum;
            reset = 0x0;
        } ifmt[7:0];
    } G0CTRL @ 0x9000;

    reg {
        name = "G0 update enable register";
        desc = "G0UPD is the G0 channel update enable register.

Data sheet 11.2.4 G0UPD (offset 0x9004, printed page 11-129, `datasheet.txt` line 40027).";

        field {
            name = "regup";
            desc = "Surface register update. After the registers at this layer are configured, the registers are updated when the value 1 is written to this bit. After updates, this bit is cleared automatically by the hardware.";
            sw = rw;
            hw = r;
            reset = 0x0;
        } regup[0:0];
    } G0UPD @ 0x9004;

    reg {
        name = "G0 address register";
        desc = "G0ADDR is the G0 address register. When the horizontal pixel offsets, the address is calculated according to the description of G0SFPOS.

Data sheet 11.2.4 G0ADDR (offset 0x9008, printed page 11-130, `datasheet.txt` line 40063).";

        field {
            name = "surface_addr";
            desc = "Address of the surface frame buffer.";
            sw = rw;
            hw = r;
            reset = 0x0;
        } surface_addr[31:0];
    } G0ADDR @ 0x9008;

    reg {
        name = "G0 stride register";
        desc = "G0STRIDE is the G0 stride register.

Data sheet 11.2.4 G0STRIDE (offset 0x900C, printed page 11-130, `datasheet.txt` line 40082).";

        field {
            name = "surface_stride";
            desc = "Stride of the frame buffer.";
            sw = rw;
            hw = r;
            reset = 0x0;
        } surface_stride[15:0];
    } G0STRIDE @ 0x900C;

    reg {
        name = "G0 overlay parameter register";
        desc = "G0CBMPARA is the G0 overlay parameter register (non-instant register).

Data sheet 11.2.4 G0CBMPARA (offset 0x9010, printed page 11-131, `datasheet.txt` line 40113).";

        enum G0CBMPARA_key_mode_enum {
            COLOR_REGARDED_AS = 0 { name = "Color Regarded As"; desc = "The color is regarded as the colorkey when the following condition is met: Keymin <= Pixel <= Keymax"; };
            COLOR_REGARDED_AS_2 = 1 { name = "Color Regarded As 2"; desc = "The color is regarded as the colorkey when either of the following conditions is met: Pixel <= Keymin or Pixel >= Keymax"; };
        };

        field {
            name = "key_mode";
            desc = "Color key mode. Listed in the bit table of the Hi3520D data sheet issue 02.";
            sw = rw;
            hw = r;
            encode = G0CBMPARA_key_mode_enum;
            reset = 0x0;
        } key_mode[15:15];

        enum G0CBMPARA_key_en_enum {
            DISABLED = 0 { name = "Disabled"; desc = "disabled"; };
            ENABLED = 1 { name = "Enabled"; desc = "enabled"; };
        };

        field {
            name = "key_en";
            desc = "Colorkey enable. Listed in the bit table of the Hi3520D data sheet issue 02.";
            sw = rw;
            hw = r;
            encode = G0CBMPARA_key_en_enum;
            reset = 0x0;
        } key_en[14:14];

        enum G0CBMPARA_premult_en_enum {
            NON_PREMULTIPLY_BITMAP = 0 { name = "Non Premultiply Bitmap"; desc = "non-premultiply bitmap"; };
            PREMULTIPLY_BITMAP = 1 { name = "Premultiply Bitmap"; desc = "premultiply bitmap"; };
        };

        field {
            name = "premult_en";
            desc = "Whether the input bitmap is a premultiply bitmap.";
            sw = rw;
            hw = r;
            encode = G0CBMPARA_premult_en_enum;
            reset = 0x0;
        } premult_en[13:13];

        enum G0CBMPARA_palpha_en_enum {
            DISABLED = 0 { name = "Disabled"; desc = "disabled"; };
            ENABLED = 1 { name = "Enabled"; desc = "enabled"; };
        };

        field {
            name = "palpha_en";
            desc = "Pixel alpha enable.";
            sw = rw;
            hw = r;
            encode = G0CBMPARA_palpha_en_enum;
            reset = 0x0;
        } palpha_en[12:12];

        field {
            name = "galpha";
            desc = "Overlay global alpha value. This value ranges from 0 to 255. The value 255 indicates opaque, and the value 0 indicates full transparent.";
            sw = rw;
            hw = r;
            reset = 0x0;
        } galpha[7:0];
    } G0CBMPARA @ 0x9010;

    reg {
        name = "G0 maximum colorkey register";
        desc = "G0CKEYMAX is the G0 maximum colorkey register (non-instant register).

Data sheet 11.2.4 G0CKEYMAX (offset 0x9014, printed page 11-131, `datasheet.txt` line 40149).";

        field {
            name = "va0";
            desc = "Alpha0 value. When the data format is alphaRGB1555 and the alpha value is 0, the alpha0 value is used.";
            sw = rw;
            hw = r;
            reset = 0x0;
        } va0[31:24];

        field {
            name = "keyr_max";
            desc = "Maximum value of colorkey R component.";
            sw = rw;
            hw = r;
            reset = 0x0;
        } keyr_max[23:16];

        field {
            name = "keyg_max";
            desc = "Maximum value of colorkey G component.";
            sw = rw;
            hw = r;
            reset = 0x0;
        } keyg_max[15:8];

        field {
            name = "keyb_max";
            desc = "Maximum value of colorkey B component.";
            sw = rw;
            hw = r;
            reset = 0x0;
        } keyb_max[7:0];
    } G0CKEYMAX @ 0x9014;

    reg {
        name = "G0 minimum colorkey register";
        desc = "G0CKEYMIN is the G0 minimum colorkey register (non-instant register).

Data sheet 11.2.4 G0CKEYMIN (offset 0x9018, printed page 11-132, `datasheet.txt` line 40182).";

        field {
            name = "va1";
            desc = "Alpha1 value. When the data format is alphaRGB1555 and the alpha value is 1, the alpha1 value is used.";
            sw = rw;
            hw = r;
            reset = 0x0;
        } va1[31:24];

        field {
            name = "keyr_min";
            desc = "Minimum value of colorkey R component.";
            sw = rw;
            hw = r;
            reset = 0x0;
        } keyr_min[23:16];

        field {
            name = "keyg_min";
            desc = "Minimum value of colorkey G component.";
            sw = rw;
            hw = r;
            reset = 0x0;
        } keyg_min[15:8];

        field {
            name = "keyb_min";
            desc = "Minimum value of colorkey B component.";
            sw = rw;
            hw = r;
            reset = 0x0;
        } keyb_min[7:0];
    } G0CKEYMIN @ 0x9018;

    reg {
        name = "G0 colorkey mask value register";
        desc = "G0CMASK is the G0 colorkey mask register (non-instant register). When the corresponding bit is 0, the colorkey is compared. In this case, this bit can be ignored.

Data sheet 11.2.4 G0CMASK (offset 0x901C, printed page 11-132, `datasheet.txt` line 40206).";

        field {
            name = "kmsk_r";
            desc = "R component of colorkey mask.";
            sw = rw;
            hw = r;
            reset = 0x0;
        } kmsk_r[23:16];

        field {
            name = "kmsk_g";
            desc = "G component of colorkey mask.";
            sw = rw;
            hw = r;
            reset = 0x0;
        } kmsk_g[15:8];

        field {
            name = "kmsk_b";
            desc = "B component of colorkey mask.";
            sw = rw;
            hw = r;
            reset = 0x0;
        } kmsk_b[7:0];
    } G0CMASK @ 0x901C;

    reg {
        name = "G0 input resolution register";
        desc = "G0IRESO is the G0 input resolution register (non-instant register).

Data sheet 11.2.4 G0IRESO (offset 0x9020, printed page 11-133, `datasheet.txt` line 40237).";

        field {
            name = "ih";
            desc = "Height (in line). The value is the actual height minus 1.Note: In interlaced output mode, the actual layer height must be an even number. There is no such limitation in progressive output mode.";
            sw = rw;
            hw = r;
            reset = 0x0;
        } ih[23:12];

        field {
            name = "iw";
            desc = "Width (in pixel). The value is the actual width minus 1. Note: The actual layer width must be an even number.";
            sw = rw;
            hw = r;
            reset = 0x0;
        } iw[11:0];
    } G0IRESO @ 0x9020;

    reg {
        name = "G0 output resolution register";
        desc = "G0ORESO is the G0 output resolution register (non-instant register).

Data sheet 11.2.4 G0ORESO (offset 0x9024, printed page 11-133, `datasheet.txt` line 40264).";

        field {
            name = "oh";
            desc = "Note: In interlaced output mode, the actual layer height must be an even number. There is no such limitation in progressive output mode.";
            sw = rw;
            hw = r;
            reset = 0x0;
        } oh[23:12];

        field {
            name = "ow";
            desc = "Width (in pixel). The value is the actual width minus 1. Note: The actual layer width must be an even number.";
            sw = rw;
            hw = r;
            reset = 0x0;
        } ow[11:0];
    } G0ORESO @ 0x9024;

    reg {
        name = "G0 surface start position (in the display window) register";
        desc = "G0DFPOS is the G0 surface start position (in the display window) register (non-instant register). The start position is in the unit of pixel.

Data sheet 11.2.4 G0DFPOS (offset 0x902C, printed page 11-134, `datasheet.txt` line 40301).";

        field {
            name = "disp_yfpos";
            desc = "Column start coordinates.";
            sw = rw;
            hw = r;
            reset = 0x0;
        } disp_yfpos[23:12];

        field {
            name = "disp_xfpos";
            desc = "Row start coordinates.";
            sw = rw;
            hw = r;
            reset = 0x0;
        } disp_xfpos[11:0];
    } G0DFPOS @ 0x902C;

    reg {
        name = "G0 surface end position (in the display window) register";
        desc = "G0DLPOS is the G0 surface end position (in the display window) register (non-instant register). The end position is in the unit of pixel.

Data sheet 11.2.4 G0DLPOS (offset 0x9030, printed page 11-134, `datasheet.txt` line 40323).";

        field {
            name = "disp_ylpos";
            desc = "Column end coordinates.";
            sw = rw;
            hw = r;
            reset = 0x0;
        } disp_ylpos[23:12];

        field {
            name = "disp_xlpos";
            desc = "Row end coordinates.";
            sw = rw;
            hw = r;
            reset = 0x0;
        } disp_xlpos[11:0];
    } G0DLPOS @ 0x9030;

    reg {
        name = "G0 input DC component register for CSC";
        desc = "G0CSCIDC is the G0 input DC component register for CSC (instant register).

Data sheet 11.2.4 G0CSCIDC (offset 0x90A0, printed page 11-135, `datasheet.txt` line 40354).";

        enum G0CSCIDC_csc_en_enum {
            DISABLED = 0 { name = "Disabled"; desc = "disabled"; };
            ENABLED = 1 { name = "Enabled"; desc = "enabled"; };
        };

        field {
            name = "csc_en";
            desc = "CSC enable.";
            sw = rw;
            hw = r;
            encode = G0CSCIDC_csc_en_enum;
            reset = 0x0;
        } csc_en[27:27];

        field {
            name = "cscidc2";
            desc = "DC parameter of input component 2. The MSB is the signed bit. The value is expressed as the complement.";
            sw = rw;
            hw = r;
            reset = 0x0;
        } cscidc2[26:18];

        field {
            name = "cscidc1";
            desc = "DC parameter of input component 1. The MSB is the signed bit. The value is expressed as the complement.";
            sw = rw;
            hw = r;
            reset = 0x0;
        } cscidc1[17:9];

        field {
            name = "cscidc0";
            desc = "DC parameter of input component 0. The MSB is the signed bit. The value is expressed as the complement.";
            sw = rw;
            hw = r;
            reset = 0x0;
        } cscidc0[8:0];
    } G0CSCIDC @ 0x90A0;

    reg {
        name = "G0 output DC component register for CSC";
        desc = "G0CSCODC is the G0 output DC component register for CSC (instant register).

Data sheet 11.2.4 G0CSCODC (offset 0x90A4, printed page 11-135, `datasheet.txt` line 40387).";

        field {
            name = "cscodc2";
            desc = "DC parameter of output component 2. The MSB is the signed bit. The value is expressed as the complement.";
            sw = rw;
            hw = r;
            reset = 0x0;
        } cscodc2[26:18];

        field {
            name = "cscodc1";
            desc = "DC parameter of output component 1. The MSB is the signed bit. The value is expressed as the complement.";
            sw = rw;
            hw = r;
            reset = 0x0;
        } cscodc1[17:9];

        field {
            name = "cscodc0";
            desc = "DC parameter of output component 0. The MSB is the signed bit. The value is expressed as the complement.";
            sw = rw;
            hw = r;
            reset = 0x0;
        } cscodc0[8:0];
    } G0CSCODC @ 0x90A4;

    reg {
        name = "G0 CSC parameter 0 register";
        desc = "G0CSCP0 is the G0 CSC parameter 0 register (instant register).

Data sheet 11.2.4 G0CSCP0 (offset 0x90A8, printed page 11-136, `datasheet.txt` line 40422).";

        field {
            name = "cscp01";
            desc = "5.8 data format that consists of a 1-bit signed bit, a 4-bit integral part, and an 8-bit fractional part. The value is expressed as the complement.";
            sw = rw;
            hw = r;
            reset = 0x0;
        } cscp01[28:16];

        field {
            name = "cscp00";
            desc = "5.8 data format that consists of a 1-bit signed bit, a 4-bit integral part, and an 8-bit fractional part. The value is expressed as the complement.";
            sw = rw;
            hw = r;
            reset = 0x0;
        } cscp00[12:0];
    } G0CSCP0 @ 0x90A8;

    reg {
        name = "G0 CSC parameter 1 register";
        desc = "G0CSCP1 is the G0 CSC parameter 1 register (instant register).

Data sheet 11.2.4 G0CSCP1 (offset 0x90AC, printed page 11-136, `datasheet.txt` line 40454).";

        field {
            name = "cscp10";
            desc = "5.8 data format that consists of a 1-bit signed bit, a 4-bit integral part, and an 8-bit fractional part. The value is expressed as the complement.";
            sw = rw;
            hw = r;
            reset = 0x0;
        } cscp10[28:16];

        field {
            name = "cscp02";
            desc = "5.8 data format that consists of a 1-bit signed bit, a 4-bit integral part, and an 8-bit fractional part. The value is expressed as the complement.";
            sw = rw;
            hw = r;
            reset = 0x0;
        } cscp02[12:0];
    } G0CSCP1 @ 0x90AC;

    reg {
        name = "G0 CSC parameter 2 register";
        desc = "G0CSCP2 is the G0 CSC parameter 2 register (instant register).

Data sheet 11.2.4 G0CSCP2 (offset 0x90B0, printed page 11-137, `datasheet.txt` line 40496).";

        field {
            name = "cscp12";
            desc = "5.8 data format that consists of a 1-bit signed bit, a 4-bit integral part, and an 8-bit fractional part. The value is expressed as the complement.";
            sw = rw;
            hw = r;
            reset = 0x0;
        } cscp12[28:16];

        field {
            name = "cscp11";
            desc = "5.8 data format that consists of a 1-bit signed bit, a 4-bit integral part, and an 8-bit fractional part. The value is expressed as the complement.";
            sw = rw;
            hw = r;
            reset = 0x0;
        } cscp11[12:0];
    } G0CSCP2 @ 0x90B0;

    reg {
        name = "G0 CSC parameter 3 register";
        desc = "G0CSCP3 is the G0 CSC parameter 3 register (instant register).

Data sheet 11.2.4 G0CSCP3 (offset 0x90B4, printed page 11-138, `datasheet.txt` line 40538).";

        field {
            name = "cscp21";
            desc = "5.8 data format that consists of a 1-bit signed bit, a 4-bit integral part, and an 8-bit fractional part. The value is expressed as the complement.";
            sw = rw;
            hw = r;
            reset = 0x0;
        } cscp21[28:16];

        field {
            name = "cscp20";
            desc = "5.8 data format that consists of a 1-bit signed bit, a 4-bit integral part, and an 8-bit fractional part. The value is expressed as the complement.";
            sw = rw;
            hw = r;
            reset = 0x0;
        } cscp20[12:0];
    } G0CSCP3 @ 0x90B4;

    reg {
        name = "G0 CSC parameter 4 register";
        desc = "G0CSCP4 is the G0 CSC parameter 4 register (instant register).

Data sheet 11.2.4 G0CSCP4 (offset 0x90B8, printed page 11-138, `datasheet.txt` line 40570).";

        field {
            name = "cscp22";
            desc = "5.8 data format that consists of a 1-bit signed bit, a 4-bit integral part, and an 8-bit fractional part. The value is expressed as the complement.";
            sw = rw;
            hw = r;
            reset = 0x0;
        } cscp22[12:0];
    } G0CSCP4 @ 0x90B8;

    reg {
        name = "G0 compressed data bank TH width register";
        desc = "G0DCMPBANKWIDTH is the G0 compressed data bank width register.

Data sheet 11.2.4 G0DCMPBANKWIDTH (offset 0x91B4, printed page 11-139, `datasheet.txt` line 40602).";

        field {
            name = "dcmp_bankwidth";
            desc = "Bank width of the compressed data, 128-bit alignment.";
            sw = rw;
            hw = r;
            reset = 0x0;
        } dcmp_bankwidth[11:0];
    } G0DCMPBANKWIDTH @ 0x91B4;

    reg {
        name = "G0 compressed data stride register";
        desc = "G0DCMPSTRIDE is the G0 compressed data stride register.

Data sheet 11.2.4 G0DCMPSTRIDE (offset 0x91B8, printed page 11-139, `datasheet.txt` line 40622).";

        field {
            name = "dcmp_stride";
            desc = "Stride of the compressed data, 128-bit alignment.";
            sw = rw;
            hw = r;
            reset = 0x0;
        } dcmp_stride[15:0];
    } G0DCMPSTRIDE @ 0x91B8;

    reg {
        name = "G0 compressed data start address register of A component";
        desc = "G0DCMPAADDR is the G0 compressed data start address register of A component.

Data sheet 11.2.4 G0DCMPAADDR (offset 0x91BC, printed page 11-139, `datasheet.txt` line 40642).";

        field {
            name = "dcmp_addr_a";
            desc = "Start address of the compressed data.";
            sw = rw;
            hw = r;
            reset = 0x0;
        } dcmp_addr_a[31:0];
    } G0DCMPAADDR @ 0x91BC;

    reg {
        name = "G0 compressed data start address register of R component";
        desc = "G0DCMPRADDR is the G0 compressed data start address register of R component.

Data sheet 11.2.4 G0DCMPRADDR (offset 0x91C0, printed page 11-140, `datasheet.txt` line 40668).";

        field {
            name = "dcmp_addr_r";
            desc = "Start address of the compressed data.";
            sw = rw;
            hw = r;
            reset = 0x0;
        } dcmp_addr_r[31:0];
    } G0DCMPRADDR @ 0x91C0;

    reg {
        name = "G0 compressed data start address register of G component";
        desc = "G0DCMPGADDR is the G0 compressed data start address register of G component.

Data sheet 11.2.4 G0DCMPGADDR (offset 0x91C4, printed page 11-140, `datasheet.txt` line 40687).";

        field {
            name = "dcmp_addr_g";
            desc = "Start address of the compressed data.";
            sw = rw;
            hw = r;
            reset = 0x0;
        } dcmp_addr_g[31:0];
    } G0DCMPGADDR @ 0x91C4;

    reg {
        name = "G0 compressed data start address register of B component";
        desc = "G0DCMPBADDR is the G0 compressed data start address register of B component.

Data sheet 11.2.4 G0DCMPBADDR (offset 0x91C8, printed page 11-140, `datasheet.txt` line 40706).";

        field {
            name = "dcmp_addr_b";
            desc = "Start address of the compressed data.";
            sw = rw;
            hw = r;
            reset = 0x0;
        } dcmp_addr_b[31:0];
    } G0DCMPBADDR @ 0x91C8;

    reg {
        name = "G2 control register";
        desc = "G2CTRL is the G2 control register (non-instant register). It is used to configure the layer information

Data sheet 11.2.4 G2CTRL (offset 0x9400, printed page 11-141, `datasheet.txt` line 40733).";

        enum G2CTRL_surface_en_enum {
            DISABLED = 0 { name = "Disabled"; desc = "disabled"; };
            ENABLED = 1 { name = "Enabled"; desc = "enabled"; };
        };

        field {
            name = "surface_en";
            desc = "Surface enable (non-instant register).";
            sw = rw;
            hw = r;
            encode = G2CTRL_surface_en_enum;
            reset = 0x0;
        } surface_en[31:31];

        enum G2CTRL_upd_mode_enum {
            UPDATE_FRAME = 0 { name = "Update Frame"; desc = "update by frame"; };
            UPDATE_FIELD = 1 { name = "Update Field"; desc = "update by field"; };
        };

        field {
            name = "upd_mode";
            desc = "Update mode.";
            sw = rw;
            hw = r;
            encode = G2CTRL_upd_mode_enum;
            reset = 0x0;
        } upd_mode[27:27];

        enum G2CTRL_read_mode_enum {
            READ_MODE_AUTOMATICALLY = 0 { name = "Read Mode Automatically"; desc = "The read mode is automatically selected based on the interface read mode. That is, the progressive read mode is selected in progressive display mode, and the interlaced read mode is selected in interlaced display mode."; };
            PROGRESSIVE_READ_MODE = 1 { name = "Progressive Read Mode"; desc = "The progressive read mode is selected forcibly."; };
        };

        field {
            name = "read_mode";
            desc = "Data read mode.";
            sw = rw;
            hw = r;
            encode = G2CTRL_read_mode_enum;
            reset = 0x0;
        } read_mode[26:26];

        enum G2CTRL_dcmp_mode_enum {
            NON_DECOMPRESSION_MODE = 0 { name = "Non Decompression Mode"; desc = "non-decompression mode"; };
            DECOMPRESSION_MODE = 1 { name = "Decompression Mode"; desc = "decompression mode"; };
        };

        field {
            name = "dcmp_mode";
            desc = "Not in the Hi3520D data sheet (version 02), which lists G2CTRL/G3CTRL bits [25:10] as reserved; copied from G0CTRL (vendor header). Decompression mode (non-instant register).";
            sw = rw;
            hw = r;
            encode = G2CTRL_dcmp_mode_enum;
            reset = 0x0;
        } dcmp_mode[25:25];

        enum G2CTRL_dcmp_inter_enum {
            PROGRESSIVE_DECOMPRESSION = 0 { name = "Progressive Decompression"; desc = "progressive decompression"; };
            INTERLACED_DECOMPRESSION = 1 { name = "Interlaced Decompression"; desc = "interlaced decompression"; };
        };

        field {
            name = "dcmp_inter";
            desc = "Not in the Hi3520D data sheet (version 02, G2CTRL/G3CTRL [25:10] reserved); copied from G0CTRL (vendor header). Interlaced decompression control (non-instant register).";
            sw = rw;
            hw = r;
            encode = G2CTRL_dcmp_inter_enum;
            reset = 0x0;
        } dcmp_inter[24:24];

        enum G2CTRL_bitext_enum {
            LOWER_BITS_STUFFED = 2 { name = "Lower Bits Stuffed"; desc = "lower bits stuffed with the MSB"; };
            LOWER_BITS_STUFFED_2 = 3 { name = "Lower Bits Stuffed 2"; desc = "lower bits stuffed with upper bits"; };
        };

        field {
            name = "bitext";
            desc = "Bit extend mode of the input bitmap. 0X: lower bits stuffed with 0s";
            sw = rw;
            hw = r;
            encode = G2CTRL_bitext_enum;
            reset = 0x0;
        } bitext[9:8];

        enum G2CTRL_ifmt_enum {
            ARGB1555 = 0x49 { name = "Argb1555"; desc = "ARGB1555"; };
            ARGB8888_OTHER_VALUES = 0x68 { name = "Argb8888 Other Values"; desc = "ARGB8888 Other values: reserved"; };
        };

        field {
            name = "ifmt";
            desc = "Input data format.";
            sw = rw;
            hw = r;
            encode = G2CTRL_ifmt_enum;
            reset = 0x0;
        } ifmt[7:0];
    } G2CTRL @ 0x9400;

    reg {
        name = "G2 update enable register";
        desc = "G2UPD is the G2 channel update enable register.

Data sheet 11.2.4 G2UPD (offset 0x9404, printed page 11-142, `datasheet.txt` line 40800).";

        field {
            name = "regup";
            desc = "Surface register update. After the registers at this layer are configured, the registers are updated when the value 1 is written to this bit. After updates, this bit is cleared automatically by the hardware";
            sw = rw;
            hw = r;
            reset = 0x0;
        } regup[0:0];
    } G2UPD @ 0x9404;

    reg {
        name = "G2 address register";
        desc = "G2ADDR is the G2 address register. When the horizontal pixel offsets, the address is calculated according to the description of G2SFPOS.

Data sheet 11.2.4 G2ADDR (offset 0x9408, printed page 11-142, `datasheet.txt` line 40827).";

        field {
            name = "surface_addr";
            desc = "Address of the surface frame buffer.";
            sw = rw;
            hw = r;
            reset = 0x0;
        } surface_addr[31:0];
    } G2ADDR @ 0x9408;

    reg {
        name = "G2 stride register";
        desc = "G2STRIDE is the G2 stride register.

Data sheet 11.2.4 G2STRIDE (offset 0x940C, printed page 11-143, `datasheet.txt` line 40853).";

        field {
            name = "surface_stride";
            desc = "Stride of the frame buffer.";
            sw = rw;
            hw = r;
            reset = 0x0;
        } surface_stride[15:0];
    } G2STRIDE @ 0x940C;

    reg {
        name = "G2 overlay parameter register";
        desc = "G2CBMPARA is the G2 overlay parameter register (non-instant register).

Data sheet 11.2.4 G2CBMPARA (offset 0x9410, printed page 11-143, `datasheet.txt` line 40874).";

        enum G2CBMPARA_key_mode_enum {
            COLOR_REGARDED_AS = 0 { name = "Color Regarded As"; desc = "The color is regarded as the colorkey when the following condition is met: Keymin <= Pixel <= Keymax"; };
            COLOR_REGARDED_AS_2 = 1 { name = "Color Regarded As 2"; desc = "The color is regarded as the colorkey when either of the following conditions is met: Pixel <= Keymin or Pixel >= Keymax"; };
        };

        field {
            name = "key_mode";
            desc = "Colorkey mode.";
            sw = rw;
            hw = r;
            encode = G2CBMPARA_key_mode_enum;
            reset = 0x0;
        } key_mode[15:15];

        enum G2CBMPARA_key_en_enum {
            DISABLED = 0 { name = "Disabled"; desc = "disabled"; };
            ENABLED = 1 { name = "Enabled"; desc = "enabled"; };
        };

        field {
            name = "key_en";
            desc = "Colorkey enable.";
            sw = rw;
            hw = r;
            encode = G2CBMPARA_key_en_enum;
            reset = 0x0;
        } key_en[14:14];

        enum G2CBMPARA_palpha_en_enum {
            DISABLED = 0 { name = "Disabled"; desc = "disabled"; };
            ENABLED = 1 { name = "Enabled"; desc = "enabled"; };
        };

        field {
            name = "palpha_en";
            desc = "Pixel alpha enable.";
            sw = rw;
            hw = r;
            encode = G2CBMPARA_palpha_en_enum;
            reset = 0x0;
        } palpha_en[12:12];

        field {
            name = "galpha";
            desc = "Overlay global alpha value. This value ranges from 0 to 255. The value 255 indicates opaque, and the value 0 indicates full transparent.";
            sw = rw;
            hw = r;
            reset = 0x0;
        } galpha[7:0];
    } G2CBMPARA @ 0x9410;

    reg {
        name = "G2 maximum colorkey register";
        desc = "G2CKEYMAX is the G2 maximum colorkey register (non-instant register).

Data sheet 11.2.4 G2CKEYMAX (offset 0x9414, printed page 11-144, `datasheet.txt` line 40927).";

        field {
            name = "va0";
            desc = "Alpha0 value. When the data format is alphaRGB1555 and the alpha value is 0, the alpha0 value is used.";
            sw = rw;
            hw = r;
            reset = 0x0;
        } va0[31:24];

        field {
            name = "keyr_max";
            desc = "Maximum value of colorkey R component.";
            sw = rw;
            hw = r;
            reset = 0x0;
        } keyr_max[23:16];

        field {
            name = "keyg_max";
            desc = "Maximum value of colorkey G component.";
            sw = rw;
            hw = r;
            reset = 0x0;
        } keyg_max[15:8];

        field {
            name = "keyb_max";
            desc = "Maximum value of colorkey B component.";
            sw = rw;
            hw = r;
            reset = 0x0;
        } keyb_max[7:0];
    } G2CKEYMAX @ 0x9414;

    reg {
        name = "G2 minimum colorkey register";
        desc = "G2CKEYMIN is the G2 minimum colorkey register (non-instant register).

Data sheet 11.2.4 G2CKEYMIN (offset 0x9418, printed page 11-144, `datasheet.txt` line 40951).";

        field {
            name = "va1";
            desc = "Alpha1 value. When the data format is alphaRGB1555 and the alpha value is 1, the alpha1 value is used.";
            sw = rw;
            hw = r;
            reset = 0x0;
        } va1[31:24];

        field {
            name = "keyr_min";
            desc = "Minimum value of colorkey R component.";
            sw = rw;
            hw = r;
            reset = 0x0;
        } keyr_min[23:16];

        field {
            name = "keyg_min";
            desc = "Minimum value of colorkey G component.";
            sw = rw;
            hw = r;
            reset = 0x0;
        } keyg_min[15:8];

        field {
            name = "keyb_min";
            desc = "Minimum value of colorkey B component.";
            sw = rw;
            hw = r;
            reset = 0x0;
        } keyb_min[7:0];
    } G2CKEYMIN @ 0x9418;

    reg {
        name = "G2 colorkey mask value register";
        desc = "G2CMASK is the G2 colorkey mask register (non-instant register). When the corresponding bit is 0, the colorkey is compared. In this case, this bit can be ignored.

Data sheet 11.2.4 G2CMASK (offset 0x941C, printed page 11-145, `datasheet.txt` line 40985).";

        field {
            name = "kmsk_r";
            desc = "R component of colorkey mask.";
            sw = rw;
            hw = r;
            reset = 0x0;
        } kmsk_r[23:16];

        field {
            name = "kmsk_g";
            desc = "G component of colorkey mask.";
            sw = rw;
            hw = r;
            reset = 0x0;
        } kmsk_g[15:8];

        field {
            name = "kmsk_b";
            desc = "B component of colorkey mask.";
            sw = rw;
            hw = r;
            reset = 0x0;
        } kmsk_b[7:0];
    } G2CMASK @ 0x941C;

    reg {
        name = "G2 input resolution register";
        desc = "G2IRESO is the G2 input resolution register (non-instant register).

Data sheet 11.2.4 G2IRESO (offset 0x9420, printed page 11-145, `datasheet.txt` line 41007).";

        field {
            name = "ih";
            desc = "Note: In interlaced output mode, the actual layer height must be an even number. There is no such limitation in progressive output mode.";
            sw = rw;
            hw = r;
            reset = 0x0;
        } ih[23:12];

        field {
            name = "iw";
            desc = "Width (in pixel). The value is the actual width minus 1. Note: The actual layer width must be an even number.";
            sw = rw;
            hw = r;
            reset = 0x0;
        } iw[11:0];
    } G2IRESO @ 0x9420;

    reg {
        name = "G2 output resolution register";
        desc = "G2ORESO is the G2 output resolution register (non-instant register).

Data sheet 11.2.4 G2ORESO (offset 0x9424, printed page 11-146, `datasheet.txt` line 41043).";

        field {
            name = "oh";
            desc = "Note: In interlaced output mode, the actual layer height must be an even number. There is no such limitation in progressive output mode.";
            sw = rw;
            hw = r;
            reset = 0x0;
        } oh[23:12];

        field {
            name = "ow";
            desc = "Width (in pixel). The value is the actual width minus 1. Note: The actual layer width must be an even number.";
            sw = rw;
            hw = r;
            reset = 0x0;
        } ow[11:0];
    } G2ORESO @ 0x9424;

    reg {
        name = "G2 surface start position (in the display window) register";
        desc = "G2DFPOS is the G2 surface start position (in the display window) register (non-instant register). The start position is in the unit of pixel.

Data sheet 11.2.4 G2DFPOS (offset 0x942C, printed page 11-146, `datasheet.txt` line 41070).";

        field {
            name = "disp_yfpos";
            desc = "Column start coordinates.";
            sw = rw;
            hw = r;
            reset = 0x0;
        } disp_yfpos[23:12];

        field {
            name = "disp_xfpos";
            desc = "Row start coordinates.";
            sw = rw;
            hw = r;
            reset = 0x0;
        } disp_xfpos[11:0];
    } G2DFPOS @ 0x942C;

    reg {
        name = "G2 surface end position (in the display window) register";
        desc = "G2DLPOS is the G2 surface end position (in the display window) register (non-instant register). The end position is in the unit of pixel.

Data sheet 11.2.4 G2DLPOS (offset 0x9430, printed page 11-147, `datasheet.txt` line 41100).";

        field {
            name = "disp_ylpos";
            desc = "Column end coordinates.";
            sw = rw;
            hw = r;
            reset = 0x0;
        } disp_ylpos[23:12];

        field {
            name = "disp_xlpos";
            desc = "Row end coordinates.";
            sw = rw;
            hw = r;
            reset = 0x0;
        } disp_xlpos[11:0];
    } G2DLPOS @ 0x9430;

    reg {
        name = "G2 input DC component register for CSC";
        desc = "G2CSCIDC is the G2 input DC component register for CSC (instant register).

Data sheet 11.2.4 G2CSCIDC (offset 0x94A0, printed page 11-147, `datasheet.txt` line 41121).";

        enum G2CSCIDC_csc_en_enum {
            DISABLED = 0 { name = "Disabled"; desc = "disabled"; };
            ENABLED = 1 { name = "Enabled"; desc = "enabled"; };
        };

        field {
            name = "csc_en";
            desc = "CSC enable.";
            sw = rw;
            hw = r;
            encode = G2CSCIDC_csc_en_enum;
            reset = 0x0;
        } csc_en[27:27];

        field {
            name = "cscidc2";
            desc = "DC parameter of input component 2. The MSB is the signed bit. The value is expressed as the complement.";
            sw = rw;
            hw = r;
            reset = 0x0;
        } cscidc2[26:18];

        field {
            name = "cscidc1";
            desc = "DC parameter of input component 1. The MSB is the signed bit. The value is expressed as the complement.";
            sw = rw;
            hw = r;
            reset = 0x0;
        } cscidc1[17:9];

        field {
            name = "cscidc0";
            desc = "DC parameter of input component 0. The MSB is the signed bit. The value is expressed as the complement.";
            sw = rw;
            hw = r;
            reset = 0x0;
        } cscidc0[8:0];
    } G2CSCIDC @ 0x94A0;

    reg {
        name = "G2 output DC component register for CSC";
        desc = "G2CSCODC is the G2 output DC component register for CSC (instant register).

Data sheet 11.2.4 G2CSCODC (offset 0x94A4, printed page 11-148, `datasheet.txt` line 41164).";

        field {
            name = "cscodc2";
            desc = "DC parameter of output component 2. The MSB is the signed bit. The value is expressed as the complement.";
            sw = rw;
            hw = r;
            reset = 0x0;
        } cscodc2[26:18];

        field {
            name = "cscodc1";
            desc = "DC parameter of output component 1. The MSB is the signed bit. The value is expressed as the complement.";
            sw = rw;
            hw = r;
            reset = 0x0;
        } cscodc1[17:9];

        field {
            name = "cscodc0";
            desc = "DC parameter of output component 0. The MSB is the signed bit. The value is expressed as the complement.";
            sw = rw;
            hw = r;
            reset = 0x0;
        } cscodc0[8:0];
    } G2CSCODC @ 0x94A4;

    reg {
        name = "G2 CSC parameter 0 register";
        desc = "G2CSCP0 is the G2 CSC parameter 0 register (instant register).

Data sheet 11.2.4 G2CSCP0 (offset 0x94A8, printed page 11-148, `datasheet.txt` line 41192).";

        field {
            name = "cscp01";
            desc = "5.8 data format that consists of a 1-bit signed bit, a 4-bit integral part, and an 8-bit fractional part. The value is expressed as the complement.";
            sw = rw;
            hw = r;
            reset = 0x0;
        } cscp01[28:16];

        field {
            name = "cscp00";
            desc = "5.8 data format that consists of a 1-bit signed bit, a 4-bit integral part, and an 8-bit fractional part. The value is expressed as the complement.";
            sw = rw;
            hw = r;
            reset = 0x0;
        } cscp00[12:0];
    } G2CSCP0 @ 0x94A8;

    reg {
        name = "G2 CSC parameter 1 register";
        desc = "G2CSCP1 is the G2 CSC parameter 1 register (instant register).

Data sheet 11.2.4 G2CSCP1 (offset 0x94AC, printed page 11-149, `datasheet.txt` line 41231).";

        field {
            name = "cscp10";
            desc = "5.8 data format that consists of a 1-bit signed bit, a 4-bit integral part, and an 8-bit fractional part. The value is expressed as the complement.";
            sw = rw;
            hw = r;
            reset = 0x0;
        } cscp10[28:16];

        field {
            name = "cscp02";
            desc = "5.8 data format that consists of a 1-bit signed bit, a 4-bit integral part, and an 8-bit fractional part. The value is expressed as the complement.";
            sw = rw;
            hw = r;
            reset = 0x0;
        } cscp02[12:0];
    } G2CSCP1 @ 0x94AC;

    reg {
        name = "G2 CSC parameter 2 register";
        desc = "G2CSCP2 is the G2 CSC parameter 2 register (instant register).

Data sheet 11.2.4 G2CSCP2 (offset 0x94B0, printed page 11-149, `datasheet.txt` line 41263).";

        field {
            name = "cscp12";
            desc = "5.8 data format that consists of a 1-bit signed bit, a 4-bit integral part, and an 8-bit fractional part. The value is expressed as the complement.";
            sw = rw;
            hw = r;
            reset = 0x0;
        } cscp12[28:16];

        field {
            name = "cscp11";
            desc = "5.8 data format that consists of a 1-bit signed bit, a 4-bit integral part, and an 8-bit fractional part. The value is expressed as the complement.";
            sw = rw;
            hw = r;
            reset = 0x0;
        } cscp11[12:0];
    } G2CSCP2 @ 0x94B0;

    reg {
        name = "G2 CSC parameter 3 register";
        desc = "G2CSCP3 is the G2 CSC parameter 3 register (instant register).

Data sheet 11.2.4 G2CSCP3 (offset 0x94B4, printed page 11-150, `datasheet.txt` line 41305).";

        field {
            name = "cscp21";
            desc = "5.8 data format that consists of a 1-bit signed bit, a 4-bit integral part, and an 8-bit fractional part. The value is expressed as the complement.";
            sw = rw;
            hw = r;
            reset = 0x0;
        } cscp21[28:16];

        field {
            name = "cscp20";
            desc = "5.8 data format that consists of a 1-bit signed bit, a 4-bit integral part, and an 8-bit fractional part. The value is expressed as the complement.";
            sw = rw;
            hw = r;
            reset = 0x0;
        } cscp20[12:0];
    } G2CSCP3 @ 0x94B4;

    reg {
        name = "G2 CSC parameter 4 register";
        desc = "G2CSCP4 is the G2 CSC parameter 4 register (instant register).

Data sheet 11.2.4 G2CSCP4 (offset 0x94B8, printed page 11-150, `datasheet.txt` line 41337).";

        field {
            name = "cscp22";
            desc = "5.8 data format that consists of a 1-bit signed bit, a 4-bit integral part, and an 8-bit fractional part. The value is expressed as the complement.";
            sw = rw;
            hw = r;
            reset = 0x0;
        } cscp22[12:0];
    } G2CSCP4 @ 0x94B8;

    reg {
        name = "G3 control register";
        desc = "G3CTRL is the G3 control register (non-instant register). It is used to configure the layer information

Data sheet 11.2.4 G3CTRL (offset 0x9600, printed page 11-151, `datasheet.txt` line 41370).";

        enum G3CTRL_surface_en_enum {
            DISABLED = 0 { name = "Disabled"; desc = "disabled"; };
            ENABLED = 1 { name = "Enabled"; desc = "enabled"; };
        };

        field {
            name = "surface_en";
            desc = "Surface enable (non-instant register).";
            sw = rw;
            hw = r;
            encode = G3CTRL_surface_en_enum;
            reset = 0x0;
        } surface_en[31:31];

        enum G3CTRL_upd_mode_enum {
            UPDATE_FRAME = 0 { name = "Update Frame"; desc = "update by frame"; };
            UPDATE_FIELD = 1 { name = "Update Field"; desc = "update by field"; };
        };

        field {
            name = "upd_mode";
            desc = "Update mode.";
            sw = rw;
            hw = r;
            encode = G3CTRL_upd_mode_enum;
            reset = 0x0;
        } upd_mode[27:27];

        enum G3CTRL_read_mode_enum {
            READ_MODE_AUTOMATICALLY = 0 { name = "Read Mode Automatically"; desc = "The read mode is automatically selected based on the interface read mode. That is, the progressive read mode is selected in progressive display mode, and the interlaced read mode is selected in interlaced display mode."; };
            PROGRESSIVE_READ_MODE = 1 { name = "Progressive Read Mode"; desc = "The progressive read mode is selected forcibly."; };
        };

        field {
            name = "read_mode";
            desc = "Data read mode.";
            sw = rw;
            hw = r;
            encode = G3CTRL_read_mode_enum;
            reset = 0x0;
        } read_mode[26:26];

        enum G3CTRL_dcmp_mode_enum {
            NON_DECOMPRESSION_MODE = 0 { name = "Non Decompression Mode"; desc = "non-decompression mode"; };
            DECOMPRESSION_MODE = 1 { name = "Decompression Mode"; desc = "decompression mode"; };
        };

        field {
            name = "dcmp_mode";
            desc = "Not in the Hi3520D data sheet (version 02), which lists G2CTRL/G3CTRL bits [25:10] as reserved; copied from G0CTRL (vendor header). Decompression mode (non-instant register).";
            sw = rw;
            hw = r;
            encode = G3CTRL_dcmp_mode_enum;
            reset = 0x0;
        } dcmp_mode[25:25];

        enum G3CTRL_dcmp_inter_enum {
            PROGRESSIVE_DECOMPRESSION = 0 { name = "Progressive Decompression"; desc = "progressive decompression"; };
            INTERLACED_DECOMPRESSION = 1 { name = "Interlaced Decompression"; desc = "interlaced decompression"; };
        };

        field {
            name = "dcmp_inter";
            desc = "Not in the Hi3520D data sheet (version 02, G2CTRL/G3CTRL [25:10] reserved); copied from G0CTRL (vendor header). Interlaced decompression control (non-instant register).";
            sw = rw;
            hw = r;
            encode = G3CTRL_dcmp_inter_enum;
            reset = 0x0;
        } dcmp_inter[24:24];

        enum G3CTRL_bitext_enum {
            LOWER_BITS_STUFFED = 2 { name = "Lower Bits Stuffed"; desc = "lower bits stuffed with the MSB"; };
            LOWER_BITS_STUFFED_2 = 3 { name = "Lower Bits Stuffed 2"; desc = "lower bits stuffed with upper bits"; };
        };

        field {
            name = "bitext";
            desc = "Bit extend mode of the input bitmap. 0X: lower bits stuffed with 0s";
            sw = rw;
            hw = r;
            encode = G3CTRL_bitext_enum;
            reset = 0x0;
        } bitext[9:8];

        enum G3CTRL_ifmt_enum {
            ARGB1555 = 0x49 { name = "Argb1555"; desc = "ARGB1555"; };
            ARGB8888_OTHER_VALUES = 0x68 { name = "Argb8888 Other Values"; desc = "ARGB8888 Other values: reserved"; };
        };

        field {
            name = "ifmt";
            desc = "Input data format.";
            sw = rw;
            hw = r;
            encode = G3CTRL_ifmt_enum;
            reset = 0x0;
        } ifmt[7:0];
    } G3CTRL @ 0x9600;

    reg {
        name = "G3 update enable register";
        desc = "G3UPD is the G3 channel update enable register.

Data sheet 11.2.4 G3UPD (offset 0x9604, printed page 11-152, `datasheet.txt` line 41437).";

        field {
            name = "regup";
            desc = "Surface register update. After the registers at this layer are configured, the registers are updated when the value 1 is written to this bit. After updates, this bit is cleared automatically by the hardware";
            sw = rw;
            hw = r;
            reset = 0x0;
        } regup[0:0];
    } G3UPD @ 0x9604;

    reg {
        name = "G3 address register";
        desc = "G3ADDR is the G3 address register. When the horizontal pixel offsets, the address is calculated according to the description of G3SFPOS.

Data sheet 11.2.4 G3ADDR (offset 0x9608, printed page 11-153, `datasheet.txt` line 41474).";

        field {
            name = "surface_addr";
            desc = "Address of the surface frame buffer.";
            sw = rw;
            hw = r;
            reset = 0x0;
        } surface_addr[31:0];
    } G3ADDR @ 0x9608;

    reg {
        name = "G3 stride register";
        desc = "G3STRIDE is the G3 stride register.

Data sheet 11.2.4 G3STRIDE (offset 0x960C, printed page 11-153, `datasheet.txt` line 41493).";

        field {
            name = "surface_stride";
            desc = "Stride of the frame buffer.";
            sw = rw;
            hw = r;
            reset = 0x0;
        } surface_stride[15:0];
    } G3STRIDE @ 0x960C;

    reg {
        name = "G3 overlay parameter register";
        desc = "G3CBMPARA is the G3 overlay parameter register (non-instant register).

Data sheet 11.2.4 G3CBMPARA (offset 0x9610, printed page 11-153, `datasheet.txt` line 41514).";

        enum G3CBMPARA_key_mode_enum {
            COLOR_REGARDED_AS = 0 { name = "Color Regarded As"; desc = "The color is regarded as the colorkey when the following condition is met: Keymin <= Pixel <= Keymax"; };
            COLOR_REGARDED_AS_2 = 1 { name = "Color Regarded As 2"; desc = "The color is regarded as the colorkey when either of the following conditions is met: Pixel <= Keymin or Pixel >= Keymax"; };
        };

        field {
            name = "key_mode";
            desc = "Color key mode. Listed in the bit table of the Hi3520D data sheet issue 02.";
            sw = rw;
            hw = r;
            encode = G3CBMPARA_key_mode_enum;
            reset = 0x0;
        } key_mode[15:15];

        enum G3CBMPARA_key_en_enum {
            DISABLED = 0 { name = "Disabled"; desc = "disabled"; };
            ENABLED = 1 { name = "Enabled"; desc = "enabled"; };
        };

        field {
            name = "key_en";
            desc = "Colorkey enable. Listed in the bit table of the Hi3520D data sheet issue 02.";
            sw = rw;
            hw = r;
            encode = G3CBMPARA_key_en_enum;
            reset = 0x0;
        } key_en[14:14];

        enum G3CBMPARA_premult_en_enum {
            NON_PREMULTIPLY_BITMAP = 0 { name = "Non Premultiply Bitmap"; desc = "non-premultiply bitmap"; };
            PREMULTIPLY_BITMAP = 1 { name = "Premultiply Bitmap"; desc = "premultiply bitmap"; };
        };

        field {
            name = "premult_en";
            desc = "Whether the input bitmap is a premultiply bitmap.";
            sw = rw;
            hw = r;
            encode = G3CBMPARA_premult_en_enum;
            reset = 0x0;
        } premult_en[13:13];

        enum G3CBMPARA_palpha_en_enum {
            DISABLED = 0 { name = "Disabled"; desc = "disabled"; };
            ENABLED = 1 { name = "Enabled"; desc = "enabled"; };
        };

        field {
            name = "palpha_en";
            desc = "Pixel alpha enable.";
            sw = rw;
            hw = r;
            encode = G3CBMPARA_palpha_en_enum;
            reset = 0x0;
        } palpha_en[12:12];

        field {
            name = "galpha";
            desc = "Overlay global alpha value. This value ranges from 0 to 255. The value 255 indicates opaque, and the value 0 indicates full transparent.";
            sw = rw;
            hw = r;
            reset = 0x0;
        } galpha[7:0];
    } G3CBMPARA @ 0x9610;

    reg {
        name = "G3 maximum colorkey register";
        desc = "G3CKEYMAX is the G3 maximum colorkey register (non-instant register).

Data sheet 11.2.4 G3CKEYMAX (offset 0x9614, printed page 11-154, `datasheet.txt` line 41560).";

        field {
            name = "va0";
            desc = "Alpha0 value. When the data format is alphaRGB1555 and the alpha value is 0, the alpha0 value is used.";
            sw = rw;
            hw = r;
            reset = 0x0;
        } va0[31:24];

        field {
            name = "keyr_max";
            desc = "Maximum value of colorkey R component.";
            sw = rw;
            hw = r;
            reset = 0x0;
        } keyr_max[23:16];

        field {
            name = "keyg_max";
            desc = "Maximum value of colorkey G component.";
            sw = rw;
            hw = r;
            reset = 0x0;
        } keyg_max[15:8];

        field {
            name = "keyb_max";
            desc = "Maximum value of colorkey B component.";
            sw = rw;
            hw = r;
            reset = 0x0;
        } keyb_max[7:0];
    } G3CKEYMAX @ 0x9614;

    reg {
        name = "G3 minimum colorkey register";
        desc = "G3CKEYMIN is the G3 minimum colorkey register (non-instant register).

Data sheet 11.2.4 G3CKEYMIN (offset 0x9618, printed page 11-155, `datasheet.txt` line 41594).";

        field {
            name = "va1";
            desc = "Alpha1 value. When the data format is alphaRGB1555 and the alpha value is 1, the alpha1 value is used.";
            sw = rw;
            hw = r;
            reset = 0x0;
        } va1[31:24];

        field {
            name = "keyr_min";
            desc = "Minimum value of colorkey R component.";
            sw = rw;
            hw = r;
            reset = 0x0;
        } keyr_min[23:16];

        field {
            name = "keyg_min";
            desc = "Minimum value of colorkey G component.";
            sw = rw;
            hw = r;
            reset = 0x0;
        } keyg_min[15:8];

        field {
            name = "keyb_min";
            desc = "Minimum value of colorkey B component.";
            sw = rw;
            hw = r;
            reset = 0x0;
        } keyb_min[7:0];
    } G3CKEYMIN @ 0x9618;

    reg {
        name = "G3 colorkey mask value register";
        desc = "G3CMASK is the G3 colorkey mask register (non-instant register). When the corresponding bit is 0, the colorkey is compared. In this case, this bit can be ignored.

Data sheet 11.2.4 G3CMASK (offset 0x961C, printed page 11-155, `datasheet.txt` line 41619).";

        field {
            name = "kmsk_r";
            desc = "R component of colorkey mask.";
            sw = rw;
            hw = r;
            reset = 0x0;
        } kmsk_r[23:16];

        field {
            name = "kmsk_g";
            desc = "G component of colorkey mask.";
            sw = rw;
            hw = r;
            reset = 0x0;
        } kmsk_g[15:8];

        field {
            name = "kmsk_b";
            desc = "B component of colorkey mask.";
            sw = rw;
            hw = r;
            reset = 0x0;
        } kmsk_b[7:0];
    } G3CMASK @ 0x961C;

    reg {
        name = "G3 input resolution register";
        desc = "G3IRESO is the G3 input resolution register (non-instant register).

Data sheet 11.2.4 G3IRESO (offset 0x9620, printed page 11-156, `datasheet.txt` line 41651).";

        field {
            name = "ih";
            desc = "Note: In interlaced output mode, the actual layer height must be an even number. There is no such limitation in progressive output mode.";
            sw = rw;
            hw = r;
            reset = 0x0;
        } ih[23:12];

        field {
            name = "iw";
            desc = "Width (in pixel). The value is the actual width minus 1. Note: The actual layer width must be an even number.";
            sw = rw;
            hw = r;
            reset = 0x0;
        } iw[11:0];
    } G3IRESO @ 0x9620;

    reg {
        name = "G3 output resolution register";
        desc = "G3ORESO is the G3 output resolution register (non-instant register).

Data sheet 11.2.4 G3ORESO (offset 0x9624, printed page 11-156, `datasheet.txt` line 41677).";

        field {
            name = "oh";
            desc = "Note: In interlaced output mode, the actual layer height must be an even number. There is no such limitation in progressive output mode.";
            sw = rw;
            hw = r;
            reset = 0x0;
        } oh[23:12];

        field {
            name = "ow";
            desc = "Width (in pixel). The value is the actual width minus 1. Note: The actual layer width must be an even number.";
            sw = rw;
            hw = r;
            reset = 0x0;
        } ow[11:0];
    } G3ORESO @ 0x9624;

    reg {
        name = "G3 surface start position (in the display window) register";
        desc = "G3DFPOS is the G3 surface start position (in the display window) register (non-instant register). The start position is in the unit of pixel.

Data sheet 11.2.4 G3DFPOS (offset 0x962C, printed page 11-157, `datasheet.txt` line 41714).";

        field {
            name = "disp_yfpos";
            desc = "Column start coordinates.";
            sw = rw;
            hw = r;
            reset = 0x0;
        } disp_yfpos[23:12];

        field {
            name = "disp_xfpos";
            desc = "Row start coordinates.";
            sw = rw;
            hw = r;
            reset = 0x0;
        } disp_xfpos[11:0];
    } G3DFPOS @ 0x962C;

    reg {
        name = "G3 surface end position (in the display window) register";
        desc = "G3DLPOS is the G3 surface end position (in the display window) register (non-instant register). The end position is in the unit of pixel.

Data sheet 11.2.4 G3DLPOS (offset 0x9630, printed page 11-157, `datasheet.txt` line 41736).";

        field {
            name = "disp_ylpos";
            desc = "Column end coordinates.";
            sw = rw;
            hw = r;
            reset = 0x0;
        } disp_ylpos[23:12];

        field {
            name = "disp_xlpos";
            desc = "Row end coordinates.";
            sw = rw;
            hw = r;
            reset = 0x0;
        } disp_xlpos[11:0];
    } G3DLPOS @ 0x9630;

    reg {
        name = "G3 input DC component register for CSC";
        desc = "G3CSCIDC is the G3 input DC component register for CSC (instant register).

Data sheet 11.2.4 G3CSCIDC (offset 0x96A0, printed page 11-158, `datasheet.txt` line 41767).";

        enum G3CSCIDC_csc_en_enum {
            DISABLED = 0 { name = "Disabled"; desc = "disabled"; };
            ENABLED = 1 { name = "Enabled"; desc = "enabled"; };
        };

        field {
            name = "csc_en";
            desc = "CSC enable.";
            sw = rw;
            hw = r;
            encode = G3CSCIDC_csc_en_enum;
            reset = 0x0;
        } csc_en[27:27];

        field {
            name = "cscidc2";
            desc = "DC parameter of input component 2. The MSB is the signed bit. The value is expressed as the complement.";
            sw = rw;
            hw = r;
            reset = 0x0;
        } cscidc2[26:18];

        field {
            name = "cscidc1";
            desc = "DC parameter of input component 1. The MSB is the signed bit. The value is expressed as the complement.";
            sw = rw;
            hw = r;
            reset = 0x0;
        } cscidc1[17:9];

        field {
            name = "cscidc0";
            desc = "DC parameter of input component 0. The MSB is the signed bit. The value is expressed as the complement.";
            sw = rw;
            hw = r;
            reset = 0x0;
        } cscidc0[8:0];
    } G3CSCIDC @ 0x96A0;

    reg {
        name = "G3 output DC component register for CSC";
        desc = "G3CSCODC is the G3 output DC component register for CSC (instant register).

Data sheet 11.2.4 G3CSCODC (offset 0x96A4, printed page 11-158, `datasheet.txt` line 41800).";

        field {
            name = "cscodc2";
            desc = "DC parameter of output component 2. The MSB is the signed bit. The value is expressed as the complement.";
            sw = rw;
            hw = r;
            reset = 0x0;
        } cscodc2[26:18];

        field {
            name = "cscodc1";
            desc = "DC parameter of output component 1. The MSB is the signed bit. The value is expressed as the complement.";
            sw = rw;
            hw = r;
            reset = 0x0;
        } cscodc1[17:9];

        field {
            name = "cscodc0";
            desc = "DC parameter of output component 0. The MSB is the signed bit. The value is expressed as the complement.";
            sw = rw;
            hw = r;
            reset = 0x0;
        } cscodc0[8:0];
    } G3CSCODC @ 0x96A4;

    reg {
        name = "G3 CSC parameter 0 register";
        desc = "G3CSCP0 is the G3 CSC parameter 0 register (instant register).

Data sheet 11.2.4 G3CSCP0 (offset 0x96A8, printed page 11-159, `datasheet.txt` line 41835).";

        field {
            name = "cscp01";
            desc = "5.8 data format that consists of a 1-bit signed bit, a 4-bit integral part, and an 8-bit fractional part. The value is expressed as the complement.";
            sw = rw;
            hw = r;
            reset = 0x0;
        } cscp01[28:16];

        field {
            name = "cscp00";
            desc = "5.8 data format that consists of a 1-bit signed bit, a 4-bit integral part, and an 8-bit fractional part. The value is expressed as the complement.";
            sw = rw;
            hw = r;
            reset = 0x0;
        } cscp00[12:0];
    } G3CSCP0 @ 0x96A8;

    reg {
        name = "G3 CSC parameter 1 register";
        desc = "G3CSCP1 is the G3 CSC parameter 1 register (instant register).

Data sheet 11.2.4 G3CSCP1 (offset 0x96AC, printed page 11-159, `datasheet.txt` line 41867).";

        field {
            name = "cscp10";
            desc = "5.8 data format that consists of a 1-bit signed bit, a 4-bit integral part, and an 8-bit fractional part. The value is expressed as the complement.";
            sw = rw;
            hw = r;
            reset = 0x0;
        } cscp10[28:16];

        field {
            name = "cscp02";
            desc = "5.8 data format that consists of a 1-bit signed bit, a 4-bit integral part, and an 8-bit fractional part. The value is expressed as the complement.";
            sw = rw;
            hw = r;
            reset = 0x0;
        } cscp02[12:0];
    } G3CSCP1 @ 0x96AC;

    reg {
        name = "G3 CSC parameter 2 register";
        desc = "G3CSCP2 is the G3 CSC parameter 2 register (instant register).

Data sheet 11.2.4 G3CSCP2 (offset 0x96B0, printed page 11-160, `datasheet.txt` line 41909).";

        field {
            name = "cscp12";
            desc = "5.8 data format that consists of a 1-bit signed bit, a 4-bit integral part, and an 8-bit fractional part. The value is expressed as the complement.";
            sw = rw;
            hw = r;
            reset = 0x0;
        } cscp12[28:16];

        field {
            name = "cscp11";
            desc = "5.8 data format that consists of a 1-bit signed bit, a 4-bit integral part, and an 8-bit fractional part. The value is expressed as the complement.";
            sw = rw;
            hw = r;
            reset = 0x0;
        } cscp11[12:0];
    } G3CSCP2 @ 0x96B0;

    reg {
        name = "G3 CSC parameter 3 register";
        desc = "G3CSCP3 is the G3 CSC parameter 3 register (instant register).

Data sheet 11.2.4 G3CSCP3 (offset 0x96B4, printed page 11-161, `datasheet.txt` line 41951).";

        field {
            name = "cscp21";
            desc = "5.8 data format that consists of a 1-bit signed bit, a 4-bit integral part, and an 8-bit fractional part. The value is expressed as the complement.";
            sw = rw;
            hw = r;
            reset = 0x0;
        } cscp21[28:16];

        field {
            name = "cscp20";
            desc = "5.8 data format that consists of a 1-bit signed bit, a 4-bit integral part, and an 8-bit fractional part. The value is expressed as the complement.";
            sw = rw;
            hw = r;
            reset = 0x0;
        } cscp20[12:0];
    } G3CSCP3 @ 0x96B4;

    reg {
        name = "G3 CSC parameter 4 register";
        desc = "G3CSCP4 is the G3 CSC parameter 4 register (instant register).

Data sheet 11.2.4 G3CSCP4 (offset 0x96B8, printed page 11-161, `datasheet.txt` line 41983).";

        field {
            name = "cscp22";
            desc = "5.8 data format that consists of a 1-bit signed bit, a 4-bit integral part, and an 8-bit fractional part. The value is expressed as the complement.";
            sw = rw;
            hw = r;
            reset = 0x0;
        } cscp22[12:0];
    } G3CSCP4 @ 0x96B8;

    reg {
        name = "HC control register";
        desc = "HCCTRL is the HC control register (non-instant register). It is used to configure the layer information

Data sheet 11.2.4 HCCTRL (offset 0x9A00, printed page 11-162, `datasheet.txt` line 42016).";

        enum HCCTRL_surface_en_enum {
            DISABLED = 0 { name = "Disabled"; desc = "disabled"; };
            ENABLED = 1 { name = "Enabled"; desc = "enabled"; };
        };

        field {
            name = "surface_en";
            desc = "Surface enable (non-instant register).";
            sw = rw;
            hw = r;
            encode = HCCTRL_surface_en_enum;
            reset = 0x0;
        } surface_en[31:31];

        enum HCCTRL_upd_mode_enum {
            UPDATE_FRAME = 0 { name = "Update Frame"; desc = "update by frame"; };
            UPDATE_FIELD = 1 { name = "Update Field"; desc = "update by field"; };
        };

        field {
            name = "upd_mode";
            desc = "Update mode.";
            sw = rw;
            hw = r;
            encode = HCCTRL_upd_mode_enum;
            reset = 0x0;
        } upd_mode[27:27];

        enum HCCTRL_read_mode_enum {
            READ_MODE_AUTOMATICALLY = 0 { name = "Read Mode Automatically"; desc = "The read mode is automatically selected based on the interface read mode. That is, the progressive read mode is selected in progressive display mode, and the interlaced read mode is selected in interlaced display mode."; };
            PROGRESSIVE_READ_MODE = 1 { name = "Progressive Read Mode"; desc = "The progressive read mode is selected forcibly."; };
        };

        field {
            name = "read_mode";
            desc = "Data read mode.";
            sw = rw;
            hw = r;
            encode = HCCTRL_read_mode_enum;
            reset = 0x0;
        } read_mode[26:26];

        enum HCCTRL_key_mode_enum {
            COLOR_REGARDED_AS = 0 { name = "Color Regarded As"; desc = "The color is regarded as the colorkey when Keymin <= Pixel <= Keymax."; };
            COLOR_REGARDED_AS_2 = 1 { name = "Color Regarded As 2"; desc = "The color is regarded as the colorkey when Pixel <= Keymin or Pixel >= Keymax."; };
        };

        field {
            name = "key_mode";
            desc = "Color key mode. Original (Chinese) data sheet, version 02, HCCTRL bit table ([15] RW key_mode).";
            sw = rw;
            hw = r;
            encode = HCCTRL_key_mode_enum;
            reset = 0x0;
        } key_mode[15:15];

        enum HCCTRL_key_en_enum {
            DISABLED = 0 { name = "Disabled"; desc = "disabled"; };
            ENABLED = 1 { name = "Enabled"; desc = "enabled"; };
        };

        field {
            name = "key_en";
            desc = "Colorkey enable. Original (Chinese) data sheet, version 02, HCCTRL bit table ([14] RW key_en).";
            sw = rw;
            hw = r;
            encode = HCCTRL_key_en_enum;
            reset = 0x0;
        } key_en[14:14];

        enum HCCTRL_bitext_enum {
            LOWER_BITS_STUFFED = 2 { name = "Lower Bits Stuffed"; desc = "lower bits stuffed with the MSB"; };
            LOWER_BITS_STUFFED_2 = 3 { name = "Lower Bits Stuffed 2"; desc = "lower bits stuffed with upper bits"; };
        };

        field {
            name = "bitext";
            desc = "Bit extend mode of the input bitmap. 0X: lower bits stuffed with 0s";
            sw = rw;
            hw = r;
            encode = HCCTRL_bitext_enum;
            reset = 0x0;
        } bitext[9:8];

        enum HCCTRL_ifmt_enum {
            ARGB1555 = 0x49 { name = "Argb1555"; desc = "ARGB1555"; };
            ARGB8888_OTHER_VALUES = 0x68 { name = "Argb8888 Other Values"; desc = "ARGB8888 Other values: reserved"; };
        };

        field {
            name = "ifmt";
            desc = "Input data format.";
            sw = rw;
            hw = r;
            encode = HCCTRL_ifmt_enum;
            reset = 0x0;
        } ifmt[7:0];
    } HCCTRL @ 0x9A00;

    reg {
        name = "HC update enable register";
        desc = "HCUPD is the HC channel update enable register.

Data sheet 11.2.4 HCUPD (offset 0x9A04, printed page 11-163, `datasheet.txt` line 42076).";

        field {
            name = "regup";
            desc = "Surface register update. After the registers at this layer are configured, the registers are updated when the value 1 is written to this bit. After updates, this bit is cleared automatically by the hardware";
            sw = rw;
            hw = r;
            reset = 0x0;
        } regup[0:0];
    } HCUPD @ 0x9A04;

    reg {
        name = "HC address register";
        desc = "HCADDR is the HC address register. When the horizontal pixel offsets, the address is calculated according to the description of HCSFPOS.

Data sheet 11.2.4 HCADDR (offset 0x9A08, printed page 11-163, `datasheet.txt` line 42103).";

        field {
            name = "surface_addr";
            desc = "Address of the surface frame buffer.";
            sw = rw;
            hw = r;
            reset = 0x0;
        } surface_addr[31:0];
    } HCADDR @ 0x9A08;

    reg {
        name = "HC stride register";
        desc = "HCSTRIDE is the HC stride register.

Data sheet 11.2.4 HCSTRIDE (offset 0x9A0C, printed page 11-164, `datasheet.txt` line 42132).";

        field {
            name = "surface_stride";
            desc = "Stride of the frame buffer.";
            sw = rw;
            hw = r;
            reset = 0x0;
        } surface_stride[15:0];
    } HCSTRIDE @ 0x9A0C;

    reg {
        name = "HC overlay parameter register";
        desc = "HCCBMPARA is the HC overlay parameter register (non-instant register).

Data sheet 11.2.4 HCCBMPARA (offset 0x9A10, printed page 11-164, `datasheet.txt` line 42153).";

        enum HCCBMPARA_key_mode_enum {
            COLOR_REGARDED_AS = 0 { name = "Color Regarded As"; desc = "The color is regarded as the colorkey when the following condition is met: Keymin <= Pixel <= Keymax"; };
            COLOR_REGARDED_AS_2 = 1 { name = "Color Regarded As 2"; desc = "The color is regarded as the colorkey when either of the following conditions is met: Pixel <= Keymin or Pixel >= Keymax"; };
        };

        field {
            name = "key_mode";
            desc = "Color key mode.";
            sw = rw;
            hw = r;
            encode = HCCBMPARA_key_mode_enum;
            reset = 0x0;
        } key_mode[15:15];

        enum HCCBMPARA_key_en_enum {
            DISABLED = 0 { name = "Disabled"; desc = "disabled"; };
            ENABLED = 1 { name = "Enabled"; desc = "enabled"; };
        };

        field {
            name = "key_en";
            desc = "Colorkey enable.";
            sw = rw;
            hw = r;
            encode = HCCBMPARA_key_en_enum;
            reset = 0x0;
        } key_en[14:14];

        enum HCCBMPARA_palpha_en_enum {
            DISABLED = 0 { name = "Disabled"; desc = "disabled"; };
            ENABLED = 1 { name = "Enabled"; desc = "enabled"; };
        };

        field {
            name = "palpha_en";
            desc = "Pixel alpha enable.";
            sw = rw;
            hw = r;
            encode = HCCBMPARA_palpha_en_enum;
            reset = 0x0;
        } palpha_en[12:12];

        enum HCCBMPARA_palpha_range_enum {
            ALPHA_0_128 = 0 { name = "Alpha 0 128"; desc = "The pixel alpha range is 0 to 128."; };
            ALPHA_0_255 = 1 { name = "Alpha 0 255"; desc = "The pixel alpha range is 0 to 255."; };
        };

        field {
            name = "palpha_range";
            desc = "Pixel alpha range.";
            sw = rw;
            hw = r;
            encode = HCCBMPARA_palpha_range_enum;
            reset = 0x0;
        } palpha_range[8:8];

        field {
            name = "galpha";
            desc = "Overlay global alpha value. This value ranges from 0 to 255. The value 255 indicates opaque, and the value 0 indicates full transparent.";
            sw = rw;
            hw = r;
            reset = 0x0;
        } galpha[7:0];
    } HCCBMPARA @ 0x9A10;

    reg {
        name = "HC maximum colorkey register";
        desc = "HCCKEYMAX is the HC maximum colorkey register (non-instant register).

Data sheet 11.2.4 HCCKEYMAX (offset 0x9A14, printed page 11-165, `datasheet.txt` line 42207).";

        field {
            name = "va0";
            desc = "Alpha0 value. When the data format is alphaRGB1555 and the alpha value is 0, the alpha0 value is used.";
            sw = rw;
            hw = r;
            reset = 0x0;
        } va0[31:24];

        field {
            name = "keyr_max";
            desc = "Maximum value of colorkey R component.";
            sw = rw;
            hw = r;
            reset = 0x0;
        } keyr_max[23:16];

        field {
            name = "keyg_max";
            desc = "Maximum value of colorkey G component.";
            sw = rw;
            hw = r;
            reset = 0x0;
        } keyg_max[15:8];

        field {
            name = "keyb_max";
            desc = "Maximum value of colorkey B component.";
            sw = rw;
            hw = r;
            reset = 0x0;
        } keyb_max[7:0];
    } HCCKEYMAX @ 0x9A14;

    reg {
        name = "HC minimum colorkey register";
        desc = "HCCKEYMIN is the HC minimum colorkey register (non-instant register).

Data sheet 11.2.4 HCCKEYMIN (offset 0x9A18, printed page 11-165, `datasheet.txt` line 42231).";

        field {
            name = "va1";
            desc = "Alpha1 value. When the data format is alphaRGB1555 and the alpha value is 1, the alpha1 value is used.";
            sw = rw;
            hw = r;
            reset = 0x0;
        } va1[31:24];

        field {
            name = "keyr_min";
            desc = "Minimum value of colorkey R component.";
            sw = rw;
            hw = r;
            reset = 0x0;
        } keyr_min[23:16];

        field {
            name = "keyg_min";
            desc = "Minimum value of colorkey G component.";
            sw = rw;
            hw = r;
            reset = 0x0;
        } keyg_min[15:8];

        field {
            name = "keyb_min";
            desc = "Minimum value of colorkey B component.";
            sw = rw;
            hw = r;
            reset = 0x0;
        } keyb_min[7:0];
    } HCCKEYMIN @ 0x9A18;

    reg {
        name = "HC colorkey mask register";
        desc = "HCCMASK is the HC colorkey mask register (non-instant register). When the corresponding bit is 1, the colorkey is compared. In this case, this bit can be ignored.

Data sheet 11.2.4 HCCMASK (offset 0x9A1C, printed page 11-166, `datasheet.txt` line 42266).";

        field {
            name = "kmsk_r";
            desc = "R component of colorkey mask.";
            sw = rw;
            hw = r;
            reset = 0x0;
        } kmsk_r[23:16];

        field {
            name = "kmsk_g";
            desc = "G component of colorkey mask.";
            sw = rw;
            hw = r;
            reset = 0x0;
        } kmsk_g[15:8];

        field {
            name = "kmsk_b";
            desc = "B component of colorkey mask.";
            sw = rw;
            hw = r;
            reset = 0x0;
        } kmsk_b[7:0];
    } HCCMASK @ 0x9A1C;

    reg {
        name = "HC input resolution register";
        desc = "HCIRESO is the HC input resolution register (non-instant register).

Data sheet 11.2.4 HCIRESO (offset 0x9A20, printed page 11-166, `datasheet.txt` line 42288).";

        field {
            name = "ih";
            desc = "Note: In interlaced output mode, the actual layer height must be an even number. There is no such limitation in progressive output mode.";
            sw = rw;
            hw = r;
            reset = 0x0;
        } ih[23:12];

        field {
            name = "iw";
            desc = "Width (in pixel). The value is the actual width minus 1. Note: The actual layer width must be an even number.";
            sw = rw;
            hw = r;
            reset = 0x0;
        } iw[11:0];
    } HCIRESO @ 0x9A20;

    reg {
        name = "HC surface start position (in the display window) register";
        desc = "HCDFPOS is the HC surface start position (in the display window) register (non-instant register). The start position is in the unit of pixel.

Data sheet 11.2.4 HCDFPOS (offset 0x9A2C, printed page 11-167, `datasheet.txt` line 42322).";

        field {
            name = "disp_yfpos";
            desc = "Column start coordinates.";
            sw = rw;
            hw = r;
            reset = 0x0;
        } disp_yfpos[23:12];

        field {
            name = "disp_xfpos";
            desc = "Row start coordinates.";
            sw = rw;
            hw = r;
            reset = 0x0;
        } disp_xfpos[11:0];
    } HCDFPOS @ 0x9A2C;

    reg {
        name = "HC surface end position (in the display window) register";
        desc = "HCDLPOS is the HC surface end position (in the display window) register (non-instant register). The end position is in the unit of pixel.

Data sheet 11.2.4 HCDLPOS (offset 0x9A30, printed page 11-167, `datasheet.txt` line 42344).";

        field {
            name = "disp_ylpos";
            desc = "Column end coordinates.";
            sw = rw;
            hw = r;
            reset = 0x0;
        } disp_ylpos[23:12];

        field {
            name = "disp_xlpos";
            desc = "Row end coordinates.";
            sw = rw;
            hw = r;
            reset = 0x0;
        } disp_xlpos[11:0];
    } HCDLPOS @ 0x9A30;

    reg {
        name = "HC input DC component register for CSC";
        desc = "HCCSCIDC is the HC input DC component register for CSC (instant register).

Data sheet 11.2.4 HCCSCIDC (offset 0x9AA0, printed page 11-168, `datasheet.txt` line 42375).";

        field {
            name = "csc_mode";
            desc = "csc_mode";
            sw = rw;
            hw = r;
            reset = 0x0;
        } csc_mode[28:28];

        field {
            name = "csc_en";
            desc = "CSC mode. 0: RGB2YUV 601 (SD) 1: RGB2YUV 709 (HD) CSC enable. 0: disabled 1: enabled";
            sw = rw;
            hw = r;
            reset = 0x0;
        } csc_en[27:27];

        field {
            name = "cscidc2";
            desc = "DC parameter of input component 2. The MSB is the signed bit. The value is expressed as the complement.";
            sw = rw;
            hw = r;
            reset = 0x0;
        } cscidc2[26:18];

        field {
            name = "cscidc1";
            desc = "DC parameter of input component 1. The MSB is the signed bit. The value is expressed as the complement.";
            sw = rw;
            hw = r;
            reset = 0x0;
        } cscidc1[17:9];

        field {
            name = "cscidc0";
            desc = "DC parameter of input component 0. The MSB is the signed bit. The value is expressed as the complement.";
            sw = rw;
            hw = r;
            reset = 0x0;
        } cscidc0[8:0];
    } HCCSCIDC @ 0x9AA0;

    reg {
        name = "HC output DC component register for CSC";
        desc = "HCCSCODC is the HC output DC component register for CSC (instant register).

Data sheet 11.2.4 HCCSCODC (offset 0x9AA4, printed page 11-168, `datasheet.txt` line 42415).";

        field {
            name = "cscodc2";
            desc = "DC parameter of output component 2. The MSB is the signed bit. The value is expressed as the complement.";
            sw = rw;
            hw = r;
            reset = 0x0;
        } cscodc2[26:18];

        field {
            name = "cscodc1";
            desc = "DC parameter of output component 1. The MSB is the signed bit. The value is expressed as the complement.";
            sw = rw;
            hw = r;
            reset = 0x0;
        } cscodc1[17:9];

        field {
            name = "cscodc0";
            desc = "DC parameter of output component 0. The MSB is the signed bit. The value is expressed as the complement.";
            sw = rw;
            hw = r;
            reset = 0x0;
        } cscodc0[8:0];
    } HCCSCODC @ 0x9AA4;

    reg {
        name = "HC CSC parameter 0 register";
        desc = "HCCSCP0 is the HC CSC parameter 0 register (instant register).

Data sheet 11.2.4 HCCSCP0 (offset 0x9AA8, printed page 11-169, `datasheet.txt` line 42452).";

        field {
            name = "cscp01";
            desc = "5.8 data format that consists of a 1-bit signed bit, a 4-bit integral part, and an 8-bit fractional part. The value is expressed as the complement.";
            sw = rw;
            hw = r;
            reset = 0x0;
        } cscp01[28:16];

        field {
            name = "cscp00";
            desc = "5.8 data format that consists of a 1-bit signed bit, a 4-bit integral part, and an 8-bit fractional part. The value is expressed as the complement.";
            sw = rw;
            hw = r;
            reset = 0x0;
        } cscp00[12:0];
    } HCCSCP0 @ 0x9AA8;

    reg {
        name = "HC CSC parameter 1 register";
        desc = "HCCSCP1 is the HC CSC parameter 1 register (instant register).

Data sheet 11.2.4 HCCSCP1 (offset 0x9AAC, printed page 11-169, `datasheet.txt` line 42484).";

        field {
            name = "cscp10";
            desc = "5.8 data format that consists of a 1-bit signed bit, a 4-bit integral part, and an 8-bit fractional part. The value is expressed as the complement.";
            sw = rw;
            hw = r;
            reset = 0x0;
        } cscp10[28:16];

        field {
            name = "cscp02";
            desc = "5.8 data format that consists of a 1-bit signed bit, a 4-bit integral part, and an 8-bit fractional part. The value is expressed as the complement.";
            sw = rw;
            hw = r;
            reset = 0x0;
        } cscp02[12:0];
    } HCCSCP1 @ 0x9AAC;

    reg {
        name = "HC CSC parameter 2 register";
        desc = "HCCSCP2 is the HC CSC parameter 2 register (instant register).

Data sheet 11.2.4 HCCSCP2 (offset 0x9AB0, printed page 11-170, `datasheet.txt` line 42526).";

        field {
            name = "cscp12";
            desc = "5.8 data format that consists of a 1-bit signed bit, a 4-bit integral part, and an 8-bit fractional part. The value is expressed as the complement.";
            sw = rw;
            hw = r;
            reset = 0x0;
        } cscp12[28:16];

        field {
            name = "cscp11";
            desc = "5.8 data format that consists of a 1-bit signed bit, a 4-bit integral part, and an 8-bit fractional part. The value is expressed as the complement.";
            sw = rw;
            hw = r;
            reset = 0x0;
        } cscp11[12:0];
    } HCCSCP2 @ 0x9AB0;

    reg {
        name = "HC CSC parameter 3 register";
        desc = "HCCSCP3 is the HC CSC parameter 3 register (instant register).

Data sheet 11.2.4 HCCSCP3 (offset 0x9AB4, printed page 11-171, `datasheet.txt` line 42568).";

        field {
            name = "cscp21";
            desc = "5.8 data format that consists of a 1-bit signed bit, a 4-bit integral part, and an 8-bit fractional part. The value is expressed as the complement.";
            sw = rw;
            hw = r;
            reset = 0x0;
        } cscp21[28:16];

        field {
            name = "cscp20";
            desc = "5.8 data format that consists of a 1-bit signed bit, a 4-bit integral part, and an 8-bit fractional part. The value is expressed as the complement.";
            sw = rw;
            hw = r;
            reset = 0x0;
        } cscp20[12:0];
    } HCCSCP3 @ 0x9AB4;

    reg {
        name = "HC CSC parameter 4 register";
        desc = "HCCSCP4 is the HC CSC parameter 4 register (instant register).

Data sheet 11.2.4 HCCSCP4 (offset 0x9AB8, printed page 11-171, `datasheet.txt` line 42600).";

        field {
            name = "cscp22";
            desc = "5.8 data format that consists of a 1-bit signed bit, a 4-bit integral part, and an 8-bit fractional part. The value is expressed as the complement.";
            sw = rw;
            hw = r;
            reset = 0x0;
        } cscp22[12:0];
    } HCCSCP4 @ 0x9AB8;

    reg {
        name = "HD0 overlay background color register";
        desc = "CBMBKG1 is the HD0 overlay background color register.

Data sheet 11.2.4 CBMBKG1 (offset 0x9E00, printed page 11-172, `datasheet.txt` line 42632).";

        field {
            name = "cbm_bkgy";
            desc = "Overlay background color of mixer 1, Y component.";
            sw = rw;
            hw = r;
            reset = 0x0;
        } cbm_bkgy[23:16];

        field {
            name = "cbm_bkgcb";
            desc = "Overlay background color of mixer 1, Cb component.";
            sw = rw;
            hw = r;
            reset = 0x0;
        } cbm_bkgcb[15:8];

        field {
            name = "cbm_bkgcr";
            desc = "Overlay background color of mixer 1, Cr component.";
            sw = rw;
            hw = r;
            reset = 0x0;
        } cbm_bkgcr[7:0];
    } CBMBKG1 @ 0x9E00;

    reg {
        name = "SD0 overlay background color register";
        desc = "CBMBKG3 is the SD0 overlay background color register.

Data sheet 11.2.4 CBMBKG3 (offset 0x9E08, printed page 11-172, `datasheet.txt` line 42654).";

        field {
            name = "cbm_bkgy";
            desc = "Overlay background color of mixer 3, Y component.";
            sw = rw;
            hw = r;
            reset = 0x0;
        } cbm_bkgy[23:16];

        field {
            name = "cbm_bkgcb";
            desc = "Overlay background color of mixer 3, Cb component.";
            sw = rw;
            hw = r;
            reset = 0x0;
        } cbm_bkgcb[15:8];

        field {
            name = "cbm_bkgcr";
            desc = "Overlay background color of mixer 3, Cr component.";
            sw = rw;
            hw = r;
            reset = 0x0;
        } cbm_bkgcr[7:0];
    } CBMBKG3 @ 0x9E08;

    reg {
        name = "SD1 overlay background color register";
        desc = "CBMBKG4 is the SD1 overlay background color register.

Data sheet 11.2.4 CBMBKG4 (offset 0x9E0C, printed page 11-173, `datasheet.txt` line 42686).";

        field {
            name = "cbm_bkgy";
            desc = "Overlay background color of mixer 4, Y component.";
            sw = rw;
            hw = r;
            reset = 0x0;
        } cbm_bkgy[23:16];

        field {
            name = "cbm_bkgcb";
            desc = "Overlay background color of mixer 4, Cb component.";
            sw = rw;
            hw = r;
            reset = 0x0;
        } cbm_bkgcb[15:8];

        field {
            name = "cbm_bkgcr";
            desc = "Overlay background color of mixer 4, Cr component.";
            sw = rw;
            hw = r;
            reset = 0x0;
        } cbm_bkgcr[7:0];
    } CBMBKG4 @ 0x9E0C;

    reg {
        name = "Crossbar configuration register";
        desc = "CBMATTR is a crossbar configuration register. sur_attr_x indicates that layer X is bound to mixer 1 or mixer 2.

Data sheet 11.2.4 CBMATTR (offset 0x9E10, printed page 11-173, `datasheet.txt` line 42709).";

        enum CBMATTR_sur_attr1_enum {
            MIXER_1_DHD = 0 { name = "Mixer 1 Dhd"; desc = "mixer 1 for DHD"; };
            MIXER_3_DSD = 1 { name = "Mixer 3 Dsd"; desc = "mixer 3 for DSD"; };
            MIXER_4_DSD1 = 2 { name = "Mixer 4 Dsd1"; desc = "mixer 4 for DSD1 Other values: reserved"; };
        };

        field {
            name = "sur_attr1";
            desc = "HC0 link.";
            sw = rw;
            hw = r;
            encode = CBMATTR_sur_attr1_enum;
            reset = 0x0;
        } sur_attr1[7:4];

        enum CBMATTR_sur_attr0_enum {
            MIXER_1_DHD = 0 { name = "Mixer 1 Dhd"; desc = "mixer 1 for DHD"; };
            MIXER_3_DSD = 1 { name = "Mixer 3 Dsd"; desc = "mixer 3 for DSD Other values: reserved"; };
        };

        field {
            name = "sur_attr0";
            desc = "VSD link. Reset value 0x1 (mixer 3 for DSD) per the data sheet total reset value 0x00000001 (issue 02).";
            sw = rw;
            hw = r;
            encode = CBMATTR_sur_attr0_enum;
            reset = 0x1;
        } sur_attr0[3:0];
    } CBMATTR @ 0x9E10;

    reg {
        name = "Mixer 1 priority configuration register";
        desc = "CBMMIX1 is the mixer 1 priority configuration register (non-instant register). The register configuration takes effect only when the VSYNC signal is valid.

Data sheet 11.2.4 CBMMIX1 (offset 0x9E14, printed page 11-174, `datasheet.txt` line 42746).";

        enum CBMMIX1_mixer_prio3_enum {
            NO_OVERLAY_LAYER = 0 { name = "No Overlay Layer"; desc = "no overlay layer"; };
            VHD = 1 { name = "Vhd"; desc = "VHD"; };
            VSD = 4 { name = "Vsd"; desc = "VSD"; };
            G0 = 9 { name = "G0"; desc = "G0"; };
            HC0_OTHER_VALUES = 14 { name = "Hc0 Other Values"; desc = "HC0 Other values: reserved"; };
        };

        field {
            name = "mixer_prio3";
            desc = "Priority 3 of the overlay layer of mixer 1.";
            sw = rw;
            hw = r;
            encode = CBMMIX1_mixer_prio3_enum;
            reset = 0x0;
        } mixer_prio3[15:12];

        enum CBMMIX1_mixer_prio2_enum {
            NO_OVERLAY_LAYER = 0 { name = "No Overlay Layer"; desc = "no overlay layer"; };
            VHD = 1 { name = "Vhd"; desc = "VHD"; };
            VSD = 4 { name = "Vsd"; desc = "VSD"; };
            G0 = 9 { name = "G0"; desc = "G0"; };
            HC0_OTHER_VALUES = 14 { name = "Hc0 Other Values"; desc = "HC0 Other values: reserved"; };
        };

        field {
            name = "mixer_prio2";
            desc = "Priority 2 of the overlay layer of mixer 1.";
            sw = rw;
            hw = r;
            encode = CBMMIX1_mixer_prio2_enum;
            reset = 0x0;
        } mixer_prio2[11:8];

        enum CBMMIX1_mixer_prio1_enum {
            NO_OVERLAY_LAYER = 0 { name = "No Overlay Layer"; desc = "no overlay layer"; };
            VHD = 1 { name = "Vhd"; desc = "VHD"; };
            VSD = 4 { name = "Vsd"; desc = "VSD"; };
            G0 = 9 { name = "G0"; desc = "G0"; };
            HC0_OTHER_VALUES = 14 { name = "Hc0 Other Values"; desc = "HC0 Other values: reserved"; };
        };

        field {
            name = "mixer_prio1";
            desc = "Priority 1 of the overlay layer of mixer 1.";
            sw = rw;
            hw = r;
            encode = CBMMIX1_mixer_prio1_enum;
            reset = 0x0;
        } mixer_prio1[7:4];

        enum CBMMIX1_mixer_prio0_enum {
            NO_OVERLAY_LAYER = 0 { name = "No Overlay Layer"; desc = "no overlay layer"; };
            VHD = 1 { name = "Vhd"; desc = "VHD"; };
            VSD = 4 { name = "Vsd"; desc = "VSD"; };
            G0 = 9 { name = "G0"; desc = "G0"; };
            HC0_OTHER_VALUES = 14 { name = "Hc0 Other Values"; desc = "HC0 Other values: reserved"; };
        };

        field {
            name = "mixer_prio0";
            desc = "Priority 0 of the overlay layer of mixer 1.";
            sw = rw;
            hw = r;
            encode = CBMMIX1_mixer_prio0_enum;
            reset = 0x0;
        } mixer_prio0[3:0];
    } CBMMIX1 @ 0x9E14;

    reg {
        name = "Mixer 3 priority configuration register";
        desc = "CBMMIX3 is the mixer 3 priority configuration register (non-instant register). The register configuration takes effect only when the VSYNC signal is valid.

Data sheet 11.2.4 CBMMIX3 (offset 0x9E1C, printed page 11-175, `datasheet.txt` line 42802).";

        enum CBMMIX3_mixer_prio2_enum {
            NO_OVERLAY_LAYER = 0 { name = "No Overlay Layer"; desc = "no overlay layer"; };
            VSD = 4 { name = "Vsd"; desc = "VSD"; };
            G2 = 11 { name = "G2"; desc = "G2"; };
            HC0_OTHER_VALUES = 14 { name = "Hc0 Other Values"; desc = "HC0 Other values: reserved"; };
        };

        field {
            name = "mixer_prio2";
            desc = "Priority 2 of the overlay layer of mixer 3.";
            sw = rw;
            hw = r;
            encode = CBMMIX3_mixer_prio2_enum;
            reset = 0x0;
        } mixer_prio2[11:8];

        enum CBMMIX3_mixer_prio1_enum {
            NO_OVERLAY_LAYER = 0 { name = "No Overlay Layer"; desc = "no overlay layer"; };
            VSD = 4 { name = "Vsd"; desc = "VSD"; };
            G2 = 11 { name = "G2"; desc = "G2"; };
            G4 = 13 { name = "G4"; desc = "G4"; };
            HC0_OTHER_VALUES = 14 { name = "Hc0 Other Values"; desc = "HC0 Other values: reserved"; };
        };

        field {
            name = "mixer_prio1";
            desc = "Priority 1 of the overlay layer of mixer 3.";
            sw = rw;
            hw = r;
            encode = CBMMIX3_mixer_prio1_enum;
            reset = 0x0;
        } mixer_prio1[7:4];

        enum CBMMIX3_mixer_prio0_enum {
            NO_OVERLAY_LAYER = 0 { name = "No Overlay Layer"; desc = "no overlay layer"; };
            VSD = 4 { name = "Vsd"; desc = "VSD"; };
            G2 = 11 { name = "G2"; desc = "G2"; };
            HC0_OTHER_VALUES = 14 { name = "Hc0 Other Values"; desc = "HC0 Other values: reserved"; };
        };

        field {
            name = "mixer_prio0";
            desc = "Priority 0 of the overlay layer of mixer 3.";
            sw = rw;
            hw = r;
            encode = CBMMIX3_mixer_prio0_enum;
            reset = 0x0;
        } mixer_prio0[3:0];
    } CBMMIX3 @ 0x9E1C;

    reg {
        name = "Mixer 4 priority configuration register";
        desc = "CBMMIX4 is the mixer 4 priority configuration register (non-instant register). The register configuration takes effect only when the VSYNC signal is valid.

Data sheet 11.2.4 CBMMIX4 (offset 0x9E20, printed page 11-176, `datasheet.txt` line 42853).";

        enum CBMMIX4_mixer_prio2_enum {
            NO_OVERLAY_LAYER = 0 { name = "No Overlay Layer"; desc = "no overlay layer"; };
            VSD1 = 5 { name = "Vsd1"; desc = "VSD1"; };
            G3 = 12 { name = "G3"; desc = "G3"; };
            HC0 = 14 { name = "Hc0"; desc = "HC0"; };
            HC1_OTHER_VALUES = 15 { name = "Hc1 Other Values"; desc = "HC1 Other values: reserved"; };
        };

        field {
            name = "mixer_prio2";
            desc = "Priority 2 of the overlay layer of mixer 4.";
            sw = rw;
            hw = r;
            encode = CBMMIX4_mixer_prio2_enum;
            reset = 0x0;
        } mixer_prio2[11:8];

        enum CBMMIX4_mixer_prio1_enum {
            NO_OVERLAY_LAYER = 0 { name = "No Overlay Layer"; desc = "no overlay layer"; };
            VSD1 = 5 { name = "Vsd1"; desc = "VSD1"; };
            G3 = 12 { name = "G3"; desc = "G3"; };
            HC0_OTHER_VALUES = 14 { name = "Hc0 Other Values"; desc = "HC0 Other values: reserved"; };
        };

        field {
            name = "mixer_prio1";
            desc = "Priority 1 of the overlay layer of mixer 4.";
            sw = rw;
            hw = r;
            encode = CBMMIX4_mixer_prio1_enum;
            reset = 0x0;
        } mixer_prio1[7:4];

        enum CBMMIX4_mixer_prio0_enum {
            NO_OVERLAY_LAYER = 0 { name = "No Overlay Layer"; desc = "no overlay layer"; };
            VSD1 = 5 { name = "Vsd1"; desc = "VSD1"; };
            G3 = 12 { name = "G3"; desc = "G3"; };
            HC0_OTHER_VALUES = 14 { name = "Hc0 Other Values"; desc = "HC0 Other values: reserved"; };
        };

        field {
            name = "mixer_prio0";
            desc = "Priority 0 of the overlay layer of mixer 4.";
            sw = rw;
            hw = r;
            encode = CBMMIX4_mixer_prio0_enum;
            reset = 0x0;
        } mixer_prio0[3:0];
    } CBMMIX4 @ 0x9E20;

    reg {
        name = "DHD global control register";
        desc = "DHD global control register.

Data sheet 11.2.4 DHDCTRL (offset 0xA000, printed page 11-177, `datasheet.txt` line 42909).";

        enum DHDCTRL_intf_en_enum {
            DISABLED = 0 { name = "Disabled"; desc = "disabled"; };
            ENABLED = 1 { name = "Enabled"; desc = "enabled"; };
        };

        field {
            name = "intf_en";
            desc = "Display interface enable (instant field). Data is output over the interface only when this field is enabled.";
            sw = rw;
            hw = r;
            encode = DHDCTRL_intf_en_enum;
            reset = 0x0;
        } intf_en[31:31];

        enum DHDCTRL_clipen_enum {
            DISABLED = 0 { name = "Disabled"; desc = "disabled"; };
            ENABLED = 1 { name = "Enabled"; desc = "enabled"; };
        };

        field {
            name = "clipen";
            desc = "Output clip enable (instant field).";
            sw = rw;
            hw = r;
            encode = DHDCTRL_clipen_enum;
            reset = 0x1;
        } clipen[16:16];

        enum DHDCTRL_gmmen_enum {
            DISABLED = 0 { name = "Disabled"; desc = "disabled"; };
            ENABLED = 1 { name = "Enabled"; desc = "enabled"; };
        };

        field {
            name = "gmmen";
            desc = "Not in the Hi3520D data sheet (version 02), which lists DHDCTRL bits [15:11] as reserved; vendor header. Output gamma correction enable (instant field).";
            sw = rw;
            hw = r;
            encode = DHDCTRL_gmmen_enum;
            reset = 0x0;
        } gmmen[14:14];

        enum DHDCTRL_gmmmode_enum {
            GAMMA_TABLE_GENERATED = 0 { name = "Gamma Table Generated"; desc = "The gamma table is generated by hardware."; };
            GAMMA_TABLE_CONFIGURED = 1 { name = "Gamma Table Configured"; desc = "The gamma table is configured by software."; };
        };

        field {
            name = "gmmmode";
            desc = "Not in the Hi3520D data sheet (version 02, DHDCTRL [15:11] reserved); vendor header. Output gamma correction mode (instant field).";
            sw = rw;
            hw = r;
            encode = DHDCTRL_gmmmode_enum;
            reset = 0x0;
        } gmmmode[13:13];

        enum DHDCTRL_idv_enum {
            DISABLED = 0 { name = "Disabled"; desc = "disabled"; };
            ENABLED = 1 { name = "Enabled"; desc = "enabled"; };
        };

        field {
            name = "idv";
            desc = "Output phase reverse enable for the data valid signal (instant field).";
            sw = rw;
            hw = r;
            encode = DHDCTRL_idv_enum;
            reset = 0x0;
        } idv[10:10];

        enum DHDCTRL_ihs_enum {
            DISABLED = 0 { name = "Disabled"; desc = "disabled"; };
            ENABLED = 1 { name = "Enabled"; desc = "enabled"; };
        };

        field {
            name = "ihs";
            desc = "Output phase reverse enable for the horizontal sync pulse (instant field).";
            sw = rw;
            hw = r;
            encode = DHDCTRL_ihs_enum;
            reset = 0x0;
        } ihs[9:9];

        enum DHDCTRL_ivs_enum {
            DISABLED = 0 { name = "Disabled"; desc = "disabled"; };
            ENABLED = 1 { name = "Enabled"; desc = "enabled"; };
        };

        field {
            name = "ivs";
            desc = "Output phase reverse enable for the vertical sync pulse (instant field).";
            sw = rw;
            hw = r;
            encode = DHDCTRL_ivs_enum;
            reset = 0x0;
        } ivs[8:8];

        enum DHDCTRL_iop_enum {
            INTERLACED_DISPLAY = 0 { name = "Interlaced Display"; desc = "interlaced display"; };
            PROGRESSIVE_DISPLAY = 1 { name = "Progressive Display"; desc = "progressive display"; };
        };

        field {
            name = "iop";
            desc = "Progressive or interlaced display (instant field).";
            sw = rw;
            hw = r;
            encode = DHDCTRL_iop_enum;
            reset = 0x0;
        } iop[7:7];

        enum DHDCTRL_synm_enum {
            TIMING_LABEL_MODE = 0 { name = "Timing Label Mode"; desc = "timing label mode (such as BT.656)"; };
            SYNC_SIGNAL_MODE = 1 { name = "Sync Signal Mode"; desc = "sync signal mode (such as LCD display)"; };
        };

        field {
            name = "synm";
            desc = "Sync mode (instant field).";
            sw = rw;
            hw = r;
            encode = DHDCTRL_synm_enum;
            reset = 0x0;
        } synm[6:6];

        enum DHDCTRL_intfb_enum {
            SINGLE_COMPONENT_MODE = 0 { name = "Single Component Mode"; desc = "single-component mode (each clock outputs one component)"; };
            V_2_COMPONENT_MODE = 1 { name = "V 2 Component Mode"; desc = "2-component mode (each clock outputs two components)"; };
            V_3_COMPONENT_MODE = 2 { name = "V 3 Component Mode"; desc = "3-component mode (each clock outputs three components)"; };
            RESERVED = 3 { name = "Reserved"; desc = "reserved"; };
        };

        field {
            name = "intfb";
            desc = "Bit width mode of the output interface (instant field).";
            sw = rw;
            hw = r;
            encode = DHDCTRL_intfb_enum;
            reset = 0x1;
        } intfb[5:4];

        enum DHDCTRL_intfdm_enum {
            YCBCR422_0X1_0XB = 0 { name = "Ycbcr422 0X1 0Xb"; desc = "YCbCr422 0x1-0xB: invalid"; };
            RGB888_YCBCR444_OUTPUT = 12 { name = "Rgb888 Ycbcr444 Output"; desc = "RGB888/YCbCr444 output Other values: invalid"; };
        };

        field {
            name = "intfdm";
            desc = "Interface data format (instant field).";
            sw = rw;
            hw = r;
            encode = DHDCTRL_intfdm_enum;
            reset = 0x0;
        } intfdm[3:0];
    } DHDCTRL @ 0xA000;

    reg {
        name = "DHD vertical timing register";
        desc = "DHDVSYNC is the DHD vertical timing register. In interlaced output mode, this register indicates the top vertical sync timing; in progressive output mode, this register indicates the frame vertical sync timing. The setting of this register takes effect immediately after configuration. That is, the timing of the VSYNC pin is affected immediately. You must configure this register before configuring DHDCTRL[intf_en]. Otherwise, the configuration does not take effect.

Data sheet 11.2.4 DHDVSYNC (offset 0xA004, printed page 11-178, `datasheet.txt` line 43003).";

        field {
            name = "vfb";
            desc = "In interlaced output mode: top vertical front blanking (TVFB) In progressive output mode: vertical front blanking (VFB) Unit: line";
            sw = rw;
            hw = r;
            reset = 0x1;
        } vfb[27:20];

        field {
            name = "vbb";
            desc = "In interlaced output mode: top vertical back blanking (TVBB) In progressive output mode: vertical back blanking (VBB) + vertical pulse width (VPW) Unit: line";
            sw = rw;
            hw = r;
            reset = 0x13;
        } vbb[19:12];

        field {
            name = "vact";
            desc = "In interlaced output mode: height of an active picture in the top field In progressive output format: height of an active picture in a frame. The register value is the actual value minus 1. Unit: line";
            sw = rw;
            hw = r;
            reset = 0x21B;
        } vact[11:0];
    } DHDVSYNC @ 0xA004;

    reg {
        name = "DHD horizontal timing register 1";
        desc = "DHDHSYNC1 is DHD horizontal timing register 1. In interlaced or progressive output mode, this register is the horizontal sync timing configuration register. The setting of this register takes effect immediately after configuration. That is, the timing of the HSYNC pin is affected immediately. You must configure this register before configuring DHDCTRL[intf_en]. Otherwise, the configuration does not take effect.

Data sheet 11.2.4 DHDHSYNC1 (offset 0xA008, printed page 11-179, `datasheet.txt` line 43056).";

        field {
            name = "hbb";
            desc = "Horizontal back blanking (HBB). Unit: pixel";
            sw = rw;
            hw = r;
            reset = 0xBF;
        } hbb[31:16];

        field {
            name = "hact";
            desc = "Number of horizontal pixels in an active region.";
            sw = rw;
            hw = r;
            reset = 0x77F;
        } hact[15:0];
    } DHDHSYNC1 @ 0xA008;

    reg {
        name = "DHD horizontal timing register 2";
        desc = "DHDHSYNC2 is DHD horizontal timing register 2. In interlaced or progressive output mode, this register is the horizontal sync timing configuration register. The setting of this register takes effect immediately after configuration. That is, the timing of the HSYNC pin is affected immediately. You must configure this register before configuring DHDCTRL[intf_en]. Otherwise, the configuration does not take effect.

Data sheet 11.2.4 DHDHSYNC2 (offset 0xA00C, printed page 11-180, `datasheet.txt` line 43096).";

        field {
            name = "hmid";
            desc = "Width of the bottom vertical sync valid signal (in pixel).";
            sw = rw;
            hw = r;
            reset = 0x0;
        } hmid[31:16];

        field {
            name = "hfb";
            desc = "Horizontal front blanking (HFB). Unit: pixel";
            sw = rw;
            hw = r;
            reset = 0x20F;
        } hfb[15:0];
    } DHDHSYNC2 @ 0xA00C;

    reg {
        name = "DHD interlaced bottom vertical timing register";
        desc = "DHD interlaced bottom vertical timing register.

Data sheet 11.2.4 DHDVPLUS (offset 0xA010, printed page 11-181, `datasheet.txt` line 43135).";

        field {
            name = "bvfb";
            desc = "In interlaced output mode: bottom vertical front blanking (BVFB) Unit: line";
            sw = rw;
            hw = r;
            reset = 0x2;
        } bvfb[27:20];

        field {
            name = "bvbb";
            desc = "In interlaced output mode: bottom vertical back blanking (BVBB) + VPW Unit: line";
            sw = rw;
            hw = r;
            reset = 0x13;
        } bvbb[19:12];

        field {
            name = "bvact";
            desc = "In interlaced output mode: height of an active picture in the bottom field. The register value is the actual value minus 1. Unit: line";
            sw = rw;
            hw = r;
            reset = 0x21B;
        } bvact[11:0];
    } DHDVPLUS @ 0xA010;

    reg {
        name = "DHD sync signal pulse with register";
        desc = "DHDPWR is the DHD sync signal pulse width register. You must configure this register before configuring DHDCTRL[intf_en]. Otherwise, the configuration does not take effect.

Data sheet 11.2.4 DHDPWR (offset 0xA014, printed page 11-181, `datasheet.txt` line 43171).";

        field {
            name = "vpw";
            desc = "VPW minus 1. Unit: pixel";
            sw = rw;
            hw = r;
            reset = 0x0;
        } vpw[23:16];

        field {
            name = "hpw";
            desc = "Horizontal pulse width (HPW) minus 1. Unit: pixel";
            sw = rw;
            hw = r;
            reset = 0x0;
        } hpw[15:0];
    } DHDPWR @ 0xA014;

    reg {
        name = "DHD vertical timing threshold register";
        desc = "DHDVTTHD is the DHD vertical timing threshold register (instant register). It can be used to set two thresholds for generating two interrupts separately.

Data sheet 11.2.4 DHDVTTHD (offset 0xA01C, printed page 11-182, `datasheet.txt` line 43208).";

        enum DHDVTTHD_thd1_mode_enum {
            FRAME_MODE_THRESHOLD = 0 { name = "Frame Mode Threshold"; desc = "frame mode. The threshold count is in the unit of frame."; };
            FIELD_MODE_THRESHOLD = 1 { name = "Field Mode Threshold"; desc = "field mode. The threshold count is in the unit of field in interlaced display mode."; };
        };

        field {
            name = "thd1_mode";
            desc = "Threshold 1 interrupt generation mode.";
            sw = rw;
            hw = r;
            encode = DHDVTTHD_thd1_mode_enum;
            reset = 0x0;
        } thd1_mode[15:15];

        field {
            name = "vtmgthd1";
            desc = "Vertical timing threshold 1. When the vertical timing counter reaches this threshold, the VOINTSTA[dhdvtthd_int1] interrupt is triggered.";
            sw = rw;
            hw = r;
            reset = 0x1;
        } vtmgthd1[12:0];
    } DHDVTTHD @ 0xA01C;

    reg {
        name = "DHD clip lower threshold register";
        desc = "DHDCLIPL is the DHD clip lower threshold register (instant register).

Data sheet 11.2.4 DHDCLIPL (offset 0xA040, printed page 11-183, `datasheet.txt` line 43252).";

        enum DHDCLIPL_clipen_enum {
            DISABLED = 0 { name = "Disabled"; desc = "disabled"; };
            ENABLED = 1 { name = "Enabled"; desc = "enabled"; };
        };

        field {
            name = "clipen";
            desc = "Clip enable.";
            sw = rw;
            hw = r;
            encode = DHDCLIPL_clipen_enum;
            reset = 0x0;
        } clipen[31:31];

        enum DHDCLIPL_dfir_en_enum {
            DISABLED = 0 { name = "Disabled"; desc = "disabled"; };
            ENABLED = 1 { name = "Enabled"; desc = "enabled"; };
        };

        field {
            name = "dfir_en";
            desc = "Horizontal chrominance down scaling enable.";
            sw = rw;
            hw = r;
            encode = DHDCLIPL_dfir_en_enum;
            reset = 0x1;
        } dfir_en[30:30];

        field {
            name = "clipcl2";
            desc = "Lower threshold Y/R of component 2, unsigned integer.";
            sw = rw;
            hw = r;
            reset = 0x10;
        } clipcl2[29:20];

        field {
            name = "clipcl1";
            desc = "Lower threshold Cb/G of component 1, unsigned integer.";
            sw = rw;
            hw = r;
            reset = 0x10;
        } clipcl1[19:10];

        field {
            name = "clipcl0";
            desc = "Lower threshold Cr/B of component 0, unsigned integer.";
            sw = rw;
            hw = r;
            reset = 0x10;
        } clipcl0[9:0];
    } DHDCLIPL @ 0xA040;

    reg {
        name = "DHD clip upper threshold register";
        desc = "DHDCLIPH is the DHD clip upper threshold register (instant register). For example, the output data needs to be clipped in BT.656 output mode.

Data sheet 11.2.4 DHDCLIPH (offset 0xA044, printed page 11-183, `datasheet.txt` line 43285).";

        field {
            name = "clipch2";
            desc = "Upper threshold Y/R of component 2, unsigned integer.";
            sw = rw;
            hw = r;
            reset = 0xEB;
        } clipch2[29:20];

        field {
            name = "clipch1";
            desc = "Upper threshold Cb/G of component 1, unsigned integer.";
            sw = rw;
            hw = r;
            reset = 0x0;
        } clipch1[19:10];

        field {
            name = "clipch0";
            desc = "Upper threshold Cr/B of component 0, unsigned integer.";
            sw = rw;
            hw = r;
            reset = 0xF0;
        } clipch0[9:0];
    } DHDCLIPH @ 0xA044;

    reg {
        name = "DHD clip lower threshold register (instant register)";
        desc = "DHDVGACLIPL is a DHD clip lower threshold register (instant register).

Data sheet 11.2.4 DHDVGACLIPL (offset 0xA060, printed page 11-184, `datasheet.txt` line 43322).";

        enum DHDVGACLIPL_clipen_enum {
            DISABLED = 0 { name = "Disabled"; desc = "disabled"; };
            ENABLED = 1 { name = "Enabled"; desc = "enabled"; };
        };

        field {
            name = "clipen";
            desc = "Clip enable.";
            sw = rw;
            hw = r;
            encode = DHDVGACLIPL_clipen_enum;
            reset = 0x0;
        } clipen[31:31];

        field {
            name = "reserved_nz";
            desc = "Reserved (RO); reads 1: the data sheet total reset value is 0x4401_0040.";
            sw = r;
            hw = w;
            reset = 0x1;
        } reserved_nz[30:30];

        field {
            name = "clipcl2";
            desc = "Lower threshold Y/R of component 2, unsigned integer.";
            sw = rw;
            hw = r;
            reset = 0x40;
        } clipcl2[29:20];

        field {
            name = "clipcl1";
            desc = "Lower threshold Cb/G of component 1, unsigned integer.";
            sw = rw;
            hw = r;
            reset = 0x40;
        } clipcl1[19:10];

        field {
            name = "clipcl0";
            desc = "Lower threshold Cr/B of component 0, unsigned integer.";
            sw = rw;
            hw = r;
            reset = 0x40;
        } clipcl0[9:0];
    } DHDVGACLIPL @ 0xA060;

    reg {
        name = "DHD clip upper threshold register (instant register)";
        desc = "DHDVGACLIPH is a DHD clip upper threshold register (instant register). For example, the output data needs to be clipped in BT.656 output mode.

Data sheet 11.2.4 DHDVGACLIPH (offset 0xA064, printed page 11-184, `datasheet.txt` line 43352).";

        field {
            name = "clipch2";
            desc = "Upper threshold Y/R of component 2, unsigned integer.";
            sw = rw;
            hw = r;
            reset = 0x3AC;
        } clipch2[29:20];

        field {
            name = "clipch1";
            desc = "Upper threshold Cb/G of component 1, unsigned integer.";
            sw = rw;
            hw = r;
            reset = 0x3C0;
        } clipch1[19:10];

        field {
            name = "clipch0";
            desc = "Upper threshold Cr/B of component 0, unsigned integer.";
            sw = rw;
            hw = r;
            reset = 0x3C0;
        } clipch0[9:0];
    } DHDVGACLIPH @ 0xA064;

    reg {
        name = "Sharpen configuration register 0 for VGA channel H";
        desc = "DHDHSPCFG0 is sharpen configuration register 0 for VGA channel H.

Data sheet 11.2.4 DHDHSPCFG0 (offset 0xA080, printed page 11-185, `datasheet.txt` line 43390).";

        field {
            name = "hsp_hf0_tmp3";
            desc = "High-frequency filtering coefficient 3, signed number.";
            sw = rw;
            hw = r;
            reset = 0x0;
        } hsp_hf0_tmp3[31:24];

        field {
            name = "hsp_hf0_tmp2";
            desc = "High-frequency filtering coefficient 2, signed number.";
            sw = rw;
            hw = r;
            reset = 0x0;
        } hsp_hf0_tmp2[23:16];

        field {
            name = "hsp_hf0_tmp1";
            desc = "High-frequency filtering coefficient 1, signed number.";
            sw = rw;
            hw = r;
            reset = 0x0;
        } hsp_hf0_tmp1[15:8];

        field {
            name = "hsp_hf0_tmp0";
            desc = "High-frequency filtering coefficient 0, signed number.";
            sw = rw;
            hw = r;
            reset = 0x0;
        } hsp_hf0_tmp0[7:0];
    } DHDHSPCFG0 @ 0xA080;

    reg {
        name = "Sharpen configuration register 1 for VGA channel H";
        desc = "DHDHSPCFG1 is sharpen configuration register 1 for VGA channel H.

Data sheet 11.2.4 DHDHSPCFG1 (offset 0xA084, printed page 11-185, `datasheet.txt` line 43412).";

        field {
            name = "hsp_en";
            desc = "Horizontal sharpen enable.";
            sw = rw;
            hw = r;
            reset = 0x0;
        } hsp_en[31:31];

        field {
            name = "hsp_hf0_coring";
            desc = "High-frequency coring coefficient, unsigned number.";
            sw = rw;
            hw = r;
            reset = 0x0;
        } hsp_hf0_coring[7:0];
    } DHDHSPCFG1 @ 0xA084;

    reg {
        name = "Sharpen configuration register 5 for VGA channel H";
        desc = "DHDHSPCFG5 is sharpen configuration register 5 for VGA channel H.

Data sheet 11.2.4 DHDHSPCFG5 (offset 0xA094, printed page 11-186, `datasheet.txt` line 43441).";

        field {
            name = "hsp_hf0_gainneg";
            desc = "High-frequency gain negative polarity coefficient, signed number (10.8).";
            sw = rw;
            hw = r;
            reset = 0x0;
        } hsp_hf0_gainneg[26:16];

        field {
            name = "hsp_hf0_gainpos";
            desc = "High-frequency gain positive polarity coefficient, signed number (10.8).";
            sw = rw;
            hw = r;
            reset = 0x0;
        } hsp_hf0_gainpos[10:0];
    } DHDHSPCFG5 @ 0xA094;

    reg {
        name = "Sharpen configuration register 6 for VGA channel H";
        desc = "DHDHSPCFG6 is sharpen configuration register 6 for VGA channel H.

Data sheet 11.2.4 DHDHSPCFG6 (offset 0xA098, printed page 11-186, `datasheet.txt` line 43467).";

        field {
            name = "hsp_hf0_adpshoot_en";
            desc = "High-frequency adjustment threshold enable.";
            sw = rw;
            hw = r;
            reset = 0x0;
        } hsp_hf0_adpshoot_en[31:31];

        field {
            name = "hsp_hf0_winsize";
            desc = "High-frequency window size, unsigned number. The value range is 0-4.";
            sw = rw;
            hw = r;
            reset = 0x0;
        } hsp_hf0_winsize[30:28];

        field {
            name = "hsp_hf0_mixratio";
            desc = "High-frequency adjustment threshold ratio, unsigned number (8.7).";
            sw = rw;
            hw = r;
            reset = 0x0;
        } hsp_hf0_mixratio[23:16];

        field {
            name = "hsp_hf0_underth";
            desc = "High-frequency adjustment lower threshold, unsigned number.";
            sw = rw;
            hw = r;
            reset = 0x0;
        } hsp_hf0_underth[15:8];

        field {
            name = "hsp_hf0_overth";
            desc = "High-frequency adjustment upper threshold, unsigned number.";
            sw = rw;
            hw = r;
            reset = 0x0;
        } hsp_hf0_overth[7:0];
    } DHDHSPCFG6 @ 0xA098;

    reg {
        name = "Sharpen configuration register 7 for VGA channel H";
        desc = "DHDHSPCFG7 is sharpen configuration register 7 for VGA channel H.

Data sheet 11.2.4 DHDHSPCFG7 (offset 0xA09C, printed page 11-187, `datasheet.txt` line 43514).";

        field {
            name = "hsp_hf1_tmp3";
            desc = "High-frequency filtering coefficient 3, signed number.";
            sw = rw;
            hw = r;
            reset = 0x0;
        } hsp_hf1_tmp3[31:24];

        field {
            name = "hsp_hf1_tmp2";
            desc = "High-frequency filtering coefficient 2, signed number.";
            sw = rw;
            hw = r;
            reset = 0x0;
        } hsp_hf1_tmp2[23:16];

        field {
            name = "hsp_hf1_tmp1";
            desc = "High-frequency filtering coefficient 1, signed number.";
            sw = rw;
            hw = r;
            reset = 0x0;
        } hsp_hf1_tmp1[15:8];

        field {
            name = "hsp_hf1_tmp0";
            desc = "High-frequency filtering coefficient 0, signed number.";
            sw = rw;
            hw = r;
            reset = 0x0;
        } hsp_hf1_tmp0[7:0];
    } DHDHSPCFG7 @ 0xA09C;

    reg {
        name = "Sharpen configuration register 8 for VGA channel H";
        desc = "DHDHSPCFG8 is sharpen configuration register 8 for VGA channel H.

Data sheet 11.2.4 DHDHSPCFG8 (offset 0xA0A0, printed page 11-187, `datasheet.txt` line 43536).";

        field {
            name = "hsp_hf1_coring";
            desc = "High-frequency coring coefficient, unsigned number.";
            sw = rw;
            hw = r;
            reset = 0x0;
        } hsp_hf1_coring[7:0];
    } DHDHSPCFG8 @ 0xA0A0;

    reg {
        name = "Sharpen configuration register 12 for VGA channel H";
        desc = "DHDHSPCFG12 is sharpen configuration register 12 for VGA channel H.

Data sheet 11.2.4 DHDHSPCFG12 (offset 0xA0B0, printed page 11-188, `datasheet.txt` line 43564).";

        field {
            name = "hsp_hf1_gainneg";
            desc = "High-frequency gain negative polarity coefficient, signed number (10.8).";
            sw = rw;
            hw = r;
            reset = 0x0;
        } hsp_hf1_gainneg[26:16];

        field {
            name = "hsp_hf1_gainpos";
            desc = "High-frequency gain positive polarity coefficient, signed number (10.8).";
            sw = rw;
            hw = r;
            reset = 0x0;
        } hsp_hf1_gainpos[10:0];
    } DHDHSPCFG12 @ 0xA0B0;

    reg {
        name = "Sharpen configuration register 13 for VGA channel H";
        desc = "DHDHSPCFG13 is sharpen configuration register 13 for VGA channel H.

Data sheet 11.2.4 DHDHSPCFG13 (offset 0xA0B4, printed page 11-188, `datasheet.txt` line 43590).";

        field {
            name = "hsp_hf1_adpshoot_en";
            desc = "High-frequency adjustment threshold enable.";
            sw = rw;
            hw = r;
            reset = 0x0;
        } hsp_hf1_adpshoot_en[31:31];

        field {
            name = "hsp_hf1_winsize";
            desc = "High-frequency window size, unsigned number. The value range is 0-4.";
            sw = rw;
            hw = r;
            reset = 0x0;
        } hsp_hf1_winsize[30:28];

        field {
            name = "hsp_hf1_mixratio";
            desc = "High-frequency adjustment threshold ratio, unsigned number (8.7).";
            sw = rw;
            hw = r;
            reset = 0x0;
        } hsp_hf1_mixratio[23:16];

        field {
            name = "hsp_hf1_underth";
            desc = "High-frequency adjustment under threshold, unsigned number.";
            sw = rw;
            hw = r;
            reset = 0x0;
        } hsp_hf1_underth[15:8];

        field {
            name = "hsp_hf1_overth";
            desc = "High-frequency adjustment over threshold, unsigned number.";
            sw = rw;
            hw = r;
            reset = 0x0;
        } hsp_hf1_overth[7:0];
    } DHDHSPCFG13 @ 0xA0B4;

    reg {
        name = "Sharpen configuration register 14 for VGA channel H";
        desc = "DHDHSPCFG14 is sharpen configuration register 14 for VGA channel H.

Data sheet 11.2.4 DHDHSPCFG14 (offset 0xA0B8, printed page 11-189, `datasheet.txt` line 43636).";

        field {
            name = "hsp_h0_en";
            desc = "High-frequency filtering 0 enable.";
            sw = rw;
            hw = r;
            reset = 0x0;
        } hsp_h0_en[31:31];

        field {
            name = "hsp_h1_en";
            desc = "High-frequency filtering 1 enable.";
            sw = rw;
            hw = r;
            reset = 0x0;
        } hsp_h1_en[30:30];

        field {
            name = "hsp_ltih_en";
            desc = "Horizontal LTI enable.";
            sw = rw;
            hw = r;
            reset = 0x0;
        } hsp_ltih_en[29:29];

        field {
            name = "hsp_ctih_en";
            desc = "Horizontal CTI enable.";
            sw = rw;
            hw = r;
            reset = 0x0;
        } hsp_ctih_en[28:28];

        field {
            name = "hsp_hf_shootdiv";
            desc = "High-frequency adjustment shift coefficient, unsigned number. The value range is 1-7.";
            sw = rw;
            hw = r;
            reset = 0x0;
        } hsp_hf_shootdiv[26:24];

        field {
            name = "hsp_lti_ratio";
            desc = "Luminance enhancement ratio, unsigned number (8.7).";
            sw = rw;
            hw = r;
            reset = 0x0;
        } hsp_lti_ratio[23:16];

        field {
            name = "hsp_ldti_gain";
            desc = "Luminance enhancement gain coefficient, unsigned number (8.5).";
            sw = rw;
            hw = r;
            reset = 0x0;
        } hsp_ldti_gain[15:8];

        field {
            name = "hsp_cdti_gain";
            desc = "Chrominance enhancement gain coefficient, unsigned number (8.5).";
            sw = rw;
            hw = r;
            reset = 0x0;
        } hsp_cdti_gain[7:0];
    } DHDHSPCFG14 @ 0xA0B8;

    reg {
        name = "Sharpen configuration register 15 for VGA channel H";
        desc = "DHDHSPCFG15 is sharpen configuration register 15 for VGA channel H.

Data sheet 11.2.4 DHDHSPCFG15 (offset 0xA0BC, printed page 11-190, `datasheet.txt` line 43685).";

        field {
            name = "hsp_peak_ratio";
            desc = "Luminance enhancement ratio, unsigned number (8.7).";
            sw = rw;
            hw = r;
            reset = 0x0;
        } hsp_peak_ratio[27:20];

        field {
            name = "hsp_glb_overth";
            desc = "Luminance enhancement global upper threshold, unsigned number.";
            sw = rw;
            hw = r;
            reset = 0x0;
        } hsp_glb_overth[18:10];

        field {
            name = "hsp_glb_underth";
            desc = "Luminance enhancement global lower threshold, unsigned number.";
            sw = rw;
            hw = r;
            reset = 0x0;
        } hsp_glb_underth[8:0];
    } DHDHSPCFG15 @ 0xA0BC;

    reg {
        name = "DHD status register";
        desc = "DHDSTATE is the DHD status register.

Data sheet 11.2.4 DHDSTATE (offset 0xA0F0, printed page 11-190, `datasheet.txt` line 43718).";

        enum DHDSTATE_bottom_field_enum {
            TOP_FIELD = 0 { name = "Top Field"; desc = "top field"; };
            BOTTOM_FIELD = 1 { name = "Bottom Field"; desc = "bottom field"; };
        };

        field {
            name = "bottom_field";
            desc = "DHD top/bottom field flag.";
            sw = r;
            hw = w;
            encode = DHDSTATE_bottom_field_enum;
            reset = 0x0;
        } bottom_field[2:2];

        enum DHDSTATE_vblank_enum {
            ACTIVE_REGION = 0 { name = "Active Region"; desc = "active region"; };
            BLANKING_REGION = 1 { name = "Blanking Region"; desc = "blanking region"; };
        };

        field {
            name = "vblank";
            desc = "DHD blanking region flag.";
            sw = r;
            hw = w;
            encode = DHDSTATE_vblank_enum;
            reset = 0x0;
        } vblank[1:1];

        enum DHDSTATE_vback_blank_enum {
            NON_BACK_BLANKING = 0 { name = "Non Back Blanking"; desc = "non-back blanking region"; };
            BACK_BLANKING_REGION = 1 { name = "Back Blanking Region"; desc = "back blanking region"; };
        };

        field {
            name = "vback_blank";
            desc = "DHD back blanking region flag.";
            sw = r;
            hw = w;
            encode = DHDSTATE_vback_blank_enum;
            reset = 0x0;
        } vback_blank[0:0];

        field {
            name = "reserved_nz_8";
            desc = "Reserved (RO); reads 1: the data sheet total reset value is 0x0000_0110 with bits 8 and 4 set inside the reserved range [31:3].";
            sw = r;
            hw = w;
            reset = 0x1;
        } reserved_nz_8[8:8];

        field {
            name = "reserved_nz_4";
            desc = "Reserved (RO); reads 1 (see reserved_nz_8).";
            sw = r;
            hw = w;
            reset = 0x1;
        } reserved_nz_4[4:4];
    } DHDSTATE @ 0xA0F0;

    reg {
        name = "DSD global control register";
        desc = "DSD is the DSD global control register. You must configure this register before configuring DSDCTRL[intf_en]. Otherwise, the configuration does not take effect.

Data sheet 11.2.4 DSDCTRL (offset 0xA800, printed page 11-191, `datasheet.txt` line 43772).";

        enum DSDCTRL_intf_en_enum {
            DISABLED = 0 { name = "Disabled"; desc = "disabled"; };
            ENABLED = 1 { name = "Enabled"; desc = "enabled"; };
        };

        field {
            name = "intf_en";
            desc = "Display interface enable (instant register). Data is output over the interface only when this bit is enabled.";
            sw = rw;
            hw = r;
            encode = DSDCTRL_intf_en_enum;
            reset = 0x0;
        } intf_en[31:31];

        enum DSDCTRL_idv_enum {
            DISABLED = 0 { name = "Disabled"; desc = "disabled"; };
            ENABLED = 1 { name = "Enabled"; desc = "enabled"; };
        };

        field {
            name = "idv";
            desc = "Output phase reverse enable for the data valid signal (instant field).";
            sw = rw;
            hw = r;
            encode = DSDCTRL_idv_enum;
            reset = 0x0;
        } idv[10:10];

        enum DSDCTRL_ihs_enum {
            DISABLED = 0 { name = "Disabled"; desc = "disabled"; };
            ENABLED = 1 { name = "Enabled"; desc = "enabled"; };
        };

        field {
            name = "ihs";
            desc = "Output phase reverse enable for the horizontal sync pulse (instant field).";
            sw = rw;
            hw = r;
            encode = DSDCTRL_ihs_enum;
            reset = 0x0;
        } ihs[9:9];

        enum DSDCTRL_ivs_enum {
            DISABLED = 0 { name = "Disabled"; desc = "disabled"; };
            ENABLED = 1 { name = "Enabled"; desc = "enabled"; };
        };

        field {
            name = "ivs";
            desc = "Output phase reverse enable for the vertical sync pulse (instant field).";
            sw = rw;
            hw = r;
            encode = DSDCTRL_ivs_enum;
            reset = 0x0;
        } ivs[8:8];

        enum DSDCTRL_iop_enum {
            INTERLACED_DISPLAY = 0 { name = "Interlaced Display"; desc = "interlaced display"; };
            PROGRESSIVE_DISPLAY = 1 { name = "Progressive Display"; desc = "progressive display"; };
        };

        field {
            name = "iop";
            desc = "Progressive or interlaced display (instant field).";
            sw = rw;
            hw = r;
            encode = DSDCTRL_iop_enum;
            reset = 0x0;
        } iop[7:7];

        enum DSDCTRL_synm_enum {
            TIMING_LABEL_MODE = 0 { name = "Timing Label Mode"; desc = "timing label mode (such as BT.656)"; };
            SYNC_SIGNAL_MODE = 1 { name = "Sync Signal Mode"; desc = "sync signal mode (such as LCD display)"; };
        };

        field {
            name = "synm";
            desc = "Sync mode (instant field).";
            sw = rw;
            hw = r;
            encode = DSDCTRL_synm_enum;
            reset = 0x0;
        } synm[6:6];

        field {
            name = "intfb";
            desc = "Bit width mode of the output interface (instant field). 00: single-component mode (each clock outputs one component) Other values: invalid";
            sw = rw;
            hw = r;
            reset = 0x0;
        } intfb[5:4];

        field {
            name = "intfdm";
            desc = "Interface data format (instant field). 0x0: YCbCr422 Other values: invalid";
            sw = rw;
            hw = r;
            reset = 0x0;
        } intfdm[3:0];
    } DSDCTRL @ 0xA800;

    reg {
        name = "DSD vertical timing register";
        desc = "DSD vertical timing register.

Data sheet 11.2.4 DSDVSYNC (offset 0xA804, printed page 11-193, `datasheet.txt` line 43857).";

        field {
            name = "vfb";
            desc = "In interlaced output mode: TVFB In progressive output mode: VFB Unit: line";
            sw = rw;
            hw = r;
            reset = 0x1;
        } vfb[27:20];

        field {
            name = "vbb";
            desc = "In interlaced output mode: TVBB In progressive output mode: VBB + VPW Unit: line";
            sw = rw;
            hw = r;
            reset = 0x15;
        } vbb[19:12];

        field {
            name = "vact";
            desc = "In interlaced output mode: height of an active picture in the top field In progressive output format: height of an active picture in a frame. The register value is the actual value minus 1. Unit: line";
            sw = rw;
            hw = r;
            reset = 0x11F;
        } vact[11:0];
    } DSDVSYNC @ 0xA804;

    reg {
        name = "DSD horizontal timing register 1";
        desc = "DSD horizontal timing register 1.

Data sheet 11.2.4 DSDHSYNC1 (offset 0xA808, printed page 11-194, `datasheet.txt` line 43906).";

        field {
            name = "hbb";
            desc = "HBB. Unit: pixel";
            sw = rw;
            hw = r;
            reset = 0x107;
        } hbb[31:16];

        field {
            name = "hact";
            desc = "Number of horizontal pixels in an active region.";
            sw = rw;
            hw = r;
            reset = 0x2CF;
        } hact[15:0];
    } DSDHSYNC1 @ 0xA808;

    reg {
        name = "DSD horizontal timing register 2";
        desc = "DSDHSYNC2 is DSD horizontal timing register 2. In interlaced or progressive output mode, this register is the horizontal sync timing configuration register. The setting of this register takes effect immediately after configuration. That is, the timing of the HSYNC pin is affected immediately. You must configure this register before configuring DSDCTRL[intf_en]. Otherwise, the configuration does not take effect.

Data sheet 11.2.4 DSDHSYNC2 (offset 0xA80C, printed page 11-194, `datasheet.txt` line 43939).";

        field {
            name = "hfb";
            desc = "HFB. Unit: pixel";
            sw = rw;
            hw = r;
            reset = 0x17;
        } hfb[15:0];
    } DSDHSYNC2 @ 0xA80C;

    reg {
        name = "DSD interlaced bottom vertical timing register";
        desc = "DSDVPLUS is the DSD interlaced bottom vertical timing register. In interlaced output mode, this register indicates the bottom vertical sync timing. You must configure this register before configuring DSDCTRL[intf_en]. Otherwise, the configuration does not take effect.

Data sheet 11.2.4 DSDVPLUS (offset 0xA810, printed page 11-195, `datasheet.txt` line 43977).";

        field {
            name = "bvfb";
            desc = "In interlaced output mode: BVFB Unit: line";
            sw = rw;
            hw = r;
            reset = 0x1;
        } bvfb[27:20];

        field {
            name = "bvbb";
            desc = "In interlaced output mode: BVBB + VPW Unit: line";
            sw = rw;
            hw = r;
            reset = 0x16;
        } bvbb[19:12];

        field {
            name = "bvact";
            desc = "In interlaced output mode: height of an active picture in the bottom field. The register value is the actual value minus 1. Unit: line";
            sw = rw;
            hw = r;
            reset = 0x11F;
        } bvact[11:0];
    } DSDVPLUS @ 0xA810;

    reg {
        name = "DSD sync signal pulse width register";
        desc = "DSD sync signal pulse width register.

Data sheet 11.2.4 DSDPWR (offset 0xA814, printed page 11-196, `datasheet.txt` line 44023).";

        field {
            name = "vpw";
            desc = "VPW minus 1. Unit: pixel";
            sw = rw;
            hw = r;
            reset = 0x0;
        } vpw[23:16];

        field {
            name = "hpw";
            desc = "HPW minus 1. Unit: pixel";
            sw = rw;
            hw = r;
            reset = 0x0;
        } hpw[15:0];
    } DSDPWR @ 0xA814;

    reg {
        name = "DSD vertical timing threshold register";
        desc = "DSDVTTHD is the DSD vertical timing threshold register (instant register). It can be used to set two thresholds for generating two interrupts separately.

Data sheet 11.2.4 DSDVTTHD (offset 0xA81C, printed page 11-196, `datasheet.txt` line 44049).";

        enum DSDVTTHD_thd1_mode_enum {
            FRAME_MODE_THRESHOLD = 0 { name = "Frame Mode Threshold"; desc = "frame mode. The threshold count is in the unit of frame."; };
            FIELD_MODE_THRESHOLD = 1 { name = "Field Mode Threshold"; desc = "field mode. The threshold count is in the unit of field in interlaced display mode."; };
        };

        field {
            name = "thd1_mode";
            desc = "Threshold 1 interrupt generation mode.";
            sw = rw;
            hw = r;
            encode = DSDVTTHD_thd1_mode_enum;
            reset = 0x0;
        } thd1_mode[15:15];

        field {
            name = "vtmgthd1";
            desc = "Vertical timing threshold 1. When the vertical timing counter reaches this threshold, the VOINTSTA[dsdvtthd_int1] interrupt is triggered.";
            sw = rw;
            hw = r;
            reset = 0x1;
        } vtmgthd1[12:0];
    } DSDVTTHD @ 0xA81C;

    reg {
        name = "DSD clip lower threshold register";
        desc = "DSDCLIPL is the DSD clip lower threshold register (instant register).

Data sheet 11.2.4 DSDCLIPL (offset 0xA840, printed page 11-197, `datasheet.txt` line 44090).";

        enum DSDCLIPL_clipen_enum {
            DISABLED = 0 { name = "Disabled"; desc = "disabled"; };
            ENABLED = 1 { name = "Enabled"; desc = "enabled"; };
        };

        field {
            name = "clipen";
            desc = "Output clip enable (instant field).";
            sw = rw;
            hw = r;
            encode = DSDCLIPL_clipen_enum;
            reset = 0x0;
        } clipen[31:31];

        enum DSDCLIPL_dfir_en_enum {
            DISABLED = 0 { name = "Disabled"; desc = "disabled"; };
            ENABLED = 1 { name = "Enabled"; desc = "enabled"; };
        };

        field {
            name = "dfir_en";
            desc = "Horizontal chrominance down scaling enable.";
            sw = rw;
            hw = r;
            encode = DSDCLIPL_dfir_en_enum;
            reset = 0x1;
        } dfir_en[30:30];

        field {
            name = "clipcl2";
            desc = "Lower threshold Y/R of component 2, unsigned integer.";
            sw = rw;
            hw = r;
            reset = 0x40;
        } clipcl2[29:20];

        field {
            name = "clipcl1";
            desc = "Lower threshold Cb/G of component 1, unsigned integer.";
            sw = rw;
            hw = r;
            reset = 0x40;
        } clipcl1[19:10];

        field {
            name = "clipcl0";
            desc = "Lower threshold Cr/B of component 0, unsigned integer.";
            sw = rw;
            hw = r;
            reset = 0x40;
        } clipcl0[9:0];
    } DSDCLIPL @ 0xA840;

    reg {
        name = "DSD clip upper threshold register";
        desc = "DSDCLIPH is the DSD clip upper threshold register (instant register). For example, the output data needs to be clipped in BT.656 output mode.

Data sheet 11.2.4 DSDCLIPH (offset 0xA844, printed page 11-197, `datasheet.txt` line 44122).";

        field {
            name = "clipch2";
            desc = "Upper threshold Y/R of component 2, unsigned integer.";
            sw = rw;
            hw = r;
            reset = 0x3AC;
        } clipch2[29:20];

        field {
            name = "clipch1";
            desc = "Upper threshold Cb/G of component 1, unsigned integer.";
            sw = rw;
            hw = r;
            reset = 0x3C0;
        } clipch1[19:10];

        field {
            name = "clipch0";
            desc = "Upper threshold Cr/B of component 0, unsigned integer.";
            sw = rw;
            hw = r;
            reset = 0x3C0;
        } clipch0[9:0];
    } DSDCLIPH @ 0xA844;

    reg {
        name = "DSD status register";
        desc = "DSDSTATE is the DSD status register.

Data sheet 11.2.4 DSDSTATE (offset 0xA8F0, printed page 11-198, `datasheet.txt` line 44160).";

        enum DSDSTATE_bottom_field_enum {
            TOP_FIELD = 0 { name = "Top Field"; desc = "top field"; };
            BOTTOM_FIELD = 1 { name = "Bottom Field"; desc = "bottom field"; };
        };

        field {
            name = "bottom_field";
            desc = "DSD top/bottom field flag.";
            sw = rw;
            hw = r;
            encode = DSDSTATE_bottom_field_enum;
            reset = 0x1;
        } bottom_field[2:2];

        enum DSDSTATE_vblank_enum {
            ACTIVE_REGION = 0 { name = "Active Region"; desc = "active region"; };
            BLANKING_REGION = 1 { name = "Blanking Region"; desc = "blanking region"; };
        };

        field {
            name = "vblank";
            desc = "DSD blanking region flag.";
            sw = rw;
            hw = r;
            encode = DSDSTATE_vblank_enum;
            reset = 0x1;
        } vblank[1:1];

        enum DSDSTATE_vback_blank_enum {
            NON_BACK_BLANKING = 0 { name = "Non Back Blanking"; desc = "non-back blanking region"; };
            BACK_BLANKING_REGION = 1 { name = "Back Blanking Region"; desc = "back blanking region"; };
        };

        field {
            name = "vback_blank";
            desc = "DSD back blanking region flag.";
            sw = rw;
            hw = r;
            encode = DSDSTATE_vback_blank_enum;
            reset = 0x0;
        } vback_blank[0:0];
    } DSDSTATE @ 0xA8F0;

    reg {
        name = "DSD1 global control register";
        desc = "DSD1 global control register.

Data sheet 11.2.4 DSD1CTRL (offset 0xAC00, printed page 11-199, `datasheet.txt` line 44212).";

        enum DSD1CTRL_intf_en_enum {
            DISABLED = 0 { name = "Disabled"; desc = "disabled"; };
            ENABLED = 1 { name = "Enabled"; desc = "enabled"; };
        };

        field {
            name = "intf_en";
            desc = "Display interface enable (instant register). Data is output over the interface only when this bit is enabled.";
            sw = rw;
            hw = r;
            encode = DSD1CTRL_intf_en_enum;
            reset = 0x0;
        } intf_en[31:31];

        enum DSD1CTRL_idv_enum {
            DISABLED = 0 { name = "Disabled"; desc = "disabled"; };
            ENABLED = 1 { name = "Enabled"; desc = "enabled"; };
        };

        field {
            name = "idv";
            desc = "Output phase reverse enable for the data valid signal (instant field).";
            sw = rw;
            hw = r;
            encode = DSD1CTRL_idv_enum;
            reset = 0x0;
        } idv[10:10];

        enum DSD1CTRL_ihs_enum {
            DISABLED = 0 { name = "Disabled"; desc = "disabled"; };
            ENABLED = 1 { name = "Enabled"; desc = "enabled"; };
        };

        field {
            name = "ihs";
            desc = "Output phase reverse enable for the horizontal sync pulse (instant field).";
            sw = rw;
            hw = r;
            encode = DSD1CTRL_ihs_enum;
            reset = 0x0;
        } ihs[9:9];

        enum DSD1CTRL_ivs_enum {
            DISABLED = 0 { name = "Disabled"; desc = "disabled"; };
            ENABLED = 1 { name = "Enabled"; desc = "enabled"; };
        };

        field {
            name = "ivs";
            desc = "Output phase reverse enable for the vertical sync pulse (instant field).";
            sw = rw;
            hw = r;
            encode = DSD1CTRL_ivs_enum;
            reset = 0x0;
        } ivs[8:8];

        enum DSD1CTRL_iop_enum {
            INTERLACED_DISPLAY = 0 { name = "Interlaced Display"; desc = "interlaced display"; };
            PROGRESSIVE_DISPLAY = 1 { name = "Progressive Display"; desc = "progressive display"; };
        };

        field {
            name = "iop";
            desc = "Progressive or interlaced display (instant field).";
            sw = rw;
            hw = r;
            encode = DSD1CTRL_iop_enum;
            reset = 0x0;
        } iop[7:7];

        enum DSD1CTRL_synm_enum {
            TIMING_LABEL_MODE = 0 { name = "Timing Label Mode"; desc = "timing label mode (such as BT.656)"; };
            SYNC_SIGNAL_MODE = 1 { name = "Sync Signal Mode"; desc = "sync signal mode (such as LCD display)"; };
        };

        field {
            name = "synm";
            desc = "Sync mode (instant field).";
            sw = rw;
            hw = r;
            encode = DSD1CTRL_synm_enum;
            reset = 0x0;
        } synm[6:6];

        field {
            name = "intfb";
            desc = "Bit width mode of the output interface (instant field). 00: single-component mode (each clock outputs one component) Other values: reserved";
            sw = rw;
            hw = r;
            reset = 0x0;
        } intfb[5:4];

        field {
            name = "intfdm";
            desc = "Interface data format (instant field). 0x0: YCbCr422 Other values: reserved";
            sw = rw;
            hw = r;
            reset = 0x0;
        } intfdm[3:0];
    } DSD1CTRL @ 0xAC00;

    reg {
        name = "DSD1 vertical timing register";
        desc = "DSD1VSYNC is the DSD1 vertical timing register. In interlaced output mode, this register indicates the top vertical sync timing; in progressive output mode, this register indicates the frame vertical sync timing. The setting of this register takes effect immediately after configuration. That is, the timing of the VSYNC pin is affected immediately. You must configure this register before configuring DSDCTRL[intf_en]. Otherwise, the configuration does not take effect.

Data sheet 11.2.4 DSD1VSYNC (offset 0xAC04, printed page 11-200, `datasheet.txt` line 44287).";

        field {
            name = "vfb";
            desc = "In interlaced output mode: TVFB In progressive output mode: VFB Unit: line";
            sw = rw;
            hw = r;
            reset = 0x1;
        } vfb[27:20];

        field {
            name = "vbb";
            desc = "In interlaced output mode: TVBB In progressive output mode: VBB + VPW Unit: line";
            sw = rw;
            hw = r;
            reset = 0x15;
        } vbb[19:12];

        field {
            name = "vact";
            desc = "In interlaced output mode: height of an active picture in the top field In progressive output format: height of an active picture in a frame. The register value is the actual value minus 1. Unit: line";
            sw = rw;
            hw = r;
            reset = 0x11F;
        } vact[11:0];
    } DSD1VSYNC @ 0xAC04;

    reg {
        name = "DSD1 horizontal timing register 1";
        desc = "DSD1 horizontal timing register 1.

Data sheet 11.2.4 DSD1HSYNC1 (offset 0xAC08, printed page 11-201, `datasheet.txt` line 44336).";

        field {
            name = "hbb";
            desc = "HBB. Unit: pixel";
            sw = rw;
            hw = r;
            reset = 0x107;
        } hbb[31:16];

        field {
            name = "hact";
            desc = "Number of horizontal pixels in an active region.";
            sw = rw;
            hw = r;
            reset = 0x2CF;
        } hact[15:0];
    } DSD1HSYNC1 @ 0xAC08;

    reg {
        name = "DSD1 horizontal timing register 2";
        desc = "DSD1 horizontal timing register 2.

Data sheet 11.2.4 DSD1HSYNC2 (offset 0xAC0C, printed page 11-202, `datasheet.txt` line 44377).";

        field {
            name = "hfb";
            desc = "HFB. Unit: pixel";
            sw = rw;
            hw = r;
            reset = 0x17;
        } hfb[15:0];
    } DSD1HSYNC2 @ 0xAC0C;

    reg {
        name = "DSD1 bottom vertical sync timing register in interlaced output mode";
        desc = "DSD1VPLUS is the DSD1 bottom vertical sync timing register in interlaced output mode. You must configure this register before configuring DSDCTRL[intf_en]. Otherwise, the configuration does not take effect.

Data sheet 11.2.4 DSD1VPLUS (offset 0xAC10, printed page 11-202, `datasheet.txt` line 44407).";

        field {
            name = "bvfb";
            desc = "In interlaced output mode: BVFB Unit: line";
            sw = rw;
            hw = r;
            reset = 0x1;
        } bvfb[27:20];

        field {
            name = "bvbb";
            desc = "In interlaced output mode: BVBB + VPW Unit: line";
            sw = rw;
            hw = r;
            reset = 0x16;
        } bvbb[19:12];

        field {
            name = "bvact";
            desc = "In interlaced output mode: height of an active picture in the bottom field. The register value is the actual value minus 1. Unit: line";
            sw = rw;
            hw = r;
            reset = 0x11F;
        } bvact[11:0];
    } DSD1VPLUS @ 0xAC10;

    reg {
        name = "DSD1 sync signal pulse width register";
        desc = "DSD1PWR is the DSD1 sync signal pulse width register. You must configure this register before configuring DSDCTRL[intf_en]. Otherwise, the configuration does not take effect.

Data sheet 11.2.4 DSD1PWR (offset 0xAC14, printed page 11-203, `datasheet.txt` line 44454).";

        field {
            name = "vpw";
            desc = "VPW minus 1. Unit: pixel";
            sw = rw;
            hw = r;
            reset = 0x0;
        } vpw[23:16];

        field {
            name = "hpw";
            desc = "HPW minus 1. Unit: pixel";
            sw = rw;
            hw = r;
            reset = 0x0;
        } hpw[15:0];
    } DSD1PWR @ 0xAC14;

    reg {
        name = "DSD1 vertical timing threshold register";
        desc = "DSD1VTTHD is the DSD1 vertical timing threshold register (instant register). It can be used to set two thresholds for generating two interrupts separately.

Data sheet 11.2.4 DSD1VTTHD (offset 0xAC1C, printed page 11-204, `datasheet.txt` line 44490).";

        enum DSD1VTTHD_thd1_mode_enum {
            FRAME_MODE_THRESHOLD = 0 { name = "Frame Mode Threshold"; desc = "frame mode. The threshold count is in the unit of frame."; };
            FIELD_MODE_THRESHOLD = 1 { name = "Field Mode Threshold"; desc = "field mode. The threshold count is in the unit of field in interlaced display mode."; };
        };

        field {
            name = "thd1_mode";
            desc = "Threshold 1 interrupt generation mode.";
            sw = rw;
            hw = r;
            encode = DSD1VTTHD_thd1_mode_enum;
            reset = 0x0;
        } thd1_mode[15:15];

        field {
            name = "vtmgthd1";
            desc = "Vertical timing threshold 1. When the vertical timing counter reaches this threshold, the VOINTSTA[dsdvtthd_int1] interrupt is triggered.";
            sw = rw;
            hw = r;
            reset = 0x1;
        } vtmgthd1[12:0];
    } DSD1VTTHD @ 0xAC1C;

    reg {
        name = "DSD1 clip lower threshold register";
        desc = "DSD1CLIPL is the DSD1 clip lower threshold register (instant register).

Data sheet 11.2.4 DSD1CLIPL (offset 0xAC40, printed page 11-204, `datasheet.txt` line 44524).";

        enum DSD1CLIPL_clipen_enum {
            DISABLED = 0 { name = "Disabled"; desc = "disabled"; };
            ENABLED = 1 { name = "Enabled"; desc = "enabled"; };
        };

        field {
            name = "clipen";
            desc = "Output clip enable (instant field).";
            sw = rw;
            hw = r;
            encode = DSD1CLIPL_clipen_enum;
            reset = 0x0;
        } clipen[31:31];

        enum DSD1CLIPL_dfir_en_enum {
            DISABLED = 0 { name = "Disabled"; desc = "disabled"; };
            ENABLED = 1 { name = "Enabled"; desc = "enabled"; };
        };

        field {
            name = "dfir_en";
            desc = "Horizontal chrominance down scaling enable.";
            sw = rw;
            hw = r;
            encode = DSD1CLIPL_dfir_en_enum;
            reset = 0x1;
        } dfir_en[30:30];

        field {
            name = "clipcl2";
            desc = "Lower threshold Y/R of component 2, unsigned integer.";
            sw = rw;
            hw = r;
            reset = 0x40;
        } clipcl2[29:20];

        field {
            name = "clipcl1";
            desc = "Lower threshold Cb/G of component 1, unsigned integer.";
            sw = rw;
            hw = r;
            reset = 0x40;
        } clipcl1[19:10];

        field {
            name = "clipcl0";
            desc = "Lower threshold Cr/B of component 0, unsigned integer.";
            sw = rw;
            hw = r;
            reset = 0x40;
        } clipcl0[9:0];
    } DSD1CLIPL @ 0xAC40;

    reg {
        name = "DSD1 clip upper threshold register";
        desc = "DSD1CLIPH is the DSD1 clip upper threshold register (instant register). For example, the output data needs to be clipped in BT.656 output mode.

Data sheet 11.2.4 DSD1CLIPH (offset 0xAC44, printed page 11-205, `datasheet.txt` line 44567).";

        field {
            name = "clipch2";
            desc = "Upper threshold Y/R of component 2, unsigned integer.";
            sw = rw;
            hw = r;
            reset = 0x3AC;
        } clipch2[29:20];

        field {
            name = "clipch1";
            desc = "Upper threshold Cb/G of component 1, unsigned integer.";
            sw = rw;
            hw = r;
            reset = 0x3C0;
        } clipch1[19:10];

        field {
            name = "clipch0";
            desc = "Upper threshold Cr/B of component 0, unsigned integer.";
            sw = rw;
            hw = r;
            reset = 0x3C0;
        } clipch0[9:0];
    } DSD1CLIPH @ 0xAC44;

    reg {
        name = "DSD1 status register";
        desc = "DSD1STATE is the DSD1 status register.

Data sheet 11.2.4 DSD1STATE (offset 0xACF0, printed page 11-206, `datasheet.txt` line 44605).";

        enum DSD1STATE_bottom_field_enum {
            TOP_FIELD = 0 { name = "Top Field"; desc = "top field"; };
            BOTTOM_FIELD = 1 { name = "Bottom Field"; desc = "bottom field"; };
        };

        field {
            name = "bottom_field";
            desc = "DSD1 top/bottom field flag.";
            sw = rw;
            hw = r;
            encode = DSD1STATE_bottom_field_enum;
            reset = 0x1;
        } bottom_field[2:2];

        enum DSD1STATE_vblank_enum {
            ACTIVE_REGION = 0 { name = "Active Region"; desc = "active region"; };
            BLANKING_REGION = 1 { name = "Blanking Region"; desc = "blanking region"; };
        };

        field {
            name = "vblank";
            desc = "DSD1 blanking region flag.";
            sw = rw;
            hw = r;
            encode = DSD1STATE_vblank_enum;
            reset = 0x1;
        } vblank[1:1];

        enum DSD1STATE_vback_blank_enum {
            NON_BACK_BLANKING = 0 { name = "Non Back Blanking"; desc = "non-back blanking region"; };
            BACK_BLANKING_REGION = 1 { name = "Back Blanking Region"; desc = "back blanking region"; };
        };

        field {
            name = "vback_blank";
            desc = "DSD1 back blanking region flag.";
            sw = rw;
            hw = r;
            encode = DSD1STATE_vback_blank_enum;
            reset = 0x0;
        } vback_blank[0:0];
    } DSD1STATE @ 0xACF0;

    reg {
        name = "DATE norm parameter configuration register";
        desc = "DATE_COEFF0 is the DATE norm parameter configuration register.

Data sheet 11.2.4 DATE_COEFF0 (offset 0xC200, printed page 11-207, `datasheet.txt` line 44650).";

        enum DATE_COEFF0_clpf_sel_enum {
            V_1_1_MHZ = 0 { name = "V 1 1 Mhz"; desc = "1.1 MHz (NTSC)"; };
            V_1_3_MHZ = 1 { name = "V 1 3 Mhz"; desc = "1.3 MHz (PAL)"; };
            V_1_6_MHZ = 2 { name = "V 1 6 Mhz"; desc = "1.6 MHz (for test)"; };
            RESERVED = 3 { name = "Reserved"; desc = "reserved"; };
        };

        field {
            name = "clpf_sel";
            desc = "Bandwidth select of the chrominance low-pass filter.";
            sw = rw;
            hw = r;
            encode = DATE_COEFF0_clpf_sel_enum;
            reset = 0x1;
        } clpf_sel[31:30];

        enum DATE_COEFF0_dis_ire_enum {
            BLACK_LEVEL_7 = 0 { name = "Black Level 7"; desc = "The black level is 7.5 IRE higher than the blanking level."; };
            BLACK_LEVEL_EQUAL = 1 { name = "Black Level Equal"; desc = "The black level is equal to the blanking level."; };
        };

        field {
            name = "dis_ire";
            desc = "For the (M) NTSC and (M, N) PAL norms, the black level is 7.5 IRE higher than the blanking level; for other norms, the black level is equal to the blanking level. This bit controls whether the black level is 7.5 IRE higher than the blanking level.";
            sw = rw;
            hw = r;
            encode = DATE_COEFF0_dis_ire_enum;
            reset = 0x0;
        } dis_ire[29:29];

        field {
            name = "reserved_nz";
            desc = "Reserved (RW in the data sheet); bit 28 reads 1: the data sheet total reset value is 0x5284_14FC.";
            sw = rw;
            hw = r;
            reset = 0x4;
        } reserved_nz[28:26];

        enum DATE_COEFF0_scanline_enum {
            V_525_LINES_FRAME = 0 { name = "V 525 Lines Frame"; desc = "525 lines in a frame"; };
            V_625_LINES_FRAME = 1 { name = "V 625 Lines Frame"; desc = "625 lines in a frame"; };
        };

        field {
            name = "scanline";
            desc = "Number of scanned lines in each frame based on norms. For the (M) NTSC, NTSC-J, and (M) PAL norm, each line contains 525 lines; for the (B, D, J, H, I) PAL, (N) PAL, and (Nc) PAL norms, each frame contains 625 lines.";
            sw = rw;
            hw = r;
            encode = DATE_COEFF0_scanline_enum;
            reset = 0x1;
        } scanline[25:25];

        enum DATE_COEFF0_rgb_en_enum {
            YPBPR = 0 { name = "Ypbpr"; desc = "YPbPr"; };
            RGB = 1 { name = "Rgb"; desc = "RGB"; };
        };

        field {
            name = "rgb_en";
            desc = "When intf_sel is set to 100, this bit determines whether the component signal is RGB or YPbPr.";
            sw = rw;
            hw = r;
            encode = DATE_COEFF0_rgb_en_enum;
            reset = 0x0;
        } rgb_en[24:24];

        enum DATE_COEFF0_vbi_lpf_en_enum {
            DISABLED = 0 { name = "Disabled"; desc = "disabled"; };
            ENABLED = 1 { name = "Enabled"; desc = "enabled"; };
        };

        field {
            name = "vbi_lpf_en";
            desc = "VBI data low-pass filtering enable.";
            sw = rw;
            hw = r;
            encode = DATE_COEFF0_vbi_lpf_en_enum;
            reset = 0x1;
        } vbi_lpf_en[23:23];

        enum DATE_COEFF0_fm_sel_enum {
            SIN_USED_SECAM = 0 { name = "Sin Used Secam"; desc = "sin used for SECAM frequency modulation"; };
            COS_USED_SECAM = 1 { name = "Cos Used Secam"; desc = "cos used for SECAM frequency modulation"; };
        };

        field {
            name = "fm_sel";
            desc = "FMSECAM frequency modulation select.";
            sw = rw;
            hw = r;
            encode = DATE_COEFF0_fm_sel_enum;
            reset = 0x0;
        } fm_sel[22:22];

        field {
            name = "style_sel";
            desc = "CVBS/S-Video output signal norm when this bit works with the scanline bit. When the scanline bit is 0 (525 scanned lines in a frame), the definition of the style_sel bit is as follows: 0x1: (M) NTSC 0x2: NTSC-J 0x4: (M) PAL Other values: reserved When the scanline bit is 1 (625 scanned lines in a frame), the definition of the style_sel bit is as follows: 0x1: (B, D, G, H, I) PAL 0x2: (N) PAL 0x4: (Nc) PAL 0x8: SECAM Other values: reserved";
            sw = rw;
            hw = r;
            reset = 0x1;
        } style_sel[21:18];

        field {
            name = "sync_mode_sel";
            desc = "bit[17]: specifies whether there are sync signals in three channels during component output. This bit takes effect only when the sync_mode_scart bit is set to 0. bit[17] is valid only when the intf_sel is set to 100 (component output enabled). The definition of bit[17] is as follows: 0: Only one channel contains sync signals using component output. 1: Three channels contain sync signals during component output. When bit[17] is set to 0, the sync channel must be the Y channel for YPbPr output and G channel for RGB output. bit[16]: specifies whether there are blanking radixes during RGB output. bit[16] is valid only when the intf_sel is set to 100 and the rgb_en bit is set to 1. The definition of bit[16] is as follows: 0: There are no blanking radixes during RGB output. 1: There are blanking radixes during RGB output.";
            sw = rw;
            hw = r;
            reset = 0x0;
        } sync_mode_sel[17:16];

        enum DATE_COEFF0_sync_mode_scart_enum {
            COMPONENT_SYNC_OUTPUT = 0 { name = "Component Sync Output"; desc = "Component sync output is configured based on sync_mode_sel[1]."; };
            COMPONENTS_THREE_CHANNELS = 1 { name = "Components Three Channels"; desc = "The components of the three channels are not overlaid and synchronized. In this case, sync_mode_sel bit[1] must be set to 0."; };
        };

        field {
            name = "sync_mode_scart";
            desc = "Overlay sync control of the components of three channels.";
            sw = rw;
            hw = r;
            encode = DATE_COEFF0_sync_mode_scart_enum;
            reset = 0x0;
        } sync_mode_scart[15:15];

        enum DATE_COEFF0_length_sel_enum {
            OUTPUT_ACCORDING_ACTIVE = 0 { name = "Output According Active"; desc = "output according to the active line width in BT.601 mode"; };
            OUTPUT_ACCORDING_ACTIVE_2 = 1 { name = "Output According Active 2"; desc = "output according to the active line width in BT.470 mode. When this bit is set to 0, the active width of the line is 720 pixels. When this bit is set to 1, the active width of the line is 704 pixels for the 625-line norm or 712 pixels for the 525-line norm. Currently, the BT.601 mode and BT.470 mode cannot be changed dynamically. You can change the mode only after reset. The BT.601 mode is recommended and this mode is the default value after power-on reset."; };
        };

        field {
            name = "length_sel";
            desc = "Active width of each video line (in pixel).";
            sw = rw;
            hw = r;
            encode = DATE_COEFF0_length_sel_enum;
            reset = 0x0;
        } length_sel[14:14];

        enum DATE_COEFF0_agc_amp_sel_enum {
            AGC_PULSE_GENERATED = 0 { name = "Agc Pulse Generated"; desc = "The AGC pulse is generated based on the on-chip default value (recommended)."; };
            AGC_PULSE_GENERATED_2 = 1 { name = "Agc Pulse Generated 2"; desc = "The AGC pulse is generated based on DATE_COEFF1[amp_outside]."; };
        };

        field {
            name = "agc_amp_sel";
            desc = "AGC pulse select.";
            sw = rw;
            hw = r;
            encode = DATE_COEFF0_agc_amp_sel_enum;
            reset = 0x0;
        } agc_amp_sel[13:13];

        field {
            name = "luma_dl";
            desc = "Forward or backward offset of the chrominance signal relative to the luminance signal, in the unit of half a pixel width. bit[12]: offset direction of the chrominance signal relative to the luminance signal. 0: backward offset 1: forward offset bit[11:9]: absolute offset of the chrominance signal relative to the luminance signal. The value is in binary format and ranges from 0 to 7. 000: The chrominance signal is aligned with the luminance signal. No adjustment is required. 001-111: The chrominance signal offsets from the luminance signal forward or backward by one to seven units.";
            sw = rw;
            hw = r;
            reset = 0xA;
        } luma_dl[12:9];

        field {
            name = "oversam_en";
            desc = "Level-1 oversampling enable. Both the luminance oversampling and chrominance oversampling are controlled. bit[7]: luminance oversampling enable. 0: disabled 1: enabled bit[6]: chrominance oversampling enable. 0: disabled 1: enabled";
            sw = rw;
            hw = r;
            reset = 0x3;
        } oversam_en[7:6];

        enum DATE_COEFF0_lunt_en_enum {
            DISABLED = 0 { name = "Disabled"; desc = "disabled"; };
            ENABLED = 1 { name = "Enabled"; desc = "enabled"; };
        };

        field {
            name = "lunt_en";
            desc = "Luminance notch enable.";
            sw = rw;
            hw = r;
            encode = DATE_COEFF0_lunt_en_enum;
            reset = 0x1;
        } lunt_en[5:5];

        enum DATE_COEFF0_oversam2_en_enum {
            DISABLED = 0 { name = "Disabled"; desc = "disabled"; };
            ENABLED = 1 { name = "Enabled"; desc = "enabled"; };
        };

        field {
            name = "oversam2_en";
            desc = "Level-2 oversampling enable. Both the luminance channel and chrominance channel are controlled.";
            sw = rw;
            hw = r;
            encode = DATE_COEFF0_oversam2_en_enum;
            reset = 0x1;
        } oversam2_en[4:4];

        enum DATE_COEFF0_chlp_en_enum {
            DISABLED = 0 { name = "Disabled"; desc = "disabled"; };
            ENABLED = 1 { name = "Enabled"; desc = "enabled"; };
        };

        field {
            name = "chlp_en";
            desc = "Chrominance low-pass filtering enable.";
            sw = rw;
            hw = r;
            encode = DATE_COEFF0_chlp_en_enum;
            reset = 0x1;
        } chlp_en[3:3];

        enum DATE_COEFF0_sylp_en_enum {
            DISABLED = 0 { name = "Disabled"; desc = "disabled"; };
            ENABLED = 1 { name = "Enabled"; desc = "enabled"; };
        };

        field {
            name = "sylp_en";
            desc = "Sync low-pass filtering enable.";
            sw = rw;
            hw = r;
            encode = DATE_COEFF0_sylp_en_enum;
            reset = 0x1;
        } sylp_en[2:2];

        enum DATE_COEFF0_chgain_en_enum {
            DISABLED = 0 { name = "Disabled"; desc = "disabled"; };
            ENABLED = 1 { name = "Enabled"; desc = "enabled"; };
        };

        field {
            name = "chgain_en";
            desc = "Chrominance gain enable.";
            sw = rw;
            hw = r;
            encode = DATE_COEFF0_chgain_en_enum;
            reset = 0x0;
        } chgain_en[1:1];

        enum DATE_COEFF0_tt_seq_enum {
            FROM_UPPER_BITS = 0 { name = "From Upper Bits"; desc = "from upper bits to lower bits"; };
            FROM_LOWER_BITS = 1 { name = "From Lower Bits"; desc = "from lower bits to upper bits"; };
        };

        field {
            name = "tt_seq";
            desc = "Sequence of transmitting the bits of the teletext data.";
            sw = rw;
            hw = r;
            encode = DATE_COEFF0_tt_seq_enum;
            reset = 0x0;
        } tt_seq[0:0];
    } DATE_COEFF0 @ 0xC200;

    reg {
        name = "DATE amplitude configuration register";
        desc = "DATE_COEFF1 is the DATE amplitude configuration register.

Data sheet 11.2.4 DATE_COEFF1 (offset 0xC204, printed page 11-210, `datasheet.txt` line 44837).";

        field {
            name = "c_gain";
            desc = "Adjustment of the chrominance sync gain amplitude.";
            sw = rw;
            hw = r;
            reset = 0x0;
        } c_gain[31:29];

        enum DATE_COEFF1_cvbs_limit_en_enum {
            DISABLED = 0 { name = "Disabled"; desc = "disabled"; };
            ENABLED = 1 { name = "Enabled"; desc = "enabled"; };
        };

        field {
            name = "cvbs_limit_en";
            desc = "CVBS amplitude limit enable.";
            sw = rw;
            hw = r;
            encode = DATE_COEFF1_cvbs_limit_en_enum;
            reset = 0x0;
        } cvbs_limit_en[28:28];

        enum DATE_COEFF1_wss_seq_enum {
            FROM_UPPER_BITS = 0 { name = "From Upper Bits"; desc = "from upper bits to lower bits"; };
            FROM_LOWER_BITS = 1 { name = "From Lower Bits"; desc = "from lower bits to upper bits"; };
        };

        field {
            name = "wss_seq";
            desc = "Sequence of transmitting the bits of the WSS data.";
            sw = rw;
            hw = r;
            encode = DATE_COEFF1_wss_seq_enum;
            reset = 0x0;
        } wss_seq[27:27];

        enum DATE_COEFF1_vps_seq_enum {
            FROM_UPPER_BITS = 0 { name = "From Upper Bits"; desc = "from upper bits to lower bits"; };
            FROM_LOWER_BITS = 1 { name = "From Lower Bits"; desc = "from lower bits to upper bits"; };
        };

        field {
            name = "vps_seq";
            desc = "Sequence of transmitting the bits of the VPS data.";
            sw = rw;
            hw = r;
            encode = DATE_COEFF1_vps_seq_enum;
            reset = 0x0;
        } vps_seq[26:26];

        enum DATE_COEFF1_cgms_seq_enum {
            FROM_UPPER_BITS = 0 { name = "From Upper Bits"; desc = "from upper bits to lower bits"; };
            FROM_LOWER_BITS = 1 { name = "From Lower Bits"; desc = "from lower bits to upper bits"; };
        };

        field {
            name = "cgms_seq";
            desc = "Sequence of transmitting the bits of the CGMS data.";
            sw = rw;
            hw = r;
            encode = DATE_COEFF1_cgms_seq_enum;
            reset = 0x0;
        } cgms_seq[25:25];

        enum DATE_COEFF1_cc_seq_enum {
            FROM_UPPER_BITS = 0 { name = "From Upper Bits"; desc = "from upper bits to lower bits"; };
            FROM_LOWER_BITS = 1 { name = "From Lower Bits"; desc = "from lower bits to upper bits"; };
        };

        field {
            name = "cc_seq";
            desc = "Sequence of transmitting the bits of the closed caption data.";
            sw = rw;
            hw = r;
            encode = DATE_COEFF1_cc_seq_enum;
            reset = 0x0;
        } cc_seq[24:24];

        enum DATE_COEFF1_c_limit_en_enum {
            DISABLED = 0 { name = "Disabled"; desc = "disabled"; };
            ENABLED = 1 { name = "Enabled"; desc = "enabled"; };
        };

        field {
            name = "c_limit_en";
            desc = "Chrominance amplitude limit enable.";
            sw = rw;
            hw = r;
            encode = DATE_COEFF1_c_limit_en_enum;
            reset = 0x0;
        } c_limit_en[23:23];

        field {
            name = "amp_outside";
            desc = "Pulse amplitude input of the external AGC.";
            sw = rw;
            hw = r;
            reset = 0x0;
        } amp_outside[22:13];

        enum DATE_COEFF1_date_test_en_enum {
            INVALID = 0 { name = "Invalid"; desc = "invalid"; };
            VALID = 1 { name = "Valid"; desc = "valid"; };
        };

        field {
            name = "date_test_en";
            desc = "Test valid signal.";
            sw = rw;
            hw = r;
            encode = DATE_COEFF1_date_test_en_enum;
            reset = 0x0;
        } date_test_en[12:12];

        field {
            name = "date_test_mode";
            desc = "Test mode signal.";
            sw = rw;
            hw = r;
            reset = 0x0;
        } date_test_mode[11:10];

        field {
            name = "dac_test";
            desc = "DAC test value input.";
            sw = rw;
            hw = r;
            reset = 0x0;
        } dac_test[9:0];
    } DATE_COEFF1 @ 0xC204;

    reg {
        name = "DATE teletext configuration register";
        desc = "DATE_COEFF7 is a DATE teletext configuration register.

Data sheet 11.2.4 DATE_COEFF7 (offset 0xC21C, printed page 11-212, `datasheet.txt` line 44909).";

        enum DATE_COEFF7_tt22_enf1_enum {
            DISABLED = 0 { name = "Disabled"; desc = "disabled"; };
            ENABLED = 1 { name = "Enabled"; desc = "enabled"; };
        };

        field {
            name = "tt22_enf1";
            desc = "Control of the teletext in line 22 in the odd field.";
            sw = rw;
            hw = r;
            encode = DATE_COEFF7_tt22_enf1_enum;
            reset = 0x0;
        } tt22_enf1[31:31];

        enum DATE_COEFF7_tt21_enf1_enum {
            DISABLED = 0 { name = "Disabled"; desc = "disabled"; };
            ENABLED = 1 { name = "Enabled"; desc = "enabled"; };
        };

        field {
            name = "tt21_enf1";
            desc = "Control of the teletext in line 21 in the odd field.";
            sw = rw;
            hw = r;
            encode = DATE_COEFF7_tt21_enf1_enum;
            reset = 0x0;
        } tt21_enf1[30:30];

        enum DATE_COEFF7_tt20_enf1_enum {
            DISABLED = 0 { name = "Disabled"; desc = "disabled"; };
            ENABLED = 1 { name = "Enabled"; desc = "enabled"; };
        };

        field {
            name = "tt20_enf1";
            desc = "Control of the teletext in line 20 in the odd field.";
            sw = rw;
            hw = r;
            encode = DATE_COEFF7_tt20_enf1_enum;
            reset = 0x0;
        } tt20_enf1[29:29];

        enum DATE_COEFF7_tt19_enf1_enum {
            DISABLED = 0 { name = "Disabled"; desc = "disabled"; };
            ENABLED = 1 { name = "Enabled"; desc = "enabled"; };
        };

        field {
            name = "tt19_enf1";
            desc = "Control of the teletext in line 19 in the odd field.";
            sw = rw;
            hw = r;
            encode = DATE_COEFF7_tt19_enf1_enum;
            reset = 0x0;
        } tt19_enf1[28:28];

        enum DATE_COEFF7_tt18_enf1_enum {
            DISABLED = 0 { name = "Disabled"; desc = "disabled"; };
            ENABLED = 1 { name = "Enabled"; desc = "enabled"; };
        };

        field {
            name = "tt18_enf1";
            desc = "Control of the teletext in line 18 in the odd field.";
            sw = rw;
            hw = r;
            encode = DATE_COEFF7_tt18_enf1_enum;
            reset = 0x0;
        } tt18_enf1[27:27];

        enum DATE_COEFF7_tt17_enf1_enum {
            DISABLED = 0 { name = "Disabled"; desc = "disabled"; };
            ENABLED = 1 { name = "Enabled"; desc = "enabled"; };
        };

        field {
            name = "tt17_enf1";
            desc = "Control of the teletext in line 17 in the odd field.";
            sw = rw;
            hw = r;
            encode = DATE_COEFF7_tt17_enf1_enum;
            reset = 0x0;
        } tt17_enf1[26:26];

        enum DATE_COEFF7_tt16_enf1_enum {
            DISABLED = 0 { name = "Disabled"; desc = "disabled"; };
            ENABLED = 1 { name = "Enabled"; desc = "enabled"; };
        };

        field {
            name = "tt16_enf1";
            desc = "Control of the teletext in line 16 in the odd field.";
            sw = rw;
            hw = r;
            encode = DATE_COEFF7_tt16_enf1_enum;
            reset = 0x0;
        } tt16_enf1[25:25];

        enum DATE_COEFF7_tt15_enf1_enum {
            DISABLED = 0 { name = "Disabled"; desc = "disabled"; };
            ENABLED = 1 { name = "Enabled"; desc = "enabled"; };
        };

        field {
            name = "tt15_enf1";
            desc = "Control of the teletext in line 15 in the odd field.";
            sw = rw;
            hw = r;
            encode = DATE_COEFF7_tt15_enf1_enum;
            reset = 0x0;
        } tt15_enf1[24:24];

        enum DATE_COEFF7_tt14_enf1_enum {
            DISABLED = 0 { name = "Disabled"; desc = "disabled"; };
            ENABLED = 1 { name = "Enabled"; desc = "enabled"; };
        };

        field {
            name = "tt14_enf1";
            desc = "Control of the teletext in line 14 in the odd field.";
            sw = rw;
            hw = r;
            encode = DATE_COEFF7_tt14_enf1_enum;
            reset = 0x0;
        } tt14_enf1[23:23];

        enum DATE_COEFF7_tt13_enf1_enum {
            DISABLED = 0 { name = "Disabled"; desc = "disabled"; };
            ENABLED = 1 { name = "Enabled"; desc = "enabled"; };
        };

        field {
            name = "tt13_enf1";
            desc = "Control of the teletext in line 13 in the odd field.";
            sw = rw;
            hw = r;
            encode = DATE_COEFF7_tt13_enf1_enum;
            reset = 0x0;
        } tt13_enf1[22:22];

        field {
            name = "tt12_enf1";
            desc = "Control of the teletext in line 12 in the odd field.0: disabled 1: enabled";
            sw = rw;
            hw = r;
            reset = 0x0;
        } tt12_enf1[21:21];

        field {
            name = "tt11_enf1";
            desc = "Control of the teletext in line 11 in the odd field.0: disabled 1: enabled";
            sw = rw;
            hw = r;
            reset = 0x0;
        } tt11_enf1[20:20];

        enum DATE_COEFF7_tt10_enf1_enum {
            DISABLED = 0 { name = "Disabled"; desc = "disabled"; };
            ENABLED = 1 { name = "Enabled"; desc = "enabled"; };
        };

        field {
            name = "tt10_enf1";
            desc = "Control of the teletext in line 10 in the odd field.";
            sw = rw;
            hw = r;
            encode = DATE_COEFF7_tt10_enf1_enum;
            reset = 0x0;
        } tt10_enf1[19:19];

        enum DATE_COEFF7_tt09_enf1_enum {
            DISABLED = 0 { name = "Disabled"; desc = "disabled"; };
            ENABLED = 1 { name = "Enabled"; desc = "enabled"; };
        };

        field {
            name = "tt09_enf1";
            desc = "Control of the teletext in line 9 in the odd field.";
            sw = rw;
            hw = r;
            encode = DATE_COEFF7_tt09_enf1_enum;
            reset = 0x0;
        } tt09_enf1[18:18];

        enum DATE_COEFF7_tt08_enf1_enum {
            DISABLED = 0 { name = "Disabled"; desc = "disabled"; };
            ENABLED = 1 { name = "Enabled"; desc = "enabled"; };
        };

        field {
            name = "tt08_enf1";
            desc = "Control of the teletext in line 8 in the odd field.";
            sw = rw;
            hw = r;
            encode = DATE_COEFF7_tt08_enf1_enum;
            reset = 0x0;
        } tt08_enf1[17:17];

        enum DATE_COEFF7_tt07_enf1_enum {
            DISABLED = 0 { name = "Disabled"; desc = "disabled"; };
            ENABLED = 1 { name = "Enabled"; desc = "enabled"; };
        };

        field {
            name = "tt07_enf1";
            desc = "Control of the teletext in line 7 in the odd field.";
            sw = rw;
            hw = r;
            encode = DATE_COEFF7_tt07_enf1_enum;
            reset = 0x0;
        } tt07_enf1[16:16];

        enum DATE_COEFF7_tt22_enf2_enum {
            DISABLED = 0 { name = "Disabled"; desc = "disabled"; };
            ENABLED = 1 { name = "Enabled"; desc = "enabled"; };
        };

        field {
            name = "tt22_enf2";
            desc = "Control of teletext in line 22 in the even field.";
            sw = rw;
            hw = r;
            encode = DATE_COEFF7_tt22_enf2_enum;
            reset = 0x0;
        } tt22_enf2[15:15];

        enum DATE_COEFF7_tt21_enf2_enum {
            DISABLED = 0 { name = "Disabled"; desc = "disabled"; };
            ENABLED = 1 { name = "Enabled"; desc = "enabled"; };
        };

        field {
            name = "tt21_enf2";
            desc = "Control of teletext in line 21 in the even field.";
            sw = rw;
            hw = r;
            encode = DATE_COEFF7_tt21_enf2_enum;
            reset = 0x0;
        } tt21_enf2[14:14];

        enum DATE_COEFF7_tt20_enf2_enum {
            DISABLED = 0 { name = "Disabled"; desc = "disabled"; };
            ENABLED = 1 { name = "Enabled"; desc = "enabled"; };
        };

        field {
            name = "tt20_enf2";
            desc = "Control of teletext in line 20 in the even field.";
            sw = rw;
            hw = r;
            encode = DATE_COEFF7_tt20_enf2_enum;
            reset = 0x0;
        } tt20_enf2[13:13];

        enum DATE_COEFF7_tt19_enf2_enum {
            DISABLED = 0 { name = "Disabled"; desc = "disabled"; };
            ENABLED = 1 { name = "Enabled"; desc = "enabled"; };
        };

        field {
            name = "tt19_enf2";
            desc = "Control of teletext in line 19 in the even field.";
            sw = rw;
            hw = r;
            encode = DATE_COEFF7_tt19_enf2_enum;
            reset = 0x0;
        } tt19_enf2[12:12];

        enum DATE_COEFF7_tt18_enf2_enum {
            DISABLED = 0 { name = "Disabled"; desc = "disabled"; };
            ENABLED = 1 { name = "Enabled"; desc = "enabled"; };
        };

        field {
            name = "tt18_enf2";
            desc = "Control of teletext in line 18 in the even field.";
            sw = rw;
            hw = r;
            encode = DATE_COEFF7_tt18_enf2_enum;
            reset = 0x0;
        } tt18_enf2[11:11];

        enum DATE_COEFF7_tt17_enf2_enum {
            DISABLED = 0 { name = "Disabled"; desc = "disabled"; };
            ENABLED = 1 { name = "Enabled"; desc = "enabled"; };
        };

        field {
            name = "tt17_enf2";
            desc = "Control of teletext in line 17 in the even field.";
            sw = rw;
            hw = r;
            encode = DATE_COEFF7_tt17_enf2_enum;
            reset = 0x0;
        } tt17_enf2[10:10];

        enum DATE_COEFF7_tt16_enf2_enum {
            DISABLED = 0 { name = "Disabled"; desc = "disabled"; };
            ENABLED = 1 { name = "Enabled"; desc = "enabled"; };
        };

        field {
            name = "tt16_enf2";
            desc = "Control of teletext in line 16 in the even field.";
            sw = rw;
            hw = r;
            encode = DATE_COEFF7_tt16_enf2_enum;
            reset = 0x0;
        } tt16_enf2[9:9];

        enum DATE_COEFF7_tt15_enf2_enum {
            DISABLED = 0 { name = "Disabled"; desc = "disabled"; };
            ENABLED = 1 { name = "Enabled"; desc = "enabled"; };
        };

        field {
            name = "tt15_enf2";
            desc = "Control of teletext in line 15 in the even field.";
            sw = rw;
            hw = r;
            encode = DATE_COEFF7_tt15_enf2_enum;
            reset = 0x0;
        } tt15_enf2[8:8];

        enum DATE_COEFF7_tt14_enf2_enum {
            DISABLED = 0 { name = "Disabled"; desc = "disabled"; };
            ENABLED = 1 { name = "Enabled"; desc = "enabled"; };
        };

        field {
            name = "tt14_enf2";
            desc = "Control of teletext in line 14 in the even field.";
            sw = rw;
            hw = r;
            encode = DATE_COEFF7_tt14_enf2_enum;
            reset = 0x0;
        } tt14_enf2[7:7];

        enum DATE_COEFF7_tt13_enf2_enum {
            DISABLED = 0 { name = "Disabled"; desc = "disabled"; };
            ENABLED = 1 { name = "Enabled"; desc = "enabled"; };
        };

        field {
            name = "tt13_enf2";
            desc = "Control of teletext in line 13 in the even field.";
            sw = rw;
            hw = r;
            encode = DATE_COEFF7_tt13_enf2_enum;
            reset = 0x0;
        } tt13_enf2[6:6];

        enum DATE_COEFF7_tt12_enf2_enum {
            DISABLED = 0 { name = "Disabled"; desc = "disabled"; };
            ENABLED = 1 { name = "Enabled"; desc = "enabled"; };
        };

        field {
            name = "tt12_enf2";
            desc = "Control of teletext in line 12 in the even field.";
            sw = rw;
            hw = r;
            encode = DATE_COEFF7_tt12_enf2_enum;
            reset = 0x0;
        } tt12_enf2[5:5];

        enum DATE_COEFF7_tt11_enf2_enum {
            DISABLED = 0 { name = "Disabled"; desc = "disabled"; };
            ENABLED = 1 { name = "Enabled"; desc = "enabled"; };
        };

        field {
            name = "tt11_enf2";
            desc = "Control of teletext in line 11 in the even field.";
            sw = rw;
            hw = r;
            encode = DATE_COEFF7_tt11_enf2_enum;
            reset = 0x0;
        } tt11_enf2[4:4];

        enum DATE_COEFF7_tt10_enf2_enum {
            DISABLED = 0 { name = "Disabled"; desc = "disabled"; };
            ENABLED = 1 { name = "Enabled"; desc = "enabled"; };
        };

        field {
            name = "tt10_enf2";
            desc = "Control of teletext in line 10 in the even field.";
            sw = rw;
            hw = r;
            encode = DATE_COEFF7_tt10_enf2_enum;
            reset = 0x0;
        } tt10_enf2[3:3];

        enum DATE_COEFF7_tt09_enf2_enum {
            DISABLED = 0 { name = "Disabled"; desc = "disabled"; };
            ENABLED = 1 { name = "Enabled"; desc = "enabled"; };
        };

        field {
            name = "tt09_enf2";
            desc = "Control of teletext in line 9 in the even field.";
            sw = rw;
            hw = r;
            encode = DATE_COEFF7_tt09_enf2_enum;
            reset = 0x0;
        } tt09_enf2[2:2];

        enum DATE_COEFF7_tt08_enf2_enum {
            DISABLED = 0 { name = "Disabled"; desc = "disabled"; };
            ENABLED = 1 { name = "Enabled"; desc = "enabled"; };
        };

        field {
            name = "tt08_enf2";
            desc = "Control of teletext in line 8 in the even field.";
            sw = rw;
            hw = r;
            encode = DATE_COEFF7_tt08_enf2_enum;
            reset = 0x0;
        } tt08_enf2[1:1];

        enum DATE_COEFF7_tt07_enf2_enum {
            DISABLED = 0 { name = "Disabled"; desc = "disabled"; };
            ENABLED = 1 { name = "Enabled"; desc = "enabled"; };
        };

        field {
            name = "tt07_enf2";
            desc = "Control of teletext in line 7 in the even field.";
            sw = rw;
            hw = r;
            encode = DATE_COEFF7_tt07_enf2_enum;
            reset = 0x0;
        } tt07_enf2[0:0];
    } DATE_COEFF7 @ 0xC21C;

    reg {
        name = "DATE teletext configuration register";
        desc = "DATE_COEFF8 is a DATE teletext configuration register.

Data sheet 11.2.4 DATE_COEFF8 (offset 0xC220, printed page 11-215, `datasheet.txt` line 45060).";

        field {
            name = "tt_staddr";
            desc = "Start address of the teletext data.";
            sw = rw;
            hw = r;
            reset = 0x0;
        } tt_staddr[31:0];
    } DATE_COEFF8 @ 0xC220;

    reg {
        name = "DATE teletext configuration register";
        desc = "DATE_COEFF9 is a DATE teletext configuration register.

Data sheet 11.2.4 DATE_COEFF9 (offset 0xC224, printed page 11-215, `datasheet.txt` line 45079).";

        field {
            name = "tt_edaddr";
            desc = "End address of the teletext data.";
            sw = rw;
            hw = r;
            reset = 0x0;
        } tt_edaddr[31:0];
    } DATE_COEFF9 @ 0xC224;

    reg {
        name = "DATE teletext configuration register";
        desc = "DATE teletext configuration register.

Data sheet 11.2.4 DATE_COEFF10 (offset 0xC228, printed page 11-216, `datasheet.txt` line 45113).";

        field {
            name = "tt_ready";
            desc = "When software sets related parameters through the bus, this bit is set to 1 and the teletext module starts to work. When the teletext module completes data transfer, this bit is set to 0. The bit status can be queried through software for the next configuration.";
            sw = rw;
            hw = r;
            reset = 0x0;
        } tt_ready[31:31];

        enum DATE_COEFF10_nabts_100ire_enum {
            V_70_IRE = 0 { name = "V 70 Ire"; desc = "70 IRE"; };
            V_100_IRE = 1 { name = "V 100 Ire"; desc = "100 IRE"; };
        };

        field {
            name = "nabts_100ire";
            desc = "NABTS-NTSC data height.";
            sw = rw;
            hw = r;
            encode = DATE_COEFF10_nabts_100ire_enum;
            reset = 0x0;
        } nabts_100ire[12:12];

        enum DATE_COEFF10_full_page_enum {
            NORMAL_MODE_TELETEXT = 0 { name = "Normal Mode Teletext"; desc = "normal mode. The teletext data is transmitted from the blanking line."; };
            FULL_PAGE_MODE = 1 { name = "Full Page Mode"; desc = "full page mode. The teletext data can also be transmitted from the active video region."; };
        };

        field {
            name = "full_page";
            desc = "Teletext data transmission mode.";
            sw = rw;
            hw = r;
            encode = DATE_COEFF10_full_page_enum;
            reset = 0x0;
        } full_page[11:11];

        enum DATE_COEFF10_tt_highest_enum {
            TELETEXT_DATA_HAS = 0 { name = "Teletext Data Has"; desc = "The teletext data has the highest priority."; };
            TELETEXT_DATA_HAS_2 = 1 { name = "Teletext Data Has 2"; desc = "The teletext data has the lowest priority. Teletext mode. This field is set to 01 in 625-line mode, indicating WST-PAL. This field is set to 10 in 525-line mode, indicating NABTS-NTSC."; };
        };

        field {
            name = "tt_highest";
            desc = "Teletext priority control.";
            sw = rw;
            hw = r;
            encode = DATE_COEFF10_tt_highest_enum;
            reset = 0x0;
        } tt_highest[10:10];

        field {
            name = "tt_mode";
            desc = "tt_mode";
            sw = rw;
            hw = r;
            reset = 0x0;
        } tt_mode[9:8];

        field {
            name = "tt_pktoff";
            desc = "tt_pktoff";
            sw = rw;
            hw = r;
            reset = 0x0;
        } tt_pktoff[7:0];
    } DATE_COEFF10 @ 0xC228;

    reg {
        name = "DATE closed caption configuration register";
        desc = "DATE_COEFF11 is a DATE closed caption configuration register.

Data sheet 11.2.4 DATE_COEFF11 (offset 0xC22C, printed page 11-217, `datasheet.txt` line 45171).";

        enum DATE_COEFF11_cc_enf1_enum {
            DISABLED = 0 { name = "Disabled"; desc = "disabled"; };
            ENABLED = 1 { name = "Enabled"; desc = "enabled"; };
        };

        field {
            name = "cc_enf1";
            desc = "Closed caption odd field enable.";
            sw = rw;
            hw = r;
            encode = DATE_COEFF11_cc_enf1_enum;
            reset = 0x0;
        } cc_enf1[21:21];

        enum DATE_COEFF11_cc_enf2_enum {
            DISABLED = 0 { name = "Disabled"; desc = "disabled"; };
            ENABLED = 1 { name = "Enabled"; desc = "enabled"; };
        };

        field {
            name = "cc_enf2";
            desc = "Closed caption even field enable.";
            sw = rw;
            hw = r;
            encode = DATE_COEFF11_cc_enf2_enum;
            reset = 0x0;
        } cc_enf2[20:20];

        field {
            name = "date_clf1";
            desc = "Configuration line of the closed caption odd field.";
            sw = rw;
            hw = r;
            reset = 0x0;
        } date_clf1[19:10];

        field {
            name = "date_clf2";
            desc = "Configuration line of the closed caption even field.";
            sw = rw;
            hw = r;
            reset = 0x0;
        } date_clf2[9:0];
    } DATE_COEFF11 @ 0xC22C;

    reg {
        name = "DATE closed caption configuration register";
        desc = "DATE_COEFF12 is a DATE closed caption configuration register.

Data sheet 11.2.4 DATE_COEFF12 (offset 0xC230, printed page 11-217, `datasheet.txt` line 45202).";

        field {
            name = "cc_f1data";
            desc = "Data of the closed caption odd field.";
            sw = rw;
            hw = r;
            reset = 0x0;
        } cc_f1data[31:16];

        field {
            name = "cc_f2data";
            desc = "Data of the closed caption even field.";
            sw = rw;
            hw = r;
            reset = 0x0;
        } cc_f2data[15:0];
    } DATE_COEFF12 @ 0xC230;

    reg {
        name = "DATE CGMS configuration register";
        desc = "DATE_COEFF13 is a DATE CGMS configuration register.

Data sheet 11.2.4 DATE_COEFF13 (offset 0xC234, printed page 11-218, `datasheet.txt` line 45232).";

        enum DATE_COEFF13_cg_enf1_enum {
            DISABLED = 0 { name = "Disabled"; desc = "disabled"; };
            ENABLED = 1 { name = "Enabled"; desc = "enabled"; };
        };

        field {
            name = "cg_enf1";
            desc = "CGMS odd field enable.";
            sw = rw;
            hw = r;
            encode = DATE_COEFF13_cg_enf1_enum;
            reset = 0x0;
        } cg_enf1[21:21];

        enum DATE_COEFF13_cg_enf2_enum {
            DISABLED = 0 { name = "Disabled"; desc = "disabled"; };
            ENABLED = 1 { name = "Enabled"; desc = "enabled"; };
        };

        field {
            name = "cg_enf2";
            desc = "CGMS even field enable.";
            sw = rw;
            hw = r;
            encode = DATE_COEFF13_cg_enf2_enum;
            reset = 0x0;
        } cg_enf2[20:20];

        field {
            name = "cg_f1data";
            desc = "Data of the CGMS odd field.";
            sw = rw;
            hw = r;
            reset = 0x0;
        } cg_f1data[19:0];
    } DATE_COEFF13 @ 0xC234;

    reg {
        name = "DATE CGMS configuration register";
        desc = "DATE_COEFF14 is a DATE CGMS configuration register.

Data sheet 11.2.4 DATE_COEFF14 (offset 0xC238, printed page 11-218, `datasheet.txt` line 45264).";

        field {
            name = "cg_f2data";
            desc = "Data of the CGMS even field.";
            sw = rw;
            hw = r;
            reset = 0x0;
        } cg_f2data[19:0];
    } DATE_COEFF14 @ 0xC238;

    reg {
        name = "DATE WSS configuration register";
        desc = "DATE WSS configuration register.

Data sheet 11.2.4 DATE_COEFF15 (offset 0xC23C, printed page 11-219, `datasheet.txt` line 45301).";

        enum DATE_COEFF15_wss_en_enum {
            DISABLED = 0 { name = "Disabled"; desc = "disabled"; };
            ENABLED = 1 { name = "Enabled"; desc = "enabled"; };
        };

        field {
            name = "wss_en";
            desc = "WSS enable.";
            sw = rw;
            hw = r;
            encode = DATE_COEFF15_wss_en_enum;
            reset = 0x0;
        } wss_en[14:14];

        field {
            name = "wss_data";
            desc = "WSS data.";
            sw = rw;
            hw = r;
            reset = 0x0;
        } wss_data[13:0];
    } DATE_COEFF15 @ 0xC23C;

    reg {
        name = "DATE VPS configuration register";
        desc = "DATE_COEFF16 is a DATE VPS configuration register.

Data sheet 11.2.4 DATE_COEFF16 (offset 0xC240, printed page 11-219, `datasheet.txt` line 45328).";

        enum DATE_COEFF16_vps_en_enum {
            DISABLED = 0 { name = "Disabled"; desc = "disabled"; };
            ENABLED = 1 { name = "Enabled"; desc = "enabled"; };
        };

        field {
            name = "vps_en";
            desc = "VPS enable.";
            sw = rw;
            hw = r;
            encode = DATE_COEFF16_vps_en_enum;
            reset = 0x0;
        } vps_en[24:24];

        field {
            name = "vps_data";
            desc = "VPS data from bit 23 to bit 0. Bit 0 is the LSB.";
            sw = rw;
            hw = r;
            reset = 0x0;
        } vps_data[23:0];
    } DATE_COEFF16 @ 0xC240;

    reg {
        name = "DATE VPS configuration register";
        desc = "DATE_COEFF17 is a DATE VPS configuration register.

Data sheet 11.2.4 DATE_COEFF17 (offset 0xC244, printed page 11-220, `datasheet.txt` line 45362).";

        field {
            name = "vps_data";
            desc = "VPS data from bit 55 to bit 24. Bit 0 is the LSB.";
            sw = rw;
            hw = r;
            reset = 0x0;
        } vps_data[31:0];
    } DATE_COEFF17 @ 0xC244;

    reg {
        name = "DATE VPS configuration register";
        desc = "DATE_COEFF18 is a DATE VPS configuration register.

Data sheet 11.2.4 DATE_COEFF18 (offset 0xC248, printed page 11-220, `datasheet.txt` line 45381).";

        field {
            name = "vps_data";
            desc = "VPS data from bit 87 to bit 56. Bit 0 is the LSB.";
            sw = rw;
            hw = r;
            reset = 0x0;
        } vps_data[31:0];
    } DATE_COEFF18 @ 0xC248;

    reg {
        name = "DATE VPS configuration register";
        desc = "DATE VPS configuration register.

Data sheet 11.2.4 DATE_COEFF19 (offset 0xC24C, printed page 11-221, `datasheet.txt` line 45414).";

        field {
            name = "vps_data";
            desc = "VPS data from bit 103 to bit 88. Bit 0 is the LSB.";
            sw = rw;
            hw = r;
            reset = 0x0;
        } vps_data[15:0];
    } DATE_COEFF19 @ 0xC24C;

    reg {
        name = "DATE teletext configuration register";
        desc = "DATE_COEFF20 is a DATE teletext configuration register.

Data sheet 11.2.4 DATE_COEFF20 (offset 0xC250, printed page 11-221, `datasheet.txt` line 45436).";

        enum DATE_COEFF20_tt06_enf1_enum {
            DISABLED = 0 { name = "Disabled"; desc = "disabled"; };
            ENABLED = 1 { name = "Enabled"; desc = "enabled"; };
        };

        field {
            name = "tt06_enf1";
            desc = "Control of teletext in line 6 in the odd field.";
            sw = rw;
            hw = r;
            encode = DATE_COEFF20_tt06_enf1_enum;
            reset = 0x0;
        } tt06_enf1[2:2];

        enum DATE_COEFF20_tt06_enf2_enum {
            DISABLED = 0 { name = "Disabled"; desc = "disabled"; };
            ENABLED = 1 { name = "Enabled"; desc = "enabled"; };
        };

        field {
            name = "tt06_enf2";
            desc = "Control of teletext in line 6 in the even field.";
            sw = rw;
            hw = r;
            encode = DATE_COEFF20_tt06_enf2_enum;
            reset = 0x0;
        } tt06_enf2[1:1];

        enum DATE_COEFF20_tt05_enf2_enum {
            DISABLED = 0 { name = "Disabled"; desc = "disabled"; };
            ENABLED = 1 { name = "Enabled"; desc = "enabled"; };
        };

        field {
            name = "tt05_enf2";
            desc = "Control of teletext in line 5 in the even field.";
            sw = rw;
            hw = r;
            encode = DATE_COEFF20_tt05_enf2_enum;
            reset = 0x0;
        } tt05_enf2[0:0];
    } DATE_COEFF20 @ 0xC250;

    reg {
        name = "DATE output matrix control register";
        desc = "DATE_COEFF21 is the DATE output matrix control register.

Data sheet 11.2.4 DATE_COEFF21 (offset 0xC254, printed page 11-222, `datasheet.txt` line 45478).";

        enum DATE_COEFF21_dac5_in_sel_enum {
            V_0 = 0 { name = "V 0"; desc = "0"; };
            CVBS = 1 { name = "Cvbs"; desc = "CVBS"; };
            G_Y = 2 { name = "G Y"; desc = "G/Y"; };
            B_PB = 3 { name = "B Pb"; desc = "B/Pb"; };
            R_PR = 4 { name = "R Pr"; desc = "R/Pr"; };
            SVIDEO_Y = 5 { name = "Svideo Y"; desc = "svideo_y"; };
            SVIDEO_C = 6 { name = "Svideo C"; desc = "svideo_c"; };
            V_0_2 = 7 { name = "V 0 2"; desc = "0"; };
        };

        field {
            name = "dac5_in_sel";
            desc = "DAC5 output mode select.";
            sw = rw;
            hw = r;
            encode = DATE_COEFF21_dac5_in_sel_enum;
            reset = 0x6;
        } dac5_in_sel[22:20];

        enum DATE_COEFF21_dac4_in_sel_enum {
            V_0 = 0 { name = "V 0"; desc = "0"; };
            CVBS = 1 { name = "Cvbs"; desc = "CVBS"; };
            G_Y = 2 { name = "G Y"; desc = "G/Y"; };
            B_PB = 3 { name = "B Pb"; desc = "B/Pb"; };
            R_PR = 4 { name = "R Pr"; desc = "R/Pr"; };
            SVIDEO_Y = 5 { name = "Svideo Y"; desc = "svideo_y"; };
            SVIDEO_C = 6 { name = "Svideo C"; desc = "svideo_c"; };
            V_0_2 = 7 { name = "V 0 2"; desc = "0"; };
        };

        field {
            name = "dac4_in_sel";
            desc = "DAC4 output mode select.";
            sw = rw;
            hw = r;
            encode = DATE_COEFF21_dac4_in_sel_enum;
            reset = 0x5;
        } dac4_in_sel[18:16];

        enum DATE_COEFF21_dac3_in_sel_enum {
            V_0 = 0 { name = "V 0"; desc = "0"; };
            CVBS = 1 { name = "Cvbs"; desc = "CVBS"; };
            G_Y = 2 { name = "G Y"; desc = "G/Y"; };
            B_PB = 3 { name = "B Pb"; desc = "B/Pb"; };
            R_PR = 4 { name = "R Pr"; desc = "R/Pr"; };
            SVIDEO_Y = 5 { name = "Svideo Y"; desc = "svideo_y"; };
            SVIDEO_C = 6 { name = "Svideo C"; desc = "svideo_c"; };
            V_0_2 = 7 { name = "V 0 2"; desc = "0"; };
        };

        field {
            name = "dac3_in_sel";
            desc = "DAC3 output mode select.";
            sw = rw;
            hw = r;
            encode = DATE_COEFF21_dac3_in_sel_enum;
            reset = 0x1;
        } dac3_in_sel[14:12];

        enum DATE_COEFF21_dac2_in_sel_enum {
            V_0 = 0 { name = "V 0"; desc = "0"; };
            CVBS = 1 { name = "Cvbs"; desc = "CVBS"; };
            G_Y = 2 { name = "G Y"; desc = "G/Y"; };
            B_PB = 3 { name = "B Pb"; desc = "B/Pb"; };
            R_PR = 4 { name = "R Pr"; desc = "R/Pr"; };
            SVIDEO_Y = 5 { name = "Svideo Y"; desc = "svideo_y"; };
            SVIDEO_C = 6 { name = "Svideo C"; desc = "svideo_c"; };
            V_0_2 = 7 { name = "V 0 2"; desc = "0"; };
        };

        field {
            name = "dac2_in_sel";
            desc = "DAC2 output mode select.";
            sw = rw;
            hw = r;
            encode = DATE_COEFF21_dac2_in_sel_enum;
            reset = 0x4;
        } dac2_in_sel[10:8];

        enum DATE_COEFF21_dac1_in_sel_enum {
            V_0 = 0 { name = "V 0"; desc = "0"; };
            CVBS = 1 { name = "Cvbs"; desc = "CVBS"; };
            G_Y = 2 { name = "G Y"; desc = "G/Y"; };
            B_PB = 3 { name = "B Pb"; desc = "B/Pb"; };
            R_PR = 4 { name = "R Pr"; desc = "R/Pr"; };
            SVIDEO_Y = 5 { name = "Svideo Y"; desc = "svideo_y"; };
            SVIDEO_C = 6 { name = "Svideo C"; desc = "svideo_c"; };
            V_0_2 = 7 { name = "V 0 2"; desc = "0"; };
        };

        field {
            name = "dac1_in_sel";
            desc = "DAC1 output mode select.";
            sw = rw;
            hw = r;
            encode = DATE_COEFF21_dac1_in_sel_enum;
            reset = 0x3;
        } dac1_in_sel[6:4];

        enum DATE_COEFF21_dac0_in_sel_enum {
            V_0 = 0 { name = "V 0"; desc = "0"; };
            CVBS = 1 { name = "Cvbs"; desc = "CVBS"; };
            G_Y = 2 { name = "G Y"; desc = "G/Y"; };
            B_PB = 3 { name = "B Pb"; desc = "B/Pb"; };
            R_PR = 4 { name = "R Pr"; desc = "R/Pr"; };
            SVIDEO_Y = 5 { name = "Svideo Y"; desc = "svideo_y"; };
            SVIDEO_C = 6 { name = "Svideo C"; desc = "svideo_c"; };
            V_0_2 = 7 { name = "V 0 2"; desc = "0"; };
        };

        field {
            name = "dac0_in_sel";
            desc = "DAC0 output mode select.";
            sw = rw;
            hw = r;
            encode = DATE_COEFF21_dac0_in_sel_enum;
            reset = 0x2;
        } dac0_in_sel[2:0];
    } DATE_COEFF21 @ 0xC254;

    reg {
        name = "DATE discrete time oscillator (DTO) initial phase configuration register";
        desc = "DATE_COEFF22 is the DATE DTO initial phase configuration register.

Data sheet 11.2.4 DATE_COEFF22 (offset 0xC258, printed page 11-224, `datasheet.txt` line 45596).";

        field {
            name = "video_phase_delta";
            desc = "DTO initial phase.";
            sw = rw;
            hw = r;
            reset = 0x0;
        } video_phase_delta[10:0];
    } DATE_COEFF22 @ 0xC258;

    reg {
        name = "DATE video output delay configuration register";
        desc = "DATE_COEFF23 is the DATE video output delay configuration register.

Data sheet 11.2.4 DATE_COEFF23 (offset 0xC25C, printed page 11-225, `datasheet.txt` line 45628).";

        field {
            name = "dac5_out_dly";
            desc = "DAC5 output delay cycle. The value is in the unit of a 54 MHz clock cycle and the value n indicates n delay cycles.";
            sw = rw;
            hw = r;
            reset = 0x0;
        } dac5_out_dly[22:20];

        field {
            name = "dac4_out_dly";
            desc = "DAC4 output delay cycle. The value is in the unit of a 54 MHz clock cycle and the value n indicates n delay cycles.";
            sw = rw;
            hw = r;
            reset = 0x0;
        } dac4_out_dly[18:16];

        field {
            name = "dac3_out_dly";
            desc = "DAC3 output delay cycle. The value is in the unit of a 54 MHz clock cycle and the value n indicates n delay cycles.";
            sw = rw;
            hw = r;
            reset = 0x0;
        } dac3_out_dly[14:12];

        field {
            name = "dac2_out_dly";
            desc = "DAC2 output delay cycle. The value is in the unit of a 54 MHz clock cycle and the value n indicates n delay cycles.";
            sw = rw;
            hw = r;
            reset = 0x0;
        } dac2_out_dly[10:8];

        field {
            name = "dac1_out_dly";
            desc = "DAC1 output delay cycle. The value is in the unit of a 54 MHz clock cycle and the value n indicates n delay cycles.";
            sw = rw;
            hw = r;
            reset = 0x0;
        } dac1_out_dly[6:4];

        field {
            name = "dac0_out_dly";
            desc = "DAC0 output delay cycle. The value is in the unit of a 54 MHz clock cycle and the value n indicates n delay cycles.";
            sw = rw;
            hw = r;
            reset = 0x0;
        } dac0_out_dly[2:0];
    } DATE_COEFF23 @ 0xC25C;

    reg {
        name = "DATE interrupt mask register";
        desc = "DATE_ISRMASK is the DATE interrupt mask register.

Data sheet 11.2.4 DATE_ISRMASK (offset 0xC280, printed page 11-226, `datasheet.txt` line 45700).";

        enum DATE_ISRMASK_tt_mask_enum {
            ENABLED = 0 { name = "Enabled"; desc = "enabled"; };
            MASKED = 1 { name = "Masked"; desc = "masked"; };
        };

        field {
            name = "tt_mask";
            desc = "Teletext interrupt mask.";
            sw = rw;
            hw = r;
            encode = DATE_ISRMASK_tt_mask_enum;
            reset = 0x0;
        } tt_mask[0:0];
    } DATE_ISRMASK @ 0xC280;

    reg {
        name = "DATE interrupt status register";
        desc = "DATE_ISRSTATE is the DATE interrupt status register.

Data sheet 11.2.4 DATE_ISRSTATE (offset 0xC284, printed page 11-226, `datasheet.txt` line 45728).";

        field {
            name = "tt_status";
            desc = "Teletext interrupt flag. After the DATE module reads all the teletext data, the bit is set to 1. Writing 1 to this bit clears this bit.";
            sw = rw;
            hw = w;
            onwrite = woclr;
            reset = 0x0;
        } tt_status[0:0];
    } DATE_ISRSTATE @ 0xC284;

    reg {
        name = "DATE interrupt register";
        desc = "DATE_ISR is the DATE interrupt register.

Data sheet 11.2.4 DATE_ISR (offset 0xC288, printed page 11-227, `datasheet.txt` line 45769).";

        enum DATE_ISR_tt_int_enum {
            NO_INTERRUPT_GENERATED = 0 { name = "No Interrupt Generated"; desc = "No interrupt is generated."; };
            INTERRUPT_GENERATED = 1 { name = "Interrupt Generated"; desc = "An interrupt is generated."; };
        };

        field {
            name = "tt_int";
            desc = "Teletext interrupt. It is the interrupt status after tt_status is masked by tt_mask.";
            sw = rw;
            hw = r;
            encode = DATE_ISR_tt_int_enum;
            reset = 0x0;
        } tt_int[0:0];
    } DATE_ISR @ 0xC288;

    reg {
        name = "DATE version register";
        desc = "DATE_VERSION is the DATE version register. The data sheet lists no bit fields for it.

Data sheet 11.2.4 DATE_VERSION (offset 0xC290, printed page 11-227, `datasheet.txt` line 45796).";

        field {
            name = "value";
            desc = "Register value (the data sheet gives no bit table for this register).";
            sw = rw;
            hw = r;
            reset = 0x24;
        } value[31:0];
    } DATE_VERSION @ 0xC290;

    reg {
        name = "DATE1 norm parameter configuration register";
        desc = "DATE1_COEFF0 is the DATE1 norm parameter configuration register.

Data sheet 11.2.4 DATE1_COEFF0 (offset 0xC400, printed page 11-228, `datasheet.txt` line 45824).";

        enum DATE1_COEFF0_clpf_sel_enum {
            V_1_1_MHZ = 0 { name = "V 1 1 Mhz"; desc = "1.1 MHz (NTSC)"; };
            V_1_3_MHZ = 1 { name = "V 1 3 Mhz"; desc = "1.3 MHz (PAL)"; };
            V_1_6_MHZ = 2 { name = "V 1 6 Mhz"; desc = "1.6 MHz (for test)"; };
            RESERVED = 3 { name = "Reserved"; desc = "reserved"; };
        };

        field {
            name = "clpf_sel";
            desc = "Bandwidth select of the chrominance low-pass filter.";
            sw = rw;
            hw = r;
            encode = DATE1_COEFF0_clpf_sel_enum;
            reset = 0x1;
        } clpf_sel[31:30];

        enum DATE1_COEFF0_dis_ire_enum {
            BLACK_LEVEL_7 = 0 { name = "Black Level 7"; desc = "The black level is 7.5 IRE higher than the blanking level."; };
            BLACK_LEVEL_EQUAL = 1 { name = "Black Level Equal"; desc = "The black level is equal to the blanking level."; };
        };

        field {
            name = "dis_ire";
            desc = "For the (M) NTSC and (M, N) PAL norms, the black level is 7.5 IRE higher than the blanking level; for other norms, the black level is equal to the blanking level. This bit controls whether the black level is 7.5 IRE higher than the blanking level.";
            sw = rw;
            hw = r;
            encode = DATE1_COEFF0_dis_ire_enum;
            reset = 0x0;
        } dis_ire[29:29];

        field {
            name = "reserved_nz";
            desc = "Reserved (RW in the data sheet); bit 28 reads 1: the data sheet total reset value is 0x5284_14FC.";
            sw = rw;
            hw = r;
            reset = 0x4;
        } reserved_nz[28:26];

        enum DATE1_COEFF0_scanline_enum {
            V_525_LINES_FRAME = 0 { name = "V 525 Lines Frame"; desc = "525 lines in a frame"; };
            V_625_LINES_FRAME = 1 { name = "V 625 Lines Frame"; desc = "625 lines in a frame"; };
        };

        field {
            name = "scanline";
            desc = "Number of scanned lines in each frame based on norms. For the (M) NTSC, NTSC-J, and (M) PAL norm, each line contains 525 lines; for the (B, D, J, H, I) PAL, (N) PAL, and (Nc) PAL norms, each frame contains 625 lines.";
            sw = rw;
            hw = r;
            encode = DATE1_COEFF0_scanline_enum;
            reset = 0x1;
        } scanline[25:25];

        enum DATE1_COEFF0_rgb_en_enum {
            YPBPR = 0 { name = "Ypbpr"; desc = "YPbPr"; };
            RGB = 1 { name = "Rgb"; desc = "RGB"; };
        };

        field {
            name = "rgb_en";
            desc = "When intf_sel is set to 100, this bit determines whether the component signal is RGB or YPbPr.";
            sw = rw;
            hw = r;
            encode = DATE1_COEFF0_rgb_en_enum;
            reset = 0x0;
        } rgb_en[24:24];

        enum DATE1_COEFF0_vbi_lpf_en_enum {
            DISABLED = 0 { name = "Disabled"; desc = "disabled"; };
            ENABLED = 1 { name = "Enabled"; desc = "enabled"; };
        };

        field {
            name = "vbi_lpf_en";
            desc = "VBI data low-pass filtering enable.";
            sw = rw;
            hw = r;
            encode = DATE1_COEFF0_vbi_lpf_en_enum;
            reset = 0x1;
        } vbi_lpf_en[23:23];

        enum DATE1_COEFF0_fm_sel_enum {
            SIN_USED_SECAM = 0 { name = "Sin Used Secam"; desc = "sin used for SECAM frequency modulation"; };
            COS_USED_SECAM = 1 { name = "Cos Used Secam"; desc = "cos used for SECAM frequency modulation"; };
        };

        field {
            name = "fm_sel";
            desc = "FMSECAM frequency modulation select.";
            sw = rw;
            hw = r;
            encode = DATE1_COEFF0_fm_sel_enum;
            reset = 0x0;
        } fm_sel[22:22];

        field {
            name = "style_sel";
            desc = "CVBS/S-Video output signal norm when this bit works with the scanline bit. When the scanline bit is 0 (525 scanned lines in a frame), the definition of the style_sel bit is as follows: 0x1: (M) NTSC 0x2: NTSC-J 0x4: (M) PAL Other values: reserved When the scanline bit is 1 (625 scanned lines in a frame), the definition of the style_sel bit is as follows: 0x1: (B, D, G, H, I) PAL 0x2: (N) PAL 0x4: (Nc) PAL 0x8: SECAM Other values: reserved";
            sw = rw;
            hw = r;
            reset = 0x1;
        } style_sel[21:18];

        field {
            name = "sync_mode_sel";
            desc = "bit[17]: specifies whether there are sync signals in three channels during component output. This bit takes effect only when the sync_mode_scart bit is set to 0. bit[17] is valid only when the intf_sel is set to 100 (component output enabled). The definition of bit[17] is as follows: 0: Only one channel contains sync signals using component output. 1: Three channels contain sync signals during component output. When bit[17] is set to 0, the sync channel must be the Y channel for YPbPr output and G channel for RGB output. bit[16]: specifies whether there are blanking radixes during RGB output. bit[16] is valid only when the intf_sel is set to 100 and the rgb_en bit is set to 1. The definition of bit[16] is as follows: 0: There are no blanking radixes during RGB output. 1: There are blanking radixes during RGB output.";
            sw = rw;
            hw = r;
            reset = 0x0;
        } sync_mode_sel[17:16];

        enum DATE1_COEFF0_sync_mode_scart_enum {
            COMPONENT_SYNC_OUTPUT = 0 { name = "Component Sync Output"; desc = "Component sync output is configured based on sync_mode_sel[1]."; };
            COMPONENTS_THREE_CHANNELS = 1 { name = "Components Three Channels"; desc = "The components of the three channels are not overlaid and synchronized. In this case, sync_mode_sel bit[1] must be set to 0."; };
        };

        field {
            name = "sync_mode_scart";
            desc = "Overlay sync control of the components of three channels.";
            sw = rw;
            hw = r;
            encode = DATE1_COEFF0_sync_mode_scart_enum;
            reset = 0x0;
        } sync_mode_scart[15:15];

        enum DATE1_COEFF0_length_sel_enum {
            OUTPUT_ACCORDING_ACTIVE = 0 { name = "Output According Active"; desc = "output according to the active line width in BT.601 mode"; };
            OUTPUT_ACCORDING_ACTIVE_2 = 1 { name = "Output According Active 2"; desc = "output according to the active line width in BT.470 mode. When this bit is set to 0, the active width of the line is 720 pixels. When this bit is set to 1, the active width of the line is 704 pixels for the 625-line norm or 712 pixels for the 525-line norm. Currently, the BT.601 mode and BT.470 mode cannot be changed dynamically. You can change the mode only after reset. The BT.601 mode is recommended and this mode is the default value after power-on reset."; };
        };

        field {
            name = "length_sel";
            desc = "Active width of each video line (in pixel).";
            sw = rw;
            hw = r;
            encode = DATE1_COEFF0_length_sel_enum;
            reset = 0x0;
        } length_sel[14:14];

        enum DATE1_COEFF0_agc_amp_sel_enum {
            AGC_PULSE_GENERATED = 0 { name = "Agc Pulse Generated"; desc = "The AGC pulse is generated based on the on-chip default value (recommended)."; };
            AGC_PULSE_GENERATED_2 = 1 { name = "Agc Pulse Generated 2"; desc = "The AGC pulse is generated based on DATE_COEFF1[amp_outside]."; };
        };

        field {
            name = "agc_amp_sel";
            desc = "AGC pulse select.";
            sw = rw;
            hw = r;
            encode = DATE1_COEFF0_agc_amp_sel_enum;
            reset = 0x0;
        } agc_amp_sel[13:13];

        field {
            name = "luma_dl";
            desc = "Forward or backward offset of the chrominance signal relative to the luminance signal, in the unit of half a pixel width. bit[12]: offset direction of the chrominance signal relative to the luminance signal. 0: backward offset 1: forward offset bit[11:9]: absolute offset of the chrominance signal relative to the luminance signal. The value is in binary format and ranges from 0 to 7. 000: The chrominance signal is aligned with the luminance signal. No adjustment is required. 001-111: The chrominance signal offsets from the luminance signal forward or backward by one to seven units.";
            sw = rw;
            hw = r;
            reset = 0xA;
        } luma_dl[12:9];

        field {
            name = "oversam_en";
            desc = "Level-1 oversampling enable. Both the luminance oversampling and chrominance oversampling are controlled. bit[7]: luminance oversampling enable. 0: disabled 1: enabled bit[6]: chrominance oversampling enable. 0: disabled 1: enabled";
            sw = rw;
            hw = r;
            reset = 0x3;
        } oversam_en[7:6];

        enum DATE1_COEFF0_lunt_en_enum {
            DISABLED = 0 { name = "Disabled"; desc = "disabled"; };
            ENABLED = 1 { name = "Enabled"; desc = "enabled"; };
        };

        field {
            name = "lunt_en";
            desc = "Luminance notch enable.";
            sw = rw;
            hw = r;
            encode = DATE1_COEFF0_lunt_en_enum;
            reset = 0x1;
        } lunt_en[5:5];

        enum DATE1_COEFF0_oversam2_en_enum {
            DISABLED = 0 { name = "Disabled"; desc = "disabled"; };
            ENABLED = 1 { name = "Enabled"; desc = "enabled"; };
        };

        field {
            name = "oversam2_en";
            desc = "Level-2 oversampling enable. Both the luminance channel and chrominance channel are controlled.";
            sw = rw;
            hw = r;
            encode = DATE1_COEFF0_oversam2_en_enum;
            reset = 0x1;
        } oversam2_en[4:4];

        enum DATE1_COEFF0_chlp_en_enum {
            DISABLED = 0 { name = "Disabled"; desc = "disabled"; };
            ENABLED = 1 { name = "Enabled"; desc = "enabled"; };
        };

        field {
            name = "chlp_en";
            desc = "Chrominance low-pass filtering enable.";
            sw = rw;
            hw = r;
            encode = DATE1_COEFF0_chlp_en_enum;
            reset = 0x1;
        } chlp_en[3:3];

        enum DATE1_COEFF0_sylp_en_enum {
            DISABLED = 0 { name = "Disabled"; desc = "disabled"; };
            ENABLED = 1 { name = "Enabled"; desc = "enabled"; };
        };

        field {
            name = "sylp_en";
            desc = "Sync low-pass filtering enable.";
            sw = rw;
            hw = r;
            encode = DATE1_COEFF0_sylp_en_enum;
            reset = 0x1;
        } sylp_en[2:2];

        enum DATE1_COEFF0_chgain_en_enum {
            DISABLED = 0 { name = "Disabled"; desc = "disabled"; };
            ENABLED = 1 { name = "Enabled"; desc = "enabled"; };
        };

        field {
            name = "chgain_en";
            desc = "Chrominance gain enable.";
            sw = rw;
            hw = r;
            encode = DATE1_COEFF0_chgain_en_enum;
            reset = 0x0;
        } chgain_en[1:1];

        enum DATE1_COEFF0_tt_seq_enum {
            FROM_UPPER_BITS = 0 { name = "From Upper Bits"; desc = "from upper bits to lower bits"; };
            FROM_LOWER_BITS = 1 { name = "From Lower Bits"; desc = "from lower bits to upper bits"; };
        };

        field {
            name = "tt_seq";
            desc = "Sequence of transmitting the bits of the teletext data.";
            sw = rw;
            hw = r;
            encode = DATE1_COEFF0_tt_seq_enum;
            reset = 0x0;
        } tt_seq[0:0];
    } DATE1_COEFF0 @ 0xC400;

    reg {
        name = "DATE1 amplitude configuration register";
        desc = "DATE1_COEFF1 is the DATE1 amplitude configuration register.

Data sheet 11.2.4 DATE1_COEFF1 (offset 0xC404, printed page 11-231, `datasheet.txt` line 46010).";

        field {
            name = "c_gain";
            desc = "Adjustment of the chrominance sync gain amplitude.";
            sw = rw;
            hw = r;
            reset = 0x0;
        } c_gain[31:29];

        enum DATE1_COEFF1_cvbs_limit_en_enum {
            DISABLED = 0 { name = "Disabled"; desc = "disabled"; };
            ENABLED = 1 { name = "Enabled"; desc = "enabled"; };
        };

        field {
            name = "cvbs_limit_en";
            desc = "CVBS amplitude limit enable.";
            sw = rw;
            hw = r;
            encode = DATE1_COEFF1_cvbs_limit_en_enum;
            reset = 0x0;
        } cvbs_limit_en[28:28];

        enum DATE1_COEFF1_wss_seq_enum {
            FROM_UPPER_BITS = 0 { name = "From Upper Bits"; desc = "from upper bits to lower bits"; };
            FROM_LOWER_BITS = 1 { name = "From Lower Bits"; desc = "from lower bits to upper bits"; };
        };

        field {
            name = "wss_seq";
            desc = "Sequence of transmitting the bits of the WSS data.";
            sw = rw;
            hw = r;
            encode = DATE1_COEFF1_wss_seq_enum;
            reset = 0x0;
        } wss_seq[27:27];

        enum DATE1_COEFF1_vps_seq_enum {
            FROM_UPPER_BITS = 0 { name = "From Upper Bits"; desc = "from upper bits to lower bits"; };
            FROM_LOWER_BITS = 1 { name = "From Lower Bits"; desc = "from lower bits to upper bits"; };
        };

        field {
            name = "vps_seq";
            desc = "Sequence of transmitting the bits of the VPS data.";
            sw = rw;
            hw = r;
            encode = DATE1_COEFF1_vps_seq_enum;
            reset = 0x0;
        } vps_seq[26:26];

        enum DATE1_COEFF1_cgms_seq_enum {
            FROM_UPPER_BITS = 0 { name = "From Upper Bits"; desc = "from upper bits to lower bits"; };
            FROM_LOWER_BITS = 1 { name = "From Lower Bits"; desc = "from lower bits to upper bits"; };
        };

        field {
            name = "cgms_seq";
            desc = "Sequence of transmitting the bits of the CGMS data.";
            sw = rw;
            hw = r;
            encode = DATE1_COEFF1_cgms_seq_enum;
            reset = 0x0;
        } cgms_seq[25:25];

        enum DATE1_COEFF1_cc_seq_enum {
            FROM_UPPER_BITS = 0 { name = "From Upper Bits"; desc = "from upper bits to lower bits"; };
            FROM_LOWER_BITS = 1 { name = "From Lower Bits"; desc = "from lower bits to upper bits"; };
        };

        field {
            name = "cc_seq";
            desc = "Sequence of transmitting the bits of the closed caption data.";
            sw = rw;
            hw = r;
            encode = DATE1_COEFF1_cc_seq_enum;
            reset = 0x0;
        } cc_seq[24:24];

        enum DATE1_COEFF1_c_limit_en_enum {
            DISABLED = 0 { name = "Disabled"; desc = "disabled"; };
            ENABLED = 1 { name = "Enabled"; desc = "enabled"; };
        };

        field {
            name = "c_limit_en";
            desc = "Chrominance amplitude limit enable.";
            sw = rw;
            hw = r;
            encode = DATE1_COEFF1_c_limit_en_enum;
            reset = 0x0;
        } c_limit_en[23:23];

        field {
            name = "amp_outside";
            desc = "Pulse amplitude input of the external AGC.";
            sw = rw;
            hw = r;
            reset = 0x0;
        } amp_outside[22:13];

        enum DATE1_COEFF1_date_test_en_enum {
            INVALID = 0 { name = "Invalid"; desc = "invalid"; };
            VALID = 1 { name = "Valid"; desc = "valid"; };
        };

        field {
            name = "date_test_en";
            desc = "Test valid signal.";
            sw = rw;
            hw = r;
            encode = DATE1_COEFF1_date_test_en_enum;
            reset = 0x0;
        } date_test_en[12:12];

        field {
            name = "date_test_mode";
            desc = "Test mode signal.";
            sw = rw;
            hw = r;
            reset = 0x0;
        } date_test_mode[11:10];

        field {
            name = "dac_test";
            desc = "DAC test value input.";
            sw = rw;
            hw = r;
            reset = 0x0;
        } dac_test[9:0];
    } DATE1_COEFF1 @ 0xC404;

    reg {
        name = "DATE1 teletext configuration register";
        desc = "DATE1_COEFF7 is a DATE1 teletext configuration register.

Data sheet 11.2.4 DATE1_COEFF7 (offset 0xC41C, printed page 11-233, `datasheet.txt` line 46082).";

        enum DATE1_COEFF7_tt22_enf1_enum {
            DISABLED = 0 { name = "Disabled"; desc = "disabled"; };
            ENABLED = 1 { name = "Enabled"; desc = "enabled"; };
        };

        field {
            name = "tt22_enf1";
            desc = "Control of teletext in line 22 in the odd field.";
            sw = rw;
            hw = r;
            encode = DATE1_COEFF7_tt22_enf1_enum;
            reset = 0x0;
        } tt22_enf1[31:31];

        enum DATE1_COEFF7_tt21_enf1_enum {
            DISABLED = 0 { name = "Disabled"; desc = "disabled"; };
            ENABLED = 1 { name = "Enabled"; desc = "enabled"; };
        };

        field {
            name = "tt21_enf1";
            desc = "Control of teletext in line 21 in the odd field.";
            sw = rw;
            hw = r;
            encode = DATE1_COEFF7_tt21_enf1_enum;
            reset = 0x0;
        } tt21_enf1[30:30];

        enum DATE1_COEFF7_tt20_enf1_enum {
            DISABLED = 0 { name = "Disabled"; desc = "disabled"; };
            ENABLED = 1 { name = "Enabled"; desc = "enabled"; };
        };

        field {
            name = "tt20_enf1";
            desc = "Control of teletext in line 20 in the odd field.";
            sw = rw;
            hw = r;
            encode = DATE1_COEFF7_tt20_enf1_enum;
            reset = 0x0;
        } tt20_enf1[29:29];

        enum DATE1_COEFF7_tt19_enf1_enum {
            DISABLED = 0 { name = "Disabled"; desc = "disabled"; };
            ENABLED = 1 { name = "Enabled"; desc = "enabled"; };
        };

        field {
            name = "tt19_enf1";
            desc = "Control of teletext in line 19 in the odd field.";
            sw = rw;
            hw = r;
            encode = DATE1_COEFF7_tt19_enf1_enum;
            reset = 0x0;
        } tt19_enf1[28:28];

        enum DATE1_COEFF7_tt18_enf1_enum {
            DISABLED = 0 { name = "Disabled"; desc = "disabled"; };
            ENABLED = 1 { name = "Enabled"; desc = "enabled"; };
        };

        field {
            name = "tt18_enf1";
            desc = "Control of teletext in line 18 in the odd field.";
            sw = rw;
            hw = r;
            encode = DATE1_COEFF7_tt18_enf1_enum;
            reset = 0x0;
        } tt18_enf1[27:27];

        enum DATE1_COEFF7_tt17_enf1_enum {
            DISABLED = 0 { name = "Disabled"; desc = "disabled"; };
            ENABLED = 1 { name = "Enabled"; desc = "enabled"; };
        };

        field {
            name = "tt17_enf1";
            desc = "Control of teletext in line 17 in the odd field.";
            sw = rw;
            hw = r;
            encode = DATE1_COEFF7_tt17_enf1_enum;
            reset = 0x0;
        } tt17_enf1[26:26];

        enum DATE1_COEFF7_tt16_enf1_enum {
            DISABLED = 0 { name = "Disabled"; desc = "disabled"; };
            ENABLED = 1 { name = "Enabled"; desc = "enabled"; };
        };

        field {
            name = "tt16_enf1";
            desc = "Control of teletext in line 16 in the odd field.";
            sw = rw;
            hw = r;
            encode = DATE1_COEFF7_tt16_enf1_enum;
            reset = 0x0;
        } tt16_enf1[25:25];

        enum DATE1_COEFF7_tt15_enf1_enum {
            DISABLED = 0 { name = "Disabled"; desc = "disabled"; };
            ENABLED = 1 { name = "Enabled"; desc = "enabled"; };
        };

        field {
            name = "tt15_enf1";
            desc = "Control of teletext in line 15 in the odd field.";
            sw = rw;
            hw = r;
            encode = DATE1_COEFF7_tt15_enf1_enum;
            reset = 0x0;
        } tt15_enf1[24:24];

        enum DATE1_COEFF7_tt14_enf1_enum {
            DISABLED = 0 { name = "Disabled"; desc = "disabled"; };
            ENABLED = 1 { name = "Enabled"; desc = "enabled"; };
        };

        field {
            name = "tt14_enf1";
            desc = "Control of teletext in line 14 in the odd field.";
            sw = rw;
            hw = r;
            encode = DATE1_COEFF7_tt14_enf1_enum;
            reset = 0x0;
        } tt14_enf1[23:23];

        enum DATE1_COEFF7_tt13_enf1_enum {
            DISABLED = 0 { name = "Disabled"; desc = "disabled"; };
            ENABLED = 1 { name = "Enabled"; desc = "enabled"; };
        };

        field {
            name = "tt13_enf1";
            desc = "Control of teletext in line 13 in the odd field.";
            sw = rw;
            hw = r;
            encode = DATE1_COEFF7_tt13_enf1_enum;
            reset = 0x0;
        } tt13_enf1[22:22];

        enum DATE1_COEFF7_tt12_enf1_enum {
            DISABLED = 0 { name = "Disabled"; desc = "disabled"; };
            ENABLED = 1 { name = "Enabled"; desc = "enabled"; };
        };

        field {
            name = "tt12_enf1";
            desc = "Control of teletext in line 12 in the odd field.";
            sw = rw;
            hw = r;
            encode = DATE1_COEFF7_tt12_enf1_enum;
            reset = 0x0;
        } tt12_enf1[21:21];

        enum DATE1_COEFF7_tt11_enf1_enum {
            DISABLED = 0 { name = "Disabled"; desc = "disabled"; };
            ENABLED = 1 { name = "Enabled"; desc = "enabled"; };
        };

        field {
            name = "tt11_enf1";
            desc = "Control of teletext in line 11 in the odd field.";
            sw = rw;
            hw = r;
            encode = DATE1_COEFF7_tt11_enf1_enum;
            reset = 0x0;
        } tt11_enf1[20:20];

        enum DATE1_COEFF7_tt10_enf1_enum {
            DISABLED = 0 { name = "Disabled"; desc = "disabled"; };
            ENABLED = 1 { name = "Enabled"; desc = "enabled"; };
        };

        field {
            name = "tt10_enf1";
            desc = "Control of teletext in line 10 in the odd field.";
            sw = rw;
            hw = r;
            encode = DATE1_COEFF7_tt10_enf1_enum;
            reset = 0x0;
        } tt10_enf1[19:19];

        enum DATE1_COEFF7_tt09_enf1_enum {
            DISABLED = 0 { name = "Disabled"; desc = "disabled"; };
            ENABLED = 1 { name = "Enabled"; desc = "enabled"; };
        };

        field {
            name = "tt09_enf1";
            desc = "Control of teletext in line 9 in the odd field.";
            sw = rw;
            hw = r;
            encode = DATE1_COEFF7_tt09_enf1_enum;
            reset = 0x0;
        } tt09_enf1[18:18];

        enum DATE1_COEFF7_tt08_enf1_enum {
            DISABLED = 0 { name = "Disabled"; desc = "disabled"; };
            ENABLED = 1 { name = "Enabled"; desc = "enabled"; };
        };

        field {
            name = "tt08_enf1";
            desc = "Control of teletext in line 8 in the odd field.";
            sw = rw;
            hw = r;
            encode = DATE1_COEFF7_tt08_enf1_enum;
            reset = 0x0;
        } tt08_enf1[17:17];

        enum DATE1_COEFF7_tt07_enf1_enum {
            DISABLED = 0 { name = "Disabled"; desc = "disabled"; };
            ENABLED = 1 { name = "Enabled"; desc = "enabled"; };
        };

        field {
            name = "tt07_enf1";
            desc = "Control of teletext in line 7 in the odd field.";
            sw = rw;
            hw = r;
            encode = DATE1_COEFF7_tt07_enf1_enum;
            reset = 0x0;
        } tt07_enf1[16:16];

        enum DATE1_COEFF7_tt22_enf2_enum {
            DISABLED = 0 { name = "Disabled"; desc = "disabled"; };
            ENABLED = 1 { name = "Enabled"; desc = "enabled"; };
        };

        field {
            name = "tt22_enf2";
            desc = "Control of teletext in line 22 in the even field.";
            sw = rw;
            hw = r;
            encode = DATE1_COEFF7_tt22_enf2_enum;
            reset = 0x0;
        } tt22_enf2[15:15];

        enum DATE1_COEFF7_tt21_enf2_enum {
            DISABLED = 0 { name = "Disabled"; desc = "disabled"; };
            ENABLED = 1 { name = "Enabled"; desc = "enabled"; };
        };

        field {
            name = "tt21_enf2";
            desc = "Control of teletext in line 21 in the even field.";
            sw = rw;
            hw = r;
            encode = DATE1_COEFF7_tt21_enf2_enum;
            reset = 0x0;
        } tt21_enf2[14:14];

        enum DATE1_COEFF7_tt20_enf2_enum {
            DISABLED = 0 { name = "Disabled"; desc = "disabled"; };
            ENABLED = 1 { name = "Enabled"; desc = "enabled"; };
        };

        field {
            name = "tt20_enf2";
            desc = "Control of teletext in line 20 in the even field.";
            sw = rw;
            hw = r;
            encode = DATE1_COEFF7_tt20_enf2_enum;
            reset = 0x0;
        } tt20_enf2[13:13];

        enum DATE1_COEFF7_tt19_enf2_enum {
            DISABLED = 0 { name = "Disabled"; desc = "disabled"; };
            ENABLED = 1 { name = "Enabled"; desc = "enabled"; };
        };

        field {
            name = "tt19_enf2";
            desc = "Control of teletext in line 19 in the even field.";
            sw = rw;
            hw = r;
            encode = DATE1_COEFF7_tt19_enf2_enum;
            reset = 0x0;
        } tt19_enf2[12:12];

        enum DATE1_COEFF7_tt18_enf2_enum {
            DISABLED = 0 { name = "Disabled"; desc = "disabled"; };
            ENABLED = 1 { name = "Enabled"; desc = "enabled"; };
        };

        field {
            name = "tt18_enf2";
            desc = "Control of teletext in line 18 in the even field.";
            sw = rw;
            hw = r;
            encode = DATE1_COEFF7_tt18_enf2_enum;
            reset = 0x0;
        } tt18_enf2[11:11];

        enum DATE1_COEFF7_tt17_enf2_enum {
            DISABLED = 0 { name = "Disabled"; desc = "disabled"; };
            ENABLED = 1 { name = "Enabled"; desc = "enabled"; };
        };

        field {
            name = "tt17_enf2";
            desc = "Control of teletext in line 17 in the even field.";
            sw = rw;
            hw = r;
            encode = DATE1_COEFF7_tt17_enf2_enum;
            reset = 0x0;
        } tt17_enf2[10:10];

        enum DATE1_COEFF7_tt16_enf2_enum {
            DISABLED = 0 { name = "Disabled"; desc = "disabled"; };
            ENABLED = 1 { name = "Enabled"; desc = "enabled"; };
        };

        field {
            name = "tt16_enf2";
            desc = "Control of teletext in line 16 in the even field.";
            sw = rw;
            hw = r;
            encode = DATE1_COEFF7_tt16_enf2_enum;
            reset = 0x0;
        } tt16_enf2[9:9];

        enum DATE1_COEFF7_tt15_enf2_enum {
            DISABLED = 0 { name = "Disabled"; desc = "disabled"; };
            ENABLED = 1 { name = "Enabled"; desc = "enabled"; };
        };

        field {
            name = "tt15_enf2";
            desc = "Control of teletext in line 15 in the even field.";
            sw = rw;
            hw = r;
            encode = DATE1_COEFF7_tt15_enf2_enum;
            reset = 0x0;
        } tt15_enf2[8:8];

        enum DATE1_COEFF7_tt14_enf2_enum {
            DISABLED = 0 { name = "Disabled"; desc = "disabled"; };
            ENABLED = 1 { name = "Enabled"; desc = "enabled"; };
        };

        field {
            name = "tt14_enf2";
            desc = "Control of teletext in line 14 in the even field.";
            sw = rw;
            hw = r;
            encode = DATE1_COEFF7_tt14_enf2_enum;
            reset = 0x0;
        } tt14_enf2[7:7];

        enum DATE1_COEFF7_tt13_enf2_enum {
            DISABLED = 0 { name = "Disabled"; desc = "disabled"; };
            ENABLED = 1 { name = "Enabled"; desc = "enabled"; };
        };

        field {
            name = "tt13_enf2";
            desc = "Control of teletext in line 13 in the even field.";
            sw = rw;
            hw = r;
            encode = DATE1_COEFF7_tt13_enf2_enum;
            reset = 0x0;
        } tt13_enf2[6:6];

        enum DATE1_COEFF7_tt12_enf2_enum {
            DISABLED = 0 { name = "Disabled"; desc = "disabled"; };
            ENABLED = 1 { name = "Enabled"; desc = "enabled"; };
        };

        field {
            name = "tt12_enf2";
            desc = "Control of teletext in line 12 in the even field.";
            sw = rw;
            hw = r;
            encode = DATE1_COEFF7_tt12_enf2_enum;
            reset = 0x0;
        } tt12_enf2[5:5];

        enum DATE1_COEFF7_tt11_enf2_enum {
            DISABLED = 0 { name = "Disabled"; desc = "disabled"; };
            ENABLED = 1 { name = "Enabled"; desc = "enabled"; };
        };

        field {
            name = "tt11_enf2";
            desc = "Control of teletext in line 11 in the even field.";
            sw = rw;
            hw = r;
            encode = DATE1_COEFF7_tt11_enf2_enum;
            reset = 0x0;
        } tt11_enf2[4:4];

        enum DATE1_COEFF7_tt10_enf2_enum {
            DISABLED = 0 { name = "Disabled"; desc = "disabled"; };
            ENABLED = 1 { name = "Enabled"; desc = "enabled"; };
        };

        field {
            name = "tt10_enf2";
            desc = "Control of teletext in line 10 in the even field.";
            sw = rw;
            hw = r;
            encode = DATE1_COEFF7_tt10_enf2_enum;
            reset = 0x0;
        } tt10_enf2[3:3];

        enum DATE1_COEFF7_tt09_enf2_enum {
            DISABLED = 0 { name = "Disabled"; desc = "disabled"; };
            ENABLED = 1 { name = "Enabled"; desc = "enabled"; };
        };

        field {
            name = "tt09_enf2";
            desc = "Control of teletext in line 9 in the even field.";
            sw = rw;
            hw = r;
            encode = DATE1_COEFF7_tt09_enf2_enum;
            reset = 0x0;
        } tt09_enf2[2:2];

        enum DATE1_COEFF7_tt08_enf2_enum {
            DISABLED = 0 { name = "Disabled"; desc = "disabled"; };
            ENABLED = 1 { name = "Enabled"; desc = "enabled"; };
        };

        field {
            name = "tt08_enf2";
            desc = "Control of teletext in line 8 in the even field.";
            sw = rw;
            hw = r;
            encode = DATE1_COEFF7_tt08_enf2_enum;
            reset = 0x0;
        } tt08_enf2[1:1];

        enum DATE1_COEFF7_tt07_enf2_enum {
            DISABLED = 0 { name = "Disabled"; desc = "disabled"; };
            ENABLED = 1 { name = "Enabled"; desc = "enabled"; };
        };

        field {
            name = "tt07_enf2";
            desc = "Control of teletext in line 7 in the even field.";
            sw = rw;
            hw = r;
            encode = DATE1_COEFF7_tt07_enf2_enum;
            reset = 0x0;
        } tt07_enf2[0:0];
    } DATE1_COEFF7 @ 0xC41C;

    reg {
        name = "DATE1 teletext configuration register";
        desc = "DATE1_COEFF8 is a DATE1 teletext configuration register.

Data sheet 11.2.4 DATE1_COEFF8 (offset 0xC420, printed page 11-236, `datasheet.txt` line 46232).";

        field {
            name = "tt_staddr";
            desc = "Start address of the teletext data.";
            sw = rw;
            hw = r;
            reset = 0x0;
        } tt_staddr[31:0];
    } DATE1_COEFF8 @ 0xC420;

    reg {
        name = "DATE1 teletext configuration register";
        desc = "DATE1_COEFF9 is a DATE1 teletext configuration register.

Data sheet 11.2.4 DATE1_COEFF9 (offset 0xC424, printed page 11-236, `datasheet.txt` line 46251).";

        field {
            name = "tt_edaddr";
            desc = "End address of the teletext data.";
            sw = rw;
            hw = r;
            reset = 0x0;
        } tt_edaddr[31:0];
    } DATE1_COEFF9 @ 0xC424;

    reg {
        name = "DATE1 teletext configuration register";
        desc = "DATE1 teletext configuration register.

Data sheet 11.2.4 DATE1_COEFF10 (offset 0xC428, printed page 11-237, `datasheet.txt` line 46285).";

        field {
            name = "tt_ready";
            desc = "When software sets related parameters through the bus, this bit is set to 1 and the teletext module starts to work. When the teletext module completes data transfer, this bit is set to 0. The bit status can be queried through software for the next configuration.";
            sw = rw;
            hw = r;
            reset = 0x0;
        } tt_ready[31:31];

        enum DATE1_COEFF10_nabts_100ire_enum {
            V_70_IRE = 0 { name = "V 70 Ire"; desc = "70 IRE"; };
            V_100_IRE = 1 { name = "V 100 Ire"; desc = "100 IRE"; };
        };

        field {
            name = "nabts_100ire";
            desc = "NABTS-NTSC data height.";
            sw = rw;
            hw = r;
            encode = DATE1_COEFF10_nabts_100ire_enum;
            reset = 0x0;
        } nabts_100ire[12:12];

        enum DATE1_COEFF10_full_page_enum {
            NORMAL_MODE_TELETEXT = 0 { name = "Normal Mode Teletext"; desc = "normal mode. The teletext data is transmitted from the blanking line."; };
            FULL_PAGE_MODE = 1 { name = "Full Page Mode"; desc = "full page mode. The teletext data can also be transmitted from the active video region."; };
        };

        field {
            name = "full_page";
            desc = "Teletext data transmission mode.";
            sw = rw;
            hw = r;
            encode = DATE1_COEFF10_full_page_enum;
            reset = 0x0;
        } full_page[11:11];

        enum DATE1_COEFF10_tt_highest_enum {
            TELETEXT_DATA_HAS = 0 { name = "Teletext Data Has"; desc = "The teletext data has the highest priority."; };
            TELETEXT_DATA_HAS_2 = 1 { name = "Teletext Data Has 2"; desc = "The teletext data has the lowest priority. Teletext mode. This field is set to 01 in 625-line mode, indicating WST-PAL. This field is set to 10 in 525-line mode, indicating NABTS-NTSC."; };
        };

        field {
            name = "tt_highest";
            desc = "Teletext priority control.";
            sw = rw;
            hw = r;
            encode = DATE1_COEFF10_tt_highest_enum;
            reset = 0x0;
        } tt_highest[10:10];

        field {
            name = "tt_mode";
            desc = "tt_mode";
            sw = rw;
            hw = r;
            reset = 0x0;
        } tt_mode[9:8];

        field {
            name = "tt_pktoff";
            desc = "tt_pktoff";
            sw = rw;
            hw = r;
            reset = 0x0;
        } tt_pktoff[7:0];
    } DATE1_COEFF10 @ 0xC428;

    reg {
        name = "DATE1 closed caption configuration register";
        desc = "DATE1_COEFF11 is a DATE1 closed caption configuration register.

Data sheet 11.2.4 DATE1_COEFF11 (offset 0xC42C, printed page 11-238, `datasheet.txt` line 46343).";

        enum DATE1_COEFF11_cc_enf1_enum {
            DISABLED = 0 { name = "Disabled"; desc = "disabled"; };
            ENABLED = 1 { name = "Enabled"; desc = "enabled"; };
        };

        field {
            name = "cc_enf1";
            desc = "Closed caption odd field enable.";
            sw = rw;
            hw = r;
            encode = DATE1_COEFF11_cc_enf1_enum;
            reset = 0x0;
        } cc_enf1[21:21];

        enum DATE1_COEFF11_cc_enf2_enum {
            DISABLED = 0 { name = "Disabled"; desc = "disabled"; };
            ENABLED = 1 { name = "Enabled"; desc = "enabled"; };
        };

        field {
            name = "cc_enf2";
            desc = "Closed caption even field enable.";
            sw = rw;
            hw = r;
            encode = DATE1_COEFF11_cc_enf2_enum;
            reset = 0x0;
        } cc_enf2[20:20];

        field {
            name = "date_clf1";
            desc = "Configuration line of the closed caption odd field.";
            sw = rw;
            hw = r;
            reset = 0x0;
        } date_clf1[19:10];

        field {
            name = "date_clf2";
            desc = "Configuration line of the closed caption even field.";
            sw = rw;
            hw = r;
            reset = 0x0;
        } date_clf2[9:0];
    } DATE1_COEFF11 @ 0xC42C;

    reg {
        name = "DATE1 closed caption configuration register";
        desc = "DATE1_COEFF12 is a DATE1 closed caption configuration register.

Data sheet 11.2.4 DATE1_COEFF12 (offset 0xC430, printed page 11-238, `datasheet.txt` line 46374).";

        field {
            name = "cc_f1data";
            desc = "Data of the closed caption odd field.";
            sw = rw;
            hw = r;
            reset = 0x0;
        } cc_f1data[31:16];

        field {
            name = "cc_f2data";
            desc = "Data of the closed caption even field.";
            sw = rw;
            hw = r;
            reset = 0x0;
        } cc_f2data[15:0];
    } DATE1_COEFF12 @ 0xC430;

    reg {
        name = "DATE1 CGMS configuration register";
        desc = "DATE1_COEFF13 is a DATE1 CGMS configuration register.

Data sheet 11.2.4 DATE1_COEFF13 (offset 0xC434, printed page 11-239, `datasheet.txt` line 46404).";

        enum DATE1_COEFF13_cg_enf1_enum {
            DISABLED = 0 { name = "Disabled"; desc = "disabled"; };
            ENABLED = 1 { name = "Enabled"; desc = "enabled"; };
        };

        field {
            name = "cg_enf1";
            desc = "CGMS odd field enable.";
            sw = rw;
            hw = r;
            encode = DATE1_COEFF13_cg_enf1_enum;
            reset = 0x0;
        } cg_enf1[21:21];

        enum DATE1_COEFF13_cg_enf2_enum {
            DISABLED = 0 { name = "Disabled"; desc = "disabled"; };
            ENABLED = 1 { name = "Enabled"; desc = "enabled"; };
        };

        field {
            name = "cg_enf2";
            desc = "CGMS even field enable.";
            sw = rw;
            hw = r;
            encode = DATE1_COEFF13_cg_enf2_enum;
            reset = 0x0;
        } cg_enf2[20:20];

        field {
            name = "cg_f1data";
            desc = "Data of the CGMS odd field.";
            sw = rw;
            hw = r;
            reset = 0x0;
        } cg_f1data[19:0];
    } DATE1_COEFF13 @ 0xC434;

    reg {
        name = "DATE1 CGMS configuration register";
        desc = "DATE1_COEFF14 is a DATE1 CGMS configuration register.

Data sheet 11.2.4 DATE1_COEFF14 (offset 0xC438, printed page 11-239, `datasheet.txt` line 46436).";

        field {
            name = "cg_f2data";
            desc = "Data of the CGMS even field.";
            sw = rw;
            hw = r;
            reset = 0x0;
        } cg_f2data[19:0];
    } DATE1_COEFF14 @ 0xC438;

    reg {
        name = "DATE1 WSS configuration register";
        desc = "DATE1 WSS configuration register.

Data sheet 11.2.4 DATE1_COEFF15 (offset 0xC43C, printed page 11-240, `datasheet.txt` line 46473).";

        enum DATE1_COEFF15_wss_en_enum {
            DISABLED = 0 { name = "Disabled"; desc = "disabled"; };
            ENABLED = 1 { name = "Enabled"; desc = "enabled"; };
        };

        field {
            name = "wss_en";
            desc = "WSS enable.";
            sw = rw;
            hw = r;
            encode = DATE1_COEFF15_wss_en_enum;
            reset = 0x0;
        } wss_en[14:14];

        field {
            name = "wss_data";
            desc = "WSS data.";
            sw = rw;
            hw = r;
            reset = 0x0;
        } wss_data[13:0];
    } DATE1_COEFF15 @ 0xC43C;

    reg {
        name = "DATE1 VPS configuration register";
        desc = "DATE1_COEFF16 is a DATE1 VPS configuration register.

Data sheet 11.2.4 DATE1_COEFF16 (offset 0xC440, printed page 11-240, `datasheet.txt` line 46500).";

        enum DATE1_COEFF16_vps_en_enum {
            DISABLED = 0 { name = "Disabled"; desc = "disabled"; };
            ENABLED = 1 { name = "Enabled"; desc = "enabled"; };
        };

        field {
            name = "vps_en";
            desc = "VPS enable.";
            sw = rw;
            hw = r;
            encode = DATE1_COEFF16_vps_en_enum;
            reset = 0x0;
        } vps_en[24:24];

        field {
            name = "vps_data";
            desc = "VPS data from bit 23 to bit 0. Bit 0 is the LSB.";
            sw = rw;
            hw = r;
            reset = 0x0;
        } vps_data[23:0];
    } DATE1_COEFF16 @ 0xC440;

    reg {
        name = "DATE1 VPS configuration register";
        desc = "DATE1_COEFF17 is a DATE1 VPS configuration register.

Data sheet 11.2.4 DATE1_COEFF17 (offset 0xC444, printed page 11-241, `datasheet.txt` line 46534).";

        field {
            name = "vps_data";
            desc = "VPS data from bit 55 to bit 24. Bit 0 is the LSB.";
            sw = rw;
            hw = r;
            reset = 0x0;
        } vps_data[31:0];
    } DATE1_COEFF17 @ 0xC444;

    reg {
        name = "DATE1 VPS configuration register";
        desc = "DATE1_COEFF18 is a DATE1 VPS configuration register.

Data sheet 11.2.4 DATE1_COEFF18 (offset 0xC448, printed page 11-241, `datasheet.txt` line 46553).";

        field {
            name = "vps_data";
            desc = "VPS data from bit 87 to bit 56. Bit 0 is the LSB.";
            sw = rw;
            hw = r;
            reset = 0x0;
        } vps_data[31:0];
    } DATE1_COEFF18 @ 0xC448;

    reg {
        name = "DATE1 VPS configuration register";
        desc = "DATE1 VPS configuration register.

Data sheet 11.2.4 DATE1_COEFF19 (offset 0xC44C, printed page 11-242, `datasheet.txt` line 46586).";

        field {
            name = "vps_data";
            desc = "VPS data from bit 103 to bit 88. Bit 0 is the LSB.";
            sw = rw;
            hw = r;
            reset = 0x0;
        } vps_data[15:0];
    } DATE1_COEFF19 @ 0xC44C;

    reg {
        name = "DATE1 teletext configuration register";
        desc = "DATE1_COEFF20 is a DATE1 teletext configuration register.

Data sheet 11.2.4 DATE1_COEFF20 (offset 0xC450, printed page 11-242, `datasheet.txt` line 46608).";

        enum DATE1_COEFF20_tt06_enf1_enum {
            DISABLED = 0 { name = "Disabled"; desc = "disabled"; };
            ENABLED = 1 { name = "Enabled"; desc = "enabled"; };
        };

        field {
            name = "tt06_enf1";
            desc = "Control of teletext in line 6 in the odd field.";
            sw = rw;
            hw = r;
            encode = DATE1_COEFF20_tt06_enf1_enum;
            reset = 0x0;
        } tt06_enf1[2:2];

        enum DATE1_COEFF20_tt06_enf2_enum {
            DISABLED = 0 { name = "Disabled"; desc = "disabled"; };
            ENABLED = 1 { name = "Enabled"; desc = "enabled"; };
        };

        field {
            name = "tt06_enf2";
            desc = "Control of teletext in line 6 in the even field.";
            sw = rw;
            hw = r;
            encode = DATE1_COEFF20_tt06_enf2_enum;
            reset = 0x0;
        } tt06_enf2[1:1];

        enum DATE1_COEFF20_tt05_enf2_enum {
            DISABLED = 0 { name = "Disabled"; desc = "disabled"; };
            ENABLED = 1 { name = "Enabled"; desc = "enabled"; };
        };

        field {
            name = "tt05_enf2";
            desc = "Control of teletext in line 5 in the even field.";
            sw = rw;
            hw = r;
            encode = DATE1_COEFF20_tt05_enf2_enum;
            reset = 0x0;
        } tt05_enf2[0:0];
    } DATE1_COEFF20 @ 0xC450;

    reg {
        name = "DATE1 output matrix control register";
        desc = "DATE1_COEFF21 is the DATE1 output matrix control register.

Data sheet 11.2.4 DATE1_COEFF21 (offset 0xC454, printed page 11-243, `datasheet.txt` line 46650).";

        enum DATE1_COEFF21_dac5_in_sel_enum {
            V_0 = 0 { name = "V 0"; desc = "0"; };
            CVBS = 1 { name = "Cvbs"; desc = "CVBS"; };
            G_Y = 2 { name = "G Y"; desc = "G/Y"; };
            B_PB = 3 { name = "B Pb"; desc = "B/Pb"; };
            R_PR = 4 { name = "R Pr"; desc = "R/Pr"; };
            SVIDEO_Y = 5 { name = "Svideo Y"; desc = "svideo_y"; };
            SVIDEO_C = 6 { name = "Svideo C"; desc = "svideo_c"; };
            V_0_2 = 7 { name = "V 0 2"; desc = "0"; };
        };

        field {
            name = "dac5_in_sel";
            desc = "DAC5 output mode select.";
            sw = rw;
            hw = r;
            encode = DATE1_COEFF21_dac5_in_sel_enum;
            reset = 0x6;
        } dac5_in_sel[22:20];

        enum DATE1_COEFF21_dac4_in_sel_enum {
            V_0 = 0 { name = "V 0"; desc = "0"; };
            CVBS = 1 { name = "Cvbs"; desc = "CVBS"; };
            G_Y = 2 { name = "G Y"; desc = "G/Y"; };
            B_PB = 3 { name = "B Pb"; desc = "B/Pb"; };
            R_PR = 4 { name = "R Pr"; desc = "R/Pr"; };
            SVIDEO_Y = 5 { name = "Svideo Y"; desc = "svideo_y"; };
            SVIDEO_C = 6 { name = "Svideo C"; desc = "svideo_c"; };
            V_0_2 = 7 { name = "V 0 2"; desc = "0"; };
        };

        field {
            name = "dac4_in_sel";
            desc = "DAC4 output mode select.";
            sw = rw;
            hw = r;
            encode = DATE1_COEFF21_dac4_in_sel_enum;
            reset = 0x5;
        } dac4_in_sel[18:16];

        enum DATE1_COEFF21_dac3_in_sel_enum {
            V_0 = 0 { name = "V 0"; desc = "0"; };
            CVBS = 1 { name = "Cvbs"; desc = "CVBS"; };
            G_Y = 2 { name = "G Y"; desc = "G/Y"; };
            B_PB = 3 { name = "B Pb"; desc = "B/Pb"; };
            R_PR = 4 { name = "R Pr"; desc = "R/Pr"; };
            SVIDEO_Y = 5 { name = "Svideo Y"; desc = "svideo_y"; };
            SVIDEO_C = 6 { name = "Svideo C"; desc = "svideo_c"; };
            V_0_2 = 7 { name = "V 0 2"; desc = "0"; };
        };

        field {
            name = "dac3_in_sel";
            desc = "DAC3 output mode select.";
            sw = rw;
            hw = r;
            encode = DATE1_COEFF21_dac3_in_sel_enum;
            reset = 0x1;
        } dac3_in_sel[14:12];

        enum DATE1_COEFF21_dac2_in_sel_enum {
            V_0 = 0 { name = "V 0"; desc = "0"; };
            CVBS = 1 { name = "Cvbs"; desc = "CVBS"; };
            G_Y = 2 { name = "G Y"; desc = "G/Y"; };
            B_PB = 3 { name = "B Pb"; desc = "B/Pb"; };
            R_PR = 4 { name = "R Pr"; desc = "R/Pr"; };
            SVIDEO_Y = 5 { name = "Svideo Y"; desc = "svideo_y"; };
            SVIDEO_C = 6 { name = "Svideo C"; desc = "svideo_c"; };
            V_0_2 = 7 { name = "V 0 2"; desc = "0"; };
        };

        field {
            name = "dac2_in_sel";
            desc = "DAC2 output mode select.";
            sw = rw;
            hw = r;
            encode = DATE1_COEFF21_dac2_in_sel_enum;
            reset = 0x4;
        } dac2_in_sel[10:8];

        enum DATE1_COEFF21_dac1_in_sel_enum {
            V_0 = 0 { name = "V 0"; desc = "0"; };
            CVBS = 1 { name = "Cvbs"; desc = "CVBS"; };
            G_Y = 2 { name = "G Y"; desc = "G/Y"; };
            B_PB = 3 { name = "B Pb"; desc = "B/Pb"; };
            R_PR = 4 { name = "R Pr"; desc = "R/Pr"; };
            SVIDEO_Y = 5 { name = "Svideo Y"; desc = "svideo_y"; };
            SVIDEO_C = 6 { name = "Svideo C"; desc = "svideo_c"; };
            V_0_2 = 7 { name = "V 0 2"; desc = "0"; };
        };

        field {
            name = "dac1_in_sel";
            desc = "DAC1 output mode select.";
            sw = rw;
            hw = r;
            encode = DATE1_COEFF21_dac1_in_sel_enum;
            reset = 0x3;
        } dac1_in_sel[6:4];

        enum DATE1_COEFF21_dac0_in_sel_enum {
            V_0 = 0 { name = "V 0"; desc = "0"; };
            CVBS = 1 { name = "Cvbs"; desc = "CVBS"; };
            G_Y = 2 { name = "G Y"; desc = "G/Y"; };
            B_PB = 3 { name = "B Pb"; desc = "B/Pb"; };
            R_PR = 4 { name = "R Pr"; desc = "R/Pr"; };
            SVIDEO_Y = 5 { name = "Svideo Y"; desc = "svideo_y"; };
            SVIDEO_C = 6 { name = "Svideo C"; desc = "svideo_c"; };
            V_0_2 = 7 { name = "V 0 2"; desc = "0"; };
        };

        field {
            name = "dac0_in_sel";
            desc = "DAC0 output mode select.";
            sw = rw;
            hw = r;
            encode = DATE1_COEFF21_dac0_in_sel_enum;
            reset = 0x2;
        } dac0_in_sel[2:0];
    } DATE1_COEFF21 @ 0xC454;

    reg {
        name = "DATE1 DTO initial phase configuration register";
        desc = "DATE1_COEFF22 is the DATE1 DTO initial phase configuration register.

Data sheet 11.2.4 DATE1_COEFF22 (offset 0xC458, printed page 11-245, `datasheet.txt` line 46768).";

        field {
            name = "video_phase_delta";
            desc = "DTO initial phase.";
            sw = rw;
            hw = r;
            reset = 0x0;
        } video_phase_delta[10:0];
    } DATE1_COEFF22 @ 0xC458;

    reg {
        name = "DATE1 video output delay configuration register";
        desc = "DATE1_COEFF23 is the DATE1 video output delay configuration register.

Data sheet 11.2.4 DATE1_COEFF23 (offset 0xC45C, printed page 11-246, `datasheet.txt` line 46800).";

        field {
            name = "dac5_out_dly";
            desc = "DAC5 output delay cycle. The value is in the unit of a 54 MHz clock cycle and the value n indicates n delay cycles.";
            sw = rw;
            hw = r;
            reset = 0x0;
        } dac5_out_dly[22:20];

        field {
            name = "dac4_out_dly";
            desc = "DAC4 output delay cycle. The value is in the unit of a 54 MHz clock cycle and the value n indicates n delay cycles.";
            sw = rw;
            hw = r;
            reset = 0x0;
        } dac4_out_dly[18:16];

        field {
            name = "dac3_out_dly";
            desc = "DAC3 output delay cycle. The value is in the unit of a 54 MHz clock cycle and the value n indicates n delay cycles.";
            sw = rw;
            hw = r;
            reset = 0x0;
        } dac3_out_dly[14:12];

        field {
            name = "dac2_out_dly";
            desc = "DAC2 output delay cycle. The value is in the unit of a 54 MHz clock cycle and the value n indicates n delay cycles.";
            sw = rw;
            hw = r;
            reset = 0x0;
        } dac2_out_dly[10:8];

        field {
            name = "dac1_out_dly";
            desc = "DAC1 output delay cycle. The value is in the unit of a 54 MHz clock cycle and the value n indicates n delay cycles.";
            sw = rw;
            hw = r;
            reset = 0x0;
        } dac1_out_dly[6:4];

        field {
            name = "dac0_out_dly";
            desc = "DAC0 output delay cycle. The value is in the unit of a 54 MHz clock cycle and the value n indicates n delay cycles.";
            sw = rw;
            hw = r;
            reset = 0x0;
        } dac0_out_dly[2:0];
    } DATE1_COEFF23 @ 0xC45C;

    reg {
        name = "DATE1 interrupt mask register";
        desc = "DATE1_ISRMASK is the DATE1 interrupt mask register.

Data sheet 11.2.4 DATE1_ISRMASK (offset 0xC480, printed page 11-247, `datasheet.txt` line 46872).";

        enum DATE1_ISRMASK_tt_mask_enum {
            ENABLED = 0 { name = "Enabled"; desc = "enabled"; };
            MASKED = 1 { name = "Masked"; desc = "masked"; };
        };

        field {
            name = "tt_mask";
            desc = "Teletext interrupt mask.";
            sw = rw;
            hw = r;
            encode = DATE1_ISRMASK_tt_mask_enum;
            reset = 0x0;
        } tt_mask[0:0];
    } DATE1_ISRMASK @ 0xC480;

    reg {
        name = "DATE1 interrupt status register";
        desc = "DATE1_ISRSTATE is the DATE1 interrupt status register.

Data sheet 11.2.4 DATE1_ISRSTATE (offset 0xC484, printed page 11-247, `datasheet.txt` line 46900).";

        field {
            name = "tt_status";
            desc = "Teletext interrupt flag. After the DATE module reads all the teletext data, the bit is set to 1. Writing 1 to this bit clears this bit.";
            sw = rw;
            hw = w;
            onwrite = woclr;
            reset = 0x0;
        } tt_status[0:0];
    } DATE1_ISRSTATE @ 0xC484;

    reg {
        name = "DATE1 interrupt register";
        desc = "DATE1_ISR is the DATE1 interrupt register.

Data sheet 11.2.4 DATE1_ISR (offset 0xC488, printed page 11-248, `datasheet.txt` line 46941).";

        enum DATE1_ISR_tt_int_enum {
            NO_INTERRUPT_GENERATED = 0 { name = "No Interrupt Generated"; desc = "No interrupt is generated."; };
            INTERRUPT_GENERATED = 1 { name = "Interrupt Generated"; desc = "An interrupt is generated."; };
        };

        field {
            name = "tt_int";
            desc = "Teletext interrupt. It is the interrupt status after tt_status is masked by tt_mask.";
            sw = rw;
            hw = r;
            encode = DATE1_ISR_tt_int_enum;
            reset = 0x0;
        } tt_int[0:0];
    } DATE1_ISR @ 0xC488;

    reg {
        name = "DATE1 version register";
        desc = "DATE1_VERSION is the DATE1 version register. The data sheet lists no bit fields for it.

Data sheet 11.2.4 DATE1_VERSION (offset 0xC490, printed page 11-248, `datasheet.txt` line 46968).";

        field {
            name = "value";
            desc = "Register value (the data sheet gives no bit table for this register).";
            sw = rw;
            hw = r;
            reset = 0x24;
        } value[31:0];
    } DATE1_VERSION @ 0xC490;

    reg {
        name = "VO control register";
        desc = "VO_CTRL is a VO control register.

Data sheet 11.2.4 VOCTRL (offset 0xCE00, printed page 11-249, `datasheet.txt` line 46996).";

        enum VOCTRL_vo_ck_gt_en_enum {
            DISABLED = 0 { name = "Disabled"; desc = "disabled"; };
            ENABLED = 1 { name = "Enabled"; desc = "enabled"; };
        };

        field {
            name = "vo_ck_gt_en";
            desc = "Clock gating enable. 0: clock gating off; 1: internal clock gating of the VOU on. The data sheet (issue 02) marks this bit RW.";
            sw = rw;
            hw = r;
            encode = VOCTRL_vo_ck_gt_en_enum;
            reset = 0x0;
        } vo_ck_gt_en[31:31];

        enum VOCTRL_vo_id_sel_enum {
            READ_ID_0 = 0 { name = "Read Id 0"; desc = "read ID 0"; };
            READ_ID_1 = 1 { name = "Read Id 1"; desc = "read ID 1"; };
        };

        field {
            name = "vo_id_sel";
            desc = "VOU read ID select.";
            sw = rw;
            hw = r;
            encode = VOCTRL_vo_id_sel_enum;
            reset = 0x0;
        } vo_id_sel[30:30];

        field {
            name = "awid_cfg";
            desc = "ID of the AXI bus write channel.";
            sw = rw;
            hw = r;
            reset = 0x0;
        } awid_cfg[27:24];

        enum VOCTRL_bus_dbg_en_enum {
            NORMAL_MODE = 0 { name = "Normal Mode"; desc = "normal mode"; };
            READ_WRITE_LOOPBACK = 1 { name = "Read Write Loopback"; desc = "read-write loopback mode for bus test"; };
            WRITE_LOOPBACK_MODE = 2 { name = "Write Loopback Mode"; desc = "write loopback mode for bus test Other values: reserved"; };
        };

        field {
            name = "bus_dbg_en";
            desc = "Bus debugging enable.";
            sw = rw;
            hw = r;
            encode = VOCTRL_bus_dbg_en_enum;
            reset = 0x0;
        } bus_dbg_en[21:20];

        field {
            name = "outstd_wid";
            desc = "Outstanding of ID of the AXI bus write channel.";
            sw = rw;
            hw = r;
            reset = 0x0;
        } outstd_wid[19:16];

        field {
            name = "arid_cfg1";
            desc = "ID 1 of the AXI bus read channel.";
            sw = rw;
            hw = r;
            reset = 0x0;
        } arid_cfg1[15:12];

        field {
            name = "arid_cfg0";
            desc = "ID 0 of the AXI bus read channel.";
            sw = rw;
            hw = r;
            reset = 0x0;
        } arid_cfg0[11:8];

        field {
            name = "outstd_rid";
            desc = "Outstanding of ID of the AXI bus read channel.";
            sw = rw;
            hw = r;
            reset = 0x0;
        } outstd_rid[7:4];

        enum VOCTRL_arb_mode_enum {
            POLLING_MODE_USED = 0 { name = "Polling Mode Used"; desc = "The polling mode is used."; };
            GRAPHICS_LAYER_TAKES = 1 { name = "Graphics Layer Takes"; desc = "The graphics layer takes priority. Other values: reserved"; };
        };

        field {
            name = "arb_mode";
            desc = "Arbitration mode of requesting data for each internal surface bus of the VOU.";
            sw = rw;
            hw = r;
            encode = VOCTRL_arb_mode_enum;
            reset = 0x0;
        } arb_mode[3:0];
    } VOCTRL @ 0xCE00;

    reg {
        name = "VO interrupt status register";
        desc = "VOINTSTA is a VO interrupt status register. It is a read-only register.

Data sheet 11.2.4 VOINTSTA (offset 0xCE04, printed page 11-250, `datasheet.txt` line 47051).";

        enum VOINTSTA_be_int_enum {
            NO_INTERRUPT_GENERATED = 0 { name = "No Interrupt Generated"; desc = "No interrupt is generated."; };
            INTERRUPT_GENERATED = 1 { name = "Interrupt Generated"; desc = "An interrupt is generated."; };
        };

        field {
            name = "be_int";
            desc = "Bus error interrupt (AXI_Master).";
            sw = r;
            hw = w;
            encode = VOINTSTA_be_int_enum;
            reset = 0x0;
        } be_int[31:31];

        field {
            name = "ut_end_int";
            desc = "UT frame end interrupt.";
            sw = r;
            hw = w;
            reset = 0x0;
        } ut_end_int[30:30];

        field {
            name = "vhd_regup_err_int";
            desc = "VHD register update error interrupt.";
            sw = r;
            hw = w;
            reset = 0x0;
        } vhd_regup_err_int[28:28];

        field {
            name = "g0rr_int";
            desc = "G0 register update interrupt.";
            sw = r;
            hw = w;
            reset = 0x0;
        } g0rr_int[23:23];

        field {
            name = "vhdrr_int";
            desc = "VHD register update interrupt.";
            sw = r;
            hw = w;
            reset = 0x0;
        } vhdrr_int[22:22];

        field {
            name = "vsdrr_int";
            desc = "VSD register update interrupt.";
            sw = r;
            hw = w;
            reset = 0x0;
        } vsdrr_int[20:20];

        field {
            name = "dsd1uf_int";
            desc = "DSD1 low-bandwidth alarm interrupt.";
            sw = r;
            hw = w;
            reset = 0x0;
        } dsd1uf_int[14:14];

        field {
            name = "wbc_te_int";
            desc = "WBC2 task completion interrupt.";
            sw = r;
            hw = w;
            reset = 0x0;
        } wbc_te_int[11:11];

        field {
            name = "dhduf_int";
            desc = "HD low-bandwidth alarm interrupt.";
            sw = r;
            hw = w;
            reset = 0x0;
        } dhduf_int[7:7];

        field {
            name = "dhdvtthd0_int";
            desc = "HD0 vertical timing interrupt.";
            sw = r;
            hw = w;
            reset = 0x0;
        } dhdvtthd0_int[4:4];

        field {
            name = "dsduf_int";
            desc = "SD low-bandwidth alarm interrupt.";
            sw = r;
            hw = w;
            reset = 0x0;
        } dsduf_int[3:3];

        field {
            name = "dsdvtthd1_int";
            desc = "SD1 vertical timing interrupt.";
            sw = r;
            hw = w;
            reset = 0x0;
        } dsdvtthd1_int[1:1];

        field {
            name = "dsdvtthd0_int";
            desc = "SD0 vertical timing interrupt.";
            sw = r;
            hw = w;
            reset = 0x0;
        } dsdvtthd0_int[0:0];
    } VOINTSTA @ 0xCE04;

    reg {
        name = "VO masked interrupt status register";
        desc = "VOMSKINTSTA is a VO masked interrupt status register. Original (Chinese) data sheet: the register is cleared by writing 1 (写 1 清零): be_int, vhd_regup_err_int, g0rr_int, vhdrr_int are RWC, ut_end_int and vsdrr_int R/WC, dsd1uf_int RW, the rest RO. Earlier versions of this file modelled the RWC bits as read-to-clear; they are write-1-to-clear. Writing 1 clears this register.

Data sheet 11.2.4 VOMSKINTSTA (offset 0xCE08, printed page 11-251, `datasheet.txt` line 47110).";

        enum VOMSKINTSTA_be_int_enum {
            NO_INTERRUPT_GENERATED = 0 { name = "No Interrupt Generated"; desc = "No interrupt is generated."; };
            INTERRUPT_GENERATED = 1 { name = "Interrupt Generated"; desc = "An interrupt is generated."; };
        };

        field {
            name = "be_int";
            desc = "Bus error interrupt (AXI_Master).";
            sw = rw;
            hw = w;
            onwrite = woclr;
            encode = VOMSKINTSTA_be_int_enum;
            reset = 0x0;
        } be_int[31:31];

        field {
            name = "ut_end_int";
            desc = "UT frame end interrupt.";
            sw = rw;
            hw = w;
            onwrite = woclr;
            reset = 0x0;
        } ut_end_int[30:30];

        field {
            name = "vhd_regup_err_int";
            desc = "VHD register update error interrupt.";
            sw = rw;
            hw = w;
            onwrite = woclr;
            reset = 0x0;
        } vhd_regup_err_int[28:28];

        field {
            name = "g0rr_int";
            desc = "G0 register update interrupt.";
            sw = rw;
            hw = w;
            onwrite = woclr;
            reset = 0x0;
        } g0rr_int[23:23];

        field {
            name = "vhdrr_int";
            desc = "VHD register update interrupt.";
            sw = rw;
            hw = w;
            onwrite = woclr;
            reset = 0x0;
        } vhdrr_int[22:22];

        field {
            name = "vsdrr_int";
            desc = "VSD register update interrupt.";
            sw = rw;
            hw = w;
            onwrite = woclr;
            reset = 0x0;
        } vsdrr_int[20:20];

        field {
            name = "dsd1uf_int";
            desc = "SD1 low-bandwidth alarm interrupt.";
            sw = rw;
            hw = r;
            reset = 0x0;
        } dsd1uf_int[14:14];

        field {
            name = "wbc_te_int";
            desc = "WBC task completion interrupt.";
            sw = r;
            hw = w;
            reset = 0x0;
        } wbc_te_int[11:11];

        field {
            name = "dhduf_int";
            desc = "HD low-bandwidth alarm interrupt.";
            sw = r;
            hw = w;
            reset = 0x0;
        } dhduf_int[7:7];

        field {
            name = "dhdvtthd1_int";
            desc = "HD0 vertical timing interrupt.";
            sw = r;
            hw = w;
            reset = 0x0;
        } dhdvtthd1_int[4:4];

        field {
            name = "dsduf_int";
            desc = "SD low-bandwidth alarm interrupt.";
            sw = r;
            hw = w;
            reset = 0x0;
        } dsduf_int[3:3];

        field {
            name = "dsdvtthd1_int";
            desc = "SD1 vertical timing interrupt.";
            sw = r;
            hw = w;
            reset = 0x0;
        } dsdvtthd1_int[1:1];

        field {
            name = "dsdvtthd0_int";
            desc = "SD0 vertical timing interrupt.";
            sw = r;
            hw = w;
            reset = 0x0;
        } dsdvtthd0_int[0:0];
    } VOMSKINTSTA @ 0xCE08;

    reg {
        name = "VDP interrupt mask register";
        desc = "VOINTMSK is a VDP interrupt mask register. It corresponds to VOINTSTA. When the corresponding bit is set to 1, the interrupt is enabled; when the corresponding bit is set to 0, the interrupt is masked.

Data sheet 11.2.4 VOINTMSK (offset 0xCE0C, printed page 11-252, `datasheet.txt` line 47172).";

        enum VOINTMSK_be_intmsk_enum {
            NO_INTERRUPT_GENERATED = 0 { name = "No Interrupt Generated"; desc = "No interrupt is generated."; };
            INTERRUPT_GENERATED = 1 { name = "Interrupt Generated"; desc = "An interrupt is generated."; };
        };

        field {
            name = "be_intmsk";
            desc = "Bus error interrupt (AXI_Master).";
            sw = rw;
            hw = r;
            encode = VOINTMSK_be_intmsk_enum;
            reset = 0x0;
        } be_intmsk[31:31];

        field {
            name = "ut_end_intmsk";
            desc = "UT frame end interrupt.";
            sw = rw;
            hw = r;
            reset = 0x0;
        } ut_end_intmsk[30:30];

        field {
            name = "vhd_regup_err_intmsk";
            desc = "VHD register update error interrupt mask. The data sheet prints the access as RWC (a copy of the VOMSKINTSTA row); modelled as a plain RW mask bit like the other bits of this register.";
            sw = rw;
            hw = r;
            reset = 0x0;
        } vhd_regup_err_intmsk[28:28];

        field {
            name = "g0rr_intmsk";
            desc = "G0 register update interrupt.";
            sw = rw;
            hw = r;
            reset = 0x0;
        } g0rr_intmsk[23:23];

        field {
            name = "vhdrr_intmsk";
            desc = "VHD register update interrupt.";
            sw = rw;
            hw = r;
            reset = 0x0;
        } vhdrr_intmsk[22:22];

        field {
            name = "vsdrr_intmsk";
            desc = "VSD register update interrupt.";
            sw = rw;
            hw = r;
            reset = 0x0;
        } vsdrr_intmsk[20:20];

        field {
            name = "dsd1uf_intmsk";
            desc = "SD1 low-bandwidth alarm interrupt.";
            sw = rw;
            hw = r;
            reset = 0x0;
        } dsd1uf_intmsk[14:14];

        field {
            name = "wbc_te_intmsk";
            desc = "WBC task completion interrupt.";
            sw = r;
            hw = w;
            reset = 0x0;
        } wbc_te_intmsk[11:11];

        field {
            name = "dhduf_intmsk";
            desc = "HD low-bandwidth alarm interrupt.";
            sw = rw;
            hw = r;
            reset = 0x0;
        } dhduf_intmsk[7:7];

        field {
            name = "dhdvtthd1_intmsk";
            desc = "HD vertical timing interrupt 1.";
            sw = rw;
            hw = r;
            reset = 0x0;
        } dhdvtthd1_intmsk[4:4];

        field {
            name = "dsduf_intmsk";
            desc = "SD low-bandwidth alarm interrupt.";
            sw = rw;
            hw = r;
            reset = 0x0;
        } dsduf_intmsk[3:3];

        field {
            name = "dsdvtthd1_intmsk";
            desc = "SD1 vertical timing interrupt 2.";
            sw = rw;
            hw = r;
            reset = 0x0;
        } dsdvtthd1_intmsk[1:1];

        field {
            name = "dsdvtthd0_intmsk";
            desc = "SD0 vertical timing interrupt 1.";
            sw = rw;
            hw = r;
            reset = 0x0;
        } dsdvtthd0_intmsk[0:0];
    } VOINTMSK @ 0xCE0C;

    reg {
        name = "VDP version register 1";
        desc = "VOUVERSION1 is VDP version register 1.

Data sheet 11.2.4 VOUVERSION1 (offset 0xCE10, printed page 11-253, `datasheet.txt` line 47234).";

        field {
            name = "vouversion0";
            desc = "VDP version.";
            sw = r;
            hw = w;
            reset = 0x76756F76;
        } vouversion0[31:0];
    } VOUVERSION1 @ 0xCE10;

    reg {
        name = "VDP version register 2";
        desc = "VOUVERSION2 is VDP version register 2.

Data sheet 11.2.4 VOUVERSION2 (offset 0xCE14, printed page 11-254, `datasheet.txt` line 47263).";

        field {
            name = "vouversion1";
            desc = "VDP version.";
            sw = r;
            hw = w;
            reset = 0x30303134;
        } vouversion1[31:0];
    } VOUVERSION2 @ 0xCE14;

    reg {
        name = "VO interface multiplexing data register (VOPINTEST)";
        desc = "VOMUXDATA is a VO interface multiplexing data register (VOPINTEST).

Data sheet 11.2.4 VOMUXDATA (offset 0xCE18, printed page 11-254, `datasheet.txt` line 47282).";

        enum VOMUXDATA_pin_test_en_enum {
            DISABLED = 0 { name = "Disabled"; desc = "disabled"; };
            ENABLED_VALUES_VO = 1 { name = "Enabled Values Vo"; desc = "enabled The values of Vo_pdata, Vo_vsync, Vo_hsync, and Vo_dv are defined by bit[23:0], bit[26], bit[25], and bit[24] of VOMUXDATA respectively."; };
        };

        field {
            name = "pin_test_en";
            desc = "Pin test mode enable.";
            sw = rw;
            hw = r;
            encode = VOMUXDATA_pin_test_en_enum;
            reset = 0x0;
        } pin_test_en[31:31];

        field {
            name = "pin_test_mode";
            desc = "Reserved.";
            sw = rw;
            hw = r;
            reset = 0x0;
        } pin_test_mode[30:27];

        field {
            name = "vsync_value";
            desc = "Configured vertical timing in test mode.";
            sw = rw;
            hw = r;
            reset = 0x0;
        } vsync_value[26:26];

        field {
            name = "hsync_value";
            desc = "Configured horizontal timing in test mode.";
            sw = rw;
            hw = r;
            reset = 0x0;
        } hsync_value[25:25];

        field {
            name = "dv_value";
            desc = "Configured data valid timing in test mode.";
            sw = rw;
            hw = r;
            reset = 0x0;
        } dv_value[24:24];

        field {
            name = "pin_test_data";
            desc = "Test data in test mode. All DACs use bit[9:0]. When the component width is greater than 8 bits, the MSB is the stuffed bit, for example, 36-bit output[35:24] = {[23:16], [23:20]}.";
            sw = rw;
            hw = r;
            reset = 0x0;
        } pin_test_data[23:0];
    } VOMUXDATA @ 0xCE18;

    reg {
        name = "VO interface multiplexing register";
        desc = "VOMUX is a VO interface multiplexing register.

Data sheet 11.2.4 VOMUX (offset 0xCE1C, printed page 11-255, `datasheet.txt` line 47328).";

        field {
            name = "hdmi_vid";
            desc = "The reverse requirements on the HDMI input interface timing can be met only when the reverse enable register is ORed with the INIF timing reverse register. bit[22]: VSYNC signal reverse enable. 0: disabled 1: enabled bit[21]: HSYNC signal reverse enable. 0: disabled 1: enabled bit[20]: data valid sync signal reverse enable. 0: disabled 1: enabled bit[19]: reserved bit[18:17]: HDMI video output format select. The default value is 00. The RGB or YCbCr format is selected by configuring the DHD. 00: YCbCr444, 30-bit sync separation mode 01: RGB444, 30-bit sync separation mode 10: YCbCr422, 20-bit sync separation mode 11: YCbCr422, 10-bit sync separation mode bit[16]: HDMI data source. 0: DHD1 output 1: DHD0 output";
            sw = rw;
            hw = r;
            reset = 0x4;
        } hdmi_vid[22:16];

        field {
            name = "reserved_nz";
            desc = "Reserved (RO); reads 0x1B: the data sheet total reset value is 0x0004_001B.";
            sw = r;
            hw = w;
            reset = 0x1B;
        } reserved_nz[15:0];
    } VOMUX @ 0xCE1C;

    reg {
        name = "VGA input DC component register for CSC";
        desc = "VGACSCIDC is a VGA input DC component register for CSC (instant register).

Data sheet 11.2.4 VGACSCIDC (offset 0xCE24, printed page 11-256, `datasheet.txt` line 47381).";

        enum VGACSCIDC_csc_mode_enum {
            YUV2RGB_601 = 0 { name = "Yuv2Rgb 601"; desc = "YUV2RGB 601 (SD)"; };
            YUV2RGB_709 = 1 { name = "Yuv2Rgb 709"; desc = "YUV2RGB 709 (HD)"; };
        };

        field {
            name = "csc_mode";
            desc = "CSC mode.";
            sw = rw;
            hw = r;
            encode = VGACSCIDC_csc_mode_enum;
            reset = 0x0;
        } csc_mode[28:28];

        enum VGACSCIDC_csc_en_enum {
            DISABLED = 0 { name = "Disabled"; desc = "disabled"; };
            ENABLED = 1 { name = "Enabled"; desc = "enabled"; };
        };

        field {
            name = "csc_en";
            desc = "CSC enable.";
            sw = rw;
            hw = r;
            encode = VGACSCIDC_csc_en_enum;
            reset = 0x0;
        } csc_en[27:27];

        field {
            name = "cscidc2";
            desc = "DC parameter of input component 2. The MSB is the signed bit. The value is expressed as the complement.";
            sw = rw;
            hw = r;
            reset = 0x1F0;
        } cscidc2[26:18];

        field {
            name = "cscidc1";
            desc = "DC parameter of input component 1. The MSB is the signed bit. The value is expressed as the complement.";
            sw = rw;
            hw = r;
            reset = 0x180;
        } cscidc1[17:9];

        field {
            name = "cscidc0";
            desc = "DC parameter of input component 0. The MSB is the signed bit. The value is expressed as the complement.";
            sw = rw;
            hw = r;
            reset = 0x180;
        } cscidc0[8:0];
    } VGACSCIDC @ 0xCE24;

    reg {
        name = "VGA output DC component register for CSC";
        desc = "VGACSCODC is a VGA output DC component register for CSC (instant register).

Data sheet 11.2.4 VGACSCODC (offset 0xCE28, printed page 11-256, `datasheet.txt` line 47420).";

        field {
            name = "cscodc2";
            desc = "DC parameter of output component 2. The MSB is the signed bit. The value is expressed as the complement.";
            sw = rw;
            hw = r;
            reset = 0x0;
        } cscodc2[26:18];

        field {
            name = "cscodc1";
            desc = "DC parameter of output component 1. The MSB is the signed bit. The value is expressed as the complement.";
            sw = rw;
            hw = r;
            reset = 0x0;
        } cscodc1[17:9];

        field {
            name = "cscodc0";
            desc = "DC parameter of output component 0. The MSB is the signed bit. The value is expressed as the complement.";
            sw = rw;
            hw = r;
            reset = 0x0;
        } cscodc0[8:0];
    } VGACSCODC @ 0xCE28;

    reg {
        name = "VGA CSC parameter 0 register";
        desc = "VGACSCP0 is the VGA CSC parameter 0 register (instant register).

Data sheet 11.2.4 VGACSCP0 (offset 0xCE2C, printed page 11-257, `datasheet.txt` line 47457).";

        field {
            name = "cscp01";
            desc = "5.8 data format that consists of a 1-bit signed bit, a 4-bit integral part, and an 8-bit fractional part. The value is expressed as the complement.";
            sw = rw;
            hw = r;
            reset = 0x0;
        } cscp01[28:16];

        field {
            name = "cscp00";
            desc = "5.8 data format that consists of a 1-bit signed bit, a 4-bit integral part, and an 8-bit fractional part. The value is expressed as the complement.";
            sw = rw;
            hw = r;
            reset = 0x100;
        } cscp00[12:0];
    } VGACSCP0 @ 0xCE2C;

    reg {
        name = "VGA CSC parameter 1 register";
        desc = "VGACSCP1 is the VGA CSC parameter 1 register (instant register).

Data sheet 11.2.4 VGACSCP1 (offset 0xCE30, printed page 11-257, `datasheet.txt` line 47488).";

        field {
            name = "cscp10";
            desc = "5.8 data format that consists of a 1-bit signed bit, a 4-bit integral part, and an 8-bit fractional part. The value is expressed as the complement.";
            sw = rw;
            hw = r;
            reset = 0x100;
        } cscp10[28:16];

        field {
            name = "cscp02";
            desc = "5.8 data format that consists of a 1-bit signed bit, a 4-bit integral part, and an 8-bit fractional part. The value is expressed as the complement.";
            sw = rw;
            hw = r;
            reset = 0x15E;
        } cscp02[12:0];
    } VGACSCP1 @ 0xCE30;

    reg {
        name = "VGA CSC parameter 2 register";
        desc = "VGACSCP2 is the VGA CSC parameter 2 register (instant register).

Data sheet 11.2.4 VGACSCP2 (offset 0xCE34, printed page 11-258, `datasheet.txt` line 47530).";

        field {
            name = "cscp12";
            desc = "5.8 data format that consists of a 1-bit signed bit, a 4-bit integral part, and an 8-bit fractional part. The value is expressed as the complement.";
            sw = rw;
            hw = r;
            reset = 0x1FAA;
        } cscp12[28:16];

        field {
            name = "cscp11";
            desc = "5.8 data format that consists of a 1-bit signed bit, a 4-bit integral part, and an 8-bit fractional part. The value is expressed as the complement.";
            sw = rw;
            hw = r;
            reset = 0x1F4E;
        } cscp11[12:0];
    } VGACSCP2 @ 0xCE34;

    reg {
        name = "VGA CSC parameter 3 register";
        desc = "VGACSCP3 is the VGA CSC parameter 3 register (instant register).

Data sheet 11.2.4 VGACSCP3 (offset 0xCE38, printed page 11-259, `datasheet.txt` line 47572).";

        field {
            name = "cscp21";
            desc = "5.8 data format that consists of a 1-bit signed bit, a 4-bit integral part, and an 8-bit fractional part. The value is expressed as the complement.";
            sw = rw;
            hw = r;
            reset = 0x1BB;
        } cscp21[28:16];

        field {
            name = "cscp20";
            desc = "5.8 data format that consists of a 1-bit signed bit, a 4-bit integral part, and an 8-bit fractional part. The value is expressed as the complement.";
            sw = rw;
            hw = r;
            reset = 0x100;
        } cscp20[12:0];
    } VGACSCP3 @ 0xCE38;

    reg {
        name = "VGA CSC parameter 4 register";
        desc = "VGACSCP4 is the VGA CSC parameter 4 register (instant register).

Data sheet 11.2.4 VGACSCP4 (offset 0xCE3C, printed page 11-259, `datasheet.txt` line 47603).";

        field {
            name = "cscp22";
            desc = "5.8 data format that consists of a 1-bit signed bit, a 4-bit integral part, and an 8-bit fractional part. The value is expressed as the complement.";
            sw = rw;
            hw = r;
            reset = 0x0;
        } cscp22[12:0];
    } VGACSCP4 @ 0xCE3C;

    reg {
        name = "Scaling/gamma/ACC coefficient update enable register";
        desc = "Scaling/gamma/ACC coefficient update enable register.

Data sheet 11.2.4 VOPARAUP (offset 0xCE40, printed page 11-260, `datasheet.txt` line 47636).";

        enum VOPARAUP_wbc_vcoef_upd_enum {
            NOT_UPDATED = 0 { name = "Not Updated"; desc = "not updated"; };
            UPDATED = 1 { name = "Updated"; desc = "updated"; };
        };

        field {
            name = "wbc_vcoef_upd";
            desc = "Indicates whether the WBC2 vertical luminance and chrominance filtering coefficients need to be updated. This bit is cleared automatically after the hardware updates coefficients.";
            sw = rw;
            hw = r;
            encode = VOPARAUP_wbc_vcoef_upd_enum;
            reset = 0x0;
        } wbc_vcoef_upd[7:7];

        enum VOPARAUP_wbc_hcoef_upd_enum {
            NOT_UPDATED = 0 { name = "Not Updated"; desc = "not updated"; };
            UPDATED = 1 { name = "Updated"; desc = "updated"; };
        };

        field {
            name = "wbc_hcoef_upd";
            desc = "Indicates whether the WBC2 horizontal luminance and chrominance filtering coefficients need to be updated. This bit is cleared automatically after the hardware updates coefficients.";
            sw = rw;
            hw = r;
            encode = VOPARAUP_wbc_hcoef_upd_enum;
            reset = 0x0;
        } wbc_hcoef_upd[6:6];

        enum VOPARAUP_dhd_gamma_upd_enum {
            NOT_UPDATED = 0 { name = "Not Updated"; desc = "not updated"; };
            UPDATED = 1 { name = "Updated"; desc = "updated"; };
        };

        field {
            name = "dhd_gamma_upd";
            desc = "Indicates whether the DHD gamma correction operation lookup table needs to be updated. This bit is cleared automatically after the hardware updates the table.";
            sw = rw;
            hw = r;
            encode = VOPARAUP_dhd_gamma_upd_enum;
            reset = 0x0;
        } dhd_gamma_upd[5:5];

        enum VOPARAUP_video_acc_upd_enum {
            NOT_UPDATED = 0 { name = "Not Updated"; desc = "not updated"; };
            UPDATED = 1 { name = "Updated"; desc = "updated"; };
        };

        field {
            name = "video_acc_upd";
            desc = "Indicates whether the ACC operation lookup table of the video layer needs to be updated. This bit is cleared automatically after the hardware updates the table.";
            sw = rw;
            hw = r;
            encode = VOPARAUP_video_acc_upd_enum;
            reset = 0x0;
        } video_acc_upd[4:4];

        enum VOPARAUP_vhd_vcoef_upd_enum {
            NOT_UPDATED = 0 { name = "Not Updated"; desc = "not updated"; };
            UPDATED = 1 { name = "Updated"; desc = "updated"; };
        };

        field {
            name = "vhd_vcoef_upd";
            desc = "Indicates whether the VHD vertical luminance and chrominance filtering coefficients need to be updated. This bit is cleared automatically after the hardware updates the coefficients.";
            sw = rw;
            hw = r;
            encode = VOPARAUP_vhd_vcoef_upd_enum;
            reset = 0x0;
        } vhd_vcoef_upd[1:1];

        enum VOPARAUP_vhd_hcoef_upd_enum {
            NOT_UPDATED = 0 { name = "Not Updated"; desc = "not updated"; };
            UPDATED = 1 { name = "Updated"; desc = "updated"; };
        };

        field {
            name = "vhd_hcoef_upd";
            desc = "Indicates whether the VHD horizontal luminance and chrominance filtering coefficients need to be updated. This bit is cleared automatically after the hardware updates the coefficients.";
            sw = rw;
            hw = r;
            encode = VOPARAUP_vhd_hcoef_upd_enum;
            reset = 0x0;
        } vhd_hcoef_upd[0:0];
    } VOPARAUP @ 0xCE40;

    reg {
        name = "VHD horizontal luminance and chrominance filtering coefficient address register";
        desc = "VHDHCOEFAD is a VHD horizontal luminance and chrominance filtering coefficient address register.

Data sheet 11.2.4 VHDHCOEFAD (offset 0xCE44, printed page 11-261, `datasheet.txt` line 47705).";

        field {
            name = "coef_addr";
            desc = "Start address of the local memory for storing coefficients.";
            sw = rw;
            hw = r;
            reset = 0x0;
        } coef_addr[31:0];
    } VHDHCOEFAD @ 0xCE44;

    reg {
        name = "VHD vertical luminance and horizontal chrominance filtering coefficient address register";
        desc = "VHDVCOEFAD is a VHD vertical luminance and horizontal chrominance filtering coefficient address register.

Data sheet 11.2.4 VHDVCOEFAD (offset 0xCE48, printed page 11-261, `datasheet.txt` line 47724).";

        field {
            name = "coef_addr";
            desc = "Start address of the local memory for storing coefficients.";
            sw = rw;
            hw = r;
            reset = 0x0;
        } coef_addr[31:0];
    } VHDVCOEFAD @ 0xCE48;

    reg {
        name = "WBC2 horizontal luminance and chrominance filtering coefficient address register";
        desc = "WBC2HCOEFAD is a WBC2 horizontal luminance and chrominance filtering coefficient address register.

Data sheet 11.2.4 WBC2HCOEFAD (offset 0xCE58, printed page 11-262, `datasheet.txt` line 47754).";

        field {
            name = "coef_addr";
            desc = "Start address of the local memory for storing coefficients.";
            sw = rw;
            hw = r;
            reset = 0x0;
        } coef_addr[31:0];
    } WBC2HCOEFAD @ 0xCE58;

    reg {
        name = "WBC2 vertical luminance and horizontal chrominance filtering coefficient address register";
        desc = "WBC2VCOEFAD is a WBC2 vertical luminance and horizontal chrominance filtering coefficient address register.

Data sheet 11.2.4 WBC2VCOEFAD (offset 0xCE5C, printed page 11-262, `datasheet.txt` line 47774).";

        field {
            name = "coef_addr";
            desc = "Start address of the local memory for storing coefficients.";
            sw = rw;
            hw = r;
            reset = 0x0;
        } coef_addr[31:0];
    } WBC2VCOEFAD @ 0xCE5C;

    reg {
        name = "VHDHLCOEF";
        desc = "Data sheet 11.2.4 VHDHLCOEF (offset 0xD000, printed page 11-263, `datasheet.txt` line 47810).";

        field {
            name = "hlcoefn2";
            desc = "Horizontal luminance scaling/filtering coefficient. Indicates the tap-2 coefficients when bits[3:0] of the register address are 0x0. Indicates the tap-4 coefficients when bits[3:0] of the register address are 0x4. Indicates the tap-6 coefficients when bits[3:0] of the register address are 0x8. Indicates the tap-8 coefficients when bits[3:0] of the register address are 0xC.";
            sw = rw;
            hw = r;
            reset = 0x0;
        } hlcoefn2[25:16];

        field {
            name = "hlcoefn1";
            desc = "Horizontal luminance scaling/filtering coefficient. Indicates the tap-1 coefficients when bits[3:0] of the register address are 0x0. Indicate the tap-3 coefficients when bits[3:0] of the register address are 0x4. Indicates the tap-5 coefficients when bits[3:0] of the register address are 0x8. Indicates the tap-7 coefficients when bits[3:0] of the register address are 0xC.";
            sw = rw;
            hw = r;
            reset = 0x0;
        } hlcoefn1[9:0];
    } VHDHLCOEF @ 0xD000;

    reg {
        name = "VHDHCCOEF";
        desc = "Data sheet 11.2.4 VHDHCCOEF (offset 0xD200, printed page 11-264, `datasheet.txt` line 47863).";

        field {
            name = "hccoefn2";
            desc = "Horizontal chrominance scaling/filtering coefficient. Indicates the tap-2 coefficients when bits[3:0] of the register address are 0x0 or 0x8. Indicates the tap-4 coefficients when bits[3:0] of the register address are 0x4 or 0xC.";
            sw = rw;
            hw = r;
            reset = 0x0;
        } hccoefn2[25:16];

        field {
            name = "hccoefn1";
            desc = "Horizontal chrominance scaling/filtering coefficient. Indicates the tap-1 coefficients when bits[3:0] of the register address are 0x0 or 0x8. Indicates the tap-3 coefficients when bits[3:0] of the register address are 0x4 or 0xC.";
            sw = rw;
            hw = r;
            reset = 0x0;
        } hccoefn1[9:0];
    } VHDHCCOEF @ 0xD200;

    reg {
        name = "VHD vertical luminance scaling/filtering coefficient register";
        desc = "VHDVLCOEF is a VHD vertical luminance scaling/filtering coefficient register. For details about the storage format, see the description of the VHDHLCOEF register. The VHD vertical luminance scaling coefficients have six taps and 32 phases. As the coefficients are symmetrical, there are 17 groups of coefficients. That is, 4-tap coefficients of phases 0-16 are stored. Each register address has two 10-bit coefficients. Therefore, four 32-bit register addresses are required for storing the 6-tap coefficients of each phase.

Data sheet 11.2.4 VHDVLCOEF (offset 0xD400, printed page 11-264, `datasheet.txt` line 47898).";

        field {
            name = "vlcoefn2";
            desc = "Vertical luminance scaling/filtering coefficient. Indicates the tap-2 coefficients when bit[3:0] of the register address are 0x0. Indicate the tap-4 coefficients when bits[3:0] of the register address are 0x4. Indicates the tap-6 coefficients when bits[3:0] of the register address are 0x8. Indicates a reserved field when bits[3:0] of the register address is 0xC.";
            sw = rw;
            hw = r;
            reset = 0x0;
        } vlcoefn2[25:16];

        field {
            name = "vlcoefn1";
            desc = "Vertical luminance scaling/filtering coefficient. Indicates the tap-1 coefficients when bits[3:0] of the register address are 0x0. Indicate the tap-3 coefficients when bits[3:0] of the register address are 0x4. Indicates the tap-5 coefficients when bits[3:0] of the register address are 0x8. Indicates a reserved field when bits[3:0] of the register address is 0xC.";
            sw = rw;
            hw = r;
            reset = 0x0;
        } vlcoefn1[9:0];
    } VHDVLCOEF @ 0xD400;

    reg {
        name = "VHD vertical chrominance scaling/filtering coefficient register";
        desc = "VHDVCCOEF is a VHD vertical chrominance scaling/filtering coefficient register. For details about the storage format, see the description of the VHDHLCOEF register. The VHD horizontal chrominance scaling coefficients have four taps and 32 phases. As the coefficients are symmetrical, there are 17 groups of coefficients. That is, 4-tap coefficients of phases 0-16 are stored. Each register address has two 10-bit coefficients. Therefore, two 32- bit register addresses are required for storing the 4-tap coefficients of each phase.

Data sheet 11.2.4 VHDVCCOEF (offset 0xD600, printed page 11-265, `datasheet.txt` line 47952).";

        field {
            name = "vccoefn2";
            desc = "Vertical luminance scaling/filtering coefficient. Indicates the tap-2 coefficients when bits[3:0] of the register address are 0x0 or 0x8. Indicates the tap-4 coefficients when bits[3:0] of the register address are 0x4 or 0xC.";
            sw = rw;
            hw = r;
            reset = 0x0;
        } vccoefn2[25:16];

        field {
            name = "vccoefn1";
            desc = "Vertical luminance scaling/filtering coefficient. Indicates the tap-1 coefficients when bits[3:0] of the register address are 0x0 or 0x8. Indicates the tap-3 coefficients when bits[3:0] of the register address are 0x4 or 0xC.";
            sw = rw;
            hw = r;
            reset = 0x0;
        } vccoefn1[9:0];
    } VHDVCCOEF @ 0xD600;

    reg {
        name = "WBC horizontal luminance scaling/filtering coefficient register";
        desc = "WBCHLCOEF is a WBC horizontal luminance scaling/filtering coefficient register. Each filtering coefficient is 10 bits consisting of one signed bit and nine fractional bits. The MSB is the signed bit and the lower nine bits are the absolute values of the fractional bits. As the coefficients are stored in the on-chip memory, the default value is variable. The WBC horizontal luminance scaling coefficients have eight taps and 32 phases. As the coefficients are symmetrical, there are 17 groups of coefficients. That is, 8-tap coefficients of phases 0-16 are stored. Each register address has two 10-bit coefficients. Therefore, four 32- bit register addresses are required for storing the 8-tap coefficients of each phase.

Data sheet 11.2.4 WBCHLCOEF (offset 0xE000, printed page 11-266, `datasheet.txt` line 48000).";

        field {
            name = "hlcoefn2";
            desc = "Horizontal luminance scaling/filtering coefficient. Indicates the tap-2 coefficients when bit[3:0] of the register address are 0x0. Indicate the tap-4 coefficients when bits[3:0] of the register address are 0x4. Indicates the tap-6 coefficients when bits[3:0] of the register address are 0x8. Indicates the tap-8 coefficients when bits[3:0] of the register address are 0xC.";
            sw = rw;
            hw = r;
            reset = 0x0;
        } hlcoefn2[25:16];

        field {
            name = "hlcoefn1";
            desc = "Horizontal luminance scaling/filtering coefficient. Indicates the tap-1 coefficients when bits[3:0] of the register address are 0x0. Indicate the tap-3 coefficients when bits[3:0] of the register address are 0x4. Indicates the tap-5 coefficients when bits[3:0] of the register address are 0x8. Indicates the tap-7 coefficients when bits[3:0] of the register address are 0xC.";
            sw = rw;
            hw = r;
            reset = 0x0;
        } hlcoefn1[9:0];
    } WBCHLCOEF @ 0xE000;

    reg {
        name = "WBC horizontal chrominance scaling/filtering coefficient register";
        desc = "WBCHCCOEF is a WBC horizontal chrominance scaling/filtering coefficient register. For details about the storage format, see the description of the WBCHLCOEF register. The VHD horizontal luminance scaling coefficients have four taps and 32 phases. As the coefficients are symmetrical, there are 17 groups of coefficients. That is, 4-tap coefficients of phases 0-16 are stored. Each register address has two 10-bit coefficients. Therefore, two 32- bit register addresses are required for storing the 4-tap coefficients of each phase.

Data sheet 11.2.4 WBCHCCOEF (offset 0xE200, printed page 11-267, `datasheet.txt` line 48053).";

        field {
            name = "hccoefn2";
            desc = "Horizontal chrominance scaling/filtering coefficient. Indicates the tap-2 coefficients when bits[3:0] of the register address are 0x0 or 0x8. Indicates the tap-4 coefficients when bits[3:0] of the register address are 0x4 or 0xC.";
            sw = rw;
            hw = r;
            reset = 0x0;
        } hccoefn2[25:16];

        field {
            name = "hccoefn1";
            desc = "Horizontal chrominance scaling/filtering coefficient. Indicates the tap-1 coefficients when bits[3:0] of the register address are 0x0 or 0x8. Indicates the tap-3 coefficients when bits[3:0] of the register address are 0x4 or 0xC.";
            sw = rw;
            hw = r;
            reset = 0x0;
        } hccoefn1[9:0];
    } WBCHCCOEF @ 0xE200;

    reg {
        name = "WBCVLCOEF";
        desc = "Data sheet 11.2.4 WBCVLCOEF (offset 0xE400, printed page 11-268, `datasheet.txt` line 48097).";

        field {
            name = "vlcoefn2";
            desc = "Vertical luminance scaling/filtering coefficient. Indicates the tap-2 coefficients when bit[3:0] of the register address are 0x0. Indicate the tap-4 coefficients when bits[3:0] of the register address are 0x4. Indicates the tap-6 coefficients when bits[3:0] of the register address are 0x8. Indicates a reserved field when bits[3:0] of the register address is 0xC.";
            sw = rw;
            hw = r;
            reset = 0x0;
        } vlcoefn2[25:16];

        field {
            name = "vlcoefn1";
            desc = "Vertical luminance scaling/filtering coefficient. Indicates the tap-1 coefficients when bits[3:0] of the register address are 0x0. Indicate the tap-3 coefficients when bits[3:0] of the register address are 0x4. Indicates the tap-5 coefficients when bits[3:0] of the register address are 0x8. Indicates a reserved field when bits[3:0] of the register address is 0xC.";
            sw = rw;
            hw = r;
            reset = 0x0;
        } vlcoefn1[9:0];
    } WBCVLCOEF @ 0xE400;

    reg {
        name = "WBCVCCOEF";
        desc = "Data sheet 11.2.4 WBCVCCOEF (offset 0xE600, printed page 11-269, `datasheet.txt` line 48149).";

        field {
            name = "vccoefn2";
            desc = "Vertical luminance scaling/filtering coefficient. Indicates the tap-2 coefficients when bits[3:0] of the register address are 0x0 or 0x8. Indicates the tap-4 coefficients when bits[3:0] of the register address are 0x4 or 0xC.";
            sw = rw;
            hw = r;
            reset = 0x0;
        } vccoefn2[25:16];

        field {
            name = "vccoefn1";
            desc = "Vertical luminance scaling/filtering coefficient. Indicates the tap-1 coefficients when bits[3:0] of the register address are 0x0 or 0x8. Indicates the tap-3 coefficients when bits[3:0] of the register address are 0x4 or 0xC.";
            sw = rw;
            hw = r;
            reset = 0x0;
        } vccoefn1[9:0];
    } WBCVCCOEF @ 0xE600;

    eHISI_VDP_VHDP VHDP[16] @ 0x400 += 0x20;
    eHISI_VDP_VSD VSD[2] @ 0x3000 += 0x1000;

};

`endif
