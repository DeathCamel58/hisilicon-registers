`ifndef HISI_USB_DEVICE_RDL
`define HISI_USB_DEVICE_RDL

regfile eHISI_USB_DEVICE_INEP0 {
    name = "USB device IN endpoint 0 registers";
    desc = "Per-endpoint device register set (offsets relative to the start of the set; endpoint n is at 0x900 + 0x20 x n). Endpoint 0 has its own control and transfer-size layouts.";

    reg {
        name = "Control register for device control IN endpoint 0";
        desc = "DIEPCTL0 is a control register for device control IN endpoint 0.

Data sheet 12.7.5.2 DIEPCTL0 (offset 0x900, printed page 12-224, `Hi3518EV20X-Hi3516CV200-Datasheet.txt` line 89586).";

        enum DIEPCTL_epena_enum {
            INVALID = 0 { name = "Invalid"; desc = "invalid"; };
            VALID = 1 { name = "Valid"; desc = "valid"; };
        };

        field {
            name = "epena";
            desc = "Endpoint enable When the IN endpoint works in scatter or gather DMA mode, this bit indicates that the descriptor structure and data buffer used for transmitting data have been set up. When the scatter or gather DMA mode is disabled, this bit indicates that data to be transmitted is ready.";
            sw = rw;
            hw = w;
            encode = DIEPCTL_epena_enum;
            reset = 0x0;
        } epena[31:31];

        enum DIEPCTL_epdis_enum {
            INVALID = 0 { name = "Invalid"; desc = "invalid"; };
            VALID = 1 { name = "Valid"; desc = "valid"; };
        };

        field {
            name = "epdis";
            desc = "Endpoint disable The application program sets this bit to 1 to end the data transmission of this endpoint. This bit is enabled only in DMA mode.";
            sw = rw;
            hw = w;
            encode = DIEPCTL_epdis_enum;
            reset = 0x0;
        } epdis[30:30];

        enum DIEPCTL_snak_enum {
            INVALID = 0 { name = "Invalid"; desc = "invalid"; };
            VALID = 1 { name = "Valid"; desc = "valid"; };
        };

        field {
            name = "snak";
            desc = "NAK configuration Writing to this bit sets the NAK bit of the endpoint to 1. The application program can use this bit to control the NAK handshake of an endpoint during a transfer. The controller core can set this bit of an endpoint after this endpoint receives the setup packet.";
            sw = w;
            hw = r;
            encode = DIEPCTL_snak_enum;
            reset = 0x0;
        } snak[27:27];

        enum DIEPCTL_cnak_enum {
            INVALID = 0 { name = "Invalid"; desc = "invalid"; };
            VALID = 1 { name = "Valid"; desc = "valid"; };
        };

        field {
            name = "cnak";
            desc = "NAK clear Writing to this bit clears the NAK bit of the endpoint.";
            sw = w;
            hw = r;
            encode = DIEPCTL_cnak_enum;
            reset = 0x0;
        } cnak[26:26];

        field {
            name = "txfnum";
            desc = "Number of TX FIFOs";
            sw = rw;
            hw = r;
            reset = 0x0;
        } txfnum[25:22];

        enum DIEPCTL_stall_enum {
            INVALID = 0 { name = "Invalid"; desc = "invalid"; };
            VALID = 1 { name = "Valid"; desc = "valid"; };
        };

        field {
            name = "stall";
            desc = "Stall handshake The application program can set this bit. The controller core clears this bit after the endpoint receives the setup packet.";
            sw = rw;
            hw = w;
            encode = DIEPCTL_stall_enum;
            reset = 0x0;
        } stall[21:21];

        enum DIEPCTL_eptype_enum {
            CONTROL_TRANSFER_ENDPOINT = 0 { name = "Control Transfer Endpoint"; desc = "control transfer endpoint"; };
            REAL_TIME_TRANSFER = 1 { name = "Real Time Transfer"; desc = "real-time transfer endpoint"; };
            BULK_TRANSFER_ENDPOINT = 2 { name = "Bulk Transfer Endpoint"; desc = "bulk transfer endpoint"; };
            INTERRUPT_TRANSFER_ENDPOINT = 3 { name = "Interrupt Transfer Endpoint"; desc = "interrupt transfer endpoint"; };
        };

        field {
            name = "eptype";
            desc = "Endpoint type";
            sw = r;
            hw = w;
            encode = DIEPCTL_eptype_enum;
            reset = 0x0;
        } eptype[19:18];

        enum DIEPCTL_naksts_enum {
            NON_NAK_HANDSHAKE = 0 { name = "Non Nak Handshake"; desc = "non-NAK handshake TX"; };
            NAK_HANDSHAKE_TX = 1 { name = "Nak Handshake Tx"; desc = "NAK handshake TX"; };
        };

        field {
            name = "naksts";
            desc = "NAK status";
            sw = r;
            hw = w;
            encode = DIEPCTL_naksts_enum;
            reset = 0x0;
        } naksts[17:17];

        enum DIEPCTL_usbactep_enum {
            INVALID = 0 { name = "Invalid"; desc = "invalid"; };
            VALID = 1 { name = "Valid"; desc = "valid"; };
        };

        field {
            name = "usbactep";
            desc = "USB activation endpoint 0 This bit is always 1, indicating that control endpoint 0 is always valid.";
            sw = r;
            hw = w;
            encode = DIEPCTL_usbactep_enum;
            reset = 0x1;
        } usbactep[15:15];

        field {
            name = "nextep";
            desc = "Next endpoint This field specifies the ID of the next endpoint that receives data.";
            sw = r;
            hw = w;
            reset = 0x0;
        } nextep[14:11];

        enum DIEPCTL_mps_enum {
            V_64_BYTES = 0 { name = "V 64 Bytes"; desc = "64 bytes"; };
            V_32_BYTES = 1 { name = "V 32 Bytes"; desc = "32 bytes"; };
            V_16_BYTES = 2 { name = "V 16 Bytes"; desc = "16 bytes"; };
            V_8_BYTES = 3 { name = "V 8 Bytes"; desc = "8 bytes"; };
        };

        field {
            name = "mps";
            desc = "Minimum packet size";
            sw = rw;
            hw = r;
            encode = DIEPCTL_mps_enum;
            reset = 0x0;
        } mps[1:0];
    } DIEPCTL @ 0x0;

    reg {
        name = "Device IN endpoint interrupt register";
        desc = "DIEPINT is an interrupt register for device IN endpoint n.

The data sheet prints one field table for both registers whose field names are partly garbled (`An`, `endpoints`, `TimeOUT_SetUp`) and merges the IN and OUT bit descriptions; the bit layout here follows the standard DWC_otg 2.x/3.x register map (which the data sheet's DIEPMSK/DOEPMSK registers confirm), the descriptions use the data sheet text. Bits are set by hardware and cleared by writing 1.

Data sheet 12.7.5.2 DIEPINTn (printed page 12-234, `Hi3518EV20X-Hi3516CV200-Datasheet.txt` line 90114).";

        enum DIEPINT_nyetintrpt_enum {
            INTERRUPT_CLEARED = 0 { name = "Interrupt Cleared"; desc = "An interrupt is cleared."; };
            INTERRUPT_GENERATED_WRITING = 1 { name = "Interrupt Generated Writing"; desc = "An interrupt is generated. Writing 1 clears the bit."; };
        };

        field {
            name = "nyetintrpt";
            desc = "NYET interrupt. NYET response TX interrupt.";
            sw = rw;
            hw = w;
            onwrite = woclr;
            encode = DIEPINT_nyetintrpt_enum;
            reset = 0x0;
        } nyetintrpt[14:14];

        enum DIEPINT_nakintrpt_enum {
            INTERRUPT_CLEARED = 0 { name = "Interrupt Cleared"; desc = "An interrupt is cleared."; };
            INTERRUPT_GENERATED_WRITING = 1 { name = "Interrupt Generated Writing"; desc = "An interrupt is generated. Writing 1 clears the bit."; };
        };

        field {
            name = "nakintrpt";
            desc = "NAK interrupt. NAK TX interrupt.";
            sw = rw;
            hw = w;
            onwrite = woclr;
            encode = DIEPINT_nakintrpt_enum;
            reset = 0x0;
        } nakintrpt[13:13];

        enum DIEPINT_bbleerr_enum {
            INTERRUPT_CLEARED = 0 { name = "Interrupt Cleared"; desc = "An interrupt is cleared."; };
            INTERRUPT_GENERATED_WRITING = 1 { name = "Interrupt Generated Writing"; desc = "An interrupt is generated. Writing 1 clears the bit."; };
        };

        field {
            name = "bbleerr";
            desc = "Babble error interrupt. Endpoint received babble interrupt.";
            sw = rw;
            hw = w;
            onwrite = woclr;
            encode = DIEPINT_bbleerr_enum;
            reset = 0x0;
        } bbleerr[12:12];

        enum DIEPINT_pktdrpsts_enum {
            INTERRUPT_CLEARED = 0 { name = "Interrupt Cleared"; desc = "An interrupt is cleared."; };
            INTERRUPT_GENERATED_WRITING = 1 { name = "Interrupt Generated Writing"; desc = "An interrupt is generated. Writing 1 clears the bit."; };
        };

        field {
            name = "pktdrpsts";
            desc = "Packet drop status interrupt";
            sw = rw;
            hw = w;
            onwrite = woclr;
            encode = DIEPINT_pktdrpsts_enum;
            reset = 0x0;
        } pktdrpsts[11:11];

        enum DIEPINT_bnaintr_enum {
            INTERRUPT_CLEARED = 0 { name = "Interrupt Cleared"; desc = "An interrupt is cleared."; };
            INTERRUPT_GENERATED_WRITING = 1 { name = "Interrupt Generated Writing"; desc = "An interrupt is generated. Writing 1 clears the bit."; };
        };

        field {
            name = "bnaintr";
            desc = "BNA interrupt. An interrupt is generated when descriptor access is not ready.";
            sw = rw;
            hw = w;
            onwrite = woclr;
            encode = DIEPINT_bnaintr_enum;
            reset = 0x0;
        } bnaintr[9:9];

        enum DIEPINT_txfifoundrn_enum {
            INTERRUPT_CLEARED = 0 { name = "Interrupt Cleared"; desc = "An interrupt is cleared."; };
            INTERRUPT_GENERATED_WRITING = 1 { name = "Interrupt Generated Writing"; desc = "An interrupt is generated. Writing 1 clears the bit."; };
        };

        field {
            name = "txfifoundrn";
            desc = "FIFO underrun interrupt. An interrupt is generated when the FIFO underrun conditions are detected. Valid when OTG_EN_DED_TX_FIFO is 1 and thresholding is enabled.";
            sw = rw;
            hw = w;
            onwrite = woclr;
            encode = DIEPINT_txfifoundrn_enum;
            reset = 0x0;
        } txfifoundrn[8:8];

        enum DIEPINT_txfemp_enum {
            INTERRUPT_CLEARED = 0 { name = "Interrupt Cleared"; desc = "An interrupt is cleared."; };
            INTERRUPT_GENERATED = 1 { name = "Interrupt Generated"; desc = "An interrupt is generated."; };
        };

        field {
            name = "txfemp";
            desc = "TX FIFO empty status interrupt. An interrupt is generated when the TX FIFO is empty or half empty.";
            sw = r;
            hw = w;
            encode = DIEPINT_txfemp_enum;
            reset = 0x0;
        } txfemp[7:7];

        enum DIEPINT_inepnakeff_enum {
            INTERRUPT_CLEARED = 0 { name = "Interrupt Cleared"; desc = "An interrupt is cleared."; };
            INTERRUPT_GENERATED_WRITING = 1 { name = "Interrupt Generated Writing"; desc = "An interrupt is generated. Writing 1 clears the bit."; };
        };

        field {
            name = "inepnakeff";
            desc = "IN endpoint NAK effective interrupt. An interrupt is generated when the IN endpoint NAK bit is set.";
            sw = rw;
            hw = w;
            onwrite = woclr;
            encode = DIEPINT_inepnakeff_enum;
            reset = 0x0;
        } inepnakeff[6:6];

        enum DIEPINT_intknepmis_enum {
            INTERRUPT_CLEARED = 0 { name = "Interrupt Cleared"; desc = "An interrupt is cleared."; };
            INTERRUPT_GENERATED_WRITING = 1 { name = "Interrupt Generated Writing"; desc = "An interrupt is generated. Writing 1 clears the bit."; };
        };

        field {
            name = "intknepmis";
            desc = "IN token received with EP mismatch interrupt. An interrupt is generated when IN tokens with mismatched EP are received.";
            sw = rw;
            hw = w;
            onwrite = woclr;
            encode = DIEPINT_intknepmis_enum;
            reset = 0x0;
        } intknepmis[5:5];

        enum DIEPINT_intktxfemp_enum {
            INTERRUPT_CLEARED = 0 { name = "Interrupt Cleared"; desc = "An interrupt is cleared."; };
            INTERRUPT_GENERATED_WRITING = 1 { name = "Interrupt Generated Writing"; desc = "An interrupt is generated. Writing 1 clears the bit."; };
        };

        field {
            name = "intktxfemp";
            desc = "IN token received when TX FIFO empty interrupt. An interrupt is generated if IN tokens are received when the corresponding TX FIFO is empty.";
            sw = rw;
            hw = w;
            onwrite = woclr;
            encode = DIEPINT_intktxfemp_enum;
            reset = 0x0;
        } intktxfemp[4:4];

        enum DIEPINT_timeout_enum {
            INTERRUPT_CLEARED = 0 { name = "Interrupt Cleared"; desc = "An interrupt is cleared."; };
            INTERRUPT_GENERATED_WRITING = 1 { name = "Interrupt Generated Writing"; desc = "An interrupt is generated. Writing 1 clears the bit."; };
        };

        field {
            name = "timeout";
            desc = "Timeout interrupt. An interrupt is generated when timeout conditions are detected.";
            sw = rw;
            hw = w;
            onwrite = woclr;
            encode = DIEPINT_timeout_enum;
            reset = 0x0;
        } timeout[3:3];

        enum DIEPINT_ahberr_enum {
            INTERRUPT_CLEARED = 0 { name = "Interrupt Cleared"; desc = "An interrupt is cleared."; };
            INTERRUPT_GENERATED_WRITING = 1 { name = "Interrupt Generated Writing"; desc = "An interrupt is generated. Writing 1 clears the bit."; };
        };

        field {
            name = "ahberr";
            desc = "AHB error interrupt. An interrupt is generated when an AHB error occurs during AHB read/write operations in internal DMA mode.";
            sw = rw;
            hw = w;
            onwrite = woclr;
            encode = DIEPINT_ahberr_enum;
            reset = 0x0;
        } ahberr[2:2];

        enum DIEPINT_epdisbld_enum {
            INTERRUPT_CLEARED = 0 { name = "Interrupt Cleared"; desc = "An interrupt is cleared."; };
            INTERRUPT_GENERATED_WRITING = 1 { name = "Interrupt Generated Writing"; desc = "An interrupt is generated. Writing 1 clears the bit."; };
        };

        field {
            name = "epdisbld";
            desc = "Endpoint disabled interrupt";
            sw = rw;
            hw = w;
            onwrite = woclr;
            encode = DIEPINT_epdisbld_enum;
            reset = 0x0;
        } epdisbld[1:1];

        enum DIEPINT_xfercompl_enum {
            INTERRUPT_CLEARED = 0 { name = "Interrupt Cleared"; desc = "An interrupt is cleared."; };
            INTERRUPT_GENERATED_WRITING = 1 { name = "Interrupt Generated Writing"; desc = "An interrupt is generated. Writing 1 clears the bit."; };
        };

        field {
            name = "xfercompl";
            desc = "Transfer completion interrupt";
            sw = rw;
            hw = w;
            onwrite = woclr;
            encode = DIEPINT_xfercompl_enum;
            reset = 0x0;
        } xfercompl[0:0];
    } DIEPINT @ 0x8;

    reg {
        name = "Transfer size register for device IN endpoint 0";
        desc = "DIEPTSIZ0 is a transfer size register for device IN endpoint 0.

Data sheet 12.7.5.2 DIEPTSIZ0 (offset 0x910, printed page 12-239, `Hi3518EV20X-Hi3516CV200-Datasheet.txt` line 90398).";

        field {
            name = "pktcnt";
            desc = "Number of packets";
            sw = rw;
            hw = r;
            reset = 0x0;
        } pktcnt[20:19];

        field {
            name = "xfersize";
            desc = "Transferred data size";
            sw = rw;
            hw = r;
            reset = 0x0;
        } xfersize[6:0];
    } DIEPTSIZ @ 0x10;

    reg {
        name = "DMA address register for device IN endpoint n";
        desc = "DIEPDMAN is a DMA address register for device IN endpoint n.

Data sheet 12.7.5.2 DIEPDMAN (offset 0x914, printed page 12-242, `Hi3518EV20X-Hi3516CV200-Datasheet.txt` line 90576).";

        field {
            name = "dmaaddr";
            desc = "DMA address";
            sw = rw;
            hw = r;
            reset = 0x0;
        } dmaaddr[31:0];
    } DIEPDMA @ 0x14;

    reg {
        name = "Device IN endpoint TX FIFO status register";
        desc = "DTXFSTSn is a TX FIFO status register for device IN endpoints.

Data sheet offset error: the summary lists a single register at 0x0938 (= IN endpoint 1 in this layout) without an array; every IN endpoint has this register at +0x18 of its register set (0x918 + 0x20 x n, as in the DWC_otg databook).

Data sheet 12.7.5.2 DTXFSTSn (offset 0x938, printed page 12-243, `Hi3518EV20X-Hi3516CV200-Datasheet.txt` line 90665).";

        enum DTXFSTS_ineptxfspcavail_enum {
            ENDPOINT_TX_FIFO = 0x0 { name = "Endpoint Tx Fifo"; desc = "The endpoint TX FIFO is full."; };
            ONE_WORD_AVAILABLE = 0x1 { name = "One Word Available"; desc = "One word is available."; };
            TWO_WORDS_AVAILABLE = 0x2 { name = "Two Words Available"; desc = "Two words are available. 0xn: n words (0 <= n <= 32768) are available."; };
            V_32768_WORDS_AVAILABLE = 0x8000 { name = "V 32768 Words Available"; desc = "32768 words are available. Other values: reserved"; };
        };

        field {
            name = "ineptxfspcavail";
            desc = "Available space for the IN endpoint TX FIFO";
            sw = r;
            hw = w;
            encode = DTXFSTS_ineptxfspcavail_enum;
            reset = 0x0;
        } ineptxfspcavail[15:0];
    } DTXFSTS @ 0x18;

    reg {
        name = "DMA buffer address register for device IN endpoint n";
        desc = "DIEPDMABN is a DMA buffer address register for device IN endpoint n.

Data sheet 12.7.5.2 DIEPDMABN (offset 0x91C, printed page 12-242, `Hi3518EV20X-Hi3516CV200-Datasheet.txt` line 90618).";

        field {
            name = "dmabufferaddr";
            desc = "DMA buffer address";
            sw = r;
            hw = w;
            reset = 0x0;
        } dmabufferaddr[31:0];
    } DIEPDMAB @ 0x1C;
};

regfile eHISI_USB_DEVICE_INEP {
    name = "USB device IN endpoint n registers";
    desc = "Per-endpoint device register set (offsets relative to the start of the set; endpoint n is at 0x900 + 0x20 x n). Used for n = 1..15.";

    reg {
        name = "Control register for device control IN endpoint 0";
        desc = "DIEPCTLN is a control register for device IN endpoint n.

Endpoint n = 1..15 (endpoint 0 is the separate IN_EP0 register set).

Data sheet 12.7.5.2 DIEPCTLN (offset 0x900, printed page 12-228, `Hi3518EV20X-Hi3516CV200-Datasheet.txt` line 89794).";

        field {
            name = "epena";
            desc = "Endpoint enable When the scatter or gather DMA is enabled: 0: The descriptor structure and the data TX function of the data buffer are disabled. 1: The descriptor structure and the data TX function of the data buffer are disabled. When the scatter/gather DMA is disabled: 0: The data on endpoints is not ready. 1: The data on endpoints is ready.";
            sw = rw;
            hw = w;
            reset = 0x0;
        } epena[31:31];

        enum DIEPCTL_epdis_enum {
            ENABLED = 0 { name = "Enabled"; desc = "enabled"; };
            DISABLED = 1 { name = "Disabled"; desc = "disabled"; };
        };

        field {
            name = "epdis";
            desc = "Endpoint disable This bit applies to the IN and OUT endpoints. The application program can set this bit to 1 to stop the data transmission/reception of an IN/OUT endpoint.";
            sw = rw;
            hw = w;
            encode = DIEPCTL_epdis_enum;
            reset = 0x0;
        } epdis[30:30];

        field {
            name = "setd1pid_setoddfr";
            desc = "DATA1 PID/odd micro-frame configuration The data PID of the interrupt endpoint and bulk IN/OUT endpoint can be set to DATA1 by setting this bit to 1. 0: invalid 1: valid For the real-time IN/OUT endpoint, the odd and even micro-frames can be set to odd micro-frames by setting this bit to 1. 0: invalid 1: valid";
            sw = w;
            hw = r;
            reset = 0x0;
        } setd1pid_setoddfr[29:29];

        field {
            name = "setd0pid_setevenfr";
            desc = "DATA0 PID/even micro-frame configuration The data PID of the interrupt endpoint and bulk IN/OUT endpoint can be set to DATA0 by setting this bit to 1. 0: invalid 1: valid For the real-time IN/OUT endpoint, the odd and even micro-frames can be set to even micro-frames by setting this bit to 1. 0: invalid 1: valid";
            sw = w;
            hw = r;
            reset = 0x0;
        } setd0pid_setevenfr[28:28];

        enum DIEPCTL_snak_enum {
            INVALID = 0 { name = "Invalid"; desc = "invalid"; };
            VALID = 1 { name = "Valid"; desc = "valid"; };
        };

        field {
            name = "snak";
            desc = "NAK configuration Writing to this bit sets the NAK bit of the endpoint to 1. The application program can use this bit to control the NAK handshake of an endpoint during a transfer. For an OUT endpoint, this bit is set after the controller core receives the transfer completion interrupt or the OUT endpoint receives the setup packet.";
            sw = w;
            hw = r;
            encode = DIEPCTL_snak_enum;
            reset = 0x0;
        } snak[27:27];

        enum DIEPCTL_cnak_enum {
            INVALID = 0 { name = "Invalid"; desc = "invalid"; };
            VALID = 1 { name = "Valid"; desc = "valid"; };
        };

        field {
            name = "cnak";
            desc = "NAK clear Writing to this bit clears the NAK bit of an IN/OUT endpoint.";
            sw = w;
            hw = r;
            encode = DIEPCTL_cnak_enum;
            reset = 0x0;
        } cnak[26:26];

        field {
            name = "txfnum";
            desc = "Number of TX FIFOs Shared FIFO operation: 0: non-periodic TX FIFO Other values: specified periodic TX FIFO number Dedicated FIFO operation: Number of FIFOs This field is valid only for IN endpoints.";
            sw = rw;
            hw = r;
            reset = 0x0;
        } txfnum[25:22];

        field {
            name = "stall";
            desc = "Stall handshake (RW) This bit applies to the non-control transfer and non-real-time transfer IN and OUT endpoints. If this bit is set to 1, the application program blocks the token packets transmitted from the USB host controller to the endpoint. 0: invalid 1: valid For the control endpoint (RWSC), this bit is set to 1 by the application program and cleared by the controller core only when the endpoint receives the setup token. 0: invalid 1: valid";
            sw = rw;
            hw = r;
            reset = 0x0;
        } stall[21:21];

        enum DIEPCTL_snp_enum {
            INVALID = 0 { name = "Invalid"; desc = "invalid"; };
            VALID = 1 { name = "Valid"; desc = "valid"; };
        };

        field {
            name = "snp";
            desc = "Snooping mode This bit is used to set the OUT endpoints to the snooping mode. In snooping mode, the controller core does not check whether the OUT packet is correct before sending the packet to the application memory.";
            sw = rw;
            hw = r;
            encode = DIEPCTL_snp_enum;
            reset = 0x0;
        } snp[20:20];

        enum DIEPCTL_eptype_enum {
            CONTROL_TRANSFER_ENDPOINT = 0 { name = "Control Transfer Endpoint"; desc = "control transfer endpoint"; };
            REAL_TIME_TRANSFER = 1 { name = "Real Time Transfer"; desc = "real-time transfer endpoint"; };
            BULK_TRANSFER_ENDPOINT = 2 { name = "Bulk Transfer Endpoint"; desc = "bulk transfer endpoint"; };
            INTERRUPT_TRANSFER_ENDPOINT = 3 { name = "Interrupt Transfer Endpoint"; desc = "interrupt transfer endpoint"; };
        };

        field {
            name = "eptype";
            desc = "Endpoint type";
            sw = rw;
            hw = r;
            encode = DIEPCTL_eptype_enum;
            reset = 0x0;
        } eptype[19:18];

        enum DIEPCTL_naksts_enum {
            NON_NAK_HANDSHAKE = 0 { name = "Non Nak Handshake"; desc = "non-NAK handshake TX"; };
            NAK_HANDSHAKE_TX = 1 { name = "Nak Handshake Tx"; desc = "NAK handshake TX"; };
        };

        field {
            name = "naksts";
            desc = "NAK status";
            sw = r;
            hw = w;
            encode = DIEPCTL_naksts_enum;
            reset = 0x0;
        } naksts[17:17];

        field {
            name = "dpid_eo_frnum";
            desc = "Endpoint data PID 0: DATA0 1: DATA1 Even/Odd frame Non-scatter/Gather DMA mode: 0: even frame 1: odd frame Scatter/Gather DMA mode: Reserved";
            sw = r;
            hw = w;
            reset = 0x0;
        } dpid_eo_frnum[16:16];

        enum DIEPCTL_usbactep_enum {
            INVALID = 0 { name = "Invalid"; desc = "invalid"; };
            VALID = 1 { name = "Valid"; desc = "valid"; };
        };

        field {
            name = "usbactep";
            desc = "USB activation endpoint 0 This bit is always 1, indicating that control endpoint 0 is always valid.";
            sw = rw;
            hw = w;
            encode = DIEPCTL_usbactep_enum;
            reset = 0x0;
        } usbactep[15:15];

        field {
            name = "nextep";
            desc = "Next endpoint This field specifies the ID of the next endpoint that receives data.";
            sw = rw;
            hw = r;
            reset = 0x0;
        } nextep[14:11];

        field {
            name = "mps";
            desc = "Maximum packet size";
            sw = rw;
            hw = r;
            reset = 0x0;
        } mps[10:0];
    } DIEPCTL @ 0x0;

    reg {
        name = "Device IN endpoint interrupt register";
        desc = "DIEPINT is an interrupt register for device IN endpoint n.

The data sheet prints one field table for both registers whose field names are partly garbled (`An`, `endpoints`, `TimeOUT_SetUp`) and merges the IN and OUT bit descriptions; the bit layout here follows the standard DWC_otg 2.x/3.x register map (which the data sheet's DIEPMSK/DOEPMSK registers confirm), the descriptions use the data sheet text. Bits are set by hardware and cleared by writing 1.

Data sheet 12.7.5.2 DIEPINTn (printed page 12-234, `Hi3518EV20X-Hi3516CV200-Datasheet.txt` line 90114).";

        enum DIEPINT_nyetintrpt_enum {
            INTERRUPT_CLEARED = 0 { name = "Interrupt Cleared"; desc = "An interrupt is cleared."; };
            INTERRUPT_GENERATED_WRITING = 1 { name = "Interrupt Generated Writing"; desc = "An interrupt is generated. Writing 1 clears the bit."; };
        };

        field {
            name = "nyetintrpt";
            desc = "NYET interrupt. NYET response TX interrupt.";
            sw = rw;
            hw = w;
            onwrite = woclr;
            encode = DIEPINT_nyetintrpt_enum;
            reset = 0x0;
        } nyetintrpt[14:14];

        enum DIEPINT_nakintrpt_enum {
            INTERRUPT_CLEARED = 0 { name = "Interrupt Cleared"; desc = "An interrupt is cleared."; };
            INTERRUPT_GENERATED_WRITING = 1 { name = "Interrupt Generated Writing"; desc = "An interrupt is generated. Writing 1 clears the bit."; };
        };

        field {
            name = "nakintrpt";
            desc = "NAK interrupt. NAK TX interrupt.";
            sw = rw;
            hw = w;
            onwrite = woclr;
            encode = DIEPINT_nakintrpt_enum;
            reset = 0x0;
        } nakintrpt[13:13];

        enum DIEPINT_bbleerr_enum {
            INTERRUPT_CLEARED = 0 { name = "Interrupt Cleared"; desc = "An interrupt is cleared."; };
            INTERRUPT_GENERATED_WRITING = 1 { name = "Interrupt Generated Writing"; desc = "An interrupt is generated. Writing 1 clears the bit."; };
        };

        field {
            name = "bbleerr";
            desc = "Babble error interrupt. Endpoint received babble interrupt.";
            sw = rw;
            hw = w;
            onwrite = woclr;
            encode = DIEPINT_bbleerr_enum;
            reset = 0x0;
        } bbleerr[12:12];

        enum DIEPINT_pktdrpsts_enum {
            INTERRUPT_CLEARED = 0 { name = "Interrupt Cleared"; desc = "An interrupt is cleared."; };
            INTERRUPT_GENERATED_WRITING = 1 { name = "Interrupt Generated Writing"; desc = "An interrupt is generated. Writing 1 clears the bit."; };
        };

        field {
            name = "pktdrpsts";
            desc = "Packet drop status interrupt";
            sw = rw;
            hw = w;
            onwrite = woclr;
            encode = DIEPINT_pktdrpsts_enum;
            reset = 0x0;
        } pktdrpsts[11:11];

        enum DIEPINT_bnaintr_enum {
            INTERRUPT_CLEARED = 0 { name = "Interrupt Cleared"; desc = "An interrupt is cleared."; };
            INTERRUPT_GENERATED_WRITING = 1 { name = "Interrupt Generated Writing"; desc = "An interrupt is generated. Writing 1 clears the bit."; };
        };

        field {
            name = "bnaintr";
            desc = "BNA interrupt. An interrupt is generated when descriptor access is not ready.";
            sw = rw;
            hw = w;
            onwrite = woclr;
            encode = DIEPINT_bnaintr_enum;
            reset = 0x0;
        } bnaintr[9:9];

        enum DIEPINT_txfifoundrn_enum {
            INTERRUPT_CLEARED = 0 { name = "Interrupt Cleared"; desc = "An interrupt is cleared."; };
            INTERRUPT_GENERATED_WRITING = 1 { name = "Interrupt Generated Writing"; desc = "An interrupt is generated. Writing 1 clears the bit."; };
        };

        field {
            name = "txfifoundrn";
            desc = "FIFO underrun interrupt. An interrupt is generated when the FIFO underrun conditions are detected. Valid when OTG_EN_DED_TX_FIFO is 1 and thresholding is enabled.";
            sw = rw;
            hw = w;
            onwrite = woclr;
            encode = DIEPINT_txfifoundrn_enum;
            reset = 0x0;
        } txfifoundrn[8:8];

        enum DIEPINT_txfemp_enum {
            INTERRUPT_CLEARED = 0 { name = "Interrupt Cleared"; desc = "An interrupt is cleared."; };
            INTERRUPT_GENERATED = 1 { name = "Interrupt Generated"; desc = "An interrupt is generated."; };
        };

        field {
            name = "txfemp";
            desc = "TX FIFO empty status interrupt. An interrupt is generated when the TX FIFO is empty or half empty.";
            sw = r;
            hw = w;
            encode = DIEPINT_txfemp_enum;
            reset = 0x0;
        } txfemp[7:7];

        enum DIEPINT_inepnakeff_enum {
            INTERRUPT_CLEARED = 0 { name = "Interrupt Cleared"; desc = "An interrupt is cleared."; };
            INTERRUPT_GENERATED_WRITING = 1 { name = "Interrupt Generated Writing"; desc = "An interrupt is generated. Writing 1 clears the bit."; };
        };

        field {
            name = "inepnakeff";
            desc = "IN endpoint NAK effective interrupt. An interrupt is generated when the IN endpoint NAK bit is set.";
            sw = rw;
            hw = w;
            onwrite = woclr;
            encode = DIEPINT_inepnakeff_enum;
            reset = 0x0;
        } inepnakeff[6:6];

        enum DIEPINT_intknepmis_enum {
            INTERRUPT_CLEARED = 0 { name = "Interrupt Cleared"; desc = "An interrupt is cleared."; };
            INTERRUPT_GENERATED_WRITING = 1 { name = "Interrupt Generated Writing"; desc = "An interrupt is generated. Writing 1 clears the bit."; };
        };

        field {
            name = "intknepmis";
            desc = "IN token received with EP mismatch interrupt. An interrupt is generated when IN tokens with mismatched EP are received.";
            sw = rw;
            hw = w;
            onwrite = woclr;
            encode = DIEPINT_intknepmis_enum;
            reset = 0x0;
        } intknepmis[5:5];

        enum DIEPINT_intktxfemp_enum {
            INTERRUPT_CLEARED = 0 { name = "Interrupt Cleared"; desc = "An interrupt is cleared."; };
            INTERRUPT_GENERATED_WRITING = 1 { name = "Interrupt Generated Writing"; desc = "An interrupt is generated. Writing 1 clears the bit."; };
        };

        field {
            name = "intktxfemp";
            desc = "IN token received when TX FIFO empty interrupt. An interrupt is generated if IN tokens are received when the corresponding TX FIFO is empty.";
            sw = rw;
            hw = w;
            onwrite = woclr;
            encode = DIEPINT_intktxfemp_enum;
            reset = 0x0;
        } intktxfemp[4:4];

        enum DIEPINT_timeout_enum {
            INTERRUPT_CLEARED = 0 { name = "Interrupt Cleared"; desc = "An interrupt is cleared."; };
            INTERRUPT_GENERATED_WRITING = 1 { name = "Interrupt Generated Writing"; desc = "An interrupt is generated. Writing 1 clears the bit."; };
        };

        field {
            name = "timeout";
            desc = "Timeout interrupt. An interrupt is generated when timeout conditions are detected.";
            sw = rw;
            hw = w;
            onwrite = woclr;
            encode = DIEPINT_timeout_enum;
            reset = 0x0;
        } timeout[3:3];

        enum DIEPINT_ahberr_enum {
            INTERRUPT_CLEARED = 0 { name = "Interrupt Cleared"; desc = "An interrupt is cleared."; };
            INTERRUPT_GENERATED_WRITING = 1 { name = "Interrupt Generated Writing"; desc = "An interrupt is generated. Writing 1 clears the bit."; };
        };

        field {
            name = "ahberr";
            desc = "AHB error interrupt. An interrupt is generated when an AHB error occurs during AHB read/write operations in internal DMA mode.";
            sw = rw;
            hw = w;
            onwrite = woclr;
            encode = DIEPINT_ahberr_enum;
            reset = 0x0;
        } ahberr[2:2];

        enum DIEPINT_epdisbld_enum {
            INTERRUPT_CLEARED = 0 { name = "Interrupt Cleared"; desc = "An interrupt is cleared."; };
            INTERRUPT_GENERATED_WRITING = 1 { name = "Interrupt Generated Writing"; desc = "An interrupt is generated. Writing 1 clears the bit."; };
        };

        field {
            name = "epdisbld";
            desc = "Endpoint disabled interrupt";
            sw = rw;
            hw = w;
            onwrite = woclr;
            encode = DIEPINT_epdisbld_enum;
            reset = 0x0;
        } epdisbld[1:1];

        enum DIEPINT_xfercompl_enum {
            INTERRUPT_CLEARED = 0 { name = "Interrupt Cleared"; desc = "An interrupt is cleared."; };
            INTERRUPT_GENERATED_WRITING = 1 { name = "Interrupt Generated Writing"; desc = "An interrupt is generated. Writing 1 clears the bit."; };
        };

        field {
            name = "xfercompl";
            desc = "Transfer completion interrupt";
            sw = rw;
            hw = w;
            onwrite = woclr;
            encode = DIEPINT_xfercompl_enum;
            reset = 0x0;
        } xfercompl[0:0];
    } DIEPINT @ 0x8;

    reg {
        name = "Transfer size register for device IN endpoint 0";
        desc = "DIEPTSIZn is a transfer size register for device IN endpoint n.

Data sheet 12.7.5.2 DIEPTSIZn (offset 0x910, printed page 12-240, `Hi3518EV20X-Hi3516CV200-Datasheet.txt` line 90461).";

        field {
            name = "mc_rxdpid_supcnt";
            desc = "Number of packets (IN endpoint, RW) 00: 0 packet 01: 1 packet 10: 2 packets 11: 3 packets Number of packets (non-periodic IN endpoints, RO) This field is valid only in internal DMA mode. PID of the received data (isochronous OUT endpoints, RO) 00: DATA0 01: DATA2 10: DATA1 11: MDATA Number of setup packets (OUT endpoint, RW) 01: 1 packet 10: 2 packets 11: 3 packets";
            sw = rw;
            hw = r;
            reset = 0x0;
        } mc_rxdpid_supcnt[30:29];

        field {
            name = "pktcnt";
            desc = "Number of packets";
            sw = rw;
            hw = r;
            reset = 0x0;
        } pktcnt[28:19];

        field {
            name = "xfersize";
            desc = "Transferred data size";
            sw = rw;
            hw = r;
            reset = 0x0;
        } xfersize[18:0];
    } DIEPTSIZ @ 0x10;

    reg {
        name = "DMA address register for device IN endpoint n";
        desc = "DIEPDMAN is a DMA address register for device IN endpoint n.

Data sheet 12.7.5.2 DIEPDMAN (offset 0x914, printed page 12-242, `Hi3518EV20X-Hi3516CV200-Datasheet.txt` line 90576).";

        field {
            name = "dmaaddr";
            desc = "DMA address";
            sw = rw;
            hw = r;
            reset = 0x0;
        } dmaaddr[31:0];
    } DIEPDMA @ 0x14;

    reg {
        name = "Device IN endpoint TX FIFO status register";
        desc = "DTXFSTSn is a TX FIFO status register for device IN endpoints.

Data sheet offset error: the summary lists a single register at 0x0938 (= IN endpoint 1 in this layout) without an array; every IN endpoint has this register at +0x18 of its register set (0x918 + 0x20 x n, as in the DWC_otg databook).

Data sheet 12.7.5.2 DTXFSTSn (offset 0x938, printed page 12-243, `Hi3518EV20X-Hi3516CV200-Datasheet.txt` line 90665).";

        enum DTXFSTS_ineptxfspcavail_enum {
            ENDPOINT_TX_FIFO = 0x0 { name = "Endpoint Tx Fifo"; desc = "The endpoint TX FIFO is full."; };
            ONE_WORD_AVAILABLE = 0x1 { name = "One Word Available"; desc = "One word is available."; };
            TWO_WORDS_AVAILABLE = 0x2 { name = "Two Words Available"; desc = "Two words are available. 0xn: n words (0 <= n <= 32768) are available."; };
            V_32768_WORDS_AVAILABLE = 0x8000 { name = "V 32768 Words Available"; desc = "32768 words are available. Other values: reserved"; };
        };

        field {
            name = "ineptxfspcavail";
            desc = "Available space for the IN endpoint TX FIFO";
            sw = r;
            hw = w;
            encode = DTXFSTS_ineptxfspcavail_enum;
            reset = 0x0;
        } ineptxfspcavail[15:0];
    } DTXFSTS @ 0x18;

    reg {
        name = "DMA buffer address register for device IN endpoint n";
        desc = "DIEPDMABN is a DMA buffer address register for device IN endpoint n.

Data sheet 12.7.5.2 DIEPDMABN (offset 0x91C, printed page 12-242, `Hi3518EV20X-Hi3516CV200-Datasheet.txt` line 90618).";

        field {
            name = "dmabufferaddr";
            desc = "DMA buffer address";
            sw = r;
            hw = w;
            reset = 0x0;
        } dmabufferaddr[31:0];
    } DIEPDMAB @ 0x1C;
};

regfile eHISI_USB_DEVICE_OUTEP0 {
    name = "USB device OUT endpoint 0 registers";
    desc = "Per-endpoint device register set (offsets relative to the start of the set; endpoint n is at 0xB00 + 0x20 x n). Endpoint 0 has its own control and transfer-size layouts.";

    reg {
        name = "Control register for device control OUT endpoint 0";
        desc = "DOEPCTL0 is a control register for device control OUT endpoint 0.

Data sheet 12.7.5.2 DOEPCTL0 (offset 0xB00, printed page 12-226, `Hi3518EV20X-Hi3516CV200-Datasheet.txt` line 89686).";

        field {
            name = "epena";
            desc = "Endpoint enable When the scatter/gather DMA is enabled: 0: The descriptor structure and the data RX function of the data buffer are disabled. 1: The descriptor structure and the data RX function of the data buffer are enabled. When the scatter/gather DMA is disabled: 0: The function of receiving data from the USB module to the memory is disabled. 1: The function of receiving data from the USB module to the memory is enabled.";
            sw = rw;
            hw = w;
            reset = 0x0;
        } epena[31:31];

        enum DOEPCTL_epdis_enum {
            ENABLED = 0 { name = "Enabled"; desc = "enabled"; };
            DISABLED = 1 { name = "Disabled"; desc = "disabled"; };
        };

        field {
            name = "epdis";
            desc = "Endpoint disable The application program cannot disable OUT control transfer endpoint 0.";
            sw = r;
            hw = w;
            encode = DOEPCTL_epdis_enum;
            reset = 0x0;
        } epdis[30:30];

        enum DOEPCTL_snak_enum {
            INVALID = 0 { name = "Invalid"; desc = "invalid"; };
            VALID = 1 { name = "Valid"; desc = "valid"; };
        };

        field {
            name = "snak";
            desc = "NAK configuration Writing to this bit sets the NAK bit of the endpoint to 1. The application program can use this bit to control the NAK handshake of an endpoint during a transfer. The controller core can set this bit of an endpoint after this endpoint receives the setup packet.";
            sw = w;
            hw = r;
            encode = DOEPCTL_snak_enum;
            reset = 0x0;
        } snak[27:27];

        enum DOEPCTL_cnak_enum {
            INVALID = 0 { name = "Invalid"; desc = "invalid"; };
            VALID = 1 { name = "Valid"; desc = "valid"; };
        };

        field {
            name = "cnak";
            desc = "NAK clear Writing to this bit clears the NAK bit of the endpoint.";
            sw = w;
            hw = r;
            encode = DOEPCTL_cnak_enum;
            reset = 0x0;
        } cnak[26:26];

        enum DOEPCTL_stall_enum {
            INVALID = 0 { name = "Invalid"; desc = "invalid"; };
            VALID = 1 { name = "Valid"; desc = "valid"; };
        };

        field {
            name = "stall";
            desc = "Stall handshake The application program can set this bit. The controller core clears this bit after the endpoint receives the setup packet.";
            sw = rw;
            hw = w;
            encode = DOEPCTL_stall_enum;
            reset = 0x0;
        } stall[21:21];

        enum DOEPCTL_snp_enum {
            INVALID = 0 { name = "Invalid"; desc = "invalid"; };
            VALID = 1 { name = "Valid"; desc = "valid"; };
        };

        field {
            name = "snp";
            desc = "Snooping mode This bit is used to set the endpoint to the snooping mode. In snooping mode, the controller core checks whether the OUT packet is correct after it sends the packet to the application memory.";
            sw = rw;
            hw = r;
            encode = DOEPCTL_snp_enum;
            reset = 0x0;
        } snp[20:20];

        enum DOEPCTL_eptype_enum {
            CONTROL_TRANSFER_ENDPOINT = 0 { name = "Control Transfer Endpoint"; desc = "control transfer endpoint"; };
            REAL_TIME_TRANSFER = 1 { name = "Real Time Transfer"; desc = "real-time transfer endpoint"; };
            BULK_TRANSFER_ENDPOINT = 2 { name = "Bulk Transfer Endpoint"; desc = "bulk transfer endpoint"; };
            INTERRUPT_TRANSFER_ENDPOINT = 3 { name = "Interrupt Transfer Endpoint"; desc = "interrupt transfer endpoint"; };
        };

        field {
            name = "eptype";
            desc = "Endpoint type";
            sw = r;
            hw = w;
            encode = DOEPCTL_eptype_enum;
            reset = 0x0;
        } eptype[19:18];

        enum DOEPCTL_naksts_enum {
            NON_NAK_HANDSHAKE = 0 { name = "Non Nak Handshake"; desc = "non-NAK handshake TX"; };
            NAK_HANDSHAKE_TX = 1 { name = "Nak Handshake Tx"; desc = "NAK handshake TX"; };
        };

        field {
            name = "naksts";
            desc = "NAK status";
            sw = r;
            hw = w;
            encode = DOEPCTL_naksts_enum;
            reset = 0x0;
        } naksts[17:17];

        enum DOEPCTL_usbactep_enum {
            INVALID = 0 { name = "Invalid"; desc = "invalid"; };
            VALID = 1 { name = "Valid"; desc = "valid"; };
        };

        field {
            name = "usbactep";
            desc = "USB activation endpoint 0 This bit is always 1, indicating that control endpoint 0 is always valid.";
            sw = r;
            hw = w;
            encode = DOEPCTL_usbactep_enum;
            reset = 0x1;
        } usbactep[15:15];

        enum DOEPCTL_mps_enum {
            V_64_BYTES = 0 { name = "V 64 Bytes"; desc = "64 bytes"; };
            V_32_BYTES = 1 { name = "V 32 Bytes"; desc = "32 bytes"; };
            V_16_BYTES = 2 { name = "V 16 Bytes"; desc = "16 bytes"; };
            V_8_BYTES = 3 { name = "V 8 Bytes"; desc = "8 bytes"; };
        };

        field {
            name = "mps";
            desc = "Minimum packet size";
            sw = rw;
            hw = r;
            encode = DOEPCTL_mps_enum;
            reset = 0x0;
        } mps[1:0];
    } DOEPCTL @ 0x0;

    reg {
        name = "Device OUT endpoint interrupt register";
        desc = "DOEPINT is an interrupt register for device OUT endpoint n.

The data sheet prints one field table for both registers whose field names are partly garbled (`An`, `endpoints`, `TimeOUT_SetUp`) and merges the IN and OUT bit descriptions; the bit layout here follows the standard DWC_otg 2.x/3.x register map (which the data sheet's DIEPMSK/DOEPMSK registers confirm), the descriptions use the data sheet text. Bits are set by hardware and cleared by writing 1.

Data sheet 12.7.5.2 DOEPINTn (printed page 12-236, `Hi3518EV20X-Hi3516CV200-Datasheet.txt` line 90253).";

        enum DOEPINT_stuppktrcvd_enum {
            INTERRUPT_CLEARED = 0 { name = "Interrupt Cleared"; desc = "An interrupt is cleared."; };
            INTERRUPT_GENERATED_WRITING = 1 { name = "Interrupt Generated Writing"; desc = "An interrupt is generated. Writing 1 clears the bit."; };
        };

        field {
            name = "stuppktrcvd";
            desc = "Setup packet received. Whether setup packets are received.";
            sw = rw;
            hw = w;
            onwrite = woclr;
            encode = DOEPINT_stuppktrcvd_enum;
            reset = 0x0;
        } stuppktrcvd[15:15];

        enum DOEPINT_nyetintrpt_enum {
            INTERRUPT_CLEARED = 0 { name = "Interrupt Cleared"; desc = "An interrupt is cleared."; };
            INTERRUPT_GENERATED_WRITING = 1 { name = "Interrupt Generated Writing"; desc = "An interrupt is generated. Writing 1 clears the bit."; };
        };

        field {
            name = "nyetintrpt";
            desc = "NYET interrupt. NYET response TX interrupt.";
            sw = rw;
            hw = w;
            onwrite = woclr;
            encode = DOEPINT_nyetintrpt_enum;
            reset = 0x0;
        } nyetintrpt[14:14];

        enum DOEPINT_nakintrpt_enum {
            INTERRUPT_CLEARED = 0 { name = "Interrupt Cleared"; desc = "An interrupt is cleared."; };
            INTERRUPT_GENERATED_WRITING = 1 { name = "Interrupt Generated Writing"; desc = "An interrupt is generated. Writing 1 clears the bit."; };
        };

        field {
            name = "nakintrpt";
            desc = "NAK interrupt. NAK TX interrupt.";
            sw = rw;
            hw = w;
            onwrite = woclr;
            encode = DOEPINT_nakintrpt_enum;
            reset = 0x0;
        } nakintrpt[13:13];

        enum DOEPINT_bbleerr_enum {
            INTERRUPT_CLEARED = 0 { name = "Interrupt Cleared"; desc = "An interrupt is cleared."; };
            INTERRUPT_GENERATED_WRITING = 1 { name = "Interrupt Generated Writing"; desc = "An interrupt is generated. Writing 1 clears the bit."; };
        };

        field {
            name = "bbleerr";
            desc = "Babble error interrupt. Endpoint received babble interrupt.";
            sw = rw;
            hw = w;
            onwrite = woclr;
            encode = DOEPINT_bbleerr_enum;
            reset = 0x0;
        } bbleerr[12:12];

        enum DOEPINT_pktdrpsts_enum {
            INTERRUPT_CLEARED = 0 { name = "Interrupt Cleared"; desc = "An interrupt is cleared."; };
            INTERRUPT_GENERATED_WRITING = 1 { name = "Interrupt Generated Writing"; desc = "An interrupt is generated. Writing 1 clears the bit."; };
        };

        field {
            name = "pktdrpsts";
            desc = "Packet drop status interrupt";
            sw = rw;
            hw = w;
            onwrite = woclr;
            encode = DOEPINT_pktdrpsts_enum;
            reset = 0x0;
        } pktdrpsts[11:11];

        enum DOEPINT_bnaintr_enum {
            INTERRUPT_CLEARED = 0 { name = "Interrupt Cleared"; desc = "An interrupt is cleared."; };
            INTERRUPT_GENERATED_WRITING = 1 { name = "Interrupt Generated Writing"; desc = "An interrupt is generated. Writing 1 clears the bit."; };
        };

        field {
            name = "bnaintr";
            desc = "BNA interrupt. An interrupt is generated when descriptor access is not ready.";
            sw = rw;
            hw = w;
            onwrite = woclr;
            encode = DOEPINT_bnaintr_enum;
            reset = 0x0;
        } bnaintr[9:9];

        enum DOEPINT_outpkterr_enum {
            INTERRUPT_CLEARED = 0 { name = "Interrupt Cleared"; desc = "An interrupt is cleared."; };
            INTERRUPT_GENERATED_WRITING = 1 { name = "Interrupt Generated Writing"; desc = "An interrupt is generated. Writing 1 clears the bit."; };
        };

        field {
            name = "outpkterr";
            desc = "OUT packet error interrupt. An interrupt is generated when an overrun or CRC error is detected. Valid when OTG_EN_DED_TX_FIFO is 1 and thresholding is enabled.";
            sw = rw;
            hw = w;
            onwrite = woclr;
            encode = DOEPINT_outpkterr_enum;
            reset = 0x0;
        } outpkterr[8:8];

        enum DOEPINT_back2backsetup_enum {
            INTERRUPT_CLEARED = 0 { name = "Interrupt Cleared"; desc = "An interrupt is cleared."; };
            INTERRUPT_GENERATED_WRITING = 1 { name = "Interrupt Generated Writing"; desc = "An interrupt is generated. Writing 1 clears the bit."; };
        };

        field {
            name = "back2backsetup";
            desc = "Back-to-back setup packets received interrupt. An interrupt is generated when the core receives more than three back-to-back setup packets.";
            sw = rw;
            hw = w;
            onwrite = woclr;
            encode = DOEPINT_back2backsetup_enum;
            reset = 0x0;
        } back2backsetup[6:6];

        enum DOEPINT_stsphsercvd_enum {
            INTERRUPT_CLEARED = 0 { name = "Interrupt Cleared"; desc = "An interrupt is cleared."; };
            INTERRUPT_GENERATED_WRITING = 1 { name = "Interrupt Generated Writing"; desc = "An interrupt is generated. Writing 1 clears the bit."; };
        };

        field {
            name = "stsphsercvd";
            desc = "Status phase received interrupt (control write)";
            sw = rw;
            hw = w;
            onwrite = woclr;
            encode = DOEPINT_stsphsercvd_enum;
            reset = 0x0;
        } stsphsercvd[5:5];

        enum DOEPINT_outtknepdis_enum {
            INTERRUPT_CLEARED = 0 { name = "Interrupt Cleared"; desc = "An interrupt is cleared."; };
            INTERRUPT_GENERATED_WRITING = 1 { name = "Interrupt Generated Writing"; desc = "An interrupt is generated. Writing 1 clears the bit."; };
        };

        field {
            name = "outtknepdis";
            desc = "OUT token received when endpoint disabled interrupt. An interrupt is generated if OUT tokens are received when endpoints are disabled.";
            sw = rw;
            hw = w;
            onwrite = woclr;
            encode = DOEPINT_outtknepdis_enum;
            reset = 0x0;
        } outtknepdis[4:4];

        enum DOEPINT_setup_enum {
            INTERRUPT_CLEARED = 0 { name = "Interrupt Cleared"; desc = "An interrupt is cleared."; };
            INTERRUPT_GENERATED_WRITING = 1 { name = "Interrupt Generated Writing"; desc = "An interrupt is generated. Writing 1 clears the bit."; };
        };

        field {
            name = "setup";
            desc = "Setup phase done interrupt";
            sw = rw;
            hw = w;
            onwrite = woclr;
            encode = DOEPINT_setup_enum;
            reset = 0x0;
        } setup[3:3];

        enum DOEPINT_ahberr_enum {
            INTERRUPT_CLEARED = 0 { name = "Interrupt Cleared"; desc = "An interrupt is cleared."; };
            INTERRUPT_GENERATED_WRITING = 1 { name = "Interrupt Generated Writing"; desc = "An interrupt is generated. Writing 1 clears the bit."; };
        };

        field {
            name = "ahberr";
            desc = "AHB error interrupt. An interrupt is generated when an AHB error occurs during AHB read/write operations in internal DMA mode.";
            sw = rw;
            hw = w;
            onwrite = woclr;
            encode = DOEPINT_ahberr_enum;
            reset = 0x0;
        } ahberr[2:2];

        enum DOEPINT_epdisbld_enum {
            INTERRUPT_CLEARED = 0 { name = "Interrupt Cleared"; desc = "An interrupt is cleared."; };
            INTERRUPT_GENERATED_WRITING = 1 { name = "Interrupt Generated Writing"; desc = "An interrupt is generated. Writing 1 clears the bit."; };
        };

        field {
            name = "epdisbld";
            desc = "Endpoint disabled interrupt";
            sw = rw;
            hw = w;
            onwrite = woclr;
            encode = DOEPINT_epdisbld_enum;
            reset = 0x0;
        } epdisbld[1:1];

        enum DOEPINT_xfercompl_enum {
            INTERRUPT_CLEARED = 0 { name = "Interrupt Cleared"; desc = "An interrupt is cleared."; };
            INTERRUPT_GENERATED_WRITING = 1 { name = "Interrupt Generated Writing"; desc = "An interrupt is generated. Writing 1 clears the bit."; };
        };

        field {
            name = "xfercompl";
            desc = "Transfer completion interrupt";
            sw = rw;
            hw = w;
            onwrite = woclr;
            encode = DOEPINT_xfercompl_enum;
            reset = 0x0;
        } xfercompl[0:0];
    } DOEPINT @ 0x8;

    reg {
        name = "Transfer size register for device OUT endpoint 0";
        desc = "DOEPTSIZ0 is a transfer size register for device OUT endpoint 0.

Data sheet 12.7.5.2 DOEPTSIZ0 (offset 0xB10, printed page 12-239, `Hi3518EV20X-Hi3516CV200-Datasheet.txt` line 90422).";

        enum DOEPTSIZ_supcnt_enum {
            V_0_PACKET = 0 { name = "V 0 Packet"; desc = "0 packet"; };
            V_1_PACKET = 1 { name = "V 1 Packet"; desc = "1 packet"; };
            V_2_PACKETS = 2 { name = "V 2 Packets"; desc = "2 packets"; };
            V_3_PACKETS = 3 { name = "V 3 Packets"; desc = "3 packets"; };
        };

        field {
            name = "supcnt";
            desc = "Number of setup packets";
            sw = rw;
            hw = r;
            encode = DOEPTSIZ_supcnt_enum;
            reset = 0x0;
        } supcnt[30:29];

        field {
            name = "pktcnt";
            desc = "Number of packets";
            sw = rw;
            hw = r;
            reset = 0x0;
        } pktcnt[19:19];

        field {
            name = "xfersize";
            desc = "Transferred data size";
            sw = rw;
            hw = r;
            reset = 0x0;
        } xfersize[6:0];
    } DOEPTSIZ @ 0x10;

    reg {
        name = "DMA address register for device OUT endpoint n";
        desc = "DOEPDMAN is a DMA address register for device OUT endpoint n.

Data sheet 12.7.5.2 DOEPDMAN (offset 0xB14, printed page 12-242, `Hi3518EV20X-Hi3516CV200-Datasheet.txt` line 90597).";

        field {
            name = "dmaaddr";
            desc = "DMA address";
            sw = rw;
            hw = r;
            reset = 0x0;
        } dmaaddr[31:0];
    } DOEPDMA @ 0x14;

    reg {
        name = "DMA buffer address register for device OUT endpoint n";
        desc = "DOEPDMABN is a DMA buffer address register for device OUT endpoint n.

Data sheet 12.7.5.2 DOEPDMABN (offset 0xB1C, printed page 12-243, `Hi3518EV20X-Hi3516CV200-Datasheet.txt` line 90646).";

        field {
            name = "dmabufferaddr";
            desc = "DMA buffer address";
            sw = r;
            hw = w;
            reset = 0x0;
        } dmabufferaddr[31:0];
    } DOEPDMAB @ 0x1C;
};

regfile eHISI_USB_DEVICE_OUTEP {
    name = "USB device OUT endpoint n registers";
    desc = "Per-endpoint device register set (offsets relative to the start of the set; endpoint n is at 0xB00 + 0x20 x n). Used for n = 1..15.";

    reg {
        name = "Control register for device control OUT endpoint 0";
        desc = "DOEPCTLN is a control register for device OUT endpoint n.

Endpoint n = 1..15 (endpoint 0 is the separate OUT_EP0 register set).

Data sheet 12.7.5.2 DOEPCTLN (offset 0xB00, printed page 12-231, `Hi3518EV20X-Hi3516CV200-Datasheet.txt` line 89958).";

        field {
            name = "epena";
            desc = "Endpoint enable When the scatter or gather DMA is enabled: 0: The descriptor structure and the data RX function of the data buffer are disabled. 1: The descriptor structure and the data RX function of the data buffer are enabled. When the scatter/gather DMA is disabled: 0: The function of receiving data from the USB module to the memory is disabled. 1: The function of receiving data from the USB module to the memory is enabled.";
            sw = rw;
            hw = w;
            reset = 0x0;
        } epena[31:31];

        enum DOEPCTL_epdis_enum {
            ENABLED = 0 { name = "Enabled"; desc = "enabled"; };
            DISABLED = 1 { name = "Disabled"; desc = "disabled"; };
        };

        field {
            name = "epdis";
            desc = "Endpoint disable This bit applies to the IN and OUT endpoints. The application program can set this bit to 1 to stop the data transmission/reception of an IN/OUT endpoint.";
            sw = rw;
            hw = w;
            encode = DOEPCTL_epdis_enum;
            reset = 0x0;
        } epdis[30:30];

        field {
            name = "setd1pid_setoddfr";
            desc = "DATA1 PID/odd micro-frame configuration The data PID of the interrupt endpoint and bulk IN/OUT endpoint can be set to DATA1 by setting this bit to 1. 0: invalid 1: valid For the real-time IN/OUT endpoint, the odd and even micro-frames can be set to odd micro-frames by setting this bit to 1. 0: invalid 1: valid";
            sw = w;
            hw = r;
            reset = 0x0;
        } setd1pid_setoddfr[29:29];

        field {
            name = "setd0pid_setevenfr";
            desc = "DATA0 PID/even micro-frame configuration The data PID of the interrupt endpoint and bulk IN/OUT endpoint can be set to DATA0 by setting this bit to 1. 0: invalid 1: valid For the real-time IN/OUT endpoint, the odd and even micro-frames can be set to even micro-frames by setting this bit to 1. 0: invalid 1: valid";
            sw = w;
            hw = r;
            reset = 0x0;
        } setd0pid_setevenfr[28:28];

        enum DOEPCTL_snak_enum {
            INVALID = 0 { name = "Invalid"; desc = "invalid"; };
            VALID = 1 { name = "Valid"; desc = "valid"; };
        };

        field {
            name = "snak";
            desc = "NAK configuration Writing to this bit sets the NAK bit of the endpoint to 1. The application program can use this bit to control the NAK handshake of an endpoint during a transfer. For an OUT endpoint, this bit is set after the controller core receives the transfer completion interrupt or the OUT endpoint receives the setup packet.";
            sw = w;
            hw = r;
            encode = DOEPCTL_snak_enum;
            reset = 0x0;
        } snak[27:27];

        enum DOEPCTL_cnak_enum {
            INVALID = 0 { name = "Invalid"; desc = "invalid"; };
            VALID = 1 { name = "Valid"; desc = "valid"; };
        };

        field {
            name = "cnak";
            desc = "NAK clear Writing to this bit clears the NAK bit of an IN/OUT endpoint.";
            sw = w;
            hw = r;
            encode = DOEPCTL_cnak_enum;
            reset = 0x0;
        } cnak[26:26];

        field {
            name = "txfnum";
            desc = "Number of TX FIFOs Shared FIFO operation: 0: non-periodic TX FIFO Other values: specified periodic TX FIFO.number Dedicated FIFO operation: Number of FIFOs This field is valid only for IN endpoints.";
            sw = rw;
            hw = r;
            reset = 0x0;
        } txfnum[25:22];

        field {
            name = "stall";
            desc = "Stall handshake (RW) Endpoint control (RWSC)";
            sw = rw;
            hw = r;
            reset = 0x0;
        } stall[21:21];

        enum DOEPCTL_snp_enum {
            INVALID = 0 { name = "Invalid"; desc = "invalid"; };
            VALID = 1 { name = "Valid"; desc = "valid"; };
        };

        field {
            name = "snp";
            desc = "Snooping mode This bit is used to set the OUT endpoint to the snooping mode. In snooping mode, the controller core does not check whether the OUT packet is correct before sending the packet to the application memory.";
            sw = rw;
            hw = r;
            encode = DOEPCTL_snp_enum;
            reset = 0x0;
        } snp[20:20];

        enum DOEPCTL_eptype_enum {
            CONTROL_TRANSFER_ENDPOINT = 0 { name = "Control Transfer Endpoint"; desc = "control transfer endpoint"; };
            REAL_TIME_TRANSFER = 1 { name = "Real Time Transfer"; desc = "real-time transfer endpoint"; };
            BULK_TRANSFER_ENDPOINT = 2 { name = "Bulk Transfer Endpoint"; desc = "bulk transfer endpoint"; };
            INTERRUPT_TRANSFER_ENDPOINT = 3 { name = "Interrupt Transfer Endpoint"; desc = "interrupt transfer endpoint"; };
        };

        field {
            name = "eptype";
            desc = "Endpoint type";
            sw = rw;
            hw = r;
            encode = DOEPCTL_eptype_enum;
            reset = 0x0;
        } eptype[19:18];

        enum DOEPCTL_naksts_enum {
            NON_NAK_HANDSHAKE = 0 { name = "Non Nak Handshake"; desc = "non-NAK handshake TX"; };
            NAK_HANDSHAKE_TX = 1 { name = "Nak Handshake Tx"; desc = "NAK handshake TX"; };
        };

        field {
            name = "naksts";
            desc = "NAK status";
            sw = r;
            hw = w;
            encode = DOEPCTL_naksts_enum;
            reset = 0x0;
        } naksts[17:17];

        field {
            name = "dpid_eo_frnum";
            desc = "Endpoint data PID 0: DATA0 1: DATA1 Even/Odd frame Non-scatter/Gather DMA mode: 0: even frame 1: odd frame Scatter/Gather DMA mode: Reserved";
            sw = r;
            hw = w;
            reset = 0x0;
        } dpid_eo_frnum[16:16];

        enum DOEPCTL_usbactep_enum {
            INVALID = 0 { name = "Invalid"; desc = "invalid"; };
            VALID = 1 { name = "Valid"; desc = "valid"; };
        };

        field {
            name = "usbactep";
            desc = "USB activation endpoint This bit applies to the IN and OUT endpoints and indicates whether an endpoint is valid.";
            sw = rw;
            hw = w;
            encode = DOEPCTL_usbactep_enum;
            reset = 0x0;
        } usbactep[15:15];

        field {
            name = "nextep";
            desc = "Next endpoint This field specifies the ID of the next endpoint that receives data.";
            sw = rw;
            hw = r;
            reset = 0x0;
        } nextep[14:11];

        field {
            name = "mps";
            desc = "Maximum packet size";
            sw = rw;
            hw = r;
            reset = 0x0;
        } mps[10:0];
    } DOEPCTL @ 0x0;

    reg {
        name = "Device OUT endpoint interrupt register";
        desc = "DOEPINT is an interrupt register for device OUT endpoint n.

The data sheet prints one field table for both registers whose field names are partly garbled (`An`, `endpoints`, `TimeOUT_SetUp`) and merges the IN and OUT bit descriptions; the bit layout here follows the standard DWC_otg 2.x/3.x register map (which the data sheet's DIEPMSK/DOEPMSK registers confirm), the descriptions use the data sheet text. Bits are set by hardware and cleared by writing 1.

Data sheet 12.7.5.2 DOEPINTn (printed page 12-236, `Hi3518EV20X-Hi3516CV200-Datasheet.txt` line 90253).";

        enum DOEPINT_stuppktrcvd_enum {
            INTERRUPT_CLEARED = 0 { name = "Interrupt Cleared"; desc = "An interrupt is cleared."; };
            INTERRUPT_GENERATED_WRITING = 1 { name = "Interrupt Generated Writing"; desc = "An interrupt is generated. Writing 1 clears the bit."; };
        };

        field {
            name = "stuppktrcvd";
            desc = "Setup packet received. Whether setup packets are received.";
            sw = rw;
            hw = w;
            onwrite = woclr;
            encode = DOEPINT_stuppktrcvd_enum;
            reset = 0x0;
        } stuppktrcvd[15:15];

        enum DOEPINT_nyetintrpt_enum {
            INTERRUPT_CLEARED = 0 { name = "Interrupt Cleared"; desc = "An interrupt is cleared."; };
            INTERRUPT_GENERATED_WRITING = 1 { name = "Interrupt Generated Writing"; desc = "An interrupt is generated. Writing 1 clears the bit."; };
        };

        field {
            name = "nyetintrpt";
            desc = "NYET interrupt. NYET response TX interrupt.";
            sw = rw;
            hw = w;
            onwrite = woclr;
            encode = DOEPINT_nyetintrpt_enum;
            reset = 0x0;
        } nyetintrpt[14:14];

        enum DOEPINT_nakintrpt_enum {
            INTERRUPT_CLEARED = 0 { name = "Interrupt Cleared"; desc = "An interrupt is cleared."; };
            INTERRUPT_GENERATED_WRITING = 1 { name = "Interrupt Generated Writing"; desc = "An interrupt is generated. Writing 1 clears the bit."; };
        };

        field {
            name = "nakintrpt";
            desc = "NAK interrupt. NAK TX interrupt.";
            sw = rw;
            hw = w;
            onwrite = woclr;
            encode = DOEPINT_nakintrpt_enum;
            reset = 0x0;
        } nakintrpt[13:13];

        enum DOEPINT_bbleerr_enum {
            INTERRUPT_CLEARED = 0 { name = "Interrupt Cleared"; desc = "An interrupt is cleared."; };
            INTERRUPT_GENERATED_WRITING = 1 { name = "Interrupt Generated Writing"; desc = "An interrupt is generated. Writing 1 clears the bit."; };
        };

        field {
            name = "bbleerr";
            desc = "Babble error interrupt. Endpoint received babble interrupt.";
            sw = rw;
            hw = w;
            onwrite = woclr;
            encode = DOEPINT_bbleerr_enum;
            reset = 0x0;
        } bbleerr[12:12];

        enum DOEPINT_pktdrpsts_enum {
            INTERRUPT_CLEARED = 0 { name = "Interrupt Cleared"; desc = "An interrupt is cleared."; };
            INTERRUPT_GENERATED_WRITING = 1 { name = "Interrupt Generated Writing"; desc = "An interrupt is generated. Writing 1 clears the bit."; };
        };

        field {
            name = "pktdrpsts";
            desc = "Packet drop status interrupt";
            sw = rw;
            hw = w;
            onwrite = woclr;
            encode = DOEPINT_pktdrpsts_enum;
            reset = 0x0;
        } pktdrpsts[11:11];

        enum DOEPINT_bnaintr_enum {
            INTERRUPT_CLEARED = 0 { name = "Interrupt Cleared"; desc = "An interrupt is cleared."; };
            INTERRUPT_GENERATED_WRITING = 1 { name = "Interrupt Generated Writing"; desc = "An interrupt is generated. Writing 1 clears the bit."; };
        };

        field {
            name = "bnaintr";
            desc = "BNA interrupt. An interrupt is generated when descriptor access is not ready.";
            sw = rw;
            hw = w;
            onwrite = woclr;
            encode = DOEPINT_bnaintr_enum;
            reset = 0x0;
        } bnaintr[9:9];

        enum DOEPINT_outpkterr_enum {
            INTERRUPT_CLEARED = 0 { name = "Interrupt Cleared"; desc = "An interrupt is cleared."; };
            INTERRUPT_GENERATED_WRITING = 1 { name = "Interrupt Generated Writing"; desc = "An interrupt is generated. Writing 1 clears the bit."; };
        };

        field {
            name = "outpkterr";
            desc = "OUT packet error interrupt. An interrupt is generated when an overrun or CRC error is detected. Valid when OTG_EN_DED_TX_FIFO is 1 and thresholding is enabled.";
            sw = rw;
            hw = w;
            onwrite = woclr;
            encode = DOEPINT_outpkterr_enum;
            reset = 0x0;
        } outpkterr[8:8];

        enum DOEPINT_back2backsetup_enum {
            INTERRUPT_CLEARED = 0 { name = "Interrupt Cleared"; desc = "An interrupt is cleared."; };
            INTERRUPT_GENERATED_WRITING = 1 { name = "Interrupt Generated Writing"; desc = "An interrupt is generated. Writing 1 clears the bit."; };
        };

        field {
            name = "back2backsetup";
            desc = "Back-to-back setup packets received interrupt. An interrupt is generated when the core receives more than three back-to-back setup packets.";
            sw = rw;
            hw = w;
            onwrite = woclr;
            encode = DOEPINT_back2backsetup_enum;
            reset = 0x0;
        } back2backsetup[6:6];

        enum DOEPINT_stsphsercvd_enum {
            INTERRUPT_CLEARED = 0 { name = "Interrupt Cleared"; desc = "An interrupt is cleared."; };
            INTERRUPT_GENERATED_WRITING = 1 { name = "Interrupt Generated Writing"; desc = "An interrupt is generated. Writing 1 clears the bit."; };
        };

        field {
            name = "stsphsercvd";
            desc = "Status phase received interrupt (control write)";
            sw = rw;
            hw = w;
            onwrite = woclr;
            encode = DOEPINT_stsphsercvd_enum;
            reset = 0x0;
        } stsphsercvd[5:5];

        enum DOEPINT_outtknepdis_enum {
            INTERRUPT_CLEARED = 0 { name = "Interrupt Cleared"; desc = "An interrupt is cleared."; };
            INTERRUPT_GENERATED_WRITING = 1 { name = "Interrupt Generated Writing"; desc = "An interrupt is generated. Writing 1 clears the bit."; };
        };

        field {
            name = "outtknepdis";
            desc = "OUT token received when endpoint disabled interrupt. An interrupt is generated if OUT tokens are received when endpoints are disabled.";
            sw = rw;
            hw = w;
            onwrite = woclr;
            encode = DOEPINT_outtknepdis_enum;
            reset = 0x0;
        } outtknepdis[4:4];

        enum DOEPINT_setup_enum {
            INTERRUPT_CLEARED = 0 { name = "Interrupt Cleared"; desc = "An interrupt is cleared."; };
            INTERRUPT_GENERATED_WRITING = 1 { name = "Interrupt Generated Writing"; desc = "An interrupt is generated. Writing 1 clears the bit."; };
        };

        field {
            name = "setup";
            desc = "Setup phase done interrupt";
            sw = rw;
            hw = w;
            onwrite = woclr;
            encode = DOEPINT_setup_enum;
            reset = 0x0;
        } setup[3:3];

        enum DOEPINT_ahberr_enum {
            INTERRUPT_CLEARED = 0 { name = "Interrupt Cleared"; desc = "An interrupt is cleared."; };
            INTERRUPT_GENERATED_WRITING = 1 { name = "Interrupt Generated Writing"; desc = "An interrupt is generated. Writing 1 clears the bit."; };
        };

        field {
            name = "ahberr";
            desc = "AHB error interrupt. An interrupt is generated when an AHB error occurs during AHB read/write operations in internal DMA mode.";
            sw = rw;
            hw = w;
            onwrite = woclr;
            encode = DOEPINT_ahberr_enum;
            reset = 0x0;
        } ahberr[2:2];

        enum DOEPINT_epdisbld_enum {
            INTERRUPT_CLEARED = 0 { name = "Interrupt Cleared"; desc = "An interrupt is cleared."; };
            INTERRUPT_GENERATED_WRITING = 1 { name = "Interrupt Generated Writing"; desc = "An interrupt is generated. Writing 1 clears the bit."; };
        };

        field {
            name = "epdisbld";
            desc = "Endpoint disabled interrupt";
            sw = rw;
            hw = w;
            onwrite = woclr;
            encode = DOEPINT_epdisbld_enum;
            reset = 0x0;
        } epdisbld[1:1];

        enum DOEPINT_xfercompl_enum {
            INTERRUPT_CLEARED = 0 { name = "Interrupt Cleared"; desc = "An interrupt is cleared."; };
            INTERRUPT_GENERATED_WRITING = 1 { name = "Interrupt Generated Writing"; desc = "An interrupt is generated. Writing 1 clears the bit."; };
        };

        field {
            name = "xfercompl";
            desc = "Transfer completion interrupt";
            sw = rw;
            hw = w;
            onwrite = woclr;
            encode = DOEPINT_xfercompl_enum;
            reset = 0x0;
        } xfercompl[0:0];
    } DOEPINT @ 0x8;

    reg {
        name = "Transfer size register for device OUT endpoint 0";
        desc = "DOEPTSIZn is a transfer size register for device OUT endpoint n.

Data sheet 12.7.5.2 DOEPTSIZn (offset 0xB10, printed page 12-241, `Hi3518EV20X-Hi3516CV200-Datasheet.txt` line 90519).";

        field {
            name = "mc_rxdpid_supcnt";
            desc = "Number of packets (IN endpoint, RW) 00: 0 packet 01: 1 packet 10: 2 packets 11: 3 packets Number of packets (non-periodic IN endpoints, RO) This field is valid only in internal DMA mode. PID of the received data (isochronous OUT endpoints, RO) 00: DATA0 01: DATA2 10: DATA1 11: MDATA Number of setup packets (OUT endpoint, RW) 01: 1 packet 10: 2 packets 11: 3 packets";
            sw = rw;
            hw = r;
            reset = 0x0;
        } mc_rxdpid_supcnt[30:29];

        field {
            name = "pktcnt";
            desc = "Number of packets";
            sw = rw;
            hw = r;
            reset = 0x0;
        } pktcnt[28:19];

        field {
            name = "xfersize";
            desc = "Transferred data size";
            sw = rw;
            hw = r;
            reset = 0x0;
        } xfersize[18:0];
    } DOEPTSIZ @ 0x10;

    reg {
        name = "DMA address register for device OUT endpoint n";
        desc = "DOEPDMAN is a DMA address register for device OUT endpoint n.

Data sheet 12.7.5.2 DOEPDMAN (offset 0xB14, printed page 12-242, `Hi3518EV20X-Hi3516CV200-Datasheet.txt` line 90597).";

        field {
            name = "dmaaddr";
            desc = "DMA address";
            sw = rw;
            hw = r;
            reset = 0x0;
        } dmaaddr[31:0];
    } DOEPDMA @ 0x14;

    reg {
        name = "DMA buffer address register for device OUT endpoint n";
        desc = "DOEPDMABN is a DMA buffer address register for device OUT endpoint n.

Data sheet 12.7.5.2 DOEPDMABN (offset 0xB1C, printed page 12-243, `Hi3518EV20X-Hi3516CV200-Datasheet.txt` line 90646).";

        field {
            name = "dmabufferaddr";
            desc = "DMA buffer address";
            sw = r;
            hw = w;
            reset = 0x0;
        } dmabufferaddr[31:0];
    } DOEPDMAB @ 0x1C;
};

regfile eHISI_USB_DEVICE {
    name = "HiSilicon USB 2.0 device controller (DesignWare DWC_otg, device mode)";
    desc = "
    HiSilicon USB 2.0 device controller at 0x10080000: a Synopsys DesignWare Cores USB 2.0 Hi-Speed On-The-Go (DWC_otg, \"dwc2\" register map, scatter/gather DMA and dedicated TX FIFO configuration, ADP/LPM/HNP/SRP, UTMI+ 16-bit PHY interface) used in device mode, with up to 16 IN and 16 OUT endpoints. The same core is documented in the data sheet with its host registers, but the host EHCI/OHCI pair at 0x100B0000 / 0x100A0000 is a separate controller (`eHISI_USB_EHCI` / `eHISI_USB_OHCI`); both share one UTMI PHY and are switched by MISC_CTRL30[usb_chipid] (0 = host, 1 = device; with usb2_phy_dmpulldown / usb2_phy_dppulldown 1 for host and 0 for device) and reset/clocked through PERI_CRG46 (DS 12.7.3). Interrupt: VIC interrupt 10 (USB_DEV).
    Layout: global registers 0x000..0x060 (GOTGCTL .. GADPCTL), FIFO size registers (HPTXFSIZ 0x100, DIEPTXF[15] at 0x104 + 4 x (n - 1), the data sheet's DPTXFSIZN / DIEPTXFN, shared-FIFO and dedicated-FIFO views of the same registers), device registers DCFG .. DEACHINTMSK 0x800..0x83C, per-endpoint interrupt mask registers DIEPEACHMSKN[16] (0x840) / DOEPEACHMSKN[16] (0x880) and per-endpoint register sets: IN_EP0 @ 0x900, IN_EP[1..15] @ 0x920 + 0x20 x (n - 1), OUT_EP0 @ 0xB00, OUT_EP[1..15] @ 0xB20 + 0x20 x (n - 1) (control, interrupt, transfer size, DMA address and DMA buffer address, plus the TX FIFO status DTXFSTS for IN endpoints). The data sheet's register tables use name suffixes N/n for the endpoint index.
    Registers are from the Hi3518E V20X/Hi3516C V200 data sheet issue 02 (2017-06-12), section 12.7.5.2 (`datasheet` text lines 86100-90660); descriptions use the data sheet text; scrambled tables are rebuilt (see the register descriptions of GRSTCTL, DIEPINT, DOEPINT). The data sheet also lists DTKNQR3 / DTKNQR4 at the addresses of DTHRCTL / DIEPEMPMSK; they are not modelled separately. Host-mode registers of the core (HCFG, HFIR, HPRT, HC channel registers, PCGCCTL) and the FIFO data windows are not described in the data sheet (host mode runs through the EHCI/OHCI pair) and are not modelled. Not hardware verified.
";

    reg {
        name = "Micro-frame length configuration register";
        desc = "INTNREG00 is a micro-frame length configuration register.

Data sheet 12.7.5.2 INTNREG00 (offset 0x90, printed page 12-161, `Hi3518EV20X-Hi3516CV200-Datasheet.txt` line 86107).";

        field {
            name = "val";
            desc = "Value of the micro-frame counter. This register is used only for emulation. In normal mode, the micro-frame length is 125 us defined by the protocol. During emulation, you can change the micro-frame length by configuring this register as required to";
            sw = rw;
            hw = r;
            reset = 0x0;
        } val[13:1];

        enum INTNREG00_en_enum {
            DISABLED = 0 { name = "Disabled"; desc = "disabled"; };
            ENABLED = 1 { name = "Enabled"; desc = "enabled"; };
        };

        field {
            name = "en";
            desc = "reduce the emulation time. Micro-frame length register enable";
            sw = rw;
            hw = r;
            encode = INTNREG00_en_enum;
            reset = 0x0;
        } en[0:0];
    } INTNREG00 @ 0x90;

    reg {
        name = "PBUF OUT/IN register";
        desc = "INSNREG01 is a PBUF out/in configuration register.

Data sheet 12.7.5.2 INSNREG01 (offset 0x94, printed page 12-162, `Hi3518EV20X-Hi3516CV200-Datasheet.txt` line 86142).";

        field {
            name = "out_threshold";
            desc = "TX threshold. If the data amount in the PBUF is above the TX threshold, data starts to be transmitted. The depth is measured by 32 bits.";
            sw = rw;
            hw = r;
            reset = 0x20;
        } out_threshold[31:16];

        field {
            name = "in_threshold";
            desc = "RX threshold. If the data amount in the PBUF is above the RX threshold, data is read from the PBUF. The depth is measured by 32 bits.";
            sw = rw;
            hw = r;
            reset = 0x20;
        } in_threshold[15:0];
    } INSNREG01 @ 0x94;

    reg {
        name = "PBUF depth register";
        desc = "INSNREG02 is a PBUF depth configuration register.

Data sheet 12.7.5.2 INSNREG02 (offset 0x98, printed page 12-162, `Hi3518EV20X-Hi3516CV200-Datasheet.txt` line 86165).";

        field {
            name = "pbuf_depth";
            desc = "PBUF depth. The depth is measured by 32 bits.";
            sw = rw;
            hw = r;
            reset = 0x80;
        } pbuf_depth[11:0];
    } INSNREG02 @ 0x98;

    reg {
        name = "Interrupt memory transfer enable register";
        desc = "INSNREG03 is an interrupt memory transfer enable register.

Data sheet 12.7.5.2 INSNREG03 (offset 0x9C, printed page 12-163, `Hi3518EV20X-Hi3516CV200-Datasheet.txt` line 86193).";

        enum INSNREG03_dis_enum {
            DISABLED = 0 { name = "Disabled"; desc = "disabled"; };
            ENABLED = 1 { name = "Enabled"; desc = "enabled"; };
        };

        field {
            name = "dis";
            desc = "256 MHz clock check enable";
            sw = rw;
            hw = r;
            encode = INSNREG03_dis_enum;
            reset = 0x0;
        } dis[14:14];

        enum INSNREG03_ctrl_enum {
            DISABLED = 0 { name = "Disabled"; desc = "disabled"; };
            ENABLED = 1 { name = "Enabled"; desc = "enabled"; };
        };

        field {
            name = "ctrl";
            desc = "Line state ignore during TESTSE0 NAK";
            sw = rw;
            hw = r;
            encode = INSNREG03_ctrl_enum;
            reset = 0x0;
        } ctrl[13:13];

        field {
            name = "val";
            desc = "TX-TX turnaround delay addition";
            sw = rw;
            hw = r;
            reset = 0x0;
        } val[12:10];

        enum INSNREG03_fetch_enum {
            CONTROLLER_FETCHES_INSTRUCTION = 0 { name = "Controller Fetches Instruction"; desc = "The controller fetches instructions from the periodic linked list only in micro-frame 0."; };
            CONTROLLER_FETCHES_INSTRUCTION_2 = 1 { name = "Controller Fetches Instruction 2"; desc = "The controller fetches instructions from the periodic linked list in every micro-frame."; };
        };

        field {
            name = "fetch";
            desc = "Instruction fetching from the periodic frame list, valid only in CONFIG1 mode";
            sw = rw;
            hw = r;
            encode = INSNREG03_fetch_enum;
            reset = 0x0;
        } fetch[9:9];

        field {
            name = "offset";
            desc = "Available time offset";
            sw = rw;
            hw = r;
            reset = 0x0;
        } offset[8:1];

        enum INSNREG03_brk_en_enum {
            DISABLED = 0 { name = "Disabled"; desc = "disabled"; };
            ENABLED = 1 { name = "Enabled"; desc = "enabled"; };
        };

        field {
            name = "brk_en";
            desc = "Interrupt memory transfer enable";
            sw = r;
            hw = w;
            encode = INSNREG03_brk_en_enum;
            reset = 0x1;
        } brk_en[0:0];
    } INSNREG03 @ 0x9C;

    reg {
        name = "Debug register";
        desc = "INTNREG04 is a debug register.

Data sheet 12.7.5.2 INTNREG04 (offset 0xA0, printed page 12-164, `Hi3518EV20X-Hi3516CV200-Datasheet.txt` line 86242).";

        enum INTNREG04_auto_en_enum {
            ENABLED_SUSPEND_SIGNAL = 0 { name = "Enabled Suspend Signal"; desc = "enabled. The suspend signal is valid when the run/stop bit is reset by software, but the hchalted bit is not set."; };
            DISABLED_PORT_NOT = 1 { name = "Disabled Port Not"; desc = "disabled. The port is not suspended when software clears the run/stop bit. The default value is 0."; };
        };

        field {
            name = "auto_en";
            desc = "Automatic feature enable";
            sw = rw;
            hw = r;
            encode = INTNREG04_auto_en_enum;
            reset = 0x0;
        } auto_en[5:5];

        enum INTNREG04_nak_reldfix_en_enum {
            ENABLED = 0 { name = "Enabled"; desc = "enabled"; };
            DISABLED = 1 { name = "Disabled"; desc = "disabled"; };
        };

        field {
            name = "nak_reldfix_en";
            desc = "NAK reload enable";
            sw = rw;
            hw = r;
            encode = INTNREG04_nak_reldfix_en_enum;
            reset = 0x0;
        } nak_reldfix_en[4:4];

        enum INTNREG04_scaledwn_enum_time_enum {
            DISABLED = 0 { name = "Disabled"; desc = "disabled"; };
            ENABLED = 1 { name = "Enabled"; desc = "enabled"; };
        };

        field {
            name = "scaledwn_enum_time";
            desc = "Port enumeration time scale down enable";
            sw = rw;
            hw = r;
            encode = INTNREG04_scaledwn_enum_time_enum;
            reset = 0x0;
        } scaledwn_enum_time[2:2];

        enum INTNREG04_hccparam_en_enum {
            DISABLED = 0 { name = "Disabled"; desc = "disabled"; };
            ENABLED = 1 { name = "Enabled"; desc = "enabled"; };
        };

        field {
            name = "hccparam_en";
            desc = "HCCPARAMS register write enable";
            sw = rw;
            hw = r;
            encode = INTNREG04_hccparam_en_enum;
            reset = 0x0;
        } hccparam_en[1:1];

        enum INTNREG04_hcsparam_en_enum {
            DISABLED = 0 { name = "Disabled"; desc = "disabled"; };
            ENABLED = 1 { name = "Enabled"; desc = "enabled"; };
        };

        field {
            name = "hcsparam_en";
            desc = "HCSPARAMS register write enable";
            sw = rw;
            hw = r;
            encode = INTNREG04_hcsparam_en_enum;
            reset = 0x0;
        } hcsparam_en[0:0];
    } INTNREG04 @ 0xA0;

    reg {
        name = "UTMI Vendor Control and status register";
        desc = "INTNREG05 is a UTMI Vendor control and status register. It is used to read or write to the UTMI PHY.

Data sheet 12.7.5.2 INTNREG05 (offset 0xA4, printed page 12-165, `Hi3518EV20X-Hi3516CV200-Datasheet.txt` line 86297).";

        field {
            name = "vbusy";
            desc = "The value 1 indicates that the hardware is writing data. This bit is cleared only when the process ends.";
            sw = r;
            hw = w;
            reset = 0x0;
        } vbusy[17:17];

        field {
            name = "vport";
            desc = "Port ID. It cannot exceed the supported number of ports.";
            sw = rw;
            hw = r;
            reset = 0x0;
        } vport[16:13];

        enum INTNREG05_vcontrol_loadm_enum {
            ENABLED = 0 { name = "Enabled"; desc = "enabled"; };
            DISABLED = 1 { name = "Disabled"; desc = "disabled"; };
        };

        field {
            name = "vcontrol_loadm";
            desc = "Load enable";
            sw = rw;
            hw = r;
            encode = INTNREG05_vcontrol_loadm_enum;
            reset = 0x1;
        } vcontrol_loadm[12:12];
    } INTNREG05 @ 0xA4;

    reg {
        name = "AHB error status register";
        desc = "INTNREG06 is an AHB error status register.

Data sheet 12.7.5.2 INTNREG06 (offset 0xA8, printed page 12-165, `Hi3518EV20X-Hi3516CV200-Datasheet.txt` line 86332).";

        field {
            name = "err_capture";
            desc = "AHB error";
            sw = rw;
            hw = r;
            reset = 0x0;
        } err_capture[31:31];

        field {
            name = "hbusrt_err";
            desc = "hbrust value during a control transfer when an AHB error occurs";
            sw = r;
            hw = w;
            reset = 0x0;
        } hbusrt_err[11:9];

        field {
            name = "num_beat_err";
            desc = "Number of beats during a burst transfer when an AHB error occurs. The maximum number of beats is 16. 0x00-0x10: valid 0x11-0x1F: reserved";
            sw = r;
            hw = w;
            reset = 0x0;
        } num_beat_err[8:4];

        field {
            name = "num_beat_ok";
            desc = "Number of completed beats during a burst transfer when an AHB error occurs";
            sw = r;
            hw = w;
            reset = 0x0;
        } num_beat_ok[3:0];
    } INTNREG06 @ 0xA8;

    reg {
        name = "AHB error address register";
        desc = "INTNREG07 is an AHB error address register.

Data sheet 12.7.5.2 INTNREG07 (offset 0xAC, printed page 12-166, `Hi3518EV20X-Hi3516CV200-Datasheet.txt` line 86375).";

        field {
            name = "err_addr";
            desc = "Address during a control transfer when an AHB error occurs";
            sw = r;
            hw = w;
            reset = 0x0;
        } err_addr[31:0];
    } INTNREG07 @ 0xAC;

    reg {
        name = "Device behavior control and status query register";
        desc = "GOTGCTL is a device behavior control and status query register.

Data sheet 12.7.5.2 GOTGCTL (offset 0x0, printed page 12-166, `Hi3518EV20X-Hi3516CV200-Datasheet.txt` line 86394).";

        enum GOTGCTL_chirpen_enum {
            DISABLED = 0 { name = "Disabled"; desc = "disabled"; };
            ENABLED = 1 { name = "Enabled"; desc = "enabled"; };
        };

        field {
            name = "chirpen";
            desc = "Chirp on enable";
            sw = rw;
            hw = r;
            encode = GOTGCTL_chirpen_enum;
            reset = 0x0;
        } chirpen[27:27];

        field {
            name = "multvalidbc";
            desc = "BC ACA input Bit[26]: rid_float Bit[25]: rid_gnd Bit[24]: rid_a Bit[23]: rid_b Bit[22]: rid_c";
            sw = r;
            hw = w;
            reset = 0x13;
        } multvalidbc[26:22];

        enum GOTGCTL_otgver_enum {
            DEVICE_VERSION_1 = 0 { name = "Device Version 1"; desc = "Device version 1.3"; };
            DEVICE_VERSION_2 = 1 { name = "Device Version 2"; desc = "Device version 2.0"; };
        };

        field {
            name = "otgver";
            desc = "Device version";
            sw = rw;
            hw = r;
            encode = GOTGCTL_otgver_enum;
            reset = 0x0;
        } otgver[20:20];

        enum GOTGCTL_bsesvld_enum {
            B_SESSION_INVALID = 0 { name = "B Session Invalid"; desc = "B-session invalid"; };
            B_SESSION_VALID = 1 { name = "B Session Valid"; desc = "B-session valid"; };
        };

        field {
            name = "bsesvld";
            desc = "Transceiver status in device mode";
            sw = r;
            hw = w;
            encode = GOTGCTL_bsesvld_enum;
            reset = 0x0;
        } bsesvld[19:19];

        enum GOTGCTL_asesvld_enum {
            SESSION_INVALID = 0 { name = "Session Invalid"; desc = "A-session invalid"; };
            SESSION_VALID = 1 { name = "Session Valid"; desc = "A-session valid"; };
        };

        field {
            name = "asesvld";
            desc = "Transceiver status in host mode";
            sw = r;
            hw = w;
            encode = GOTGCTL_asesvld_enum;
            reset = 0x0;
        } asesvld[18:18];

        enum GOTGCTL_dbnctime_enum {
            LONG_DEJITTER_TIME = 0 { name = "Long Dejitter Time"; desc = "long dejitter time"; };
            SHORT_DEJITTER_TIME = 1 { name = "Short Dejitter Time"; desc = "short dejitter time"; };
        };

        field {
            name = "dbnctime";
            desc = "Dejitter time";
            sw = r;
            hw = w;
            encode = GOTGCTL_dbnctime_enum;
            reset = 0x0;
        } dbnctime[17:17];

        enum GOTGCTL_conidsts_enum {
            DEVICE_WORKS_DEVICE = 0 { name = "Device Works Device"; desc = "The device works in A-device mode."; };
            DEVICE_WORKS_B = 1 { name = "Device Works B"; desc = "The device works in B-device mode."; };
        };

        field {
            name = "conidsts";
            desc = "USB_ID status";
            sw = r;
            hw = w;
            encode = GOTGCTL_conidsts_enum;
            reset = 0x1;
        } conidsts[16:16];

        enum GOTGCTL_devhnpen_enum {
            DISABLED = 0 { name = "Disabled"; desc = "disabled"; };
            ENABLED = 1 { name = "Enabled"; desc = "enabled"; };
        };

        field {
            name = "devhnpen";
            desc = "Device HNP enable";
            sw = rw;
            hw = r;
            encode = GOTGCTL_devhnpen_enum;
            reset = 0x0;
        } devhnpen[11:11];

        enum GOTGCTL_hstsethnpen_enum {
            DISABLED = 0 { name = "Disabled"; desc = "disabled"; };
            ENABLED = 1 { name = "Enabled"; desc = "enabled"; };
        };

        field {
            name = "hstsethnpen";
            desc = "Host HNP enable";
            sw = rw;
            hw = r;
            encode = GOTGCTL_hstsethnpen_enum;
            reset = 0x0;
        } hstsethnpen[10:10];

        enum GOTGCTL_hnpreq_enum {
            NO = 0 { name = "No"; desc = "no"; };
            YES = 1 { name = "Yes"; desc = "yes"; };
        };

        field {
            name = "hnpreq";
            desc = "HNP request";
            sw = rw;
            hw = r;
            encode = GOTGCTL_hnpreq_enum;
            reset = 0x0;
        } hnpreq[9:9];

        enum GOTGCTL_hstnegscs_enum {
            HOST_NEGOTIATION_FAILS = 0 { name = "Host Negotiation Fails"; desc = "Host negotiation fails."; };
            HOST_NEGOTIATION_SUCCESSFUL = 1 { name = "Host Negotiation Successful"; desc = "Host negotiation is successful."; };
        };

        field {
            name = "hstnegscs";
            desc = "Host negotiation indicator";
            sw = r;
            hw = w;
            encode = GOTGCTL_hstnegscs_enum;
            reset = 0x0;
        } hstnegscs[8:8];

        enum GOTGCTL_bvalidovval_enum {
            BVALID_0 = 0 { name = "Bvalid 0"; desc = "Bvalid = 0"; };
            BVALID_1_WHEN = 1 { name = "Bvalid 1 When"; desc = "Bvalid = 1 When GOTGCTL[bvalidoven] is 1, this bit is valid."; };
        };

        field {
            name = "bvalidovval";
            desc = "Bvalid setting";
            sw = rw;
            hw = r;
            encode = GOTGCTL_bvalidovval_enum;
            reset = 0x0;
        } bvalidovval[7:7];

        enum GOTGCTL_bvalidoven_enum {
            BVALID_CAN_OVERWRITTEN = 0 { name = "Bvalid Can Overwritten"; desc = "Bvalid can be overwritten."; };
            BVALID_CANNOT_OVERWRITTEN = 1 { name = "Bvalid Cannot Overwritten"; desc = "Bvalid cannot be overwritten."; };
        };

        field {
            name = "bvalidoven";
            desc = "Bvalid signal overwrite enable";
            sw = rw;
            hw = r;
            encode = GOTGCTL_bvalidoven_enum;
            reset = 0x0;
        } bvalidoven[6:6];

        enum GOTGCTL_avalidovval_enum {
            AVALID_0 = 0 { name = "Avalid 0"; desc = "Avalid = 0"; };
            AVALID_1_WHEN = 1 { name = "Avalid 1 When"; desc = "Avalid = 1 When GOTGCTL[avalidoven] is 1, this bit is valid."; };
        };

        field {
            name = "avalidovval";
            desc = "Avalid setting";
            sw = rw;
            hw = r;
            encode = GOTGCTL_avalidovval_enum;
            reset = 0x0;
        } avalidovval[5:5];

        enum GOTGCTL_avalidoven_enum {
            AVALID_CAN_OVERWRITTEN = 0 { name = "Avalid Can Overwritten"; desc = "Avalid can be overwritten."; };
            AVALID_CANNOT_OVERWRITTEN = 1 { name = "Avalid Cannot Overwritten"; desc = "Avalid cannot be overwritten."; };
        };

        field {
            name = "avalidoven";
            desc = "Avalid signal overwrite enable";
            sw = rw;
            hw = r;
            encode = GOTGCTL_avalidoven_enum;
            reset = 0x0;
        } avalidoven[4:4];

        enum GOTGCTL_vbvalidovval_enum {
            VBUSVALID_0 = 0 { name = "Vbusvalid 0"; desc = "vbusvalid = 0"; };
            VBUSVALID_1_WHEN = 1 { name = "Vbusvalid 1 When"; desc = "vbusvalid = 1 When GOTGCTL[vbvalidoven] is 1, this bit is valid."; };
        };

        field {
            name = "vbvalidovval";
            desc = "vbusvalid setting";
            sw = rw;
            hw = r;
            encode = GOTGCTL_vbvalidovval_enum;
            reset = 0x0;
        } vbvalidovval[3:3];

        enum GOTGCTL_vbvalidoven_enum {
            VBUSVALID_CAN_OVERWRITTEN = 0 { name = "Vbusvalid Can Overwritten"; desc = "vbusvalid can be overwritten."; };
            VBUSVALID_CANNOT_OVERWRITTEN = 1 { name = "Vbusvalid Cannot Overwritten"; desc = "vbusvalid cannot be overwritten."; };
        };

        field {
            name = "vbvalidoven";
            desc = "vbusvalid signal overwrite enable.";
            sw = rw;
            hw = r;
            encode = GOTGCTL_vbvalidoven_enum;
            reset = 0x0;
        } vbvalidoven[2:2];

        enum GOTGCTL_sesreq_enum {
            NO = 0 { name = "No"; desc = "no"; };
            YES = 1 { name = "Yes"; desc = "yes"; };
        };

        field {
            name = "sesreq";
            desc = "Session request";
            sw = rw;
            hw = r;
            encode = GOTGCTL_sesreq_enum;
            reset = 0x0;
        } sesreq[1:1];

        enum GOTGCTL_sesreqscs_enum {
            FAILURE = 0 { name = "Failure"; desc = "failure"; };
            SUCCESS = 1 { name = "Success"; desc = "success"; };
        };

        field {
            name = "sesreqscs";
            desc = "Session request status";
            sw = r;
            hw = w;
            encode = GOTGCTL_sesreqscs_enum;
            reset = 0x0;
        } sesreqscs[0:0];
    } GOTGCTL @ 0x0;

    reg {
        name = "Device interrupt generation indicator/clear register";
        desc = "GOTGINT is a device interrupt generation indicator/clear register.

The data sheet lists these bits as read-only but each description says writing 1 clears the interrupt; they are modelled write-1-to-clear.

Data sheet 12.7.5.2 GOTGINT (offset 0x4, printed page 12-169, `Hi3518EV20X-Hi3516CV200-Datasheet.txt` line 86520).";

        field {
            name = "multvalipchng";
            desc = "An interrupt is generated when the value of at least one ACA pin changes. Setting this bit to 1 clears the interrupt. This bit is valid only when OTG_BC_SUPPORT is 1.";
            sw = rw;
            hw = w;
            onwrite = woclr;
            reset = 0x0;
        } multvalipchng[20:20];

        field {
            name = "dbncedone";
            desc = "An interrupt is generated when dejitter is successful. Setting this bit to 1 clears the interrupt. This bit is valid only when the HNP Capable or SRP Capable bit is set to 1.";
            sw = rw;
            hw = w;
            onwrite = woclr;
            reset = 0x0;
        } dbncedone[19:19];

        field {
            name = "adevtoutchg";
            desc = "An interrupt is generated when waiting for the connection of device B times out. Setting this bit to 1 clears the interrupt.";
            sw = rw;
            hw = w;
            onwrite = woclr;
            reset = 0x0;
        } adevtoutchg[18:18];

        field {
            name = "hstnegdet";
            desc = "An interrupt is generated when host negotiation is detected. Setting this bit to 1 clears the interrupt.";
            sw = rw;
            hw = w;
            onwrite = woclr;
            reset = 0x0;
        } hstnegdet[17:17];

        field {
            name = "hstnegsucstschng";
            desc = "An interrupt is generated when the host negotiation request fails or is successful. Setting this bit to 1 clears the interrupt.";
            sw = rw;
            hw = w;
            onwrite = woclr;
            reset = 0x0;
        } hstnegsucstschng[9:9];

        field {
            name = "sesreqsucstschng";
            desc = "An interrupt is generated when the session request fails or is successful. Setting this bit to 1 clears the interrupt.";
            sw = rw;
            hw = w;
            onwrite = woclr;
            reset = 0x0;
        } sesreqsucstschng[8:8];

        field {
            name = "sesenddet";
            desc = "An interrupt is generated when utmiotg_bvalid is deasserted. Setting this bit to 1 clears the interrupt.";
            sw = rw;
            hw = w;
            onwrite = woclr;
            reset = 0x0;
        } sesenddet[2:2];
    } GOTGINT @ 0x4;

    reg {
        name = "AHB configuration register";
        desc = "GAHBCFG is an AHB configuration register.

Linux `dwc2` sets glblintrmsk (bit 0), hbstlen (burst type, 5 = INCR4 is typical) and dmaen (bit 5) for DMA operation.

Data sheet 12.7.5.2 GAHBCFG (offset 0x8, printed page 12-170, `Hi3518EV20X-Hi3516CV200-Datasheet.txt` line 86579).";

        enum GAHBCFG_invdescendianness_enum {
            DESCRIPTOR_BYTE_SEQUENCE = 0 { name = "Descriptor Byte Sequence"; desc = "The descriptor byte sequence is similar to the AHB master byte sequence."; };
            WHEN_AHB_MASTER = 1 { name = "When Ahb Master"; desc = "When the AHB master byte sequence is big endian, the descriptor byte sequence is little endian. When the AHB master byte sequence is little endian, the descriptor byte sequence is big endian."; };
        };

        field {
            name = "invdescendianness";
            desc = "Descriptor byte invert";
            sw = rw;
            hw = r;
            encode = GAHBCFG_invdescendianness_enum;
            reset = 0x0;
        } invdescendianness[24:24];

        enum GAHBCFG_ahbsingle_enum {
            REMAINING_DATA_TRANSMITTED = 0 { name = "Remaining Data Transmitted"; desc = "The remaining data is transmitted based on the INCR burst size."; };
            REMAINING_DATA_TRANSMITTED_2 = 1 { name = "Remaining Data Transmitted 2"; desc = "The remaining data is transmitted based on the single burst size."; };
        };

        field {
            name = "ahbsingle";
            desc = "Transfer in DMA mode";
            sw = rw;
            hw = r;
            encode = GAHBCFG_ahbsingle_enum;
            reset = 0x0;
        } ahbsingle[23:23];

        field {
            name = "notialldmawrit";
            desc = "DMA write operation notification. This bit is valid only when GAHBCFG[remmemsupp] is 1.";
            sw = rw;
            hw = r;
            reset = 0x0;
        } notialldmawrit[22:22];

        enum GAHBCFG_remmemsupp_enum {
            INT_DMA_REQ = 0 { name = "Int Dma Req"; desc = "int_dma_req and int_dma_done are not set to 1, and the controller core handles the XferComp interrupt immediately after the DMA write operation is complete."; };
            INT_DMA_REQ_2 = 1 { name = "Int Dma Req 2"; desc = "int_dma_req is set to 1 when the HSOTG DMA starts writing data to an external memory; int_dma_done is set to 1 when the transfer of the controller core is complete, indicating that the HSOTG write operation is complete. In this case, the controller core waits until the system sys_dma_done signal becomes valid, and then starts the next DMA transfer."; };
        };

        field {
            name = "remmemsupp";
            desc = "Remote memory support";
            sw = rw;
            hw = r;
            encode = GAHBCFG_remmemsupp_enum;
            reset = 0x0;
        } remmemsupp[21:21];

        enum GAHBCFG_nptxfemplvl_enum {
            TXFEMP_INTERRUPT_INDICATES = 0 { name = "Txfemp Interrupt Indicates"; desc = "The TxFEmp interrupt indicates that the TX FIFO at the IN endpoint is half empty."; };
            TXFEMP_INTERRUPT_INDICATES_2 = 1 { name = "Txfemp Interrupt Indicates 2"; desc = "The TxFEmp interrupt indicates that the TX FIFO at the IN endpoint is empty."; };
        };

        field {
            name = "nptxfemplvl";
            desc = "Empty status level of the non-periodic TX FIFO";
            sw = rw;
            hw = r;
            encode = GAHBCFG_nptxfemplvl_enum;
            reset = 0x0;
        } nptxfemplvl[7:7];

        enum GAHBCFG_dmaen_enum {
            CORE_WORKS_SLAVE = 0 { name = "Core Works Slave"; desc = "The core works in slave mode."; };
            CORE_WORKS_DMA = 1 { name = "Core Works Dma"; desc = "The core works in DMA mode."; };
        };

        field {
            name = "dmaen";
            desc = "DMA mode enable";
            sw = rw;
            hw = r;
            encode = GAHBCFG_dmaen_enum;
            reset = 0x0;
        } dmaen[5:5];

        field {
            name = "hbstlen";
            desc = "Burst length/type for both the external and internal DMA modes In external DMA mode: 0000: 1 word 0001: 4 words 0010: 8 words 0011: 16 words 0100: 32 words 0101: 64 words 0110: 128 words 0111: 256 words Other values: reserved In internal DMA mode: 0000: Single 0001: INCR 0011: INCR4 0101: INCR8 0111: INCR16 Other values: reserved";
            sw = rw;
            hw = r;
            reset = 0x0;
        } hbstlen[4:1];

        enum GAHBCFG_glblintrmsk_enum {
            MASKED = 0 { name = "Masked"; desc = "masked"; };
            NOT_MASKED = 1 { name = "Not Masked"; desc = "not masked"; };
        };

        field {
            name = "glblintrmsk";
            desc = "Global interrupt mask";
            sw = rw;
            hw = r;
            encode = GAHBCFG_glblintrmsk_enum;
            reset = 0x0;
        } glblintrmsk[0:0];
    } GAHBCFG @ 0x8;

    reg {
        name = "USB configuration register";
        desc = "GUSBCFG is a USB configuration register.

DS field 'r' (bit 21) is the ULPI external VBUS indicator; renamed `ulpiextvbusindicator` as in the DWC_otg databook. The data sheet reset value 0x00001400 = usbtrdtim 5 (16-bit UTMI+).

Data sheet 12.7.5.2 GUSBCFG (offset 0xC, printed page 12-172, `Hi3518EV20X-Hi3516CV200-Datasheet.txt` line 86677).";

        field {
            name = "corrupttxpkt";
            desc = "Unexpected TX packet This bit is for debugging only and is always set to 0.";
            sw = w;
            hw = r;
            reset = 0x0;
        } corrupttxpkt[31:31];

        enum GUSBCFG_forcedevmode_enum {
            NORMAL_MODE = 0 { name = "Normal Mode"; desc = "normal mode"; };
            FORCIBLE_DEVICE_MODE = 1 { name = "Forcible Device Mode"; desc = "forcible device mode"; };
        };

        field {
            name = "forcedevmode";
            desc = "Forcible device mode";
            sw = rw;
            hw = r;
            encode = GUSBCFG_forcedevmode_enum;
            reset = 0x0;
        } forcedevmode[30:30];

        enum GUSBCFG_forcehstmode_enum {
            NORMAL_MODE = 0 { name = "Normal Mode"; desc = "normal mode"; };
            FORCIBLE_HOST_MODE = 1 { name = "Forcible Host Mode"; desc = "forcible host mode"; };
        };

        field {
            name = "forcehstmode";
            desc = "Forcible host mode";
            sw = rw;
            hw = r;
            encode = GUSBCFG_forcehstmode_enum;
            reset = 0x0;
        } forcehstmode[29:29];

        enum GUSBCFG_txenddelay_enum {
            DISABLED = 0 { name = "Disabled"; desc = "disabled"; };
            ENABLED = 1 { name = "Enabled"; desc = "enabled"; };
        };

        field {
            name = "txenddelay";
            desc = "TX end delay enable";
            sw = rw;
            hw = r;
            encode = GUSBCFG_txenddelay_enum;
            reset = 0x0;
        } txenddelay[28:28];

        enum GUSBCFG_usbtrafctl_enum {
            PULL_UP_PULL = 0 { name = "Pull Up Pull"; desc = "Pull-up and pull-down resistors are attached."; };
            PULL_UP_PULL_2 = 1 { name = "Pull Up Pull 2"; desc = "Pull-up and pull-down resistors are detached."; };
        };

        field {
            name = "usbtrafctl";
            desc = "USB pull-up/pull-down resistor control (traffic signaling)";
            sw = rw;
            hw = r;
            encode = GUSBCFG_usbtrafctl_enum;
            reset = 0x0;
        } usbtrafctl[27:27];

        enum GUSBCFG_ic_usbcap_enum {
            IC_USB_PHY = 0 { name = "Ic Usb Phy"; desc = "The IC_USB PHY interface is not selected."; };
            IC_USB_PHY_2 = 1 { name = "Ic Usb Phy 2"; desc = "The IC_USB PHY interface is selected."; };
        };

        field {
            name = "ic_usbcap";
            desc = "IC_USB enable";
            sw = r;
            hw = w;
            encode = GUSBCFG_ic_usbcap_enum;
            reset = 0x0;
        } ic_usbcap[26:26];

        enum GUSBCFG_ulpi_enum {
            ENABLED = 0 { name = "Enabled"; desc = "enabled"; };
            DISABLED = 1 { name = "Disabled"; desc = "disabled"; };
        };

        field {
            name = "ulpi";
            desc = "ULPI interface protection enable";
            sw = rw;
            hw = r;
            encode = GUSBCFG_ulpi_enum;
            reset = 0x0;
        } ulpi[25:25];

        enum GUSBCFG_indicator_enum {
            COMPLEMENTARY_OUTPUT_SIGNAL = 0 { name = "Complementary Output Signal"; desc = "The complementary output signal is determined by the vbusvalid comparator."; };
            COMPLEMENTARY_OUTPUT_SIGNAL_2 = 1 { name = "Complementary Output Signal 2"; desc = "The complementary output signal is not determined by the vbusvalid comparator. When TG_HSPHY_INTERFACE is 1, this bit is read-only. When TG_HSPHY_INTERFACE is 0, this bit is reserved."; };
        };

        field {
            name = "indicator";
            desc = "Indicator pass through";
            sw = rw;
            hw = r;
            encode = GUSBCFG_indicator_enum;
            reset = 0x0;
        } indicator[24:24];

        enum GUSBCFG_complement_enum {
            PHY_DOES_NOT = 0 { name = "Phy Does Not"; desc = "The PHY does not invert the ExternalVbusIndicator signal."; };
            PHY_INVERTS_EXTERNALVBUSINDICA = 1 { name = "Phy Inverts Externalvbusindica"; desc = "The PHY inverts the ExternalVbusIndicator signal."; };
        };

        field {
            name = "complement";
            desc = "Indicator complement";
            sw = rw;
            hw = r;
            encode = GUSBCFG_complement_enum;
            reset = 0x0;
        } complement[23:23];

        enum GUSBCFG_termseldlpulse_enum {
            UTMI_TXVALID_DRIVES = 0 { name = "Utmi Txvalid Drives"; desc = "utmi_txvalid drives the line pulse."; };
            UTMI_TERMSEL_DRIVES = 1 { name = "Utmi Termsel Drives"; desc = "utmi_termsel drives the line pulse."; };
        };

        field {
            name = "termseldlpulse";
            desc = "SRP line pulse drive";
            sw = rw;
            hw = r;
            encode = GUSBCFG_termseldlpulse_enum;
            reset = 0x0;
        } termseldlpulse[22:22];

        enum GUSBCFG_ulpiextvbusindicator_enum {
            PHY_USES_INTERNAL = 0 { name = "Phy Uses Internal"; desc = "The PHY uses the internal vbusvalid comparator."; };
            PHY_USES_EXTERNAL = 1 { name = "Phy Uses External"; desc = "The PHY uses the external vbusvalid comparator. This bit is valid only when OTG_HSPHY_INTERFACE is 2 or 3."; };
        };

        field {
            name = "ulpiextvbusindicator";
            desc = "ULPI external VBUS over-current indicator";
            sw = rw;
            hw = r;
            encode = GUSBCFG_ulpiextvbusindicator_enum;
            reset = 0x0;
        } ulpiextvbusindicator[21:21];

        enum GUSBCFG_ulpiextvbusdrv_enum {
            PHY_USES_INTERNAL = 0 { name = "Phy Uses Internal"; desc = "The PHY uses the internal charge pump to drive VBUS."; };
            PHY_USES_EXTERNAL = 1 { name = "Phy Uses External"; desc = "The PHY uses the external power supply to drive VBUS."; };
        };

        field {
            name = "ulpiextvbusdrv";
            desc = "ULPI external VBUS drive";
            sw = rw;
            hw = r;
            encode = GUSBCFG_ulpiextvbusdrv_enum;
            reset = 0x0;
        } ulpiextvbusdrv[20:20];

        enum GUSBCFG_ulpiclksusm_enum {
            PHY_DISABLES_INTERNAL = 0 { name = "Phy Disables Internal"; desc = "The PHY disables the internal clock in suspend mode."; };
            PHY_DOES_NOT = 1 { name = "Phy Does Not"; desc = "The PHY does not disable the internal clock in suspend mode. This bit is valid only when OTG_HSPHY_INTERFACE is 2 or 3."; };
        };

        field {
            name = "ulpiclksusm";
            desc = "ULPI clock suspend";
            sw = rw;
            hw = r;
            encode = GUSBCFG_ulpiclksusm_enum;
            reset = 0x0;
        } ulpiclksusm[19:19];

        enum GUSBCFG_ulpiautores_enum {
            PHY_DOES_NOT = 0 { name = "Phy Does Not"; desc = "The PHY does not use the automatic restore feature."; };
            PHY_USES_AUTOMATIC = 1 { name = "Phy Uses Automatic"; desc = "The PHY uses the automatic restore feature."; };
        };

        field {
            name = "ulpiautores";
            desc = "ULPI automatic restore";
            sw = rw;
            hw = r;
            encode = GUSBCFG_ulpiautores_enum;
            reset = 0x0;
        } ulpiautores[18:18];

        enum GUSBCFG_ulpifsls_enum {
            ULPI_INTERFACE = 0 { name = "Ulpi Interface"; desc = "ULPI interface"; };
            ULPI_FS_LS = 1 { name = "Ulpi Fs Ls"; desc = "ULPI FS/LS serial interface"; };
        };

        field {
            name = "ulpifsls";
            desc = "ULPI FS/LS select";
            sw = rw;
            hw = r;
            encode = GUSBCFG_ulpifsls_enum;
            reset = 0x0;
        } ulpifsls[17:17];

        enum GUSBCFG_otgi2csel_enum {
            UTMI_USB_1 = 0 { name = "Utmi Usb 1"; desc = "UTMI USB 1.1 full-speed interface"; };
            I_2_C = 1 { name = "I2C"; desc = "I2C interface"; };
        };

        field {
            name = "otgi2csel";
            desc = "UTMI or I2C interface select";
            sw = rw;
            hw = r;
            encode = GUSBCFG_otgi2csel_enum;
            reset = 0x0;
        } otgi2csel[16:16];

        enum GUSBCFG_phylpwrclksel_enum {
            INTERNAL_480_MHZ = 0 { name = "Internal 480 Mhz"; desc = "internal 480 MHz PLL clock"; };
            EXTERNAL_48_MHZ = 1 { name = "External 48 Mhz"; desc = "external 48 MHz clock"; };
        };

        field {
            name = "phylpwrclksel";
            desc = "PHY low-power clock select";
            sw = rw;
            hw = r;
            encode = GUSBCFG_phylpwrclksel_enum;
            reset = 0x0;
        } phylpwrclksel[15:15];

        enum GUSBCFG_usbtrdtim_enum {
            THIS_FIELD_SET = 5 { name = "This Field Set"; desc = "This field is set to this value when the MAC interface is a 16-bit UTMI+ interface."; };
            THIS_FIELD_SET_2 = 9 { name = "This Field Set 2"; desc = "This field is set to this value when the MAC interface is an 8-bit UTMI+ interface. Other values: reserved"; };
        };

        field {
            name = "usbtrdtim";
            desc = "USB turnaround time";
            sw = rw;
            hw = r;
            encode = GUSBCFG_usbtrdtim_enum;
            reset = 0x5;
        } usbtrdtim[13:10];

        enum GUSBCFG_hnpcap_enum {
            DISABLED = 0 { name = "Disabled"; desc = "disabled"; };
            ENABLED = 1 { name = "Enabled"; desc = "enabled"; };
        };

        field {
            name = "hnpcap";
            desc = "HNP enable";
            sw = rw;
            hw = r;
            encode = GUSBCFG_hnpcap_enum;
            reset = 0x0;
        } hnpcap[9:9];

        enum GUSBCFG_srpcap_enum {
            DISABLED = 0 { name = "Disabled"; desc = "disabled"; };
            ENABLED = 1 { name = "Enabled"; desc = "enabled"; };
        };

        field {
            name = "srpcap";
            desc = "SRP enable";
            sw = rw;
            hw = r;
            encode = GUSBCFG_srpcap_enum;
            reset = 0x0;
        } srpcap[8:8];

        enum GUSBCFG_ddrsel_enum {
            SINGLE_RATE_ULPI = 0 { name = "Single Rate Ulpi"; desc = "single-rate ULPI interface"; };
            DOUBLE_RATE_ULPI = 1 { name = "Double Rate Ulpi"; desc = "double-rate ULPI interface This bit is valid only when OTG_HSPHY_INTERFACE is 2 or 3."; };
        };

        field {
            name = "ddrsel";
            desc = "ULPI DDR select";
            sw = rw;
            hw = r;
            encode = GUSBCFG_ddrsel_enum;
            reset = 0x0;
        } ddrsel[7:7];

        enum GUSBCFG_physel_enum {
            USB_2_0 = 0 { name = "Usb 2 0"; desc = "USB 2.0 high-speed UTMI+ or ULPI PHY interface"; };
            USB_1_1 = 1 { name = "Usb 1 1"; desc = "USB 1.1 full-speed serial transceiver If the USB 1.1 full-speed serial transceiver is not selected, this bit is always 0 and read-only. If the USB 2.0 high-speed PHY is not selected, this bit is always 1 and read-only. If the preceding interface types are not selected (non-zero value), this bit is used to select the interface to be activated, and this bit can be read or written."; };
        };

        field {
            name = "physel";
            desc = "USB 2.0 high-speed PHY or USB 1.1 full-speed serial transceiver";
            sw = rw;
            hw = r;
            encode = GUSBCFG_physel_enum;
            reset = 0x0;
        } physel[6:6];

        enum GUSBCFG_fsintf_enum {
            V_6_PIN_UNIDIRECTIONAL = 0 { name = "V 6 Pin Unidirectional"; desc = "6-pin unidirectional full-speed serial interface"; };
            V_3_PIN_BIDIRECTIONAL = 1 { name = "V 3 Pin Bidirectional"; desc = "3-pin bidirectional full-speed serial interface If the USB 1.1 full-speed serial transceiver is not selected, this bit is always 0 and write-only. If the USB 1.1 full-speed interface is selected, this bit can be used to select the 3-pin or 6-pin interface and can be read or written."; };
        };

        field {
            name = "fsintf";
            desc = "Full-speed serial interface select";
            sw = rw;
            hw = r;
            encode = GUSBCFG_fsintf_enum;
            reset = 0x0;
        } fsintf[5:5];

        enum GUSBCFG_ulpi_utmi_sel_enum {
            UTMI_INTERFACE = 0 { name = "Utmi Interface"; desc = "UTMI+ interface"; };
            ULPI_INTERFACE = 1 { name = "Ulpi Interface"; desc = "ULPI interface"; };
        };

        field {
            name = "ulpi_utmi_sel";
            desc = "ULPI or UTMI select";
            sw = rw;
            hw = r;
            encode = GUSBCFG_ulpi_utmi_sel_enum;
            reset = 0x0;
        } ulpi_utmi_sel[4:4];

        enum GUSBCFG_phyif_enum {
            V_8_BITS = 0 { name = "V 8 Bits"; desc = "8 bits"; };
            V_16_BITS = 1 { name = "V 16 Bits"; desc = "16 bits"; };
        };

        field {
            name = "phyif";
            desc = "PHY interface";
            sw = rw;
            hw = r;
            encode = GUSBCFG_phyif_enum;
            reset = 0x0;
        } phyif[3:3];

        field {
            name = "toutcal";
            desc = "HS/FS timeout calibration High-speed operations: One 30-MHz PHY clock = 16 bit times One 60-MHz PHY clock = 8 bit times Full speed operation: One 30-MHz PHY clock = 0.4 bit times One 60-MHz PHY clock = 0.2 bit times One 48-MHz PHY clock = 0.25 bit times";
            sw = rw;
            hw = r;
            reset = 0x0;
        } toutcal[2:0];
    } GUSBCFG @ 0xC;

    reg {
        name = "Reset hardware feature register";
        desc = "GRSTCTL is a reset hardware feature register.

The data sheet table for this register is garbled (access words broken across lines, rxfflsh and frmcntrrst printed as RO, the descriptions of txfflsh, rxfflsh, intknqflsh and frmcntrrst shifted by one row, csftrst without text). The fields are rebuilt from the data sheet text and the DWC_otg databook: the four flush/reset bits are set by software and cleared by hardware (`R_WS_SC`).

Data sheet 12.7.5.2 GRSTCTL (offset 0x10, printed page 12-175, `Hi3518EV20X-Hi3516CV200-Datasheet.txt` line 86865).";

        enum GRSTCTL_ahbidle_enum {
            NO = 0 { name = "No"; desc = "no"; };
            YES = 1 { name = "Yes"; desc = "yes"; };
        };

        field {
            name = "ahbidle";
            desc = "Whether the AHB master state machine is idle";
            sw = r;
            hw = w;
            encode = GRSTCTL_ahbidle_enum;
            reset = 0x1;
        } ahbidle[31:31];

        enum GRSTCTL_dmareq_enum {
            OTHER_CASES = 0 { name = "Other Cases"; desc = "other cases"; };
            DMA_REQUEST_BEING = 1 { name = "Dma Request Being"; desc = "The DMA request is being processed."; };
        };

        field {
            name = "dmareq";
            desc = "DMA request signal, indicating that the DMA request is being processed. This bit is only for debugging.";
            sw = r;
            hw = w;
            encode = GRSTCTL_dmareq_enum;
            reset = 0x0;
        } dmareq[30:30];

        enum GRSTCTL_txfnum_enum {
            HOST_MODE_NON = 0x0 { name = "Host Mode Non"; desc = "In host mode, non-periodic TX FIFOs are flushed. During shared FIFO operations, non-periodic TX FIFOs are flushed in device mode. In dedicated FIFO mode, TX FIFO 0 is flushed in device mode."; };
            HOST_MODE_PERIODIC = 0x1 { name = "Host Mode Periodic"; desc = "In host mode, periodic TX FIFOs are flushed. During shared FIFO operations, periodic TX FIFO 1 is flushed in device mode. In dedicated FIFO mode, TX FIFO 1 is flushed in device mode."; };
            DURING_SHARED_FIFO = 0x2 { name = "During Shared Fifo"; desc = "During shared FIFO operations, periodic TX FIFO 2 is flushed in device mode. In dedicated FIFO mode, TX FIFO 2 is flushed in device mode."; };
            DURING_SHARED_FIFO_2 = 0xF { name = "During Shared Fifo 2"; desc = "During shared FIFO operations, periodic TX FIFO 15 is flushed in device mode. In dedicated FIFO mode, TX FIFO 15 is flushed in device mode."; };
            ALL_TX_FIFOS = 0x10 { name = "All Tx Fifos"; desc = "All TX FIFOs are flushed in device or host mode."; };
        };

        field {
            name = "txfnum";
            desc = "TX FIFO ID, which must be updated by using the TX FIFO flush bit. This field cannot be overwritten before the controller core clears the TX FIFO flush bit.";
            sw = rw;
            hw = r;
            encode = GRSTCTL_txfnum_enum;
            reset = 0x0;
        } txfnum[10:6];

        enum GRSTCTL_txfflsh_enum {
            NOT_FLUSHED = 0 { name = "Not Flushed"; desc = "not flushed"; };
            FLUSHED = 1 { name = "Flushed"; desc = "flushed"; };
        };

        field {
            name = "txfflsh";
            desc = "TX FIFO flush. This bit can be used to flush one or all TX FIFOs (selected by txfnum); the FIFOs cannot be flushed during transactions. This bit can be written only after the application program confirms that the controller core does not read or write the FIFO. It takes eight clock cycles to clear this bit, during which the application program must wait.";
            sw = rw;
            hw = w;
            encode = GRSTCTL_txfflsh_enum;
            reset = 0x0;
        } txfflsh[5:5];

        enum GRSTCTL_rxfflsh_enum {
            NOT_FLUSHED = 0 { name = "Not Flushed"; desc = "not flushed"; };
            FLUSHED = 1 { name = "Flushed"; desc = "flushed"; };
        };

        field {
            name = "rxfflsh";
            desc = "RX FIFO flush. This bit flushes all RX FIFOs; the FIFOs cannot be flushed during transactions. This bit can be written only after the application program confirms that the controller core does not read or write the FIFO. It takes eight clock cycles to clear this bit, during which the application program must wait.";
            sw = rw;
            hw = w;
            encode = GRSTCTL_rxfflsh_enum;
            reset = 0x0;
        } rxfflsh[4:4];

        enum GRSTCTL_intknqflsh_enum {
            NOT_FLUSHED = 0 { name = "Not Flushed"; desc = "not flushed"; };
            FLUSHED = 1 { name = "Flushed"; desc = "flushed"; };
        };

        field {
            name = "intknqflsh";
            desc = "In token sequence learning queue flush. This bit is valid only when OTG_EN_DED_TX_FIFO is 0.";
            sw = rw;
            hw = w;
            encode = GRSTCTL_intknqflsh_enum;
            reset = 0x0;
        } intknqflsh[3:3];

        enum GRSTCTL_frmcntrrst_enum {
            NOT_RESET = 0 { name = "Not Reset"; desc = "not reset"; };
            RESET_F = 1 { name = "Reset F"; desc = "reset"; };
        };

        field {
            name = "frmcntrrst";
            desc = "Host frame counter reset. This bit is used to reset the frame number counter. When the frame number counter is reset, the ID of the next transmitted SOF micro-frame is 0.";
            sw = rw;
            hw = w;
            encode = GRSTCTL_frmcntrrst_enum;
            reset = 0x0;
        } frmcntrrst[2:2];

        field {
            name = "csftrst";
            desc = "Core soft reset. All interrupts and CSR registers are cleared except the bits kept by the controller (PCGCCTL[rstpdwnmodule], PCGCCTL[gatehclk], PCGCCTL[pwrclmp], PCGCCTL[stoppphylpwrclkselclk], GUSBCFG[phylpwrclksel, ddrsel, physel, fsintf, ulpi_utmi_sel, phyif, txenddelay, termseldlpulse, ulpiclksusm, ulpiautores, ulpifsls], GGPIO, GPWRDN, GADPCTL). The bit clears itself when the reset is done; software must wait for it (and GRSTCTL[ahbidle]) before using the core.";
            sw = rw;
            hw = w;
            reset = 0x0;
        } csftrst[0:0];
    } GRSTCTL @ 0x10;

    reg {
        name = "System interrupt register";
        desc = "GINTSTS is a system interrupt register.

Bits that the data sheet marks RWSC are modelled write-1-to-clear (`wc`): hardware sets them, software clears them by writing 1. The `lpm_int` bit (bit 27) has reset 1 and `goutnakeff` (bit 7) has reset 1 per the data sheet's Total Reset Value 0x08000080. The data sheet text of `iepint` refers to DOEPINTn (should be DIEPINTn).

Data sheet 12.7.5.2 GINTSTS (offset 0x14, printed page 12-178, `Hi3518EV20X-Hi3516CV200-Datasheet.txt` line 87006).";

        field {
            name = "wkupint";
            desc = "Suspend/Resume detection interrupt. Setting this bit to 1 clears the interrupt.";
            sw = rw;
            hw = w;
            onwrite = woclr;
            reset = 0x0;
        } wkupint[31:31];

        field {
            name = "sessreqint";
            desc = "In host mode, an interrupt is generated when a device session request is detected. In device mode, an interrupt is generated when utmisrp_bvalid is 1. Setting this bit to 1 clears the interrupt.";
            sw = rw;
            hw = w;
            onwrite = woclr;
            reset = 0x0;
        } sessreqint[30:30];

        field {
            name = "disconnint";
            desc = "An interrupt is generated when the system detects that the device is disconnected. Setting this bit to 1 clears the interrupt.";
            sw = rw;
            hw = w;
            onwrite = woclr;
            reset = 0x0;
        } disconnint[29:29];

        field {
            name = "conidstschng";
            desc = "An interrupt is generated when the slot ID changes. Setting this bit to 1 clears the interrupt.";
            sw = rw;
            hw = w;
            onwrite = woclr;
            reset = 0x0;
        } conidstschng[28:28];

        field {
            name = "lpm_int";
            desc = "In device mode, an interrupt is generated when the device receives an LPM transaction and transmits a response indicating no errors. In host mode, an interrupt is generated when the device receives an LPM transaction and transmits a response indicating no errors, or when the host core completes the preset LPM transactions.";
            sw = rw;
            hw = w;
            onwrite = woclr;
            reset = 0x1;
        } lpm_int[27:27];

        field {
            name = "ptxfemp";
            desc = "Periodic TX FIFO empty interrupt An interrupt is generated when the periodic TX FIFO is empty or half empty.";
            sw = r;
            hw = w;
            reset = 0x0;
        } ptxfemp[26:26];

        field {
            name = "hchint";
            desc = "In host mode, an interrupt is generated in a core channel. This bit is cleared by clearing the corresponding status bit.";
            sw = r;
            hw = w;
            reset = 0x0;
        } hchint[25:25];

        field {
            name = "prtint";
            desc = "In host mode, an interrupt is generated when the status of a port of the DWC_otg core changes.";
            sw = r;
            hw = w;
            reset = 0x0;
        } prtint[24:24];

        field {
            name = "resetdet";
            desc = "In device mode, an interrupt is generated when the device is suspended and the system detects that the USB module is reset in power-down module. In host mode, this interrupt is not generated.";
            sw = rw;
            hw = w;
            onwrite = woclr;
            reset = 0x0;
        } resetdet[23:23];

        field {
            name = "fetsusp";
            desc = "This interrupt is valid only in DMA mode. This interrupt indicates that the core stops obtaining data from IN endpoints.";
            sw = rw;
            hw = w;
            onwrite = woclr;
            reset = 0x0;
        } fetsusp[22:22];

        field {
            name = "isochronous";
            desc = "In host mode, an interrupt is generated if there are pending transactions. In device mode, an interrupt is generated when there are isochronous OUT transfers to be completed.";
            sw = rw;
            hw = w;
            onwrite = woclr;
            reset = 0x0;
        } isochronous[21:21];

        field {
            name = "incompisoin";
            desc = "An interrupt is generated when there are isochronous IN transfers to be completed. In scatter/gather DMA mode, this interrupt is not generated.";
            sw = rw;
            hw = w;
            onwrite = woclr;
            reset = 0x0;
        } incompisoin[20:20];

        field {
            name = "oepint";
            desc = "In device mode, an interrupt is generated on an OUT endpoint. This interrupt is cleared by clearing the corresponding status bit in the DOEPINTn register.";
            sw = r;
            hw = w;
            reset = 0x0;
        } oepint[19:19];

        field {
            name = "iepint";
            desc = "In device mode, an interrupt is generated on an IN endpoint. This interrupt is cleared by clearing the corresponding status bit in the DIEPINTn register (the data sheet says DOEPINTn, a copy error).";
            sw = r;
            hw = w;
            reset = 0x0;
        } iepint[18:18];

        field {
            name = "epmis";
            desc = "An interrupt is generated when endpoints mismatch. This bit is valid only during shared FIFO operations.";
            sw = r;
            hw = w;
            reset = 0x0;
        } epmis[17:17];

        field {
            name = "rstrdoneint";
            desc = "An interrupt is caused by the restore command after hibernation.";
            sw = rw;
            hw = w;
            onwrite = woclr;
            reset = 0x0;
        } rstrdoneint[16:16];

        field {
            name = "eopf";
            desc = "Periodic frame end interrupt Setting this bit to 1 clears the interrupt.";
            sw = rw;
            hw = w;
            onwrite = woclr;
            reset = 0x0;
        } eopf[15:15];

        field {
            name = "isooutdrop";
            desc = "Isochronous OUT packet drop interrupt";
            sw = rw;
            hw = w;
            onwrite = woclr;
            reset = 0x0;
        } isooutdrop[14:14];

        field {
            name = "enumdone";
            desc = "Speed enumeration completion interrupt";
            sw = rw;
            hw = w;
            onwrite = woclr;
            reset = 0x0;
        } enumdone[13:13];

        field {
            name = "usbrst";
            desc = "USB reset detection interrupt";
            sw = rw;
            hw = w;
            onwrite = woclr;
            reset = 0x0;
        } usbrst[12:12];

        field {
            name = "usbsusp";
            desc = "USB suspend detection interrupt";
            sw = rw;
            hw = w;
            onwrite = woclr;
            reset = 0x0;
        } usbsusp[11:11];

        field {
            name = "erlysusp";
            desc = "USB idle 3 ms detection interrupt";
            sw = rw;
            hw = w;
            onwrite = woclr;
            reset = 0x0;
        } erlysusp[10:10];

        field {
            name = "i2cint";
            desc = "An interrupt is generated when I2C access through the I2C interface is complete. This bit is enabled only when OTG_I2C_INTERFACE is 1.";
            sw = rw;
            hw = w;
            onwrite = woclr;
            reset = 0x0;
        } i2cint[9:9];

        field {
            name = "ulpickinti2cckint";
            desc = "When the ULPI Carkit interrupt is generated, the core sets the interrupt bit to 1. This bit is valid only when OTG_ULPI_CARKIT is 1; otherwise, reading this bit returns 0. When the I2C Carkit interrupt is generated, the core sets the interrupt bit to 1. This bit is valid only when OTG_I2C_INTERFACE is 1; otherwise, reading this bit returns 0.";
            sw = rw;
            hw = w;
            onwrite = woclr;
            reset = 0x0;
        } ulpickinti2cckint[8:8];

        field {
            name = "goutnakeff";
            desc = "The global OUT NAK bit in the device control register is set. This interrupt is cleared by clearing the global OUT NAK bit.";
            sw = r;
            hw = w;
            reset = 0x1;
        } goutnakeff[7:7];

        field {
            name = "ginnakeff";
            desc = "An interrupt is generated when the global non-periodic IN NAK is set in the device control register.";
            sw = r;
            hw = w;
            reset = 0x0;
        } ginnakeff[6:6];

        field {
            name = "nptxfemp";
            desc = "An interrupt is generated when the non-periodic TX FIFO is empty or half empty.";
            sw = r;
            hw = w;
            reset = 0x0;
        } nptxfemp[5:5];

        field {
            name = "rxflvl";
            desc = "There is at least a pending packet to be read by the RX FIFO.";
            sw = r;
            hw = w;
            reset = 0x0;
        } rxflvl[4:4];

        field {
            name = "sof";
            desc = "In host mode, an SOF, micro-SOF, or keep-active is being transmitted. In device mode, an SOF token is received by the USB module.";
            sw = rw;
            hw = w;
            onwrite = woclr;
            reset = 0x0;
        } sof[3:3];

        field {
            name = "otgint";
            desc = "An OTG even is in progress. This interrupt is cleared by clearing the corresponding bit in the GOTGINT register.";
            sw = r;
            hw = w;
            reset = 0x0;
        } otgint[2:2];

        field {
            name = "modemis";
            desc = "Mode mismatch interrupt When the core works in device mode, a register in host mode needs to be accessed. When the core works in host mode, a register in device mode needs to be accessed.";
            sw = rw;
            hw = w;
            onwrite = woclr;
            reset = 0x0;
        } modemis[1:1];

        enum GINTSTS_curmod_enum {
            DEVICE_MODE = 0 { name = "Device Mode"; desc = "device mode"; };
            HOST_MODE = 1 { name = "Host Mode"; desc = "host mode"; };
        };

        field {
            name = "curmod";
            desc = "Current operating mode";
            sw = r;
            hw = w;
            encode = GINTSTS_curmod_enum;
            reset = 0x0;
        } curmod[0:0];
    } GINTSTS @ 0x14;

    reg {
        name = "System interrupt mask register";
        desc = "GINTMSK is a system interrupt mask register.

Data sheet 12.7.5.2 GINTMSK (offset 0x18, printed page 12-181, `Hi3518EV20X-Hi3516CV200-Datasheet.txt` line 87206).";

        enum GINTMSK_wkupintmsk_enum {
            MASKED = 0 { name = "Masked"; desc = "masked"; };
            NOT_MASKED = 1 { name = "Not Masked"; desc = "not masked"; };
        };

        field {
            name = "wkupintmsk";
            desc = "Resume/Remote wakeup detection interrupt mask";
            sw = rw;
            hw = r;
            encode = GINTMSK_wkupintmsk_enum;
            reset = 0x0;
        } wkupintmsk[31:31];

        enum GINTMSK_sessreqintmsk_enum {
            MASKED = 0 { name = "Masked"; desc = "masked"; };
            NOT_MASKED = 1 { name = "Not Masked"; desc = "not masked"; };
        };

        field {
            name = "sessreqintmsk";
            desc = "Session request/new session detection interrupt mask";
            sw = rw;
            hw = r;
            encode = GINTMSK_sessreqintmsk_enum;
            reset = 0x0;
        } sessreqintmsk[30:30];

        enum GINTMSK_disconnintmsk_enum {
            MASKED = 0 { name = "Masked"; desc = "masked"; };
            NOT_MASKED = 1 { name = "Not Masked"; desc = "not masked"; };
        };

        field {
            name = "disconnintmsk";
            desc = "Disconnect detection interrupt mask";
            sw = rw;
            hw = r;
            encode = GINTMSK_disconnintmsk_enum;
            reset = 0x0;
        } disconnintmsk[29:29];

        enum GINTMSK_conidstschngmsk_enum {
            MASKED = 0 { name = "Masked"; desc = "masked"; };
            NOT_MASKED = 1 { name = "Not Masked"; desc = "not masked"; };
        };

        field {
            name = "conidstschngmsk";
            desc = "Connector ID status change interrupt mask";
            sw = rw;
            hw = r;
            encode = GINTMSK_conidstschngmsk_enum;
            reset = 0x0;
        } conidstschngmsk[28:28];

        enum GINTMSK_lpm_intmsk_enum {
            MASKED = 0 { name = "Masked"; desc = "masked"; };
            NOT_MASKED = 1 { name = "Not Masked"; desc = "not masked"; };
        };

        field {
            name = "lpm_intmsk";
            desc = "LPM transaction RX interrupt mask";
            sw = rw;
            hw = r;
            encode = GINTMSK_lpm_intmsk_enum;
            reset = 0x0;
        } lpm_intmsk[27:27];

        enum GINTMSK_ptxfempmsk_enum {
            MASKED = 0 { name = "Masked"; desc = "masked"; };
            NOT_MASKED = 1 { name = "Not Masked"; desc = "not masked"; };
        };

        field {
            name = "ptxfempmsk";
            desc = "Periodic TX FIFO empty interrupt mask";
            sw = rw;
            hw = r;
            encode = GINTMSK_ptxfempmsk_enum;
            reset = 0x0;
        } ptxfempmsk[26:26];

        enum GINTMSK_hchintmsk_enum {
            MASKED = 0 { name = "Masked"; desc = "masked"; };
            NOT_MASKED = 1 { name = "Not Masked"; desc = "not masked"; };
        };

        field {
            name = "hchintmsk";
            desc = "Host channel interrupt mask";
            sw = rw;
            hw = r;
            encode = GINTMSK_hchintmsk_enum;
            reset = 0x0;
        } hchintmsk[25:25];

        enum GINTMSK_prtintmsk_enum {
            MASKED = 0 { name = "Masked"; desc = "masked"; };
            NOT_MASKED = 1 { name = "Not Masked"; desc = "not masked"; };
        };

        field {
            name = "prtintmsk";
            desc = "Host port interrupt mask";
            sw = rw;
            hw = r;
            encode = GINTMSK_prtintmsk_enum;
            reset = 0x0;
        } prtintmsk[24:24];

        enum GINTMSK_resetdetmsk_enum {
            MASKED = 0 { name = "Masked"; desc = "masked"; };
            NOT_MASKED = 1 { name = "Not Masked"; desc = "not masked"; };
        };

        field {
            name = "resetdetmsk";
            desc = "Reset detection interrupt mask";
            sw = rw;
            hw = r;
            encode = GINTMSK_resetdetmsk_enum;
            reset = 0x0;
        } resetdetmsk[23:23];

        enum GINTMSK_fetsuspmsk_enum {
            MASKED = 0 { name = "Masked"; desc = "masked"; };
            NOT_MASKED = 1 { name = "Not Masked"; desc = "not masked"; };
        };

        field {
            name = "fetsuspmsk";
            desc = "Data fetch suspended interrupt mask";
            sw = rw;
            hw = r;
            encode = GINTMSK_fetsuspmsk_enum;
            reset = 0x0;
        } fetsuspmsk[22:22];

        field {
            name = "pisooutmsk";
            desc = "Incomplete periodic transfer interrupt mask 0: masked 1: not masked Incomplete isochronous OUT transfer interrupt mask 0: masked 1: not masked";
            sw = rw;
            hw = r;
            reset = 0x0;
        } pisooutmsk[21:21];

        enum GINTMSK_incompisoinmsk_enum {
            MASKED = 0 { name = "Masked"; desc = "masked"; };
            NOT_MASKED_THIS = 1 { name = "Not Masked This"; desc = "not masked This bit can be enabled only when periodic endpoints are enabled in dedicated TX FIFO mode."; };
        };

        field {
            name = "incompisoinmsk";
            desc = "Incomplete isochronous in transfer interrupt mask";
            sw = rw;
            hw = r;
            encode = GINTMSK_incompisoinmsk_enum;
            reset = 0x0;
        } incompisoinmsk[20:20];

        enum GINTMSK_oepintmsk_enum {
            MASKED = 0 { name = "Masked"; desc = "masked"; };
            NOT_MASKED = 1 { name = "Not Masked"; desc = "not masked"; };
        };

        field {
            name = "oepintmsk";
            desc = "OUT endpoint interrupt mask";
            sw = rw;
            hw = r;
            encode = GINTMSK_oepintmsk_enum;
            reset = 0x0;
        } oepintmsk[19:19];

        enum GINTMSK_iepintmsk_enum {
            MASKED = 0 { name = "Masked"; desc = "masked"; };
            NOT_MASKED = 1 { name = "Not Masked"; desc = "not masked"; };
        };

        field {
            name = "iepintmsk";
            desc = "IN endpoint interrupt mask";
            sw = rw;
            hw = r;
            encode = GINTMSK_iepintmsk_enum;
            reset = 0x0;
        } iepintmsk[18:18];

        enum GINTMSK_epmismsk_enum {
            MASKED = 0 { name = "Masked"; desc = "masked"; };
            NOT_MASKED = 1 { name = "Not Masked"; desc = "not masked"; };
        };

        field {
            name = "epmismsk";
            desc = "Endpoint mismatch interrupt mask";
            sw = rw;
            hw = r;
            encode = GINTMSK_epmismsk_enum;
            reset = 0x0;
        } epmismsk[17:17];

        enum GINTMSK_rstrdoneintmsk_enum {
            MASKED = 0 { name = "Masked"; desc = "masked"; };
            NOT_MASKED_THIS = 1 { name = "Not Masked This"; desc = "not masked This bit is valid only when the hibernation function is enabled (OTG_EN_PWROPT = 2)."; };
        };

        field {
            name = "rstrdoneintmsk";
            desc = "Restore done interrupt mask";
            sw = rw;
            hw = r;
            encode = GINTMSK_rstrdoneintmsk_enum;
            reset = 0x0;
        } rstrdoneintmsk[16:16];

        enum GINTMSK_eopfmsk_enum {
            MASKED = 0 { name = "Masked"; desc = "masked"; };
            NOT_MASKED = 1 { name = "Not Masked"; desc = "not masked"; };
        };

        field {
            name = "eopfmsk";
            desc = "End of periodic frame interrupt mask";
            sw = rw;
            hw = r;
            encode = GINTMSK_eopfmsk_enum;
            reset = 0x0;
        } eopfmsk[15:15];

        enum GINTMSK_isooutdropmsk_enum {
            MASKED = 0 { name = "Masked"; desc = "masked"; };
            NOT_MASKED = 1 { name = "Not Masked"; desc = "not masked"; };
        };

        field {
            name = "isooutdropmsk";
            desc = "Device only isochronous OUT packet drop interrupt mask";
            sw = rw;
            hw = r;
            encode = GINTMSK_isooutdropmsk_enum;
            reset = 0x0;
        } isooutdropmsk[14:14];

        enum GINTMSK_enumdonemsk_enum {
            MASKED = 0 { name = "Masked"; desc = "masked"; };
            NOT_MASKED = 1 { name = "Not Masked"; desc = "not masked"; };
        };

        field {
            name = "enumdonemsk";
            desc = "Enumeration done interrupt mask";
            sw = rw;
            hw = r;
            encode = GINTMSK_enumdonemsk_enum;
            reset = 0x0;
        } enumdonemsk[13:13];

        enum GINTMSK_usbrstmsk_enum {
            MASKED = 0 { name = "Masked"; desc = "masked"; };
            NOT_MASKED = 1 { name = "Not Masked"; desc = "not masked"; };
        };

        field {
            name = "usbrstmsk";
            desc = "USB reset interrupt mask";
            sw = rw;
            hw = r;
            encode = GINTMSK_usbrstmsk_enum;
            reset = 0x0;
        } usbrstmsk[12:12];

        enum GINTMSK_usbsuspmsk_enum {
            MASKED = 0 { name = "Masked"; desc = "masked"; };
            NOT_MASKED = 1 { name = "Not Masked"; desc = "not masked"; };
        };

        field {
            name = "usbsuspmsk";
            desc = "USB suspend interrupt mask";
            sw = rw;
            hw = r;
            encode = GINTMSK_usbsuspmsk_enum;
            reset = 0x0;
        } usbsuspmsk[11:11];

        enum GINTMSK_erlysuspmsk_enum {
            MASKED = 0 { name = "Masked"; desc = "masked"; };
            NOT_MASKED = 1 { name = "Not Masked"; desc = "not masked"; };
        };

        field {
            name = "erlysuspmsk";
            desc = "Early suspend interrupt mask";
            sw = rw;
            hw = r;
            encode = GINTMSK_erlysuspmsk_enum;
            reset = 0x0;
        } erlysuspmsk[10:10];

        enum GINTMSK_i2cintmsk_enum {
            MASKED = 0 { name = "Masked"; desc = "masked"; };
            NOT_MASKED = 1 { name = "Not Masked"; desc = "not masked"; };
        };

        field {
            name = "i2cintmsk";
            desc = "I2C interrupt mask";
            sw = rw;
            hw = r;
            encode = GINTMSK_i2cintmsk_enum;
            reset = 0x0;
        } i2cintmsk[9:9];

        field {
            name = "ulpickintmsk";
            desc = "ULPI Carkit interrupt mask 0: masked 1: not masked I2C Carkit interrupt mask 0: masked 1: not masked";
            sw = rw;
            hw = r;
            reset = 0x0;
        } ulpickintmsk[8:8];

        enum GINTMSK_goutnakeffmsk_enum {
            MASKED = 0 { name = "Masked"; desc = "masked"; };
            NOT_MASKED = 1 { name = "Not Masked"; desc = "not masked"; };
        };

        field {
            name = "goutnakeffmsk";
            desc = "Global OUT NAK effective interrupt mask";
            sw = rw;
            hw = r;
            encode = GINTMSK_goutnakeffmsk_enum;
            reset = 0x0;
        } goutnakeffmsk[7:7];

        enum GINTMSK_ginnakeffmsk_enum {
            MASKED = 0 { name = "Masked"; desc = "masked"; };
            NOT_MASKED = 1 { name = "Not Masked"; desc = "not masked"; };
        };

        field {
            name = "ginnakeffmsk";
            desc = "Global non-periodic IN NAK effective interrupt mask";
            sw = rw;
            hw = r;
            encode = GINTMSK_ginnakeffmsk_enum;
            reset = 0x0;
        } ginnakeffmsk[6:6];

        enum GINTMSK_nptxfempmsk_enum {
            MASKED = 0 { name = "Masked"; desc = "masked"; };
            NOT_MASKED = 1 { name = "Not Masked"; desc = "not masked"; };
        };

        field {
            name = "nptxfempmsk";
            desc = "Non-periodic TX FIFO empty interrupt mask";
            sw = rw;
            hw = r;
            encode = GINTMSK_nptxfempmsk_enum;
            reset = 0x0;
        } nptxfempmsk[5:5];

        enum GINTMSK_rxflvlmsk_enum {
            MASKED = 0 { name = "Masked"; desc = "masked"; };
            NOT_MASKED = 1 { name = "Not Masked"; desc = "not masked"; };
        };

        field {
            name = "rxflvlmsk";
            desc = "RX FIFO non-empty interrupt mask";
            sw = rw;
            hw = r;
            encode = GINTMSK_rxflvlmsk_enum;
            reset = 0x0;
        } rxflvlmsk[4:4];

        enum GINTMSK_sofmsk_enum {
            MASKED = 0 { name = "Masked"; desc = "masked"; };
            NOT_MASKED = 1 { name = "Not Masked"; desc = "not masked"; };
        };

        field {
            name = "sofmsk";
            desc = "Start of (micro) frame interrupt mask";
            sw = rw;
            hw = r;
            encode = GINTMSK_sofmsk_enum;
            reset = 0x0;
        } sofmsk[3:3];

        enum GINTMSK_otgintmsk_enum {
            MASKED = 0 { name = "Masked"; desc = "masked"; };
            NOT_MASKED = 1 { name = "Not Masked"; desc = "not masked"; };
        };

        field {
            name = "otgintmsk";
            desc = "Device interrupt mask";
            sw = rw;
            hw = r;
            encode = GINTMSK_otgintmsk_enum;
            reset = 0x0;
        } otgintmsk[2:2];

        enum GINTMSK_modemismsk_enum {
            MASKED = 0 { name = "Masked"; desc = "masked"; };
            NOT_MASKED = 1 { name = "Not Masked"; desc = "not masked"; };
        };

        field {
            name = "modemismsk";
            desc = "Mode mismatch interrupt mask";
            sw = rw;
            hw = r;
            encode = GINTMSK_modemismsk_enum;
            reset = 0x0;
        } modemismsk[1:1];
    } GINTMSK @ 0x18;

    reg {
        name = "RX status debug read register";
        desc = "GRXSTSR is an RX status debugging read register.

Data sheet 12.7.5.2 GRXSTSR (offset 0x1C, printed page 12-184, `Hi3518EV20X-Hi3516CV200-Datasheet.txt` line 87369).";

        field {
            name = "fn_devicemode";
            desc = "Number of frames";
            sw = r;
            hw = w;
            reset = 0x0;
        } fn_devicemode[24:21];

        enum GRXSTSR_pktsts_devicemode_enum {
            GLOBAL_OUT_NAK = 1 { name = "Global Out Nak"; desc = "global OUT NAK (interrupt triggered)"; };
            DATA_PACKET_RECEIVED = 2 { name = "Data Packet Received"; desc = "IN data packet received"; };
            TRANSFER_COMPLETION = 3 { name = "Transfer Completion"; desc = "IN transfer completion (interrupt triggered)"; };
            DATA_TOGGLE_ERROR = 5 { name = "Data Toggle Error"; desc = "data toggle error (interrupt triggered)"; };
            CHANNEL_STOP_OTHER = 7 { name = "Channel Stop Other"; desc = "channel stop (interrupt triggered) Other values: reserved"; };
        };

        field {
            name = "pktsts_devicemode";
            desc = "Data packet status";
            sw = r;
            hw = w;
            encode = GRXSTSR_pktsts_devicemode_enum;
            reset = 0x0;
        } pktsts_devicemode[20:17];

        enum GRXSTSR_dpid_devicemode_enum {
            DATA0 = 0 { name = "Data0"; desc = "DATA0"; };
            DATA1 = 2 { name = "Data1"; desc = "DATA1"; };
            DATA2 = 1 { name = "Data2"; desc = "DATA2"; };
            MDATA = 3 { name = "Mdata"; desc = "MDATA"; };
        };

        field {
            name = "dpid_devicemode";
            desc = "Data PID of the received packet";
            sw = r;
            hw = w;
            encode = GRXSTSR_dpid_devicemode_enum;
            reset = 0x0;
        } dpid_devicemode[16:15];

        field {
            name = "bcnt_devicemodechnum_devicemod";
            desc = "Byte size of the received IN data packets";
            sw = r;
            hw = w;
            reset = 0x0;
        } bcnt_devicemodechnum_devicemod[14:4];

        field {
            name = "chnum_devicemode";
            desc = "Number of channels from which the current data packets are received";
            sw = r;
            hw = w;
            reset = 0x0;
        } chnum_devicemode[3:0];
    } GRXSTSR @ 0x1C;

    reg {
        name = "RX status read&pop register";
        desc = "GRXSTSP is an RX status read&pop register.

Data sheet 12.7.5.2 GRXSTSP (offset 0x20, printed page 12-185, `Hi3518EV20X-Hi3516CV200-Datasheet.txt` line 87425).";

        field {
            name = "fn_devicemode";
            desc = "Number of frames";
            sw = r;
            hw = w;
            reset = 0x0;
        } fn_devicemode[24:21];

        enum GRXSTSP_pktsts_devicemode_enum {
            GLOBAL_OUT_NAK = 1 { name = "Global Out Nak"; desc = "global OUT NAK (interrupt triggered)"; };
            DATA_PACKET_RECEIVED = 2 { name = "Data Packet Received"; desc = "IN data packet received"; };
            TRANSFER_COMPLETION = 3 { name = "Transfer Completion"; desc = "IN transfer completion (interrupt triggered)"; };
            DATA_TOGGLE_ERROR = 5 { name = "Data Toggle Error"; desc = "data toggle error (interrupt triggered)"; };
            CHANNEL_STOP_OTHER = 7 { name = "Channel Stop Other"; desc = "channel stop (interrupt triggered) Other values: reserved"; };
        };

        field {
            name = "pktsts_devicemode";
            desc = "Data packet status";
            sw = r;
            hw = w;
            encode = GRXSTSP_pktsts_devicemode_enum;
            reset = 0x0;
        } pktsts_devicemode[20:17];

        enum GRXSTSP_dpid_devicemode_enum {
            DATA0 = 0 { name = "Data0"; desc = "DATA0"; };
            DATA1 = 2 { name = "Data1"; desc = "DATA1"; };
            DATA2 = 1 { name = "Data2"; desc = "DATA2"; };
            MDATA = 3 { name = "Mdata"; desc = "MDATA"; };
        };

        field {
            name = "dpid_devicemode";
            desc = "Data PID of the received packet";
            sw = r;
            hw = w;
            encode = GRXSTSP_dpid_devicemode_enum;
            reset = 0x0;
        } dpid_devicemode[16:15];

        field {
            name = "bcnt_devicemodechnum_devicemod";
            desc = "Byte size of the received IN data packets";
            sw = r;
            hw = w;
            reset = 0x0;
        } bcnt_devicemodechnum_devicemod[14:4];

        field {
            name = "chnum_devicemode";
            desc = "Number of channels from which the current data packets are received";
            sw = r;
            hw = w;
            reset = 0x0;
        } chnum_devicemode[3:0];
    } GRXSTSP @ 0x20;

    reg {
        name = "RX FIFO size configuration register";
        desc = "GRXFSIZ is an RX FIFO size configuration register.

Data sheet 12.7.5.2 GRXFSIZ (offset 0x24, printed page 12-186, `Hi3518EV20X-Hi3516CV200-Datasheet.txt` line 87481).";

        field {
            name = "rxfdep";
            desc = "RX FIFO depth. Its value range is 16-32768.";
            sw = rw;
            hw = r;
            reset = 0x211;
        } rxfdep[15:0];
    } GRXFSIZ @ 0x24;

    reg {
        name = "Non-periodic TX FIFO size configuration register";
        desc = "GNPTXFSIZ is a non-periodic TX FIFO size configuration register.

Data sheet 12.7.5.2 GNPTXFSIZ (offset 0x28, printed page 12-187, `Hi3518EV20X-Hi3516CV200-Datasheet.txt` line 87510).";

        field {
            name = "ineptxf0dep";
            desc = "Depth of IN endpoint TX FIFO 0. Its value range is 16-32768.";
            sw = rw;
            hw = r;
            reset = 0x100;
        } ineptxf0dep[31:16];

        field {
            name = "ineptxf0staddr";
            desc = "Start address for the TX RAM of IN endpoint FIFO 0";
            sw = rw;
            hw = r;
            reset = 0x211;
        } ineptxf0staddr[15:0];
    } GNPTXFSIZ @ 0x28;

    reg {
        name = "Non-periodic TX FIFO and non-periodic TX request query register";
        desc = "GNPTXSTS is a non-periodic TX FIFO and non-periodic TX request query register.

Data sheet 12.7.5.2 GNPTXSTS (offset 0x2C, printed page 12-187, `Hi3518EV20X-Hi3516CV200-Datasheet.txt` line 87529).";

        field {
            name = "nptxqtop";
            desc = "Non-periodic TX request queue top Bit[30:27]: number of channels or endpoints bit[26:25]: 00: IN/OUT token 01: zero-length transmit packet (device IN/host OUT) 10: PING/CSPLIT token 11: channel stop command Bit[24]: stop (the selected channel or endpoint is used for attempting)";
            sw = r;
            hw = w;
            reset = 0x0;
        } nptxqtop[30:24];

        enum GNPTXSTS_nptxqspcavail_enum {
            NON_PERIODIC_TX = 0x0 { name = "Non Periodic Tx"; desc = "The non-periodic TX request queue is full."; };
            ONE_ADDRESS_AVAILABLE = 0x1 { name = "One Address Available"; desc = "One address is available."; };
            TWO_ADDRESSES_AVAILABLE = 0x2 { name = "Two Addresses Available"; desc = "Two addresses are available. 0xn: n addresses (0 <= n <= 8) are available. Other values: reserved"; };
        };

        field {
            name = "nptxqspcavail";
            desc = "Available space for the non-periodic TX request queue";
            sw = r;
            hw = w;
            encode = GNPTXSTS_nptxqspcavail_enum;
            reset = 0x8;
        } nptxqspcavail[23:16];

        enum GNPTXSTS_nptxfspcavail_enum {
            NON_PERIODIC_TX = 0x0 { name = "Non Periodic Tx"; desc = "The non-periodic TX FIFO is full."; };
            ONE_WORD_AVAILABLE = 0x1 { name = "One Word Available"; desc = "One word is available."; };
            TWO_WORDS_AVAILABLE = 0x2 { name = "Two Words Available"; desc = "Two words are available. 0xn: n words (0 <= n <= 32768) are available."; };
            V_32768_WORDS_AVAILABLE = 0x8000 { name = "V 32768 Words Available"; desc = "32768 words are available. Other values: reserved"; };
        };

        field {
            name = "nptxfspcavail";
            desc = "Total available space for the non-periodic TX request queue";
            sw = r;
            hw = w;
            encode = GNPTXSTS_nptxfspcavail_enum;
            reset = 0x100;
        } nptxfspcavail[15:0];
    } GNPTXSTS @ 0x2C;

    reg {
        name = "I2C access register";
        desc = "GI2CCTL is an I2C access register.

Data sheet 12.7.5.2 GI2CCTL (offset 0x30, printed page 12-188, `Hi3518EV20X-Hi3516CV200-Datasheet.txt` line 87584).";

        enum GI2CCTL_bsydne_enum {
            DONE = 0 { name = "Done"; desc = "done"; };
            BUSY = 1 { name = "Busy"; desc = "busy"; };
        };

        field {
            name = "bsydne";
            desc = "I2C busy/done";
            sw = rw;
            hw = w;
            encode = GI2CCTL_bsydne_enum;
            reset = 0x0;
        } bsydne[31:31];

        enum GI2CCTL_rw_f_enum {
            WRITE = 0 { name = "Write"; desc = "write"; };
            READ = 1 { name = "Read"; desc = "read"; };
        };

        field {
            name = "rw";
            desc = "Read/Write indicator";
            sw = rw;
            hw = r;
            encode = GI2CCTL_rw_f_enum;
            reset = 0x0;
        } rw_f[30:30];

        enum GI2CCTL_i2cdatse0_enum {
            VP_VM_USB = 0 { name = "Vp Vm Usb"; desc = "VP_VM USB mode"; };
            DAT_SE0_USB = 1 { name = "Dat Se0 Usb"; desc = "DAT_SE0 USB mode"; };
        };

        field {
            name = "i2cdatse0";
            desc = "USB mode of the FS interface";
            sw = rw;
            hw = r;
            encode = GI2CCTL_i2cdatse0_enum;
            reset = 0x0;
        } i2cdatse0[28:28];

        enum GI2CCTL_i2cdevadr_enum {
            V_7_H2C = 0 { name = "V 7 H2C"; desc = "7'h2C"; };
            V_7_H2D = 1 { name = "V 7 H2D"; desc = "7'h2D"; };
            V_7_H2E = 2 { name = "V 7 H2E"; desc = "7'h2E"; };
            V_7_H2F = 3 { name = "V 7 H2F"; desc = "7'h2F"; };
        };

        field {
            name = "i2cdevadr";
            desc = "I2C device address";
            sw = rw;
            hw = r;
            encode = GI2CCTL_i2cdevadr_enum;
            reset = 0x0;
        } i2cdevadr[27:26];

        enum GI2CCTL_i2csuspctl_enum {
            UTMI_SUSPEND_N = 0 { name = "Utmi Suspend N"; desc = "utmi_suspend_n is used."; };
            SUSPEND_BIT_PHY = 1 { name = "Suspend Bit Phy"; desc = "The suspend bit in the PHY register is edited by using the I2C write function."; };
        };

        field {
            name = "i2csuspctl";
            desc = "I2C suspend control";
            sw = rw;
            hw = r;
            encode = GI2CCTL_i2csuspctl_enum;
            reset = 0x0;
        } i2csuspctl[25:25];

        enum GI2CCTL_ack_enum {
            NAK = 0 { name = "Nak"; desc = "NAK"; };
            ACK = 1 { name = "Ack"; desc = "ACK"; };
        };

        field {
            name = "ack";
            desc = "I2C ACK";
            sw = r;
            hw = w;
            encode = GI2CCTL_ack_enum;
            reset = 0x0;
        } ack[24:24];

        enum GI2CCTL_i2cen_enum {
            DISABLED = 0 { name = "Disabled"; desc = "disabled"; };
            ENABLED = 1 { name = "Enabled"; desc = "enabled"; };
        };

        field {
            name = "i2cen";
            desc = "I2C transaction enable";
            sw = rw;
            hw = r;
            encode = GI2CCTL_i2cen_enum;
            reset = 0x0;
        } i2cen[23:23];

        field {
            name = "addr";
            desc = "I2C slave address";
            sw = rw;
            hw = r;
            reset = 0x0;
        } addr[22:16];

        field {
            name = "regaddr";
            desc = "I2C register address";
            sw = rw;
            hw = r;
            reset = 0x0;
        } regaddr[15:8];

        field {
            name = "rwdata";
            desc = "I2C read//write data";
            sw = rw;
            hw = r;
            reset = 0x0;
        } rwdata[7:0];
    } GI2CCTL @ 0x30;

    reg {
        name = "PHY vendor control register";
        desc = "GPVNDCTL is a PHY vendor control register.

Data sheet 12.7.5.2 GPVNDCTL (offset 0x34, printed page 12-189, `Hi3518EV20X-Hi3516CV200-Datasheet.txt` line 87646).";

        enum GPVNDCTL_disulpidrvr_enum {
            ENABLED = 0 { name = "Enabled"; desc = "enabled"; };
            DISABLED = 1 { name = "Disabled"; desc = "disabled"; };
        };

        field {
            name = "disulpidrvr";
            desc = "ULPI interface enable";
            sw = rw;
            hw = w;
            encode = GPVNDCTL_disulpidrvr_enum;
            reset = 0x0;
        } disulpidrvr[31:31];

        enum GPVNDCTL_vstsdone_enum {
            NEW_REGISTER_REQUEST = 0 { name = "New Register Request"; desc = "The new register request is set."; };
            VENDOR_CONTROL_ACCESS = 1 { name = "Vendor Control Access"; desc = "Vendor control access ends."; };
        };

        field {
            name = "vstsdone";
            desc = "Vendor control access (done)";
            sw = rw;
            hw = w;
            encode = GPVNDCTL_vstsdone_enum;
            reset = 0x0;
        } vstsdone[27:27];

        enum GPVNDCTL_vstsbsy_enum {
            VENDOR_CONTROL_ACCESS = 0 { name = "Vendor Control Access"; desc = "Vendor control access ends."; };
            VENDOR_CONTROL_ACCESS_2 = 1 { name = "Vendor Control Access 2"; desc = "Vendor control access is in progress."; };
        };

        field {
            name = "vstsbsy";
            desc = "Vendor control access (busy)";
            sw = r;
            hw = w;
            encode = GPVNDCTL_vstsbsy_enum;
            reset = 0x0;
        } vstsbsy[26:26];

        enum GPVNDCTL_newregreq_enum {
            NO_ACCESS_REQUEST = 0 { name = "No Access Request"; desc = "no access request"; };
            NEW_VENDOR_CONTROL = 1 { name = "New Vendor Control"; desc = "new vendor control access request"; };
        };

        field {
            name = "newregreq";
            desc = "New vendor control access";
            sw = rw;
            hw = w;
            encode = GPVNDCTL_newregreq_enum;
            reset = 0x0;
        } newregreq[25:25];

        enum GPVNDCTL_regwr_enum {
            READ = 0 { name = "Read"; desc = "read"; };
            WRITE = 1 { name = "Write"; desc = "write"; };
        };

        field {
            name = "regwr";
            desc = "Register read/write";
            sw = rw;
            hw = r;
            encode = GPVNDCTL_regwr_enum;
            reset = 0x0;
        } regwr[22:22];

        field {
            name = "regaddr";
            desc = "Register access address";
            sw = rw;
            hw = r;
            reset = 0x0;
        } regaddr[21:16];

        field {
            name = "vctrlextregaddr";
            desc = "Address for the UTMI+ vendor control register bit[15:12]: 4-bit parallel output bus addressing bit[11:8]: utmi_vcontrol[3:0]";
            sw = rw;
            hw = r;
            reset = 0x0;
        } vctrlextregaddr[15:8];

        field {
            name = "regdata";
            desc = "Register data This bit is valid after the Vstatus Done bit is set.";
            sw = rw;
            hw = r;
            reset = 0x0;
        } regdata[7:0];
    } GPVNDCTL @ 0x34;

    reg {
        name = "GPIO register";
        desc = "GGPIO is a GPIO register.

Data sheet 12.7.5.2 GGPIO (offset 0x38, printed page 12-190, `Hi3518EV20X-Hi3516CV200-Datasheet.txt` line 87709).";

        field {
            name = "gpo";
            desc = "General-purpose output, which is driven by gp_o[15:0] of the core";
            sw = rw;
            hw = r;
            reset = 0x0;
        } gpo[31:16];

        field {
            name = "gpi";
            desc = "General-purpose input, which reflects gp_i[15:0] of the core";
            sw = rw;
            hw = r;
            reset = 0x0;
        } gpi[15:0];
    } GGPIO @ 0x38;

    reg {
        name = "User ID query register";
        desc = "GUID is a user ID register.

Data sheet 12.7.5.2 GUID (offset 0x3C, printed page 12-191, `Hi3518EV20X-Hi3516CV200-Datasheet.txt` line 87739).";

        field {
            name = "userid";
            desc = "User ID";
            sw = rw;
            hw = r;
            reset = 0x0;
        } userid[31:0];
    } GUID @ 0x3C;

    reg {
        name = "Synopsys ID query register";
        desc = "GSNPSID is a Synopsys ID query register.

Data sheet 12.7.5.2 GSNPSID (offset 0x40, printed page 12-191, `Hi3518EV20X-Hi3516CV200-Datasheet.txt` line 87757).";

        field {
            name = "synopsysid";
            desc = "ID of the current DWC_otg core";
            sw = rw;
            hw = r;
            reset = 0x4F54300A;
        } synopsysid[31:0];
    } GSNPSID @ 0x40;

    reg {
        name = "User hardware configuration register 1";
        desc = "GHWCFG1 is user hardware configuration register 1.

Data sheet 12.7.5.2 GHWCFG1 (offset 0x44, printed page 12-191, `Hi3518EV20X-Hi3516CV200-Datasheet.txt` line 87776).";

        field {
            name = "epdir";
            desc = "Endpoint direction The endpoint direction is expressed by two bits. Endpoint bit[31:30]: direction of endpoint 15 bit[29:28]: direction of endpoint 14 ...";
            sw = r;
            hw = w;
            reset = 0x0;
        } epdir[31:0];
    } GHWCFG1 @ 0x44;

    reg {
        name = "User hardware configuration register 2";
        desc = "GHWCFG2 is user hardware configuration register 2.

Data sheet 12.7.5.2 GHWCFG2 (offset 0x48, printed page 12-192, `Hi3518EV20X-Hi3516CV200-Datasheet.txt` line 87816).";

        enum GHWCFG2_otg_enable_ic_usb_enum {
            DISABLED = 0 { name = "Disabled"; desc = "disabled"; };
            ENABLED = 1 { name = "Enabled"; desc = "enabled"; };
        };

        field {
            name = "otg_enable_ic_usb";
            desc = "IC_USB select enable";
            sw = r;
            hw = w;
            encode = GHWCFG2_otg_enable_ic_usb_enum;
            reset = 0x0;
        } otg_enable_ic_usb[31:31];

        field {
            name = "tknqdepth";
            desc = "Depth of the IN token sequence learning queue in device mode The value range is 0-30.";
            sw = r;
            hw = w;
            reset = 0x8;
        } tknqdepth[30:26];

        enum GHWCFG2_ptxqdepth_enum {
            V_2 = 0 { name = "V 2"; desc = "2"; };
            V_4 = 1 { name = "V 4"; desc = "4"; };
            V_8 = 2 { name = "V 8"; desc = "8"; };
            V_16 = 3 { name = "V 16"; desc = "16"; };
        };

        field {
            name = "ptxqdepth";
            desc = "Depth of the periodic request queue in host mode";
            sw = r;
            hw = w;
            encode = GHWCFG2_ptxqdepth_enum;
            reset = 0x2;
        } ptxqdepth[25:24];

        enum GHWCFG2_nptxqdepth_enum {
            V_2 = 0 { name = "V 2"; desc = "2"; };
            V_4 = 1 { name = "V 4"; desc = "4"; };
            V_8_OTHER_VALUES = 2 { name = "V 8 Other Values"; desc = "8 Other values: reserved"; };
        };

        field {
            name = "nptxqdepth";
            desc = "Depth of the non-periodic request queue";
            sw = r;
            hw = w;
            encode = GHWCFG2_nptxqdepth_enum;
            reset = 0x2;
        } nptxqdepth[23:22];

        enum GHWCFG2_multiprocintrpt_enum {
            DISABLED = 0 { name = "Disabled"; desc = "disabled"; };
            ENABLED = 1 { name = "Enabled"; desc = "enabled"; };
        };

        field {
            name = "multiprocintrpt";
            desc = "Multi-processor interrupt enable";
            sw = rw;
            hw = r;
            encode = GHWCFG2_multiprocintrpt_enum;
            reset = 0x0;
        } multiprocintrpt[20:20];

        enum GHWCFG2_dynfifosizing_enum {
            DISABLED = 0 { name = "Disabled"; desc = "disabled"; };
            ENABLED = 1 { name = "Enabled"; desc = "enabled"; };
        };

        field {
            name = "dynfifosizing";
            desc = "FIFO size dynamic change enable";
            sw = r;
            hw = w;
            encode = GHWCFG2_dynfifosizing_enum;
            reset = 0x0;
        } dynfifosizing[19:19];

        enum GHWCFG2_periosupport_enum {
            NOT_SUPPORTED = 0 { name = "Not Supported"; desc = "not supported"; };
            SUPPORTED = 1 { name = "Supported"; desc = "supported"; };
        };

        field {
            name = "periosupport";
            desc = "Periodic OUT channel support in host mode";
            sw = r;
            hw = w;
            encode = GHWCFG2_periosupport_enum;
            reset = 0x1;
        } periosupport[18:18];

        field {
            name = "numhstchnl";
            desc = "Number of host channels 0-15: The value 0 indicates one channel, and the value 15 indicates 16 channels.";
            sw = r;
            hw = w;
            reset = 0x3;
        } numhstchnl[17:14];

        field {
            name = "numdeveps";
            desc = "Number of device endpoints (excluding endpoint 0) The value range is 1-15.";
            sw = r;
            hw = w;
            reset = 0x2;
        } numdeveps[13:10];

        enum GHWCFG2_fsphytype_enum {
            FULL_SPEED_INTERFACE = 0 { name = "Full Speed Interface"; desc = "The full-speed interface is not supported."; };
            FULL_SPEED_INTERFACE_2 = 1 { name = "Full Speed Interface 2"; desc = "The full-speed interface is supported."; };
            FS_PINS_SHARE = 2 { name = "Fs Pins Share"; desc = "FS pins share with UTMI+ pins."; };
            FS_PINS_SHARE_2 = 3 { name = "Fs Pins Share 2"; desc = "FS pins share with ULPI pins."; };
        };

        field {
            name = "fsphytype";
            desc = "Type of the full-speed PHY interface";
            sw = r;
            hw = w;
            encode = GHWCFG2_fsphytype_enum;
            reset = 0x0;
        } fsphytype[9:8];

        enum GHWCFG2_hsphytype_enum {
            HIGH_SPEED_INTERFACE = 0 { name = "High Speed Interface"; desc = "high-speed interface not supported"; };
            UTMI = 1 { name = "Utmi"; desc = "UTMI+"; };
            ULPI = 2 { name = "Ulpi"; desc = "ULPI"; };
            UTMI_ULPI = 3 { name = "Utmi Ulpi"; desc = "UTMI+ and ULPI"; };
        };

        field {
            name = "hsphytype";
            desc = "Type of the high-speed PHY interface";
            sw = r;
            hw = w;
            encode = GHWCFG2_hsphytype_enum;
            reset = 0x1;
        } hsphytype[7:6];

        enum GHWCFG2_singpnt_enum {
            MULTI_POINT_APPLICATION = 0 { name = "Multi Point Application"; desc = "multi-point application (hub and split supported)"; };
            SINGLE_POINT_APPLICATION = 1 { name = "Single Point Application"; desc = "single-point application (hub and split not supported)"; };
        };

        field {
            name = "singpnt";
            desc = "Point-to-point";
            sw = r;
            hw = w;
            encode = GHWCFG2_singpnt_enum;
            reset = 0x0;
        } singpnt[5:5];

        enum GHWCFG2_otgarch_enum {
            SLAVE_ONLY = 0 { name = "Slave Only"; desc = "slave only"; };
            EXTERNAL_DMA = 1 { name = "External Dma"; desc = "external DMA"; };
            INTERNAL_DMA_OTHER = 2 { name = "Internal Dma Other"; desc = "internal DMA Other values: reserved"; };
        };

        field {
            name = "otgarch";
            desc = "Device architecture";
            sw = r;
            hw = w;
            encode = GHWCFG2_otgarch_enum;
            reset = 0x2;
        } otgarch[4:3];

        enum GHWCFG2_otgmode_enum {
            HNP_SRP_CAPABLE = 0 { name = "Hnp Srp Capable"; desc = "HNP- and SRP-capable OTG (host & device)"; };
            SRP_CAPABLE_OTG = 1 { name = "Srp Capable Otg"; desc = "SRP-capable OTG (host & device)"; };
            NON_HNP_NON = 2 { name = "Non Hnp Non"; desc = "non-HNP and non-SRP capable OTG (host & device)"; };
            SRP_CAPABLE_DEVICE = 3 { name = "Srp Capable Device"; desc = "SRP-capable device"; };
            NON_OTG_DEVICE = 4 { name = "Non Otg Device"; desc = "non-OTG device"; };
            SRP_CAPABLE_HOST = 5 { name = "Srp Capable Host"; desc = "SRP-Capable host"; };
            NON_OTG_HOST = 6 { name = "Non Otg Host"; desc = "non-OTG host Other values: reserved"; };
        };

        field {
            name = "otgmode";
            desc = "Operating mode";
            sw = r;
            hw = w;
            encode = GHWCFG2_otgmode_enum;
            reset = 0x0;
        } otgmode[2:0];
    } GHWCFG2 @ 0x48;

    reg {
        name = "User hardware configuration register 3";
        desc = "GHWCFG3 is user hardware configuration register 3.

Data sheet 12.7.5.2 GHWCFG3 (offset 0x4C, printed page 12-194, `Hi3518EV20X-Hi3516CV200-Datasheet.txt` line 87922).";

        field {
            name = "dfifodepth";
            desc = "DFIFO depth. The value range is 32-32768.";
            sw = r;
            hw = w;
            reset = 0x501;
        } dfifodepth[31:16];

        field {
            name = "lpmmode";
            desc = "LPM working mode (configurable)";
            sw = r;
            hw = w;
            reset = 0x0;
        } lpmmode[15:15];

        enum GHWCFG3_bcsupport_enum {
            NOT_SUPPORTED = 0 { name = "Not Supported"; desc = "not supported"; };
            SUPPORTED = 1 { name = "Supported"; desc = "supported"; };
        };

        field {
            name = "bcsupport";
            desc = "Whether the HS device controller supports the battery charger";
            sw = r;
            hw = w;
            encode = GHWCFG3_bcsupport_enum;
            reset = 0x1;
        } bcsupport[14:14];

        enum GHWCFG3_hsicmode_enum {
            HSIC_CAPABLE_SHARES = 0 { name = "Hsic Capable Shares"; desc = "The HSIC-capable shares with the UTMI PHY interface"; };
            HSIC_MODE_NOT = 1 { name = "Hsic Mode Not"; desc = "The HSIC mode is not selected."; };
        };

        field {
            name = "hsicmode";
            desc = "HSIC mode select";
            sw = r;
            hw = w;
            encode = GHWCFG3_hsicmode_enum;
            reset = 0x0;
        } hsicmode[13:13];

        enum GHWCFG3_adpsupport_enum {
            NO = 0 { name = "No"; desc = "no"; };
            YES = 1 { name = "Yes"; desc = "yes"; };
        };

        field {
            name = "adpsupport";
            desc = "Whether the device controller has an ADP logic";
            sw = r;
            hw = w;
            encode = GHWCFG3_adpsupport_enum;
            reset = 0x1;
        } adpsupport[12:12];

        enum GHWCFG3_rsttype_enum {
            ASYNCHRONOUS_RESET = 0 { name = "Asynchronous Reset"; desc = "asynchronous reset"; };
            SYNCHRONOUS_RESET = 1 { name = "Synchronous Reset"; desc = "synchronous reset"; };
        };

        field {
            name = "rsttype";
            desc = "Reset mode of clock always blocks";
            sw = r;
            hw = w;
            encode = GHWCFG3_rsttype_enum;
            reset = 0x0;
        } rsttype[11:11];

        enum GHWCFG3_optfeature_enum {
            NOT_REMOVED = 0 { name = "Not Removed"; desc = "not removed"; };
            REMOVED = 1 { name = "Removed"; desc = "removed"; };
        };

        field {
            name = "optfeature";
            desc = "Feature removal Features include the user ID register, GPIO interface ports, and SOF toggle and counter ports.";
            sw = r;
            hw = w;
            encode = GHWCFG3_optfeature_enum;
            reset = 0x1;
        } optfeature[10:10];

        enum GHWCFG3_vndctlsupt_enum {
            NOT_SUPPORTED = 0 { name = "Not Supported"; desc = "not supported"; };
            SUPPORTED = 1 { name = "Supported"; desc = "supported"; };
        };

        field {
            name = "vndctlsupt";
            desc = "Vendor control interface support";
            sw = r;
            hw = w;
            encode = GHWCFG3_vndctlsupt_enum;
            reset = 0x0;
        } vndctlsupt[9:9];

        enum GHWCFG3_i2cintsel_enum {
            NOT_SELECTED = 0 { name = "Not Selected"; desc = "not selected"; };
            SELECTED = 1 { name = "Selected"; desc = "selected"; };
        };

        field {
            name = "i2cintsel";
            desc = "I2C interface select";
            sw = r;
            hw = w;
            encode = GHWCFG3_i2cintsel_enum;
            reset = 0x0;
        } i2cintsel[8:8];

        enum GHWCFG3_otgen_enum {
            DISABLED = 0 { name = "Disabled"; desc = "disabled"; };
            ENABLED = 1 { name = "Enabled"; desc = "enabled"; };
        };

        field {
            name = "otgen";
            desc = "Device function enable";
            sw = r;
            hw = w;
            encode = GHWCFG3_otgen_enum;
            reset = 0x1;
        } otgen[7:7];

        enum GHWCFG3_pktsizewidth_enum {
            V_4_BITS = 0 { name = "V 4 Bits"; desc = "4 bits"; };
            V_5_BITS = 1 { name = "V 5 Bits"; desc = "5 bits"; };
            V_6_BITS = 2 { name = "V 6 Bits"; desc = "6 bits"; };
            V_7_BITS = 3 { name = "V 7 Bits"; desc = "7 bits"; };
            V_8_BITS = 4 { name = "V 8 Bits"; desc = "8 bits"; };
            V_9_BITS = 5 { name = "V 9 Bits"; desc = "9 bits"; };
            V_10_BITS_OTHER = 6 { name = "V 10 Bits Other"; desc = "10 bits Other values: reserved"; };
        };

        field {
            name = "pktsizewidth";
            desc = "Data packet width";
            sw = r;
            hw = w;
            encode = GHWCFG3_pktsizewidth_enum;
            reset = 0x6;
        } pktsizewidth[6:4];

        enum GHWCFG3_xfersizewidth_enum {
            V_11_BITS = 0 { name = "V 11 Bits"; desc = "11 bits"; };
            V_12_BITS = 1 { name = "V 12 Bits"; desc = "12 bits"; };
            V_19_BITS_OTHER = 8 { name = "V 19 Bits Other"; desc = "19 bits Other values: reserved"; };
        };

        field {
            name = "xfersizewidth";
            desc = "Transfer width";
            sw = r;
            hw = w;
            encode = GHWCFG3_xfersizewidth_enum;
            reset = 0x8;
        } xfersizewidth[3:0];
    } GHWCFG3 @ 0x4C;

    reg {
        name = "User hardware configuration register 4";
        desc = "GHWCFG4 is user hardware configuration register 4.

Data sheet 12.7.5.2 GHWCFG4 (offset 0x50, printed page 12-196, `Hi3518EV20X-Hi3516CV200-Datasheet.txt` line 88008).";

        enum GHWCFG4_descdma_enum {
            NO_DYNAMIC_CONFIGURATION = 0 { name = "No Dynamic Configuration"; desc = "no dynamic configuration"; };
            DYNAMIC_CONFIGURATION = 1 { name = "Dynamic Configuration"; desc = "dynamic configuration"; };
        };

        field {
            name = "descdma";
            desc = "Scatter/Gather DMA";
            sw = r;
            hw = w;
            encode = GHWCFG4_descdma_enum;
            reset = 0x0;
        } descdma[31:31];

        enum GHWCFG4_descdmaen_enum {
            FAST = 0 { name = "Fast"; desc = "fast"; };
            SLOW = 1 { name = "Slow"; desc = "slow"; };
        };

        field {
            name = "descdmaen";
            desc = "PAD slew rate";
            sw = r;
            hw = w;
            encode = GHWCFG4_descdmaen_enum;
            reset = 0x1;
        } descdmaen[30:30];

        enum GHWCFG4_ineps_enum {
            ONE_ENDPOINT = 0 { name = "One Endpoint"; desc = "one IN endpoint"; };
            TWO_ENDPOINTS = 1 { name = "Two Endpoints"; desc = "two IN endpoints ..."; };
            V_16_ENDPOINTS = 15 { name = "V 16 Endpoints"; desc = "16 IN endpoints"; };
        };

        field {
            name = "ineps";
            desc = "Number of IN endpoints in device mode";
            sw = r;
            hw = w;
            encode = GHWCFG4_ineps_enum;
            reset = 0x1;
        } ineps[29:26];

        enum GHWCFG4_dedfifomode_enum {
            DISABLED = 0 { name = "Disabled"; desc = "disabled"; };
            ENABLED = 1 { name = "Enabled"; desc = "enabled"; };
        };

        field {
            name = "dedfifomode";
            desc = "Dedicated TX FIFO enable for device IN endpoints";
            sw = r;
            hw = w;
            encode = GHWCFG4_dedfifomode_enum;
            reset = 0x1;
        } dedfifomode[25:25];

        enum GHWCFG4_sessendfltr_enum {
            DISABLED = 0 { name = "Disabled"; desc = "disabled"; };
            ENABLED = 1 { name = "Enabled"; desc = "enabled"; };
        };

        field {
            name = "sessendfltr";
            desc = "session_end filter enable";
            sw = r;
            hw = w;
            encode = GHWCFG4_sessendfltr_enum;
            reset = 0x0;
        } sessendfltr[24:24];

        enum GHWCFG4_bvalidfltr_enum {
            DISABLED = 0 { name = "Disabled"; desc = "disabled"; };
            ENABLED = 1 { name = "Enabled"; desc = "enabled"; };
        };

        field {
            name = "bvalidfltr";
            desc = "b_valid filter enable";
            sw = r;
            hw = w;
            encode = GHWCFG4_bvalidfltr_enum;
            reset = 0x0;
        } bvalidfltr[23:23];

        enum GHWCFG4_avalidfltr_enum {
            DISABLED = 0 { name = "Disabled"; desc = "disabled"; };
            ENABLED = 1 { name = "Enabled"; desc = "enabled"; };
        };

        field {
            name = "avalidfltr";
            desc = "a_valid filter enable";
            sw = r;
            hw = w;
            encode = GHWCFG4_avalidfltr_enum;
            reset = 0x0;
        } avalidfltr[22:22];

        enum GHWCFG4_vbusvalidfltr_enum {
            DISABLED = 0 { name = "Disabled"; desc = "disabled"; };
            ENABLED = 1 { name = "Enabled"; desc = "enabled"; };
        };

        field {
            name = "vbusvalidfltr";
            desc = "VBUS valid filter enable";
            sw = r;
            hw = w;
            encode = GHWCFG4_vbusvalidfltr_enum;
            reset = 0x0;
        } vbusvalidfltr[21:21];

        enum GHWCFG4_iddgfltr_enum {
            DISABLED = 0 { name = "Disabled"; desc = "disabled"; };
            ENABLED = 1 { name = "Enabled"; desc = "enabled"; };
        };

        field {
            name = "iddgfltr";
            desc = "IDDIG filter enable";
            sw = r;
            hw = w;
            encode = GHWCFG4_iddgfltr_enum;
            reset = 0x0;
        } iddgfltr[20:20];

        field {
            name = "numctleps";
            desc = "Number of controlled endpoints excluding endpoint 0 in device mode The value range is 0-15.";
            sw = r;
            hw = w;
            reset = 0x0;
        } numctleps[19:16];

        enum GHWCFG4_phydatawidth_enum {
            V_8_BITS = 0 { name = "V 8 Bits"; desc = "8 bits"; };
            V_16_BITS = 1 { name = "V 16 Bits"; desc = "16 bits"; };
            V_8_BIT_16 = 2 { name = "V 8 Bit 16"; desc = "8 bit or 16 bits, which is configured by using software Other values: reserved"; };
        };

        field {
            name = "phydatawidth";
            desc = "Data width of the UTMI+ PHY/ULPI-to-internal UTMI+ wrapper";
            sw = r;
            hw = w;
            encode = GHWCFG4_phydatawidth_enum;
            reset = 0x2;
        } phydatawidth[15:14];

        enum GHWCFG4_extndedhibernation_enum {
            DISABLED = 0 { name = "Disabled"; desc = "disabled"; };
            ENABLED = 1 { name = "Enabled"; desc = "enabled"; };
        };

        field {
            name = "extndedhibernation";
            desc = "Extended hibernation enable";
            sw = r;
            hw = w;
            encode = GHWCFG4_extndedhibernation_enum;
            reset = 0x0;
        } extndedhibernation[7:7];

        enum GHWCFG4_hibernation_enum {
            DISABLED = 0 { name = "Disabled"; desc = "disabled"; };
            ENABLED = 1 { name = "Enabled"; desc = "enabled"; };
        };

        field {
            name = "hibernation";
            desc = "Hibernation enable";
            sw = r;
            hw = w;
            encode = GHWCFG4_hibernation_enum;
            reset = 0x0;
        } hibernation[6:6];

        enum GHWCFG4_ahbfreq_enum {
            NO = 0 { name = "No"; desc = "no"; };
            YES = 1 { name = "Yes"; desc = "yes"; };
        };

        field {
            name = "ahbfreq";
            desc = "Whether the minimum AHB frequency is lower than 60 MHz";
            sw = r;
            hw = w;
            encode = GHWCFG4_ahbfreq_enum;
            reset = 0x1;
        } ahbfreq[5:5];

        enum GHWCFG4_partialpwrdn_enum {
            DISABLED = 0 { name = "Disabled"; desc = "disabled"; };
            ENABLED = 1 { name = "Enabled"; desc = "enabled"; };
        };

        field {
            name = "partialpwrdn";
            desc = "Partial power down enable";
            sw = r;
            hw = w;
            encode = GHWCFG4_partialpwrdn_enum;
            reset = 0x0;
        } partialpwrdn[4:4];

        field {
            name = "numdevperioeps";
            desc = "Number of periodic IN endpoints in device mode The value range is 0-15.";
            sw = r;
            hw = w;
            reset = 0x0;
        } numdevperioeps[3:0];
    } GHWCFG4 @ 0x50;

    reg {
        name = "LPM configuration register";
        desc = "GLPMCFG is an LPM configuration register.

Data sheet 12.7.5.2 GLPMCFG (offset 0x54, printed page 12-198, `Hi3518EV20X-Hi3516CV200-Datasheet.txt` line 88111).";

        field {
            name = "invselhsic";
            desc = "HSIC select (by using HSIC-invert) enable If if_sel_hsic is 1: InvSelHsic = 1: disabled InvSelHsic = 0: enabled If if_sel_hsic is 0: InvSelHsic = 1: enabled InvSelHsic = 0: disabled";
            sw = rw;
            hw = r;
            reset = 0x0;
        } invselhsic[31:31];

        field {
            name = "hsiccon";
            desc = "HSIC-connect Host mode: When this bit is set to 1, the bus HSIC is driven to idle status and waits for the HSIC connect sequence transmitted from the device. Device mode: When this bit is set to 1, the device waits for the HSIC idle line state on the bus. The HSIC connection starts after the idle line state occurs.";
            sw = rw;
            hw = r;
            reset = 0x0;
        } hsiccon[30:30];

        enum GLPMCFG_rstrslpsts_enum {
            CORE_ENTERS_SHALLOW = 0 { name = "Core Enters Shallow"; desc = "The core enters the shallow sleep mode."; };
            CORE_ENTERS_DEEP = 1 { name = "Core Enters Deep"; desc = "The core enters the deep sleep mode."; };
        };

        field {
            name = "rstrslpsts";
            desc = "Restore SlpSts";
            sw = rw;
            hw = r;
            encode = GLPMCFG_rstrslpsts_enum;
            reset = 0x0;
        } rstrslpsts[29:29];

        enum GLPMCFG_enbesl_enum {
            DISABLED = 0 { name = "Disabled"; desc = "disabled"; };
            ENABLED = 1 { name = "Enabled"; desc = "enabled"; };
        };

        field {
            name = "enbesl";
            desc = "Best effort service latency (BESL) enable";
            sw = rw;
            hw = r;
            encode = GLPMCFG_enbesl_enum;
            reset = 0x0;
        } enbesl[28:28];

        field {
            name = "lpm_retrycnt_sts";
            desc = "LPM retry count This field is used to count the remaining retries.";
            sw = r;
            hw = w;
            reset = 0x0;
        } lpm_retrycnt_sts[27:25];

        field {
            name = "sndlpm";
            desc = "LPM transaction TX";
            sw = rw;
            hw = w;
            reset = 0x0;
        } sndlpm[24:24];

        field {
            name = "lpm_retry_cnt";
            desc = "LPM retry count statistics When a device provides error information, this field shows the extra LPM retries of the host before the device validity signal arrives.";
            sw = rw;
            hw = r;
            reset = 0x0;
        } lpm_retry_cnt[23:21];

        field {
            name = "lpm_chnl_indx";
            desc = "LPM channel index The number of LPM transaction channels is provided. The core automatically calculates the device address and number of endpoints based on the LPM channel index.";
            sw = rw;
            hw = r;
            reset = 0x0;
        } lpm_chnl_indx[20:17];

        enum GLPMCFG_l1resumeok_enum {
            RESUMED = 0 { name = "Resumed"; desc = "resumed"; };
            NOT_RESUMED = 1 { name = "Not Resumed"; desc = "not resumed"; };
        };

        field {
            name = "l1resumeok";
            desc = "Resume from the sleep state";
            sw = r;
            hw = w;
            encode = GLPMCFG_l1resumeok_enum;
            reset = 0x0;
        } l1resumeok[16:16];

        enum GLPMCFG_slpsts_enum {
            RESUME = 0 { name = "Resume"; desc = "resume"; };
            SLEEP = 1 { name = "Sleep"; desc = "sleep"; };
        };

        field {
            name = "slpsts";
            desc = "Port sleep state";
            sw = r;
            hw = w;
            encode = GLPMCFG_slpsts_enum;
            reset = 0x0;
        } slpsts[15:15];

        enum GLPMCFG_corel1res_enum {
            ACK = 3 { name = "Ack"; desc = "ACK"; };
            NYET = 2 { name = "Nyet"; desc = "NYET"; };
            STALL = 1 { name = "Stall"; desc = "STALL"; };
            ERROR = 0 { name = "Error"; desc = "error (no handshake response)"; };
        };

        field {
            name = "corel1res";
            desc = "LPM response In device mode, this field reflects the response to the LPM transaction. In host mode, this field indicates the handshake response from the device during LPM transaction.";
            sw = r;
            hw = w;
            encode = GLPMCFG_corel1res_enum;
            reset = 0x0;
        } corel1res[14:13];

        field {
            name = "hird_thres";
            desc = "BESL or HIRD threshold";
            sw = rw;
            hw = r;
            reset = 0x0;
        } hird_thres[12:8];

        enum GLPMCFG_enblslpm_enum {
            DISABLED = 0 { name = "Disabled"; desc = "disabled"; };
            ENABLED = 1 { name = "Enabled"; desc = "enabled"; };
        };

        field {
            name = "enblslpm";
            desc = "utmi_sleep_n enable";
            sw = rw;
            hw = r;
            encode = GLPMCFG_enblslpm_enum;
            reset = 0x0;
        } enblslpm[7:7];

        field {
            name = "bremotewake";
            desc = "Remote wake enable In host mode, the enable signal is transmitted from the wIndex field of the LPM transaction. In device mode (read-only), when the ACK, NYET, or STALL response is transmitted to the LPM transaction, this bit is updated together with the received LPM token, bRemoteWake, and bmAttribute.";
            sw = rw;
            hw = r;
            reset = 0x0;
        } bremotewake[6:6];

        field {
            name = "hird";
            desc = "When EnBESL is 0: Host-initiated resume period In host mode, this field is assigned by the LPM transaction. In device mode, this field is updated by LPM token HIRD bmAttribute. Sl. No HIRD[3:0] THIRD (us) 1 4'b0000 50 2 4'b0001 125 3 4'b0010 200 4 4'b0011 275 5 4'b0100 350 6 4'b0101 425 7 4'b0110 500 8 4'b0111 575 9 4'b1000 650 10 4'b1001 725 11 4'b1010 800 12 4'b1011 875 13 4'b1100 950 14 4'b1101 1025 15 4'b1110 1100 16 4'b1111 1175 When EnBESL is 1: BESL In host mode, the BESL value is transmitted to the LPM transaction In device mode, this field is updated by LPM token BESL bmAttribute.";
            sw = rw;
            hw = r;
            reset = 0x0;
        } hird[5:2];

        enum GLPMCFG_appl1res_enum {
            NYET = 0 { name = "Nyet"; desc = "NYET"; };
            ACK = 1 { name = "Ack"; desc = "ACK"; };
        };

        field {
            name = "appl1res";
            desc = "LPM response programmed by the application (device mode)";
            sw = rw;
            hw = r;
            encode = GLPMCFG_appl1res_enum;
            reset = 0x0;
        } appl1res[1:1];

        enum GLPMCFG_lpmcap_enum {
            DISABLED = 0 { name = "Disabled"; desc = "disabled"; };
            ENABLED = 1 { name = "Enabled"; desc = "enabled"; };
        };

        field {
            name = "lpmcap";
            desc = "LPM enable";
            sw = rw;
            hw = r;
            encode = GLPMCFG_lpmcap_enum;
            reset = 0x0;
        } lpmcap[0:0];
    } GLPMCFG @ 0x54;

    reg {
        name = "Power-down register";
        desc = "GPWRDN is a power down register.

Interrupt/status bits that the data sheet marks RWSC (adpint, stschngint, srpdetect, disconnectdetect, resetdetected, lnstschng) are modelled write-1-to-clear.

Data sheet 12.7.5.2 GPWRDN (offset 0x58, printed page 12-200, `Hi3518EV20X-Hi3516CV200-Datasheet.txt` line 88251).";

        field {
            name = "multvalidbc";
            desc = "BC ACA input Bit 28 - rid_float Bit 27 - rid_gnd Bit 26 - rid_a Bit 25 - rid_b Bit 24 - rid_c";
            sw = r;
            hw = w;
            reset = 0x13;
        } multvalidbc[28:24];

        field {
            name = "adpint";
            desc = "An interrupt is generated when the ADP is in progress. Setting this bit to 1 clears this interrupt.";
            sw = rw;
            hw = w;
            onwrite = woclr;
            reset = 0x0;
        } adpint[23:23];

        enum GPWRDN_bsessvld_enum {
            B_VALID_0 = 0 { name = "B Valid 0"; desc = "B-Valid = 0"; };
            B_VALID_1 = 1 { name = "B Valid 1"; desc = "B-valid = 1"; };
        };

        field {
            name = "bsessvld";
            desc = "B session validity";
            sw = r;
            hw = w;
            encode = GPWRDN_bsessvld_enum;
            reset = 0x0;
        } bsessvld[22:22];

        enum GPWRDN_iddig_enum {
            HOST_MODE = 0 { name = "Host Mode"; desc = "host mode"; };
            DEVICE_MODE = 1 { name = "Device Mode"; desc = "device mode"; };
        };

        field {
            name = "iddig";
            desc = "IDDIG signal status indicator Current operating mode";
            sw = r;
            hw = w;
            encode = GPWRDN_iddig_enum;
            reset = 0x1;
        } iddig[21:21];

        enum GPWRDN_linestate_enum {
            DM_0_DP = 0 { name = "Dm 0 Dp"; desc = "DM = 0, DP = 0"; };
            DM_0_DP_2 = 1 { name = "Dm 0 Dp 2"; desc = "DM = 0, DP = 1"; };
            DM_1_DP = 2 { name = "Dm 1 Dp"; desc = "DM = 1, DP = 0"; };
            UNDEFINED = 3 { name = "Undefined"; desc = "undefined"; };
        };

        field {
            name = "linestate";
            desc = "Current line state indicator";
            sw = r;
            hw = w;
            encode = GPWRDN_linestate_enum;
            reset = 0x0;
        } linestate[20:19];

        enum GPWRDN_stschngintmsk_enum {
            MASKED = 0 { name = "Masked"; desc = "masked"; };
            NOT_MASKED = 1 { name = "Not Masked"; desc = "not masked"; };
        };

        field {
            name = "stschngintmsk";
            desc = "StsChng interrupt mask";
            sw = rw;
            hw = r;
            encode = GPWRDN_stschngintmsk_enum;
            reset = 0x0;
        } stschngintmsk[18:18];

        enum GPWRDN_stschngint_enum {
            NOT_CHANGED = 0 { name = "Not Changed"; desc = "not changed"; };
            CHANGED = 1 { name = "Changed"; desc = "changed"; };
        };

        field {
            name = "stschngint";
            desc = "StsChng interrupt The bit indicates whether the status of the IDDIG or BSessVld signal changes.";
            sw = rw;
            hw = w;
            onwrite = woclr;
            encode = GPWRDN_stschngint_enum;
            reset = 0x0;
        } stschngint[17:17];

        enum GPWRDN_srpdetectmsk_enum {
            NOT_MASKED = 0 { name = "Not Masked"; desc = "not masked"; };
            MASKED = 1 { name = "Masked"; desc = "masked"; };
        };

        field {
            name = "srpdetectmsk";
            desc = "SRPDetect interrupt mask, valid only in host mode";
            sw = rw;
            hw = r;
            encode = GPWRDN_srpdetectmsk_enum;
            reset = 0x0;
        } srpdetectmsk[16:16];

        enum GPWRDN_srpdetect_enum {
            NOT_DETECTED = 0 { name = "Not Detected"; desc = "not detected"; };
            DETECTED = 1 { name = "Detected"; desc = "detected"; };
        };

        field {
            name = "srpdetect";
            desc = "SRP detection";
            sw = rw;
            hw = w;
            onwrite = woclr;
            encode = GPWRDN_srpdetect_enum;
            reset = 0x0;
        } srpdetect[15:15];

        enum GPWRDN_conndetmsk_enum {
            MASKED = 0 { name = "Masked"; desc = "masked"; };
            NOT_MASKED_THIS = 1 { name = "Not Masked This"; desc = "not masked This bit is valid only when OTG_EN_PWROPT is 2."; };
        };

        field {
            name = "conndetmsk";
            desc = "Connection detection interrupt mask";
            sw = rw;
            hw = r;
            encode = GPWRDN_conndetmsk_enum;
            reset = 0x0;
        } conndetmsk[14:14];

        enum GPWRDN_connectdet_enum {
            DISCONNECTED = 0 { name = "Disconnected"; desc = "disconnected"; };
            CONNECTED_THIS_BIT = 1 { name = "Connected This Bit"; desc = "connected This bit is valid only when OTG_EN_PWROPT is 2."; };
        };

        field {
            name = "connectdet";
            desc = "Connection detection";
            sw = r;
            hw = w;
            encode = GPWRDN_connectdet_enum;
            reset = 0x0;
        } connectdet[13:13];

        enum GPWRDN_k_enum {
            MASKED = 0 { name = "Masked"; desc = "masked"; };
            NOT_MASKED_THIS = 1 { name = "Not Masked This"; desc = "not masked This bit is valid only when OTG_EN_PWROPT is 2."; };
        };

        field {
            name = "k";
            desc = "Disconnection detection interrupt mask";
            sw = rw;
            hw = r;
            encode = GPWRDN_k_enum;
            reset = 0x0;
        } k[12:12];

        enum GPWRDN_disconnectdetect_enum {
            NOT_DISCONNECTED = 0 { name = "Not Disconnected"; desc = "not disconnected"; };
            DISCONNECTED_THIS_BIT = 1 { name = "Disconnected This Bit"; desc = "disconnected This bit is valid only when OTG_EN_PWROPT is 2."; };
        };

        field {
            name = "disconnectdetect";
            desc = "Disconnection detection";
            sw = rw;
            hw = w;
            onwrite = woclr;
            encode = GPWRDN_disconnectdetect_enum;
            reset = 0x0;
        } disconnectdetect[11:11];

        enum GPWRDN_resetdetmsk_enum {
            MASKED = 0 { name = "Masked"; desc = "masked"; };
            NOT_MASKED_THIS = 1 { name = "Not Masked This"; desc = "not masked This bit is valid only when OTG_EN_PWROPT is 2."; };
        };

        field {
            name = "resetdetmsk";
            desc = "Reset detection interrupt mask";
            sw = rw;
            hw = r;
            encode = GPWRDN_resetdetmsk_enum;
            reset = 0x0;
        } resetdetmsk[10:10];

        enum GPWRDN_resetdetected_enum {
            NOT_RESET = 0 { name = "Not Reset"; desc = "not reset"; };
            RESET_THIS_BIT = 1 { name = "Reset This Bit"; desc = "reset This bit is valid only when OTG_EN_PWROPT is 2."; };
        };

        field {
            name = "resetdetected";
            desc = "Reset detection";
            sw = rw;
            hw = w;
            onwrite = woclr;
            encode = GPWRDN_resetdetected_enum;
            reset = 0x0;
        } resetdetected[9:9];

        enum GPWRDN_k_2_enum {
            MASKED = 0 { name = "Masked"; desc = "masked"; };
            NOT_MASKED_THIS = 1 { name = "Not Masked This"; desc = "not masked This bit is valid only when OTG_EN_PWROPT is 2."; };
        };

        field {
            name = "k";
            desc = "Line state change interrupt mask";
            sw = rw;
            hw = r;
            encode = GPWRDN_k_2_enum;
            reset = 0x0;
        } k_2[8:8];

        enum GPWRDN_lnstschng_enum {
            NOT_CHANGED = 0 { name = "Not Changed"; desc = "not changed"; };
            CHANGED_THIS_BIT = 1 { name = "Changed This Bit"; desc = "changed This bit is valid only when GPWRDN[pmuactv] is 1 and OTG_EN_PWROPT is 2."; };
        };

        field {
            name = "lnstschng";
            desc = "Line state change detection";
            sw = rw;
            hw = w;
            onwrite = woclr;
            encode = GPWRDN_lnstschng_enum;
            reset = 0x0;
        } lnstschng[7:7];

        field {
            name = "disablevbus";
            desc = "Vbus disable In host mode: 0: PrtPwr is not 0. 1: PrtPwr is 0. In device mode: 0: The level of the bvalid signal is high. 1: The level of the bvalid signal is low. This bit is valid only when GPWRDN[pmuactv] is 1.";
            sw = rw;
            hw = r;
            reset = 0x0;
        } disablevbus[6:6];

        enum GPWRDN_pwrdnswtch_enum {
            V_0 = 0 { name = "V 0"; desc = "on"; };
            OFF = 1 { name = "Off"; desc = "off"; };
        };

        field {
            name = "pwrdnswtch";
            desc = "Power down switch";
            sw = rw;
            hw = r;
            encode = GPWRDN_pwrdnswtch_enum;
            reset = 0x0;
        } pwrdnswtch[5:5];

        enum GPWRDN_pwrdnrst_n_enum {
            RESET_F = 0 { name = "Reset F"; desc = "reset"; };
            NOT_RESET = 1 { name = "Not Reset"; desc = "not reset"; };
        };

        field {
            name = "pwrdnrst_n";
            desc = "Power down reset";
            sw = rw;
            hw = r;
            encode = GPWRDN_pwrdnrst_n_enum;
            reset = 0x1;
        } pwrdnrst_n[4:4];

        enum GPWRDN_pwrdnclmp_enum {
            DISABLED = 0 { name = "Disabled"; desc = "disabled"; };
            ENABLED = 1 { name = "Enabled"; desc = "enabled"; };
        };

        field {
            name = "pwrdnclmp";
            desc = "Power down beat enable";
            sw = rw;
            hw = r;
            encode = GPWRDN_pwrdnclmp_enum;
            reset = 0x0;
        } pwrdnclmp[3:3];

        enum GPWRDN_restore_enum {
            DWC_OTG_NORMAL = 0 { name = "Dwc Otg Normal"; desc = "DWC_otg is in normal mode."; };
            DWC_OTG_RESTORE = 1 { name = "Dwc Otg Restore"; desc = "DWC_otg is in restore mode. This bit is valid only when OTG_EN_PWROPT is 2."; };
        };

        field {
            name = "restore";
            desc = "Restore";
            sw = rw;
            hw = r;
            encode = GPWRDN_restore_enum;
            reset = 0x0;
        } restore[2:2];

        enum GPWRDN_pmuactv_enum {
            DISABLED = 0 { name = "Disabled"; desc = "disabled"; };
            ENABLED = 1 { name = "Enabled"; desc = "enabled"; };
        };

        field {
            name = "pmuactv";
            desc = "PMU enable";
            sw = rw;
            hw = r;
            encode = GPWRDN_pmuactv_enum;
            reset = 0x0;
        } pmuactv[1:1];

        enum GPWRDN_pmuintsel_enum {
            INTERNAL_DWC_OTG = 0 { name = "Internal Dwc Otg"; desc = "internal DWC_otg_core interrupt"; };
            EXTERNAL_DWC_OTG = 1 { name = "External Dwc Otg"; desc = "external DWC_otg_core interrupt"; };
        };

        field {
            name = "pmuintsel";
            desc = "PMU interrupt select";
            sw = rw;
            hw = r;
            encode = GPWRDN_pmuintsel_enum;
            reset = 0x0;
        } pmuintsel[0:0];
    } GPWRDN @ 0x58;

    reg {
        name = "DFIFO software configuration register";
        desc = "GDFIFOCFG is a DFIFO software configuration register.

Data sheet 12.7.5.2 GDFIFOCFG (offset 0x5C, printed page 12-203, `Hi3518EV20X-Hi3516CV200-Datasheet.txt` line 88416).";

        field {
            name = "epinfobaseaddr";
            desc = "Start address for the EP info controller";
            sw = rw;
            hw = r;
            reset = 0x501;
        } epinfobaseaddr[31:16];

        field {
            name = "gdfifocfg";
            desc = "DFIFO size, which is dynamically configured";
            sw = rw;
            hw = r;
            reset = 0x511;
        } gdfifocfg[15:0];
    } GDFIFOCFG @ 0x5C;

    reg {
        name = "ADP timer control and status register";
        desc = "GADPCTL is an ADP timer control and status register.

Data sheet 12.7.5.2 GADPCTL (offset 0x60, printed page 12-204, `Hi3518EV20X-Hi3516CV200-Datasheet.txt` line 88446).";

        enum GADPCTL_ar_enum {
            READ_WRITE = 0 { name = "Read Write"; desc = "read/write"; };
            READ_ONLY = 1 { name = "Read Only"; desc = "read-only"; };
            WRITE_ONLY = 2 { name = "Write Only"; desc = "write-only"; };
            RESERVED = 3 { name = "Reserved"; desc = "reserved"; };
        };

        field {
            name = "ar";
            desc = "Access request";
            sw = rw;
            hw = r;
            encode = GADPCTL_ar_enum;
            reset = 0x0;
        } ar[28:27];

        enum GADPCTL_adptoutmsk_enum {
            MASKED = 0 { name = "Masked"; desc = "masked"; };
            NOT_MASKED = 1 { name = "Not Masked"; desc = "not masked"; };
        };

        field {
            name = "adptoutmsk";
            desc = "ADP timeout interrupt mask";
            sw = rw;
            hw = r;
            encode = GADPCTL_adptoutmsk_enum;
            reset = 0x0;
        } adptoutmsk[26:26];

        enum GADPCTL_adpsnsintmsk_enum {
            MASKED = 0 { name = "Masked"; desc = "masked"; };
            NOT_MASKED = 1 { name = "Not Masked"; desc = "not masked"; };
        };

        field {
            name = "adpsnsintmsk";
            desc = "ADP sense interrupt mask";
            sw = rw;
            hw = r;
            encode = GADPCTL_adpsnsintmsk_enum;
            reset = 0x0;
        } adpsnsintmsk[25:25];

        enum GADPCTL_adpprbintmsk_enum {
            MASKED = 0 { name = "Masked"; desc = "masked"; };
            NOT_MASKED = 1 { name = "Not Masked"; desc = "not masked"; };
        };

        field {
            name = "adpprbintmsk";
            desc = "ADB probe interrupt mask";
            sw = rw;
            hw = w;
            onread = rclr;
            encode = GADPCTL_adpprbintmsk_enum;
            reset = 0x0;
        } adpprbintmsk[24:24];

        field {
            name = "adptoutint";
            desc = "ADP timeout interrupt Setting this bit to 1 clears this interrupt.";
            sw = rw;
            hw = w;
            onread = rclr;
            reset = 0x0;
        } adptoutint[23:23];

        field {
            name = "adpsnsint";
            desc = "ADP sense interrupt Setting this bit to 1 clears this interrupt.";
            sw = rw;
            hw = w;
            onread = rclr;
            reset = 0x0;
        } adpsnsint[22:22];

        field {
            name = "adpprbint";
            desc = "ADP probe interrupt Setting this bit to 1 clears this interrupt.";
            sw = rw;
            hw = w;
            onread = rclr;
            reset = 0x0;
        } adpprbint[21:21];

        enum GADPCTL_adpen_enum {
            DISABLED = 0 { name = "Disabled"; desc = "disabled"; };
            ENABLED = 1 { name = "Enabled"; desc = "enabled"; };
        };

        field {
            name = "adpen";
            desc = "ADP enable";
            sw = rw;
            hw = r;
            encode = GADPCTL_adpen_enum;
            reset = 0x0;
        } adpen[20:20];

        enum GADPCTL_adpres_enum {
            NOT_RESET = 0 { name = "Not Reset"; desc = "not reset"; };
            RESET_F = 1 { name = "Reset F"; desc = "reset"; };
        };

        field {
            name = "adpres";
            desc = "ADP reset";
            sw = rw;
            hw = w;
            onread = rclr;
            encode = GADPCTL_adpres_enum;
            reset = 0x0;
        } adpres[19:19];

        enum GADPCTL_enasns_enum {
            DISABLED = 0 { name = "Disabled"; desc = "disabled"; };
            ENABLED = 1 { name = "Enabled"; desc = "enabled"; };
        };

        field {
            name = "enasns";
            desc = "Sense enable";
            sw = rw;
            hw = r;
            encode = GADPCTL_enasns_enum;
            reset = 0x0;
        } enasns[18:18];

        enum GADPCTL_enaprb_enum {
            DISABLED = 0 { name = "Disabled"; desc = "disabled"; };
            ENABLED = 1 { name = "Enabled"; desc = "enabled"; };
        };

        field {
            name = "enaprb";
            desc = "Probe enable";
            sw = rw;
            hw = r;
            encode = GADPCTL_enaprb_enum;
            reset = 0x0;
        } enaprb[17:17];

        enum GADPCTL_rtim_enum {
            V_1_CYCLES = 0x0 { name = "V 1 Cycles"; desc = "1 cycles"; };
            V_2_CYCLES = 0x1 { name = "V 2 Cycles"; desc = "2 cycles"; };
            V_3_CYCLES = 0x2 { name = "V 3 Cycles"; desc = "3 cycles ..."; };
            V_2048_CYCLES = 0x7FF { name = "V 2048 Cycles"; desc = "2048 cycles"; };
        };

        field {
            name = "rtim";
            desc = "Ramp time The following is the mapping between the values and 32 kHz clock cycle:";
            sw = r;
            hw = w;
            encode = GADPCTL_rtim_enum;
            reset = 0x0;
        } rtim[16:6];

        enum GADPCTL_prbper_enum {
            V_0_625S_0 = 0 { name = "V 0 625S 0"; desc = "0.625s to 0.925s (0.775s typically)"; };
            V_1_25S_1 = 1 { name = "V 1 25S 1"; desc = "1.25s to 1.85s (1.55s typically)"; };
            V_1_9S_2 = 2 { name = "V 1 9S 2"; desc = "1.9s to 2.6s (2.275s typically)"; };
            RESERVED = 3 { name = "Reserved"; desc = "reserved"; };
        };

        field {
            name = "prbper";
            desc = "Probe period";
            sw = rw;
            hw = r;
            encode = GADPCTL_prbper_enum;
            reset = 0x0;
        } prbper[5:4];

        enum GADPCTL_prbdelta_enum {
            V_1_CYCLE = 0 { name = "V 1 Cycle"; desc = "1 cycle"; };
            V_2_CYCLES = 1 { name = "V 2 Cycles"; desc = "2 cycles"; };
            V_3_CYCLES = 2 { name = "V 3 Cycles"; desc = "3 cycles"; };
            V_4_CYCLES = 3 { name = "V 4 Cycles"; desc = "4 cycles"; };
        };

        field {
            name = "prbdelta";
            desc = "Probe delta The following is the mapping between the values and 32 kHz clock cycle:";
            sw = rw;
            hw = r;
            encode = GADPCTL_prbdelta_enum;
            reset = 0x0;
        } prbdelta[3:2];

        enum GADPCTL_prbdschg_enum {
            V_4_MS = 0 { name = "V 4 Ms"; desc = "4 ms"; };
            V_8_MS = 1 { name = "V 8 Ms"; desc = "8 ms"; };
            V_16_MS = 2 { name = "V 16 Ms"; desc = "16 ms"; };
            V_32_MS = 3 { name = "V 32 Ms"; desc = "32 ms"; };
        };

        field {
            name = "prbdschg";
            desc = "Probe discharge TADP_DSCHG time";
            sw = rw;
            hw = r;
            encode = GADPCTL_prbdschg_enum;
            reset = 0x0;
        } prbdschg[1:0];
    } GADPCTL @ 0x60;

    reg {
        name = "TX FIFO configuration register";
        desc = "HPTXFSIZ is a TX FIFO configuration register.

Data sheet 12.7.5.2 HPTXFSIZ (offset 0x100, printed page 12-206, `Hi3518EV20X-Hi3516CV200-Datasheet.txt` line 88584).";

        field {
            name = "ptxfsize";
            desc = "Depth of the host periodic TX FIFO. Its value range is 16-32768.";
            sw = rw;
            hw = r;
            reset = 0x0;
        } ptxfsize[31:16];

        field {
            name = "ptxfstaddr";
            desc = "Start address for the host periodic TX FIFO";
            sw = rw;
            hw = r;
            reset = 0x0;
        } ptxfstaddr[15:0];
    } HPTXFSIZ @ 0x100;

    reg {
        name = "Device IN endpoint TX FIFO size register";
        desc = "DIEPTXFN is a device IN endpoint TX FIFO size register. NOTE This register is valid only in dedicated FIFO mode.

Data sheet 12.7.5.2 DIEPTXFN (offset 0x104, printed page 12-207, `Hi3518EV20X-Hi3516CV200-Datasheet.txt` line 88645).";

        field {
            name = "inepntxfdep";
            desc = "Depth of the IN endpoint TX FIFO The value range is 16-32768.";
            sw = rw;
            hw = r;
        } inepntxfdep[31:16];

        field {
            name = "inepntxfstaddr";
            desc = "Start address for the IN endpoint FIFOn TX RAM";
            sw = rw;
            hw = r;
        } inepntxfstaddr[15:0];
    } DIEPTXF[15] @ 0x104 += 0x4;

    reg {
        name = "Device configuration register";
        desc = "DCFG is a device configuration register.

Data sheet 12.7.5.2 DCFG (offset 0x800, printed page 12-208, `Hi3518EV20X-Hi3516CV200-Datasheet.txt` line 88678).";

        field {
            name = "resvalid";
            desc = "Resume time control This bit is valid only when DCFG[ena32khzsusp] is 1.";
            sw = rw;
            hw = r;
            reset = 0x20;
        } resvalid[31:26];

        enum DCFG_perschintvl_enum {
            V_25_FRAMES = 0 { name = "V 25 Frames"; desc = "25% of (micro) frames"; };
            V_50_FRAMES = 1 { name = "V 50 Frames"; desc = "50% of (micro) frames"; };
            V_75_FRAMES = 2 { name = "V 75 Frames"; desc = "75% of (micro) frames"; };
            RESERVED = 3 { name = "Reserved"; desc = "reserved"; };
        };

        field {
            name = "perschintvl";
            desc = "Ratio of the (micro) frames in scatter/gather DMA mode";
            sw = rw;
            hw = r;
            encode = DCFG_perschintvl_enum;
            reset = 0x1;
        } perschintvl[25:24];

        enum DCFG_descdma_enum {
            DISABLED = 0 { name = "Disabled"; desc = "disabled"; };
            ENABLED = 1 { name = "Enabled"; desc = "enabled"; };
        };

        field {
            name = "descdma";
            desc = "Scatter/Gather DMA enable in device mode";
            sw = rw;
            hw = r;
            encode = DCFG_descdma_enum;
            reset = 0x0;
        } descdma[23:23];

        field {
            name = "epmiscnt";
            desc = "IN endpoint mismatch statistics";
            sw = rw;
            hw = r;
            reset = 0x0;
        } epmiscnt[22:18];

        enum DCFG_endevoutnak_enum {
            DISABLED = 0 { name = "Disabled"; desc = "disabled"; };
            ENABLED = 1 { name = "Enabled"; desc = "enabled"; };
        };

        field {
            name = "endevoutnak";
            desc = "Device OUT NAK enable";
            sw = rw;
            hw = r;
            encode = DCFG_endevoutnak_enum;
            reset = 0x0;
        } endevoutnak[13:13];

        enum DCFG_perfrint_enum {
            V_80_FRAME_INTERVAL = 0 { name = "V 80 Frame Interval"; desc = "80% of the (micro) frame interval"; };
            V_85 = 1 { name = "V 85"; desc = "85%"; };
            V_90 = 2 { name = "V 90"; desc = "90%"; };
            V_95 = 3 { name = "V 95"; desc = "95%"; };
        };

        field {
            name = "perfrint";
            desc = "Periodic frame interval";
            sw = rw;
            hw = r;
            encode = DCFG_perfrint_enum;
            reset = 0x0;
        } perfrint[12:11];

        field {
            name = "devaddr";
            desc = "Device address";
            sw = rw;
            hw = r;
            reset = 0x0;
        } devaddr[10:4];

        enum DCFG_ena32khzsusp_enum {
            DISABLED = 0 { name = "Disabled"; desc = "disabled"; };
            ENABLED = 1 { name = "Enabled"; desc = "enabled"; };
        };

        field {
            name = "ena32khzsusp";
            desc = "32 kHz suspend mode enable";
            sw = rw;
            hw = r;
            encode = DCFG_ena32khzsusp_enum;
            reset = 0x0;
        } ena32khzsusp[3:3];

        field {
            name = "nzstsouthshk";
            desc = "Non-zero-length status OUT handshake select";
            sw = rw;
            hw = r;
            reset = 0x0;
        } nzstsouthshk[2:2];

        enum DCFG_devspd_enum {
            HIGH_SPEED = 0 { name = "High Speed"; desc = "high speed (30 MHz or 60 MHz USB 2.0 PHY clock)"; };
            FULL_SPEED = 1 { name = "Full Speed"; desc = "full speed (30 MHz or 60 MHz USB 2.0 PHY clock)"; };
            LOW_SPEED = 2 { name = "Low Speed"; desc = "low speed (6 MHz USB 1.1 transceiver clock)"; };
            FULL_SPEED_2 = 3 { name = "Full Speed 2"; desc = "full speed (48 MHz USB 1.1 transceiver clock)"; };
        };

        field {
            name = "devspd";
            desc = "Device speed";
            sw = rw;
            hw = r;
            encode = DCFG_devspd_enum;
            reset = 0x0;
        } devspd[1:0];
    } DCFG @ 0x800;

    reg {
        name = "Device control register";
        desc = "DCTL is a device control register.

Reset 0x00000002: sftdiscon = 1 (the device is soft-disconnected after reset; clear it to connect).

Data sheet 12.7.5.2 DCTL (offset 0x804, printed page 12-209, `Hi3518EV20X-Hi3516CV200-Datasheet.txt` line 88745).";

        enum DCTL_encontonbna_enum {
            DISABLED = 0 { name = "Disabled"; desc = "disabled"; };
            ENABLED = 1 { name = "Enabled"; desc = "enabled"; };
        };

        field {
            name = "encontonbna";
            desc = "Continue on BNA enable";
            sw = rw;
            hw = r;
            encode = DCTL_encontonbna_enum;
            reset = 0x0;
        } encontonbna[17:17];

        enum DCTL_nakonbble_enum {
            NO_OPERATION = 0 { name = "No Operation"; desc = "no operation"; };
            NAK_CONFIGURED_RECEIVED = 1 { name = "Nak Configured Received"; desc = "NAK configured on the received babble"; };
        };

        field {
            name = "nakonbble";
            desc = "NAK on babble error";
            sw = rw;
            hw = r;
            encode = DCTL_nakonbble_enum;
            reset = 0x0;
        } nakonbble[16:16];

        enum DCTL_ignrfrmnum_enum {
            NOT_IGNORED = 0 { name = "Not Ignored"; desc = "not ignored"; };
            IGNORED = 1 { name = "Ignored"; desc = "ignored"; };
        };

        field {
            name = "ignrfrmnum";
            desc = "Whether the number of frames on isochronous endpoints is ignored";
            sw = rw;
            hw = r;
            encode = DCTL_ignrfrmnum_enum;
            reset = 0x0;
        } ignrfrmnum[15:15];

        enum DCTL_pwronprgdone_enum {
            NOT_WOKEN_UP = 0 { name = "Not Woken Up"; desc = "not woken up"; };
            WOKEN_UP = 1 { name = "Woken Up"; desc = "woken up"; };
        };

        field {
            name = "pwronprgdone";
            desc = "Resume from the power-down mode";
            sw = rw;
            hw = r;
            encode = DCTL_pwronprgdone_enum;
            reset = 0x0;
        } pwronprgdone[11:11];

        enum DCTL_cgoutnak_enum {
            NO_OPERATION = 0 { name = "No Operation"; desc = "no operation"; };
            CLEARED = 1 { name = "Cleared"; desc = "cleared"; };
        };

        field {
            name = "cgoutnak";
            desc = "Global OUT NAK clear";
            sw = w;
            hw = r;
            encode = DCTL_cgoutnak_enum;
            reset = 0x0;
        } cgoutnak[10:10];

        enum DCTL_sgoutnak_enum {
            NO_OPERATION = 0 { name = "No Operation"; desc = "no operation"; };
            CONFIGURED = 1 { name = "Configured"; desc = "configured"; };
        };

        field {
            name = "sgoutnak";
            desc = "Global OUT NAK";
            sw = w;
            hw = r;
            encode = DCTL_sgoutnak_enum;
            reset = 0x0;
        } sgoutnak[9:9];

        enum DCTL_cgnpinnak_enum {
            NO_OPERATION = 0 { name = "No Operation"; desc = "no operation"; };
            CLEARED = 1 { name = "Cleared"; desc = "cleared"; };
        };

        field {
            name = "cgnpinnak";
            desc = "Global non-periodic IN NAK clear";
            sw = w;
            hw = r;
            encode = DCTL_cgnpinnak_enum;
            reset = 0x0;
        } cgnpinnak[8:8];

        enum DCTL_sgnpinnak_enum {
            NO_OPERATION = 0 { name = "No Operation"; desc = "no operation"; };
            CONFIGURED = 1 { name = "Configured"; desc = "configured"; };
        };

        field {
            name = "sgnpinnak";
            desc = "Global non-periodic IN NAK";
            sw = w;
            hw = r;
            encode = DCTL_sgnpinnak_enum;
            reset = 0x0;
        } sgnpinnak[7:7];

        enum DCTL_tstctl_enum {
            TEST_MODE_DISABLED = 0 { name = "Test Mode Disabled"; desc = "test mode disabled"; };
            TEST_J_MODE = 1 { name = "Test J Mode"; desc = "Test_J mode"; };
            TEST_K_MODE = 2 { name = "Test K Mode"; desc = "Test_K mode"; };
            TEST_SE0_NAK = 3 { name = "Test Se0 Nak"; desc = "Test_SE0_NAK mode"; };
            TEST_PACKET_MODE = 4 { name = "Test Packet Mode"; desc = "Test_Packet mode"; };
            TEST_FORCE_ENABLE = 5 { name = "Test Force Enable"; desc = "Test_Force_Enable Other values: reserved"; };
        };

        field {
            name = "tstctl";
            desc = "Test control";
            sw = rw;
            hw = r;
            encode = DCTL_tstctl_enum;
            reset = 0x0;
        } tstctl[6:4];

        enum DCTL_goutnaksts_enum {
            HANDSHAKE_TX = 0 { name = "Handshake Tx"; desc = "handshake TX"; };
            NAK_HANDSHAKE_TX = 1 { name = "Nak Handshake Tx"; desc = "NAK handshake TX"; };
        };

        field {
            name = "goutnaksts";
            desc = "Global OUT NAK status";
            sw = r;
            hw = w;
            encode = DCTL_goutnaksts_enum;
            reset = 0x0;
        } goutnaksts[3:3];

        enum DCTL_gnpinnaksts_enum {
            HANDSHAKE_TX = 0 { name = "Handshake Tx"; desc = "handshake TX"; };
            NAK_HANDSHAKE_TX = 1 { name = "Nak Handshake Tx"; desc = "NAK handshake TX"; };
        };

        field {
            name = "gnpinnaksts";
            desc = "Global non-periodic IN NAK status";
            sw = r;
            hw = w;
            encode = DCTL_gnpinnaksts_enum;
            reset = 0x0;
        } gnpinnaksts[2:2];

        enum DCTL_sftdiscon_enum {
            COMMON_MODE = 0 { name = "Common Mode"; desc = "common mode"; };
            CORE_DRIVES_PHY = 1 { name = "Core Drives Phy"; desc = "The core drives phy_opmode_o to 2'b01, and then triggers USB disconnection."; };
        };

        field {
            name = "sftdiscon";
            desc = "Soft disconnection";
            sw = rw;
            hw = r;
            encode = DCTL_sftdiscon_enum;
            reset = 0x1;
        } sftdiscon[1:1];

        enum DCTL_rmtwkupsig_enum {
            NOT_WOKEN_UP = 0 { name = "Not Woken Up"; desc = "not woken up remotely"; };
            WOKEN_UP_REMOTELY = 1 { name = "Woken Up Remotely"; desc = "woken up remotely"; };
        };

        field {
            name = "rmtwkupsig";
            desc = "Remote wakeup signal TX";
            sw = rw;
            hw = r;
            encode = DCTL_rmtwkupsig_enum;
            reset = 0x0;
        } rmtwkupsig[0:0];
    } DCTL @ 0x804;

    reg {
        name = "Device status register";
        desc = "DSTS is a device status query register.

Data sheet 12.7.5.2 DSTS (offset 0x808, printed page 12-211, `Hi3518EV20X-Hi3516CV200-Datasheet.txt` line 88842).";

        field {
            name = "devlnsts";
            desc = "Logic level of the current USB data line bit[23]: logic level of D+ bit[22]: logic level of D-";
            sw = r;
            hw = w;
            reset = 0x0;
        } devlnsts[23:22];

        field {
            name = "soffn";
            desc = "Number of frames or micro frames in the received SOF packets";
            sw = r;
            hw = w;
            reset = 0x7FF;
        } soffn[21:8];

        enum DSTS_errticerr_enum {
            NO_IRREGULAR_ERROR = 0 { name = "No Irregular Error"; desc = "No irregular error occurs in the UTMI+ interface."; };
            IRREGULAR_ERROR_OCCURS = 1 { name = "Irregular Error Occurs"; desc = "An irregular error occurs in the UTMI+ interface."; };
        };

        field {
            name = "errticerr";
            desc = "Irregular error indicator The controller core sets this bit to 1 when any irregular error (for example, phy_rxvalid_i is set to 1 and retains this value for 2 ms due to an PHY error) occurs in the UTMI+ interface.";
            sw = r;
            hw = w;
            encode = DSTS_errticerr_enum;
            reset = 0x0;
        } errticerr[3:3];

        enum DSTS_enumspd_enum {
            HIGH_SPEED = 0 { name = "High Speed"; desc = "high speed (30 MHz or 60 MHz PHY clock)"; };
            FULL_SPEED = 1 { name = "Full Speed"; desc = "full speed (30 MHz or 60 MHz PHY clock)"; };
            LOW_SPEED = 2 { name = "Low Speed"; desc = "low speed (6 MHz PHY clock)."; };
            FULL_SPEED_2 = 3 { name = "Full Speed 2"; desc = "full speed (48 MHz PHY clock)."; };
        };

        field {
            name = "enumspd";
            desc = "Enumeration speed";
            sw = r;
            hw = w;
            encode = DSTS_enumspd_enum;
            reset = 0x1;
        } enumspd[2:1];

        field {
            name = "suspsts";
            desc = "Suspend status. When the suspend conditions are detected, this bit is 1.";
            sw = r;
            hw = w;
            reset = 0x0;
        } suspsts[0:0];
    } DSTS @ 0x808;

    reg {
        name = "Common interrupt mask register for device IN endpoints";
        desc = "DIEPMSK is a common interrupt mask register for device IN endpoints.

Data sheet 12.7.5.2 DIEPMSK (offset 0x810, printed page 12-212, `Hi3518EV20X-Hi3516CV200-Datasheet.txt` line 88893).";

        enum DIEPMSK_nakmsk_enum {
            MASKED = 0 { name = "Masked"; desc = "masked"; };
            NOT_MASKED = 1 { name = "Not Masked"; desc = "not masked"; };
        };

        field {
            name = "nakmsk";
            desc = "NAK interrupt mask";
            sw = rw;
            hw = r;
            encode = DIEPMSK_nakmsk_enum;
            reset = 0x0;
        } nakmsk[13:13];

        enum DIEPMSK_bnainintrmsk_enum {
            MASKED = 0 { name = "Masked"; desc = "masked"; };
            NOT_MASKED = 1 { name = "Not Masked"; desc = "not masked"; };
        };

        field {
            name = "bnainintrmsk";
            desc = "BNA interrupt mask";
            sw = rw;
            hw = r;
            encode = DIEPMSK_bnainintrmsk_enum;
            reset = 0x0;
        } bnainintrmsk[9:9];

        enum DIEPMSK_txfifoundrnmsk_enum {
            MASKED = 0 { name = "Masked"; desc = "masked"; };
            NOT_MASKED = 1 { name = "Not Masked"; desc = "not masked"; };
        };

        field {
            name = "txfifoundrnmsk";
            desc = "FIFO underrun interrupt mask";
            sw = rw;
            hw = r;
            encode = DIEPMSK_txfifoundrnmsk_enum;
            reset = 0x0;
        } txfifoundrnmsk[8:8];

        enum DIEPMSK_inepnakeffmsk_enum {
            MASKED = 0 { name = "Masked"; desc = "masked"; };
            NOT_MASKED = 1 { name = "Not Masked"; desc = "not masked"; };
        };

        field {
            name = "inepnakeffmsk";
            desc = "IN endpoint NAK effective interrupt mask";
            sw = rw;
            hw = r;
            encode = DIEPMSK_inepnakeffmsk_enum;
            reset = 0x0;
        } inepnakeffmsk[6:6];

        enum DIEPMSK_intknepmismsk_enum {
            MASKED = 0 { name = "Masked"; desc = "masked"; };
            NOT_MASKED = 1 { name = "Not Masked"; desc = "not masked"; };
        };

        field {
            name = "intknepmismsk";
            desc = "IN token received with EP mismatch interrupt mask";
            sw = rw;
            hw = r;
            encode = DIEPMSK_intknepmismsk_enum;
            reset = 0x0;
        } intknepmismsk[5:5];

        enum DIEPMSK_intkntxfempmsk_enum {
            MASKED = 0 { name = "Masked"; desc = "masked"; };
            NOT_MASKED = 1 { name = "Not Masked"; desc = "not masked"; };
        };

        field {
            name = "intkntxfempmsk";
            desc = "IN token received when TX FIFO empty interrupt mask";
            sw = rw;
            hw = r;
            encode = DIEPMSK_intkntxfempmsk_enum;
            reset = 0x0;
        } intkntxfempmsk[4:4];

        enum DIEPMSK_timeoutmsk_enum {
            MASKED = 0 { name = "Masked"; desc = "masked"; };
            NOT_MASKED = 1 { name = "Not Masked"; desc = "not masked"; };
        };

        field {
            name = "timeoutmsk";
            desc = "Timeout interrupt mask";
            sw = rw;
            hw = r;
            encode = DIEPMSK_timeoutmsk_enum;
            reset = 0x0;
        } timeoutmsk[3:3];

        enum DIEPMSK_ahberrmsk_enum {
            MASKED = 0 { name = "Masked"; desc = "masked"; };
            NOT_MASKED = 1 { name = "Not Masked"; desc = "not masked"; };
        };

        field {
            name = "ahberrmsk";
            desc = "AHB error interrupt mask";
            sw = rw;
            hw = r;
            encode = DIEPMSK_ahberrmsk_enum;
            reset = 0x0;
        } ahberrmsk[2:2];

        enum DIEPMSK_epdisbldmsk_enum {
            MASKED = 0 { name = "Masked"; desc = "masked"; };
            NOT_MASKED = 1 { name = "Not Masked"; desc = "not masked"; };
        };

        field {
            name = "epdisbldmsk";
            desc = "Endpoint disabled interrupt mask";
            sw = rw;
            hw = r;
            encode = DIEPMSK_epdisbldmsk_enum;
            reset = 0x0;
        } epdisbldmsk[1:1];

        enum DIEPMSK_xfercomplmsk_enum {
            MASKED = 0 { name = "Masked"; desc = "masked"; };
            NOT_MASKED = 1 { name = "Not Masked"; desc = "not masked"; };
        };

        field {
            name = "xfercomplmsk";
            desc = "Transfer completed interrupt mask";
            sw = rw;
            hw = r;
            encode = DIEPMSK_xfercomplmsk_enum;
            reset = 0x0;
        } xfercomplmsk[0:0];
    } DIEPMSK @ 0x810;

    reg {
        name = "Common interrupt mask register for device OUT endpoints";
        desc = "DOEPMSK is a common interrupt mask register for device OUT endpoints.

Data sheet 12.7.5.2 DOEPMSK (offset 0x814, printed page 12-213, `Hi3518EV20X-Hi3516CV200-Datasheet.txt` line 88961).";

        enum DOEPMSK_nyetmsk_enum {
            MASKED = 0 { name = "Masked"; desc = "masked"; };
            NOT_MASKED = 1 { name = "Not Masked"; desc = "not masked"; };
        };

        field {
            name = "nyetmsk";
            desc = "NYET interrupt mask";
            sw = rw;
            hw = r;
            encode = DOEPMSK_nyetmsk_enum;
            reset = 0x0;
        } nyetmsk[14:14];

        enum DOEPMSK_nakmsk_enum {
            MASKED = 0 { name = "Masked"; desc = "masked"; };
            NOT_MASKED = 1 { name = "Not Masked"; desc = "not masked"; };
        };

        field {
            name = "nakmsk";
            desc = "NAK interrupt mask";
            sw = rw;
            hw = r;
            encode = DOEPMSK_nakmsk_enum;
            reset = 0x0;
        } nakmsk[13:13];

        enum DOEPMSK_bbleerrmsk_enum {
            MASKED = 0 { name = "Masked"; desc = "masked"; };
            NOT_MASKED = 1 { name = "Not Masked"; desc = "not masked"; };
        };

        field {
            name = "bbleerrmsk";
            desc = "Babble error interrupt mask";
            sw = rw;
            hw = r;
            encode = DOEPMSK_bbleerrmsk_enum;
            reset = 0x0;
        } bbleerrmsk[12:12];

        enum DOEPMSK_bnaoutintrmsk_enum {
            MASKED = 0 { name = "Masked"; desc = "masked"; };
            NOT_MASKED = 1 { name = "Not Masked"; desc = "not masked"; };
        };

        field {
            name = "bnaoutintrmsk";
            desc = "BNA interrupt mask";
            sw = rw;
            hw = r;
            encode = DOEPMSK_bnaoutintrmsk_enum;
            reset = 0x0;
        } bnaoutintrmsk[9:9];

        enum DOEPMSK_outpkterrmsk_enum {
            MASKED = 0 { name = "Masked"; desc = "masked"; };
            NOT_MASKED = 1 { name = "Not Masked"; desc = "not masked"; };
        };

        field {
            name = "outpkterrmsk";
            desc = "OUT packet error interrupt mask";
            sw = rw;
            hw = r;
            encode = DOEPMSK_outpkterrmsk_enum;
            reset = 0x0;
        } outpkterrmsk[8:8];

        enum DOEPMSK_back2backsetupmsk_enum {
            MASKED = 0 { name = "Masked"; desc = "masked"; };
            NOT_MASKED = 1 { name = "Not Masked"; desc = "not masked"; };
        };

        field {
            name = "back2backsetupmsk";
            desc = "Back-to-back setup packets received interrupt mask";
            sw = rw;
            hw = r;
            encode = DOEPMSK_back2backsetupmsk_enum;
            reset = 0x0;
        } back2backsetupmsk[6:6];

        enum DOEPMSK_stsphsercvdmsk_enum {
            MASKED = 0 { name = "Masked"; desc = "masked"; };
            NOT_MASKED = 1 { name = "Not Masked"; desc = "not masked"; };
        };

        field {
            name = "stsphsercvdmsk";
            desc = "Status phase received interrupt mask";
            sw = rw;
            hw = r;
            encode = DOEPMSK_stsphsercvdmsk_enum;
            reset = 0x0;
        } stsphsercvdmsk[5:5];

        enum DOEPMSK_outtknepdismsk_enum {
            MASKED = 0 { name = "Masked"; desc = "masked"; };
            NOT_MASKED = 1 { name = "Not Masked"; desc = "not masked"; };
        };

        field {
            name = "outtknepdismsk";
            desc = "W OUT token received when endpoint disabled interrupt mask";
            sw = rw;
            hw = r;
            encode = DOEPMSK_outtknepdismsk_enum;
            reset = 0x0;
        } outtknepdismsk[4:4];

        enum DOEPMSK_setupmsk_enum {
            MASKED = 0 { name = "Masked"; desc = "masked"; };
            NOT_MASKED = 1 { name = "Not Masked"; desc = "not masked"; };
        };

        field {
            name = "setupmsk";
            desc = "Setup phase done interrupt mask";
            sw = rw;
            hw = r;
            encode = DOEPMSK_setupmsk_enum;
            reset = 0x0;
        } setupmsk[3:3];

        enum DOEPMSK_ahberrmsk_enum {
            MASKED = 0 { name = "Masked"; desc = "masked"; };
            NOT_MASKED = 1 { name = "Not Masked"; desc = "not masked"; };
        };

        field {
            name = "ahberrmsk";
            desc = "AHB error interrupt mask";
            sw = rw;
            hw = r;
            encode = DOEPMSK_ahberrmsk_enum;
            reset = 0x0;
        } ahberrmsk[2:2];

        enum DOEPMSK_epdisbldmsk_enum {
            MASKED = 0 { name = "Masked"; desc = "masked"; };
            NOT_MASKED = 1 { name = "Not Masked"; desc = "not masked"; };
        };

        field {
            name = "epdisbldmsk";
            desc = "Endpoint disabled interrupt mask";
            sw = rw;
            hw = r;
            encode = DOEPMSK_epdisbldmsk_enum;
            reset = 0x0;
        } epdisbldmsk[1:1];

        enum DOEPMSK_xfercomplmsk_enum {
            MASKED = 0 { name = "Masked"; desc = "masked"; };
            NOT_MASKED = 1 { name = "Not Masked"; desc = "not masked"; };
        };

        field {
            name = "xfercomplmsk";
            desc = "Transfer completed interrupt mask";
            sw = rw;
            hw = r;
            encode = DOEPMSK_xfercomplmsk_enum;
            reset = 0x0;
        } xfercomplmsk[0:0];
    } DOEPMSK @ 0x814;

    reg {
        name = "Interrupt register for all device endpoints";
        desc = "DAINT is an interrupt register for all device endpoints.

Data sheet 12.7.5.2 DAINT (offset 0x818, printed page 12-214, `Hi3518EV20X-Hi3516CV200-Datasheet.txt` line 89039).";

        field {
            name = "outepint";
            desc = "OUT endpoint interrupt Bit 16: OUT endpoint 0 ... Bit 31: OUT endpoint 15";
            sw = r;
            hw = w;
            reset = 0x0;
        } outepint[31:16];

        field {
            name = "inepint";
            desc = "IN endpoint interrupt Bit 0: IN endpoint 0 ... Bit 15: IN endpoint 15";
            sw = r;
            hw = w;
            reset = 0x0;
        } inepint[15:0];
    } DAINT @ 0x818;

    reg {
        name = "Interrupt mask register for all endpoints";
        desc = "DAINTMSK is an interrupt mask register for all endpoints.

Data sheet 12.7.5.2 DAINTMSK (offset 0x81C, printed page 12-215, `Hi3518EV20X-Hi3516CV200-Datasheet.txt` line 89075).";

        field {
            name = "outepmsk";
            desc = "OUT endpoint interrupt mask Bit 16: OUT endpoint 0 ... Bit 31: OUT endpoint 15";
            sw = rw;
            hw = r;
            reset = 0x0;
        } outepmsk[31:16];

        field {
            name = "inepmsk";
            desc = "IN endpoint interrupt mask Bit 0: IN endpoint 0 ... Bit 15: IN endpoint 15";
            sw = rw;
            hw = r;
            reset = 0x0;
        } inepmsk[15:0];
    } DAINTMSK @ 0x81C;

    reg {
        name = "Device IN token learning sequence queue read register 1";
        desc = "DTKNQR1 is device IN token sequence learning queue read register 1.

Together with DTKNQR2 this holds the IN token sequence learning queue (shared-FIFO mode only).

Data sheet 12.7.5.2 DTKNQR1 (offset 0x820, printed page 12-216, `Hi3518EV20X-Hi3516CV200-Datasheet.txt` line 89113).";

        field {
            name = "eptkn";
            desc = "Token endpoint ID Four bits are used to indicate the token endpoint ID. Bit[31:28]: endpoint ID of token 5 Bit[27:24]: endpoint ID of token 4 … Bit[15:12]: endpoint ID of token 1 Bit[11:8]: endpoint ID of token 0";
            sw = r;
            hw = w;
            reset = 0x0;
        } eptkn[31:8];

        enum DTKNQR1_wrapbit_enum {
            LEARNING_QUEUE_TOKEN = 0 { name = "Learning Queue Token"; desc = "The learning queue of the IN token is cleared."; };
            WRITE_POINTER_WRAPPED = 1 { name = "Write Pointer Wrapped"; desc = "The write pointer is wrapped."; };
        };

        field {
            name = "wrapbit";
            desc = "Wrapping bit";
            sw = r;
            hw = w;
            encode = DTKNQR1_wrapbit_enum;
            reset = 0x0;
        } wrapbit[7:7];

        field {
            name = "intknwptr";
            desc = "IN token queue write pointer";
            sw = r;
            hw = w;
            reset = 0x0;
        } intknwptr[4:0];
    } DTKNQR1 @ 0x820;

    reg {
        name = "Device IN token learning sequence queue read register 2";
        desc = "DTKNQR2 is device IN token sequence learning queue read register 2.

Data sheet 12.7.5.2 DTKNQR2 (offset 0x824, printed page 12-216, `Hi3518EV20X-Hi3516CV200-Datasheet.txt` line 89144).";

        field {
            name = "eptkn";
            desc = "Token endpoint ID Four bits are used to indicate the token endpoint ID. Bit[31:28]: endpoint ID of token 13 Bit[27:24]: endpoint ID of token 12 … Bit[7:4]: endpoint ID of token 7";
            sw = r;
            hw = w;
            reset = 0x0;
        } eptkn[31:0];
    } DTKNQR2 @ 0x824;

    reg {
        name = "Device VBUS discharge time register";
        desc = "DVBUSDIS is a device VBUS discharge time register.

Data sheet 12.7.5.2 DVBUSDIS (offset 0x828, printed page 12-218, `Hi3518EV20X-Hi3516CV200-Datasheet.txt` line 89232).";

        field {
            name = "dvbusdis";
            desc = "Device VBUS discharge time";
            sw = rw;
            hw = r;
            reset = 0x17D7;
        } dvbusdis[15:0];
    } DVBUSDIS @ 0x828;

    reg {
        name = "Device VBUS pulsing time register";
        desc = "DVBUSPULSE is a device VBUS pulsing time register.

Data sheet 12.7.5.2 DVBUSPULSE (offset 0x82C, printed page 12-218, `Hi3518EV20X-Hi3516CV200-Datasheet.txt` line 89252).";

        field {
            name = "dvbuspulse";
            desc = "Device VBUS pulse time";
            sw = r;
            hw = w;
            reset = 0x5B8;
        } dvbuspulse[11:0];
    } DVBUSPULSE @ 0x82C;

    reg {
        name = "Device threshold control register";
        desc = "DTHRCTL is a device threshold control register.

The data sheet Total Reset Value 0x0C100020 also has the reserved bit 26 set (not modelled; arbprken is bit 27). The data sheet summary also lists DTKNQR3 at 0x830; that is the same address (DTKNQR3 and DTHRCTL share it in the DWC_otg databook depending on the core configuration); only DTHRCTL, which the vendor driver uses, is modelled.

Data sheet 12.7.5.2 DTHRCTL (offset 0x830, printed page 12-219, `Hi3518EV20X-Hi3516CV200-Datasheet.txt` line 89281).";

        enum DTHRCTL_arbprken_enum {
            DISABLED = 0 { name = "Disabled"; desc = "disabled"; };
            ENABLED = 1 { name = "Enabled"; desc = "enabled"; };
        };

        field {
            name = "arbprken";
            desc = "Arbitrator parking enable";
            sw = rw;
            hw = r;
            encode = DTHRCTL_arbprken_enum;
            reset = 0x1;
        } arbprken[27:27];

        field {
            name = "rxthrlen";
            desc = "RX threshold length";
            sw = rw;
            hw = r;
            reset = 0x8;
        } rxthrlen[25:17];

        enum DTHRCTL_rxthren_enum {
            DISABLED = 0 { name = "Disabled"; desc = "disabled"; };
            ENABLED = 1 { name = "Enabled"; desc = "enabled"; };
        };

        field {
            name = "rxthren";
            desc = "RX threshold enable Some RX FIFO problems may be caused after the RX threshold is enabled, especially when there are RX and babble errors.";
            sw = rw;
            hw = r;
            encode = DTHRCTL_rxthren_enum;
            reset = 0x0;
        } rxthren[16:16];

        enum DTHRCTL_ahbthrratio_enum {
            AHB_THRESHOLD_MAC = 0 { name = "Ahb Threshold Mac"; desc = "AHB threshold = MAC threshold"; };
            AHB_THRESHOLD_MAC_2 = 1 { name = "Ahb Threshold Mac 2"; desc = "AHB threshold = MAC threshold/2"; };
            AHB_THRESHOLD_MAC_3 = 2 { name = "Ahb Threshold Mac 3"; desc = "AHB threshold = MAC threshold/4"; };
            AHB_THRESHOLD_MAC_4 = 3 { name = "Ahb Threshold Mac 4"; desc = "AHB threshold = MAC threshold/8"; };
        };

        field {
            name = "ahbthrratio";
            desc = "AHB threshold ratio";
            sw = rw;
            hw = r;
            encode = DTHRCTL_ahbthrratio_enum;
            reset = 0x0;
        } ahbthrratio[12:11];

        field {
            name = "txthrlen";
            desc = "TX threshold length";
            sw = rw;
            hw = r;
            reset = 0x8;
        } txthrlen[10:2];

        enum DTHRCTL_isothren_enum {
            DISABLED = 0 { name = "Disabled"; desc = "disabled"; };
            ENABLED = 1 { name = "Enabled"; desc = "enabled"; };
        };

        field {
            name = "isothren";
            desc = "ISO IN endpoint threshold enable";
            sw = rw;
            hw = r;
            encode = DTHRCTL_isothren_enum;
            reset = 0x0;
        } isothren[1:1];

        enum DTHRCTL_nonisothren_enum {
            DISABLED = 0 { name = "Disabled"; desc = "disabled"; };
            ENABLED = 1 { name = "Enabled"; desc = "enabled"; };
        };

        field {
            name = "nonisothren";
            desc = "Non-ISO IN endpoint threshold enable";
            sw = rw;
            hw = r;
            encode = DTHRCTL_nonisothren_enum;
            reset = 0x0;
        } nonisothren[0:0];
    } DTHRCTL @ 0x830;

    reg {
        name = "FIFO empty interrupt mask register for device IN endpoints";
        desc = "DIEPEMPMSK is a FIFO empty interrupt mask register for device IN endpoints.

The data sheet summary also lists DTKNQR4 at 0x834; same address, see DTHRCTL. Only DIEPEMPMSK is modelled. (DTKNQR3/DTKNQR4 text: 'Token endpoint ID' fields eptkn, bit[31:28] = token 21/29 ... bit[3:0] = token 1/2.)

Data sheet 12.7.5.2 DIEPEMPMSK (offset 0x834, printed page 12-220, `Hi3518EV20X-Hi3516CV200-Datasheet.txt` line 89336).";

        field {
            name = "ineptxfempmsk";
            desc = "IN EP TX FIFO empty interrupt mask Bit 0: IN endpoint 0 ... Bit 15: IN endpoint 15";
            sw = rw;
            hw = r;
            reset = 0x0;
        } ineptxfempmsk[15:0];
    } DIEPEMPMSK @ 0x834;

    reg {
        name = "Interrupt register for each device endpoint";
        desc = "DEACHINT is an interrupt register for each device endpoint.

DS typo: the description of echinepint numbers the IN endpoints backwards (`Bit 15: IN endpoint 0 ... Bit 0: IN endpoint 15`); bit n is IN endpoint n as in DAINT.

Data sheet 12.7.5.2 DEACHINT (offset 0x838, printed page 12-220, `Hi3518EV20X-Hi3516CV200-Datasheet.txt` line 89360).";

        field {
            name = "echoutepint";
            desc = "OUT endpoint interrupt Bit 16: OUT endpoint 0 ... Bit 31: OUT endpoint 15";
            sw = rw;
            hw = r;
            reset = 0x0;
        } echoutepint[31:16];

        field {
            name = "echinepint";
            desc = "IN endpoint interrupt Bit 15: IN endpoint 0 ... Bit 0: IN endpoint 15";
            sw = rw;
            hw = r;
            reset = 0x0;
        } echinepint[15:0];
    } DEACHINT @ 0x838;

    reg {
        name = "Interrupt register for each device endpoint SK";
        desc = "DEACHINTMSK is an interrupt mask register for each device endpoint.

DS typo: the echinepmsk description numbers the IN endpoints as bits 16..31; they are bits 0..15 (IN) and 16..31 (OUT) as in DEACHINT.

Data sheet 12.7.5.2 DEACHINTMSK (offset 0x83C, printed page 12-221, `Hi3518EV20X-Hi3516CV200-Datasheet.txt` line 89397).";

        enum DEACHINTMSK_echoutepmsk_enum {
            MASKED = 0x0 { name = "Masked"; desc = "masked"; };
            NOT_MASKED = 0x1 { name = "Not Masked"; desc = "not masked"; };
        };

        field {
            name = "echoutepmsk";
            desc = "OUT endpoint interrupt mask Bit 16: OUT endpoint 0 ... Bit 31: OUT endpoint 15";
            sw = rw;
            hw = r;
            encode = DEACHINTMSK_echoutepmsk_enum;
            reset = 0x0;
        } echoutepmsk[31:16];

        enum DEACHINTMSK_echinepmsk_enum {
            MASKED = 0x0 { name = "Masked"; desc = "masked"; };
            NOT_MASKED = 0x1 { name = "Not Masked"; desc = "not masked"; };
        };

        field {
            name = "echinepmsk";
            desc = "IN endpoint interrupt mask Bit 16: IN endpoint 0 ... Bit 31: IN endpoint 15";
            sw = rw;
            hw = r;
            encode = DEACHINTMSK_echinepmsk_enum;
            reset = 0x0;
        } echinepmsk[15:0];
    } DEACHINTMSK @ 0x83C;

    reg {
        name = "Interrupt register for device IN endpoint n";
        desc = "DIEPEACHMSKN is an interrupt register for device IN endpoint n.

Array: one register per IN endpoint n (0..15) at 0x840 + 4 x n. The data sheet Total Reset Value 0x00400000 has a bit set inside the reserved field (bit 22), not modelled (the DWC_otg reset value of the register is 0).

Data sheet 12.7.5.2 DIEPEACHMSKN (offset 0x840, printed page 12-221, `Hi3518EV20X-Hi3516CV200-Datasheet.txt` line 89430).";

        enum DIEPEACHMSKN_nakmsk_enum {
            MASKED = 0 { name = "Masked"; desc = "masked"; };
            NOT_MASKED = 1 { name = "Not Masked"; desc = "not masked"; };
        };

        field {
            name = "nakmsk";
            desc = "NAK interrupt mask";
            sw = rw;
            hw = r;
            encode = DIEPEACHMSKN_nakmsk_enum;
            reset = 0x0;
        } nakmsk[13:13];

        enum DIEPEACHMSKN_bnainintrmsk_enum {
            MASKED = 0 { name = "Masked"; desc = "masked"; };
            NOT_MASKED = 1 { name = "Not Masked"; desc = "not masked"; };
        };

        field {
            name = "bnainintrmsk";
            desc = "BNA interrupt mask";
            sw = rw;
            hw = r;
            encode = DIEPEACHMSKN_bnainintrmsk_enum;
            reset = 0x0;
        } bnainintrmsk[9:9];

        enum DIEPEACHMSKN_txfifoundrnmsk_enum {
            MASKED = 0 { name = "Masked"; desc = "masked"; };
            NOT_MASKED = 1 { name = "Not Masked"; desc = "not masked"; };
        };

        field {
            name = "txfifoundrnmsk";
            desc = "FIFO underrun interrupt mask";
            sw = rw;
            hw = r;
            encode = DIEPEACHMSKN_txfifoundrnmsk_enum;
            reset = 0x0;
        } txfifoundrnmsk[8:8];

        enum DIEPEACHMSKN_inepnakeffmsk_enum {
            MASKED = 0 { name = "Masked"; desc = "masked"; };
            NOT_MASKED = 1 { name = "Not Masked"; desc = "not masked"; };
        };

        field {
            name = "inepnakeffmsk";
            desc = "IN endpoint NAK effective interrupt mask";
            sw = rw;
            hw = r;
            encode = DIEPEACHMSKN_inepnakeffmsk_enum;
            reset = 0x0;
        } inepnakeffmsk[6:6];

        enum DIEPEACHMSKN_intknepmismsk_enum {
            MASKED = 0 { name = "Masked"; desc = "masked"; };
            NOT_MASKED = 1 { name = "Not Masked"; desc = "not masked"; };
        };

        field {
            name = "intknepmismsk";
            desc = "IN token received with EP mismatch interrupt mask";
            sw = rw;
            hw = r;
            encode = DIEPEACHMSKN_intknepmismsk_enum;
            reset = 0x0;
        } intknepmismsk[5:5];

        enum DIEPEACHMSKN_intkntxfempmsk_enum {
            MASKED = 0 { name = "Masked"; desc = "masked"; };
            NOT_MASKED = 1 { name = "Not Masked"; desc = "not masked"; };
        };

        field {
            name = "intkntxfempmsk";
            desc = "IN token received when TX FIFO empty interrupt mask";
            sw = rw;
            hw = r;
            encode = DIEPEACHMSKN_intkntxfempmsk_enum;
            reset = 0x0;
        } intkntxfempmsk[4:4];

        enum DIEPEACHMSKN_timeoutmsk_enum {
            MASKED = 0 { name = "Masked"; desc = "masked"; };
            NOT_MASKED = 1 { name = "Not Masked"; desc = "not masked"; };
        };

        field {
            name = "timeoutmsk";
            desc = "Timeout interrupt mask (non-isochronous endpoints)";
            sw = rw;
            hw = r;
            encode = DIEPEACHMSKN_timeoutmsk_enum;
            reset = 0x0;
        } timeoutmsk[3:3];

        enum DIEPEACHMSKN_ahberrmsk_enum {
            MASKED = 0 { name = "Masked"; desc = "masked"; };
            NOT_MASKED = 1 { name = "Not Masked"; desc = "not masked"; };
        };

        field {
            name = "ahberrmsk";
            desc = "AHB error interrupt mask";
            sw = rw;
            hw = r;
            encode = DIEPEACHMSKN_ahberrmsk_enum;
            reset = 0x0;
        } ahberrmsk[2:2];

        enum DIEPEACHMSKN_epdisbldmsk_enum {
            MASKED = 0 { name = "Masked"; desc = "masked"; };
            NOT_MASKED = 1 { name = "Not Masked"; desc = "not masked"; };
        };

        field {
            name = "epdisbldmsk";
            desc = "Endpoint disable interrupt mask";
            sw = rw;
            hw = r;
            encode = DIEPEACHMSKN_epdisbldmsk_enum;
            reset = 0x0;
        } epdisbldmsk[1:1];

        enum DIEPEACHMSKN_xfercomplmsk_enum {
            MASKED = 0 { name = "Masked"; desc = "masked"; };
            NOT_MASKED = 1 { name = "Not Masked"; desc = "not masked"; };
        };

        field {
            name = "xfercomplmsk";
            desc = "Transfer completion interrupt mask";
            sw = rw;
            hw = r;
            encode = DIEPEACHMSKN_xfercomplmsk_enum;
            reset = 0x0;
        } xfercomplmsk[0:0];
    } DIEPEACHMSKN[16] @ 0x840 += 0x4;

    reg {
        name = "Interrupt register for device OUT endpoint n";
        desc = "DOEPEACHMSKN is an interrupt register for device OUT endpoint n.

Array: one register per OUT endpoint n (0..15) at 0x880 + 4 x n. The data sheet Total Reset Value 0x00800000 has a bit set inside the reserved field (bit 23), not modelled (the DWC_otg reset value of the register is 0).

Data sheet 12.7.5.2 DOEPEACHMSKN (offset 0x880, printed page 12-223, `Hi3518EV20X-Hi3516CV200-Datasheet.txt` line 89512).";

        enum DOEPEACHMSKN_nyetmsk_enum {
            MASKED = 0 { name = "Masked"; desc = "masked"; };
            NOT_MASKED = 1 { name = "Not Masked"; desc = "not masked"; };
        };

        field {
            name = "nyetmsk";
            desc = "NYET interrupt mask";
            sw = rw;
            hw = r;
            encode = DOEPEACHMSKN_nyetmsk_enum;
            reset = 0x0;
        } nyetmsk[14:14];

        enum DOEPEACHMSKN_nakmsk_enum {
            MASKED = 0 { name = "Masked"; desc = "masked"; };
            NOT_MASKED = 1 { name = "Not Masked"; desc = "not masked"; };
        };

        field {
            name = "nakmsk";
            desc = "NAK interrupt mask";
            sw = rw;
            hw = r;
            encode = DOEPEACHMSKN_nakmsk_enum;
            reset = 0x0;
        } nakmsk[13:13];

        enum DOEPEACHMSKN_bbleerrmsk_enum {
            MASKED = 0 { name = "Masked"; desc = "masked"; };
            NOT_MASKED = 1 { name = "Not Masked"; desc = "not masked"; };
        };

        field {
            name = "bbleerrmsk";
            desc = "Babble error interrupt mask";
            sw = rw;
            hw = r;
            encode = DOEPEACHMSKN_bbleerrmsk_enum;
            reset = 0x0;
        } bbleerrmsk[12:12];

        enum DOEPEACHMSKN_bnaoutintrmsk_enum {
            MASKED = 0 { name = "Masked"; desc = "masked"; };
            NOT_MASKED = 1 { name = "Not Masked"; desc = "not masked"; };
        };

        field {
            name = "bnaoutintrmsk";
            desc = "BNA interrupt mask";
            sw = rw;
            hw = r;
            encode = DOEPEACHMSKN_bnaoutintrmsk_enum;
            reset = 0x0;
        } bnaoutintrmsk[9:9];

        enum DOEPEACHMSKN_outpkterrmsk_enum {
            MASKED = 0 { name = "Masked"; desc = "masked"; };
            NOT_MASKED = 1 { name = "Not Masked"; desc = "not masked"; };
        };

        field {
            name = "outpkterrmsk";
            desc = "OUT packet error interrupt mask";
            sw = rw;
            hw = r;
            encode = DOEPEACHMSKN_outpkterrmsk_enum;
            reset = 0x0;
        } outpkterrmsk[8:8];

        enum DOEPEACHMSKN_back2backsetup_enum {
            MASKED = 0 { name = "Masked"; desc = "masked"; };
            NOT_MASKED = 1 { name = "Not Masked"; desc = "not masked"; };
        };

        field {
            name = "back2backsetup";
            desc = "Back-to-back setup packets received interrupt mask";
            sw = rw;
            hw = r;
            encode = DOEPEACHMSKN_back2backsetup_enum;
            reset = 0x0;
        } back2backsetup[6:6];

        enum DOEPEACHMSKN_outtknepdismsk_enum {
            MASKED = 0 { name = "Masked"; desc = "masked"; };
            NOT_MASKED = 1 { name = "Not Masked"; desc = "not masked"; };
        };

        field {
            name = "outtknepdismsk";
            desc = "OUT token received when endpoint disabled interrupt mask";
            sw = rw;
            hw = r;
            encode = DOEPEACHMSKN_outtknepdismsk_enum;
            reset = 0x0;
        } outtknepdismsk[4:4];

        enum DOEPEACHMSKN_setupmsk_enum {
            MASKED = 0 { name = "Masked"; desc = "masked"; };
            NOT_MASKED = 1 { name = "Not Masked"; desc = "not masked"; };
        };

        field {
            name = "setupmsk";
            desc = "Setup phase done interrupt mask";
            sw = rw;
            hw = r;
            encode = DOEPEACHMSKN_setupmsk_enum;
            reset = 0x0;
        } setupmsk[3:3];

        enum DOEPEACHMSKN_ahberrmsk_enum {
            MASKED = 0 { name = "Masked"; desc = "masked"; };
            NOT_MASKED = 1 { name = "Not Masked"; desc = "not masked"; };
        };

        field {
            name = "ahberrmsk";
            desc = "AHB error interrupt mask";
            sw = rw;
            hw = r;
            encode = DOEPEACHMSKN_ahberrmsk_enum;
            reset = 0x0;
        } ahberrmsk[2:2];

        enum DOEPEACHMSKN_epdisbldmsk_enum {
            MASKED = 0 { name = "Masked"; desc = "masked"; };
            NOT_MASKED = 1 { name = "Not Masked"; desc = "not masked"; };
        };

        field {
            name = "epdisbldmsk";
            desc = "Endpoint disabled interrupt mask";
            sw = rw;
            hw = r;
            encode = DOEPEACHMSKN_epdisbldmsk_enum;
            reset = 0x0;
        } epdisbldmsk[1:1];

        enum DOEPEACHMSKN_xfercomplmsk_enum {
            MASKED = 0 { name = "Masked"; desc = "masked"; };
            NOT_MASKED = 1 { name = "Not Masked"; desc = "not masked"; };
        };

        field {
            name = "xfercomplmsk";
            desc = "Transfer completion interrupt mask";
            sw = rw;
            hw = r;
            encode = DOEPEACHMSKN_xfercomplmsk_enum;
            reset = 0x0;
        } xfercomplmsk[0:0];
    } DOEPEACHMSKN[16] @ 0x880 += 0x4;

    eHISI_USB_DEVICE_INEP0   IN_EP0   @ 0x900;
    eHISI_USB_DEVICE_INEP    IN_EP[15]  @ 0x920 += 0x20;
    eHISI_USB_DEVICE_OUTEP0  OUT_EP0  @ 0xB00;
    eHISI_USB_DEVICE_OUTEP   OUT_EP[15] @ 0xB20 += 0x20;

};

`endif
