`ifndef HISI_MISC_CTRL_RDL
`define HISI_MISC_CTRL_RDL

regfile eHISI_MISC_CTRL {
    name = "MISC control registers, Hi3518E V20X / Hi3516C V200";
    desc = "
    Peripheral control (`MISC_CTRLn`, data sheet 3.5.5) at 0x20120000: SPI/UART/SDIO glue, bus priorities and QoS for the media AXI buses, USB controller/PHY glue
    (MISC_CTRL30), ACODEC control (MISC_CTRL49..54), memory timing adjustment and the eMMC DLL. Registers not listed are not implemented/not documented. Several registers
    cannot be soft reset (stated in their description). MISC_CTRL32 (0x80) is not in the data sheet and is modelled from the vendor USB driver.
    ";

    reg {
        name = "MISC register 1";
        desc = "MISC_CTRL1 is MISC register 1. This register cannot be soft reset.

This register cannot be soft reset. bootrom_pgen powers the BOOTROM off after boot.

Vendor use: the vendor DDR training (ddr_ddrt_prepare_custom, arch/arm/cpu/hi3518ev200/ddr_training_custom.c) sets tde_ddrt_mst_sel (bit 2) so the DDRT test module reaches the DDR, and the vendor register table clears ive_gzip_mst_sel (bit 12) before DDR init. Live: 0x00200004 at U-Boot (bit 2 left set after training, mipi_phy_mode 2), 0x00201000 under the SDK kernel (bit 2 cleared, ive_gzip_mst_sel set).

Data sheet 3.5.5.2 MISC_CTRL1 (offset 0x4, printed page 3-61, `hi3518ev200-datasheet.txt` line 25509).";

        enum MISC_CTRL1_vicap_vpss_online_enum {
            OFFLINE_MODE = 0 { name = "Offline Mode"; desc = "offline mode"; };
            ONLINE_MODE = 1 { name = "Online Mode"; desc = "online mode"; };
        };

        field {
            name = "vicap_vpss_online";
            desc = "VICAP and VPSS mode";
            sw = rw;
            hw = r;
            encode = MISC_CTRL1_vicap_vpss_online_enum;
            reset = 0x0;
        } vicap_vpss_online[30:30];

        enum MISC_CTRL1_ssp1_cs_sel_enum {
            CS0 = 0 { name = "Cs0"; desc = "CS0"; };
            CS1_1X_RESERVED = 1 { name = "Cs1 1X Reserved"; desc = "CS1 1x: reserved"; };
        };

        field {
            name = "ssp1_cs_sel";
            desc = "SSP1 CS select";
            sw = rw;
            hw = r;
            encode = MISC_CTRL1_ssp1_cs_sel_enum;
            reset = 0x0;
        } ssp1_cs_sel[27:26];

        enum MISC_CTRL1_mipi_phy_mode_enum {
            MIPI_MODE = 0 { name = "Mipi Mode"; desc = "MIPI mode"; };
            LVDS_MODE = 1 { name = "Lvds Mode"; desc = "LVDS mode"; };
            CMOS_MODE = 2 { name = "Cmos Mode"; desc = "CMOS mode"; };
            BYPASS_MODE = 3 { name = "Bypass Mode"; desc = "bypass mode"; };
        };

        field {
            name = "mipi_phy_mode";
            desc = "MIPI PHY mode";
            sw = rw;
            hw = r;
            encode = MISC_CTRL1_mipi_phy_mode_enum;
            reset = 0x1;
        } mipi_phy_mode[21:20];

        enum MISC_CTRL1_ive_gzip_mst_sel_enum {
            GZIP = 0 { name = "Gzip"; desc = "GZIP"; };
            IVE = 1 { name = "Ive"; desc = "IVE"; };
        };

        field {
            name = "ive_gzip_mst_sel";
            desc = "IVE/GZIP access select through media1 AXI";
            sw = rw;
            hw = r;
            encode = MISC_CTRL1_ive_gzip_mst_sel_enum;
            reset = 0x0;
        } ive_gzip_mst_sel[12:12];

        enum MISC_CTRL1_spi1_cs1_ctrl_enum {
            NOT_INVERTED = 0 { name = "Not Inverted"; desc = "not inverted"; };
            INVERTED = 1 { name = "Inverted"; desc = "inverted"; };
        };

        field {
            name = "spi1_cs1_ctrl";
            desc = "Reverse control for the spi1_cs1 signal";
            sw = rw;
            hw = r;
            encode = MISC_CTRL1_spi1_cs1_ctrl_enum;
            reset = 0x0;
        } spi1_cs1_ctrl[10:10];

        enum MISC_CTRL1_spi1_cs0_ctrl_enum {
            NOT_INVERTED = 0 { name = "Not Inverted"; desc = "not inverted"; };
            INVERTED = 1 { name = "Inverted"; desc = "inverted"; };
        };

        field {
            name = "spi1_cs0_ctrl";
            desc = "Reverse control for the spi1_cs0 signal";
            sw = rw;
            hw = r;
            encode = MISC_CTRL1_spi1_cs0_ctrl_enum;
            reset = 0x0;
        } spi1_cs0_ctrl[9:9];

        enum MISC_CTRL1_spi0_cs0_ctrl_enum {
            NOT_INVERTED = 0 { name = "Not Inverted"; desc = "not inverted"; };
            INVERTED = 1 { name = "Inverted"; desc = "inverted"; };
        };

        field {
            name = "spi0_cs0_ctrl";
            desc = "Reverse control for the spi0_cs0 signal";
            sw = rw;
            hw = r;
            encode = MISC_CTRL1_spi0_cs0_ctrl_enum;
            reset = 0x0;
        } spi0_cs0_ctrl[8:8];

        enum MISC_CTRL1_uart1_rts_ctrl_enum {
            NOT_INVERTED = 0 { name = "Not Inverted"; desc = "not inverted"; };
            INVERTED = 1 { name = "Inverted"; desc = "inverted"; };
        };

        field {
            name = "uart1_rts_ctrl";
            desc = "Reverse control for the uart1_rts signal";
            sw = rw;
            hw = r;
            encode = MISC_CTRL1_uart1_rts_ctrl_enum;
            reset = 0x0;
        } uart1_rts_ctrl[7:7];

        enum MISC_CTRL1_bootrom_pgen_enum {
            POWERED = 0 { name = "Powered"; desc = "powered on"; };
            POWERED_OFF = 1 { name = "Powered Off"; desc = "powered off"; };
        };

        field {
            name = "bootrom_pgen";
            desc = "BOOTROM power supply control";
            sw = rw;
            hw = r;
            encode = MISC_CTRL1_bootrom_pgen_enum;
            reset = 0x0;
        } bootrom_pgen[6:6];

        enum MISC_CTRL1_bootram1_ck_gt_en_enum {
            ENABLED = 0 { name = "Enabled"; desc = "enabled"; };
            DISABLED = 1 { name = "Disabled"; desc = "disabled"; };
        };

        field {
            name = "bootram1_ck_gt_en";
            desc = "BOOTRAM1 clock enable";
            sw = rw;
            hw = r;
            encode = MISC_CTRL1_bootram1_ck_gt_en_enum;
            reset = 0x0;
        } bootram1_ck_gt_en[4:4];

        enum MISC_CTRL1_bootram0_ck_gt_en_enum {
            ENABLED = 0 { name = "Enabled"; desc = "enabled"; };
            DISABLED = 1 { name = "Disabled"; desc = "disabled"; };
        };

        field {
            name = "bootram0_ck_gt_en";
            desc = "BOOTRAM0 clock enable";
            sw = rw;
            hw = r;
            encode = MISC_CTRL1_bootram0_ck_gt_en_enum;
            reset = 0x0;
        } bootram0_ck_gt_en[3:3];

        enum MISC_CTRL1_tde_ddrt_mst_sel_enum {
            TDE = 0 { name = "Tde"; desc = "TDE"; };
            DDRT = 1 { name = "Ddrt"; desc = "DDRT"; };
        };

        field {
            name = "tde_ddrt_mst_sel";
            desc = "MDU/DDRT access select through media1 AXI";
            sw = rw;
            hw = r;
            encode = MISC_CTRL1_tde_ddrt_mst_sel_enum;
            reset = 0x0;
        } tde_ddrt_mst_sel[2:2];

        enum MISC_CTRL1_sdio1_card_det_mode_enum {
            NOT_INVERTED = 0 { name = "Not Inverted"; desc = "not inverted"; };
            INVERTED = 1 { name = "Inverted"; desc = "inverted"; };
        };

        field {
            name = "sdio1_card_det_mode";
            desc = "Reverse control for the SDIO1 card detection signal";
            sw = rw;
            hw = r;
            encode = MISC_CTRL1_sdio1_card_det_mode_enum;
            reset = 0x0;
        } sdio1_card_det_mode[1:1];

        enum MISC_CTRL1_sdio0_card_det_mode_enum {
            NOT_INVERTED = 0 { name = "Not Inverted"; desc = "not inverted"; };
            INVERTED = 1 { name = "Inverted"; desc = "inverted"; };
        };

        field {
            name = "sdio0_card_det_mode";
            desc = "Reverse control for the SDIO0 card detection signal";
            sw = rw;
            hw = r;
            encode = MISC_CTRL1_sdio0_card_det_mode_enum;
            reset = 0x0;
        } sdio0_card_det_mode[0:0];
    } MISC_CTRL1 @ 0x4;

    reg {
        name = "MISC register 2";
        desc = "MISC_CTRL2 is MISC register 2. This register cannot be soft reset.

Data sheet 3.5.5.2 MISC_CTRL2 (offset 0x8, printed page 3-63, `hi3518ev200-datasheet.txt` line 25610).";

        field {
            name = "arm9_mem_dly";
            desc = "ARM9 mem speed adjustment control";
            sw = rw;
            hw = r;
            reset = 0x1;
        } arm9_mem_dly[2:0];
    } MISC_CTRL2 @ 0x8;

    reg {
        name = "MISC register 3";
        desc = "MISC_CTRL3 is MISC register 3. This register cannot be soft reset.

Data sheet 3.5.5.2 MISC_CTRL3 (offset 0xC, printed page 3-63, `hi3518ev200-datasheet.txt` line 25636).";

        enum MISC_CTRL3_powerswitch_sel_mux_enum {
            SDIO0_CONTROLLER = 0 { name = "Sdio0 Controller"; desc = "SDIO0 controller"; };
            POWERSWITCH_SEL_REGISTER = 1 { name = "Powerswitch Sel Register"; desc = "powerswitch_sel register"; };
        };

        field {
            name = "powerswitch_sel_mux";
            desc = "Power switch source select";
            sw = rw;
            hw = r;
            encode = MISC_CTRL3_powerswitch_sel_mux_enum;
            reset = 0x0;
        } powerswitch_sel_mux[1:1];

        enum MISC_CTRL3_powerswitch_sel_enum {
            V_3_3_V = 0 { name = "V 3 3 V"; desc = "3.3 V"; };
            V_1_8_V = 1 { name = "V 1 8 V"; desc = "1.8 V"; };
        };

        field {
            name = "powerswitch_sel";
            desc = "Power switch select (valid only when powerswitch_sel_mux is 1)";
            sw = rw;
            hw = r;
            encode = MISC_CTRL3_powerswitch_sel_enum;
            reset = 0x0;
        } powerswitch_sel[0:0];
    } MISC_CTRL3 @ 0xC;

    reg {
        name = "MISC register 4";
        desc = "MISC_CTRL4 is MISC register 4. This register cannot be soft reset.

Hardware: a live dump reads 0x8000007B (bits 0, 1, 3, 4, 5, 6 and 31 set); the reserved bits [30:7] and bit 2 read 0 although the data sheet total reset value is 0xFFFFFFFF.

Data sheet 3.5.5.2 MISC_CTRL4 (offset 0x10, printed page 3-64, `hi3518ev200-datasheet.txt` line 25682).";

        enum MISC_CTRL4_avc_ret1n_bypass_enum {
            ENABLED = 0 { name = "Enabled"; desc = "enabled"; };
            BYPASSED = 1 { name = "Bypassed"; desc = "bypassed"; };
        };

        field {
            name = "avc_ret1n_bypass";
            desc = "AVC automatic mem ret1n function bypass";
            sw = rw;
            hw = r;
            encode = MISC_CTRL4_avc_ret1n_bypass_enum;
            reset = 0x1;
        } avc_ret1n_bypass[31:31];

        field {
            name = "reserved_nz_30_7";
            desc = "Reserved read-only bits. The data sheet total reset value of this register has these bits set (reset 0xFFFFFF), but a live dump from a Hi3518E V200 board (OpenIPC U-Boot and SDK Linux, 2026-11-10) reads 0 in them, so hardware reads 0 here and the reset is modelled as 0.";
            sw = r;
            hw = w;
            reset = 0x0;
        } reserved_nz_30_7[30:7];

        field {
            name = "sdio1_ret1n";
            desc = "mem ret1n signal in the SDIO1 CTRL. Set this signal to 1 when the SDIO1 CTRL is enabled or set this signal to 0 when the SDIO1 CTRL is disabled to reduce mem power consumption.";
            sw = rw;
            hw = r;
            reset = 0x1;
        } sdio1_ret1n[6:6];

        field {
            name = "sdio0_ret1n";
            desc = "mem ret1n signal in the SDIO0 CTRL. Set this signal to 1 when the SDIO0 CTRL is enabled or set this signal to 0 when the SDIO0 CTRL is disabled to reduce mem power consumption.";
            sw = rw;
            hw = r;
            reset = 0x1;
        } sdio0_ret1n[5:5];

        field {
            name = "reserved_nz_4_4";
            desc = "Reserved in the bit table, but the data sheet total reset value of this register has these bits set (reset 0x1).";
            sw = r;
            hw = w;
            reset = 0x1;
        } reserved_nz_4_4[4:4];

        field {
            name = "usb_ret1n";
            desc = "mem ret1n signal in the USB CTRL. Set this signal to 1 when the USB CTRL is enabled or set this signal to 0 when the USB CTRL is disabled to reduce mem power consumption.";
            sw = rw;
            hw = r;
            reset = 0x1;
        } usb_ret1n[3:3];

        field {
            name = "reserved_nz_2_2";
            desc = "Reserved read-only bits. The data sheet total reset value of this register has these bits set (reset 0x1), but a live dump from a Hi3518E V200 board (OpenIPC U-Boot and SDK Linux, 2026-11-10) reads 0 in them, so hardware reads 0 here and the reset is modelled as 0.";
            sw = r;
            hw = w;
            reset = 0x0;
        } reserved_nz_2_2[2:2];

        field {
            name = "cipher_ret1n";
            desc = "mem ret1n signal in the cipher. Set this signal to 1 when the cipher is enabled or set this signal to 0 when the cipher is disabled to reduce mem power consumption.";
            sw = rw;
            hw = r;
            reset = 0x1;
        } cipher_ret1n[1:1];

        field {
            name = "bootram_ret1n";
            desc = "mem ret1n signal in the BOOTROM. Set this signal to 1 when the BOOTROM is enabled or set this signal to 0 when the BOOTROM is disabled to reduce mem power consumption.";
            sw = rw;
            hw = r;
            reset = 0x1;
        } bootram_ret1n[0:0];
    } MISC_CTRL4 @ 0x10;

    reg {
        name = "MISC register 6";
        desc = "MISC_CTRL6 is MISC register 6.

Data sheet 3.5.5.2 MISC_CTRL6 (offset 0x18, printed page 3-65, `hi3518ev200-datasheet.txt` line 25737).";

        enum MISC_CTRL6_sysaxi_timeout_en_m2_enum {
            DISABLED = 0 { name = "Disabled"; desc = "disabled"; };
            ENABLED = 1 { name = "Enabled"; desc = "enabled"; };
        };

        field {
            name = "sysaxi_timeout_en_m2";
            desc = "Timeout count enable for the SYS AXI bus M2 port (AHB0)";
            sw = rw;
            hw = r;
            encode = MISC_CTRL6_sysaxi_timeout_en_m2_enum;
            reset = 0x0;
        } sysaxi_timeout_en_m2[31:31];

        field {
            name = "sysaxi_timeout_value_m2";
            desc = "Timeout count value of the SYS AXI bus M2 port (AHB0) Count value = sysaxi_timeout_value_m2 x 2";
            sw = rw;
            hw = r;
            reset = 0x0;
        } sysaxi_timeout_value_m2[30:16];

        enum MISC_CTRL6_sysaxi_timeout_en_m1_enum {
            DISABLED = 0 { name = "Disabled"; desc = "disabled"; };
            ENABLED = 1 { name = "Enabled"; desc = "enabled"; };
        };

        field {
            name = "sysaxi_timeout_en_m1";
            desc = "Timeout count enable for the SYS AXI bus M1 port (CPU)";
            sw = rw;
            hw = r;
            encode = MISC_CTRL6_sysaxi_timeout_en_m1_enum;
            reset = 0x0;
        } sysaxi_timeout_en_m1[15:15];

        field {
            name = "sysaxi_timeout_value_m1";
            desc = "Timeout count value of the SYS AXI bus M1 port (CPU) Count value = sysaxi_timeout_value_m1 x 2";
            sw = rw;
            hw = r;
            reset = 0x0;
        } sysaxi_timeout_value_m1[14:0];
    } MISC_CTRL6 @ 0x18;

    reg {
        name = "MISC register 7";
        desc = "MISC_CTRL7 is MISC register 7.

Data sheet 3.5.5.2 MISC_CTRL7 (offset 0x1C, printed page 3-66, `hi3518ev200-datasheet.txt` line 25786).";

        enum MISC_CTRL7_sysaxi_timeout_en_m3_enum {
            DISABLED = 0 { name = "Disabled"; desc = "disabled"; };
            ENABLED = 1 { name = "Enabled"; desc = "enabled"; };
        };

        field {
            name = "sysaxi_timeout_en_m3";
            desc = "Timeout count enable for the SYS AXI bus M3 port (AHB1)";
            sw = rw;
            hw = r;
            encode = MISC_CTRL7_sysaxi_timeout_en_m3_enum;
            reset = 0x0;
        } sysaxi_timeout_en_m3[15:15];

        field {
            name = "sysaxi_timeout_value_m3";
            desc = "Timeout count value of the SYS AXI bus M3 port (AHB1) Count value = sysaxi_timeout_value_m3 x 2";
            sw = rw;
            hw = r;
            reset = 0x0;
        } sysaxi_timeout_value_m3[14:0];
    } MISC_CTRL7 @ 0x1C;

    reg {
        name = "MISC register 8";
        desc = "MISC_CTRL8 is MISC register 8.

Data sheet 3.5.5.2 MISC_CTRL8 (offset 0x20, printed page 3-66, `hi3518ev200-datasheet.txt` line 25821).";

        field {
            name = "sysaxi_port3_pri";
            desc = "Priority of the SYS AXI bus M3 port (AHB1) The value 3 indicates the highest priority.";
            sw = rw;
            hw = r;
            reset = 0x0;
        } sysaxi_port3_pri[10:8];

        field {
            name = "sysaxi_port2_pri";
            desc = "Priority of the SYS AXI bus M2 port (AHB0) The value 3 indicates the highest priority.";
            sw = rw;
            hw = r;
            reset = 0x1;
        } sysaxi_port2_pri[6:4];

        field {
            name = "sysaxi_port1_pri";
            desc = "Priority of the SYS AXI bus M1 port (CPU) The value 3 indicates the highest priority.";
            sw = rw;
            hw = r;
            reset = 0x2;
        } sysaxi_port1_pri[2:0];
    } MISC_CTRL8 @ 0x20;

    reg {
        name = "MISC register 9";
        desc = "MISC_CTRL9 is MISC register 9.

DS inconsistency: the bit row of the data sheet gives resets that do not match the header; the header total reset 0x123 is modelled (s1 = 3, s2 = 2, s3 = 1, s4 = 0).

Data sheet 3.5.5.2 MISC_CTRL9 (offset 0x24, printed page 3-67, `hi3518ev200-datasheet.txt` line 25869).";

        field {
            name = "sysaxi_slave_priority_s4";
            desc = "Bus access priority of the SYS AXI s4 (mddrc) port The value 3 indicates the highest priority.";
            sw = rw;
            hw = r;
            reset = 0x0;
        } sysaxi_slave_priority_s4[14:12];

        field {
            name = "sysaxi_slave_priority_s3";
            desc = "Bus access priority of the SYS AXI s3 (mediaapb) port The value 3 indicates the highest priority.";
            sw = rw;
            hw = r;
            reset = 0x1;
        } sysaxi_slave_priority_s3[10:8];

        field {
            name = "sysaxi_slave_priority_s2";
            desc = "Bus access priority of the SYS AXI s2 (sysapb) port The value 3 indicates the highest priority.";
            sw = rw;
            hw = r;
            reset = 0x2;
        } sysaxi_slave_priority_s2[6:4];

        field {
            name = "sysaxi_slave_priority_s1";
            desc = "Bus access priority of the SYS AXI s1 (ahb_cfg) port The value 3 indicates the highest priority.";
            sw = rw;
            hw = r;
            reset = 0x3;
        } sysaxi_slave_priority_s1[2:0];
    } MISC_CTRL9 @ 0x24;

    reg {
        name = "MISC register 11";
        desc = "MISC_CTRL11 is MISC register 11.

Data sheet 3.5.5.2 MISC_CTRL11 (offset 0x2C, printed page 3-68, `hi3518ev200-datasheet.txt` line 25923).";

        enum MISC_CTRL11_media0axi_timeout_en_m2_enum {
            DISABLED = 0 { name = "Disabled"; desc = "disabled"; };
            ENABLED = 1 { name = "Enabled"; desc = "enabled"; };
        };

        field {
            name = "media0axi_timeout_en_m2";
            desc = "Timeout count enable for the MDA0 AXI bus M2 port (VGS)";
            sw = rw;
            hw = r;
            encode = MISC_CTRL11_media0axi_timeout_en_m2_enum;
            reset = 0x0;
        } media0axi_timeout_en_m2[31:31];

        field {
            name = "media0axi_timeout_value_m2";
            desc = "Timeout count value of the MDA0 AXI bus M2 port (VGS) Count value = media0axi_timeout_value_m2 x 2";
            sw = rw;
            hw = r;
            reset = 0x0;
        } media0axi_timeout_value_m2[30:16];

        enum MISC_CTRL11_media0axi_timeout_en_m1_enum {
            DISABLED = 0 { name = "Disabled"; desc = "disabled"; };
            ENABLED = 1 { name = "Enabled"; desc = "enabled"; };
        };

        field {
            name = "media0axi_timeout_en_m1";
            desc = "Timeout count enable for the MDA0 AXI bus M1 port (AVC)";
            sw = rw;
            hw = r;
            encode = MISC_CTRL11_media0axi_timeout_en_m1_enum;
            reset = 0x0;
        } media0axi_timeout_en_m1[15:15];

        field {
            name = "media0axi_timeout_value_m1";
            desc = "Timeout count value of the MDA0 AXI bus M1 port (AVC) Count value = media0axi_timeout_value_m1 x 2";
            sw = rw;
            hw = r;
            reset = 0x0;
        } media0axi_timeout_value_m1[14:0];
    } MISC_CTRL11 @ 0x2C;

    reg {
        name = "MISC register 14";
        desc = "MISC_CTRL14 is MISC register 14.

DS inconsistency: header total reset 0x1 (port1 = 1, port2 = 0, as modelled) vs bit row (port2 = 2, port1 = 3). The text says value 1 is the highest priority. Needs a hardware read.

Data sheet 3.5.5.2 MISC_CTRL14 (offset 0x38, printed page 3-69, `hi3518ev200-datasheet.txt` line 25975).";

        field {
            name = "media0axi_port2_pri";
            desc = "Priority of the media 0 AXI bus M2 port (VGS) The value 1 indicates the highest priority.";
            sw = rw;
            hw = r;
            reset = 0x0;
        } media0axi_port2_pri[6:4];

        field {
            name = "media0axi_port1_pri";
            desc = "Priority of the media 0 AXI bus M1 port (AVC) The value 1 indicates the highest priority.";
            sw = rw;
            hw = r;
            reset = 0x1;
        } media0axi_port1_pri[2:0];
    } MISC_CTRL14 @ 0x38;

    reg {
        name = "MISC register 15";
        desc = "MISC_CTRL15 is MISC register 15.

Data sheet 3.5.5.2 MISC_CTRL15 (offset 0x3C, printed page 3-70, `hi3518ev200-datasheet.txt` line 26020).";

        enum MISC_CTRL15_media1axi_timeout_en_m2_enum {
            DISABLED = 0 { name = "Disabled"; desc = "disabled"; };
            ENABLED = 1 { name = "Enabled"; desc = "enabled"; };
        };

        field {
            name = "media1axi_timeout_en_m2";
            desc = "Timeout count enable for the media 1 AXI bus M2 port (JPGE)";
            sw = rw;
            hw = r;
            encode = MISC_CTRL15_media1axi_timeout_en_m2_enum;
            reset = 0x0;
        } media1axi_timeout_en_m2[31:31];

        field {
            name = "media1axi_timeout_value_m2";
            desc = "Timeout count value of the media 1 AXI bus M2 port (JPGE) Count value = media1axi_timeout_value_m2 x 2";
            sw = rw;
            hw = r;
            reset = 0x0;
        } media1axi_timeout_value_m2[30:16];

        enum MISC_CTRL15_media1axi_timeout_en_m1_enum {
            DISABLED = 0 { name = "Disabled"; desc = "disabled"; };
            ENABLED = 1 { name = "Enabled"; desc = "enabled"; };
        };

        field {
            name = "media1axi_timeout_en_m1";
            desc = "Timeout count enable for the media 1 AXI bus M1 port (TDE_DDRT)";
            sw = rw;
            hw = r;
            encode = MISC_CTRL15_media1axi_timeout_en_m1_enum;
            reset = 0x0;
        } media1axi_timeout_en_m1[15:15];

        field {
            name = "media1axi_timeout_value_m1";
            desc = "Timeout count value of the media 1 AXI bus M1 port (TDE_DDRT) Count value = media1axi_timeout_value_m1 x 2";
            sw = rw;
            hw = r;
            reset = 0x0;
        } media1axi_timeout_value_m1[14:0];
    } MISC_CTRL15 @ 0x3C;

    reg {
        name = "MISC register 16";
        desc = "MISC_CTRL16 is MISC register 16.

Data sheet 3.5.5.2 MISC_CTRL16 (offset 0x40, printed page 3-71, `hi3518ev200-datasheet.txt` line 26069).";

        enum MISC_CTRL16_media1axi_timeout_en_m4_enum {
            DISABLED = 0 { name = "Disabled"; desc = "disabled"; };
            ENABLED = 1 { name = "Enabled"; desc = "enabled"; };
        };

        field {
            name = "media1axi_timeout_en_m4";
            desc = "Timeout count enable for the media 1 AXI bus M4 port (IVE_GZIP)";
            sw = rw;
            hw = r;
            encode = MISC_CTRL16_media1axi_timeout_en_m4_enum;
            reset = 0x0;
        } media1axi_timeout_en_m4[31:31];

        field {
            name = "media1axi_timeout_value_m4";
            desc = "Timeout count value of the media 1 AXI bus M4 port (IVE_GZIP) Count value = media1axi_timeout_value_m4 x 2";
            sw = rw;
            hw = r;
            reset = 0x0;
        } media1axi_timeout_value_m4[30:16];

        enum MISC_CTRL16_media1axi_timeout_en_m3_enum {
            DISABLED = 0 { name = "Disabled"; desc = "disabled"; };
            ENABLED = 1 { name = "Enabled"; desc = "enabled"; };
        };

        field {
            name = "media1axi_timeout_en_m3";
            desc = "Timeout count enable for the media 1 AXI bus M3 port (AIAO)";
            sw = rw;
            hw = r;
            encode = MISC_CTRL16_media1axi_timeout_en_m3_enum;
            reset = 0x0;
        } media1axi_timeout_en_m3[15:15];

        field {
            name = "media1axi_timeout_value_m3";
            desc = "Timeout count value of the media 1 AXI bus M3 port (AIAO) Count value = media1axi_timeout_value_m3 x 2";
            sw = rw;
            hw = r;
            reset = 0x0;
        } media1axi_timeout_value_m3[14:0];
    } MISC_CTRL16 @ 0x40;

    reg {
        name = "MISC register 18";
        desc = "MISC_CTRL18 is MISC register 18.

Data sheet 3.5.5.2 MISC_CTRL18 (offset 0x48, printed page 3-72, `hi3518ev200-datasheet.txt` line 26117).";

        field {
            name = "media1axi_port4_pri";
            desc = "Priority of the media 1 AXI bus port 4 (the data sheet text is empty; named after the register description of MISC_CTRL14).";
            sw = rw;
            hw = r;
            reset = 0x0;
        } media1axi_port4_pri[14:12];

        field {
            name = "media1axi_port3_pri";
            desc = "Priority of the media 1 AXI bus port 3 (the data sheet text is empty; named after the register description of MISC_CTRL14).";
            sw = rw;
            hw = r;
            reset = 0x1;
        } media1axi_port3_pri[10:8];

        field {
            name = "media1axi_port2_pri";
            desc = "Priority of the media 1 AXI bus port 2 (the data sheet text is empty; named after the register description of MISC_CTRL14).";
            sw = rw;
            hw = r;
            reset = 0x2;
        } media1axi_port2_pri[6:4];

        field {
            name = "media1axi_port1_pri";
            desc = "Priority of the media 1 AXI bus port 1 (the data sheet text is empty; named after the register description of MISC_CTRL14).";
            sw = rw;
            hw = r;
            reset = 0x3;
        } media1axi_port1_pri[2:0];
    } MISC_CTRL18 @ 0x48;

    reg {
        name = "MISC register 22";
        desc = "MISC_CTRL22 is MISC register 22.

Data sheet 3.5.5.2 MISC_CTRL22 (offset 0x58, printed page 3-73, `hi3518ev200-datasheet.txt` line 26172).";

        field {
            name = "reserved_nz_31_28";
            desc = "Reserved read-only bits. The data sheet total reset value of this register has these bits set (reset 0x7), but a live dump from a Hi3518E V200 board (OpenIPC U-Boot and SDK Linux, 2026-11-10) reads 0 in them, so hardware reads 0 here and the reset is modelled as 0.";
            sw = r;
            hw = w;
            reset = 0x0;
        } reserved_nz_31_28[31:28];

        field {
            name = "hash_qosmap";
            desc = "QoS value of the hash in the MDDRC";
            sw = rw;
            hw = r;
            reset = 0x6;
        } hash_qosmap[27:24];

        field {
            name = "ive_gzip_qosmap";
            desc = "QoS value of the ive_gzip in the MDDRC";
            sw = rw;
            hw = r;
            reset = 0x5;
        } ive_gzip_qosmap[23:20];

        field {
            name = "aio_qosmap";
            desc = "QoS value of the AIAO in the MDDRC";
            sw = rw;
            hw = r;
            reset = 0x4;
        } aio_qosmap[19:16];

        field {
            name = "jpge_qosmap";
            desc = "QoS value of the JPGE in the MDDRC";
            sw = rw;
            hw = r;
            reset = 0x3;
        } jpge_qosmap[15:12];

        field {
            name = "tde_ddrt_qosmap";
            desc = "QoS value of the tde_ddrt in the MDDRC";
            sw = rw;
            hw = r;
            reset = 0x2;
        } tde_ddrt_qosmap[11:8];

        field {
            name = "vicap_qosmap";
            desc = "QoS value of the VICAP in the MDDRC";
            sw = rw;
            hw = r;
            reset = 0x1;
        } vicap_qosmap[7:4];

        field {
            name = "vdp_qosmap";
            desc = "QoS value of the VDP in the MDDRC";
            sw = rw;
            hw = r;
            reset = 0x0;
        } vdp_qosmap[3:0];
    } MISC_CTRL22 @ 0x58;

    reg {
        name = "MISC register 23";
        desc = "MISC_CTRL23 is MISC register 23.

Data sheet 3.5.5.2 MISC_CTRL23 (offset 0x5C, printed page 3-73, `hi3518ev200-datasheet.txt` line 26199).";

        field {
            name = "reserved_nz_31_24";
            desc = "Reserved read-only bits. The data sheet total reset value of this register has these bits set (reset 0x76), but a live dump from a Hi3518E V200 board (OpenIPC U-Boot and SDK Linux, 2026-11-10) reads 0 in them, so hardware reads 0 here and the reset is modelled as 0.";
            sw = r;
            hw = w;
            reset = 0x0;
        } reserved_nz_31_24[31:24];

        field {
            name = "fmc_qosmap";
            desc = "QoS value of the FMC in the MDDRC";
            sw = rw;
            hw = r;
            reset = 0x5;
        } fmc_qosmap[23:20];

        field {
            name = "sdio1_qosmap";
            desc = "QoS value of SDIO1 in the MDDRC";
            sw = rw;
            hw = r;
            reset = 0x4;
        } sdio1_qosmap[19:16];

        field {
            name = "sdio0_qosmap";
            desc = "QoS value of SDIO0 in the MDDRC";
            sw = rw;
            hw = r;
            reset = 0x3;
        } sdio0_qosmap[15:12];

        field {
            name = "cpu_qosmap";
            desc = "QoS value of the CPU in the MDDRC";
            sw = rw;
            hw = r;
            reset = 0x2;
        } cpu_qosmap[11:8];

        field {
            name = "vpss_qosmap";
            desc = "QoS value of the VPSS in the MDDRC";
            sw = rw;
            hw = r;
            reset = 0x1;
        } vpss_qosmap[7:4];

        field {
            name = "vgs_qosmap";
            desc = "QoS value of the VGS in the MDDRC";
            sw = rw;
            hw = r;
            reset = 0x0;
        } vgs_qosmap[3:0];
    } MISC_CTRL23 @ 0x5C;

    reg {
        name = "MISC register 24";
        desc = "MISC_CTRL24 is MISC register 24.

Data sheet 3.5.5.2 MISC_CTRL24 (offset 0x60, printed page 3-74, `hi3518ev200-datasheet.txt` line 26229).";

        field {
            name = "reserved_nz_31_24";
            desc = "Reserved read-only bits. The data sheet total reset value of this register has these bits set (reset 0x76), but a live dump from a Hi3518E V200 board (OpenIPC U-Boot and SDK Linux, 2026-11-10) reads 0 in them, so hardware reads 0 here and the reset is modelled as 0.";
            sw = r;
            hw = w;
            reset = 0x0;
        } reserved_nz_31_24[31:24];

        field {
            name = "avc_qosmap";
            desc = "QoS value of the AVC in the MDDRC";
            sw = rw;
            hw = r;
            reset = 0x5;
        } avc_qosmap[23:20];

        field {
            name = "usb_qosmap";
            desc = "QoS value of the USB in the MDDRC";
            sw = rw;
            hw = r;
            reset = 0x4;
        } usb_qosmap[19:16];

        field {
            name = "cipher_qosmap";
            desc = "QoS value of the cipher in the MDDRC";
            sw = rw;
            hw = r;
            reset = 0x3;
        } cipher_qosmap[15:12];

        field {
            name = "dma2_qosmap";
            desc = "QoS value of DMA2 in the MDDRC";
            sw = rw;
            hw = r;
            reset = 0x2;
        } dma2_qosmap[11:8];

        field {
            name = "dma1_qosmap";
            desc = "QoS value of DMA1 in the MDDRC";
            sw = rw;
            hw = r;
            reset = 0x1;
        } dma1_qosmap[7:4];

        field {
            name = "eth_qosmap";
            desc = "QoS value of the ETH in the MDDRC";
            sw = rw;
            hw = r;
            reset = 0x0;
        } eth_qosmap[3:0];
    } MISC_CTRL24 @ 0x60;

    reg {
        name = "MISC register 25";
        desc = "MISC_CTRL25 is MISC register 25.

Data sheet 3.5.5.2 MISC_CTRL25 (offset 0x64, printed page 3-74, `hi3518ev200-datasheet.txt` line 26254).";

        field {
            name = "reserved_nz_31_28";
            desc = "Reserved read-only bits. The data sheet total reset value of this register has these bits set (reset 0x3), but a live dump from a Hi3518E V200 board (OpenIPC U-Boot and SDK Linux, 2026-11-10) reads 0 in them, so hardware reads 0 here and the reset is modelled as 0.";
            sw = r;
            hw = w;
            reset = 0x0;
        } reserved_nz_31_28[31:28];

        field {
            name = "hash_to";
            desc = "Timeout select for the hash in the MDDRC";
            sw = rw;
            hw = r;
            reset = 0x2;
        } hash_to[27:24];

        field {
            name = "ive_gzip_to";
            desc = "Timeout select for the ive_gzip in the MDDRC";
            sw = rw;
            hw = r;
            reset = 0x1;
        } ive_gzip_to[23:20];

        field {
            name = "aio_to";
            desc = "Timeout select for the AIAO in the MDDRC";
            sw = rw;
            hw = r;
            reset = 0x0;
        } aio_to[19:16];

        field {
            name = "jpge_to";
            desc = "Timeout select for the JPGE in the MDDRC";
            sw = rw;
            hw = r;
            reset = 0x3;
        } jpge_to[15:12];

        field {
            name = "tde_ddrt_to";
            desc = "Timeout select for the tde_ddrt in the MDDRC";
            sw = rw;
            hw = r;
            reset = 0x2;
        } tde_ddrt_to[11:8];

        field {
            name = "vicap_to";
            desc = "Timeout select for the VICAP in the MDDRC";
            sw = rw;
            hw = r;
            reset = 0x1;
        } vicap_to[7:4];

        field {
            name = "vdp_to";
            desc = "Timeout select for the VDP in the MDDRC";
            sw = rw;
            hw = r;
            reset = 0x0;
        } vdp_to[3:0];
    } MISC_CTRL25 @ 0x64;

    reg {
        name = "MISC register 26";
        desc = "MISC_CTRL26 is MISC register 26.

Data sheet 3.5.5.2 MISC_CTRL26 (offset 0x68, printed page 3-75, `hi3518ev200-datasheet.txt` line 26287).";

        field {
            name = "reserved_nz_31_24";
            desc = "Reserved read-only bits. The data sheet total reset value of this register has these bits set (reset 0x32), but a live dump from a Hi3518E V200 board (OpenIPC U-Boot and SDK Linux, 2026-11-10) reads 0 in them, so hardware reads 0 here and the reset is modelled as 0.";
            sw = r;
            hw = w;
            reset = 0x0;
        } reserved_nz_31_24[31:24];

        field {
            name = "fmc_to";
            desc = "Timeout select for the FMC in the MDDRC";
            sw = rw;
            hw = r;
            reset = 0x1;
        } fmc_to[23:20];

        field {
            name = "sdio1_to";
            desc = "Timeout select for SDIO1 in the MDDRC";
            sw = rw;
            hw = r;
            reset = 0x0;
        } sdio1_to[19:16];

        field {
            name = "sdio0_to";
            desc = "Timeout select for SDIO0 in the MDDRC";
            sw = rw;
            hw = r;
            reset = 0x3;
        } sdio0_to[15:12];

        field {
            name = "cpu_to";
            desc = "Timeout select for the CPU in the MDDRC";
            sw = rw;
            hw = r;
            reset = 0x2;
        } cpu_to[11:8];

        field {
            name = "vpss_to";
            desc = "Timeout select for the VPSS in the MDDRC";
            sw = rw;
            hw = r;
            reset = 0x1;
        } vpss_to[7:4];

        field {
            name = "vgs_to";
            desc = "Timeout select for the VGS in the MDDRC";
            sw = rw;
            hw = r;
            reset = 0x0;
        } vgs_to[3:0];
    } MISC_CTRL26 @ 0x68;

    reg {
        name = "MISC register 27";
        desc = "MISC_CTRL27 is MISC register 27.

Data sheet 3.5.5.2 MISC_CTRL27 (offset 0x6C, printed page 3-75, `hi3518ev200-datasheet.txt` line 26312).";

        field {
            name = "reserved_nz_31_24";
            desc = "Reserved read-only bits. The data sheet total reset value of this register has these bits set (reset 0x32), but a live dump from a Hi3518E V200 board (OpenIPC U-Boot and SDK Linux, 2026-11-10) reads 0 in them, so hardware reads 0 here and the reset is modelled as 0.";
            sw = r;
            hw = w;
            reset = 0x0;
        } reserved_nz_31_24[31:24];

        field {
            name = "avc_to";
            desc = "Timeout select for the AVC in the MDDRC";
            sw = rw;
            hw = r;
            reset = 0x1;
        } avc_to[23:20];

        field {
            name = "usb_to";
            desc = "Timeout select for the USB in the MDDRC";
            sw = rw;
            hw = r;
            reset = 0x0;
        } usb_to[19:16];

        field {
            name = "cipher_to";
            desc = "Timeout select for the cipher in the MDDRC";
            sw = rw;
            hw = r;
            reset = 0x3;
        } cipher_to[15:12];

        field {
            name = "dma2_to";
            desc = "Timeout select for DMA2 in the MDDRC";
            sw = rw;
            hw = r;
            reset = 0x2;
        } dma2_to[11:8];

        field {
            name = "dma1_to";
            desc = "Timeout select for DMA1 in the MDDRC";
            sw = rw;
            hw = r;
            reset = 0x1;
        } dma1_to[7:4];

        field {
            name = "eth_to";
            desc = "Timeout select for the ETH in the MDDRC";
            sw = rw;
            hw = r;
            reset = 0x0;
        } eth_to[3:0];
    } MISC_CTRL27 @ 0x6C;

    reg {
        name = "MISC register 30";
        desc = "MISC_CTRL30 is MISC register 30.

USB controller/PHY glue (DS 12.7.3): host mode = usb_chipid 0 with both pull-downs (usb2_phy_dmpulldown/dppulldown) set to 1; device mode = usb_chipid 1 with both pull-downs 0. usbpwr_pctrl / usbovr_p_ctrl set the polarity of USB_PWREN and USB0/1_OVRCUR. Vendor U-Boot (hiusb-3518ev200.c) clears ss_word_if_i (8-bit UTMI), clears ss_ena_incr16_i, sets usbovr_p_ctrl, then writes the PHY tuning register at MISC + 0x80 (MISC_CTRL32, not in the data sheet).

Hardware (Hi3518E V200 board, OpenIPC U-Boot and SDK Linux 4.9.37, live dump 2026-11-10): reads 0x0C0311A0 in both, i.e. the reset value 0x0C0313A0 with only ss_ena_incr16_i cleared, as the vendor sequence does (ss_word_if_i 0 = 8-bit UTMI, usbovr_p_ctrl 1, port_pwr_en 1, both pull-downs 1 = host mode). The SDK leaves usb_chipid 0.

Data sheet 3.5.5.2 MISC_CTRL30 (offset 0x78, printed page 3-76, `hi3518ev200-datasheet.txt` line 26348).";

        enum MISC_CTRL30_usb_chipid_enum {
            HOST = 0 { name = "Host"; desc = "host"; };
            DEVICE = 1 { name = "Device"; desc = "device"; };
        };

        field {
            name = "usb_chipid";
            desc = "Host and device switching control";
            sw = rw;
            hw = r;
            encode = MISC_CTRL30_usb_chipid_enum;
            reset = 0x0;
        } usb_chipid[31:31];

        enum MISC_CTRL30_usb2_phy_dmpulldown_enum {
            DISABLED = 0 { name = "Disabled"; desc = "disabled"; };
            ENABLED = 1 { name = "Enabled"; desc = "enabled"; };
        };

        field {
            name = "usb2_phy_dmpulldown";
            desc = "D- pull-down resistor enable";
            sw = rw;
            hw = r;
            encode = MISC_CTRL30_usb2_phy_dmpulldown_enum;
            reset = 0x1;
        } usb2_phy_dmpulldown[27:27];

        enum MISC_CTRL30_usb2_phy_dppulldown_enum {
            DISABLED = 0 { name = "Disabled"; desc = "disabled"; };
            ENABLED = 1 { name = "Enabled"; desc = "enabled"; };
        };

        field {
            name = "usb2_phy_dppulldown";
            desc = "D+ pull-down resistor enable";
            sw = rw;
            hw = r;
            encode = MISC_CTRL30_usb2_phy_dppulldown_enum;
            reset = 0x1;
        } usb2_phy_dppulldown[26:26];

        enum MISC_CTRL30_ss_scaledown_mode_enum {
            SCALE_DOWN_DISABLED = 0 { name = "Scale Down Disabled"; desc = "Scale-down is disabled for all timings, and the actual timings are used."; };
            SCALE_DOWN_ENABLED = 1 { name = "Scale Down Enabled"; desc = "Scale-down is enabled for all timings except the suspended and resumed timings in device mode."; };
            SCALE_DOWN_ENABLED_2 = 2 { name = "Scale Down Enabled 2"; desc = "Scale-down is enabled only for the suspended and resumed timings in device mode."; };
            SCALE_DOWN_TIMINGS = 3 { name = "Scale Down Timings"; desc = "Scale-down timings of bit 0 and bit 1 are enabled."; };
        };

        field {
            name = "ss_scaledown_mode";
            desc = "Scale-down mode";
            sw = rw;
            hw = r;
            encode = MISC_CTRL30_ss_scaledown_mode_enum;
            reset = 0x0;
        } ss_scaledown_mode[25:24];

        enum MISC_CTRL30_ss_hubsetup_min_i_enum {
            V_5_IDLE_FULL = 0 { name = "V 5 Idle Full"; desc = "5 idle full-speed cycles"; };
            V_4_FULL_SPEED = 1 { name = "V 4 Full Speed"; desc = "4 full-speed idle cycles"; };
        };

        field {
            name = "ss_hubsetup_min_i";
            desc = "Number of idle cycles after the full-speed preamble packet";
            sw = rw;
            hw = r;
            encode = MISC_CTRL30_ss_hubsetup_min_i_enum;
            reset = 0x0;
        } ss_hubsetup_min_i[22:22];

        enum MISC_CTRL30_usbovr_p_ctrl_enum {
            ACTIVE_LOW = 0 { name = "Active Low"; desc = "active low"; };
            ACTIVE_HIGH = 1 { name = "Active High"; desc = "active high"; };
        };

        field {
            name = "usbovr_p_ctrl";
            desc = "Over-current protection polarity";
            sw = rw;
            hw = r;
            encode = MISC_CTRL30_usbovr_p_ctrl_enum;
            reset = 0x1;
        } usbovr_p_ctrl[17:17];

        enum MISC_CTRL30_usbpwr_pctrl_enum {
            ACTIVE_LOW = 0 { name = "Active Low"; desc = "active low"; };
            ACTIVE_HIGH = 1 { name = "Active High"; desc = "active high"; };
        };

        field {
            name = "usbpwr_pctrl";
            desc = "USB PHY power shutdown polarity";
            sw = rw;
            hw = r;
            encode = MISC_CTRL30_usbpwr_pctrl_enum;
            reset = 0x1;
        } usbpwr_pctrl[16:16];

        enum MISC_CTRL30_port_ovr_en_enum {
            DISABLED = 0 { name = "Disabled"; desc = "disabled"; };
            ENABLED = 1 { name = "Enabled"; desc = "enabled"; };
        };

        field {
            name = "port_ovr_en";
            desc = "Over-current protection enable for the USB PHY";
            sw = rw;
            hw = r;
            encode = MISC_CTRL30_port_ovr_en_enum;
            reset = 0x0;
        } port_ovr_en[14:14];

        enum MISC_CTRL30_port_pwr_en_enum {
            POWER_SHUT_DOWN = 0 { name = "Power Shut Down"; desc = "The power is shut down."; };
            CONTROLLER_POWER_OUTPUT = 1 { name = "Controller Power Output"; desc = "The controller power output is enabled."; };
        };

        field {
            name = "port_pwr_en";
            desc = "USB PHY power shutdown control";
            sw = rw;
            hw = r;
            encode = MISC_CTRL30_port_pwr_en_enum;
            reset = 0x1;
        } port_pwr_en[12:12];

        field {
            name = "ss_ena_incr16_i";
            desc = "AHB burst 16 enable 0: disabled 1 (default): enabled";
            sw = rw;
            hw = r;
            reset = 0x1;
        } ss_ena_incr16_i[9:9];

        field {
            name = "ss_ena_incr8_i";
            desc = "AHB burst 8 enable 0: disabled 1 (default): enabled";
            sw = rw;
            hw = r;
            reset = 0x1;
        } ss_ena_incr8_i[8:8];

        field {
            name = "ss_ena_incr4_i";
            desc = "AHB burst 4 enable 0: disabled 1 (default): enabled";
            sw = rw;
            hw = r;
            reset = 0x1;
        } ss_ena_incr4_i[7:7];

        field {
            name = "ss_ena_incr_align_i";
            desc = "Burst alignment enable 0 (default): disabled 1: enabled";
            sw = rw;
            hw = r;
            reset = 0x0;
        } ss_ena_incr_align_i[6:6];

        field {
            name = "ss_autoppd_on_overcur_en_i";
            desc = "Automatic port power shutdown enable during over-current 0: disabled 1 (default): enabled";
            sw = rw;
            hw = r;
            reset = 0x1;
        } ss_autoppd_on_overcur_en_i[5:5];

        field {
            name = "app_start_clk_i";
            desc = "Open host controller interface (OHCI) clock control 0 (default): The OHCI works normally. 1: The OHCI clock is enabled in suspend mode.";
            sw = rw;
            hw = r;
            reset = 0x0;
        } app_start_clk_i[2:2];

        field {
            name = "ohci_susp_lgcy_i";
            desc = "Strap input signal when the OHCI is suspended";
            sw = rw;
            hw = r;
            reset = 0x0;
        } ohci_susp_lgcy_i[1:1];

        field {
            name = "ss_word_if_i";
            desc = "Data bit width select for the UTMI interface 0 (default): 8 bits 1: 16 bits";
            sw = rw;
            hw = r;
            reset = 0x0;
        } ss_word_if_i[0:0];
    } MISC_CTRL30 @ 0x78;

    reg {
        name = "Audio CODEC (ACODEC) control register 6";
        desc = "MISC_CTRL49 is ACODEC control register 6.

Vendor use: acodec.ko (Hi3518EV200_MPP_V1.0.5.0, OpenIPC kmod copy, static analysis only) ioremaps 0x201200C4..0x201200E3 as one block (this register is word 0 of it) and its soft-reset routine (also run at module load) writes 0x9B here: ACODEC receive-channel select 3/3, ctcm bias on. At load it first clears bit 15 of PERI_CRG35 (0x2003008C), then steps MISC_CTRL50 through 0xFCCC0000, 0xFCFC0000, 0xF8FC0000 (vref powered up last) before the soft-reset writes.

Data sheet 3.5.5.2 MISC_CTRL49 (offset 0xC4, printed page 3-78, `hi3518ev200-datasheet.txt` line 26465).";

        field {
            name = "pdb_ctcm_ibias";
            desc = "This bit is set to 1 in normal mode.";
            sw = rw;
            hw = r;
            reset = 0x0;
        } pdb_ctcm_ibias[7:7];

        field {
            name = "pd_ctcm";
            desc = "This bit is set to 0 in normal mode.";
            sw = rw;
            hw = r;
            reset = 0x1;
        } pd_ctcm[6:6];

        enum MISC_CTRL49_rx_chnll_sel_enum {
            AC_INL_PIN = 3 { name = "Ac Inl Pin"; desc = "The AC_INL pin is selected as the single-ended input of the audio-left channel."; };
            AC_INL_AC = 4 { name = "Ac Inl Ac"; desc = "The AC_INL and AC_INR pins are selected as the positive end and negative end of the differential input for the audio-left channel respectively. Other values: reserved"; };
        };

        field {
            name = "rx_chnll_sel";
            desc = "RXPGA_L input signal select";
            sw = rw;
            hw = r;
            encode = MISC_CTRL49_rx_chnll_sel_enum;
            reset = 0x3;
        } rx_chnll_sel[5:3];

        field {
            name = "rx_chnlr_sel";
            desc = "RXPGA_R input signal select 011: The AC_INR pin is selected as the single-ended input of the audio-right channel. Other values: reserved";
            sw = rw;
            hw = r;
            reset = 0x3;
        } rx_chnlr_sel[2:0];
    } MISC_CTRL49 @ 0xC4;

    reg {
        name = "ACODEC control register 0";
        desc = "MISC_CTRL50 is ACODEC control register 0.

Vendor use: acodec.ko (Hi3518EV200_MPP_V1.0.5.0, OpenIPC kmod copy, static analysis only) ioremaps 0x201200C4..0x201200E3 as one block (this register is word 1 of it) and its soft-reset routine (also run at module load) writes 0x00F22C2C here: all ADC/DAC/vref/micbias powered up (pd_* = 0), mute_dacl/mute_dacr (bits 23:22) = 1 and the ADC mutes (19:18) = 0, mclk_ana_sel (bit 17) = 1, mic gain code 0x0B left and right. At load it first clears bit 15 of PERI_CRG35 (0x2003008C), then steps MISC_CTRL50 through 0xFCCC0000, 0xFCFC0000, 0xF8FC0000 (vref powered up last) before the soft-reset writes.

Data sheet 3.5.5.2 MISC_CTRL50 (offset 0xC8, printed page 3-79, `hi3518ev200-datasheet.txt` line 26511).";

        enum MISC_CTRL50_pd_adcl_enum {
            NORMAL_MODE = 0 { name = "Normal Mode"; desc = "normal mode"; };
            POWERED_OFF = 1 { name = "Powered Off"; desc = "powered off"; };
        };

        field {
            name = "pd_adcl";
            desc = "ADCL power-off control";
            sw = rw;
            hw = r;
            encode = MISC_CTRL50_pd_adcl_enum;
            reset = 0x1;
        } pd_adcl[31:31];

        enum MISC_CTRL50_pd_adcr_enum {
            NORMAL_MODE = 0 { name = "Normal Mode"; desc = "normal mode"; };
            POWERED_OFF = 1 { name = "Powered Off"; desc = "powered off"; };
        };

        field {
            name = "pd_adcr";
            desc = "ADCR power-off control. This bit needs to be set to 1 when the differential input is selected.";
            sw = rw;
            hw = r;
            encode = MISC_CTRL50_pd_adcr_enum;
            reset = 0x1;
        } pd_adcr[30:30];

        enum MISC_CTRL50_pd_dacl_enum {
            NORMAL_MODE = 0 { name = "Normal Mode"; desc = "normal mode"; };
            POWERED_OFF = 1 { name = "Powered Off"; desc = "powered off"; };
        };

        field {
            name = "pd_dacl";
            desc = "DACL power-off control";
            sw = rw;
            hw = r;
            encode = MISC_CTRL50_pd_dacl_enum;
            reset = 0x1;
        } pd_dacl[29:29];

        enum MISC_CTRL50_pd_dacr_enum {
            NORMAL_MODE = 0 { name = "Normal Mode"; desc = "normal mode"; };
            POWERED_OFF = 1 { name = "Powered Off"; desc = "powered off"; };
        };

        field {
            name = "pd_dacr";
            desc = "DACR power-off control";
            sw = rw;
            hw = r;
            encode = MISC_CTRL50_pd_dacr_enum;
            reset = 0x1;
        } pd_dacr[28:28];

        enum MISC_CTRL50_pd_micbias_enum {
            NORMAL_MODE = 0 { name = "Normal Mode"; desc = "normal mode"; };
            POWERED_OFF = 1 { name = "Powered Off"; desc = "powered off"; };
        };

        field {
            name = "pd_micbias";
            desc = "Microphone bias circuit power-off control";
            sw = rw;
            hw = r;
            encode = MISC_CTRL50_pd_micbias_enum;
            reset = 0x1;
        } pd_micbias[27:27];

        enum MISC_CTRL50_pd_vref_enum {
            NORMAL_MODE = 0 { name = "Normal Mode"; desc = "normal mode"; };
            POWERED_OFF = 1 { name = "Powered Off"; desc = "powered off"; };
        };

        field {
            name = "pd_vref";
            desc = "Reference voltage power-off control";
            sw = rw;
            hw = r;
            encode = MISC_CTRL50_pd_vref_enum;
            reset = 0x1;
        } pd_vref[26:26];

        enum MISC_CTRL50_mute_dacl_enum {
            NORMAL_MODE = 0 { name = "Normal Mode"; desc = "normal mode"; };
            MUTED = 1 { name = "Muted"; desc = "muted"; };
        };

        field {
            name = "mute_dacl";
            desc = "DACL analog mute";
            sw = rw;
            hw = r;
            encode = MISC_CTRL50_mute_dacl_enum;
            reset = 0x1;
        } mute_dacl[23:23];

        enum MISC_CTRL50_mute_dacr_enum {
            NORMAL_MODE = 0 { name = "Normal Mode"; desc = "normal mode"; };
            MUTED = 1 { name = "Muted"; desc = "muted"; };
        };

        field {
            name = "mute_dacr";
            desc = "DACR analog mute";
            sw = rw;
            hw = r;
            encode = MISC_CTRL50_mute_dacr_enum;
            reset = 0x1;
        } mute_dacr[22:22];

        enum MISC_CTRL50_mute_adcl_enum {
            NORMAL_MODE = 0 { name = "Normal Mode"; desc = "normal mode"; };
            MUTED = 1 { name = "Muted"; desc = "muted"; };
        };

        field {
            name = "mute_adcl";
            desc = "ADCL analog mute";
            sw = rw;
            hw = r;
            encode = MISC_CTRL50_mute_adcl_enum;
            reset = 0x1;
        } mute_adcl[19:19];

        enum MISC_CTRL50_mute_adcr_enum {
            NORMAL_MODE = 0 { name = "Normal Mode"; desc = "normal mode"; };
            MUTED = 1 { name = "Muted"; desc = "muted"; };
        };

        field {
            name = "mute_adcr";
            desc = "ADCR analog mute";
            sw = rw;
            hw = r;
            encode = MISC_CTRL50_mute_adcr_enum;
            reset = 0x1;
        } mute_adcr[18:18];

        field {
            name = "mclk_ana_sel";
            desc = "This bit is set to 1 in normal mode.";
            sw = rw;
            hw = r;
            reset = 0x0;
        } mclk_ana_sel[17:17];

        enum MISC_CTRL50_pd_ibias_enum {
            NORMAL_MODE = 0 { name = "Normal Mode"; desc = "normal mode"; };
            POWERED_OFF = 1 { name = "Powered Off"; desc = "powered off"; };
        };

        field {
            name = "pd_ibias";
            desc = "Global IBIAS power-off control";
            sw = rw;
            hw = r;
            encode = MISC_CTRL50_pd_ibias_enum;
            reset = 0x1;
        } pd_ibias[15:15];

        enum MISC_CTRL50_gain_micl_enum {
            V_0_DB = 0x0 { name = "V 0 Db"; desc = "0 dB"; };
            V_2_DB = 0x1 { name = "V 2 Db"; desc = "2 dB"; };
            V_4_DB = 0x2 { name = "V 4 Db"; desc = "4 dB"; };
            V_6_DB = 0x3 { name = "V 6 Db"; desc = "6 dB"; };
            V_8_DB = 0x4 { name = "V 8 Db"; desc = "8 dB"; };
            V_10_DB = 0x5 { name = "V 10 Db"; desc = "10 dB"; };
            V_12_DB = 0x6 { name = "V 12 Db"; desc = "12 dB"; };
            V_14_DB = 0x7 { name = "V 14 Db"; desc = "14 dB"; };
            V_16_DB = 0x8 { name = "V 16 Db"; desc = "16 dB"; };
            V_18_DB = 0x9 { name = "V 18 Db"; desc = "18 dB"; };
            V_20_DB = 0xA { name = "V 20 Db"; desc = "20 dB"; };
            V_22_DB = 0xB { name = "V 22 Db"; desc = "22 dB"; };
            V_24_DB = 0xC { name = "V 24 Db"; desc = "24 dB"; };
            V_26_DB = 0xD { name = "V 26 Db"; desc = "26 dB"; };
            V_28_DB = 0xE { name = "V 28 Db"; desc = "28 dB"; };
            V_30_DB = 0xF { name = "V 30 Db"; desc = "30 dB"; };
            V_1_5_DB = 0x10 { name = "V 1 5 Db"; desc = "-1.5 dB"; };
        };

        field {
            name = "gain_micl";
            desc = "AC_INL input gain control";
            sw = rw;
            hw = r;
            encode = MISC_CTRL50_gain_micl_enum;
            reset = 0x0;
        } gain_micl[14:10];

        enum MISC_CTRL50_gainboostl_enum {
            V_0_DB = 0 { name = "V 0 Db"; desc = "0 dB"; };
            V_20_DB = 1 { name = "V 20 Db"; desc = "20 dB"; };
        };

        field {
            name = "gainboostl";
            desc = "AC_INL gain boost control";
            sw = rw;
            hw = r;
            encode = MISC_CTRL50_gainboostl_enum;
            reset = 0x0;
        } gainboostl[9:9];

        enum MISC_CTRL50_gain_micr_enum {
            V_0_DB = 0x0 { name = "V 0 Db"; desc = "0 dB"; };
            V_2_DB = 0x1 { name = "V 2 Db"; desc = "2 dB"; };
            V_4_DB = 0x2 { name = "V 4 Db"; desc = "4 dB"; };
            V_6_DB = 0x3 { name = "V 6 Db"; desc = "6 dB"; };
            V_8_DB = 0x4 { name = "V 8 Db"; desc = "8 dB"; };
            V_10_DB = 0x5 { name = "V 10 Db"; desc = "10 dB"; };
            V_12_DB = 0x6 { name = "V 12 Db"; desc = "12 dB"; };
            V_14_DB = 0x7 { name = "V 14 Db"; desc = "14 dB"; };
            V_16_DB = 0x8 { name = "V 16 Db"; desc = "16 dB"; };
            V_18_DB = 0x9 { name = "V 18 Db"; desc = "18 dB"; };
            V_20_DB = 0xA { name = "V 20 Db"; desc = "20 dB"; };
            V_22_DB = 0xB { name = "V 22 Db"; desc = "22 dB"; };
            V_24_DB = 0xC { name = "V 24 Db"; desc = "24 dB"; };
            V_26_DB = 0xD { name = "V 26 Db"; desc = "26 dB"; };
            V_28_DB = 0xE { name = "V 28 Db"; desc = "28 dB"; };
            V_30_DB = 0xF { name = "V 30 Db"; desc = "30 dB"; };
            V_1_5_DB = 0x10 { name = "V 1 5 Db"; desc = "-1.5 dB"; };
        };

        field {
            name = "gain_micr";
            desc = "AC_INR input gain control";
            sw = rw;
            hw = r;
            encode = MISC_CTRL50_gain_micr_enum;
            reset = 0x0;
        } gain_micr[6:2];

        enum MISC_CTRL50_gainboostr_enum {
            V_0_DB = 0 { name = "V 0 Db"; desc = "0 dB"; };
            V_20_DB = 1 { name = "V 20 Db"; desc = "20 dB"; };
        };

        field {
            name = "gainboostr";
            desc = "AC_INR gain boost control";
            sw = rw;
            hw = r;
            encode = MISC_CTRL50_gainboostr_enum;
            reset = 0x0;
        } gainboostr[1:1];
    } MISC_CTRL50 @ 0xC8;

    reg {
        name = "ACODEC control register 1";
        desc = "MISC_CTRL51 is ACODEC control register 1.

ACODEC (audio codec) control register 1. Reserved bits have non-zero reset values (analog configuration).

Vendor use: acodec.ko (Hi3518EV200_MPP_V1.0.5.0, OpenIPC kmod copy, static analysis only) ioremaps 0x201200C4..0x201200E3 as one block (this register is word 2 of it) and its soft-reset routine (also run at module load) writes 0xFF035168 here: all four converter resets released and all four converters enabled (bits 31:24 = 1), i2s1_fs_sel and the reserved analog bits at their reset value. At load it first clears bit 15 of PERI_CRG35 (0x2003008C), then steps MISC_CTRL50 through 0xFCCC0000, 0xFCFC0000, 0xF8FC0000 (vref powered up last) before the soft-reset writes.

Data sheet 3.5.5.2 MISC_CTRL51 (offset 0xCC, printed page 3-81, `hi3518ev200-datasheet.txt` line 26643).";

        field {
            name = "dacl_rst_n";
            desc = "This bit is set to 1 in normal mode.";
            sw = rw;
            hw = r;
            reset = 0x0;
        } dacl_rst_n[31:31];

        field {
            name = "dacr_rst_n";
            desc = "This bit is set to 1 in normal mode.";
            sw = rw;
            hw = r;
            reset = 0x0;
        } dacr_rst_n[30:30];

        field {
            name = "adcl_rst_n";
            desc = "This bit is set to 1 in normal mode.";
            sw = rw;
            hw = r;
            reset = 0x0;
        } adcl_rst_n[29:29];

        field {
            name = "adcr_rst_n";
            desc = "This bit is set to 1 in normal mode.";
            sw = rw;
            hw = r;
            reset = 0x0;
        } adcr_rst_n[28:28];

        enum MISC_CTRL51_dacl_en_enum {
            DISABLED = 0 { name = "Disabled"; desc = "disabled"; };
            ENABLED = 1 { name = "Enabled"; desc = "enabled"; };
        };

        field {
            name = "dacl_en";
            desc = "DACL enable";
            sw = rw;
            hw = r;
            encode = MISC_CTRL51_dacl_en_enum;
            reset = 0x0;
        } dacl_en[27:27];

        enum MISC_CTRL51_dacr_en_enum {
            DISABLED = 0 { name = "Disabled"; desc = "disabled"; };
            ENABLED = 1 { name = "Enabled"; desc = "enabled"; };
        };

        field {
            name = "dacr_en";
            desc = "DACR enable";
            sw = rw;
            hw = r;
            encode = MISC_CTRL51_dacr_en_enum;
            reset = 0x0;
        } dacr_en[26:26];

        enum MISC_CTRL51_adcl_en_enum {
            DISABLED = 0 { name = "Disabled"; desc = "disabled"; };
            ENABLED = 1 { name = "Enabled"; desc = "enabled"; };
        };

        field {
            name = "adcl_en";
            desc = "ADCL enable";
            sw = rw;
            hw = r;
            encode = MISC_CTRL51_adcl_en_enum;
            reset = 0x0;
        } adcl_en[25:25];

        enum MISC_CTRL51_adcr_en_enum {
            DISABLED = 0 { name = "Disabled"; desc = "disabled"; };
            ENABLED = 1 { name = "Enabled"; desc = "enabled"; };
        };

        field {
            name = "adcr_en";
            desc = "ADCR enable";
            sw = rw;
            hw = r;
            encode = MISC_CTRL51_adcr_en_enum;
            reset = 0x0;
        } adcr_en[24:24];

        field {
            name = "reserved_nz_23_18";
            desc = "Reserved in the bit table, but the data sheet total reset value of this register has these bits set (reset 0x3C).";
            sw = r;
            hw = w;
            reset = 0x3C;
        } reserved_nz_23_18[23:18];

        enum MISC_CTRL51_i2s1_fs_sel_enum {
            MCLK_512_2 = 0x18 { name = "Mclk 512 2"; desc = "mclk/512/2, selected when the MCLK is 1024 FS clocks"; };
            MCLK_256_2 = 0x19 { name = "Mclk 256 2"; desc = "mclk/256/2, selected when the MCLK is 512 FS clocks"; };
            MCLK_128_2 = 0x1A { name = "Mclk 128 2"; desc = "mclk/128/2, selected when the MCLK is 256 FS clocks"; };
            MCLK_64_2 = 0x1B { name = "Mclk 64 2"; desc = "mclk/64/2, selected when the MCLK is 128 FS clocks 111xx: mclk/32/2, selected when the MCLK is 64 FS clocks"; };
        };

        field {
            name = "i2s1_fs_sel";
            desc = "Sampling rate of I S channel";
            sw = rw;
            hw = r;
            encode = MISC_CTRL51_i2s1_fs_sel_enum;
            reset = 0x1A;
        } i2s1_fs_sel[17:13];

        field {
            name = "reserved_nz_12_1";
            desc = "Reserved in the bit table, but the data sheet total reset value of this register has these bits set (reset 0xD25).";
            sw = r;
            hw = w;
            reset = 0xD25;
        } reserved_nz_12_1[12:1];

        enum MISC_CTRL51_rst_enum {
            NORMAL_MODE = 0 { name = "Normal Mode"; desc = "normal mode"; };
            RESET_F = 1 { name = "Reset F"; desc = "reset"; };
        };

        field {
            name = "rst";
            desc = "Analog circuit reset";
            sw = rw;
            hw = r;
            encode = MISC_CTRL51_rst_enum;
            reset = 0x0;
        } rst[0:0];
    } MISC_CTRL51 @ 0xCC;

    reg {
        name = "ACODEC control register 2";
        desc = "MISC_CTRL52 is ACODEC control register 2.

Vendor use: acodec.ko (Hi3518EV200_MPP_V1.0.5.0, OpenIPC kmod copy, static analysis only) ioremaps 0x201200C4..0x201200E3 as one block (this register is word 3 of it) and its soft-reset routine (also run at module load) writes 0x08000001 here: dacvu (bit 27) = 1, dacr_lrsel = 1. At load it first clears bit 15 of PERI_CRG35 (0x2003008C), then steps MISC_CTRL50 through 0xFCCC0000, 0xFCFC0000, 0xF8FC0000 (vref powered up last) before the soft-reset writes.

Data sheet 3.5.5.2 MISC_CTRL52 (offset 0xD0, printed page 3-83, `hi3518ev200-datasheet.txt` line 26713).";

        enum MISC_CTRL52_smutel_enum {
            DISABLED = 0 { name = "Disabled"; desc = "disabled"; };
            ENABLED = 1 { name = "Enabled"; desc = "enabled"; };
        };

        field {
            name = "smutel";
            desc = "DACL soft mute control";
            sw = rw;
            hw = r;
            encode = MISC_CTRL52_smutel_enum;
            reset = 0x0;
        } smutel[31:31];

        enum MISC_CTRL52_smuter_enum {
            DISABLED = 0 { name = "Disabled"; desc = "disabled"; };
            ENABLED = 1 { name = "Enabled"; desc = "enabled"; };
        };

        field {
            name = "smuter";
            desc = "DACR soft mute control";
            sw = rw;
            hw = r;
            encode = MISC_CTRL52_smuter_enum;
            reset = 0x0;
        } smuter[30:30];

        enum MISC_CTRL52_sunmutel_enum {
            DISABLED = 0 { name = "Disabled"; desc = "disabled"; };
            ENABLED = 1 { name = "Enabled"; desc = "enabled"; };
        };

        field {
            name = "sunmutel";
            desc = "DACL soft mute control";
            sw = rw;
            hw = r;
            encode = MISC_CTRL52_sunmutel_enum;
            reset = 0x0;
        } sunmutel[29:29];

        enum MISC_CTRL52_sunmuter_enum {
            DISABLED = 0 { name = "Disabled"; desc = "disabled"; };
            ENABLED = 1 { name = "Enabled"; desc = "enabled"; };
        };

        field {
            name = "sunmuter";
            desc = "DACR soft mute control";
            sw = rw;
            hw = r;
            encode = MISC_CTRL52_sunmuter_enum;
            reset = 0x0;
        } sunmuter[28:28];

        enum MISC_CTRL52_dacvu_enum {
            NOT_UPDATED = 0 { name = "Not Updated"; desc = "not updated"; };
            UPDATED = 1 { name = "Updated"; desc = "updated"; };
        };

        field {
            name = "dacvu";
            desc = "DAC volume update control";
            sw = rw;
            hw = r;
            encode = MISC_CTRL52_dacvu_enum;
            reset = 0x0;
        } dacvu[27:27];

        enum MISC_CTRL52_mutel_rate_enum {
            FS_2 = 0 { name = "Fs 2"; desc = "fs/2"; };
            FS_8 = 1 { name = "Fs 8"; desc = "fs/8"; };
            FS_32 = 2 { name = "Fs 32"; desc = "fs/32"; };
            FS_64 = 3 { name = "Fs 64"; desc = "fs/64"; };
        };

        field {
            name = "mutel_rate";
            desc = "DACL soft mute rate control";
            sw = rw;
            hw = r;
            encode = MISC_CTRL52_mutel_rate_enum;
            reset = 0x0;
        } mutel_rate[26:25];

        enum MISC_CTRL52_muter_rate_enum {
            FS_2 = 0 { name = "Fs 2"; desc = "fs/2"; };
            FS_8 = 1 { name = "Fs 8"; desc = "fs/8"; };
            FS_32 = 2 { name = "Fs 32"; desc = "fs/32"; };
            FS_64 = 3 { name = "Fs 64"; desc = "fs/64"; };
        };

        field {
            name = "muter_rate";
            desc = "DACR soft mute rate control";
            sw = rw;
            hw = r;
            encode = MISC_CTRL52_muter_rate_enum;
            reset = 0x0;
        } muter_rate[24:23];

        field {
            name = "dacr_lrsel";
            desc = "This bit is set to 1 in normal mode.";
            sw = rw;
            hw = r;
            reset = 0x1;
        } dacr_lrsel[0:0];
    } MISC_CTRL52 @ 0xD0;

    reg {
        name = "ACODEC control register 3";
        desc = "MISC_CTRL53 is ACODEC control register 3.

Vendor use: acodec.ko (Hi3518EV200_MPP_V1.0.5.0, OpenIPC kmod copy, static analysis only) ioremaps 0x201200C4..0x201200E3 as one block (this register is word 4 of it) and its soft-reset routine (also run at module load) writes 0x07072424 here: DAC left/right volume code 0x07. At load it first clears bit 15 of PERI_CRG35 (0x2003008C), then steps MISC_CTRL50 through 0xFCCC0000, 0xFCFC0000, 0xF8FC0000 (vref powered up last) before the soft-reset writes.

Data sheet 3.5.5.2 MISC_CTRL53 (offset 0xD4, printed page 3-84, `hi3518ev200-datasheet.txt` line 26770).";

        enum MISC_CTRL53_dacl_mute_enum {
            NORMAL_MODE = 0 { name = "Normal Mode"; desc = "normal mode"; };
            MUTED = 1 { name = "Muted"; desc = "muted"; };
        };

        field {
            name = "dacl_mute";
            desc = "DACL digital mute control";
            sw = rw;
            hw = r;
            encode = MISC_CTRL53_dacl_mute_enum;
            reset = 0x0;
        } dacl_mute[31:31];

        enum MISC_CTRL53_dacl_vol_enum {
            V_6_DB = 0x0 { name = "V 6 Db"; desc = "6 dB"; };
            V_5_DB = 0x1 { name = "V 5 Db"; desc = "5 dB"; };
            V_4_DB = 0x2 { name = "V 4 Db"; desc = "4 dB …"; };
            V_120_DB_WHEN = 0x7E { name = "V 120 Db When"; desc = "-120 dB When dacl_vol is 0x7F, the DACL is muted."; };
        };

        field {
            name = "dacl_vol";
            desc = "DACL digital volume control, You are advised not to use this field, but to use the digital volume adjustment function in the AIAO module to control the digital volume output. The volume is calculated as follows: (6 - dacl_vol) dB";
            sw = rw;
            hw = r;
            encode = MISC_CTRL53_dacl_vol_enum;
            reset = 0x6;
        } dacl_vol[30:24];

        enum MISC_CTRL53_dacr_mute_enum {
            NORMAL_MODE = 0 { name = "Normal Mode"; desc = "normal mode"; };
            MUTED = 1 { name = "Muted"; desc = "muted"; };
        };

        field {
            name = "dacr_mute";
            desc = "DACR digital mute control";
            sw = rw;
            hw = r;
            encode = MISC_CTRL53_dacr_mute_enum;
            reset = 0x0;
        } dacr_mute[23:23];

        enum MISC_CTRL53_dacr_vol_enum {
            V_6_DB = 0x0 { name = "V 6 Db"; desc = "6 dB"; };
            V_5_DB = 0x1 { name = "V 5 Db"; desc = "5 dB"; };
            V_4_DB = 0x2 { name = "V 4 Db"; desc = "4 dB …"; };
            V_120_DB_WHEN = 0x7E { name = "V 120 Db When"; desc = "-120 dB When dacr_vol is 0x7F, the DACR is muted."; };
        };

        field {
            name = "dacr_vol";
            desc = "DACR digital volume control, You are advised not to use this field, but to use the digital volume adjustment function in the AIAO module to control the digital volume output. The volume is calculated as follows: (6 - dacr_vol) dB";
            sw = rw;
            hw = r;
            encode = MISC_CTRL53_dacr_vol_enum;
            reset = 0x6;
        } dacr_vol[22:16];

        field {
            name = "reserved_nz_15_0";
            desc = "Reserved in the bit table, but the data sheet total reset value of this register has these bits set (reset 0x2424).";
            sw = r;
            hw = w;
            reset = 0x2424;
        } reserved_nz_15_0[15:0];
    } MISC_CTRL53 @ 0xD4;

    reg {
        name = "ACODEC control register 4";
        desc = "MISC_CTRL54 is ACODEC control register 4.

Vendor use: acodec.ko (Hi3518EV200_MPP_V1.0.5.0, OpenIPC kmod copy, static analysis only) ioremaps 0x201200C4..0x201200E3 as one block (this register is word 5 of it) and its soft-reset routine (also run at module load) writes 0x1E1EC001 here: ADC left/right volume code 0x1E, both HPF enabled (bits 15:14), adcr_lrsel = 1. At load it first clears bit 15 of PERI_CRG35 (0x2003008C), then steps MISC_CTRL50 through 0xFCCC0000, 0xFCFC0000, 0xF8FC0000 (vref powered up last) before the soft-reset writes.

Data sheet 3.5.5.2 MISC_CTRL54 (offset 0xD8, printed page 3-85, `hi3518ev200-datasheet.txt` line 26827).";

        enum MISC_CTRL54_adcl_mute_enum {
            UNMUTED = 0 { name = "Unmuted"; desc = "unmuted"; };
            MUTED = 1 { name = "Muted"; desc = "muted"; };
        };

        field {
            name = "adcl_mute";
            desc = "ADCL digital mute control";
            sw = rw;
            hw = r;
            encode = MISC_CTRL54_adcl_mute_enum;
            reset = 0x0;
        } adcl_mute[31:31];

        field {
            name = "adcl_vol";
            desc = "ADCL volume control, You are advised not to use this field, but to use the digital volume adjustment function in the AIAO module to control the digital volume output. The volume is calculated as follows: (30 - adcl_vol) dB 00: 30 dB 01: 29 dB 02: 28 dB … 7E: -96 dB 7F: -97 dB";
            sw = rw;
            hw = r;
            reset = 0x1E;
        } adcl_vol[30:24];

        enum MISC_CTRL54_adcr_mute_enum {
            UNMUTED = 0 { name = "Unmuted"; desc = "unmuted"; };
            MUTED = 1 { name = "Muted"; desc = "muted"; };
        };

        field {
            name = "adcr_mute";
            desc = "ADCR digital mute control";
            sw = rw;
            hw = r;
            encode = MISC_CTRL54_adcr_mute_enum;
            reset = 0x0;
        } adcr_mute[23:23];

        field {
            name = "adcr_vol";
            desc = "ADCR volume control, You are advised not to use this field, but to use the digital volume adjustment function in the AIAO module to control the digital volume output. The volume is calculated as follows: (30 - adcr_vol) dB 00: 30 dB 01: 29 dB 02: 28 dB … 7E: -96 dB 7F: -97 dB";
            sw = rw;
            hw = r;
            reset = 0x1E;
        } adcr_vol[22:16];

        enum MISC_CTRL54_adcl_hpf_en_enum {
            DISABLED = 0 { name = "Disabled"; desc = "disabled"; };
            ENABLED = 1 { name = "Enabled"; desc = "enabled"; };
        };

        field {
            name = "adcl_hpf_en";
            desc = "ADCL high-pass filter enable";
            sw = rw;
            hw = r;
            encode = MISC_CTRL54_adcl_hpf_en_enum;
            reset = 0x0;
        } adcl_hpf_en[15:15];

        enum MISC_CTRL54_adcr_hpf_en_enum {
            DISABLED = 0 { name = "Disabled"; desc = "disabled"; };
            ENABLED = 1 { name = "Enabled"; desc = "enabled"; };
        };

        field {
            name = "adcr_hpf_en";
            desc = "ADCR high-pass filter enable";
            sw = rw;
            hw = r;
            encode = MISC_CTRL54_adcr_hpf_en_enum;
            reset = 0x0;
        } adcr_hpf_en[14:14];

        field {
            name = "adcr_lrsel";
            desc = "This bit is set to 1 in normal mode.";
            sw = rw;
            hw = r;
            reset = 0x1;
        } adcr_lrsel[0:0];
    } MISC_CTRL54 @ 0xD8;

    reg {
        name = "MISC register 56";
        desc = "MISC_CTRL56 is MISC register 56.

Data sheet 3.5.5.2 MISC_CTRL56 (offset 0xE0, printed page 3-86, `hi3518ev200-datasheet.txt` line 26897).";

        enum MISC_CTRL56_i2s_pad_mclk_sel_enum {
            AIAO_I2S_RX = 0 { name = "Aiao I2S Rx"; desc = "aiao_i2s_rx_mclk"; };
            AIAO_I2S_TX = 1 { name = "Aiao I2S Tx"; desc = "aiao_i2s_tx_mclk"; };
        };

        field {
            name = "i2s_pad_mclk_sel";
            desc = "mclk selection control for the chip I S interface.";
            sw = rw;
            hw = r;
            encode = MISC_CTRL56_i2s_pad_mclk_sel_enum;
            reset = 0x0;
        } i2s_pad_mclk_sel[3:3];

        enum MISC_CTRL56_i2s_pad_enable_enum {
            CHANNEL_BETWEEN_I = 0 { name = "Channel Between I"; desc = "The channel between the I S interface of the chip and AIAO is disabled, and the I S interface of the chip has no output."; };
            CHANNEL_BETWEEN_I_2 = 1 { name = "Channel Between I 2"; desc = "The channel between the I S interface of the chip and AIAO is enabled, and the I S interface of the chip connects to the I S interface of the AIAO. Note: i2s_pad_enable and audio_enable cannot be 1 at the same time."; };
        };

        field {
            name = "i2s_pad_enable";
            desc = "Enable for the channel between the I S interface of the chip and AIAO";
            sw = rw;
            hw = r;
            encode = MISC_CTRL56_i2s_pad_enable_enum;
            reset = 0x0;
        } i2s_pad_enable[1:1];

        enum MISC_CTRL56_audio_enable_enum {
            CHANNEL_BETWEEN_I = 0 { name = "Channel Between I"; desc = "The channel between the I S interface of the internal audio CODEC and AIAO is disabled, and the I S interface of the internal audio CODEC has no output."; };
            CHANNEL_BETWEEN_I_2 = 1 { name = "Channel Between I 2"; desc = "The channel between the I S interface of the internal audio CODEC and AIAO is enabled, and the I S interface of internal audio CODEC connects to the I S interface of the AIAO. Note: i2s_pad_enable and audio_enable cannot be 1 at the same time."; };
        };

        field {
            name = "audio_enable";
            desc = "Enable for the channel between the I S interface of the internal audio CODEC and AIAO";
            sw = rw;
            hw = r;
            encode = MISC_CTRL56_audio_enable_enum;
            reset = 0x0;
        } audio_enable[0:0];
    } MISC_CTRL56 @ 0xE0;

    reg {
        name = "MISC register 60";
        desc = "MISC_CTRL60 is MISC register 60.

Data sheet 3.5.5.2 MISC_CTRL60 (offset 0xF0, printed page 3-87, `hi3518ev200-datasheet.txt` line 26958).";

        field {
            name = "core_mem_ras_emaw";
            desc = "core mem ras emaw (the data sheet gives only the field name for this bit field).";
            sw = rw;
            hw = r;
            reset = 0x0;
        } core_mem_ras_emaw[21:20];

        field {
            name = "core_mem_ras_emab";
            desc = "core mem ras emab (the data sheet gives only the field name for this bit field).";
            sw = rw;
            hw = r;
            reset = 0x2;
        } core_mem_ras_emab[18:16];

        field {
            name = "core_mem_rft_emab";
            desc = "core mem rft emab (the data sheet gives only the field name for this bit field).";
            sw = rw;
            hw = r;
            reset = 0x2;
        } core_mem_rft_emab[14:12];

        field {
            name = "core_mem_rft_emaa";
            desc = "core mem rft emaa (the data sheet gives only the field name for this bit field).";
            sw = rw;
            hw = r;
            reset = 0x2;
        } core_mem_rft_emaa[10:8];

        field {
            name = "core_mem_rfs_emaw";
            desc = "core mem rfs emaw (the data sheet gives only the field name for this bit field).";
            sw = rw;
            hw = r;
            reset = 0x0;
        } core_mem_rfs_emaw[5:4];

        field {
            name = "core_mem_rfs_ema";
            desc = "core mem rfs ema (the data sheet gives only the field name for this bit field).";
            sw = rw;
            hw = r;
            reset = 0x2;
        } core_mem_rfs_ema[2:0];
    } MISC_CTRL60 @ 0xF0;

    reg {
        name = "MISC register 61";
        desc = "MISC_CTRL61 is MISC register 61.

Data sheet 3.5.5.2 MISC_CTRL61 (offset 0xF4, printed page 3-88, `hi3518ev200-datasheet.txt` line 27014).";

        field {
            name = "core_mem_ros_ema";
            desc = "core mem ros ema (the data sheet gives only the field name for this bit field).";
            sw = rw;
            hw = r;
            reset = 0x2;
        } core_mem_ros_ema[18:16];

        field {
            name = "core_mem_rad_emawb";
            desc = "core mem rad emawb (the data sheet gives only the field name for this bit field).";
            sw = rw;
            hw = r;
            reset = 0x0;
        } core_mem_rad_emawb[13:12];

        field {
            name = "core_mem_rad_emab";
            desc = "core mem rad emab (the data sheet gives only the field name for this bit field).";
            sw = rw;
            hw = r;
            reset = 0x2;
        } core_mem_rad_emab[10:8];

        field {
            name = "core_mem_rad_emawa";
            desc = "core mem rad emawa (the data sheet gives only the field name for this bit field).";
            sw = rw;
            hw = r;
            reset = 0x0;
        } core_mem_rad_emawa[5:4];

        field {
            name = "core_mem_rad_emaa";
            desc = "core mem rad emaa (the data sheet gives only the field name for this bit field).";
            sw = rw;
            hw = r;
            reset = 0x2;
        } core_mem_rad_emaa[2:0];
    } MISC_CTRL61 @ 0xF4;

    reg {
        name = "MISC register 80";
        desc = "MISC_CTRL80 is MISC register 80.

eMMC DLL control (field meaning not described in the data sheet beyond the signal names).

Data sheet 3.5.5.2 MISC_CTRL80 (offset 0x140, printed page 3-89, `hi3518ev200-datasheet.txt` line 27065).";

        field {
            name = "emmc_dll_dsel";
            desc = "emmc dll dsel (the data sheet gives only the field name for this bit field).";
            sw = rw;
            hw = r;
            reset = 0x0;
        } emmc_dll_dsel[17:16];

        field {
            name = "emmc_dll_ssel";
            desc = "emmc dll ssel (the data sheet gives only the field name for this bit field).";
            sw = rw;
            hw = r;
            reset = 0x0;
        } emmc_dll_ssel[15:8];

        field {
            name = "emmc_dll_mode";
            desc = "emmc dll mode (the data sheet gives only the field name for this bit field).";
            sw = rw;
            hw = r;
            reset = 0x0;
        } emmc_dll_mode[7:7];

        field {
            name = "emmc_dll_stop";
            desc = "emmc dll stop (the data sheet gives only the field name for this bit field).";
            sw = rw;
            hw = r;
            reset = 0x0;
        } emmc_dll_stop[6:6];

        field {
            name = "emmc_dll_bypass";
            desc = "emmc dll bypass (the data sheet gives only the field name for this bit field).";
            sw = rw;
            hw = r;
            reset = 0x0;
        } emmc_dll_bypass[5:5];

        field {
            name = "emmc_dll_slave_enDLL";
            desc = "emmc dll slave enDLL (the data sheet gives only the field name for this bit field).";
            sw = rw;
            hw = r;
            reset = 0x0;
        } emmc_dll_slave_enDLL[4:4];

        field {
            name = "emmc_dll_tune";
            desc = "emmc dll tune (the data sheet gives only the field name for this bit field).";
            sw = rw;
            hw = r;
            reset = 0x0;
        } emmc_dll_tune[3:0];
    } MISC_CTRL80 @ 0x140;

    reg {
        name = "MISC register 81";
        desc = "MISC_CTRL81 is MISC register 81.

Data sheet 3.5.5.2 MISC_CTRL81 (offset 0x144, printed page 3-90, `hi3518ev200-datasheet.txt` line 27109).";

        field {
            name = "emmc_dll_lock";
            desc = "emmc dll lock (the data sheet gives only the field name for this bit field).";
            sw = r;
            hw = w;
            reset = 0x0;
        } emmc_dll_lock[10:10];

        field {
            name = "emmc_dll_ready";
            desc = "emmc dll ready (the data sheet gives only the field name for this bit field).";
            sw = r;
            hw = w;
            reset = 0x0;
        } emmc_dll_ready[9:9];

        field {
            name = "emmc_dll_overflow";
            desc = "emmc dll overflow (the data sheet gives only the field name for this bit field).";
            sw = r;
            hw = w;
            reset = 0x0;
        } emmc_dll_overflow[8:8];

        field {
            name = "emmc_dll_mdly_tap";
            desc = "emmc dll mdly tap (the data sheet gives only the field name for this bit field).";
            sw = r;
            hw = w;
            reset = 0x0;
        } emmc_dll_mdly_tap[7:0];
    } MISC_CTRL81 @ 0x144;

    reg {
        name = "USB 2.0 PHY control (vendor, not in the data sheet)";
        desc = "Not in the data sheet (it lists MISC_CTRL30 at 0x78 and the next register at 0xC4); layout reconstructed from the vendor code. The vendor U-Boot (drivers/usb/host/hiusb/hiusb-3518ev200.c, MISC_USB = MISC_CTRL + 0x80) and the vendor/OpenIPC kernel (drivers/phy/hibvt/phy-hi3518ev20x-usb.c) drive the USB 2.0 PHY through it with fixed write pairs that differ only in bit 5: 0x0C06 then 0x0C26 (5 ms), 0x1C00 then 0x1C20, 0x0C09 then 0x0C29, 0x1A0A then 0x1A2A, and (kernel, threshold 650 to 550) 0x000A then 0x092A; the vendor U-Boot uses only 0x0C06/0x0C26 and 0x0000/0x1C20. [inferred] This is an indirect PHY register port: [3:0] register address, [5] write strobe (low value then high value), [15:8] write data. Live evidence (Hi3518E V200 board, 2026-11-10): after the U-Boot sequence the register reads 0x001C1C20 and after the kernel sequence 0x0009092A, i.e. bits [23:16] read back as a copy of the last written [15:8]. Bit meanings of the PHY registers themselves are not documented.";
        field { name = "phy_addr"; desc = "[inferred] USB 2.0 PHY register address (values seen: 0x0, 0x6, 0x9, 0xA)"; sw = rw; hw = na; } phy_addr[3:0];
        field { name = "phy_wr_strobe"; desc = "[inferred] Write strobe: the vendor code writes the word with this bit 0, waits 10 us, then writes it again with this bit 1 (0x26 vs 0x06 in the low byte)"; sw = rw; hw = na; } phy_wr_strobe[5:5];
        field { name = "phy_wdata"; desc = "[inferred] Data written to the addressed USB 2.0 PHY register (values seen: 0x0C, 0x1C, 0x1A, 0x09)"; sw = rw; hw = na; } phy_wdata[15:8];
        field { name = "phy_rdata"; desc = "[inferred] Read-back of the PHY register data: reads as a copy of the last written phy_wdata on the board (0x1C and 0x09 seen)"; sw = r; hw = na; } phy_rdata[23:16];
    } MISC_CTRL32 @ 0x80;

    reg {
        name = "MISC register 31 (vendor, not in the data sheet)";
        desc = "Not in the data sheet and not touched by any vendor code found (U-Boot hiusb-3518ev200.c, kernel phy-hi3518ev20x-usb.c, DDR training). A live dump of a Hi3518E V200 board reads 0x029991C5 both in U-Boot and in Linux, so it is not a status that changes with the SDK sequence (U-Boot after a warm reset equals Linux). [inferred] Sits between MISC_CTRL30 (USB controller strap/config, 0x78) and the USB PHY port (0x80), so probably another USB PHY/controller parameter word. Bit meanings unknown.";
        field { name = "value"; desc = "Undocumented word (observed 0x029991C5)"; sw = rw; hw = na; } value[31:0];
    } MISC_CTRL31 @ 0x7C;

    reg {
        name = "MISC register 55 (vendor, not in the data sheet)";
        desc = "Not in the data sheet (it lists MISC_CTRL54 at 0xD8, ACODEC control register 4, then MISC_CTRL56 at 0xE0). A live dump of a Hi3518E V200 board reads 0x24242424 both in U-Boot and in Linux. [inferred] Probably the next ACODEC control word (the ACODEC registers 0xC8..0xD8 carry analog defaults of the 0x24 / 0x1E / 0x06 kind). Bit meanings unknown.";
        field { name = "value"; desc = "Undocumented word (observed 0x24242424)"; sw = rw; hw = na; } value[31:0];
    } MISC_CTRL55 @ 0xDC;

};

`endif
