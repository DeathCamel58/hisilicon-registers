`ifndef HISI_TDE_RDL
`define HISI_TDE_RDL

addrmap aHISI_TDE {
    name = "HiSilicon TDE (registers not described)";
    desc = "Not described: no register of this block is described; the registers exist only in closed vendor libraries (the MPP binary modules), not in the data sheet or any vendor source in the tree. The 64 KB window is kept only so that the block base address and size exist in the address map (STUB). Two-dimensional engine (data sheet 8.1, overview/features only): RGB/YCbCr conversion, direct copy and fill, 2D resize, anti-flicker, clip, alpha blending, colorkey, clip mask, status interrupts. No register description in the data sheet; the only vendor source is the TDE API header (`openhisilicon/include/tde_api.h`, no register map). Instances, per data sheet memory map and interrupt table (cross-chip audit 2026-11-11, docs/rdl-campaign/tde.md; every data sheet checked: none has a TDE register table, only the chapter with features): Hi3515 and Hi3520 V100 0x20140000 (VIC interrupt 18); Hi3516 V100 0x20630000 (IRQ 53); Hi3516C V100, Hi3518A/C, Hi3518E V100/V200 and Hi3516C V200 0x20610000 (IRQ 27); Hi3516A/D 0x20610000 (GIC 69); Hi3520D/Hi3515A/Hi3515C 0x20610000 (GIC 70); Hi3516A V200 and Hi3519 V101 0x11100000 (GIC 66); Hi3516A V300 0x11210000 (GIC 67). Hi3511/Hi3512 (interrupt 31, 0x90010000 reserved in the memory map) and Hi3516C V300/Hi3516E V100 (no TDE) have no window in the data sheet. Source: data sheet, confidence HIGH for base and IRQ. Listed as an open item in docs/rdl-sweep/PORT-BLOCKS.md.";

    external mem {
        name = "Undocumented register window";
        desc = "The whole 64 KB window of the block. Register layout unknown; placeholder so the block base address and size exist in the map. No registers are described.";
        mementries = 16384;
        memwidth = 32;
        sw = rw;
    } REGS;
};

regfile eHISI_TDE_V0 {
    name = "HiSilicon TDE, Hi3510-style register map (candidate)";
    desc = "CANDIDATE LAYOUT, LOW CONFIDENCE, NOT HARDWARE VERIFIED, NOT INSTANTIATED. First-generation two-dimensional engine register map of the Hi3510 as used by the MiniGUI NEWGAL HiSilicon backend (MiniGUI `src/newgal/hisi/tde_reg.h` (GPL-3.0, Feynman Software 2007, Hi3510 SDK register layout; https://github.com/VincentWei/MiniGUI)): 11 registers in a 0x84-byte window at Hi3510 address 0x90010300 (TDE_REG_BASE_ADDR), i.e. offset 0x300 inside a 0x90010000 block. Applicability: the Hi3511/Hi3512 data sheet describes the TDE in chapter 2D engine (VIC interrupt 31, AHB master/slave, direct copy/fill, ROP, colour key, resize) without a register chapter and lists 0x9001_0000 only as a reserved 64 KB window; the Hi3515 lists a TDE window at 0x20140000 and the Hi3520 V100 likewise, but their TDE generation is unknown. Instantiate only after a probe: read TDE_STATUS (+0x380 from the block base on the Hi3511 if the Hi3510 placement holds) and write/read TDE_SIZE. Everything is marked `[inferred]`: field names from the header, meanings from the names, reset values and access types unknown (modelled RW, no reset).

    Generated 2026-11-10 by build/rdl-audit/video-rdl-scratch/gen_tde.py.";

    reg {
        name = "TDE control / start";
        desc = "[inferred] Control register: start bit, ROP code, command bits, global alpha and in/out colour formats (MiniGUI `src/newgal/hisi/tde_reg.h` (GPL-3.0, Feynman Software 2007, Hi3510 SDK register layout; https://github.com/VincentWei/MiniGUI), union TDE_Reg_Control).";

        field {
            name = "in_color_format";
            desc = "[inferred] Input colour format code.";
            sw = rw;
            hw = r;
        } in_color_format[31:28];

        field {
            name = "out_color_format";
            desc = "[inferred] Output colour format code.";
            sw = rw;
            hw = r;
        } out_color_format[27:24];

        field {
            name = "alpha";
            desc = "[inferred] Global alpha value.";
            sw = rw;
            hw = r;
        } alpha[23:16];

        field {
            name = "tde_cmd_cmd";
            desc = "[inferred] Command type (2 bits).";
            sw = rw;
            hw = r;
        } tde_cmd_cmd[12:11];

        field {
            name = "tde_cmd_colorspace";
            desc = "[inferred] Colour-space conversion select.";
            sw = rw;
            hw = r;
        } tde_cmd_colorspace[10:10];

        field {
            name = "tde_cmd_data_opt";
            desc = "[inferred] Data operation select (2 bits).";
            sw = rw;
            hw = r;
        } tde_cmd_data_opt[9:8];

        field {
            name = "tde_cmd_outalphafrom";
            desc = "[inferred] Output alpha source select.";
            sw = rw;
            hw = r;
        } tde_cmd_outalphafrom[7:7];

        field {
            name = "rop_code";
            desc = "[inferred] Raster operation code (4 bits).";
            sw = rw;
            hw = r;
        } rop_code[5:2];

        field {
            name = "tde_start";
            desc = "[inferred] Start the operation (self-clearing).";
            sw = rw;
            hw = r;
        } tde_start[0:0];
    } TDE_CTRL @ 0x0;

    reg {
        name = "Blit size";
        desc = "[inferred] Width and height of the blit (MiniGUI `src/newgal/hisi/tde_reg.h` (GPL-3.0, Feynman Software 2007, Hi3510 SDK register layout; https://github.com/VincentWei/MiniGUI), union TDE_Reg_Size).";

        field {
            name = "blt_height";
            desc = "[inferred] Blit height in pixels.";
            sw = rw;
            hw = r;
        } blt_height[23:12];

        field {
            name = "blt_width";
            desc = "[inferred] Blit width in pixels.";
            sw = rw;
            hw = r;
        } blt_width[11:0];
    } TDE_SIZE @ 0x4;

    reg {
        name = "Source address";
        desc = "[inferred] Source bitmap physical address (MiniGUI `src/newgal/hisi/tde_reg.h` (GPL-3.0, Feynman Software 2007, Hi3510 SDK register layout; https://github.com/VincentWei/MiniGUI)).";

        field {
            name = "value";
            desc = "[inferred] 32-bit register value (bit layout not in the source).";
            sw = rw;
            hw = r;
        } value[31:0];
    } TDE_SRC_ADDR @ 0x8;

    reg {
        name = "Destination address";
        desc = "[inferred] Destination bitmap physical address (MiniGUI `src/newgal/hisi/tde_reg.h` (GPL-3.0, Feynman Software 2007, Hi3510 SDK register layout; https://github.com/VincentWei/MiniGUI)).";

        field {
            name = "value";
            desc = "[inferred] 32-bit register value (bit layout not in the source).";
            sw = rw;
            hw = r;
        } value[31:0];
    } TDE_DST_ADDR @ 0xC;

    reg {
        name = "Output address";
        desc = "[inferred] Output bitmap physical address (MiniGUI `src/newgal/hisi/tde_reg.h` (GPL-3.0, Feynman Software 2007, Hi3510 SDK register layout; https://github.com/VincentWei/MiniGUI)).";

        field {
            name = "value";
            desc = "[inferred] 32-bit register value (bit layout not in the source).";
            sw = rw;
            hw = r;
        } value[31:0];
    } TDE_OUT_ADDR @ 0x10;

    reg {
        name = "Source / destination stride";
        desc = "[inferred] Strides in bytes (MiniGUI `src/newgal/hisi/tde_reg.h` (GPL-3.0, Feynman Software 2007, Hi3510 SDK register layout; https://github.com/VincentWei/MiniGUI), union TDE_Reg_SrcDstStride).";

        field {
            name = "src_stride";
            desc = "[inferred] Source stride in bytes.";
            sw = rw;
            hw = r;
        } src_stride[31:16];

        field {
            name = "dst_stride";
            desc = "[inferred] Destination stride in bytes.";
            sw = rw;
            hw = r;
        } dst_stride[15:0];
    } TDE_SRC_DST_STRIDE @ 0x14;

    reg {
        name = "Miscellaneous";
        desc = "[inferred] Output stride, pattern size, endianness and FIFO write protection (MiniGUI `src/newgal/hisi/tde_reg.h` (GPL-3.0, Feynman Software 2007, Hi3510 SDK register layout; https://github.com/VincentWei/MiniGUI), union TDE_Reg_Misc).";

        field {
            name = "fifo_wrprotect";
            desc = "[inferred] FIFO write protection.";
            sw = rw;
            hw = r;
        } fifo_wrprotect[31:31];

        field {
            name = "endian_sel";
            desc = "[inferred] Endian select.";
            sw = rw;
            hw = r;
        } endian_sel[30:30];

        field {
            name = "pattern_width";
            desc = "[inferred] Pattern width (pattern fill).";
            sw = rw;
            hw = r;
        } pattern_width[25:21];

        field {
            name = "pattern_height";
            desc = "[inferred] Pattern height (pattern fill).";
            sw = rw;
            hw = r;
        } pattern_height[20:16];

        field {
            name = "gout_stride";
            desc = "[inferred] Output stride in bytes.";
            sw = rw;
            hw = r;
        } gout_stride[15:0];
    } TDE_MISC @ 0x18;

    reg {
        name = "Fill colour";
        desc = "[inferred] Fill colour as packed 8-bit R/G/B (MiniGUI `src/newgal/hisi/tde_reg.h` (GPL-3.0, Feynman Software 2007, Hi3510 SDK register layout; https://github.com/VincentWei/MiniGUI)).";

        field {
            name = "r";
            desc = "[inferred] Red component.";
            sw = rw;
            hw = r;
        } r_f[23:16];

        field {
            name = "g";
            desc = "[inferred] Green component.";
            sw = rw;
            hw = r;
        } g[15:8];

        field {
            name = "b";
            desc = "[inferred] Blue component.";
            sw = rw;
            hw = r;
        } b[7:0];
    } TDE_COLOR_FILLED @ 0x1C;

    reg {
        name = "Colour-key maximum";
        desc = "[inferred] Colour-key maximum as packed 8-bit R/G/B (MiniGUI `src/newgal/hisi/tde_reg.h` (GPL-3.0, Feynman Software 2007, Hi3510 SDK register layout; https://github.com/VincentWei/MiniGUI)).";

        field {
            name = "r";
            desc = "[inferred] Red component.";
            sw = rw;
            hw = r;
        } r_f[23:16];

        field {
            name = "g";
            desc = "[inferred] Green component.";
            sw = rw;
            hw = r;
        } g[15:8];

        field {
            name = "b";
            desc = "[inferred] Blue component.";
            sw = rw;
            hw = r;
        } b[7:0];
    } TDE_COLOR_SPACE_MAX @ 0x20;

    reg {
        name = "Colour-key minimum";
        desc = "[inferred] Colour-key minimum as packed 8-bit R/G/B (MiniGUI `src/newgal/hisi/tde_reg.h` (GPL-3.0, Feynman Software 2007, Hi3510 SDK register layout; https://github.com/VincentWei/MiniGUI)).";

        field {
            name = "r";
            desc = "[inferred] Red component.";
            sw = rw;
            hw = r;
        } r_f[23:16];

        field {
            name = "g";
            desc = "[inferred] Green component.";
            sw = rw;
            hw = r;
        } g[15:8];

        field {
            name = "b";
            desc = "[inferred] Blue component.";
            sw = rw;
            hw = r;
        } b[7:0];
    } TDE_COLOR_SPACE_MIN @ 0x24;

    reg {
        name = "TDE status";
        desc = "[inferred] FIFO depth and overflow history (MiniGUI `src/newgal/hisi/tde_reg.h` (GPL-3.0, Feynman Software 2007, Hi3510 SDK register layout; https://github.com/VincentWei/MiniGUI), union TDE_Reg_Status).";

        field {
            name = "history_fifooverflow";
            desc = "[inferred] FIFO overflow occurred (sticky).";
            sw = rw;
            hw = r;
        } history_fifooverflow[7:7];

        field {
            name = "fifo_depth";
            desc = "[inferred] Current FIFO depth.";
            sw = rw;
            hw = r;
        } fifo_depth[4:0];
    } TDE_STATUS @ 0x80;
};

regfile eHISI_TDE_V1 {
    name = "HiSilicon TDE v1 (linked-list engine), candidate register map";
    desc = "CANDIDATE LAYOUT, LOW CONFIDENCE, NOT HARDWARE VERIFIED, NOT INSTANTIATED. Register map of the HiSilicon TDE v1 (2013-2016 'AQ' linked-list 2D engine) as programmed by the HiSTB SDK driver (HiSTB SDK `source/msp/drv/tde/adp/tde_v1_0/tde_hal.h` + `tde_hal_k.c` (proprietary SDK upload, https://github.com/JasonFreeLab/HiSTBLinuxV100R005C00SPC050; offsets, names and written values only, no text copied)): a 42-word node image at 0x0-0xA4 (TDE_HWNode_S: instruction, two sources, target, colour conversion, CLUT, resize, de-flicker, ALU, colour key, clip, macro-block addresses, ARGB order, colorize, alpha blend, CSC tables) and control registers at 0x804-0x86C (reset, start, list address/next address/update masks, status, interrupt, bus limiter, request threshold, AXI ID); TDE_REG_SIZE 0x1000. Applicability to the Hi3520D (TDE at 0x20610000, GIC interrupt 70), Hi3516 V100, Hi3516A/D, Hi3518E/3516C, Hi3519 generations: the Hi3520D data sheet 8.1 feature list (ROP, colour key, clip, alpha, 2D resize, anti-flicker, register linked list) is the TDE v1 feature set, but the revision is unverified. Probe before use: read 0x20610000 + 0x814 (TDE_STA, expect bit 0 clear when idle) and + 0x818 (TDE_INT) with the TDE clock enabled; a Hi3510-style engine would instead answer at + 0x0/+0x80 (`eHISI_TDE_V0`). Node word bit layouts are not in the fetched files (they are in the SDK's TDE union header); only the packings visible in the driver are noted. Everything is marked `[inferred]`; reset values and access types unknown (modelled RW, no reset).

    Generated 2026-11-10 by build/rdl-audit/video-rdl-scratch/gen_tde.py.";

    reg {
        name = "Ins (node word 0)";
        desc = "[inferred] Instruction word of the node (operation type, enables; bit 14 = clip enable per the driver). Node word 0 of the TDE_HWNode_S register image: the engine loads these 42 words from the linked list (AQ) in DDR; the same words are readable here (HiSTB SDK `source/msp/drv/tde/adp/tde_v1_0/tde_hal.h` + `tde_hal_k.c` (proprietary SDK upload, https://github.com/JasonFreeLab/HiSTBLinuxV100R005C00SPC050; offsets, names and written values only, no text copied)).";

        field {
            name = "value";
            desc = "[inferred] 32-bit register value (bit layout not in the source).";
            sw = rw;
            hw = r;
        } value[31:0];
    } TDE_INS @ 0x0;

    reg {
        name = "S1 Addr (node word 1)";
        desc = "[inferred] Source 1 address. Node word 1 of the TDE_HWNode_S register image: the engine loads these 42 words from the linked list (AQ) in DDR; the same words are readable here (HiSTB SDK `source/msp/drv/tde/adp/tde_v1_0/tde_hal.h` + `tde_hal_k.c` (proprietary SDK upload, https://github.com/JasonFreeLab/HiSTBLinuxV100R005C00SPC050; offsets, names and written values only, no text copied)).";

        field {
            name = "value";
            desc = "[inferred] 32-bit register value (bit layout not in the source).";
            sw = rw;
            hw = r;
        } value[31:0];
    } TDE_S1_ADDR @ 0x4;

    reg {
        name = "S1 Type (node word 2)";
        desc = "[inferred] Source 1 type (colour format, pitch...). Node word 2 of the TDE_HWNode_S register image: the engine loads these 42 words from the linked list (AQ) in DDR; the same words are readable here (HiSTB SDK `source/msp/drv/tde/adp/tde_v1_0/tde_hal.h` + `tde_hal_k.c` (proprietary SDK upload, https://github.com/JasonFreeLab/HiSTBLinuxV100R005C00SPC050; offsets, names and written values only, no text copied)).";

        field {
            name = "value";
            desc = "[inferred] 32-bit register value (bit layout not in the source).";
            sw = rw;
            hw = r;
        } value[31:0];
    } TDE_S1_TYPE @ 0x8;

    reg {
        name = "S1 Xy (node word 3)";
        desc = "[inferred] Source 1 start position. Node word 3 of the TDE_HWNode_S register image: the engine loads these 42 words from the linked list (AQ) in DDR; the same words are readable here (HiSTB SDK `source/msp/drv/tde/adp/tde_v1_0/tde_hal.h` + `tde_hal_k.c` (proprietary SDK upload, https://github.com/JasonFreeLab/HiSTBLinuxV100R005C00SPC050; offsets, names and written values only, no text copied)).";

        field {
            name = "value";
            desc = "[inferred] 32-bit register value (bit layout not in the source).";
            sw = rw;
            hw = r;
        } value[31:0];
    } TDE_S1_XY @ 0xC;

    reg {
        name = "S1 Fill (node word 4)";
        desc = "[inferred] Source 1 fill colour. Node word 4 of the TDE_HWNode_S register image: the engine loads these 42 words from the linked list (AQ) in DDR; the same words are readable here (HiSTB SDK `source/msp/drv/tde/adp/tde_v1_0/tde_hal.h` + `tde_hal_k.c` (proprietary SDK upload, https://github.com/JasonFreeLab/HiSTBLinuxV100R005C00SPC050; offsets, names and written values only, no text copied)).";

        field {
            name = "value";
            desc = "[inferred] 32-bit register value (bit layout not in the source).";
            sw = rw;
            hw = r;
        } value[31:0];
    } TDE_S1_FILL @ 0x10;

    reg {
        name = "S2 Addr (node word 5)";
        desc = "[inferred] Source 2 address. Node word 5 of the TDE_HWNode_S register image: the engine loads these 42 words from the linked list (AQ) in DDR; the same words are readable here (HiSTB SDK `source/msp/drv/tde/adp/tde_v1_0/tde_hal.h` + `tde_hal_k.c` (proprietary SDK upload, https://github.com/JasonFreeLab/HiSTBLinuxV100R005C00SPC050; offsets, names and written values only, no text copied)).";

        field {
            name = "value";
            desc = "[inferred] 32-bit register value (bit layout not in the source).";
            sw = rw;
            hw = r;
        } value[31:0];
    } TDE_S2_ADDR @ 0x14;

    reg {
        name = "S2 Type (node word 6)";
        desc = "[inferred] Source 2 type. Node word 6 of the TDE_HWNode_S register image: the engine loads these 42 words from the linked list (AQ) in DDR; the same words are readable here (HiSTB SDK `source/msp/drv/tde/adp/tde_v1_0/tde_hal.h` + `tde_hal_k.c` (proprietary SDK upload, https://github.com/JasonFreeLab/HiSTBLinuxV100R005C00SPC050; offsets, names and written values only, no text copied)).";

        field {
            name = "value";
            desc = "[inferred] 32-bit register value (bit layout not in the source).";
            sw = rw;
            hw = r;
        } value[31:0];
    } TDE_S2_TYPE @ 0x18;

    reg {
        name = "S2 Xy (node word 7)";
        desc = "[inferred] Source 2 start position. Node word 7 of the TDE_HWNode_S register image: the engine loads these 42 words from the linked list (AQ) in DDR; the same words are readable here (HiSTB SDK `source/msp/drv/tde/adp/tde_v1_0/tde_hal.h` + `tde_hal_k.c` (proprietary SDK upload, https://github.com/JasonFreeLab/HiSTBLinuxV100R005C00SPC050; offsets, names and written values only, no text copied)).";

        field {
            name = "value";
            desc = "[inferred] 32-bit register value (bit layout not in the source).";
            sw = rw;
            hw = r;
        } value[31:0];
    } TDE_S2_XY @ 0x1C;

    reg {
        name = "S2 Size (node word 8)";
        desc = "[inferred] Source 2 size. Node word 8 of the TDE_HWNode_S register image: the engine loads these 42 words from the linked list (AQ) in DDR; the same words are readable here (HiSTB SDK `source/msp/drv/tde/adp/tde_v1_0/tde_hal.h` + `tde_hal_k.c` (proprietary SDK upload, https://github.com/JasonFreeLab/HiSTBLinuxV100R005C00SPC050; offsets, names and written values only, no text copied)).";

        field {
            name = "value";
            desc = "[inferred] 32-bit register value (bit layout not in the source).";
            sw = rw;
            hw = r;
        } value[31:0];
    } TDE_S2_SIZE @ 0x20;

    reg {
        name = "S2 Fill (node word 9)";
        desc = "[inferred] Source 2 fill colour. Node word 9 of the TDE_HWNode_S register image: the engine loads these 42 words from the linked list (AQ) in DDR; the same words are readable here (HiSTB SDK `source/msp/drv/tde/adp/tde_v1_0/tde_hal.h` + `tde_hal_k.c` (proprietary SDK upload, https://github.com/JasonFreeLab/HiSTBLinuxV100R005C00SPC050; offsets, names and written values only, no text copied)).";

        field {
            name = "value";
            desc = "[inferred] 32-bit register value (bit layout not in the source).";
            sw = rw;
            hw = r;
        } value[31:0];
    } TDE_S2_FILL @ 0x24;

    reg {
        name = "Tar Addr (node word 10)";
        desc = "[inferred] Target address. Node word 10 of the TDE_HWNode_S register image: the engine loads these 42 words from the linked list (AQ) in DDR; the same words are readable here (HiSTB SDK `source/msp/drv/tde/adp/tde_v1_0/tde_hal.h` + `tde_hal_k.c` (proprietary SDK upload, https://github.com/JasonFreeLab/HiSTBLinuxV100R005C00SPC050; offsets, names and written values only, no text copied)).";

        field {
            name = "value";
            desc = "[inferred] 32-bit register value (bit layout not in the source).";
            sw = rw;
            hw = r;
        } value[31:0];
    } TDE_TAR_ADDR @ 0x28;

    reg {
        name = "Tar Type (node word 11)";
        desc = "[inferred] Target type. Node word 11 of the TDE_HWNode_S register image: the engine loads these 42 words from the linked list (AQ) in DDR; the same words are readable here (HiSTB SDK `source/msp/drv/tde/adp/tde_v1_0/tde_hal.h` + `tde_hal_k.c` (proprietary SDK upload, https://github.com/JasonFreeLab/HiSTBLinuxV100R005C00SPC050; offsets, names and written values only, no text copied)).";

        field {
            name = "value";
            desc = "[inferred] 32-bit register value (bit layout not in the source).";
            sw = rw;
            hw = r;
        } value[31:0];
    } TDE_TAR_TYPE @ 0x2C;

    reg {
        name = "Tar Xy (node word 12)";
        desc = "[inferred] Target start position. Node word 12 of the TDE_HWNode_S register image: the engine loads these 42 words from the linked list (AQ) in DDR; the same words are readable here (HiSTB SDK `source/msp/drv/tde/adp/tde_v1_0/tde_hal.h` + `tde_hal_k.c` (proprietary SDK upload, https://github.com/JasonFreeLab/HiSTBLinuxV100R005C00SPC050; offsets, names and written values only, no text copied)).";

        field {
            name = "value";
            desc = "[inferred] 32-bit register value (bit layout not in the source).";
            sw = rw;
            hw = r;
        } value[31:0];
    } TDE_TAR_XY @ 0x30;

    reg {
        name = "Ts Size (node word 13)";
        desc = "[inferred] Target size. Node word 13 of the TDE_HWNode_S register image: the engine loads these 42 words from the linked list (AQ) in DDR; the same words are readable here (HiSTB SDK `source/msp/drv/tde/adp/tde_v1_0/tde_hal.h` + `tde_hal_k.c` (proprietary SDK upload, https://github.com/JasonFreeLab/HiSTBLinuxV100R005C00SPC050; offsets, names and written values only, no text copied)).";

        field {
            name = "value";
            desc = "[inferred] 32-bit register value (bit layout not in the source).";
            sw = rw;
            hw = r;
        } value[31:0];
    } TDE_TS_SIZE @ 0x34;

    reg {
        name = "Color Conv (node word 14)";
        desc = "[inferred] Colour conversion control. Node word 14 of the TDE_HWNode_S register image: the engine loads these 42 words from the linked list (AQ) in DDR; the same words are readable here (HiSTB SDK `source/msp/drv/tde/adp/tde_v1_0/tde_hal.h` + `tde_hal_k.c` (proprietary SDK upload, https://github.com/JasonFreeLab/HiSTBLinuxV100R005C00SPC050; offsets, names and written values only, no text copied)).";

        field {
            name = "value";
            desc = "[inferred] 32-bit register value (bit layout not in the source).";
            sw = rw;
            hw = r;
        } value[31:0];
    } TDE_COLOR_CONV @ 0x38;

    reg {
        name = "Clut Addr (node word 15)";
        desc = "[inferred] CLUT (palette) address. Node word 15 of the TDE_HWNode_S register image: the engine loads these 42 words from the linked list (AQ) in DDR; the same words are readable here (HiSTB SDK `source/msp/drv/tde/adp/tde_v1_0/tde_hal.h` + `tde_hal_k.c` (proprietary SDK upload, https://github.com/JasonFreeLab/HiSTBLinuxV100R005C00SPC050; offsets, names and written values only, no text copied)).";

        field {
            name = "value";
            desc = "[inferred] 32-bit register value (bit layout not in the source).";
            sw = rw;
            hw = r;
        } value[31:0];
    } TDE_CLUT_ADDR @ 0x3C;

    reg {
        name = "2D Rsz (node word 16)";
        desc = "[inferred] 2D resize control (bit 0 horizontal enable, bit 1 vertical enable per the driver's AlpBorder field). Node word 16 of the TDE_HWNode_S register image: the engine loads these 42 words from the linked list (AQ) in DDR; the same words are readable here (HiSTB SDK `source/msp/drv/tde/adp/tde_v1_0/tde_hal.h` + `tde_hal_k.c` (proprietary SDK upload, https://github.com/JasonFreeLab/HiSTBLinuxV100R005C00SPC050; offsets, names and written values only, no text copied)).";

        field {
            name = "value";
            desc = "[inferred] 32-bit register value (bit layout not in the source).";
            sw = rw;
            hw = r;
        } value[31:0];
    } TDE_2D_RSZ @ 0x40;

    reg {
        name = "Hf Coef Addr (node word 17)";
        desc = "[inferred] Horizontal filter coefficient table address. Node word 17 of the TDE_HWNode_S register image: the engine loads these 42 words from the linked list (AQ) in DDR; the same words are readable here (HiSTB SDK `source/msp/drv/tde/adp/tde_v1_0/tde_hal.h` + `tde_hal_k.c` (proprietary SDK upload, https://github.com/JasonFreeLab/HiSTBLinuxV100R005C00SPC050; offsets, names and written values only, no text copied)).";

        field {
            name = "value";
            desc = "[inferred] 32-bit register value (bit layout not in the source).";
            sw = rw;
            hw = r;
        } value[31:0];
    } TDE_HF_COEF_ADDR @ 0x44;

    reg {
        name = "Vf Coef Addr (node word 18)";
        desc = "[inferred] Vertical filter coefficient table address. Node word 18 of the TDE_HWNode_S register image: the engine loads these 42 words from the linked list (AQ) in DDR; the same words are readable here (HiSTB SDK `source/msp/drv/tde/adp/tde_v1_0/tde_hal.h` + `tde_hal_k.c` (proprietary SDK upload, https://github.com/JasonFreeLab/HiSTBLinuxV100R005C00SPC050; offsets, names and written values only, no text copied)).";

        field {
            name = "value";
            desc = "[inferred] 32-bit register value (bit layout not in the source).";
            sw = rw;
            hw = r;
        } value[31:0];
    } TDE_VF_COEF_ADDR @ 0x48;

    reg {
        name = "Rsz Step (node word 19)";
        desc = "[inferred] Resize horizontal step. Node word 19 of the TDE_HWNode_S register image: the engine loads these 42 words from the linked list (AQ) in DDR; the same words are readable here (HiSTB SDK `source/msp/drv/tde/adp/tde_v1_0/tde_hal.h` + `tde_hal_k.c` (proprietary SDK upload, https://github.com/JasonFreeLab/HiSTBLinuxV100R005C00SPC050; offsets, names and written values only, no text copied)).";

        field {
            name = "value";
            desc = "[inferred] 32-bit register value (bit layout not in the source).";
            sw = rw;
            hw = r;
        } value[31:0];
    } TDE_RSZ_STEP @ 0x4C;

    reg {
        name = "Rsz Y Ofst (node word 20)";
        desc = "[inferred] Resize vertical offset (bits [15:0] offset, bit 16 sign per the driver). Node word 20 of the TDE_HWNode_S register image: the engine loads these 42 words from the linked list (AQ) in DDR; the same words are readable here (HiSTB SDK `source/msp/drv/tde/adp/tde_v1_0/tde_hal.h` + `tde_hal_k.c` (proprietary SDK upload, https://github.com/JasonFreeLab/HiSTBLinuxV100R005C00SPC050; offsets, names and written values only, no text copied)).";

        field {
            name = "value";
            desc = "[inferred] 32-bit register value (bit layout not in the source).";
            sw = rw;
            hw = r;
        } value[31:0];
    } TDE_RSZ_Y_OFST @ 0x50;

    reg {
        name = "Rsz X Ofst (node word 21)";
        desc = "[inferred] Resize horizontal offset (bits [15:0] offset, bit 16 sign). Node word 21 of the TDE_HWNode_S register image: the engine loads these 42 words from the linked list (AQ) in DDR; the same words are readable here (HiSTB SDK `source/msp/drv/tde/adp/tde_v1_0/tde_hal.h` + `tde_hal_k.c` (proprietary SDK upload, https://github.com/JasonFreeLab/HiSTBLinuxV100R005C00SPC050; offsets, names and written values only, no text copied)).";

        field {
            name = "value";
            desc = "[inferred] 32-bit register value (bit layout not in the source).";
            sw = rw;
            hw = r;
        } value[31:0];
    } TDE_RSZ_X_OFST @ 0x54;

    reg {
        name = "Dfe Coef0 (node word 22)";
        desc = "[inferred] Anti-flicker (de-flicker) coefficients 0: per the driver bits [15:8] current-line coefficient, [23:16] last-line coefficient, [31:24] threshold. Node word 22 of the TDE_HWNode_S register image: the engine loads these 42 words from the linked list (AQ) in DDR; the same words are readable here (HiSTB SDK `source/msp/drv/tde/adp/tde_v1_0/tde_hal.h` + `tde_hal_k.c` (proprietary SDK upload, https://github.com/JasonFreeLab/HiSTBLinuxV100R005C00SPC050; offsets, names and written values only, no text copied)).";

        field {
            name = "value";
            desc = "[inferred] 32-bit register value (bit layout not in the source).";
            sw = rw;
            hw = r;
        } value[31:0];
    } TDE_DFE_COEF0 @ 0x58;

    reg {
        name = "Dfe Coef1 (node word 23)";
        desc = "[inferred] Anti-flicker coefficients 1 (same packing as DFE_COEF0). Node word 23 of the TDE_HWNode_S register image: the engine loads these 42 words from the linked list (AQ) in DDR; the same words are readable here (HiSTB SDK `source/msp/drv/tde/adp/tde_v1_0/tde_hal.h` + `tde_hal_k.c` (proprietary SDK upload, https://github.com/JasonFreeLab/HiSTBLinuxV100R005C00SPC050; offsets, names and written values only, no text copied)).";

        field {
            name = "value";
            desc = "[inferred] 32-bit register value (bit layout not in the source).";
            sw = rw;
            hw = r;
        } value[31:0];
    } TDE_DFE_COEF1 @ 0x5C;

    reg {
        name = "Dfe Coef2 (node word 24)";
        desc = "[inferred] Anti-flicker coefficients 2. Node word 24 of the TDE_HWNode_S register image: the engine loads these 42 words from the linked list (AQ) in DDR; the same words are readable here (HiSTB SDK `source/msp/drv/tde/adp/tde_v1_0/tde_hal.h` + `tde_hal_k.c` (proprietary SDK upload, https://github.com/JasonFreeLab/HiSTBLinuxV100R005C00SPC050; offsets, names and written values only, no text copied)).";

        field {
            name = "value";
            desc = "[inferred] 32-bit register value (bit layout not in the source).";
            sw = rw;
            hw = r;
        } value[31:0];
    } TDE_DFE_COEF2 @ 0x60;

    reg {
        name = "Dfe Coef3 (node word 25)";
        desc = "[inferred] Anti-flicker coefficients 3. Node word 25 of the TDE_HWNode_S register image: the engine loads these 42 words from the linked list (AQ) in DDR; the same words are readable here (HiSTB SDK `source/msp/drv/tde/adp/tde_v1_0/tde_hal.h` + `tde_hal_k.c` (proprietary SDK upload, https://github.com/JasonFreeLab/HiSTBLinuxV100R005C00SPC050; offsets, names and written values only, no text copied)).";

        field {
            name = "value";
            desc = "[inferred] 32-bit register value (bit layout not in the source).";
            sw = rw;
            hw = r;
        } value[31:0];
    } TDE_DFE_COEF3 @ 0x64;

    reg {
        name = "Alu (node word 26)";
        desc = "[inferred] ALU mode (ROP / blend / colour-key mode). Node word 26 of the TDE_HWNode_S register image: the engine loads these 42 words from the linked list (AQ) in DDR; the same words are readable here (HiSTB SDK `source/msp/drv/tde/adp/tde_v1_0/tde_hal.h` + `tde_hal_k.c` (proprietary SDK upload, https://github.com/JasonFreeLab/HiSTBLinuxV100R005C00SPC050; offsets, names and written values only, no text copied)).";

        field {
            name = "value";
            desc = "[inferred] 32-bit register value (bit layout not in the source).";
            sw = rw;
            hw = r;
        } value[31:0];
    } TDE_ALU @ 0x68;

    reg {
        name = "Ck Min (node word 27)";
        desc = "[inferred] Colour-key minimum: per the driver packed per component, [7:0] Cr or blue, [15:8] Cb or green, [23:16] Y or red, [31:24] alpha. Node word 27 of the TDE_HWNode_S register image: the engine loads these 42 words from the linked list (AQ) in DDR; the same words are readable here (HiSTB SDK `source/msp/drv/tde/adp/tde_v1_0/tde_hal.h` + `tde_hal_k.c` (proprietary SDK upload, https://github.com/JasonFreeLab/HiSTBLinuxV100R005C00SPC050; offsets, names and written values only, no text copied)).";

        field {
            name = "value";
            desc = "[inferred] 32-bit register value (bit layout not in the source).";
            sw = rw;
            hw = r;
        } value[31:0];
    } TDE_CK_MIN @ 0x6C;

    reg {
        name = "Ck Max (node word 28)";
        desc = "[inferred] Colour-key maximum (same packing as CK_MIN). Node word 28 of the TDE_HWNode_S register image: the engine loads these 42 words from the linked list (AQ) in DDR; the same words are readable here (HiSTB SDK `source/msp/drv/tde/adp/tde_v1_0/tde_hal.h` + `tde_hal_k.c` (proprietary SDK upload, https://github.com/JasonFreeLab/HiSTBLinuxV100R005C00SPC050; offsets, names and written values only, no text copied)).";

        field {
            name = "value";
            desc = "[inferred] 32-bit register value (bit layout not in the source).";
            sw = rw;
            hw = r;
        } value[31:0];
    } TDE_CK_MAX @ 0x70;

    reg {
        name = "Clip Start (node word 29)";
        desc = "[inferred] Clip rectangle start. Node word 29 of the TDE_HWNode_S register image: the engine loads these 42 words from the linked list (AQ) in DDR; the same words are readable here (HiSTB SDK `source/msp/drv/tde/adp/tde_v1_0/tde_hal.h` + `tde_hal_k.c` (proprietary SDK upload, https://github.com/JasonFreeLab/HiSTBLinuxV100R005C00SPC050; offsets, names and written values only, no text copied)).";

        field {
            name = "value";
            desc = "[inferred] 32-bit register value (bit layout not in the source).";
            sw = rw;
            hw = r;
        } value[31:0];
    } TDE_CLIP_START @ 0x74;

    reg {
        name = "Clip Stop (node word 30)";
        desc = "[inferred] Clip rectangle end. Node word 30 of the TDE_HWNode_S register image: the engine loads these 42 words from the linked list (AQ) in DDR; the same words are readable here (HiSTB SDK `source/msp/drv/tde/adp/tde_v1_0/tde_hal.h` + `tde_hal_k.c` (proprietary SDK upload, https://github.com/JasonFreeLab/HiSTBLinuxV100R005C00SPC050; offsets, names and written values only, no text copied)).";

        field {
            name = "value";
            desc = "[inferred] 32-bit register value (bit layout not in the source).";
            sw = rw;
            hw = r;
        } value[31:0];
    } TDE_CLIP_STOP @ 0x78;

    reg {
        name = "Y1 Addr (node word 31)";
        desc = "[inferred] Macro-block luma address (source 1). Node word 31 of the TDE_HWNode_S register image: the engine loads these 42 words from the linked list (AQ) in DDR; the same words are readable here (HiSTB SDK `source/msp/drv/tde/adp/tde_v1_0/tde_hal.h` + `tde_hal_k.c` (proprietary SDK upload, https://github.com/JasonFreeLab/HiSTBLinuxV100R005C00SPC050; offsets, names and written values only, no text copied)).";

        field {
            name = "value";
            desc = "[inferred] 32-bit register value (bit layout not in the source).";
            sw = rw;
            hw = r;
        } value[31:0];
    } TDE_Y1_ADDR @ 0x7C;

    reg {
        name = "Y1 Pitch (node word 32)";
        desc = "[inferred] Macro-block luma pitch (source 1). Node word 32 of the TDE_HWNode_S register image: the engine loads these 42 words from the linked list (AQ) in DDR; the same words are readable here (HiSTB SDK `source/msp/drv/tde/adp/tde_v1_0/tde_hal.h` + `tde_hal_k.c` (proprietary SDK upload, https://github.com/JasonFreeLab/HiSTBLinuxV100R005C00SPC050; offsets, names and written values only, no text copied)).";

        field {
            name = "value";
            desc = "[inferred] 32-bit register value (bit layout not in the source).";
            sw = rw;
            hw = r;
        } value[31:0];
    } TDE_Y1_PITCH @ 0x80;

    reg {
        name = "Y2 Addr (node word 33)";
        desc = "[inferred] Macro-block luma address (source 2). Node word 33 of the TDE_HWNode_S register image: the engine loads these 42 words from the linked list (AQ) in DDR; the same words are readable here (HiSTB SDK `source/msp/drv/tde/adp/tde_v1_0/tde_hal.h` + `tde_hal_k.c` (proprietary SDK upload, https://github.com/JasonFreeLab/HiSTBLinuxV100R005C00SPC050; offsets, names and written values only, no text copied)).";

        field {
            name = "value";
            desc = "[inferred] 32-bit register value (bit layout not in the source).";
            sw = rw;
            hw = r;
        } value[31:0];
    } TDE_Y2_ADDR @ 0x84;

    reg {
        name = "Y2 Pitch (node word 34)";
        desc = "[inferred] Macro-block luma pitch (source 2). Node word 34 of the TDE_HWNode_S register image: the engine loads these 42 words from the linked list (AQ) in DDR; the same words are readable here (HiSTB SDK `source/msp/drv/tde/adp/tde_v1_0/tde_hal.h` + `tde_hal_k.c` (proprietary SDK upload, https://github.com/JasonFreeLab/HiSTBLinuxV100R005C00SPC050; offsets, names and written values only, no text copied)).";

        field {
            name = "value";
            desc = "[inferred] 32-bit register value (bit layout not in the source).";
            sw = rw;
            hw = r;
        } value[31:0];
    } TDE_Y2_PITCH @ 0x88;

    reg {
        name = "Rsz Vstep (node word 35)";
        desc = "[inferred] Resize vertical step. Node word 35 of the TDE_HWNode_S register image: the engine loads these 42 words from the linked list (AQ) in DDR; the same words are readable here (HiSTB SDK `source/msp/drv/tde/adp/tde_v1_0/tde_hal.h` + `tde_hal_k.c` (proprietary SDK upload, https://github.com/JasonFreeLab/HiSTBLinuxV100R005C00SPC050; offsets, names and written values only, no text copied)).";

        field {
            name = "value";
            desc = "[inferred] 32-bit register value (bit layout not in the source).";
            sw = rw;
            hw = r;
        } value[31:0];
    } TDE_RSZ_VSTEP @ 0x8C;

    reg {
        name = "Argb Order (node word 36)";
        desc = "[inferred] ARGB component order. Node word 36 of the TDE_HWNode_S register image: the engine loads these 42 words from the linked list (AQ) in DDR; the same words are readable here (HiSTB SDK `source/msp/drv/tde/adp/tde_v1_0/tde_hal.h` + `tde_hal_k.c` (proprietary SDK upload, https://github.com/JasonFreeLab/HiSTBLinuxV100R005C00SPC050; offsets, names and written values only, no text copied)).";

        field {
            name = "value";
            desc = "[inferred] 32-bit register value (bit layout not in the source).";
            sw = rw;
            hw = r;
        } value[31:0];
    } TDE_ARGB_ORDER @ 0x90;

    reg {
        name = "Ck Mask (node word 37)";
        desc = "[inferred] Colour-key component mask (same packing as CK_MIN). Node word 37 of the TDE_HWNode_S register image: the engine loads these 42 words from the linked list (AQ) in DDR; the same words are readable here (HiSTB SDK `source/msp/drv/tde/adp/tde_v1_0/tde_hal.h` + `tde_hal_k.c` (proprietary SDK upload, https://github.com/JasonFreeLab/HiSTBLinuxV100R005C00SPC050; offsets, names and written values only, no text copied)).";

        field {
            name = "value";
            desc = "[inferred] 32-bit register value (bit layout not in the source).";
            sw = rw;
            hw = r;
        } value[31:0];
    } TDE_CK_MASK @ 0x94;

    reg {
        name = "Colorize (node word 38)";
        desc = "[inferred] Colorize control. Node word 38 of the TDE_HWNode_S register image: the engine loads these 42 words from the linked list (AQ) in DDR; the same words are readable here (HiSTB SDK `source/msp/drv/tde/adp/tde_v1_0/tde_hal.h` + `tde_hal_k.c` (proprietary SDK upload, https://github.com/JasonFreeLab/HiSTBLinuxV100R005C00SPC050; offsets, names and written values only, no text copied)).";

        field {
            name = "value";
            desc = "[inferred] 32-bit register value (bit layout not in the source).";
            sw = rw;
            hw = r;
        } value[31:0];
    } TDE_COLORIZE @ 0x98;

    reg {
        name = "Alpha Blend (node word 39)";
        desc = "[inferred] Alpha-blend control. Node word 39 of the TDE_HWNode_S register image: the engine loads these 42 words from the linked list (AQ) in DDR; the same words are readable here (HiSTB SDK `source/msp/drv/tde/adp/tde_v1_0/tde_hal.h` + `tde_hal_k.c` (proprietary SDK upload, https://github.com/JasonFreeLab/HiSTBLinuxV100R005C00SPC050; offsets, names and written values only, no text copied)).";

        field {
            name = "value";
            desc = "[inferred] 32-bit register value (bit layout not in the source).";
            sw = rw;
            hw = r;
        } value[31:0];
    } TDE_ALPHA_BLEND @ 0x9C;

    reg {
        name = "Icsc Addr (node word 40)";
        desc = "[inferred] Input colour-space conversion table address. Node word 40 of the TDE_HWNode_S register image: the engine loads these 42 words from the linked list (AQ) in DDR; the same words are readable here (HiSTB SDK `source/msp/drv/tde/adp/tde_v1_0/tde_hal.h` + `tde_hal_k.c` (proprietary SDK upload, https://github.com/JasonFreeLab/HiSTBLinuxV100R005C00SPC050; offsets, names and written values only, no text copied)).";

        field {
            name = "value";
            desc = "[inferred] 32-bit register value (bit layout not in the source).";
            sw = rw;
            hw = r;
        } value[31:0];
    } TDE_ICSC_ADDR @ 0xA0;

    reg {
        name = "Ocsc Addr (node word 41)";
        desc = "[inferred] Output colour-space conversion table address. Node word 41 of the TDE_HWNode_S register image: the engine loads these 42 words from the linked list (AQ) in DDR; the same words are readable here (HiSTB SDK `source/msp/drv/tde/adp/tde_v1_0/tde_hal.h` + `tde_hal_k.c` (proprietary SDK upload, https://github.com/JasonFreeLab/HiSTBLinuxV100R005C00SPC050; offsets, names and written values only, no text copied)).";

        field {
            name = "value";
            desc = "[inferred] 32-bit register value (bit layout not in the source).";
            sw = rw;
            hw = r;
        } value[31:0];
    } TDE_OCSC_ADDR @ 0xA4;

    reg {
        name = "Soft reset";
        desc = "[inferred] The driver writes 0xFFFFFFFF to reset the engine. (HiSTB SDK `source/msp/drv/tde/adp/tde_v1_0/tde_hal.h` + `tde_hal_k.c` (proprietary SDK upload, https://github.com/JasonFreeLab/HiSTBLinuxV100R005C00SPC050; offsets, names and written values only, no text copied); the control-register offsets are those listed in docs/rdl-campaign/video-online-sources.md from that driver).";

        field {
            name = "value";
            desc = "[inferred] 32-bit register value (bit layout not in the source).";
            sw = rw;
            hw = r;
        } value[31:0];
    } TDE_RST @ 0x804;

    reg {
        name = "Control / start";
        desc = "[inferred] The driver writes 0x1 to start the queued list. (HiSTB SDK `source/msp/drv/tde/adp/tde_v1_0/tde_hal.h` + `tde_hal_k.c` (proprietary SDK upload, https://github.com/JasonFreeLab/HiSTBLinuxV100R005C00SPC050; offsets, names and written values only, no text copied); the control-register offsets are those listed in docs/rdl-campaign/video-online-sources.md from that driver).";

        field {
            name = "value";
            desc = "[inferred] 32-bit register value (bit layout not in the source).";
            sw = rw;
            hw = r;
        } value[31:0];
    } TDE_CTRL @ 0x808;

    reg {
        name = "Current AQ (list) node address";
        desc = "[inferred] Address of the node being executed (read by the driver to find the current node). (HiSTB SDK `source/msp/drv/tde/adp/tde_v1_0/tde_hal.h` + `tde_hal_k.c` (proprietary SDK upload, https://github.com/JasonFreeLab/HiSTBLinuxV100R005C00SPC050; offsets, names and written values only, no text copied); the control-register offsets are those listed in docs/rdl-campaign/video-online-sources.md from that driver).";

        field {
            name = "value";
            desc = "[inferred] 32-bit register value (bit layout not in the source).";
            sw = rw;
            hw = r;
        } value[31:0];
    } TDE_AQ_ADDR @ 0x810;

    reg {
        name = "Status";
        desc = "[inferred] Bit 0 = busy (the driver treats bit 0 clear as idle). (HiSTB SDK `source/msp/drv/tde/adp/tde_v1_0/tde_hal.h` + `tde_hal_k.c` (proprietary SDK upload, https://github.com/JasonFreeLab/HiSTBLinuxV100R005C00SPC050; offsets, names and written values only, no text copied); the control-register offsets are those listed in docs/rdl-campaign/video-online-sources.md from that driver).";

        field {
            name = "value";
            desc = "[inferred] 32-bit register value (bit layout not in the source).";
            sw = rw;
            hw = r;
        } value[31:0];
    } TDE_STA @ 0x814;

    reg {
        name = "Interrupt status / mask";
        desc = "[inferred] Interrupt register; the driver writes 0x800F001F after reset and writes back the read value to acknowledge; bits [15:0] status, [31:16] mask per the driver's (status << 16) packing. (HiSTB SDK `source/msp/drv/tde/adp/tde_v1_0/tde_hal.h` + `tde_hal_k.c` (proprietary SDK upload, https://github.com/JasonFreeLab/HiSTBLinuxV100R005C00SPC050; offsets, names and written values only, no text copied); the control-register offsets are those listed in docs/rdl-campaign/video-online-sources.md from that driver).";

        field {
            name = "value";
            desc = "[inferred] 32-bit register value (bit layout not in the source).";
            sw = rw;
            hw = r;
        } value[31:0];
    } TDE_INT @ 0x818;

    reg {
        name = "AQ control";
        desc = "[inferred] List control: completion mode 0x0 = start the next list after the current list, 0x4 = after the current node and line. (HiSTB SDK `source/msp/drv/tde/adp/tde_v1_0/tde_hal.h` + `tde_hal_k.c` (proprietary SDK upload, https://github.com/JasonFreeLab/HiSTBLinuxV100R005C00SPC050; offsets, names and written values only, no text copied); the control-register offsets are those listed in docs/rdl-campaign/video-online-sources.md from that driver).";

        field {
            name = "value";
            desc = "[inferred] 32-bit register value (bit layout not in the source).";
            sw = rw;
            hw = r;
        } value[31:0];
    } TDE_AQ_CTRL @ 0x82C;

    reg {
        name = "AQ next node address";
        desc = "[inferred] Physical address of the next node to execute. (HiSTB SDK `source/msp/drv/tde/adp/tde_v1_0/tde_hal.h` + `tde_hal_k.c` (proprietary SDK upload, https://github.com/JasonFreeLab/HiSTBLinuxV100R005C00SPC050; offsets, names and written values only, no text copied); the control-register offsets are those listed in docs/rdl-campaign/video-online-sources.md from that driver).";

        field {
            name = "value";
            desc = "[inferred] 32-bit register value (bit layout not in the source).";
            sw = rw;
            hw = r;
        } value[31:0];
    } TDE_AQ_NADDR @ 0x830;

    reg {
        name = "AQ update mask (low)";
        desc = "[inferred] Low 32 bits of the 64-bit node-field update mask (which node words the list entry updates). (HiSTB SDK `source/msp/drv/tde/adp/tde_v1_0/tde_hal.h` + `tde_hal_k.c` (proprietary SDK upload, https://github.com/JasonFreeLab/HiSTBLinuxV100R005C00SPC050; offsets, names and written values only, no text copied); the control-register offsets are those listed in docs/rdl-campaign/video-online-sources.md from that driver).";

        field {
            name = "value";
            desc = "[inferred] 32-bit register value (bit layout not in the source).";
            sw = rw;
            hw = r;
        } value[31:0];
    } TDE_AQ_UPDATE @ 0x834;

    reg {
        name = "Bus limiter";
        desc = "[inferred] The driver writes 0x80770000. (HiSTB SDK `source/msp/drv/tde/adp/tde_v1_0/tde_hal.h` + `tde_hal_k.c` (proprietary SDK upload, https://github.com/JasonFreeLab/HiSTBLinuxV100R005C00SPC050; offsets, names and written values only, no text copied); the control-register offsets are those listed in docs/rdl-campaign/video-online-sources.md from that driver).";

        field {
            name = "value";
            desc = "[inferred] 32-bit register value (bit layout not in the source).";
            sw = rw;
            hw = r;
        } value[31:0];
    } TDE_BUS_LIMITER @ 0x844;

    reg {
        name = "AQ update mask (high)";
        desc = "[inferred] High 32 bits of the node-field update mask. (HiSTB SDK `source/msp/drv/tde/adp/tde_v1_0/tde_hal.h` + `tde_hal_k.c` (proprietary SDK upload, https://github.com/JasonFreeLab/HiSTBLinuxV100R005C00SPC050; offsets, names and written values only, no text copied); the control-register offsets are those listed in docs/rdl-campaign/video-online-sources.md from that driver).";

        field {
            name = "value";
            desc = "[inferred] 32-bit register value (bit layout not in the source).";
            sw = rw;
            hw = r;
        } value[31:0];
    } TDE_AQ_UPDATE2 @ 0x85C;

    reg {
        name = "Request threshold";
        desc = "[inferred] The driver writes 0x01FEF7CF. (HiSTB SDK `source/msp/drv/tde/adp/tde_v1_0/tde_hal.h` + `tde_hal_k.c` (proprietary SDK upload, https://github.com/JasonFreeLab/HiSTBLinuxV100R005C00SPC050; offsets, names and written values only, no text copied); the control-register offsets are those listed in docs/rdl-campaign/video-online-sources.md from that driver).";

        field {
            name = "value";
            desc = "[inferred] 32-bit register value (bit layout not in the source).";
            sw = rw;
            hw = r;
        } value[31:0];
    } TDE_REQ_TH @ 0x868;

    reg {
        name = "AXI ID";
        desc = "[inferred] The driver writes 0x3010. (HiSTB SDK `source/msp/drv/tde/adp/tde_v1_0/tde_hal.h` + `tde_hal_k.c` (proprietary SDK upload, https://github.com/JasonFreeLab/HiSTBLinuxV100R005C00SPC050; offsets, names and written values only, no text copied); the control-register offsets are those listed in docs/rdl-campaign/video-online-sources.md from that driver).";

        field {
            name = "value";
            desc = "[inferred] 32-bit register value (bit layout not in the source).";
            sw = rw;
            hw = r;
        } value[31:0];
    } TDE_AXI_ID @ 0x86C;
};

`endif
