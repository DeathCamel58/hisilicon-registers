`ifndef HISI_TDE_RDL
`define HISI_TDE_RDL

addrmap aHISI_TDE {
    name = "HiSilicon TDE (registers not described)";
    desc = "Not described: no register of this block is described; the registers exist only in closed vendor libraries (the MPP binary modules), not in the data sheet or any vendor source in the tree. The 64 KB window is kept only so that the block base address and size exist in the address map (STUB). Two-dimensional engine (data sheet 8.1, overview/features only): RGB/YCbCr conversion, direct copy and fill, 2D resize, anti-flicker, clip, alpha blending, colorkey, clip mask, status interrupts. No register description in the data sheet; the only vendor source is the TDE API header (`openhisilicon/include/tde_api.h`, no register map). Instances, per data sheet memory map and interrupt table (cross-chip audit 2026-11-11, docs/rdl-campaign/tde.md; every data sheet checked: none has a TDE register table, only the chapter with features): Hi3515 and Hi3520 V100 0x20140000 (VIC interrupt 18); Hi3516 V100 0x20630000 (IRQ 53); Hi3516C V100, Hi3518A/C, Hi3518E V100/V200 and Hi3516C V200 0x20610000 (IRQ 27); Hi3516A/D 0x20610000 (GIC 69); Hi3520D/Hi3515A/Hi3515C 0x20610000 (GIC 70); Hi3516A V200 and Hi3519 V101 0x11100000 (GIC 66); Hi3516A V300 0x11210000 (GIC 67). Hi3511/Hi3512 (interrupt 31, 0x90010000 reserved in the memory map) and Hi3516C V300/Hi3516E V100 (no TDE) have no window in the data sheet. Source: data sheet, confidence HIGH for base and IRQ. Listed as an open item in docs/rdl-sweep/PORT-BLOCKS.md. VENDOR MODULES (2026-11-11, docs/rdl-campaign/tde-vendor.md): static analysis of the vendor MPP TDE modules found four register generations, modelled as eHISI_TDE_G0 (Hi3518/Hi3516C V100), eHISI_TDE_G1 (Hi3520D/Hi3515A/C), eHISI_TDE_G2 (Hi3516A/D, Hi3518E V200/Hi3516C V200) and eHISI_TDE_G3 (Hi3516A V300); chips without a vendor module in the corpus (Hi3511/Hi3515 V100/Hi3520 V100, Hi3516 V100, Hi3516A V200, Hi3519) keep this window-only block.";

    external mem {
        name = "Undocumented register window";
        desc = "The whole 64 KB window of the block. Register layout unknown; placeholder so the block base address and size exist in the map. No registers are described.";
        mementries = 16384;
        memwidth = 32;
        sw = rw;
    } REGS;
};

regfile eHISI_TDE_V0 {
    name = "HiSilicon TDE, Hi3510-style register map (candidate)";
    desc = "CANDIDATE LAYOUT, LOW CONFIDENCE, NOT HARDWARE VERIFIED, NOT INSTANTIATED. First-generation two-dimensional engine register map of the Hi3510 as used by the MiniGUI NEWGAL HiSilicon backend (MiniGUI `src/newgal/hisi/tde_reg.h` (GPL-3.0, Feynman Software 2007, Hi3510 SDK register layout; https://github.com/VincentWei/MiniGUI)): 11 registers in a 0x84-byte window at Hi3510 address 0x90010300 (TDE_REG_BASE_ADDR), i.e. offset 0x300 inside a 0x90010000 block. Applicability: the Hi3511/Hi3512 data sheet describes the TDE in chapter 2D engine (VIC interrupt 31, AHB master/slave, direct copy/fill, ROP, colour key, resize) without a register chapter and lists 0x9001_0000 only as a reserved 64 KB window; the Hi3515 lists a TDE window at 0x20140000 and the Hi3520 V100 likewise, but their TDE generation is unknown. Instantiate only after a probe: read TDE_STATUS (+0x380 from the block base on the Hi3511 if the Hi3510 placement holds) and write/read TDE_SIZE. Everything is marked `[inferred]`: field names from the header, meanings from the names, reset values and access types unknown (modelled RW, no reset).

    Generated 2026-11-10 by build/rdl-audit/video-rdl-scratch/gen_tde.py.";

    reg {
        name = "TDE control / start";
        desc = "[inferred] Control register: start bit, ROP code, command bits, global alpha and in/out colour formats (MiniGUI `src/newgal/hisi/tde_reg.h` (GPL-3.0, Feynman Software 2007, Hi3510 SDK register layout; https://github.com/VincentWei/MiniGUI), union TDE_Reg_Control).";

        field {
            name = "in_color_format";
            desc = "[inferred] Input colour format code.";
            sw = rw;
            hw = r;
        } in_color_format[31:28];

        field {
            name = "out_color_format";
            desc = "[inferred] Output colour format code.";
            sw = rw;
            hw = r;
        } out_color_format[27:24];

        field {
            name = "alpha";
            desc = "[inferred] Global alpha value.";
            sw = rw;
            hw = r;
        } alpha[23:16];

        field {
            name = "tde_cmd_cmd";
            desc = "[inferred] Command type (2 bits).";
            sw = rw;
            hw = r;
        } tde_cmd_cmd[12:11];

        field {
            name = "tde_cmd_colorspace";
            desc = "[inferred] Colour-space conversion select.";
            sw = rw;
            hw = r;
        } tde_cmd_colorspace[10:10];

        field {
            name = "tde_cmd_data_opt";
            desc = "[inferred] Data operation select (2 bits).";
            sw = rw;
            hw = r;
        } tde_cmd_data_opt[9:8];

        field {
            name = "tde_cmd_outalphafrom";
            desc = "[inferred] Output alpha source select.";
            sw = rw;
            hw = r;
        } tde_cmd_outalphafrom[7:7];

        field {
            name = "rop_code";
            desc = "[inferred] Raster operation code (4 bits).";
            sw = rw;
            hw = r;
        } rop_code[5:2];

        field {
            name = "tde_start";
            desc = "[inferred] Start the operation (self-clearing).";
            sw = rw;
            hw = r;
        } tde_start[0:0];
    } TDE_CTRL @ 0x0;

    reg {
        name = "Blit size";
        desc = "[inferred] Width and height of the blit (MiniGUI `src/newgal/hisi/tde_reg.h` (GPL-3.0, Feynman Software 2007, Hi3510 SDK register layout; https://github.com/VincentWei/MiniGUI), union TDE_Reg_Size).";

        field {
            name = "blt_height";
            desc = "[inferred] Blit height in pixels.";
            sw = rw;
            hw = r;
        } blt_height[23:12];

        field {
            name = "blt_width";
            desc = "[inferred] Blit width in pixels.";
            sw = rw;
            hw = r;
        } blt_width[11:0];
    } TDE_SIZE @ 0x4;

    reg {
        name = "Source address";
        desc = "[inferred] Source bitmap physical address (MiniGUI `src/newgal/hisi/tde_reg.h` (GPL-3.0, Feynman Software 2007, Hi3510 SDK register layout; https://github.com/VincentWei/MiniGUI)).";

        field {
            name = "value";
            desc = "[inferred] 32-bit register value (bit layout not in the source).";
            sw = rw;
            hw = r;
        } value[31:0];
    } TDE_SRC_ADDR @ 0x8;

    reg {
        name = "Destination address";
        desc = "[inferred] Destination bitmap physical address (MiniGUI `src/newgal/hisi/tde_reg.h` (GPL-3.0, Feynman Software 2007, Hi3510 SDK register layout; https://github.com/VincentWei/MiniGUI)).";

        field {
            name = "value";
            desc = "[inferred] 32-bit register value (bit layout not in the source).";
            sw = rw;
            hw = r;
        } value[31:0];
    } TDE_DST_ADDR @ 0xC;

    reg {
        name = "Output address";
        desc = "[inferred] Output bitmap physical address (MiniGUI `src/newgal/hisi/tde_reg.h` (GPL-3.0, Feynman Software 2007, Hi3510 SDK register layout; https://github.com/VincentWei/MiniGUI)).";

        field {
            name = "value";
            desc = "[inferred] 32-bit register value (bit layout not in the source).";
            sw = rw;
            hw = r;
        } value[31:0];
    } TDE_OUT_ADDR @ 0x10;

    reg {
        name = "Source / destination stride";
        desc = "[inferred] Strides in bytes (MiniGUI `src/newgal/hisi/tde_reg.h` (GPL-3.0, Feynman Software 2007, Hi3510 SDK register layout; https://github.com/VincentWei/MiniGUI), union TDE_Reg_SrcDstStride).";

        field {
            name = "src_stride";
            desc = "[inferred] Source stride in bytes.";
            sw = rw;
            hw = r;
        } src_stride[31:16];

        field {
            name = "dst_stride";
            desc = "[inferred] Destination stride in bytes.";
            sw = rw;
            hw = r;
        } dst_stride[15:0];
    } TDE_SRC_DST_STRIDE @ 0x14;

    reg {
        name = "Miscellaneous";
        desc = "[inferred] Output stride, pattern size, endianness and FIFO write protection (MiniGUI `src/newgal/hisi/tde_reg.h` (GPL-3.0, Feynman Software 2007, Hi3510 SDK register layout; https://github.com/VincentWei/MiniGUI), union TDE_Reg_Misc).";

        field {
            name = "fifo_wrprotect";
            desc = "[inferred] FIFO write protection.";
            sw = rw;
            hw = r;
        } fifo_wrprotect[31:31];

        field {
            name = "endian_sel";
            desc = "[inferred] Endian select.";
            sw = rw;
            hw = r;
        } endian_sel[30:30];

        field {
            name = "pattern_width";
            desc = "[inferred] Pattern width (pattern fill).";
            sw = rw;
            hw = r;
        } pattern_width[25:21];

        field {
            name = "pattern_height";
            desc = "[inferred] Pattern height (pattern fill).";
            sw = rw;
            hw = r;
        } pattern_height[20:16];

        field {
            name = "gout_stride";
            desc = "[inferred] Output stride in bytes.";
            sw = rw;
            hw = r;
        } gout_stride[15:0];
    } TDE_MISC @ 0x18;

    reg {
        name = "Fill colour";
        desc = "[inferred] Fill colour as packed 8-bit R/G/B (MiniGUI `src/newgal/hisi/tde_reg.h` (GPL-3.0, Feynman Software 2007, Hi3510 SDK register layout; https://github.com/VincentWei/MiniGUI)).";

        field {
            name = "r";
            desc = "[inferred] Red component.";
            sw = rw;
            hw = r;
        } r_f[23:16];

        field {
            name = "g";
            desc = "[inferred] Green component.";
            sw = rw;
            hw = r;
        } g[15:8];

        field {
            name = "b";
            desc = "[inferred] Blue component.";
            sw = rw;
            hw = r;
        } b[7:0];
    } TDE_COLOR_FILLED @ 0x1C;

    reg {
        name = "Colour-key maximum";
        desc = "[inferred] Colour-key maximum as packed 8-bit R/G/B (MiniGUI `src/newgal/hisi/tde_reg.h` (GPL-3.0, Feynman Software 2007, Hi3510 SDK register layout; https://github.com/VincentWei/MiniGUI)).";

        field {
            name = "r";
            desc = "[inferred] Red component.";
            sw = rw;
            hw = r;
        } r_f[23:16];

        field {
            name = "g";
            desc = "[inferred] Green component.";
            sw = rw;
            hw = r;
        } g[15:8];

        field {
            name = "b";
            desc = "[inferred] Blue component.";
            sw = rw;
            hw = r;
        } b[7:0];
    } TDE_COLOR_SPACE_MAX @ 0x20;

    reg {
        name = "Colour-key minimum";
        desc = "[inferred] Colour-key minimum as packed 8-bit R/G/B (MiniGUI `src/newgal/hisi/tde_reg.h` (GPL-3.0, Feynman Software 2007, Hi3510 SDK register layout; https://github.com/VincentWei/MiniGUI)).";

        field {
            name = "r";
            desc = "[inferred] Red component.";
            sw = rw;
            hw = r;
        } r_f[23:16];

        field {
            name = "g";
            desc = "[inferred] Green component.";
            sw = rw;
            hw = r;
        } g[15:8];

        field {
            name = "b";
            desc = "[inferred] Blue component.";
            sw = rw;
            hw = r;
        } b[7:0];
    } TDE_COLOR_SPACE_MIN @ 0x24;

    reg {
        name = "TDE status";
        desc = "[inferred] FIFO depth and overflow history (MiniGUI `src/newgal/hisi/tde_reg.h` (GPL-3.0, Feynman Software 2007, Hi3510 SDK register layout; https://github.com/VincentWei/MiniGUI), union TDE_Reg_Status).";

        field {
            name = "history_fifooverflow";
            desc = "[inferred] FIFO overflow occurred (sticky).";
            sw = rw;
            hw = r;
        } history_fifooverflow[7:7];

        field {
            name = "fifo_depth";
            desc = "[inferred] Current FIFO depth.";
            sw = rw;
            hw = r;
        } fifo_depth[4:0];
    } TDE_STATUS @ 0x80;
};

regfile eHISI_TDE_V1 {
    name = "HiSilicon TDE v1 (linked-list engine), candidate register map";
    desc = "CANDIDATE LAYOUT, LOW CONFIDENCE, NOT HARDWARE VERIFIED, NOT INSTANTIATED. Register map of the HiSilicon TDE v1 (2013-2016 'AQ' linked-list 2D engine) as programmed by the HiSTB SDK driver (HiSTB SDK `source/msp/drv/tde/adp/tde_v1_0/tde_hal.h` + `tde_hal_k.c` (proprietary SDK upload, https://github.com/JasonFreeLab/HiSTBLinuxV100R005C00SPC050; offsets, names and written values only, no text copied)): a 42-word node image at 0x0-0xA4 (TDE_HWNode_S: instruction, two sources, target, colour conversion, CLUT, resize, de-flicker, ALU, colour key, clip, macro-block addresses, ARGB order, colorize, alpha blend, CSC tables) and control registers at 0x804-0x86C (reset, start, list address/next address/update masks, status, interrupt, bus limiter, request threshold, AXI ID); TDE_REG_SIZE 0x1000. Applicability to the Hi3520D (TDE at 0x20610000, GIC interrupt 70), Hi3516 V100, Hi3516A/D, Hi3518E/3516C, Hi3519 generations: the Hi3520D data sheet 8.1 feature list (ROP, colour key, clip, alpha, 2D resize, anti-flicker, register linked list) is the TDE v1 feature set, but the revision is unverified. Probe before use: read 0x20610000 + 0x814 (TDE_STA, expect bit 0 clear when idle) and + 0x818 (TDE_INT) with the TDE clock enabled; a Hi3510-style engine would instead answer at + 0x0/+0x80 (`eHISI_TDE_V0`). Node word bit layouts are not in the fetched files (they are in the SDK's TDE union header); only the packings visible in the driver are noted. Everything is marked `[inferred]`; reset values and access types unknown (modelled RW, no reset).

    Generated 2026-11-10 by build/rdl-audit/video-rdl-scratch/gen_tde.py.";

    reg {
        name = "Ins (node word 0)";
        desc = "[inferred] Instruction word of the node (operation type, enables; bit 14 = clip enable per the driver). Node word 0 of the TDE_HWNode_S register image: the engine loads these 42 words from the linked list (AQ) in DDR; the same words are readable here (HiSTB SDK `source/msp/drv/tde/adp/tde_v1_0/tde_hal.h` + `tde_hal_k.c` (proprietary SDK upload, https://github.com/JasonFreeLab/HiSTBLinuxV100R005C00SPC050; offsets, names and written values only, no text copied)).";

        field {
            name = "value";
            desc = "[inferred] 32-bit register value (bit layout not in the source).";
            sw = rw;
            hw = r;
        } value[31:0];
    } TDE_INS @ 0x0;

    reg {
        name = "S1 Addr (node word 1)";
        desc = "[inferred] Source 1 address. Node word 1 of the TDE_HWNode_S register image: the engine loads these 42 words from the linked list (AQ) in DDR; the same words are readable here (HiSTB SDK `source/msp/drv/tde/adp/tde_v1_0/tde_hal.h` + `tde_hal_k.c` (proprietary SDK upload, https://github.com/JasonFreeLab/HiSTBLinuxV100R005C00SPC050; offsets, names and written values only, no text copied)).";

        field {
            name = "value";
            desc = "[inferred] 32-bit register value (bit layout not in the source).";
            sw = rw;
            hw = r;
        } value[31:0];
    } TDE_S1_ADDR @ 0x4;

    reg {
        name = "S1 Type (node word 2)";
        desc = "[inferred] Source 1 type (colour format, pitch...). Node word 2 of the TDE_HWNode_S register image: the engine loads these 42 words from the linked list (AQ) in DDR; the same words are readable here (HiSTB SDK `source/msp/drv/tde/adp/tde_v1_0/tde_hal.h` + `tde_hal_k.c` (proprietary SDK upload, https://github.com/JasonFreeLab/HiSTBLinuxV100R005C00SPC050; offsets, names and written values only, no text copied)).";

        field {
            name = "value";
            desc = "[inferred] 32-bit register value (bit layout not in the source).";
            sw = rw;
            hw = r;
        } value[31:0];
    } TDE_S1_TYPE @ 0x8;

    reg {
        name = "S1 Xy (node word 3)";
        desc = "[inferred] Source 1 start position. Node word 3 of the TDE_HWNode_S register image: the engine loads these 42 words from the linked list (AQ) in DDR; the same words are readable here (HiSTB SDK `source/msp/drv/tde/adp/tde_v1_0/tde_hal.h` + `tde_hal_k.c` (proprietary SDK upload, https://github.com/JasonFreeLab/HiSTBLinuxV100R005C00SPC050; offsets, names and written values only, no text copied)).";

        field {
            name = "value";
            desc = "[inferred] 32-bit register value (bit layout not in the source).";
            sw = rw;
            hw = r;
        } value[31:0];
    } TDE_S1_XY @ 0xC;

    reg {
        name = "S1 Fill (node word 4)";
        desc = "[inferred] Source 1 fill colour. Node word 4 of the TDE_HWNode_S register image: the engine loads these 42 words from the linked list (AQ) in DDR; the same words are readable here (HiSTB SDK `source/msp/drv/tde/adp/tde_v1_0/tde_hal.h` + `tde_hal_k.c` (proprietary SDK upload, https://github.com/JasonFreeLab/HiSTBLinuxV100R005C00SPC050; offsets, names and written values only, no text copied)).";

        field {
            name = "value";
            desc = "[inferred] 32-bit register value (bit layout not in the source).";
            sw = rw;
            hw = r;
        } value[31:0];
    } TDE_S1_FILL @ 0x10;

    reg {
        name = "S2 Addr (node word 5)";
        desc = "[inferred] Source 2 address. Node word 5 of the TDE_HWNode_S register image: the engine loads these 42 words from the linked list (AQ) in DDR; the same words are readable here (HiSTB SDK `source/msp/drv/tde/adp/tde_v1_0/tde_hal.h` + `tde_hal_k.c` (proprietary SDK upload, https://github.com/JasonFreeLab/HiSTBLinuxV100R005C00SPC050; offsets, names and written values only, no text copied)).";

        field {
            name = "value";
            desc = "[inferred] 32-bit register value (bit layout not in the source).";
            sw = rw;
            hw = r;
        } value[31:0];
    } TDE_S2_ADDR @ 0x14;

    reg {
        name = "S2 Type (node word 6)";
        desc = "[inferred] Source 2 type. Node word 6 of the TDE_HWNode_S register image: the engine loads these 42 words from the linked list (AQ) in DDR; the same words are readable here (HiSTB SDK `source/msp/drv/tde/adp/tde_v1_0/tde_hal.h` + `tde_hal_k.c` (proprietary SDK upload, https://github.com/JasonFreeLab/HiSTBLinuxV100R005C00SPC050; offsets, names and written values only, no text copied)).";

        field {
            name = "value";
            desc = "[inferred] 32-bit register value (bit layout not in the source).";
            sw = rw;
            hw = r;
        } value[31:0];
    } TDE_S2_TYPE @ 0x18;

    reg {
        name = "S2 Xy (node word 7)";
        desc = "[inferred] Source 2 start position. Node word 7 of the TDE_HWNode_S register image: the engine loads these 42 words from the linked list (AQ) in DDR; the same words are readable here (HiSTB SDK `source/msp/drv/tde/adp/tde_v1_0/tde_hal.h` + `tde_hal_k.c` (proprietary SDK upload, https://github.com/JasonFreeLab/HiSTBLinuxV100R005C00SPC050; offsets, names and written values only, no text copied)).";

        field {
            name = "value";
            desc = "[inferred] 32-bit register value (bit layout not in the source).";
            sw = rw;
            hw = r;
        } value[31:0];
    } TDE_S2_XY @ 0x1C;

    reg {
        name = "S2 Size (node word 8)";
        desc = "[inferred] Source 2 size. Node word 8 of the TDE_HWNode_S register image: the engine loads these 42 words from the linked list (AQ) in DDR; the same words are readable here (HiSTB SDK `source/msp/drv/tde/adp/tde_v1_0/tde_hal.h` + `tde_hal_k.c` (proprietary SDK upload, https://github.com/JasonFreeLab/HiSTBLinuxV100R005C00SPC050; offsets, names and written values only, no text copied)).";

        field {
            name = "value";
            desc = "[inferred] 32-bit register value (bit layout not in the source).";
            sw = rw;
            hw = r;
        } value[31:0];
    } TDE_S2_SIZE @ 0x20;

    reg {
        name = "S2 Fill (node word 9)";
        desc = "[inferred] Source 2 fill colour. Node word 9 of the TDE_HWNode_S register image: the engine loads these 42 words from the linked list (AQ) in DDR; the same words are readable here (HiSTB SDK `source/msp/drv/tde/adp/tde_v1_0/tde_hal.h` + `tde_hal_k.c` (proprietary SDK upload, https://github.com/JasonFreeLab/HiSTBLinuxV100R005C00SPC050; offsets, names and written values only, no text copied)).";

        field {
            name = "value";
            desc = "[inferred] 32-bit register value (bit layout not in the source).";
            sw = rw;
            hw = r;
        } value[31:0];
    } TDE_S2_FILL @ 0x24;

    reg {
        name = "Tar Addr (node word 10)";
        desc = "[inferred] Target address. Node word 10 of the TDE_HWNode_S register image: the engine loads these 42 words from the linked list (AQ) in DDR; the same words are readable here (HiSTB SDK `source/msp/drv/tde/adp/tde_v1_0/tde_hal.h` + `tde_hal_k.c` (proprietary SDK upload, https://github.com/JasonFreeLab/HiSTBLinuxV100R005C00SPC050; offsets, names and written values only, no text copied)).";

        field {
            name = "value";
            desc = "[inferred] 32-bit register value (bit layout not in the source).";
            sw = rw;
            hw = r;
        } value[31:0];
    } TDE_TAR_ADDR @ 0x28;

    reg {
        name = "Tar Type (node word 11)";
        desc = "[inferred] Target type. Node word 11 of the TDE_HWNode_S register image: the engine loads these 42 words from the linked list (AQ) in DDR; the same words are readable here (HiSTB SDK `source/msp/drv/tde/adp/tde_v1_0/tde_hal.h` + `tde_hal_k.c` (proprietary SDK upload, https://github.com/JasonFreeLab/HiSTBLinuxV100R005C00SPC050; offsets, names and written values only, no text copied)).";

        field {
            name = "value";
            desc = "[inferred] 32-bit register value (bit layout not in the source).";
            sw = rw;
            hw = r;
        } value[31:0];
    } TDE_TAR_TYPE @ 0x2C;

    reg {
        name = "Tar Xy (node word 12)";
        desc = "[inferred] Target start position. Node word 12 of the TDE_HWNode_S register image: the engine loads these 42 words from the linked list (AQ) in DDR; the same words are readable here (HiSTB SDK `source/msp/drv/tde/adp/tde_v1_0/tde_hal.h` + `tde_hal_k.c` (proprietary SDK upload, https://github.com/JasonFreeLab/HiSTBLinuxV100R005C00SPC050; offsets, names and written values only, no text copied)).";

        field {
            name = "value";
            desc = "[inferred] 32-bit register value (bit layout not in the source).";
            sw = rw;
            hw = r;
        } value[31:0];
    } TDE_TAR_XY @ 0x30;

    reg {
        name = "Ts Size (node word 13)";
        desc = "[inferred] Target size. Node word 13 of the TDE_HWNode_S register image: the engine loads these 42 words from the linked list (AQ) in DDR; the same words are readable here (HiSTB SDK `source/msp/drv/tde/adp/tde_v1_0/tde_hal.h` + `tde_hal_k.c` (proprietary SDK upload, https://github.com/JasonFreeLab/HiSTBLinuxV100R005C00SPC050; offsets, names and written values only, no text copied)).";

        field {
            name = "value";
            desc = "[inferred] 32-bit register value (bit layout not in the source).";
            sw = rw;
            hw = r;
        } value[31:0];
    } TDE_TS_SIZE @ 0x34;

    reg {
        name = "Color Conv (node word 14)";
        desc = "[inferred] Colour conversion control. Node word 14 of the TDE_HWNode_S register image: the engine loads these 42 words from the linked list (AQ) in DDR; the same words are readable here (HiSTB SDK `source/msp/drv/tde/adp/tde_v1_0/tde_hal.h` + `tde_hal_k.c` (proprietary SDK upload, https://github.com/JasonFreeLab/HiSTBLinuxV100R005C00SPC050; offsets, names and written values only, no text copied)).";

        field {
            name = "value";
            desc = "[inferred] 32-bit register value (bit layout not in the source).";
            sw = rw;
            hw = r;
        } value[31:0];
    } TDE_COLOR_CONV @ 0x38;

    reg {
        name = "Clut Addr (node word 15)";
        desc = "[inferred] CLUT (palette) address. Node word 15 of the TDE_HWNode_S register image: the engine loads these 42 words from the linked list (AQ) in DDR; the same words are readable here (HiSTB SDK `source/msp/drv/tde/adp/tde_v1_0/tde_hal.h` + `tde_hal_k.c` (proprietary SDK upload, https://github.com/JasonFreeLab/HiSTBLinuxV100R005C00SPC050; offsets, names and written values only, no text copied)).";

        field {
            name = "value";
            desc = "[inferred] 32-bit register value (bit layout not in the source).";
            sw = rw;
            hw = r;
        } value[31:0];
    } TDE_CLUT_ADDR @ 0x3C;

    reg {
        name = "2D Rsz (node word 16)";
        desc = "[inferred] 2D resize control (bit 0 horizontal enable, bit 1 vertical enable per the driver's AlpBorder field). Node word 16 of the TDE_HWNode_S register image: the engine loads these 42 words from the linked list (AQ) in DDR; the same words are readable here (HiSTB SDK `source/msp/drv/tde/adp/tde_v1_0/tde_hal.h` + `tde_hal_k.c` (proprietary SDK upload, https://github.com/JasonFreeLab/HiSTBLinuxV100R005C00SPC050; offsets, names and written values only, no text copied)).";

        field {
            name = "value";
            desc = "[inferred] 32-bit register value (bit layout not in the source).";
            sw = rw;
            hw = r;
        } value[31:0];
    } TDE_2D_RSZ @ 0x40;

    reg {
        name = "Hf Coef Addr (node word 17)";
        desc = "[inferred] Horizontal filter coefficient table address. Node word 17 of the TDE_HWNode_S register image: the engine loads these 42 words from the linked list (AQ) in DDR; the same words are readable here (HiSTB SDK `source/msp/drv/tde/adp/tde_v1_0/tde_hal.h` + `tde_hal_k.c` (proprietary SDK upload, https://github.com/JasonFreeLab/HiSTBLinuxV100R005C00SPC050; offsets, names and written values only, no text copied)).";

        field {
            name = "value";
            desc = "[inferred] 32-bit register value (bit layout not in the source).";
            sw = rw;
            hw = r;
        } value[31:0];
    } TDE_HF_COEF_ADDR @ 0x44;

    reg {
        name = "Vf Coef Addr (node word 18)";
        desc = "[inferred] Vertical filter coefficient table address. Node word 18 of the TDE_HWNode_S register image: the engine loads these 42 words from the linked list (AQ) in DDR; the same words are readable here (HiSTB SDK `source/msp/drv/tde/adp/tde_v1_0/tde_hal.h` + `tde_hal_k.c` (proprietary SDK upload, https://github.com/JasonFreeLab/HiSTBLinuxV100R005C00SPC050; offsets, names and written values only, no text copied)).";

        field {
            name = "value";
            desc = "[inferred] 32-bit register value (bit layout not in the source).";
            sw = rw;
            hw = r;
        } value[31:0];
    } TDE_VF_COEF_ADDR @ 0x48;

    reg {
        name = "Rsz Step (node word 19)";
        desc = "[inferred] Resize horizontal step. Node word 19 of the TDE_HWNode_S register image: the engine loads these 42 words from the linked list (AQ) in DDR; the same words are readable here (HiSTB SDK `source/msp/drv/tde/adp/tde_v1_0/tde_hal.h` + `tde_hal_k.c` (proprietary SDK upload, https://github.com/JasonFreeLab/HiSTBLinuxV100R005C00SPC050; offsets, names and written values only, no text copied)).";

        field {
            name = "value";
            desc = "[inferred] 32-bit register value (bit layout not in the source).";
            sw = rw;
            hw = r;
        } value[31:0];
    } TDE_RSZ_STEP @ 0x4C;

    reg {
        name = "Rsz Y Ofst (node word 20)";
        desc = "[inferred] Resize vertical offset (bits [15:0] offset, bit 16 sign per the driver). Node word 20 of the TDE_HWNode_S register image: the engine loads these 42 words from the linked list (AQ) in DDR; the same words are readable here (HiSTB SDK `source/msp/drv/tde/adp/tde_v1_0/tde_hal.h` + `tde_hal_k.c` (proprietary SDK upload, https://github.com/JasonFreeLab/HiSTBLinuxV100R005C00SPC050; offsets, names and written values only, no text copied)).";

        field {
            name = "value";
            desc = "[inferred] 32-bit register value (bit layout not in the source).";
            sw = rw;
            hw = r;
        } value[31:0];
    } TDE_RSZ_Y_OFST @ 0x50;

    reg {
        name = "Rsz X Ofst (node word 21)";
        desc = "[inferred] Resize horizontal offset (bits [15:0] offset, bit 16 sign). Node word 21 of the TDE_HWNode_S register image: the engine loads these 42 words from the linked list (AQ) in DDR; the same words are readable here (HiSTB SDK `source/msp/drv/tde/adp/tde_v1_0/tde_hal.h` + `tde_hal_k.c` (proprietary SDK upload, https://github.com/JasonFreeLab/HiSTBLinuxV100R005C00SPC050; offsets, names and written values only, no text copied)).";

        field {
            name = "value";
            desc = "[inferred] 32-bit register value (bit layout not in the source).";
            sw = rw;
            hw = r;
        } value[31:0];
    } TDE_RSZ_X_OFST @ 0x54;

    reg {
        name = "Dfe Coef0 (node word 22)";
        desc = "[inferred] Anti-flicker (de-flicker) coefficients 0: per the driver bits [15:8] current-line coefficient, [23:16] last-line coefficient, [31:24] threshold. Node word 22 of the TDE_HWNode_S register image: the engine loads these 42 words from the linked list (AQ) in DDR; the same words are readable here (HiSTB SDK `source/msp/drv/tde/adp/tde_v1_0/tde_hal.h` + `tde_hal_k.c` (proprietary SDK upload, https://github.com/JasonFreeLab/HiSTBLinuxV100R005C00SPC050; offsets, names and written values only, no text copied)).";

        field {
            name = "value";
            desc = "[inferred] 32-bit register value (bit layout not in the source).";
            sw = rw;
            hw = r;
        } value[31:0];
    } TDE_DFE_COEF0 @ 0x58;

    reg {
        name = "Dfe Coef1 (node word 23)";
        desc = "[inferred] Anti-flicker coefficients 1 (same packing as DFE_COEF0). Node word 23 of the TDE_HWNode_S register image: the engine loads these 42 words from the linked list (AQ) in DDR; the same words are readable here (HiSTB SDK `source/msp/drv/tde/adp/tde_v1_0/tde_hal.h` + `tde_hal_k.c` (proprietary SDK upload, https://github.com/JasonFreeLab/HiSTBLinuxV100R005C00SPC050; offsets, names and written values only, no text copied)).";

        field {
            name = "value";
            desc = "[inferred] 32-bit register value (bit layout not in the source).";
            sw = rw;
            hw = r;
        } value[31:0];
    } TDE_DFE_COEF1 @ 0x5C;

    reg {
        name = "Dfe Coef2 (node word 24)";
        desc = "[inferred] Anti-flicker coefficients 2. Node word 24 of the TDE_HWNode_S register image: the engine loads these 42 words from the linked list (AQ) in DDR; the same words are readable here (HiSTB SDK `source/msp/drv/tde/adp/tde_v1_0/tde_hal.h` + `tde_hal_k.c` (proprietary SDK upload, https://github.com/JasonFreeLab/HiSTBLinuxV100R005C00SPC050; offsets, names and written values only, no text copied)).";

        field {
            name = "value";
            desc = "[inferred] 32-bit register value (bit layout not in the source).";
            sw = rw;
            hw = r;
        } value[31:0];
    } TDE_DFE_COEF2 @ 0x60;

    reg {
        name = "Dfe Coef3 (node word 25)";
        desc = "[inferred] Anti-flicker coefficients 3. Node word 25 of the TDE_HWNode_S register image: the engine loads these 42 words from the linked list (AQ) in DDR; the same words are readable here (HiSTB SDK `source/msp/drv/tde/adp/tde_v1_0/tde_hal.h` + `tde_hal_k.c` (proprietary SDK upload, https://github.com/JasonFreeLab/HiSTBLinuxV100R005C00SPC050; offsets, names and written values only, no text copied)).";

        field {
            name = "value";
            desc = "[inferred] 32-bit register value (bit layout not in the source).";
            sw = rw;
            hw = r;
        } value[31:0];
    } TDE_DFE_COEF3 @ 0x64;

    reg {
        name = "Alu (node word 26)";
        desc = "[inferred] ALU mode (ROP / blend / colour-key mode). Node word 26 of the TDE_HWNode_S register image: the engine loads these 42 words from the linked list (AQ) in DDR; the same words are readable here (HiSTB SDK `source/msp/drv/tde/adp/tde_v1_0/tde_hal.h` + `tde_hal_k.c` (proprietary SDK upload, https://github.com/JasonFreeLab/HiSTBLinuxV100R005C00SPC050; offsets, names and written values only, no text copied)).";

        field {
            name = "value";
            desc = "[inferred] 32-bit register value (bit layout not in the source).";
            sw = rw;
            hw = r;
        } value[31:0];
    } TDE_ALU @ 0x68;

    reg {
        name = "Ck Min (node word 27)";
        desc = "[inferred] Colour-key minimum: per the driver packed per component, [7:0] Cr or blue, [15:8] Cb or green, [23:16] Y or red, [31:24] alpha. Node word 27 of the TDE_HWNode_S register image: the engine loads these 42 words from the linked list (AQ) in DDR; the same words are readable here (HiSTB SDK `source/msp/drv/tde/adp/tde_v1_0/tde_hal.h` + `tde_hal_k.c` (proprietary SDK upload, https://github.com/JasonFreeLab/HiSTBLinuxV100R005C00SPC050; offsets, names and written values only, no text copied)).";

        field {
            name = "value";
            desc = "[inferred] 32-bit register value (bit layout not in the source).";
            sw = rw;
            hw = r;
        } value[31:0];
    } TDE_CK_MIN @ 0x6C;

    reg {
        name = "Ck Max (node word 28)";
        desc = "[inferred] Colour-key maximum (same packing as CK_MIN). Node word 28 of the TDE_HWNode_S register image: the engine loads these 42 words from the linked list (AQ) in DDR; the same words are readable here (HiSTB SDK `source/msp/drv/tde/adp/tde_v1_0/tde_hal.h` + `tde_hal_k.c` (proprietary SDK upload, https://github.com/JasonFreeLab/HiSTBLinuxV100R005C00SPC050; offsets, names and written values only, no text copied)).";

        field {
            name = "value";
            desc = "[inferred] 32-bit register value (bit layout not in the source).";
            sw = rw;
            hw = r;
        } value[31:0];
    } TDE_CK_MAX @ 0x70;

    reg {
        name = "Clip Start (node word 29)";
        desc = "[inferred] Clip rectangle start. Node word 29 of the TDE_HWNode_S register image: the engine loads these 42 words from the linked list (AQ) in DDR; the same words are readable here (HiSTB SDK `source/msp/drv/tde/adp/tde_v1_0/tde_hal.h` + `tde_hal_k.c` (proprietary SDK upload, https://github.com/JasonFreeLab/HiSTBLinuxV100R005C00SPC050; offsets, names and written values only, no text copied)).";

        field {
            name = "value";
            desc = "[inferred] 32-bit register value (bit layout not in the source).";
            sw = rw;
            hw = r;
        } value[31:0];
    } TDE_CLIP_START @ 0x74;

    reg {
        name = "Clip Stop (node word 30)";
        desc = "[inferred] Clip rectangle end. Node word 30 of the TDE_HWNode_S register image: the engine loads these 42 words from the linked list (AQ) in DDR; the same words are readable here (HiSTB SDK `source/msp/drv/tde/adp/tde_v1_0/tde_hal.h` + `tde_hal_k.c` (proprietary SDK upload, https://github.com/JasonFreeLab/HiSTBLinuxV100R005C00SPC050; offsets, names and written values only, no text copied)).";

        field {
            name = "value";
            desc = "[inferred] 32-bit register value (bit layout not in the source).";
            sw = rw;
            hw = r;
        } value[31:0];
    } TDE_CLIP_STOP @ 0x78;

    reg {
        name = "Y1 Addr (node word 31)";
        desc = "[inferred] Macro-block luma address (source 1). Node word 31 of the TDE_HWNode_S register image: the engine loads these 42 words from the linked list (AQ) in DDR; the same words are readable here (HiSTB SDK `source/msp/drv/tde/adp/tde_v1_0/tde_hal.h` + `tde_hal_k.c` (proprietary SDK upload, https://github.com/JasonFreeLab/HiSTBLinuxV100R005C00SPC050; offsets, names and written values only, no text copied)).";

        field {
            name = "value";
            desc = "[inferred] 32-bit register value (bit layout not in the source).";
            sw = rw;
            hw = r;
        } value[31:0];
    } TDE_Y1_ADDR @ 0x7C;

    reg {
        name = "Y1 Pitch (node word 32)";
        desc = "[inferred] Macro-block luma pitch (source 1). Node word 32 of the TDE_HWNode_S register image: the engine loads these 42 words from the linked list (AQ) in DDR; the same words are readable here (HiSTB SDK `source/msp/drv/tde/adp/tde_v1_0/tde_hal.h` + `tde_hal_k.c` (proprietary SDK upload, https://github.com/JasonFreeLab/HiSTBLinuxV100R005C00SPC050; offsets, names and written values only, no text copied)).";

        field {
            name = "value";
            desc = "[inferred] 32-bit register value (bit layout not in the source).";
            sw = rw;
            hw = r;
        } value[31:0];
    } TDE_Y1_PITCH @ 0x80;

    reg {
        name = "Y2 Addr (node word 33)";
        desc = "[inferred] Macro-block luma address (source 2). Node word 33 of the TDE_HWNode_S register image: the engine loads these 42 words from the linked list (AQ) in DDR; the same words are readable here (HiSTB SDK `source/msp/drv/tde/adp/tde_v1_0/tde_hal.h` + `tde_hal_k.c` (proprietary SDK upload, https://github.com/JasonFreeLab/HiSTBLinuxV100R005C00SPC050; offsets, names and written values only, no text copied)).";

        field {
            name = "value";
            desc = "[inferred] 32-bit register value (bit layout not in the source).";
            sw = rw;
            hw = r;
        } value[31:0];
    } TDE_Y2_ADDR @ 0x84;

    reg {
        name = "Y2 Pitch (node word 34)";
        desc = "[inferred] Macro-block luma pitch (source 2). Node word 34 of the TDE_HWNode_S register image: the engine loads these 42 words from the linked list (AQ) in DDR; the same words are readable here (HiSTB SDK `source/msp/drv/tde/adp/tde_v1_0/tde_hal.h` + `tde_hal_k.c` (proprietary SDK upload, https://github.com/JasonFreeLab/HiSTBLinuxV100R005C00SPC050; offsets, names and written values only, no text copied)).";

        field {
            name = "value";
            desc = "[inferred] 32-bit register value (bit layout not in the source).";
            sw = rw;
            hw = r;
        } value[31:0];
    } TDE_Y2_PITCH @ 0x88;

    reg {
        name = "Rsz Vstep (node word 35)";
        desc = "[inferred] Resize vertical step. Node word 35 of the TDE_HWNode_S register image: the engine loads these 42 words from the linked list (AQ) in DDR; the same words are readable here (HiSTB SDK `source/msp/drv/tde/adp/tde_v1_0/tde_hal.h` + `tde_hal_k.c` (proprietary SDK upload, https://github.com/JasonFreeLab/HiSTBLinuxV100R005C00SPC050; offsets, names and written values only, no text copied)).";

        field {
            name = "value";
            desc = "[inferred] 32-bit register value (bit layout not in the source).";
            sw = rw;
            hw = r;
        } value[31:0];
    } TDE_RSZ_VSTEP @ 0x8C;

    reg {
        name = "Argb Order (node word 36)";
        desc = "[inferred] ARGB component order. Node word 36 of the TDE_HWNode_S register image: the engine loads these 42 words from the linked list (AQ) in DDR; the same words are readable here (HiSTB SDK `source/msp/drv/tde/adp/tde_v1_0/tde_hal.h` + `tde_hal_k.c` (proprietary SDK upload, https://github.com/JasonFreeLab/HiSTBLinuxV100R005C00SPC050; offsets, names and written values only, no text copied)).";

        field {
            name = "value";
            desc = "[inferred] 32-bit register value (bit layout not in the source).";
            sw = rw;
            hw = r;
        } value[31:0];
    } TDE_ARGB_ORDER @ 0x90;

    reg {
        name = "Ck Mask (node word 37)";
        desc = "[inferred] Colour-key component mask (same packing as CK_MIN). Node word 37 of the TDE_HWNode_S register image: the engine loads these 42 words from the linked list (AQ) in DDR; the same words are readable here (HiSTB SDK `source/msp/drv/tde/adp/tde_v1_0/tde_hal.h` + `tde_hal_k.c` (proprietary SDK upload, https://github.com/JasonFreeLab/HiSTBLinuxV100R005C00SPC050; offsets, names and written values only, no text copied)).";

        field {
            name = "value";
            desc = "[inferred] 32-bit register value (bit layout not in the source).";
            sw = rw;
            hw = r;
        } value[31:0];
    } TDE_CK_MASK @ 0x94;

    reg {
        name = "Colorize (node word 38)";
        desc = "[inferred] Colorize control. Node word 38 of the TDE_HWNode_S register image: the engine loads these 42 words from the linked list (AQ) in DDR; the same words are readable here (HiSTB SDK `source/msp/drv/tde/adp/tde_v1_0/tde_hal.h` + `tde_hal_k.c` (proprietary SDK upload, https://github.com/JasonFreeLab/HiSTBLinuxV100R005C00SPC050; offsets, names and written values only, no text copied)).";

        field {
            name = "value";
            desc = "[inferred] 32-bit register value (bit layout not in the source).";
            sw = rw;
            hw = r;
        } value[31:0];
    } TDE_COLORIZE @ 0x98;

    reg {
        name = "Alpha Blend (node word 39)";
        desc = "[inferred] Alpha-blend control. Node word 39 of the TDE_HWNode_S register image: the engine loads these 42 words from the linked list (AQ) in DDR; the same words are readable here (HiSTB SDK `source/msp/drv/tde/adp/tde_v1_0/tde_hal.h` + `tde_hal_k.c` (proprietary SDK upload, https://github.com/JasonFreeLab/HiSTBLinuxV100R005C00SPC050; offsets, names and written values only, no text copied)).";

        field {
            name = "value";
            desc = "[inferred] 32-bit register value (bit layout not in the source).";
            sw = rw;
            hw = r;
        } value[31:0];
    } TDE_ALPHA_BLEND @ 0x9C;

    reg {
        name = "Icsc Addr (node word 40)";
        desc = "[inferred] Input colour-space conversion table address. Node word 40 of the TDE_HWNode_S register image: the engine loads these 42 words from the linked list (AQ) in DDR; the same words are readable here (HiSTB SDK `source/msp/drv/tde/adp/tde_v1_0/tde_hal.h` + `tde_hal_k.c` (proprietary SDK upload, https://github.com/JasonFreeLab/HiSTBLinuxV100R005C00SPC050; offsets, names and written values only, no text copied)).";

        field {
            name = "value";
            desc = "[inferred] 32-bit register value (bit layout not in the source).";
            sw = rw;
            hw = r;
        } value[31:0];
    } TDE_ICSC_ADDR @ 0xA0;

    reg {
        name = "Ocsc Addr (node word 41)";
        desc = "[inferred] Output colour-space conversion table address. Node word 41 of the TDE_HWNode_S register image: the engine loads these 42 words from the linked list (AQ) in DDR; the same words are readable here (HiSTB SDK `source/msp/drv/tde/adp/tde_v1_0/tde_hal.h` + `tde_hal_k.c` (proprietary SDK upload, https://github.com/JasonFreeLab/HiSTBLinuxV100R005C00SPC050; offsets, names and written values only, no text copied)).";

        field {
            name = "value";
            desc = "[inferred] 32-bit register value (bit layout not in the source).";
            sw = rw;
            hw = r;
        } value[31:0];
    } TDE_OCSC_ADDR @ 0xA4;

    reg {
        name = "Soft reset";
        desc = "[inferred] The driver writes 0xFFFFFFFF to reset the engine. (HiSTB SDK `source/msp/drv/tde/adp/tde_v1_0/tde_hal.h` + `tde_hal_k.c` (proprietary SDK upload, https://github.com/JasonFreeLab/HiSTBLinuxV100R005C00SPC050; offsets, names and written values only, no text copied); the control-register offsets are those listed in docs/rdl-campaign/video-online-sources.md from that driver).";

        field {
            name = "value";
            desc = "[inferred] 32-bit register value (bit layout not in the source).";
            sw = rw;
            hw = r;
        } value[31:0];
    } TDE_RST @ 0x804;

    reg {
        name = "Control / start";
        desc = "[inferred] The driver writes 0x1 to start the queued list. (HiSTB SDK `source/msp/drv/tde/adp/tde_v1_0/tde_hal.h` + `tde_hal_k.c` (proprietary SDK upload, https://github.com/JasonFreeLab/HiSTBLinuxV100R005C00SPC050; offsets, names and written values only, no text copied); the control-register offsets are those listed in docs/rdl-campaign/video-online-sources.md from that driver).";

        field {
            name = "value";
            desc = "[inferred] 32-bit register value (bit layout not in the source).";
            sw = rw;
            hw = r;
        } value[31:0];
    } TDE_CTRL @ 0x808;

    reg {
        name = "Current AQ (list) node address";
        desc = "[inferred] Address of the node being executed (read by the driver to find the current node). (HiSTB SDK `source/msp/drv/tde/adp/tde_v1_0/tde_hal.h` + `tde_hal_k.c` (proprietary SDK upload, https://github.com/JasonFreeLab/HiSTBLinuxV100R005C00SPC050; offsets, names and written values only, no text copied); the control-register offsets are those listed in docs/rdl-campaign/video-online-sources.md from that driver).";

        field {
            name = "value";
            desc = "[inferred] 32-bit register value (bit layout not in the source).";
            sw = rw;
            hw = r;
        } value[31:0];
    } TDE_AQ_ADDR @ 0x810;

    reg {
        name = "Status";
        desc = "[inferred] Bit 0 = busy (the driver treats bit 0 clear as idle). (HiSTB SDK `source/msp/drv/tde/adp/tde_v1_0/tde_hal.h` + `tde_hal_k.c` (proprietary SDK upload, https://github.com/JasonFreeLab/HiSTBLinuxV100R005C00SPC050; offsets, names and written values only, no text copied); the control-register offsets are those listed in docs/rdl-campaign/video-online-sources.md from that driver).";

        field {
            name = "value";
            desc = "[inferred] 32-bit register value (bit layout not in the source).";
            sw = rw;
            hw = r;
        } value[31:0];
    } TDE_STA @ 0x814;

    reg {
        name = "Interrupt status / mask";
        desc = "[inferred] Interrupt register; the driver writes 0x800F001F after reset and writes back the read value to acknowledge; bits [15:0] status, [31:16] mask per the driver's (status << 16) packing. (HiSTB SDK `source/msp/drv/tde/adp/tde_v1_0/tde_hal.h` + `tde_hal_k.c` (proprietary SDK upload, https://github.com/JasonFreeLab/HiSTBLinuxV100R005C00SPC050; offsets, names and written values only, no text copied); the control-register offsets are those listed in docs/rdl-campaign/video-online-sources.md from that driver).";

        field {
            name = "value";
            desc = "[inferred] 32-bit register value (bit layout not in the source).";
            sw = rw;
            hw = r;
        } value[31:0];
    } TDE_INT @ 0x818;

    reg {
        name = "AQ control";
        desc = "[inferred] List control: completion mode 0x0 = start the next list after the current list, 0x4 = after the current node and line. (HiSTB SDK `source/msp/drv/tde/adp/tde_v1_0/tde_hal.h` + `tde_hal_k.c` (proprietary SDK upload, https://github.com/JasonFreeLab/HiSTBLinuxV100R005C00SPC050; offsets, names and written values only, no text copied); the control-register offsets are those listed in docs/rdl-campaign/video-online-sources.md from that driver).";

        field {
            name = "value";
            desc = "[inferred] 32-bit register value (bit layout not in the source).";
            sw = rw;
            hw = r;
        } value[31:0];
    } TDE_AQ_CTRL @ 0x82C;

    reg {
        name = "AQ next node address";
        desc = "[inferred] Physical address of the next node to execute. (HiSTB SDK `source/msp/drv/tde/adp/tde_v1_0/tde_hal.h` + `tde_hal_k.c` (proprietary SDK upload, https://github.com/JasonFreeLab/HiSTBLinuxV100R005C00SPC050; offsets, names and written values only, no text copied); the control-register offsets are those listed in docs/rdl-campaign/video-online-sources.md from that driver).";

        field {
            name = "value";
            desc = "[inferred] 32-bit register value (bit layout not in the source).";
            sw = rw;
            hw = r;
        } value[31:0];
    } TDE_AQ_NADDR @ 0x830;

    reg {
        name = "AQ update mask (low)";
        desc = "[inferred] Low 32 bits of the 64-bit node-field update mask (which node words the list entry updates). (HiSTB SDK `source/msp/drv/tde/adp/tde_v1_0/tde_hal.h` + `tde_hal_k.c` (proprietary SDK upload, https://github.com/JasonFreeLab/HiSTBLinuxV100R005C00SPC050; offsets, names and written values only, no text copied); the control-register offsets are those listed in docs/rdl-campaign/video-online-sources.md from that driver).";

        field {
            name = "value";
            desc = "[inferred] 32-bit register value (bit layout not in the source).";
            sw = rw;
            hw = r;
        } value[31:0];
    } TDE_AQ_UPDATE @ 0x834;

    reg {
        name = "Bus limiter";
        desc = "[inferred] The driver writes 0x80770000. (HiSTB SDK `source/msp/drv/tde/adp/tde_v1_0/tde_hal.h` + `tde_hal_k.c` (proprietary SDK upload, https://github.com/JasonFreeLab/HiSTBLinuxV100R005C00SPC050; offsets, names and written values only, no text copied); the control-register offsets are those listed in docs/rdl-campaign/video-online-sources.md from that driver).";

        field {
            name = "value";
            desc = "[inferred] 32-bit register value (bit layout not in the source).";
            sw = rw;
            hw = r;
        } value[31:0];
    } TDE_BUS_LIMITER @ 0x844;

    reg {
        name = "AQ update mask (high)";
        desc = "[inferred] High 32 bits of the node-field update mask. (HiSTB SDK `source/msp/drv/tde/adp/tde_v1_0/tde_hal.h` + `tde_hal_k.c` (proprietary SDK upload, https://github.com/JasonFreeLab/HiSTBLinuxV100R005C00SPC050; offsets, names and written values only, no text copied); the control-register offsets are those listed in docs/rdl-campaign/video-online-sources.md from that driver).";

        field {
            name = "value";
            desc = "[inferred] 32-bit register value (bit layout not in the source).";
            sw = rw;
            hw = r;
        } value[31:0];
    } TDE_AQ_UPDATE2 @ 0x85C;

    reg {
        name = "Request threshold";
        desc = "[inferred] The driver writes 0x01FEF7CF. (HiSTB SDK `source/msp/drv/tde/adp/tde_v1_0/tde_hal.h` + `tde_hal_k.c` (proprietary SDK upload, https://github.com/JasonFreeLab/HiSTBLinuxV100R005C00SPC050; offsets, names and written values only, no text copied); the control-register offsets are those listed in docs/rdl-campaign/video-online-sources.md from that driver).";

        field {
            name = "value";
            desc = "[inferred] 32-bit register value (bit layout not in the source).";
            sw = rw;
            hw = r;
        } value[31:0];
    } TDE_REQ_TH @ 0x868;

    reg {
        name = "AXI ID";
        desc = "[inferred] The driver writes 0x3010. (HiSTB SDK `source/msp/drv/tde/adp/tde_v1_0/tde_hal.h` + `tde_hal_k.c` (proprietary SDK upload, https://github.com/JasonFreeLab/HiSTBLinuxV100R005C00SPC050; offsets, names and written values only, no text copied); the control-register offsets are those listed in docs/rdl-campaign/video-online-sources.md from that driver).";

        field {
            name = "value";
            desc = "[inferred] 32-bit register value (bit layout not in the source).";
            sw = rw;
            hw = r;
        } value[31:0];
    } TDE_AXI_ID @ 0x86C;
};

// ---- vendor-derived generations (2026-11-11, docs/rdl-campaign/tde-vendor.md) ----

regfile eHISI_TDE_G0 {
    name = "HiSilicon TDE, Hi3518 / Hi3516C V100 generation (vendor-derived)";
    desc = "VENDOR-DERIVED, CONFIDENCE MEDIUM/LOW, NOT VERIFIED ON HARDWARE. No data sheet has a TDE register table. Static analysis (objdump, nothing executed) of hi3518_tde.ko (HiSilicon MPP, Linux 3.0.8, OpenIPC Hi3518EV100 rootfs; unstripped, HAL functions TdeHal*) shows a compact control block in the first 0x48 bytes of the window (the module maps the base 0x20610000 and takes IRQ 27, both matching the data sheets); the operation itself is described by a node in DDR (physical address in TDE_NODE_ADDR), which is why the register set is so small. This layout is different from every later generation (those put the same ID word at 0x800 and the list control at 0x800-0x86C); ID constant 0x20080228 is common to all. Used by: Hi3518A/C V100; Hi3516C V100 (same MPP family: the Hi3518 module serves it, data-sheet base/IRQ identical, no Hi3516C-specific module in the corpus). Documented in docs/rdl-campaign/tde-vendor.md. Registers not named here were not seen accessed.";

    reg {
        name = "TDE version / ID";
        desc = "Read-only ID word; the module's version check (bTdeHalSwVersion) compares it with 0x20080228, the same constant every other TDE generation compares against at its own offset (0x800 there). Source: vendor module hi3518_tde.ko (bTdeHalSwVersion), confidence HIGH for the offset and constant, static analysis of the disassembly. Not verified on hardware.";

        field {
            name = "value";
            desc = "32 bit value, single field (bit layout not observed in the vendor code). Not verified on hardware.";
            sw = r;
            hw = w;
        } value[31:0];
    } TDE_VERSION @ 0x0;

    reg {
        name = "TDE soft reset";
        desc = "Written with 1 by TdeHalCtlReset and TdeHalResumeInit (engine reset), always followed by clearing all interrupt status bits (TDE_INT = 0xFF). Name taken from the same function in the HiSTB v1 driver (TDE_RST at 0x804 there). Source: vendor module hi3518_tde.ko (TdeHalCtlReset, TdeHalResumeInit), confidence MEDIUM, static analysis of the disassembly. Not verified on hardware.";

        field {
            name = "value";
            desc = "32 bit value, single field (bit layout not observed in the vendor code). Not verified on hardware.";
            sw = w;
            hw = r;
        } value[31:0];
    } TDE_RST @ 0x8;

    reg {
        name = "TDE control / start";
        desc = "Read-modify-write with bit 0 set as the very last step of TdeHalNodeExecute, after the node address and update word were written: starts the job. Other bits never touched. Source: vendor module hi3518_tde.ko (TdeHalNodeExecute), confidence MEDIUM, static analysis of the disassembly. Not verified on hardware.";

        field {
            name = "start";
            desc = "Set by TdeHalNodeExecute to start the queued node (vendor-observed).";
            sw = rw;
            hw = rw;
        } start[0:0];

        field {
            name = "rest";
            desc = "Unknown purpose, vendor-observed only, confidence LOW, not verified on hardware.";
            sw = rw;
            hw = rw;
        } rest[31:1];
    } TDE_CTRL @ 0xC;

    reg {
        name = "UNK_0010";
        desc = "Written with 0x80000000 by TdeHalOpen and TdeHalResumeInit, after TDE_NODE_ADDR was cleared. Access observed: written. Neighbors: TDE_NODE_ADDR. Unknown purpose, vendor-observed only, confidence LOW, not verified on hardware.";

        field {
            name = "value";
            desc = "Unknown purpose, vendor-observed only, confidence LOW, not verified on hardware.";
            sw = w;
            hw = r;
        } value[31:0];
    } UNK_0010 @ 0x10;

    reg {
        name = "TDE node list address";
        desc = "Physical address of the first node of the job (wgetphy of the node buffer + 32, i.e. the engine-visible part of the node), written by TdeHalNodeExecute before TDE_CTRL.start; cleared to 0 by TdeHalOpen/TdeHalResumeInit. Name by analogy with the HiSTB v1 TDE_AQ_NADDR. Source: vendor module hi3518_tde.ko (TdeHalNodeExecute, TdeHalOpen), confidence MEDIUM, static analysis of the disassembly. Not verified on hardware.";

        field {
            name = "value";
            desc = "32 bit value, single field (bit layout not observed in the vendor code). Not verified on hardware.";
            sw = w;
            hw = r;
        } value[31:0];
    } TDE_NODE_ADDR @ 0x14;

    reg {
        name = "UNK_0018";
        desc = "Written by TdeHalNodeExecute with its third argument right after TDE_NODE_ADDR (in the HiSTB v1 / later generations the corresponding argument is the node field update mask, so this is probably the update mask, inferred, LOW). Access observed: written. Unknown purpose, vendor-observed only, confidence LOW, not verified on hardware.";

        field {
            name = "value";
            desc = "Unknown purpose, vendor-observed only, confidence LOW, not verified on hardware.";
            sw = w;
            hw = r;
        } value[31:0];
    } UNK_0018 @ 0x18;

    reg {
        name = "UNK_0024";
        desc = "Read-modify-write with bit 31 set by TdeHalCtlReset, TdeHalResumeInit and TdeHalInit (after the soft reset), no other bit touched. Access observed: read-modify-write, value 0x80000000 OR-ed in. Unknown purpose, vendor-observed only, confidence LOW, not verified on hardware.";

        field {
            name = "bit31_unk";
            desc = "Unknown purpose, vendor-observed only, confidence LOW, not verified on hardware.";
            sw = rw;
            hw = rw;
        } bit31_unk[31:31];

        field {
            name = "rest";
            desc = "Unknown purpose, vendor-observed only, confidence LOW, not verified on hardware.";
            sw = rw;
            hw = rw;
        } rest[30:0];
    } UNK_0024 @ 0x24;

    reg {
        name = "TDE interrupt status";
        desc = "Read and written back unchanged by TdeHalCtlIntStats (acknowledge of every status bit that read as set, i.e. write-1-clear); TdeHalCtlReset writes 0xFF (clear all 8 status bits). Name by analogy with the HiSTB v1 TDE_INT (0x818 there). Source: vendor module hi3518_tde.ko (TdeHalCtlIntStats, TdeHalCtlReset), confidence MEDIUM, static analysis of the disassembly. Not verified on hardware.";

        field {
            name = "value";
            desc = "32 bit value, single field (bit layout not observed in the vendor code). Not verified on hardware.";
            sw = rw;
            hw = rw;
        } value[31:0];
    } TDE_INT @ 0x30;

    reg {
        name = "TDE status";
        desc = "Bit 0 is the busy bit: TdeHalCtlIsIdle returns !bit0; TdeHalCtlIsIdleSafely polls it ten times in a row and TdeHalNodeExecute refuses to start (-1) when it is set. Other bits never examined. Source: vendor module hi3518_tde.ko (TdeHalCtlIsIdle, TdeHalCtlIsIdleSafely, TdeHalNodeExecute), confidence HIGH, static analysis of the disassembly. Not verified on hardware.";

        field {
            name = "busy";
            desc = "1 = a job is running (vendor-observed idle test).";
            sw = r;
            hw = w;
        } busy[0:0];

        field {
            name = "rest";
            desc = "Unknown purpose, vendor-observed only, confidence LOW, not verified on hardware.";
            sw = r;
            hw = w;
        } rest[31:1];
    } TDE_STA @ 0x38;

    reg {
        name = "TDE finished node address";
        desc = "Read by TdeHalNodeGetFinishHandle: the value (when non-zero) is converted back to the kernel address of the node (physical address minus 32, wgetvrt) and the node's handle field (+28) is returned as the finished job handle. So it reads the engine-visible address of the node that just completed. Source: vendor module hi3518_tde.ko (TdeHalNodeGetFinishHandle), confidence MEDIUM, static analysis of the disassembly. Not verified on hardware.";

        field {
            name = "value";
            desc = "32 bit value, single field (bit layout not observed in the vendor code). Not verified on hardware.";
            sw = r;
            hw = w;
        } value[31:0];
    } TDE_FINISH_NODE @ 0x44;
};

regfile eHISI_TDE_G1 {
    name = "HiSilicon TDE, Hi3520D / Hi3515A / Hi3515C generation (vendor-derived)";
    desc = "VENDOR-DERIVED, CONFIDENCE MEDIUM/LOW, NOT VERIFIED ON HARDWARE. No data sheet has a TDE register table. Static analysis (objdump, nothing executed) of hi3520D_tde.ko (HiSilicon MPP V2.0.5.1, Linux 3.0.8, unstripped, HAL TdeHal*; init: ioremap of 0x20610000, size 0x3000, request_irq 70 = GIC ID 70, matching the data sheet). The list-control block at 0x800 (version, reset, status, interrupt, list control, next node, bus limiter) has the same offsets and meaning as the later Hi3516A/Hi3518E/Hi3521 generation (eHISI_TDE_G2), whose names follow the HiSTB v1 driver; this module differs in three ways: (1) every write to that block is repeated at +0x1000 (second copy 0x1800-0x1844, only the first is read), (2) it does not use the 0x868/0x86C registers, (3) jobs are submitted through a second register bank at 0x2000-0x2054 (TdeHalSubJob, the interrupt path reads 0x2030-0x2040), not through the async list node-address register. The node itself is a DDR structure of 42 words followed by a 64 bit update mask at +0xA8/+0xAC (TdeHalNodeGetNdSize), the layout of the HiSTB v1 node (see eHISI_TDE_V1). Registers not listed were not seen accessed. Documented in docs/rdl-campaign/tde-vendor.md. SECOND PASS (2026-11-11, docs/rdl-campaign/tde-vendor.md): (1) bring-up order in the vendor module (HIGH): SYS command 0x51 = SYS_HAL_TdeClkEn(1) sets PERI_CRG22 (0x20030058) bit 1, then command 0x50 = SYS_HAL_TdeResetSel(0) clears bit 0, then the bus limiter and the 0x2050 write; (2) the job node (DDR) is documented in eHISI_TDE_G1_NODE (42 words, bit fields; positions verified in this module, names from HiSTB v1); (3) the 0x2000 bank looks like a job FIFO (handle, node address, control, 64 bit update mask, completion count/handle); register names given in the UNK_ descriptions are GUESSES; (4) TdeHalNodeSetRop is an empty stub in this module (returns 0xA064800B): ROP is not usable with this vendor build; pattern fill (modes 9 and 10 of TdeHalNodeSetBaseOperate) and quick copy/fill exist; (5) at least five resize filter-coefficient tables are loaded into MMZ memory at init (TdeHalInit/TdeHalLoadFiltParam) and referenced by node words HF_COEF_ADDR/VF_COEF_ADDR.";

    reg {
        name = "TDE version / ID";
        desc = "Read-only ID word; bTdeHalSwVersion compares it with 0x20080228. BOARD-READ on the Hi3520D (nvr0408, 2026-11-11, U-Boot and Linux): 0x20110322, not the vendor constant (a date-code style value, 2011-03-22; the meaning is INFERRED); a driver must not insist on 0x20080228. (same constant on every TDE generation). Source: vendor module hi3520D_tde.ko (bTdeHalSwVersion), confidence HIGH, static analysis of the disassembly. Not verified on hardware.";

        field {
            name = "value";
            desc = "32 bit value, single field (bit layout not observed in the vendor code). Not verified on hardware.";
            sw = r;
            hw = w;
        } value[31:0];
    } TDE_VERSION @ 0x800;

    reg {
        name = "TDE soft reset";
        desc = "Written with 0xFFFFFFFF by TdeHalInit, TdeHalCtlReset and TdeHalResumeInit (engine reset); HiSTB v1 name. The module writes every register of this bank twice, at this offset and at +0x1000 (a second copy of the bank at 0x1800-0x1844; the mirror is only ever written, except TDE_INT which is read and written back at both); reads use the first copy. Source: vendor module hi3520D_tde.ko (TdeHalCtlReset), confidence MEDIUM, static analysis of the disassembly. Not verified on hardware.";

        field {
            name = "value";
            desc = "32 bit value, single field (bit layout not observed in the vendor code). Not verified on hardware.";
            sw = w;
            hw = r;
        } value[31:0];
    } TDE_RST @ 0x804;

    reg {
        name = "TDE status";
        desc = "Bit 0 is the (asynchronous-queue) busy bit: TdeHalCtlIsIdle returns !bit0 and TdeHalCtlIsIdleSafely polls it ten times. HiSTB v1 name. Source: vendor module hi3520D_tde.ko (TdeHalCtlIsIdle, TdeHalCtlIsIdleSafely), confidence HIGH, static analysis of the disassembly. Not verified on hardware.";

        field {
            name = "busy";
            desc = "1 = busy (vendor-observed idle test).";
            sw = r;
            hw = w;
        } busy[0:0];

        field {
            name = "rest";
            desc = "Unknown purpose, vendor-observed only, confidence LOW, not verified on hardware.";
            sw = r;
            hw = w;
        } rest[31:1];
    } TDE_STA @ 0x814;

    reg {
        name = "TDE interrupt status / mask";
        desc = "TdeHalCtlIntStats reads it and writes the value back (acknowledge, write-1-clear); TdeHalCtlReset/TdeHalInit/TdeHalResumeInit write 0x800F001F. In the HiSTB v1 driver the register is split [15:0] status and [31:16] mask (inferred, LOW). The module writes every register of this bank twice, at this offset and at +0x1000 (a second copy of the bank at 0x1800-0x1844; the mirror is only ever written, except TDE_INT which is read and written back at both); reads use the first copy. Source: vendor module hi3520D_tde.ko (TdeHalCtlIntStats, TdeHalCtlReset), confidence MEDIUM, static analysis of the disassembly. Not verified on hardware. SECOND PASS: the interrupt service routine tde_osr_isr does NOT read this register; the only function that reads it (TdeHalCtlIntStats, which reads and writes back 0x818 and 0x1818 and returns the 0x1818 value) has no caller inside hi3520D_tde.ko, and the completion path uses the 0x2000 bank. Meaning of the status bits is therefore still unknown (the node's INS.aq_irq_mask = 8 enables the node-complete interrupt, INFERRED). The module never calls TdeHalCtlReset either; the engine reset is the CRG reset bit (PERI_CRG22 bit 0).";

        field {
            name = "value";
            desc = "32 bit value, single field (bit layout not observed in the vendor code). Not verified on hardware.";
            sw = rw;
            hw = rw;
        } value[31:0];
    } TDE_INT @ 0x818;

    reg {
        name = "TDE async list control";
        desc = "Read-modify-write by TdeHalSystemInit, TdeHalOpen and TdeHalResumeInit: bit 24 set, bits [23:20] = 4. The same value (enable plus mode 4 = start next list after the current node and line) is what the HiSTB v1 driver writes to its TDE_AQ_CTRL (u32AqEn bit 24, u32AqOperMode [23:20]). The module writes every register of this bank twice, at this offset and at +0x1000 (a second copy of the bank at 0x1800-0x1844; the mirror is only ever written, except TDE_INT which is read and written back at both); reads use the first copy. Source: vendor module hi3520D_tde.ko (TdeHalOpen, TdeHalSystemInit), confidence MEDIUM, static analysis of the disassembly. Not verified on hardware.";

        field {
            name = "aq_oper_mode";
            desc = "List operating mode; the module writes 4 (HiSTB v1: 0 = next list after the current list, 4 = after the current node and line).";
            sw = rw;
            hw = rw;
        } aq_oper_mode[23:20];

        field {
            name = "aq_en";
            desc = "Async list enable; set by the module.";
            sw = rw;
            hw = rw;
        } aq_en[24:24];

        field {
            name = "rest";
            desc = "Unknown purpose, vendor-observed only, confidence LOW, not verified on hardware.";
            sw = rw;
            hw = rw;
        } rest[31:25];

        field {
            name = "rest_lo";
            desc = "Unknown purpose, vendor-observed only, confidence LOW, not verified on hardware.";
            sw = rw;
            hw = rw;
        } rest_lo[19:0];
    } TDE_AQ_CTRL @ 0x82C;

    reg {
        name = "TDE async list next node address";
        desc = "Written with 0 by TdeHalOpen, TdeHalSystemInit and TdeHalResumeInit (list cleared); this module never writes a node address here, jobs are submitted through the 0x2000 bank (TdeHalSubJob). HiSTB v1 name (TDE_AQ_NADDR). The module writes every register of this bank twice, at this offset and at +0x1000 (a second copy of the bank at 0x1800-0x1844; the mirror is only ever written, except TDE_INT which is read and written back at both); reads use the first copy. Source: vendor module hi3520D_tde.ko (TdeHalOpen), confidence MEDIUM for the clear, LOW for the name, static analysis of the disassembly. Not verified on hardware.";

        field {
            name = "value";
            desc = "32 bit value, single field (bit layout not observed in the vendor code). Not verified on hardware.";
            sw = w;
            hw = r;
        } value[31:0];
    } TDE_AQ_NADDR @ 0x830;

    reg {
        name = "TDE bus limiter";
        desc = "Read-modify-write by TdeHalSetClock: OR-ed with 0x80220000 (bit 31 and bits 17 and 21; HiSTB v1 writes 0x80770000, the later generations 0x80220000). Called when the clock is switched on. HiSTB v1 name. The module writes every register of this bank twice, at this offset and at +0x1000 (a second copy of the bank at 0x1800-0x1844; the mirror is only ever written, except TDE_INT which is read and written back at both); reads use the first copy. Source: vendor module hi3520D_tde.ko (TdeHalSetClock), confidence MEDIUM, static analysis of the disassembly. Not verified on hardware.";

        field {
            name = "value";
            desc = "32 bit value, single field (bit layout not observed in the vendor code). Not verified on hardware.";
            sw = rw;
            hw = rw;
        } value[31:0];
    } TDE_BUS_LIMITER @ 0x844;

    reg {
        name = "UNK_2000";
        desc = "Read by TdeHalSubJob: bit 0 set means busy, the job is refused (-1). This is probably the synchronous-queue status (the data sheet says the engine has a sync and an async list). Access observed: read, bit 0 tested. Unknown purpose, vendor-observed only, confidence LOW, not verified on hardware. SECOND PASS: refused when bit 0 is set, i.e. a submit FIFO full/busy flag (INFERRED, MEDIUM). GUESS name: SUBMIT_STATUS.";

        field {
            name = "busy_unk";
            desc = "Unknown purpose, vendor-observed only, confidence LOW, not verified on hardware.";
            sw = r;
            hw = w;
        } busy_unk[0:0];

        field {
            name = "rest";
            desc = "Unknown purpose, vendor-observed only, confidence LOW, not verified on hardware.";
            sw = r;
            hw = w;
        } rest[31:1];
    } UNK_2000 @ 0x2000;

    reg {
        name = "UNK_2008";
        desc = "Written with 0 as the last register write of TdeHalSubJob (after the node address, i.e. probably the submit/start trigger of the 0x2000 bank). Access observed: written, value 0. Neighbors: UNK_2010..UNK_201C. Unknown purpose, vendor-observed only, confidence LOW, not verified on hardware. SECOND PASS: GUESS name: SUBMIT (write 0 = submit the staged job), confidence MEDIUM.";

        field {
            name = "value";
            desc = "Unknown purpose, vendor-observed only, confidence LOW, not verified on hardware.";
            sw = w;
            hw = r;
        } value[31:0];
    } UNK_2008 @ 0x2008;

    reg {
        name = "UNK_2010";
        desc = "Written by TdeHalSubJob with its first argument (a job/handle word of the caller). Access observed: written. Neighbors: UNK_2014 (node address). Unknown purpose, vendor-observed only, confidence LOW, not verified on hardware. SECOND PASS (2026-11-11, docs/rdl-campaign/tde-vendor.md): the value is the job handle (TdeOsiListSubJob passes the handle of the job, [job+8]); the interrupt path gets the same handle back from UNK_2038 bits [7:0] and uses it to find the finished job. GUESS name: JOB_HANDLE, confidence MEDIUM.";

        field {
            name = "value";
            desc = "Unknown purpose, vendor-observed only, confidence LOW, not verified on hardware.";
            sw = w;
            hw = r;
        } value[31:0];
    } UNK_2010 @ 0x2010;

    reg {
        name = "UNK_2014";
        desc = "Written by TdeHalSubJob with the physical address of the node (wgetphy of the node buffer + 32, same address convention as the other generations' node address register). Access observed: written. Probably the node (list) address of the 0x2000 bank, inferred, LOW. Unknown purpose, vendor-observed only, confidence LOW, not verified on hardware. SECOND PASS: the address points at the compact node (eHISI_TDE_G1_NODE: only the words with an update-mask bit set, then next address and next mask). GUESS name: NODE_ADDR, confidence MEDIUM.";

        field {
            name = "value";
            desc = "Unknown purpose, vendor-observed only, confidence LOW, not verified on hardware.";
            sw = w;
            hw = r;
        } value[31:0];
    } UNK_2014 @ 0x2014;

    reg {
        name = "UNK_2018";
        desc = "Written by TdeHalSubJob with 0x01000000 (bit 24 set, bits [23:20] = 0), the same bit layout as TDE_AQ_CTRL (bit 24 enable, [23:20] mode) with mode 0, so probably the control register of this bank (inferred, LOW). Access observed: written. Unknown purpose, vendor-observed only, confidence LOW, not verified on hardware. SECOND PASS: GUESS name: SUBMIT_CTRL, confidence MEDIUM.";

        field {
            name = "value";
            desc = "Unknown purpose, vendor-observed only, confidence LOW, not verified on hardware.";
            sw = w;
            hw = r;
        } value[31:0];
    } UNK_2018 @ 0x2018;

    reg {
        name = "UNK_201C";
        desc = "Written by TdeHalSubJob with its third argument (a word supplied by the caller, probably the update mask of the node). Access observed: written. Unknown purpose, vendor-observed only, confidence LOW, not verified on hardware. SECOND PASS: the register pair UNK_201C (low) and UNK_2054 (high) takes the 64 bit update mask of the first node (TdeOsiListSubJob loads it as a 64 bit value from the node record and TdeHalSubJob passes the two halves to these registers). GUESS name: NODE_UPDATE_LO, confidence MEDIUM.";

        field {
            name = "value";
            desc = "Unknown purpose, vendor-observed only, confidence LOW, not verified on hardware.";
            sw = w;
            hw = r;
        } value[31:0];
    } UNK_201C @ 0x201C;

    reg {
        name = "UNK_2030";
        desc = "Read by TdeHalCtlFifoIntStats (interrupt service path): a value of 0xFFFFFFFF makes the module print a diagnostic and the value is passed on to TdeOsiListIntProc as the first word of the status record. Access observed: read. Neighbors: UNK_2038, UNK_2040. Unknown purpose, vendor-observed only, confidence LOW, not verified on hardware. SECOND PASS: the interrupt service loop (TdeOsiListIntProc) reads the status record, completes the job whose handle is in UNK_2038, submits the next waiting job and repeats while this first word is greater than 1, so this word is probably a count of completion records (INFERRED, LOW-MEDIUM; value 0xFFFFFFFF is reported as an error). GUESS name: DONE_COUNT.";

        field {
            name = "value";
            desc = "Unknown purpose, vendor-observed only, confidence LOW, not verified on hardware.";
            sw = r;
            hw = w;
        } value[31:0];
    } UNK_2030 @ 0x2030;

    reg {
        name = "UNK_2038";
        desc = "Read by TdeHalCtlFifoIntStats; the low 8 bits are stored as the second word of the status record, CORRECTION (2026-11-11, disassembly of TdeOsiListIntProc, HIGH): TdeOsiListIntProc does NOT use this word, it uses the third word (0x2040) as the job handle. Board: the low byte read 1 after the first job, so this is a status or count, not the handle (GUESS: completion status). Access observed: read, bits [7:0] used. Unknown purpose, vendor-observed only, confidence LOW, not verified on hardware. SECOND PASS: handle of the finished job. Reading it probably pops the completion FIFO (INFERRED: the ISR reads three words per record and loops). GUESS name: DONE_HANDLE, confidence MEDIUM.";

        field {
            name = "handle_unk";
            desc = "Unknown purpose, vendor-observed only, confidence LOW, not verified on hardware.";
            sw = r;
            hw = w;
        } handle_unk[7:0];

        field {
            name = "rest";
            desc = "Unknown purpose, vendor-observed only, confidence LOW, not verified on hardware.";
            sw = r;
            hw = w;
        } rest[31:8];
    } UNK_2038 @ 0x2038;

    reg {
        name = "UNK_2040";
        desc = "Read by TdeHalCtlFifoIntStats and stored as the third word of the status record CORRECTION (2026-11-11, HIGH, disassembly of TdeOsiListIntProc): the full 32 bit word is compared with the job handles of the pending list (the handle written to 0x2010; handles 1..1024 select list 1, others list 0). Access observed: read. Unknown purpose, vendor-observed only, confidence LOW, not verified on hardware.";

        field {
            name = "value";
            desc = "Unknown purpose, vendor-observed only, confidence LOW, not verified on hardware.";
            sw = r;
            hw = w;
        } value[31:0];
    } UNK_2040 @ 0x2040;

    reg {
        name = "UNK_2050";
        desc = "Written with 4 by TdeHalSetClock after the clock was enabled (same mode value 4 as TDE_AQ_CTRL). Access observed: written. Unknown purpose, vendor-observed only, confidence LOW, not verified on hardware.";

        field {
            name = "value";
            desc = "Unknown purpose, vendor-observed only, confidence LOW, not verified on hardware.";
            sw = w;
            hw = r;
        } value[31:0];
    } UNK_2050 @ 0x2050;

    reg {
        name = "UNK_2054";
        desc = "Written by TdeHalSubJob with its fourth argument (caller-supplied word). Access observed: written. Unknown purpose, vendor-observed only, confidence LOW, not verified on hardware. SECOND PASS: upper 32 bits of the update mask (see UNK_201C). GUESS name: NODE_UPDATE_HI, confidence MEDIUM.";

        field {
            name = "value";
            desc = "Unknown purpose, vendor-observed only, confidence LOW, not verified on hardware.";
            sw = w;
            hw = r;
        } value[31:0];
    } UNK_2054 @ 0x2054;

    reg {
        name = "UNK_1804";
        desc = "Mirror of TDE_RST (0x804): every write the module makes to TDE_RST is repeated here (TdeHalCtlReset, TdeHalInit, TdeHalResumeInit, TdeHalOpen, TdeHalSetClock); TDE_RST itself is the copy that is read, except TdeHalCtlIntStats which also reads and writes back 0x1818. Purpose of the duplicate unknown (probably a second list context, the data sheet mentions a sync and an async list). Access observed: written (0x1818 read and written back). Unknown purpose, vendor-observed only, confidence LOW, not verified on hardware.";

        field {
            name = "value";
            desc = "Unknown purpose, vendor-observed only, confidence LOW, not verified on hardware.";
            sw = w;
            hw = r;
        } value[31:0];
    } UNK_1804 @ 0x1804;

    reg {
        name = "UNK_1818";
        desc = "Mirror of TDE_INT (0x818): every write the module makes to TDE_INT is repeated here (TdeHalCtlReset, TdeHalInit, TdeHalResumeInit, TdeHalOpen, TdeHalSetClock); TDE_INT itself is the copy that is read, except TdeHalCtlIntStats which also reads and writes back 0x1818. Purpose of the duplicate unknown (probably a second list context, the data sheet mentions a sync and an async list). Access observed: written (0x1818 read and written back). Unknown purpose, vendor-observed only, confidence LOW, not verified on hardware.";

        field {
            name = "value";
            desc = "Unknown purpose, vendor-observed only, confidence LOW, not verified on hardware.";
            sw = rw;
            hw = rw;
        } value[31:0];
    } UNK_1818 @ 0x1818;

    reg {
        name = "UNK_182C";
        desc = "Mirror of TDE_AQ_CTRL (0x82C): every write the module makes to TDE_AQ_CTRL is repeated here (TdeHalCtlReset, TdeHalInit, TdeHalResumeInit, TdeHalOpen, TdeHalSetClock); TDE_AQ_CTRL itself is the copy that is read, except TdeHalCtlIntStats which also reads and writes back 0x1818. Purpose of the duplicate unknown (probably a second list context, the data sheet mentions a sync and an async list). Access observed: written (0x1818 read and written back). Unknown purpose, vendor-observed only, confidence LOW, not verified on hardware.";

        field {
            name = "value";
            desc = "Unknown purpose, vendor-observed only, confidence LOW, not verified on hardware.";
            sw = rw;
            hw = rw;
        } value[31:0];
    } UNK_182C @ 0x182C;

    reg {
        name = "UNK_1830";
        desc = "Mirror of TDE_AQ_NADDR (0x830): every write the module makes to TDE_AQ_NADDR is repeated here (TdeHalCtlReset, TdeHalInit, TdeHalResumeInit, TdeHalOpen, TdeHalSetClock); TDE_AQ_NADDR itself is the copy that is read, except TdeHalCtlIntStats which also reads and writes back 0x1818. Purpose of the duplicate unknown (probably a second list context, the data sheet mentions a sync and an async list). Access observed: written (0x1818 read and written back). Unknown purpose, vendor-observed only, confidence LOW, not verified on hardware.";

        field {
            name = "value";
            desc = "Unknown purpose, vendor-observed only, confidence LOW, not verified on hardware.";
            sw = w;
            hw = r;
        } value[31:0];
    } UNK_1830 @ 0x1830;

    reg {
        name = "UNK_1844";
        desc = "Mirror of TDE_BUS_LIMITER (0x844): every write the module makes to TDE_BUS_LIMITER is repeated here (TdeHalCtlReset, TdeHalInit, TdeHalResumeInit, TdeHalOpen, TdeHalSetClock); TDE_BUS_LIMITER itself is the copy that is read, except TdeHalCtlIntStats which also reads and writes back 0x1818. Purpose of the duplicate unknown (probably a second list context, the data sheet mentions a sync and an async list). Access observed: written (0x1818 read and written back). Unknown purpose, vendor-observed only, confidence LOW, not verified on hardware.";

        field {
            name = "value";
            desc = "Unknown purpose, vendor-observed only, confidence LOW, not verified on hardware.";
            sw = rw;
            hw = rw;
        } value[31:0];
    } UNK_1844 @ 0x1844;
};

regfile eHISI_TDE_G1_NODE {
    name = "HiSilicon TDE, Hi3520D job node image (in DDR, NOT MMIO registers)";
    desc = "NOT A REGISTER FILE: this is the layout of one hardware job node in DDR, described as a regfile only so that the words and bit fields can be documented here. NOT INSTANTIATED. Vendor-derived (static analysis of hi3520D_tde.ko, docs/rdl-campaign/tde-vendor.md), NOT VERIFIED ON HARDWARE. Confidence per field: a field note 'VERIFIED IN THE HI3520D MODULE' means the bit position was read from the Hi3520D module disassembly (HIGH; every bfi/orr into the node word was checked against the HiSTB v1 layout and matched; names and meanings come from the HiSTB v1 driver names, so the MEANING of a named bit is MEDIUM); a field note 'HiSTB v1 layout only' means only the HiSTB layout is known (INFERRED, MEDIUM-LOW). STRUCTURE (HIGH): the module builds a software node whose hardware part is 42 words at offsets 0x00-0xA4 plus a 64 bit update mask at +0xA8/+0xAC (bit n = word n was set; TdeHalNodeGetNdSize accepts bits 0..41). The node the engine reads (TdeHalNodeMakeNd) is COMPACT: only the words whose update-mask bit is set, in index order, followed by 12 bytes (next-node physical address, next update mask low, next update mask high; TdeHalFillLastNodeNextInfo writes them into the last three words, 0 = end of list). Allocated size = 44 + 4 * popcount(mask), with a 32 byte software header in front (the hardware address is node + 32, wgetphy(node + 32)). TdeHalNodeInitNd zeroes 0xD8 bytes, sets update mask = 1 (word 0 only), INS.aq_irq_mask = 8, clears TAR_TYPE bits 24 and 25 (scan direction). Words must be 32 bit aligned; the node address written to the engine is a physical address below 4 GiB. Coordinates are 12 bits (0..4095), pitch 16 bits.";
    reg {
        name = "Instruction word (node word 0)";
        desc = "Node word 0 at node offset 0x00. Selects the operation. The module starts every node with only this word updated and AqIrqMask = 8 (TdeHalNodeInitNd). Source: hi3520D_tde.ko TdeHalNodeSet* (offsets and bit positions) and HiSTB v1 tde_hal.h (names).";
        field {
            name = "src1_mod";
            desc = "Source 1 mode: 0 disabled, 1 bitmap, 2 pattern, 3 fill, 5 quick copy, 7 quick fill (TdeHalNodeSetBaseOperate switch: the 11 cases and the [2:0] field position are in the module, the values 0, 1 seen directly; 2, 3, 5, 7 by the HiSTB enum, MEDIUM). VERIFIED IN THE HI3520D MODULE (HIGH): position seen in hi3520D_tde.ko. Not verified on hardware. OPERATION MODES (third pass, 2026-11-11, PROVEN in TdeHalNodeSetBaseOperate jump table of hi3520D_tde.ko): quick fill 7 with src2 0; quick copy 5 with src2 0; normal one-source blit 0 with src2 1 (bitmap); two-source blit 1 and src2 1; fill with a bitmap 1 and src2 3; single-source pattern fill 0 and src2 2; double-source pattern fill 1 and src2 2. Unverified on hardware.";
            sw = rw;
            hw = r;
        } src1_mod[2:0];
        field {
            name = "src2_mod";
            desc = "Source 2 mode: 0 disabled, 1 bitmap, 2 pattern, 3 fill (SetBaseOperate). VERIFIED IN THE HI3520D MODULE (HIGH): position seen in hi3520D_tde.ko. Not verified on hardware. Values per operation: see src1_mod (third pass). The normal one-source blit of the vendor (format convert, colorize, mirror, resize) uses the SOURCE 2 slot with src1 disabled and ALU mode 7.";
            sw = rw;
            hw = r;
        } src2_mod[4:3];
        field {
            name = "ics_conv";
            desc = "Input color space conversion enable (HiSTB name IcsConv). HiSTB v1 layout only (MEDIUM, INFERRED: not seen in the Hi3520D module code). Not verified on hardware.";
            sw = rw;
            hw = r;
        } ics_conv[5:5];
        field {
            name = "resize";
            desc = "2D resize enable (HiSTB name Resize); set by TdeHalNodeSetResize, bit not isolated in the module. HiSTB v1 layout only (MEDIUM, INFERRED: not seen in the Hi3520D module code). Not verified on hardware.";
            sw = rw;
            hw = r;
        } resize[6:6];
        field {
            name = "dfe_en";
            desc = "De-flicker enable (set with 0x80 by TdeHalNodeSetFlicker). VERIFIED IN THE HI3520D MODULE (HIGH): position seen in hi3520D_tde.ko. Not verified on hardware.";
            sw = rw;
            hw = r;
        } dfe_en[7:7];
        field {
            name = "y1_en";
            desc = "Y1 channel enable: macroblock source 1 (set with 0x100 by TdeHalNodeSetSrc1 for MB formats). VERIFIED IN THE HI3520D MODULE (HIGH): position seen in hi3520D_tde.ko. Not verified on hardware.";
            sw = rw;
            hw = r;
        } y1_en[8:8];
        field {
            name = "y2_en";
            desc = "Y2 channel enable: macroblock source 2 (set with 0x200 by TdeHalNodeSetSrc2 for MB formats). VERIFIED IN THE HI3520D MODULE (HIGH): position seen in hi3520D_tde.ko. Not verified on hardware.";
            sw = rw;
            hw = r;
        } y2_en[9:9];
        field {
            name = "clut";
            desc = "CLUT enable (set with 0x800 by TdeHalNodeSetClutOpt). VERIFIED IN THE HI3520D MODULE (HIGH): position seen in hi3520D_tde.ko. Not verified on hardware.";
            sw = rw;
            hw = r;
        } clut[11:11];
        field {
            name = "color_key";
            desc = "Color key enable (set with 0x1000 by TdeHalNodeSetColorKey). VERIFIED IN THE HI3520D MODULE (HIGH): position seen in hi3520D_tde.ko. Not verified on hardware.";
            sw = rw;
            hw = r;
        } color_key[12:12];
        field {
            name = "icsc_sel";
            desc = "Input color space conversion select (HiSTB name IcscSel). HiSTB v1 layout only (MEDIUM, INFERRED: not seen in the Hi3520D module code). Not verified on hardware.";
            sw = rw;
            hw = r;
        } icsc_sel[13:13];
        field {
            name = "clip";
            desc = "Clip enable (set with 0x4000 by TdeHalNodeSetClipping and InitChildNd). VERIFIED IN THE HI3520D MODULE (HIGH): position seen in hi3520D_tde.ko. Not verified on hardware.";
            sw = rw;
            hw = r;
        } clip[14:14];
        field {
            name = "mb_mode";
            desc = "Macroblock operation mode (3 bits, TdeHalNodeSetMbMode). VERIFIED IN THE HI3520D MODULE (HIGH): position seen in hi3520D_tde.ko. Not verified on hardware.";
            sw = rw;
            hw = r;
        } mb_mode[17:15];
        field {
            name = "mb_en";
            desc = "Macroblock operation enable (HiSTB name MbEn); BaseOperate sets it for the MB modes (MbEn named in the HiSTB union). HiSTB v1 layout only (MEDIUM, INFERRED: not seen in the Hi3520D module code). Not verified on hardware.";
            sw = rw;
            hw = r;
        } mb_en[18:18];
        field {
            name = "aq_irq_mask";
            desc = "Asynchronous list interrupt mask: TdeHalNodeInitNd and InitChildNd write the value 8 (bit 22) into every node; the HiSTB name for the 8 is the node-complete interrupt enable (INFERRED, MEDIUM). VERIFIED IN THE HI3520D MODULE (HIGH): position seen in hi3520D_tde.ko. Not verified on hardware.";
            sw = rw;
            hw = r;
        } aq_irq_mask[22:19];
        field {
            name = "sq_irq_mask";
            desc = "Synchronous list interrupt mask (HiSTB name SqIrqMask). HiSTB v1 layout only (MEDIUM, INFERRED: not seen in the Hi3520D module code). Not verified on hardware.";
            sw = rw;
            hw = r;
        } sq_irq_mask[27:23];
        field {
            name = "ocs_conv";
            desc = "Output color space conversion enable (HiSTB name OcsConv). HiSTB v1 layout only (MEDIUM, INFERRED: not seen in the Hi3520D module code). Not verified on hardware.";
            sw = rw;
            hw = r;
        } ocs_conv[28:28];
        field {
            name = "block_flag";
            desc = "Block (slice) flag for wide pictures (HiSTB name BlockFlag). HiSTB v1 layout only (MEDIUM, INFERRED: not seen in the Hi3520D module code). Not verified on hardware.";
            sw = rw;
            hw = r;
        } block_flag[29:29];
        field {
            name = "first_block";
            desc = "First block flag. HiSTB v1 layout only (MEDIUM, INFERRED: not seen in the Hi3520D module code). Not verified on hardware.";
            sw = rw;
            hw = r;
        } first_block[30:30];
        field {
            name = "last_block";
            desc = "Last block flag. HiSTB v1 layout only (MEDIUM, INFERRED: not seen in the Hi3520D module code). Not verified on hardware.";
            sw = rw;
            hw = r;
        } last_block[31:31];
    } NODE_INS @ 0x00;

    reg {
        name = "Source 1 address";
        desc = "Node word 1 at node offset 0x04. Physical address of source 1 (for macroblock formats the chroma address; the luma address goes to Y1_ADDR). Source: hi3520D_tde.ko TdeHalNodeSet* (offsets and bit positions) and HiSTB v1 tde_hal.h (names).";
        field {
            name = "addr";
            desc = "Physical address (TdeHalNodeSetSrc1). VERIFIED IN THE HI3520D MODULE (HIGH): position seen in hi3520D_tde.ko. Not verified on hardware.";
            sw = rw;
            hw = r;
        } addr[31:0];
    } NODE_S1_ADDR @ 0x04;

    reg {
        name = "Source 1 type";
        desc = "Node word 2 at node offset 0x08. Layout shared with S2_TYPE. Source: hi3520D_tde.ko TdeHalNodeSet* (offsets and bit positions) and HiSTB v1 tde_hal.h (names).";
        field {
            name = "pitch";
            desc = "Line pitch in bytes (for MB formats the chroma pitch). VERIFIED IN THE HI3520D MODULE (HIGH): position seen in hi3520D_tde.ko. Not verified on hardware.";
            sw = rw;
            hw = r;
        } pitch[15:0];
        field {
            name = "fmt";
            desc = "Pixel format: 0 RGB444, 1 RGB555, 2 RGB565, 3 RGB888, 4 ARGB4444, 5 ARGB1555, 6 ARGB8565, 7 ARGB8888, 8..11 CLUT1/2/4/8, 12 ACLUT44, 13 ACLUT88, 16 A1, 17 A8, 18 YCbCr888, 19 AYCbCr8888, 20 YCbCr422, 22 byte, 23 halfword, 24..28 macroblock formats (values from the HiSTB enum; the module separates <=23 from >=24 and <=7 for the ARGB order, matching the enum). VERIFIED IN THE HI3520D MODULE (HIGH): position seen in hi3520D_tde.ko. Not verified on hardware.";
            sw = rw;
            hw = r;
        } fmt[20:16];
        field {
            name = "alpha_range";
            desc = "Alpha range (0..255 versus 0..128). VERIFIED IN THE HI3520D MODULE (HIGH): position seen in hi3520D_tde.ko. Not verified on hardware.";
            sw = rw;
            hw = r;
        } alpha_range[21:21];
        field {
            name = "colorize";
            desc = "Colorize enable (Src2 only; set by TdeHalNodeSetColorize). VERIFIED IN THE HI3520D MODULE (HIGH): position seen in hi3520D_tde.ko. Not verified on hardware.";
            sw = rw;
            hw = r;
        } colorize[22:22];
        field {
            name = "hscan";
            desc = "Horizontal scan direction (0 left to right, 1 reversed). VERIFIED IN THE HI3520D MODULE (HIGH): position seen in hi3520D_tde.ko. Not verified on hardware.";
            sw = rw;
            hw = r;
        } hscan[24:24];
        field {
            name = "vscan";
            desc = "Vertical scan direction. VERIFIED IN THE HI3520D MODULE (HIGH): position seen in hi3520D_tde.ko. Not verified on hardware.";
            sw = rw;
            hw = r;
        } vscan[25:25];
        field {
            name = "rgb_exp";
            desc = "RGB expand mode: cleared by SetSrc1/SetSrc2, set by TdeHalNodeSetExpAlpha (ARGB1555 alpha expansion). VERIFIED IN THE HI3520D MODULE (HIGH): position seen in hi3520D_tde.ko. Not verified on hardware.";
            sw = rw;
            hw = r;
        } rgb_exp[29:29];
    } NODE_S1_TYPE @ 0x08;

    reg {
        name = "Source 1 position";
        desc = "Node word 3 at node offset 0x0C. Layout shared with S2_XY. Source: hi3520D_tde.ko TdeHalNodeSet* (offsets and bit positions) and HiSTB v1 tde_hal.h (names).";
        field {
            name = "x";
            desc = "First X. VERIFIED IN THE HI3520D MODULE (HIGH): position seen in hi3520D_tde.ko. Not verified on hardware.";
            sw = rw;
            hw = r;
        } x[11:0];
        field {
            name = "y";
            desc = "First Y. VERIFIED IN THE HI3520D MODULE (HIGH): position seen in hi3520D_tde.ko. Not verified on hardware.";
            sw = rw;
            hw = r;
        } y[27:16];
    } NODE_S1_XY @ 0x0C;

    reg {
        name = "Source 1 fill value";
        desc = "Node word 4 at node offset 0x10. Fill color for quick fill (TdeHalNodeSetBaseOperate, mode 0). Source: hi3520D_tde.ko TdeHalNodeSet* (offsets and bit positions) and HiSTB v1 tde_hal.h (names).";
        field {
            name = "data";
            desc = "Fill data, packed in the target pixel format. VERIFIED IN THE HI3520D MODULE (HIGH): position seen in hi3520D_tde.ko. Not verified on hardware.";
            sw = rw;
            hw = r;
        } data[31:0];
    } NODE_S1_FILL @ 0x10;

    reg {
        name = "Source 2 address";
        desc = "Node word 5 at node offset 0x14. As S1_ADDR. Source: hi3520D_tde.ko TdeHalNodeSet* (offsets and bit positions) and HiSTB v1 tde_hal.h (names).";
        field {
            name = "addr";
            desc = "Physical address (TdeHalNodeSetSrc2). VERIFIED IN THE HI3520D MODULE (HIGH): position seen in hi3520D_tde.ko. Not verified on hardware.";
            sw = rw;
            hw = r;
        } addr[31:0];
    } NODE_S2_ADDR @ 0x14;

    reg {
        name = "Source 2 type";
        desc = "Node word 6 at node offset 0x18. Same layout as S1_TYPE (TdeHalNodeSetSrc2 writes the identical bit positions). Source: hi3520D_tde.ko TdeHalNodeSet* (offsets and bit positions) and HiSTB v1 tde_hal.h (names).";
        field {
            name = "pitch";
            desc = "Line pitch. VERIFIED IN THE HI3520D MODULE (HIGH): position seen in hi3520D_tde.ko. Not verified on hardware.";
            sw = rw;
            hw = r;
        } pitch[15:0];
        field {
            name = "fmt";
            desc = "Pixel format (as S1_TYPE). VERIFIED IN THE HI3520D MODULE (HIGH): position seen in hi3520D_tde.ko. Not verified on hardware.";
            sw = rw;
            hw = r;
        } fmt[20:16];
        field {
            name = "alpha_range";
            desc = "Alpha range. VERIFIED IN THE HI3520D MODULE (HIGH): position seen in hi3520D_tde.ko. Not verified on hardware.";
            sw = rw;
            hw = r;
        } alpha_range[21:21];
        field {
            name = "colorize";
            desc = "Colorize enable. VERIFIED IN THE HI3520D MODULE (HIGH): position seen in hi3520D_tde.ko. Not verified on hardware.";
            sw = rw;
            hw = r;
        } colorize[22:22];
        field {
            name = "hscan";
            desc = "Horizontal scan direction. VERIFIED IN THE HI3520D MODULE (HIGH): position seen in hi3520D_tde.ko. Not verified on hardware.";
            sw = rw;
            hw = r;
        } hscan[24:24];
        field {
            name = "vscan";
            desc = "Vertical scan direction. VERIFIED IN THE HI3520D MODULE (HIGH): position seen in hi3520D_tde.ko. Not verified on hardware.";
            sw = rw;
            hw = r;
        } vscan[25:25];
        field {
            name = "rgb_exp";
            desc = "RGB expand mode. VERIFIED IN THE HI3520D MODULE (HIGH): position seen in hi3520D_tde.ko. Not verified on hardware.";
            sw = rw;
            hw = r;
        } rgb_exp[29:29];
    } NODE_S2_TYPE @ 0x18;

    reg {
        name = "Source 2 position";
        desc = "Node word 7 at node offset 0x1C. As S1_XY. Source: hi3520D_tde.ko TdeHalNodeSet* (offsets and bit positions) and HiSTB v1 tde_hal.h (names).";
        field {
            name = "x";
            desc = "First X. VERIFIED IN THE HI3520D MODULE (HIGH): position seen in hi3520D_tde.ko. Not verified on hardware.";
            sw = rw;
            hw = r;
        } x[11:0];
        field {
            name = "y";
            desc = "First Y. VERIFIED IN THE HI3520D MODULE (HIGH): position seen in hi3520D_tde.ko. Not verified on hardware.";
            sw = rw;
            hw = r;
        } y[27:16];
    } NODE_S2_XY @ 0x1C;

    reg {
        name = "Source 2 size";
        desc = "Node word 8 at node offset 0x20.  Source: hi3520D_tde.ko TdeHalNodeSet* (offsets and bit positions) and HiSTB v1 tde_hal.h (names).";
        field {
            name = "width";
            desc = "Width in pixels. VERIFIED IN THE HI3520D MODULE (HIGH): position seen in hi3520D_tde.ko. Not verified on hardware.";
            sw = rw;
            hw = r;
        } width[11:0];
        field {
            name = "height";
            desc = "Height in lines. VERIFIED IN THE HI3520D MODULE (HIGH): position seen in hi3520D_tde.ko. Not verified on hardware.";
            sw = rw;
            hw = r;
        } height[27:16];
    } NODE_S2_SIZE @ 0x20;

    reg {
        name = "Source 2 fill value";
        desc = "Node word 9 at node offset 0x24. Fill color of the normal fill modes. Source: hi3520D_tde.ko TdeHalNodeSet* (offsets and bit positions) and HiSTB v1 tde_hal.h (names).";
        field {
            name = "data";
            desc = "Fill data. VERIFIED IN THE HI3520D MODULE (HIGH): position seen in hi3520D_tde.ko. Not verified on hardware.";
            sw = rw;
            hw = r;
        } data[31:0];
    } NODE_S2_FILL @ 0x24;

    reg {
        name = "Target address";
        desc = "Node word 10 at node offset 0x28.  Source: hi3520D_tde.ko TdeHalNodeSet* (offsets and bit positions) and HiSTB v1 tde_hal.h (names).";
        field {
            name = "addr";
            desc = "Physical address (TdeHalNodeSetTgt). VERIFIED IN THE HI3520D MODULE (HIGH): position seen in hi3520D_tde.ko. Not verified on hardware.";
            sw = rw;
            hw = r;
        } addr[31:0];
    } NODE_TAR_ADDR @ 0x28;

    reg {
        name = "Target type";
        desc = "Node word 11 at node offset 0x2C.  Source: hi3520D_tde.ko TdeHalNodeSet* (offsets and bit positions) and HiSTB v1 tde_hal.h (names).";
        field {
            name = "pitch";
            desc = "Line pitch. VERIFIED IN THE HI3520D MODULE (HIGH): position seen in hi3520D_tde.ko. Not verified on hardware.";
            sw = rw;
            hw = r;
        } pitch[15:0];
        field {
            name = "fmt";
            desc = "Pixel format (as S1_TYPE). VERIFIED IN THE HI3520D MODULE (HIGH): position seen in hi3520D_tde.ko. Not verified on hardware.";
            sw = rw;
            hw = r;
        } fmt[20:16];
        field {
            name = "alpha_range";
            desc = "Alpha range. VERIFIED IN THE HI3520D MODULE (HIGH): position seen in hi3520D_tde.ko. Not verified on hardware.";
            sw = rw;
            hw = r;
        } alpha_range[21:21];
        field {
            name = "alpha_from";
            desc = "Source of the output alpha (2 bits, TdeHalNodeSetTgt argument). VERIFIED IN THE HI3520D MODULE (HIGH): position seen in hi3520D_tde.ko. Values: TdeOsiQuickCopy passes 1 in its direct path (HIGH, disassembly d4b0) and 0 in its temp-buffer path; TdeOsiSingleSrc1Blit passes 0; fill and the other operations pass the caller option (the API default is 0). Meaning of 1 (probably the source 1 alpha) is a GUESS. Board 2026-11-11: quick fill with 0 completes, quick copy with 0 timed out (cause not yet known, docs/rdl-campaign/tde-vendor.md quick copy section).";
            sw = rw;
            hw = r;
        } alpha_from[23:22];
        field {
            name = "hscan";
            desc = "Horizontal scan direction. VERIFIED IN THE HI3520D MODULE (HIGH): position seen in hi3520D_tde.ko. Not verified on hardware.";
            sw = rw;
            hw = r;
        } hscan[24:24];
        field {
            name = "vscan";
            desc = "Vertical scan direction. VERIFIED IN THE HI3520D MODULE (HIGH): position seen in hi3520D_tde.ko. Not verified on hardware.";
            sw = rw;
            hw = r;
        } vscan[25:25];
        field {
            name = "rgb_round";
            desc = "RGB truncation mode (cleared by SetTgt). VERIFIED IN THE HI3520D MODULE (HIGH): position seen in hi3520D_tde.ko. Not verified on hardware.";
            sw = rw;
            hw = r;
        } rgb_round[26:26];
        field {
            name = "dfe_lastline_out";
            desc = "Output the de-flicker result at the last line (TdeHalNodeSetResize). VERIFIED IN THE HI3520D MODULE (HIGH): position seen in hi3520D_tde.ko. Not verified on hardware.";
            sw = rw;
            hw = r;
        } dfe_lastline_out[27:27];
        field {
            name = "dfe_firstline_out";
            desc = "Output the de-flicker result at the first line. VERIFIED IN THE HI3520D MODULE (HIGH): position seen in hi3520D_tde.ko. Not verified on hardware.";
            sw = rw;
            hw = r;
        } dfe_firstline_out[28:28];
    } NODE_TAR_TYPE @ 0x2C;

    reg {
        name = "Target position";
        desc = "Node word 12 at node offset 0x30.  Source: hi3520D_tde.ko TdeHalNodeSet* (offsets and bit positions) and HiSTB v1 tde_hal.h (names).";
        field {
            name = "x";
            desc = "First X. VERIFIED IN THE HI3520D MODULE (HIGH): position seen in hi3520D_tde.ko. Not verified on hardware.";
            sw = rw;
            hw = r;
        } x[11:0];
        field {
            name = "y";
            desc = "First Y. VERIFIED IN THE HI3520D MODULE (HIGH): position seen in hi3520D_tde.ko. Not verified on hardware.";
            sw = rw;
            hw = r;
        } y[27:16];
    } NODE_TAR_XY @ 0x30;

    reg {
        name = "Target size";
        desc = "Node word 13 at node offset 0x34. Size of the operation (also the source 1 size). Source: hi3520D_tde.ko TdeHalNodeSet* (offsets and bit positions) and HiSTB v1 tde_hal.h (names).";
        field {
            name = "width";
            desc = "Width in pixels. VERIFIED IN THE HI3520D MODULE (HIGH): position seen in hi3520D_tde.ko. Not verified on hardware.";
            sw = rw;
            hw = r;
        } width[11:0];
        field {
            name = "alpha_thr_lo";
            desc = "Alpha threshold, low 4 bits. VERIFIED IN THE HI3520D MODULE (HIGH): position seen in hi3520D_tde.ko. Not verified on hardware.";
            sw = rw;
            hw = r;
        } alpha_thr_lo[15:12];
        field {
            name = "height";
            desc = "Height in lines. VERIFIED IN THE HI3520D MODULE (HIGH): position seen in hi3520D_tde.ko. Not verified on hardware.";
            sw = rw;
            hw = r;
        } height[27:16];
        field {
            name = "alpha_thr_hi";
            desc = "Alpha threshold, high 4 bits. VERIFIED IN THE HI3520D MODULE (HIGH): position seen in hi3520D_tde.ko. Not verified on hardware.";
            sw = rw;
            hw = r;
        } alpha_thr_hi[31:28];
    } NODE_TS_SIZE @ 0x34;

    reg {
        name = "Color conversion / alpha 1555 / CLUT mode";
        desc = "Node word 14 at node offset 0x38.  Source: hi3520D_tde.ko TdeHalNodeSet* (offsets and bit positions) and HiSTB v1 tde_hal.h (names).";
        field {
            name = "in_colorimetry";
            desc = "Input conversion standard (written from the conversion command bytes by TdeHalNodeSetColorConvert; exact semantics of bits 0, 1, 2, 4, 5 from the HiSTB names). VERIFIED IN THE HI3520D MODULE (HIGH): position seen in hi3520D_tde.ko. Not verified on hardware.";
            sw = rw;
            hw = r;
        } in_colorimetry[0:0];
        field {
            name = "in_rgb2yc";
            desc = "Input conversion direction. VERIFIED IN THE HI3520D MODULE (HIGH): position seen in hi3520D_tde.ko. Not verified on hardware.";
            sw = rw;
            hw = r;
        } in_rgb2yc[1:1];
        field {
            name = "in_colorspace";
            desc = "Input matrix select. VERIFIED IN THE HI3520D MODULE (HIGH): position seen in hi3520D_tde.ko. Not verified on hardware.";
            sw = rw;
            hw = r;
        } in_colorspace[2:2];
        field {
            name = "in_chroma_fmt";
            desc = "Input chroma format. HiSTB v1 layout only (MEDIUM, INFERRED: not seen in the Hi3520D module code). Not verified on hardware.";
            sw = rw;
            hw = r;
        } in_chroma_fmt[3:3];
        field {
            name = "out_colorimetry";
            desc = "Output conversion standard. VERIFIED IN THE HI3520D MODULE (HIGH): position seen in hi3520D_tde.ko. Not verified on hardware.";
            sw = rw;
            hw = r;
        } out_colorimetry[4:4];
        field {
            name = "out_colorspace";
            desc = "Output matrix select. VERIFIED IN THE HI3520D MODULE (HIGH): position seen in hi3520D_tde.ko. Not verified on hardware.";
            sw = rw;
            hw = r;
        } out_colorspace[5:5];
        field {
            name = "out_chroma_fmt";
            desc = "Output chroma format. HiSTB v1 layout only (MEDIUM, INFERRED: not seen in the Hi3520D module code). Not verified on hardware.";
            sw = rw;
            hw = r;
        } out_chroma_fmt[6:6];
        field {
            name = "clut_mod";
            desc = "CLUT mode (TdeHalNodeSetClutOpt). VERIFIED IN THE HI3520D MODULE (HIGH): position seen in hi3520D_tde.ko. Not verified on hardware.";
            sw = rw;
            hw = r;
        } clut_mod[9:9];
        field {
            name = "clut_reload";
            desc = "Reload the CLUT from CLUT_ADDR. VERIFIED IN THE HI3520D MODULE (HIGH): position seen in hi3520D_tde.ko. Not verified on hardware.";
            sw = rw;
            hw = r;
        } clut_reload[10:10];
        field {
            name = "ocsc_reload";
            desc = "Reload the custom output CSC coefficients (TDeHalNodeSetCsc/SetWbcCsc). VERIFIED IN THE HI3520D MODULE (HIGH): position seen in hi3520D_tde.ko. Not verified on hardware.";
            sw = rw;
            hw = r;
        } ocsc_reload[12:12];
        field {
            name = "ocsc_custom";
            desc = "Custom output CSC enable. VERIFIED IN THE HI3520D MODULE (HIGH): position seen in hi3520D_tde.ko. Not verified on hardware.";
            sw = rw;
            hw = r;
        } ocsc_custom[13:13];
        field {
            name = "icsc_reload";
            desc = "Reload the custom input CSC. VERIFIED IN THE HI3520D MODULE (HIGH): position seen in hi3520D_tde.ko. Not verified on hardware.";
            sw = rw;
            hw = r;
        } icsc_reload[14:14];
        field {
            name = "icsc_custom";
            desc = "Custom input CSC enable. VERIFIED IN THE HI3520D MODULE (HIGH): position seen in hi3520D_tde.ko. Not verified on hardware.";
            sw = rw;
            hw = r;
        } icsc_custom[15:15];
        field {
            name = "alpha0";
            desc = "ARGB1555 alpha for A=0 (TdeHalNodeSetExpAlpha). VERIFIED IN THE HI3520D MODULE (HIGH): position seen in hi3520D_tde.ko. Not verified on hardware.";
            sw = rw;
            hw = r;
        } alpha0[23:16];
        field {
            name = "alpha1";
            desc = "ARGB1555 alpha for A=1. VERIFIED IN THE HI3520D MODULE (HIGH): position seen in hi3520D_tde.ko. Not verified on hardware.";
            sw = rw;
            hw = r;
        } alpha1[31:24];
    } NODE_COLOR_CONV @ 0x38;

    reg {
        name = "CLUT address";
        desc = "Node word 15 at node offset 0x3C.  Source: hi3520D_tde.ko TdeHalNodeSet* (offsets and bit positions) and HiSTB v1 tde_hal.h (names).";
        field {
            name = "addr";
            desc = "Physical address of the color look-up table (SetClutOpt). VERIFIED IN THE HI3520D MODULE (HIGH): position seen in hi3520D_tde.ko. Not verified on hardware.";
            sw = rw;
            hw = r;
        } addr[31:0];
    } NODE_CLUT_ADDR @ 0x3C;

    reg {
        name = "2D resize control";
        desc = "Node word 16 at node offset 0x40.  Source: hi3520D_tde.ko TdeHalNodeSet* (offsets and bit positions) and HiSTB v1 tde_hal.h (names).";
        field {
            name = "hf_mod";
            desc = "Horizontal filter mode. VERIFIED IN THE HI3520D MODULE (HIGH): position seen in hi3520D_tde.ko. Not verified on hardware.";
            sw = rw;
            hw = r;
        } hf_mod[1:0];
        field {
            name = "vf_mod";
            desc = "Vertical filter mode. VERIFIED IN THE HI3520D MODULE (HIGH): position seen in hi3520D_tde.ko. Not verified on hardware.";
            sw = rw;
            hw = r;
        } vf_mod[5:4];
        field {
            name = "dfe_mod";
            desc = "De-flicker coefficient select (TdeHalNodeSetFlicker). VERIFIED IN THE HI3520D MODULE (HIGH): position seen in hi3520D_tde.ko. Not verified on hardware.";
            sw = rw;
            hw = r;
        } dfe_mod[9:8];
        field {
            name = "alp_border";
            desc = "Alpha border mode (TdeHalNodeSetAlphaBorder: bit 12 horizontal, bit 13 vertical). VERIFIED IN THE HI3520D MODULE (HIGH): position seen in hi3520D_tde.ko. Not verified on hardware.";
            sw = rw;
            hw = r;
        } alp_border[13:12];
        field {
            name = "vf_ring_en";
            desc = "Vertical median filter. VERIFIED IN THE HI3520D MODULE (HIGH): position seen in hi3520D_tde.ko. Not verified on hardware.";
            sw = rw;
            hw = r;
        } vf_ring_en[16:16];
        field {
            name = "hf_ring_en";
            desc = "Horizontal median filter. VERIFIED IN THE HI3520D MODULE (HIGH): position seen in hi3520D_tde.ko. Not verified on hardware.";
            sw = rw;
            hw = r;
        } hf_ring_en[17:17];
        field {
            name = "coef_sym";
            desc = "Symmetric filter coefficients. VERIFIED IN THE HI3520D MODULE (HIGH): position seen in hi3520D_tde.ko. Not verified on hardware.";
            sw = rw;
            hw = r;
        } coef_sym[18:18];
        field {
            name = "vf_coef_reload";
            desc = "Reload the vertical coefficient table from VF_COEF_ADDR (set with 0x1000000). VERIFIED IN THE HI3520D MODULE (HIGH): position seen in hi3520D_tde.ko. Not verified on hardware.";
            sw = rw;
            hw = r;
        } vf_coef_reload[24:24];
        field {
            name = "hf_coef_reload";
            desc = "Reload the horizontal coefficient table (set with 0x2000000). VERIFIED IN THE HI3520D MODULE (HIGH): position seen in hi3520D_tde.ko. Not verified on hardware.";
            sw = rw;
            hw = r;
        } hf_coef_reload[25:25];
        field {
            name = "dfe_alpha_disable";
            desc = "Disable alpha de-flicker. VERIFIED IN THE HI3520D MODULE (HIGH): position seen in hi3520D_tde.ko. Not verified on hardware.";
            sw = rw;
            hw = r;
        } dfe_alpha_disable[26:26];
    } NODE_RSZ_2D @ 0x40;

    reg {
        name = "Horizontal filter coefficient address";
        desc = "Node word 17 at node offset 0x44. The module loads five filter-parameter tables (TdeHalInit / TdeHalLoadFiltParam, allocated in MMZ) and writes the address chosen by the scale step (TdeHalGetResizeParaHTable). Source: hi3520D_tde.ko TdeHalNodeSet* (offsets and bit positions) and HiSTB v1 tde_hal.h (names). Third pass (PROVEN from TdeHalLoadFiltParam and TdeHalFillHFilterAddrByType): the horizontal table block holds 6 tables in 160 byte slots (33 words, 4 signed bytes each = 8 symmetric taps in the stored half-form; 132 bytes used). The slot is chosen by the horizontal step (12 bit fraction, 4096 = 1.0): up to 2048 slot 0, up to 4096 slot 1, up to 8192 slot 2, up to 12412 slot 3, up to 16384 slot 4, above slot 5 (type 0). The module has 7 coefficient sets; set 0 was used. Meaning of the taps per phase is not decoded. Unverified on hardware.";
        field {
            name = "addr";
            desc = "Physical address. VERIFIED IN THE HI3520D MODULE (HIGH): position seen in hi3520D_tde.ko. Not verified on hardware.";
            sw = rw;
            hw = r;
        } addr[31:0];
    } NODE_HF_COEF_ADDR @ 0x44;

    reg {
        name = "Vertical filter coefficient address";
        desc = "Node word 18 at node offset 0x48.  Source: hi3520D_tde.ko TdeHalNodeSet* (offsets and bit positions) and HiSTB v1 tde_hal.h (names). Third pass (PROVEN from TdeHalLoadFiltParam): 12 vertical tables of 8 words (32 bytes); each word packs five signed taps (bytes of the 40 byte source table, 8 phases of 5 taps) as bits 4:0, 10:5, 18:11, 25:19, 31:26. The table is chosen by the vertical step: below 3724 table 0, 3724 to 4095 table 1, 4096 to 4500 table 2, 4501 to 4934 table 3 (limits read from the module); the next limits 4935, 5327, 5729, 6142, 8193, 12289, 16385, 20481 are from the HiSTB ratio comments (INFERRED). The vertical block is placed after the 960 byte horizontal block in the same allocation.";
        field {
            name = "addr";
            desc = "Physical address. VERIFIED IN THE HI3520D MODULE (HIGH): position seen in hi3520D_tde.ko. Not verified on hardware.";
            sw = rw;
            hw = r;
        } addr[31:0];
    } NODE_VF_COEF_ADDR @ 0x48;

    reg {
        name = "Horizontal resize step";
        desc = "Node word 19 at node offset 0x4C. Fixed point, 0x1000 = 1.0 (NO_SCALE_STEP in the HiSTB source; the module compares steps with the same table limits). Source: hi3520D_tde.ko TdeHalNodeSet* (offsets and bit positions) and HiSTB v1 tde_hal.h (names). Third pass (INFERRED from the HiSTB OSI layer): step = ((input size - 1) shifted left 12) divided by (output size - 1); the vendor rejects a minification beyond 255 and its tables cover steps up to 0.2 (20480). A 1:1 direction (4096) sends no coefficient table and filter mode 0.";
        field {
            name = "step";
            desc = "Step value. VERIFIED IN THE HI3520D MODULE (HIGH): position seen in hi3520D_tde.ko. Not verified on hardware.";
            sw = rw;
            hw = r;
        } step[31:0];
    } NODE_RSZ_STEP @ 0x4C;

    reg {
        name = "Vertical resize start offset";
        desc = "Node word 20 at node offset 0x50. Sign in bit 16, magnitude in [15:0] (TdeHalNodeSetResize). Source: hi3520D_tde.ko TdeHalNodeSet* (offsets and bit positions) and HiSTB v1 tde_hal.h (names).";
        field {
            name = "ofst";
            desc = "Offset magnitude. VERIFIED IN THE HI3520D MODULE (HIGH): position seen in hi3520D_tde.ko. Not verified on hardware.";
            sw = rw;
            hw = r;
        } ofst[15:0];
        field {
            name = "sign";
            desc = "Sign. VERIFIED IN THE HI3520D MODULE (HIGH): position seen in hi3520D_tde.ko. Not verified on hardware.";
            sw = rw;
            hw = r;
        } sign[16:16];
    } NODE_RSZ_Y_OFST @ 0x50;

    reg {
        name = "Horizontal resize start offset";
        desc = "Node word 21 at node offset 0x54. As RSZ_Y_OFST. Source: hi3520D_tde.ko TdeHalNodeSet* (offsets and bit positions) and HiSTB v1 tde_hal.h (names).";
        field {
            name = "ofst";
            desc = "Offset magnitude. VERIFIED IN THE HI3520D MODULE (HIGH): position seen in hi3520D_tde.ko. Not verified on hardware.";
            sw = rw;
            hw = r;
        } ofst[15:0];
        field {
            name = "sign";
            desc = "Sign. VERIFIED IN THE HI3520D MODULE (HIGH): position seen in hi3520D_tde.ko. Not verified on hardware.";
            sw = rw;
            hw = r;
        } sign[16:16];
    } NODE_RSZ_X_OFST @ 0x54;

    reg {
        name = "De-flicker coefficient 0";
        desc = "Node word 22 at node offset 0x58. Four packed coefficients (TdeHalNodeSetFlicker; byte shifts 8 and 24). Source: hi3520D_tde.ko TdeHalNodeSet* (offsets and bit positions) and HiSTB v1 tde_hal.h (names).";
        field {
            name = "coef";
            desc = "Packed coefficients. VERIFIED IN THE HI3520D MODULE (HIGH): position seen in hi3520D_tde.ko. Not verified on hardware.";
            sw = rw;
            hw = r;
        } coef[31:0];
    } NODE_DFE_COEF0 @ 0x58;

    reg {
        name = "De-flicker coefficient 1";
        desc = "Node word 23 at node offset 0x5C. Four packed coefficients (TdeHalNodeSetFlicker; byte shifts 8 and 24). Source: hi3520D_tde.ko TdeHalNodeSet* (offsets and bit positions) and HiSTB v1 tde_hal.h (names).";
        field {
            name = "coef";
            desc = "Packed coefficients. VERIFIED IN THE HI3520D MODULE (HIGH): position seen in hi3520D_tde.ko. Not verified on hardware.";
            sw = rw;
            hw = r;
        } coef[31:0];
    } NODE_DFE_COEF1 @ 0x5C;

    reg {
        name = "De-flicker coefficient 2";
        desc = "Node word 24 at node offset 0x60. Four packed coefficients (TdeHalNodeSetFlicker; byte shifts 8 and 24). Source: hi3520D_tde.ko TdeHalNodeSet* (offsets and bit positions) and HiSTB v1 tde_hal.h (names).";
        field {
            name = "coef";
            desc = "Packed coefficients. VERIFIED IN THE HI3520D MODULE (HIGH): position seen in hi3520D_tde.ko. Not verified on hardware.";
            sw = rw;
            hw = r;
        } coef[31:0];
    } NODE_DFE_COEF2 @ 0x60;

    reg {
        name = "De-flicker coefficient 3";
        desc = "Node word 25 at node offset 0x64. Four packed coefficients (TdeHalNodeSetFlicker; byte shifts 8 and 24). Source: hi3520D_tde.ko TdeHalNodeSet* (offsets and bit positions) and HiSTB v1 tde_hal.h (names).";
        field {
            name = "coef";
            desc = "Packed coefficients. VERIFIED IN THE HI3520D MODULE (HIGH): position seen in hi3520D_tde.ko. Not verified on hardware.";
            sw = rw;
            hw = r;
        } coef[31:0];
    } NODE_DFE_COEF3 @ 0x64;

    reg {
        name = "ALU / ROP / color key / global alpha";
        desc = "Node word 26 at node offset 0x68.  Source: hi3520D_tde.ko TdeHalNodeSet* (offsets and bit positions) and HiSTB v1 tde_hal.h (names).";
        field {
            name = "alu_mod";
            desc = "ALU mode: 0 source 1 bypass, 1 ROP, 2 blend, 3 blend with source 2, 4 mask ROP 1, 5 mask blend, 6 concatenate, 7 source 2 bypass, 8 mask ROP 2 (HiSTB enum; the module writes the field through TdeHalNodeGetAluMod). VERIFIED IN THE HI3520D MODULE (HIGH): position seen in hi3520D_tde.ko. Not verified on hardware. Third pass (PROVEN in TdeHalNodeSetBaseOperate): when the caller passes no ALU command the field is 7 (source 2 bypass) for every normal blit and pattern case, 0 for quick fill/copy; an alpha blend writes 2. Unverified on hardware.";
            sw = rw;
            hw = r;
        } alu_mod[3:0];
        field {
            name = "alpha_thr_en";
            desc = "Alpha threshold enable (written by SetBaseOperate from a module variable). VERIFIED IN THE HI3520D MODULE (HIGH): position seen in hi3520D_tde.ko. Not verified on hardware.";
            sw = rw;
            hw = r;
        } alpha_thr_en[4:4];
        field {
            name = "alpha_rop_mod";
            desc = "ROP code for alpha. NOTE: TdeHalNodeSetRop in the Hi3520D module is an empty stub returning error 0xA064800B: the ROP path is unusable on this vendor build. HiSTB v1 layout only (MEDIUM, INFERRED: not seen in the Hi3520D module code). Not verified on hardware.";
            sw = rw;
            hw = r;
        } alpha_rop_mod[8:5];
        field {
            name = "rgb_rop_mod";
            desc = "ROP code for RGB (see above). HiSTB v1 layout only (MEDIUM, INFERRED: not seen in the Hi3520D module code). Not verified on hardware.";
            sw = rw;
            hw = r;
        } rgb_rop_mod[12:9];
        field {
            name = "global_alpha";
            desc = "Global alpha (TdeHalNodeSetGlobalAlpha). VERIFIED IN THE HI3520D MODULE (HIGH): position seen in hi3520D_tde.ko. Not verified on hardware.";
            sw = rw;
            hw = r;
        } global_alpha[20:13];
        field {
            name = "ck_b_mod";
            desc = "Color key mode, blue/V/index (0 inside, 1 outside, 2 ignore per the HiSTB constants). VERIFIED IN THE HI3520D MODULE (HIGH): position seen in hi3520D_tde.ko. Not verified on hardware. Third pass (PROVEN, TdeHalNodeSetColorKey ARGB branch): the component mode is 2 if the ignore flag is set, else 1 if the out-of-range flag is set, else 0 (inside the [min, max] range). Unverified on hardware.";
            sw = rw;
            hw = r;
        } ck_b_mod[22:21];
        field {
            name = "ck_g_mod";
            desc = "Color key mode, green/U. VERIFIED IN THE HI3520D MODULE (HIGH): position seen in hi3520D_tde.ko. Not verified on hardware.";
            sw = rw;
            hw = r;
        } ck_g_mod[24:23];
        field {
            name = "ck_r_mod";
            desc = "Color key mode, red/Y. VERIFIED IN THE HI3520D MODULE (HIGH): position seen in hi3520D_tde.ko. Not verified on hardware.";
            sw = rw;
            hw = r;
        } ck_r_mod[26:25];
        field {
            name = "ck_a_mod";
            desc = "Color key mode, alpha. VERIFIED IN THE HI3520D MODULE (HIGH): position seen in hi3520D_tde.ko. Not verified on hardware.";
            sw = rw;
            hw = r;
        } ck_a_mod[28:27];
        field {
            name = "ck_sel";
            desc = "Color key source select. VERIFIED IN THE HI3520D MODULE (HIGH): position seen in hi3520D_tde.ko. Not verified on hardware. Third pass: the value is the first word of the vendor color key command (PROVEN). The OSI layer passes 0 for a background key and, for a foreground key on a non-CLUT format, 3 (HiSTB OSI source, MEDIUM; 2 is used when a CLUT expands first). Unverified on hardware.";
            sw = rw;
            hw = r;
        } ck_sel[30:29];
        field {
            name = "blend_reverse";
            desc = "Swap foreground and background of the blend (TdeHalNodeSetBlendRvs). VERIFIED IN THE HI3520D MODULE (HIGH): position seen in hi3520D_tde.ko. Not verified on hardware.";
            sw = rw;
            hw = r;
        } blend_reverse[31:31];
    } NODE_ALU @ 0x68;

    reg {
        name = "Color key minimum";
        desc = "Node word 27 at node offset 0x6C. Per-component minimum, bytes in the order B, G, R, A (little end first). Source: hi3520D_tde.ko TdeHalNodeSet* (offsets and bit positions) and HiSTB v1 tde_hal.h (names). Third pass (PROVEN): for ARGB formats the word is blue minimum in bits 7:0, green 15:8, red 23:16, alpha 31:24 (the vendor key command holds min, max, out flag, ignore flag per component). The key is set together with INS bit 12 and the five words ALU, CK_MIN, CK_MAX, CK_MASK.";
        field {
            name = "val";
            desc = "Packed minimum. VERIFIED IN THE HI3520D MODULE (HIGH): position seen in hi3520D_tde.ko. Not verified on hardware.";
            sw = rw;
            hw = r;
        } val[31:0];
    } NODE_CK_MIN @ 0x6C;

    reg {
        name = "Color key maximum";
        desc = "Node word 28 at node offset 0x70.  Source: hi3520D_tde.ko TdeHalNodeSet* (offsets and bit positions) and HiSTB v1 tde_hal.h (names).";
        field {
            name = "val";
            desc = "Packed maximum. VERIFIED IN THE HI3520D MODULE (HIGH): position seen in hi3520D_tde.ko. Not verified on hardware.";
            sw = rw;
            hw = r;
        } val[31:0];
    } NODE_CK_MAX @ 0x70;

    reg {
        name = "Clip start";
        desc = "Node word 29 at node offset 0x74.  Source: hi3520D_tde.ko TdeHalNodeSet* (offsets and bit positions) and HiSTB v1 tde_hal.h (names).";
        field {
            name = "x";
            desc = "Clip X start. VERIFIED IN THE HI3520D MODULE (HIGH): position seen in hi3520D_tde.ko. Not verified on hardware.";
            sw = rw;
            hw = r;
        } x[11:0];
        field {
            name = "y";
            desc = "Clip Y start. VERIFIED IN THE HI3520D MODULE (HIGH): position seen in hi3520D_tde.ko. Not verified on hardware.";
            sw = rw;
            hw = r;
        } y[27:16];
        field {
            name = "clip_inside";
            desc = "Bit 31 is set when the clip mode is inside (TdeHalNodeSetClipping conditional); exact meaning INFERRED, LOW. HiSTB v1 layout only (MEDIUM, INFERRED: not seen in the Hi3520D module code). Not verified on hardware.";
            sw = rw;
            hw = r;
        } clip_inside[31:31];
    } NODE_CLIP_START @ 0x74;

    reg {
        name = "Clip stop";
        desc = "Node word 30 at node offset 0x78.  Source: hi3520D_tde.ko TdeHalNodeSet* (offsets and bit positions) and HiSTB v1 tde_hal.h (names).";
        field {
            name = "x";
            desc = "Clip X end. VERIFIED IN THE HI3520D MODULE (HIGH): position seen in hi3520D_tde.ko. Not verified on hardware.";
            sw = rw;
            hw = r;
        } x[11:0];
        field {
            name = "y";
            desc = "Clip Y end. VERIFIED IN THE HI3520D MODULE (HIGH): position seen in hi3520D_tde.ko. Not verified on hardware.";
            sw = rw;
            hw = r;
        } y[27:16];
    } NODE_CLIP_STOP @ 0x78;

    reg {
        name = "Luma address, source 1 (macroblock)";
        desc = "Node word 31 at node offset 0x7C.  Source: hi3520D_tde.ko TdeHalNodeSet* (offsets and bit positions) and HiSTB v1 tde_hal.h (names).";
        field {
            name = "addr";
            desc = "Physical address (TdeHalNodeSetSrc1 MB path). VERIFIED IN THE HI3520D MODULE (HIGH): position seen in hi3520D_tde.ko. Not verified on hardware.";
            sw = rw;
            hw = r;
        } addr[31:0];
    } NODE_Y1_ADDR @ 0x7C;

    reg {
        name = "Luma pitch, source 1";
        desc = "Node word 32 at node offset 0x80.  Source: hi3520D_tde.ko TdeHalNodeSet* (offsets and bit positions) and HiSTB v1 tde_hal.h (names).";
        field {
            name = "pitch";
            desc = "Pitch. VERIFIED IN THE HI3520D MODULE (HIGH): position seen in hi3520D_tde.ko. Not verified on hardware.";
            sw = rw;
            hw = r;
        } pitch[15:0];
    } NODE_Y1_PITCH @ 0x80;

    reg {
        name = "Luma address, source 2 (macroblock)";
        desc = "Node word 33 at node offset 0x84.  Source: hi3520D_tde.ko TdeHalNodeSet* (offsets and bit positions) and HiSTB v1 tde_hal.h (names).";
        field {
            name = "addr";
            desc = "Physical address (TdeHalNodeSetSrc2 MB path). VERIFIED IN THE HI3520D MODULE (HIGH): position seen in hi3520D_tde.ko. Not verified on hardware.";
            sw = rw;
            hw = r;
        } addr[31:0];
    } NODE_Y2_ADDR @ 0x84;

    reg {
        name = "Luma pitch, source 2";
        desc = "Node word 34 at node offset 0x88.  Source: hi3520D_tde.ko TdeHalNodeSet* (offsets and bit positions) and HiSTB v1 tde_hal.h (names).";
        field {
            name = "pitch";
            desc = "Pitch. VERIFIED IN THE HI3520D MODULE (HIGH): position seen in hi3520D_tde.ko. Not verified on hardware.";
            sw = rw;
            hw = r;
        } pitch[15:0];
    } NODE_Y2_PITCH @ 0x88;

    reg {
        name = "Vertical resize step";
        desc = "Node word 35 at node offset 0x8C.  Source: hi3520D_tde.ko TdeHalNodeSet* (offsets and bit positions) and HiSTB v1 tde_hal.h (names).";
        field {
            name = "step";
            desc = "Step value. VERIFIED IN THE HI3520D MODULE (HIGH): position seen in hi3520D_tde.ko. Not verified on hardware.";
            sw = rw;
            hw = r;
        } step[31:0];
    } NODE_RSZ_VSTEP @ 0x8C;

    reg {
        name = "ARGB component order";
        desc = "Node word 36 at node offset 0x90.  Source: hi3520D_tde.ko TdeHalNodeSet* (offsets and bit positions) and HiSTB v1 tde_hal.h (names).";
        field {
            name = "src1";
            desc = "Source 1 order (written for formats up to ARGB8888). VERIFIED IN THE HI3520D MODULE (HIGH): position seen in hi3520D_tde.ko. Not verified on hardware.";
            sw = rw;
            hw = r;
        } src1[4:0];
        field {
            name = "src2";
            desc = "Source 2 order. VERIFIED IN THE HI3520D MODULE (HIGH): position seen in hi3520D_tde.ko. Not verified on hardware.";
            sw = rw;
            hw = r;
        } src2[12:8];
        field {
            name = "tar";
            desc = "Target order. VERIFIED IN THE HI3520D MODULE (HIGH): position seen in hi3520D_tde.ko. Not verified on hardware.";
            sw = rw;
            hw = r;
        } tar[20:16];
    } NODE_ARGB_ORDER @ 0x90;

    reg {
        name = "Color key mask";
        desc = "Node word 37 at node offset 0x94.  Source: hi3520D_tde.ko TdeHalNodeSet* (offsets and bit positions) and HiSTB v1 tde_hal.h (names). Third pass (PROVEN): every branch of TdeHalNodeSetColorKey (ARGB, CLUT, YCbCr) writes 0xFFFFFFFF to this word; the per-component mask bytes of the vendor command are not used.";
        field {
            name = "blue";
            desc = "Blue/V mask. VERIFIED IN THE HI3520D MODULE (HIGH): position seen in hi3520D_tde.ko. Not verified on hardware.";
            sw = rw;
            hw = r;
        } blue[7:0];
        field {
            name = "green";
            desc = "Green/U mask. VERIFIED IN THE HI3520D MODULE (HIGH): position seen in hi3520D_tde.ko. Not verified on hardware.";
            sw = rw;
            hw = r;
        } green[15:8];
        field {
            name = "red";
            desc = "Red/Y mask. VERIFIED IN THE HI3520D MODULE (HIGH): position seen in hi3520D_tde.ko. Not verified on hardware.";
            sw = rw;
            hw = r;
        } red[23:16];
        field {
            name = "alpha";
            desc = "Alpha mask. VERIFIED IN THE HI3520D MODULE (HIGH): position seen in hi3520D_tde.ko. Not verified on hardware.";
            sw = rw;
            hw = r;
        } alpha[31:24];
    } NODE_CK_MASK @ 0x94;

    reg {
        name = "Colorize value";
        desc = "Node word 38 at node offset 0x98.  Source: hi3520D_tde.ko TdeHalNodeSet* (offsets and bit positions) and HiSTB v1 tde_hal.h (names).";
        field {
            name = "val";
            desc = "Colorize color (TdeHalNodeSetColorize). VERIFIED IN THE HI3520D MODULE (HIGH): position seen in hi3520D_tde.ko. Not verified on hardware.";
            sw = rw;
            hw = r;
        } val[31:0];
    } NODE_COLORIZE @ 0x98;

    reg {
        name = "Alpha blend control";
        desc = "Node word 39 at node offset 0x9C.  Source: hi3520D_tde.ko TdeHalNodeSet* (offsets and bit positions) and HiSTB v1 tde_hal.h (names).";
        field {
            name = "src1_blend_mode";
            desc = "Source 1 blend mode (TdeHalNodeSetBlend). VERIFIED IN THE HI3520D MODULE (HIGH): position seen in hi3520D_tde.ko. Not verified on hardware. Third pass (PROVEN, TdeHalNodeSetBlend jump table): factor codes are 0 zero, 1 one, 4 source 2 alpha, 5 one minus source 2 alpha, 8 source 1 alpha, 9 one minus source 1 alpha (10 is source 2 alpha saturate in the vendor enum, not used by the command table). Per command (source 1 mode, source 2 mode): none 5,4; clear 0,0; src 0,1; src-over 5,1; dst-over 1,9; src-in 0,8; dst-in 4,0; src-out 0,9; dst-out 5,0; src-atop 5,8; dst-atop 4,9; add 1,1; xor 5,9; dst 1,0. In a double-source blit source 1 is the background and source 2 the foreground (vendor TdeOsiDoubleSrcBlit). SetBlend always sets bit 6, clears bits 5, 7 and 13 and takes bits 4, 12, 14, 15 from the option struct. Unverified on hardware.";
            sw = rw;
            hw = r;
        } src1_blend_mode[3:0];
        field {
            name = "src1_premulti_en";
            desc = "Source 1 pre-multiplied alpha. VERIFIED IN THE HI3520D MODULE (HIGH): position seen in hi3520D_tde.ko. Not verified on hardware.";
            sw = rw;
            hw = r;
        } src1_premulti_en[4:4];
        field {
            name = "src1_multi_global_en";
            desc = "Source 1 multiply global alpha (cleared by SetBlend). VERIFIED IN THE HI3520D MODULE (HIGH): position seen in hi3520D_tde.ko. Not verified on hardware.";
            sw = rw;
            hw = r;
        } src1_multi_global_en[5:5];
        field {
            name = "src1_pixel_alpha_en";
            desc = "Source 1 pixel alpha (set by SetBlend). VERIFIED IN THE HI3520D MODULE (HIGH): position seen in hi3520D_tde.ko. Not verified on hardware.";
            sw = rw;
            hw = r;
        } src1_pixel_alpha_en[6:6];
        field {
            name = "src1_global_alpha_en";
            desc = "Source 1 global alpha (cleared by SetBlend, set by the global alpha cases). VERIFIED IN THE HI3520D MODULE (HIGH): position seen in hi3520D_tde.ko. Not verified on hardware.";
            sw = rw;
            hw = r;
        } src1_global_alpha_en[7:7];
        field {
            name = "src2_blend_mode";
            desc = "Source 2 blend mode. VERIFIED IN THE HI3520D MODULE (HIGH): position seen in hi3520D_tde.ko. Not verified on hardware.";
            sw = rw;
            hw = r;
        } src2_blend_mode[11:8];
        field {
            name = "src2_premulti_en";
            desc = "Source 2 pre-multiplied alpha. VERIFIED IN THE HI3520D MODULE (HIGH): position seen in hi3520D_tde.ko. Not verified on hardware.";
            sw = rw;
            hw = r;
        } src2_premulti_en[12:12];
        field {
            name = "src2_multi_global_en";
            desc = "Source 2 multiply global alpha. VERIFIED IN THE HI3520D MODULE (HIGH): position seen in hi3520D_tde.ko. Not verified on hardware.";
            sw = rw;
            hw = r;
        } src2_multi_global_en[13:13];
        field {
            name = "src2_pixel_alpha_en";
            desc = "Source 2 pixel alpha. VERIFIED IN THE HI3520D MODULE (HIGH): position seen in hi3520D_tde.ko. Not verified on hardware.";
            sw = rw;
            hw = r;
        } src2_pixel_alpha_en[14:14];
        field {
            name = "src2_global_alpha_en";
            desc = "Source 2 global alpha. VERIFIED IN THE HI3520D MODULE (HIGH): position seen in hi3520D_tde.ko. Not verified on hardware.";
            sw = rw;
            hw = r;
        } src2_global_alpha_en[15:15];
        field {
            name = "alpha_rop_en";
            desc = "Apply the alpha ROP during blending (TdeHalNodeEnableAlphaRop sets 0x10000). VERIFIED IN THE HI3520D MODULE (HIGH): position seen in hi3520D_tde.ko. Not verified on hardware.";
            sw = rw;
            hw = r;
        } alpha_rop_en[16:16];
    } NODE_ALPHA_BLEND @ 0x9C;

    reg {
        name = "Custom input CSC coefficient address";
        desc = "Node word 40 at node offset 0xA0.  Source: hi3520D_tde.ko TdeHalNodeSet* (offsets and bit positions) and HiSTB v1 tde_hal.h (names).";
        field {
            name = "addr";
            desc = "Physical address (TDeHalNodeSetCsc: store at node+0xA0). VERIFIED IN THE HI3520D MODULE (HIGH): position seen in hi3520D_tde.ko. Not verified on hardware.";
            sw = rw;
            hw = r;
        } addr[31:0];
    } NODE_ICSC_ADDR @ 0xA0;

    reg {
        name = "Custom output CSC coefficient address";
        desc = "Node word 41 at node offset 0xA4.  Source: hi3520D_tde.ko TdeHalNodeSet* (offsets and bit positions) and HiSTB v1 tde_hal.h (names).";
        field {
            name = "addr";
            desc = "Physical address (node+0xA4). VERIFIED IN THE HI3520D MODULE (HIGH): position seen in hi3520D_tde.ko. Not verified on hardware.";
            sw = rw;
            hw = r;
        } addr[31:0];
    } NODE_OCSC_ADDR @ 0xA4;

};

regfile eHISI_TDE_G2 {
    name = "HiSilicon TDE, Hi3516A/D and Hi3518E V200 / Hi3516C V200 generation (vendor-derived)";
    desc = "VENDOR-DERIVED, CONFIDENCE MEDIUM, NOT VERIFIED ON HARDWARE. No data sheet has a TDE register table. Static analysis (objdump, nothing executed) of hi3516a_tde.ko (Linux 3.4.35 and 4.9.37 builds) and hi3518e_tde.ko (4.9.37): HAL functions TdeHal*, identical register offsets and written values in both; the same list-control offsets are also written by hi3535_tde.ko, hi3521a_tde.ko, hi3531d_tde.ko, hi3536*_tde.ko and hi_tde.ko (not RDL chips: layout widely shared, the Hi3535 module has the same 0x81C/0x820 queue registers as this one, the Hi3521/3531/3536 modules lack them). Base 0x20610000 (ioremap in the module), interrupt per data sheet. Register names are the HiSTB v1 names (that driver programs the same offsets and values, see eHISI_TDE_V1), purposes come from the vendor functions. The job itself is a DDR node (42 words + 64 bit update mask), addresses go to TDE_AQ_NADDR. Compared with the Hi3520D module (eHISI_TDE_G1) this generation has no 0x1800 mirror and no 0x2000 bank, but adds 0x81C/0x820 (synchronous queue), 0x868 and 0x86C. Documented in docs/rdl-campaign/tde-vendor.md.";

    reg {
        name = "TDE version / ID";
        desc = "Read-only ID word; bTdeHalSwVersion compares it with 0x20080228. BOARD-READ on the Hi3518E V200 (Night Owl camera, 2026-11-11, OpenIPC Linux, majestic stopped, PERI_CRG22 clock on + reset released for the read, CRG restored): 0x20101206 (neither 0x20080228 nor the Hi3520D value 0x20110322; date-code style 2010-12-06, meaning INFERRED); +0x000..+0x008 read 0 when idle. A driver must not insist on one constant. BOARD-READ on the Hi3520D (nvr0408, 2026-11-11, U-Boot and Linux): 0x20110322, not the vendor constant (a date-code style value, 2011-03-22; the meaning is INFERRED); a driver must not insist on 0x20080228. Source: vendor module hi3516a_tde.ko, hi3518e_tde.ko (bTdeHalSwVersion), confidence HIGH, static analysis of the disassembly. Not verified on hardware. The two modules show identical offsets and values.";

        field {
            name = "value";
            desc = "32 bit value, single field (bit layout not observed in the vendor code). Not verified on hardware.";
            sw = r;
            hw = w;
        } value[31:0];
    } TDE_VERSION @ 0x800;

    reg {
        name = "TDE soft reset";
        desc = "Written with 0xFFFFFFFF by TdeHalCtlReset, TdeHalResumeInit and TdeHalNodeExecute (reset before every job when the engine was found idle). HiSTB v1 name. Source: vendor module hi3516a_tde.ko, hi3518e_tde.ko (TdeHalCtlReset), confidence MEDIUM, static analysis of the disassembly. Not verified on hardware. The two modules show identical offsets and values.";

        field {
            name = "value";
            desc = "32 bit value, single field (bit layout not observed in the vendor code). Not verified on hardware.";
            sw = w;
            hw = r;
        } value[31:0];
    } TDE_RST @ 0x804;

    reg {
        name = "TDE control / start";
        desc = "Written with 1 as the last step of TdeHalNodeExecute (start of the list). HiSTB v1 name. Source: vendor module hi3516a_tde.ko, hi3518e_tde.ko (TdeHalNodeExecute), confidence MEDIUM, static analysis of the disassembly. Not verified on hardware. The two modules show identical offsets and values.";

        field {
            name = "value";
            desc = "32 bit value, single field (bit layout not observed in the vendor code). Not verified on hardware.";
            sw = w;
            hw = r;
        } value[31:0];
    } TDE_CTRL @ 0x808;

    reg {
        name = "TDE async list current node address";
        desc = "Read by TdeHalCurNode and TdeHalNodeSuspend: address of the node being executed; zero means none. HiSTB v1 name. Source: vendor module hi3516a_tde.ko, hi3518e_tde.ko (TdeHalCurNode, TdeHalNodeSuspend), confidence HIGH for the access, MEDIUM for the meaning, static analysis of the disassembly. Not verified on hardware. The two modules show identical offsets and values.";

        field {
            name = "value";
            desc = "32 bit value, single field (bit layout not observed in the vendor code). Not verified on hardware.";
            sw = r;
            hw = w;
        } value[31:0];
    } TDE_AQ_ADDR @ 0x810;

    reg {
        name = "TDE status";
        desc = "Bit 0 = busy (TdeHalCtlIsIdle, TdeHalNodeExecute waits up to ten reads for it to clear); bit 2 = synchronous queue working (TdeHalIsSqWork returns bit 2); bits [27:16] = count of finished nodes (TdeHalNodeSuspend masks (value >> 16) with 0xFFF to find the node the engine stopped at). HiSTB v1 name. Source: vendor module hi3516a_tde.ko, hi3518e_tde.ko (TdeHalCtlIsIdle, TdeHalIsSqWork, TdeHalNodeSuspend), confidence HIGH for bits 0/2, MEDIUM for the node count, static analysis of the disassembly. Not verified on hardware. The two modules show identical offsets and values.";

        field {
            name = "busy";
            desc = "1 = async list busy.";
            sw = r;
            hw = w;
        } busy[0:0];

        field {
            name = "sq_work";
            desc = "1 = synchronous queue working (vendor name SqWork).";
            sw = r;
            hw = w;
        } sq_work[2:2];

        field {
            name = "node_cnt";
            desc = "Finished-node number used by TdeHalNodeSuspend (12 bits).";
            sw = r;
            hw = w;
        } node_cnt[27:16];

        field {
            name = "rest_unk";
            desc = "Unknown purpose, vendor-observed only, confidence LOW, not verified on hardware.";
            sw = r;
            hw = w;
        } rest_unk[31:28];

        field {
            name = "rest_mid";
            desc = "Unknown purpose, vendor-observed only, confidence LOW, not verified on hardware.";
            sw = r;
            hw = w;
        } rest_mid[15:3];

        field {
            name = "rest_b1";
            desc = "Unknown purpose, vendor-observed only, confidence LOW, not verified on hardware.";
            sw = r;
            hw = w;
        } rest_b1[1:1];
    } TDE_STA @ 0x814;

    reg {
        name = "TDE interrupt status / mask";
        desc = "TdeHalCtlIntStats reads and writes back (acknowledge); TdeHalCtlIntClear keeps the low 16 bits and ORs its argument shifted into [31:16]; TdeHalCtlReset/ResumeInit/NodeExecute write 0x800F001F. Split [15:0] status, [31:16] interrupt mask/enable as in the HiSTB v1 driver (the polarity of the upper half is not stated by the code). Source: vendor module hi3516a_tde.ko, hi3518e_tde.ko (TdeHalCtlIntStats, TdeHalCtlIntClear), confidence MEDIUM, static analysis of the disassembly. Not verified on hardware. The two modules show identical offsets and values. SECOND PASS: the interrupt service routine tde_osr_isr does NOT read this register; the only function that reads it (TdeHalCtlIntStats, which reads and writes back 0x818 and 0x1818 and returns the 0x1818 value) has no caller inside hi3520D_tde.ko, and the completion path uses the 0x2000 bank. Meaning of the status bits is therefore still unknown (the node's INS.aq_irq_mask = 8 enables the node-complete interrupt, INFERRED). The module never calls TdeHalCtlReset either; the engine reset is the CRG reset bit (PERI_CRG22 bit 0).";

        field {
            name = "status";
            desc = "Interrupt status, acknowledged by writing the read value back (write-1-clear, vendor-observed).";
            sw = rw;
            hw = rw;
        } status[15:0];

        field {
            name = "mask";
            desc = "Interrupt enable/mask bits written by TdeHalCtlIntClear; reset value written is 0x800F (vendor-observed).";
            sw = rw;
            hw = rw;
        } mask[31:16];
    } TDE_INT @ 0x818;

    reg {
        name = "UNK_081C";
        desc = "Read-modify-write by TdeHalNodeExecute and TdeHalResumeInit: bits [25:21] and bits [1:0] cleared, nothing set. Probably the control register of the synchronous queue (it sits next to the SQ bit in TDE_STA, inferred, LOW). Access observed: read-modify-write. Unknown purpose, vendor-observed only, confidence LOW, not verified on hardware.";

        field {
            name = "value";
            desc = "Unknown purpose, vendor-observed only, confidence LOW, not verified on hardware.";
            sw = rw;
            hw = rw;
        } value[31:0];
    } UNK_081C @ 0x81C;

    reg {
        name = "UNK_0820";
        desc = "Written with 0 by TdeHalNodeExecute, TdeHalResumeInit and TdeHalInit, right next to the TDE_AQ_NADDR clear (so probably the SQ node address, inferred, LOW). Access observed: written, value 0. Unknown purpose, vendor-observed only, confidence LOW, not verified on hardware.";

        field {
            name = "value";
            desc = "Unknown purpose, vendor-observed only, confidence LOW, not verified on hardware.";
            sw = w;
            hw = r;
        } value[31:0];
    } UNK_0820 @ 0x820;

    reg {
        name = "TDE async list control";
        desc = "Read-modify-write by TdeHalNodeExecute/TdeHalResumeInit/TdeHalInit: bit 24 set, bits [23:20] cleared then bit 22 set (mode 4); the error path of TdeHalNodeExecute clears [23:20] again. HiSTB v1 TDE_AQ_CTRL (u32AqEn bit 24, u32AqOperMode [23:20]). Source: vendor module hi3516a_tde.ko, hi3518e_tde.ko (TdeHalNodeExecute), confidence MEDIUM, static analysis of the disassembly. Not verified on hardware. The two modules show identical offsets and values.";

        field {
            name = "aq_oper_mode";
            desc = "List operating mode; the module programs 4 (HiSTB v1: 0 = next list after the current list, 4 = after the current node and line).";
            sw = rw;
            hw = rw;
        } aq_oper_mode[23:20];

        field {
            name = "aq_en";
            desc = "Async list enable.";
            sw = rw;
            hw = rw;
        } aq_en[24:24];

        field {
            name = "rest_hi";
            desc = "Unknown purpose, vendor-observed only, confidence LOW, not verified on hardware.";
            sw = rw;
            hw = rw;
        } rest_hi[31:25];

        field {
            name = "rest_lo";
            desc = "Unknown purpose, vendor-observed only, confidence LOW, not verified on hardware.";
            sw = rw;
            hw = rw;
        } rest_lo[19:0];
    } TDE_AQ_CTRL @ 0x82C;

    reg {
        name = "TDE async list next node address";
        desc = "Physical address of the first node to execute, written by TdeHalNodeExecute and TdeHalRestoreAloneNode; written with 0 by TdeHalResumeInit/Init. HiSTB v1 name. Source: vendor module hi3516a_tde.ko, hi3518e_tde.ko (TdeHalNodeExecute, TdeHalRestoreAloneNode), confidence HIGH, static analysis of the disassembly. Not verified on hardware. The two modules show identical offsets and values.";

        field {
            name = "value";
            desc = "32 bit value, single field (bit layout not observed in the vendor code). Not verified on hardware.";
            sw = w;
            hw = r;
        } value[31:0];
    } TDE_AQ_NADDR @ 0x830;

    reg {
        name = "TDE async node update mask (low)";
        desc = "Low 32 bits of the 64 bit node update mask (which node words the engine reloads), written by TdeHalNodeExecute and TdeHalRestoreAloneNode (the mask is node word 42, +0xA8). HiSTB v1 name. Source: vendor module hi3516a_tde.ko, hi3518e_tde.ko (TdeHalNodeExecute), confidence MEDIUM, static analysis of the disassembly. Not verified on hardware. The two modules show identical offsets and values.";

        field {
            name = "value";
            desc = "32 bit value, single field (bit layout not observed in the vendor code). Not verified on hardware.";
            sw = w;
            hw = r;
        } value[31:0];
    } TDE_AQ_UPDATE @ 0x834;

    reg {
        name = "TDE bus limiter";
        desc = "Written with 0x80220000 by TdeHalCtlReset/ResumeInit/NodeExecute (HiSTB v1: 0x80770000). HiSTB v1 name. Source: vendor module hi3516a_tde.ko, hi3518e_tde.ko (TdeHalCtlReset), confidence MEDIUM, static analysis of the disassembly. Not verified on hardware. The two modules show identical offsets and values.";

        field {
            name = "value";
            desc = "32 bit value, single field (bit layout not observed in the vendor code). Not verified on hardware.";
            sw = w;
            hw = r;
        } value[31:0];
    } TDE_BUS_LIMITER @ 0x844;

    reg {
        name = "TDE async node update mask (high)";
        desc = "High 32 bits of the node update mask, written by TdeHalNodeExecute. HiSTB v1 name. Source: vendor module hi3516a_tde.ko, hi3518e_tde.ko (TdeHalNodeExecute), confidence MEDIUM, static analysis of the disassembly. Not verified on hardware. The two modules show identical offsets and values.";

        field {
            name = "value";
            desc = "32 bit value, single field (bit layout not observed in the vendor code). Not verified on hardware.";
            sw = w;
            hw = r;
        } value[31:0];
    } TDE_AQ_UPDATE2 @ 0x85C;

    reg {
        name = "TDE request threshold";
        desc = "Written with 0x01FEF7CF by TdeHalCtlReset/ResumeInit/NodeExecute (same value as the HiSTB v1 driver). HiSTB v1 name. Source: vendor module hi3516a_tde.ko, hi3518e_tde.ko (TdeHalCtlReset), confidence MEDIUM, static analysis of the disassembly. Not verified on hardware. The two modules show identical offsets and values.";

        field {
            name = "value";
            desc = "32 bit value, single field (bit layout not observed in the vendor code). Not verified on hardware.";
            sw = w;
            hw = r;
        } value[31:0];
    } TDE_REQ_TH @ 0x868;

    reg {
        name = "TDE AXI ID";
        desc = "Written with 0x1010 by TdeHalResumeInit and TdeHalNodeExecute (HiSTB v1 writes 0x3010). HiSTB v1 name. Source: vendor module hi3516a_tde.ko, hi3518e_tde.ko (TdeHalResumeInit), confidence MEDIUM, static analysis of the disassembly. Not verified on hardware. The two modules show identical offsets and values.";

        field {
            name = "value";
            desc = "32 bit value, single field (bit layout not observed in the vendor code). Not verified on hardware.";
            sw = w;
            hw = r;
        } value[31:0];
    } TDE_AXI_ID @ 0x86C;
};

regfile eHISI_TDE_G3 {
    name = "HiSilicon TDE, Hi3516A V300 generation (vendor-derived stubs)";
    desc = "VENDOR-DERIVED STUBS, CONFIDENCE LOW, NOT VERIFIED ON HARDWARE. The Hi3516A V300 user guide lists the TDE window (0x11210000, 64 KB, GIC 67) and a feature list only. Static analysis (objdump, nothing executed) of open_tde.ko (OpenIPC Hi3516AV300 rootfs, Linux 4.9.37; the base comes from the device tree through devm_ioremap_resource, the module also contains a constant 0x11210000): a new register map, unlike every older generation: node address as a 64 bit pair at 0xF8/0xFC (this generation addresses more than 4 GB), start at 0x500, interrupt block 0x510-0x514, an unknown register at 0x530, status and current node at 0x4000-0x4014. The register names of the older generations do not apply. Registers not listed were not seen accessed; the node zoom/filter fields the module also writes are DDR node bytes, not registers. Documented in docs/rdl-campaign/tde-vendor.md.";

    reg {
        name = "UNK_00F8";
        desc = "Node address, low word: tde_hal_node_execute writes its first argument here (after clearing both words to 0); tde_hal_resume_init clears it. The pair 0xF8/0xFC is a 64 bit physical node address (inferred from the two-argument call, MEDIUM). Access observed: written. Unknown purpose, vendor-observed only, confidence LOW, not verified on hardware.";

        field {
            name = "value";
            desc = "Unknown purpose, vendor-observed only, confidence LOW, not verified on hardware.";
            sw = w;
            hw = r;
        } value[31:0];
    } UNK_00F8 @ 0xF8;

    reg {
        name = "UNK_00FC";
        desc = "Node address, high word: tde_hal_node_execute writes its second argument here (after 0). Access observed: written. See UNK_00F8. Unknown purpose, vendor-observed only, confidence LOW, not verified on hardware.";

        field {
            name = "value";
            desc = "Unknown purpose, vendor-observed only, confidence LOW, not verified on hardware.";
            sw = w;
            hw = r;
        } value[31:0];
    } UNK_00FC @ 0xFC;

    reg {
        name = "UNK_0500";
        desc = "Written with 1 as the last register write of tde_hal_node_execute, after the node address and an osal_dmb barrier (the start command of the list; compare TDE_CTRL at 0x808 on the older generation, inferred, LOW). Access observed: written, value 1. Unknown purpose, vendor-observed only, confidence LOW, not verified on hardware.";

        field {
            name = "value";
            desc = "Unknown purpose, vendor-observed only, confidence LOW, not verified on hardware.";
            sw = w;
            hw = r;
        } value[31:0];
    } UNK_0500 @ 0x500;

    reg {
        name = "UNK_0510";
        desc = "Written with 0xF by tde_hal_ctl_reset, tde_hal_node_execute and tde_hal_resume_init (clears four status bits), and with the value just read from 0x514 by tde_hal_ctl_int_status (acknowledge). Probably the interrupt status clear register (inferred, LOW). Access observed: written. Unknown purpose, vendor-observed only, confidence LOW, not verified on hardware.";

        field {
            name = "value";
            desc = "Unknown purpose, vendor-observed only, confidence LOW, not verified on hardware.";
            sw = w;
            hw = r;
        } value[31:0];
    } UNK_0510 @ 0x510;

    reg {
        name = "UNK_0514";
        desc = "Read by tde_hal_ctl_int_status (status word, also logged as 'tde register int status'), and read-modify-written by tde_hal_ctl_int_clear: low 16 bits kept, argument shifted into [31:16] (the layout of TDE_INT 0x818 on the older generation). Access observed: read, read-modify-write. Unknown purpose, vendor-observed only, confidence LOW, not verified on hardware.";

        field {
            name = "value";
            desc = "Unknown purpose, vendor-observed only, confidence LOW, not verified on hardware.";
            sw = rw;
            hw = rw;
        } value[31:0];
    } UNK_0514 @ 0x514;

    reg {
        name = "UNK_0530";
        desc = "Written with 0x0100647F by tde_hal_ctl_reset, tde_hal_node_execute and tde_hal_resume_init right after the interrupt clear (position and role like TDE_REQ_TH 0x868 / TDE_BUS_LIMITER on the older generation, not the same value, inferred, LOW). Access observed: written. Unknown purpose, vendor-observed only, confidence LOW, not verified on hardware.";

        field {
            name = "value";
            desc = "Unknown purpose, vendor-observed only, confidence LOW, not verified on hardware.";
            sw = w;
            hw = r;
        } value[31:0];
    } UNK_0530 @ 0x530;

    reg {
        name = "UNK_4000";
        desc = "Read by tde_hal_ctl_is_idle, tde_hal_ctl_is_idle_safely and tde_hal_node_execute: the low 8 bits are tested, all zero means idle (node_execute polls up to ten times and refuses to start otherwise). Probably the engine status (inferred, LOW). Access observed: read, bits [7:0] used. Unknown purpose, vendor-observed only, confidence LOW, not verified on hardware.";

        field {
            name = "busy_unk";
            desc = "Unknown purpose, vendor-observed only, confidence LOW, not verified on hardware.";
            sw = r;
            hw = w;
        } busy_unk[7:0];

        field {
            name = "rest";
            desc = "Unknown purpose, vendor-observed only, confidence LOW, not verified on hardware.";
            sw = r;
            hw = w;
        } rest[31:8];
    } UNK_4000 @ 0x4000;

    reg {
        name = "UNK_4010";
        desc = "Read by tde_hal_cur_node together with UNK_4014: the 64 bit address of the node being executed (inferred from the function name and the two-word return value, LOW). Access observed: read. Unknown purpose, vendor-observed only, confidence LOW, not verified on hardware.";

        field {
            name = "value";
            desc = "Unknown purpose, vendor-observed only, confidence LOW, not verified on hardware.";
            sw = r;
            hw = w;
        } value[31:0];
    } UNK_4010 @ 0x4010;

    reg {
        name = "UNK_4014";
        desc = "High word of the pair read by tde_hal_cur_node. Access observed: read. See UNK_4010. Unknown purpose, vendor-observed only, confidence LOW, not verified on hardware.";

        field {
            name = "value";
            desc = "Unknown purpose, vendor-observed only, confidence LOW, not verified on hardware.";
            sw = r;
            hw = w;
        } value[31:0];
    } UNK_4014 @ 0x4014;
};

`endif
