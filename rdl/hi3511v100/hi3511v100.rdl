`include "defines.rdl"

`include "../common/ARM_PL011.rdl"
`include "../common/ARM_PL061.rdl"
`include "../common/ARM_PL190.rdl"
`include "../common/DW_APB_I2C.rdl"
`include "../common/HISI_CIPHER.rdl"
`include "../common/HISI_DDRC.rdl"
`include "../common/HISI_DMAC.rdl"
`include "../common/HISI_DWMMC.rdl"
`include "../common/HISI_IR_V1.rdl"
`include "../common/HISI_SIO_V1.rdl"
`include "../common/HISI_SMI.rdl"
`include "../common/HISI_SPI.rdl"
`include "../common/HISI_RTC.rdl"
`include "../common/HISI_SYS_CTRL.rdl"
`include "../common/HISI_TIMER_SP804.rdl"
`include "../common/HISI_USB_HOST.rdl"
`include "../common/HISI_VEDU.rdl"
`include "../common/HISI_WDG_SP805.rdl"

addrmap hi3511v100 {
    name = "hi3511v100 registers";
    desc = "
        ## Datasheets

        * [Full Datasheet](assets/Hi3511-Datasheet.pdf)

        ## Diagrams

        ![Logic Block Diagram](assets/Logic-Block-Diagram.png)

        ## Addresses

        | Start Address | End Address | Description            | Documented Here |
        |---------------|-------------|------------------------|-----------------|
        | 0xE0000000    | 0xFFFFFFFF  | DDR512 MB              | &#10060;        |
        | 0xC0000000    | 0xDFFFFFFF  | Reserved 512 MB              | &#10060;        |
        | 0xB0000000    | 0xBFFFFFFF  | PCI address space 256 MB        | &#10060;        |
        | 0xA0030000    | 0xAFFFFFFF  | Reserved 255.8 MB             | &#10060;        |
        | 0xA0020000    | 0xA002FFFF  | Reserved 64 KB               | &#10060;        |
        | 0xA0010000    | 0xA001FFFF  | Reserved 64 KB               | &#10060;        |
        | 0xA0000000    | 0xA000FFFF  | USB 1.1 HOST registers 64 KB | &#9989;         |
        | 0x900B0000    | 0x9FFFFFFF  | Reserved 255.3 MB            | &#10060;        |
        | 0x900A0000    | 0x900AFFFF  | SIO1 registers 64 KB         | &#9989;         |
        | 0x90090000    | 0x9009FFFF  | Reserved 64 KB               | &#10060;        |
        | 0x90080000    | 0x9008FFFF  | VEDU registers 64 KB         | &#9989;         |
        | 0x90070000    | 0x9007FFFF  | DSU registers 64 KB          | &#10060;        |
        | 0x90060000    | 0x9006FFFF  | VIU registers 64 KB          | &#10060;        |
        | 0x90050000    | 0x9005FFFF  | VOU registers 64 KB          | &#10060;        |
        | 0x90040000    | 0x9004FFFF  | CIPHER registers 64 KB       | &#9989;         |
        | 0x90030000    | 0x9003FFFF  | ETH registers 64 KB          | &#10060;        |
        | 0x90020000    | 0x9002FFFF  | MMC registers 64 KB          | &#9989;         |
        | 0x90010000    | 0x9001FFFF  | Reserved 64 KB               | &#10060;        |
        | 0x90000000    | 0x9000FFFF  | Reserved 64 KB               | &#10060;        |
        | 0x800A0000    | 0x8FFFFFFF  | Reserved 255 MB              | &#10060;        |
        | 0x80090000    | 0x8009FFFF  | USB 2.0 OTG registers 64 KB  | &#10060;        |
        | 0x80080000    | 0x8008FFFF  | SIO0 registers 64 KB         | &#9989;         |
        | 0x80000000    | 0x8007FFFF  | Reserved 512 KB              | &#10060;        |
        | 0x36000000    | 0x7FFFFFFF  | Reserved 1183 MB             | &#10060;        |
        | 0x34000000    | 0x35FFFFFF  | SMI CS0 32 MB          | &#10060;        |
        | 0x32000000    | 0x33FFFFFF  | Reserved 32 MB               | &#10060;        |
        | 0x30000000    | 0x31FFFFFF  | SMI CS1 32 MB          | &#10060;        |
        | 0x2C000000    | 0x2FFFFFFF  | Reserved 64 MB               | &#10060;        |
        | 0x28000000    | 0x2BFFFFFF  | Reserved 64 MB               | &#10060;        |
        | 0x24000000    | 0x27FFFFFF  | Reserved 64 MB               | &#10060;        |
        | 0x101FE000    | 0x23FFFFFF  | Reserved 318 MB              | &#10060;        |
        | 0x101FD000    | 0x101FDFFF  | Reserved 4 KB                | &#10060;        |
        | 0x101FB000    | 0x101FCFFF  | Reserved 16 KB               | &#10060;        |
        | 0x101FA000    | 0x101FAFFF  | GPIO7 registers 4 KB         | &#9989;         |
        | 0x101F9000    | 0x101F9FFF  | GPIO6 registers 4 KB         | &#9989;         |
        | 0x101F8000    | 0x101F8FFF  | GPIO5 registers 4 KB         | &#9989;         |
        | 0x101F7000    | 0x101F7FFF  | GPIO4 registers 4 KB         | &#9989;         |
        | 0x101F6000    | 0x101F6FFF  | I2C registers 4 KB           | &#9989;         |
        | 0x101F5000    | 0x101F5FFF  | Reserved 4 KB                | &#10060;        |
        | 0x101F4000    | 0x101F4FFF  | SSP registers 4 KB           | &#9989;           |
        | 0x101F3000    | 0x101F3FFF  | UART2 registers 4 KB         | &#9989;         |
        | 0x101F2000    | 0x101F2FFF  | UART1 registers 4 KB         | &#9989;         |
        | 0x101F1000    | 0x101F1FFF  | UART0 registers 4 KB         | &#9989;         |
        | 0x101F0000    | 0x101F0FFF  | Reserved 4 KB                | &#10060;        |
        | 0x101EF000    | 0x101EFFFF  | Reserved 4 KB                | &#10060;        |
        | 0x101EB000    | 0x101EEFFF  | Reserved 16 KB               | &#10060;        |
        | 0x101EA000    | 0x101EAFFF  | Reserved 4 KB                | &#10060;        |
        | 0x101E9000    | 0x101E9FFF  | IR registers 4 KB            | &#9989;         |
        | 0x101E8000    | 0x101E8FFF  | RTC registers 4 KB           | &#9989;         |
        | 0x101E7000    | 0x101E7FFF  | GPIO3 registers 4 KB         | &#9989;         |
        | 0x101E6000    | 0x101E6FFF  | GPIO2 registers 4 KB         | &#9989;         |
        | 0x101E5000    | 0x101E5FFF  | GPIO1 registers 4 KB         | &#9989;         |
        | 0x101E4000    | 0x101E4FFF  | GPIO0 registers 4 KB         | &#9989;         |
        | 0x101E3000    | 0x101E3FFF  | Timer2/3 registers 4 KB      | &#9989;         |
        | 0x101E2000    | 0x101E2FFF  | Timer0/1 registers 4 KB      | &#9989;         |
        | 0x101E1000    | 0x101E1FFF  | WatchDog registers 4 KB      | &#9989;         |
        | 0x101E0000    | 0x101E0FFF  | System control registers 4 KB           | &#9989;         |
        | 0x10160000    | 0x101DFFFF  | Reserved 512 KB              | &#10060;        |
        | 0x10150000    | 0x1015FFFF  | DDRC registers 64 KB         | &#9989;         |
        | 0x10140000    | 0x1014FFFF  | INT registers 64 KB          | &#9989;         |
        | 0x10130000    | 0x1013FFFF  | DMA registers 64 KB          | &#9989;         |
        | 0x10120000    | 0x1012FFFF  | Reserved 64 KB               | &#10060;        |
        | 0x10110000    | 0x1011FFFF  | Reserved 64 KB               | &#10060;        |
        | 0x10100000    | 0x1010FFFF  | SMI registers 64 KB          | &#9989;         |
        | 0x01000000    | 0x100FFFFF  | Reserved 257 MB              | &#10060;        |
        | 0x00000000    | 0x00FFFFFF  | - 16 MB                | &#10060;        |

        <!-- overview:begin -->

        ### Diagrams

        ![Logic block diagram](assets/diagrams/hi3511v100-logic.svg)

        ![Register blocks by function](assets/diagrams/hi3511v100-blocks.svg)

        ![Clock tree](assets/diagrams/hi3511v100-clocks.svg)

        ![Boot flow](assets/diagrams/hi3511v100-boot.svg)

        ![Interrupt topology](assets/diagrams/hi3511v100-irq.svg)

        ![Reset tree](assets/diagrams/hi3511v100-resets.svg)

        ![Power domains](assets/diagrams/hi3511v100-power.svg)

        ![CRG register map](assets/diagrams/hi3511v100-crgmap.svg)

        ![IP edition per chip](assets/diagrams/hi3511v100-family.svg)

        ### Chip ID

        | Chip | System controller ID registers (0xEE0 .. 0xEEC) | Value read as SC_SYSID |
        |---|---|---|
        | hi3511v100 | SYSID0..3 reset values from the RDL | 0x35110100 |
        | hi3512v100 | SYSID0..3 reset values from the RDL | 0x35110100 |

        The four 8-bit registers form the 32-bit chip ID (SYSID3 is the most significant byte). The values are the reset values of the register descriptions: one data sheet documents one ID for all chips it covers, so the chips of a shared data sheet are not distinguished here (the real value of each variant is not stated).

        ### Key specifications (data sheet chapter 1 and 3; the data sheet is Chinese, translated)

        One data sheet covers the Hi3511 and the Hi3512 (the Hi3512 chip root has no RTC block; the data sheet text used for this table is written for the Hi3511 and names the Hi3512 only in the title). The block sets are in the register-block table of each chip root.

        | | Hi3511 V100 / Hi3512 V100 |
        |---|---|
        | CPU | ARM926EJ-S, up to 270 MHz, 16 KB I + 16 KB D cache, 2 KB ITCM, MMU; one VIC, 32 interrupt sources |
        | DDR | one DDR2 controller, one chip select, 16-bit (up to 256 MB) or 32-bit (up to 512 MB) devices |
        | Flash | 8-bit NOR on the SMI interface (up to 32 MB per chip select) |
        | Video codec | H.264 Main/Baseline L3 and JPEG/MJPEG baseline; large stream up to 60 fps D1 or 240 fps CIF, small stream up to 60 fps CIF; single encode or decode up to 75 fps D1 or 300 fps CIF; simultaneous up to 30 fps D1 or 120 fps CIF; CBR/VBR 16 kbit/s to 20 Mbit/s |
        | Video input (Hi3511) | 4 x BT.656 YCrCb 4:2:2 8-bit (2 of them also BT.601), each can carry 2 multiplexed BT.656 channels; one SMPTE296M 720p 16-bit input; 2 digital camera inputs |
        | Video output | one BT.656 output |
        | Audio | 2 I2S interfaces (SIO), 8/16/32-bit samples, 4-48 kHz, 8 audio channels in per interface |
        | Network | one 10/100 Mbit/s Ethernet MAC (MII; 2 configurable DMAC address filters, flow control) |
        | Other | PCI host/slave bridge (33/66 MHz, up to 5 devices), MMC/SD/SDIO, one USB 2.0 OTG and one USB 1.1 host, I2C, 3 UART, SPI/SSP, IR, up to 8 GPIO groups, 2 dual timers, watchdog, RTC, DES/3DES cipher |
        | Package | 441-pin TFBGA, 19 x 19 mm, 0.8 mm pitch; 0.8 W typical (DVR use); 0.13 um; core 1.2 V, 1.8 V, 3.3 V; -25 to +85 C |

        ### Boot (data sheet 3.3.2)

        Two boot methods: from the SMI controller (asynchronous 8-bit NOR flash; the pin FUNSEL0 is pulled to 0 to select the SMI interface) or from the DDR interface. With SMI boot the NOR chip select maps to address 0 until the remap is cleared. Diagram: boot flow.

        ### Memory map notes (data sheet 3.3.2, Figure 3-3)

        * 32-bit address and data buses, 4 GB space. SMI boot: the NOR flash is mapped at address 0 until the remap is cleared.
        * Peripheral registers sit in the 0x101E0000-0x101FFFFF window (system controller 0x101E0000, timers, WDG, RTC, IR, UARTs, GPIO0-7 in 0x101E4000-0x101FAFFF) and the 0x10000000-0x1013FFFF AHB window (SMI, DMAC 0x10130000, VIC, DDRC, ...); the register-block table lists every base address.
        * The data sheet draws the address spaces as a figure; fixed windows beyond the register blocks (SMI chip selects, DDR, PCI) are in the figure only and are not repeated here.

        ### DMA request lines (data sheet 3.4, Table 3-15; checked against the RDL DMAC description)

        One DMAC (PL080-style, block DMAC at 0x10130000, interrupt 17 on the VIC): 8 channels, 16 request lines.

        | Line | Peripheral | Line | Peripheral |
        |---|---|---|---|
        | 0-1 | Reserved | 8 | SSP RX |
        | 2 | SIO0 RX | 9 | SSP TX |
        | 3 | SIO0 TX | 10-11 | Reserved |
        | 4 | SIO1 RX | 12 | MMC RX |
        | 5 | printed as Reserved (probably SIO1 TX) | 13 | MMC TX |
        | 6-7 | Reserved | 14 | UART0 RX |
        | | | 15 | UART0 TX |

        ### Power, reset and system modes (data sheet 3.1, 3.2)

        * Resets: RSTN to npor, global soft reset from the system controller, per-module soft resets in the system controller (same scheme as the later chips; PCIRSTN for the PCI block).
        * System modes (SC_CTRL): NORMAL, SLOW (crystal), DOZE, SLEEP; ARMPLL on/off by SC_PLLCTRL[0] or by the mode (SC_CTRL[2:0]); ARM frequency mode SC_PERCTRL2[7] arm_hclk_sel. Two crystal inputs: XIN (PLL) and XIN24 (USB 2.0 OTG PHY).
        * The data sheet has no power-domain table.

        ### Clock-gate map (generated from the system controller registers)

        Each peripheral clock has an enable bit in PEREN (SC_PEREN, offset 0x24) and the matching disable bit in PERDIS (SC_PERDIS, offset 0x28); writing 1 to a bit in PEREN enables the clock, writing 1 to the same bit in PERDIS disables it; the state is read back in PERCLKEN (SC_PERCLKEN).

        | Bit | Clock enable field | Gated module |
        |---|---|---|
        | 0 | veduclken | VEDU |
        | 2 | cipherclken | CIPHER |
        | 3 | dsuclken | DSU |
        | 4 | smiclken | SMI |
        | 5 | uart0clken | UART0 |
        | 6 | uart1clken | UART1 |
        | 7 | sspclken | SSP |
        | 8 | irclken | IR |
        | 9 | pciclken | PCI |
        | 10 | mmcclken | MMC |
        | 11 | voclken | VO |
        | 12 | vihclken | VIH |
        | 13 | vi0clken | VI0 |
        | 14 | vi1clken | VI1 |
        | 15 | vi2clken | VI2 |
        | 16 | vi3clken | VI3 |
        | 17 | ethclken | ETH |
        | 18 | sio0clken | SIO0 |
        | 19 | sio1clken | SIO1 |
        | 20 | otgclken | OTG |
        | 21 | usbclken | USB |
        | 22 | uart2clken | UART2 |

        Per-module soft resets and the ARM/IP clock frequency selects are in SC_PERCTRLn / PERIPHCTRLn (see the register pages and the clock tree diagram).

        ### Interrupts (VIC source numbers, data sheet Table 3-13; the data sheet is Chinese, names translated)

        COMMRX and COMMTX are for CPU debug use.

        | # | Source | # | Source | # | Source |
        |---|---|---|---|---|---|
        | 0 | Watchdog | 11 | SSP | 22 | External pin INTRN (multiplexed pin) |
        | 1 | Software interrupt | 12 | UART0 | 23 | USB 2.0 OTG |
        | 2 | COMMRX | 13 | UART1 | 24 | MMC |
        | 3 | COMMTX | 14 | UART2 | 25 | VIU |
        | 4 | Dual-Timer0 | 15 | ETH | 26 | DSU |
        | 5 | Dual-Timer1 | 16 | VOU | 27 | SIO0 |
        | 6 | GPIO0 | 17 | DMAC | 28 | VEDU |
        | 7 | GPIO1 | 18 | SIO1 | 29 | Reserved |
        | 8 | GPIO2-GPIO7 (combined) | 19 | I2C | 30 | PCI |
        | 9 | IR | 20 | USB 1.1 host | 31 | TDE |
        | 10 | RTC | 21 | CIPHER |  |  |

        ### Register blocks (generated from this description)

        | Base | Instance | Block | Register space |
        |---|---|---|---|
        | 0x10100000 | SMI | Static memory interface controller (SMI, PL172-style) | 520 B |
        | 0x10130000 | DMAC | HiSilicon DMA controller (PL080-compatible, 4 or 8 channels) | 512 B |
        | 0x10140000 | VIC | Vectored interrupt controller (ARM PrimeCell PL190) | 4 KB |
        | 0x10150000 | DDRC | DDRC Registers | 184 B |
        | 0x101E0000 | SYS_CTRL | System Controller Registers | 3824 B |
        | 0x101E1000 | WDG | Watchdog Registers | 3076 B |
        | 0x101E2000 | TIMER0 | Timer Registers | 28 B |
        | 0x101E2020 | TIMER1 | Timer Registers | 28 B |
        | 0x101E3000 | TIMER2 | Timer Registers | 28 B |
        | 0x101E3020 | TIMER3 | Timer Registers | 28 B |
        | 0x101E4000 | GPIO0 | ARM PL061 | 1053 B |
        | 0x101E5000 | GPIO1 | ARM PL061 | 1053 B |
        | 0x101E6000 | GPIO2 | ARM PL061 | 1053 B |
        | 0x101E7000 | GPIO3 | ARM PL061 | 1053 B |
        | 0x101E8000 | RTC | RTC (ARM PL031-style 32-bit counter) | 32 B |
        | 0x101E9000 | IR | HiSilicon IR receiver (V1, mode 0 only) | 56 B |
        | 0x101F1000 | UART0 | UART (ARM PrimeCell PL011) | 4 KB |
        | 0x101F2000 | UART1 | UART (ARM PrimeCell PL011) | 4 KB |
        | 0x101F3000 | UART2 | UART (ARM PrimeCell PL011) | 4 KB |
        | 0x101F4000 | SPI | SPI Registers | 40 B |
        | 0x101F6000 | I2C | Synopsys DW_apb_i2c I2C Master/Slave Controller (16-bit, Hi3511/Hi3512/Hi3515/Hi3520 V100) | 148 B |
        | 0x101F7000 | GPIO4 | ARM PL061 | 1053 B |
        | 0x101F8000 | GPIO5 | ARM PL061 | 1053 B |
        | 0x101F9000 | GPIO6 | ARM PL061 | 1053 B |
        | 0x101FA000 | GPIO7 | ARM PL061 | 1053 B |
        | 0x80080000 | SIO0 | HiSilicon SIO V1 (I2S/PCM audio interface, Hi3511/Hi3512) | 196 B |
        | 0x90020000 | MMC | HiSilicon MMC/SD/SDIO controller (DesignWare-MMC based, himciv200) | 260 B |
        | 0x90040000 | CIPHER | CIPHER Registers | 132 B |
        | 0x90080000 | VEDU | HiSilicon VEDU (registers not described) | 64 KB |
        | 0x900A0000 | SIO1 | HiSilicon SIO V1 (I2S/PCM audio interface, Hi3511/Hi3512) | 196 B |
        | 0xA0000000 | USB11_HOST | HiSilicon USB 2.0 host controller - OHCI | 88 B |

        The table is generated from the elaborated root (instances at their absolute addresses; register space is the span of the block's registers, not the data sheet window).

        <!-- overview:end -->
    ";

    eHISI_SMI           SMI             @ 0x10100000;
    eHISI_DMAC          DMAC            @ 0x10130000;
    eARM_PL190          VIC             @ 0x10140000;
    eDDRC               DDRC            @ 0x10150000;
    eSYS_CTRL           SYS_CTRL        @ 0x101E0000;
    eHISI_RTC           RTC             @ 0x101E8000;
    eHISI_WDG_SP805     WDG             @ 0x101E1000;
    eHISI_TIMER_SP804   TIMER0          @ 0x101E2000;
    eHISI_TIMER_SP804   TIMER1          @ 0x101E2020;
    eHISI_TIMER_SP804   TIMER2          @ 0x101E3000;
    eHISI_TIMER_SP804   TIMER3          @ 0x101E3020;
    eARM_PL061          GPIO0           @ 0x101E4000;
    eARM_PL061          GPIO1           @ 0x101E5000;
    eARM_PL061          GPIO2           @ 0x101E6000;
    eARM_PL061          GPIO3           @ 0x101E7000;
    eHISI_IR_V1         IR              @ 0x101E9000;
    eARM_PL011          UART0           @ 0x101F1000;
    eARM_PL011          UART1           @ 0x101F2000;
    eARM_PL011          UART2           @ 0x101F3000;
    eDW_APB_I2C         I2C             @ 0x101F6000;
    eARM_PL061          GPIO4           @ 0x101F7000;
    eARM_PL061          GPIO5           @ 0x101F8000;
    eARM_PL061          GPIO6           @ 0x101F9000;
    eARM_PL061          GPIO7           @ 0x101FA000;
    eHISI_SPI           SPI             @ 0x101F4000;
    eHISI_SIO_V1        SIO0            @ 0x80080000;
    eHISI_DWMMC         MMC             @ 0x90020000;
    eHISI_CIPHER        CIPHER          @ 0x90040000;
    aHISI_VEDU          VEDU            @ 0x90080000;
    eHISI_SIO_V1        SIO1            @ 0x900A0000;
    eHISI_USB_OHCI      USB11_HOST      @ 0xA0000000;
};
