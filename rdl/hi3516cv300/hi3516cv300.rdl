`include "defines.rdl"

`include "CRG.rdl"
`include "MISC_CTRL.rdl"
`include "../common/ARM_PL011.rdl"
`include "../common/ARM_PL061.rdl"
`include "../common/ARM_PL190.rdl"
`include "../common/HISI_AIAO.rdl"
`include "../common/HISI_AUDIO_CODEC.rdl"
`include "../common/HISI_CIPHER_MC.rdl"
`include "../common/HISI_DDRT.rdl"
`include "../common/HISI_DMAC.rdl"
`include "../common/HISI_DWMMC.rdl"
`include "../common/HISI_FEMAC.rdl"
`include "../common/HISI_FMC.rdl"
`include "../common/HISI_HASH.rdl"
`include "../common/HISI_I2C_V2.rdl"
`include "../common/HISI_IR.rdl"
`include "../common/HISI_ISP_CV300.rdl"
`include "../common/HISI_IVE.rdl"
`include "../common/HISI_JPGE.rdl"
`include "../common/HISI_LSADC_V2.rdl"
`include "../common/HISI_DDRC_V2.rdl"
`include "../common/HISI_DDRC_T28_PHY.rdl"
`include "../common/HISI_HPM.rdl"
`include "../common/HISI_MIPI_RX_CV300.rdl"
`include "../common/HISI_OTP_KEY_CTRL.rdl"
`include "../common/HISI_PWM.rdl"
`include "../common/HISI_RSA.rdl"
`include "../common/HISI_RTC_SPI.rdl"
`include "../common/HISI_RTC_SPI_V3.rdl"
`include "../common/HISI_SPI.rdl"
`include "../common/HISI_SPI_3WIRE.rdl"
`include "../common/HISI_SYS_CTRL.rdl"
`include "../common/HISI_TIMER_SP804.rdl"
`include "../common/HISI_TRNG.rdl"
`include "../common/HISI_USB_DEVICE.rdl"
`include "../common/HISI_USB_HOST.rdl"
`include "../common/HISI_VEDU_V2.rdl"
`include "../common/HISI_VPSS_V2.rdl"
`include "../common/HISI_POWER_CTRL.rdl"
`include "../common/HISI_IO_CONFIG_CV300.rdl"
`include "../common/HISI_VICAP_CV300.rdl"
`include "../common/HISI_VDP_CV300.rdl"
`include "../common/HISI_WDG_SP805.rdl"

addrmap hi3516cv300 {
    name = "hi3516cv300 registers";
    desc = "
        ## Datasheets

        * [Full Datasheet Hi3516CV300](assets/Hi3516CV300-Datasheet.pdf)
        * [Full Datasheet Hi3516CV300 and Hi3516EV100](assets/Hi3516CV300-Hi3516EV100-Datasheet.pdf)

        ## Diagrams

        ![Application Block Diagram](assets/Hi3516CV300-Application-Block-Diagram.png)
        ![Logic Block Diagram](assets/Hi3516CV300-Logic-Block-Diagram.png)

        <!-- overview:begin -->

        ### Diagrams

        ![Logic block diagram](assets/diagrams/hi3516cv300-logic.svg)

        ![Register blocks by function](assets/diagrams/hi3516cv300-blocks.svg)

        ![Clock tree](assets/diagrams/hi3516cv300-clocks.svg)

        ![Boot flow](assets/diagrams/hi3516cv300-boot.svg)

        ![Video pipeline](assets/diagrams/hi3516cv300-video.svg)

        ![Interrupt topology](assets/diagrams/hi3516cv300-irq.svg)

        ![Reset tree](assets/diagrams/hi3516cv300-resets.svg)

        ![Storage, USB and Ethernet paths](assets/diagrams/hi3516cv300-io.svg)

        ![DMA request lines](assets/diagrams/hi3516cv300-dma.svg)

        ![Bus masters and DDR QoS groups](assets/diagrams/hi3516cv300-busqos.svg)

        ![Power domains](assets/diagrams/hi3516cv300-power.svg)

        ![CRG register map](assets/diagrams/hi3516cv300-crgmap.svg)

        ![IP editions across the camera family](assets/diagrams/hi3516cv300-editions.svg)

        ### Camera family comparison (data sheet chapter 1)

        One column per chip, taken from the data sheets named in the header row below; `-` = the sheet gives no value. The Hi3518 sheet covers the A and C variants; the Hi3518E V200 sheet covers V200, V201 and Hi3516C V200.

        | Item | Hi3516 V100 | Hi3516C V100 | Hi3518A V100 | Hi3518C V100 | Hi3518E V100 | Hi3516C V300 | Hi3516E V100 | Hi3518E V200 | Hi3518E V201 | Hi3516C V200 |
        |---|---|---|---|---|---|---|---|---|---|---|
        | Data sheet (issue, date, language) | 00B60 2011-08-12, Chinese | 00B02 2013-02-05 | Hi3518 sheet (A and C in one document) | same document as A | 03 2015-11-26 | 05 2018-05-10 (C V300 and E V100 in one document) | same document as C V300 | 02 2017-06-12 (one document for V200, V201, Hi3516C V200) | same document | same document |
        | CPU | Cortex-A9 up to 800 MHz, VFP, 32 KB I + 32 KB D L1, 256 KB L2, about 2000 DMIPS | ARM926 up to 440 MHz, 16 KB I + 16 KB D, 2 KB ITCM | ARM926 up to 440 MHz, 16 KB I + 16 KB D, 2 KB ITCM | ARM926 up to 440 MHz, 16 KB I + 16 KB D, 2 KB ITCM | ARM926 up to 440 MHz, 16 KB I + 16 KB D | ARM926 up to 800 MHz, 32 KB I + 32 KB D | ARM926 up to 800 MHz, 32 KB I + 32 KB D | ARM926 540 MHz, 32 KB I + 32 KB D | ARM926 540 MHz, 32 KB I + 32 KB D | ARM926 600 MHz, 32 KB I + 32 KB D |
        | Interrupt controller | ARM GIC (A9 MPCore), IDs 0-31 internal | PL190 VIC | PL190 VIC | PL190 VIC | PL190 VIC | PL190 VIC | PL190 VIC | PL190 VIC | PL190 VIC | PL190 VIC |
        | DDR | DDR2/DDR3, 32 or 16 bit, up to 500 MHz, 1 GB (32 bit) / 512 MB (16 bit) | DDR2/DDR3, 16 bit, up to 440 MHz, up to 256 MB | DDR2/DDR3, 16 bit, up to 400 MHz, up to 256 MB | DDR2/DDR3, 16 bit, up to 400 MHz, up to 128 MB | embedded 16-bit DDR2, up to 512 Mbit | external 16-bit DDR3/DDR3L, up to 4 Gbit | embedded 512 Mbit DDR (1.8 V) | embedded 16-bit DDR2 512 Mbit, 360 MHz | embedded 16-bit DDR2 256 Mbit, 360 MHz | external 16-bit DDR2/DDR3/DDR3L, up to 4 Gbit, 400 MHz |
        | Boot media | NAND, SPI flash, or PCIe load into DDR | SPI NOR, NAND | SPI NOR, NAND | SPI NOR only | SPI NOR only | SPI NOR/NAND, eMMC (4-bit), serial (fastboot), SD/USB update | same as C V300 (SPI NOR/NAND, eMMC, fastboot, update) | serial (BOOTROM), SPI NOR/NAND, eMMC | same as V200 | same as V200 |
        | Flash controllers | NANDC (2 CS), SFC (2 CS) | SFC (1 CS), NANDC | SFC (1 CS), NANDC | SFC (1 CS) | SFC (1 CS) | FMC (SPI NOR/NAND), eMMC via MMC | FMC, eMMC via MMC | FMC, eMMC | FMC, eMMC | FMC, eMMC |
        | Video encoder | H.264 BP/MP/HP, MPEG4 SP, JPEG; up to 16 Mpixel | H.264 BP/MP, MJPEG/JPEG; 1080p@30 + VGA@30 + JPEG 1080p@1 | H.264 BP/MP, MJPEG/JPEG; 720p@30 + VGA@30 + QVGA@30 + JPEG 720p@1 | H.264 BP/MP, MJPEG/JPEG; 720p@30 + QVGA@30 + JPEG 720p@1 | H.264 BP/MP, MJPEG/JPEG; 720p@25 + JPEG 720p@3 | H.264 BP/MP/HP, H.265 Main, MJPEG/JPEG; 2048x2048@15 + 640x640@15, or 1080p@30 + 480p@30 + 240p@30 | same codecs; 1536x1536 (width up to 2048); 1080p@20 + 576p@20 | H.264 BP/MP/HP, MJPEG/JPEG; 1080p@20 | H.264 BP/MP/HP, MJPEG/JPEG; 960p@25 (no LDC, no 90/270 rotation) | H.264 BP/MP/HP, MJPEG/JPEG; 1080p@30 |
        | Video in | 8-16 bit RGB Bayer up to 150 MHz, BT.601/656/1120, dual sensor | 8/10/12-bit Bayer up to 74.25 MHz, BT.656/BT.1120 | 8/10/12-bit Bayer up to 74.25 MHz, BT.656/BT.1120 | 8/10/12-bit Bayer up to 74.25 MHz, BT.656/BT.1120 | 8/10/12-bit Bayer up to 74.25 MHz, BT.656/BT.1120, 1080p@30 / 720p@30 | 8-14 bit Bayer DC, BT.601/656/1120, MIPI, LVDS/sub-LVDS, HiSPi, up to 2048x2048 and 250 Mpixel/s | same as C V300 | MIPI / LVDS / HiSPi / BT.656 (VICAP) | same as V200 | same as V200, plus differential and single-ended pin modes |
        | Video out | CVBS, BT.656, BT.1120 (1080p@30) | CVBS, BT.1120 (1080p@30) | CVBS, BT.1120 | BT.1120 (no CVBS) | BT.1120 (no CVBS) | PAL/NTSC CVBS, BT.656, 6-bit RGB565 LCD | BT.656, RGB565 LCD (no CVBS) | - | - | - |
        | Ethernet | GMAC 10/100/1000, RGMII/MII | MAC 10/100, RGMII/MII | MAC 10/100, RGMII/MII | MAC 10/100, RGMII/MII | MAC 10/100, RMII/MII | MAC 10/100 RMII, TSO | MAC 10/100 RMII, TSO | MAC + internal FE PHY | MAC + internal FE PHY | MAC + internal FE PHY |
        | USB | 2 x USB 2.0 host | 1 x USB 2.0 host | 1 x USB 2.0 host | 1 x USB 2.0 host | 1 x USB 2.0 host | 1 x USB 2.0 host/device | 1 x USB 2.0 host/device | USB 2.0 host/device | USB 2.0 host/device | USB 2.0 host/device |
        | SDIO/MMC | 2 x MMC (SD/SDIO/eMMC) | 1 x SDIO 2.0 | 1 x SDIO 2.0 | 1 x SDIO 2.0 | 1 x SDIO 2.0 | 3 x SDIO 2.0 (two with 3.3/1.8 V) + eMMC 4.5 | 3 x SDIO 2.0 + eMMC 4.5 | 2 x SDIO + eMMC | 2 x SDIO + eMMC | 2 x SDIO + eMMC |
        | Package | FC-CSP 416, 15x15 mm, 0.65 mm | FCBGA 293, 13x13x1.37 mm, 0.65 mm | FCBGA 293, 13x13x1.37 mm, 0.65 mm | ePad QFP, 20x20x1.0 mm, 0.4 mm | BGA 220, 11x11 mm, 0.65 mm | TFBGA 273, 12x12 mm, 0.65 mm | TFBGA 231, 10x14 mm, 0.65 mm | TFBGA 192, 10x10 mm | TFBGA 192, 10x10 mm | TFBGA 273, 12x12 mm |
        | Typical power | 1200 mW | 850 mW | 700 mW | 700 mW (one value for the Hi3518 sheet) | 900 mW | 550 mW (1080p30) | 600 mW (1080p20) | - | - | - |
        | Core / DDR voltage | 1.0 V core; 1.8/1.5 V DDR; 2.5 V, 3.3 V | 1.2 V; 1.5/1.8 V DDR; 3.3 V I/O | 1.2 V; 1.5/1.8 V DDR; 3.3 V I/O | 1.2 V; 1.5/1.8 V DDR; 3.3 V I/O | 1.2 V; 1.8 V embedded DDR; 3.3 V I/O | 0.9 V; 1.5/1.35 V DDR; 3.3 V I/O | 0.9 V; 1.8 V DDR; 3.3 V I/O | - | - | - |
        | Chip ID (SC_SYSID) | 0x3516_0100 | 0x3518_0100 (as printed in the sheet) | 0x3518_0100 | 0x3518_0100 | 0x3518_0100 (as printed) | 0x3516_C300 | 0x3516_C300 (one value printed for both) | 0x3518E200, SCSYSID0[31:24] = 0x02 | 0x3518E200, [31:24] = 0x03 | 0x3518E200, [31:24] = 0x01 |
        | SDK kernel | - | Linux 3.0.y | Linux 3.0.y | Linux 3.0.y | Linux 3.0.y | Linux 3.18 | Linux 3.18 | - | - | - |

        Differences the data sheets state: the Hi3518C has no NAND controller, no CVBS output, no 90/270 degree rotation, no autofocus, two UARTs, no SSP/IR and 128 MB maximum DDR; the Hi3516C V100 is the Hi3518A with 1080p encoding; the Hi3518E V100 is a 720p part with embedded DDR2 and no NAND controller; the Hi3516E V100 differs from the Hi3516C V300 by embedded 512 Mbit DDR, a 231-pin package, no CVBS output, no two-frame WDR and the lower encoder limit; the Hi3518E V200/V201/Hi3516C V200 differ in CPU speed, DDR, package and encoder performance (table in the root description above).

        Chip: Hi3516C V300 (Hi3516C V300 / Hi3516E V100 data sheet, issue 05 (2018-05-10), chapter 1).

        ### Boot selection (data sheet 1.3 / 1.4)

        | Strap | Boot medium |
        |---|---|
        | BOOT_SEL1 (MDCK) = 0, BOOT_SEL0 (EPHY_RSTN) = 0 | SPI NOR/NAND on the FMC; SFC_DEVICE_MODE (SENSOR_RSTN) / SFC_BOOT_MODE (SFC_CLK): 00 NOR 3-byte, 01 NOR 4-byte, 10 NAND 1-line, 11 NAND 4-line |
        | BOOT_SEL1 = 0, BOOT_SEL0 = 1 | eMMC (4-bit only on the Hi3516C V300) |
        | BOOT_SEL1 = 1, BOOT_SEL0 = 0 or 1 | fastboot (serial download, UART); on timeout the chip jumps to SPI flash (BOOT_SEL0 = 0) or eMMC (BOOT_SEL0 = 1) |
        | UPDATE_MODE (GPIO0_3) = 0 | U-Boot update from an SD card or the USB port (BOOT_SEL0 = 0 updates SPI flash, 1 updates eMMC) |

        ### Memory map notes

        * 0x00000000-0x03FFFFFF: during remap the start address space is deasserted, after remap it points to the on-chip RAM (Table 1-3). BOOTROM at 0x04000000 (64 KB window, 32 KB real), on-chip RAM at 0x04010000 (64 KB window, 32 KB real; the sheet repeats the word BOOTROM in the RAM row, a typo).
        * Register windows: FMC 0x10000000, DMAC 0x10030000, VIC 0x10040000, ETH 0x10050000, Cipher 0x10080000, HASH 0x10090000, MMC0-3 0x100C0000-0x100F0000, USB OHCI/EHCI/device 0x10110000/0x10120000/0x10130000, I/O multiplexing 0x12040000.

        ### DMA request lines (data sheet Table 3-12, DMAC at 0x10030000)

        | Req | Peripheral | Req | Peripheral | Req | Peripheral | Req | Peripheral |
        |---|---|---|---|---|---|---|---|
        | 0 | I2C0 RX | 4 | I2C1 RX | 8 | UART1 RX | 12 | SSP0 RX |
        | 1 | I2C0 TX | 5 | I2C1 TX | 9 | UART1 TX | 13 | SSP0 TX |
        | 2 | Reserved | 6 | UART0 RX | 10 | UART2 RX | 14 | SSP1 RX |
        | 3 | Reserved | 7 | UART0 TX | 11 | UART2 TX | 15 | SSP1 TX |

        Channel 0 has the highest priority and channel 3 the lowest, as in the V100 family sheets. The sheet text example (UART0 RX as request 5) disagrees with the table (UART0 RX is 6); the table is used here.

        ### Pin multiplexing summary (generated from the IO_CONFIG registers)

        66 one-per-pin `muxctrl_regN` registers. Alternate functions per interface, as named in the register enumerations (GPIO is always one of the choices); 38 pins have no alternate function other than GPIO. Per-pin choices are in the IO_CONFIG register pages.

        | Interface | Functions |
        |---|---|
        | Video input (VI / VIU) | VI_DATA9-15, VI_HS, VI_VS |
        | Video output (VO / LCD) | LCD_CLK, LCD_DATA0-5, LCD_DE, LCD_HSYNC, LCD_VSYNC, VOU656_CLK, VOU656_DATA0-7 |
        | Sensor control | FLASH_TRIG, SENSOR_CLK, SENSOR_RSTN, SHUTTER_TRIG, SPI_3LINE_CSN, SPI_3LINE_SCLK, SPI_3LINE_SDATA |
        | SPI / SSP | SPI0_CSN, SPI0_SCLK, SPI0_SDI, SPI0_SDO, SPI1_CSN0, SPI1_CSN1, SPI1_SCLK, SPI1_SDI, SPI1_SDO |
        | I2C | I2C0_SCL, I2C0_SDA, I2C1_SCL, I2C1_SDA |
        | Audio (I2S / SIO) | I2S_BCLK_TX, I2S_MCLK, I2S_SD_RX, I2S_SD_TX, I2S_WS_TX |
        | PWM | pwm_pmux |

        The Hi3516C V300 / Hi3516E V100 data sheet has no IO register table (only the Table 1-1 memory-map row): the mux functions above come from the vendor device tree (INFERRED provenance, see the register block description).

        ### Clocks (data sheet 3.2, Tables 3-2 to 3-4)

        XIN is the PLL input (24 MHz crystal), RTC_XIN the RTC clock (32.768 kHz). Three PLLs, two configuration registers each: APLL PERI_CRG_PLL0/1 (programmable), VPLL PERI_CRG_PLL4/5 and EPLL PERI_CRG_PLL8/9 (fixed). FOUTVCO = 24 MHz x (fbdiv + frac/2^24) / refdiv, must be above 800 MHz and at most 2.3 GHz; FOUTPOSTDIV = FOUTVCO / (pstdiv1 x pstdiv2); FOUT1ph0 .. FOUT4 = FOUTPOSTDIV-style divides by 2, 4, 6, 8. All clocks default to the 24 MHz crystal after reset where noted below.

        | Module | Default | Selectable (Table 3-2) |
        |---|---|---|
        | ARM9 | 24 MHz | 24 MHz, APLL POSTDIV, APLL FOUTVCO/2, 594 MHz |
        | DDR controller | 24 MHz | 24 MHz, APLL FOUTPOSTDIV divided, 250 MHz, 198 MHz |
        | SYS APB | 24 MHz | 24, 50 MHz |
        | ISP | 83.3 MHz | VICAP clock or VICAP / 2 |
        | VICAP | 83.3 MHz | 83.3, 125, 148.5, 198 MHz |
        | VDP clock out | 27 MHz | 74.25, 27 MHz, LCD clock |
        | VPSS | 148.5 MHz | offline: 148.5, 198, 250 MHz; online: VICAP or VICAP / 2 |
        | VEDU | 166.6 MHz | 166.6, 198 MHz |
        | VGS | 198 MHz | 198, 250, 297, 396 MHz |
        | AIAO | 1188 MHz | 1188 MHz (actual clock is a divided value) |
        | IVE | 198 MHz | 198, 250, 297 MHz |
        | JPGE, GZIP | 198 MHz | 198 MHz |
        | FMC | 24 MHz | 24, 83.3, 148.5, 198, 297 MHz |
        | Sensor clock | 74.25 MHz | 74.25, 37.125, 54, 27, 24, 25 MHz |

        Timer count clocks: SC_CTRL timeren0ov/1ov/2ov/3ov (bits 16, 18, 20, 22): reference clock (0) or bus clock (1). Clock gates and per-IP selects are in the CRG gate map above.

        ### Reset and power

        * Reset sources (data sheet 3.1): the internal POR module only (no reset pin selection), the watchdog reset, and the global soft reset (sys_rst_req, deasserts after at least 64 ms, excludes clock/test circuits and registers without soft reset); per-module soft resets from the CRG as on the older chips.
        * Power controller (data sheet 3.10): the power controller (PC) and RTC form the always-on area; PWR_SEQ0/1/2 switch the external supplies (DC/DC, SDIO Wi-Fi/BT/4G module) with configurable timing, triggered by PWR_WAKEUP, PWR_BUTTON (low for 2 s powers on, 10 s forces power off) or the RTC alarm; the PC runs from the 32.768 kHz RTC clock, so AVDD_BAT and the RTC crystal must be present; the PC reset pulse must be at least 0.3 ms. Standby current is at the microamp level. Other low-power means: clock gating, per-module low power, DDR self-refresh, adaptive voltage scaling.

        ### Bus ports (system controller registers)

        | Bus | Masters | Slaves |
        |---|---|---|
        | SYS AXI | CPU (M1), AHB master 0 (M2), AHB master 1 (M3), AHB master 2 (M4) | S1 AHB_SUBSYS, S2 SYS APB, S3 media APB, S4 MDDRC |
        | media AXI | VGS (M1), IVE (M2), JPGE (M3), DDRT / GZIP (M4) | (towards DDR) |
        | VIVO AXI | VICAP (M1), AIAO (M2), VDP (M3) | (towards DDR) |

        Source: MISC_CTRL5-22 (SYS bus, media bus, VIVO bus timeout and priority registers). The data sheets name only the bus master ports of the registers; which peripheral sits behind each AHB master port is not stated (the SYS AXI masters are arbitrated at the MDDRC slave port s4).

        ### Interrupts (ARM926 VIC source numbers, data sheet Table 3-8)

        | # | Source | # | Source | # | Source |
        |---|---|---|---|---|---|
        | 0 | Global soft interrupt | 11 | FMC/eMMC | 22 | VICAP |
        | 1 | WatchDog | 12 | ETH | 23 | VDP |
        | 2 | RTC | 13 | CIPHER | 24 | VEDU |
        | 3 | Timer0/Timer1 | 14 | DMAC | 25 | UART2 |
        | 4 | Timer2/Timer3 | 15 | USB_EHCI | 26 | JPGE |
        | 5 | UART0 | 16 | USB_OHCI | 27 | SDIO1/SDIO2 |
        | 6 | SSP0 | 17 | VPSS | 28 | MIPI |
        | 7 | SSP1 | 18 | SDIO0 | 29 | VGS |
        | 8 | GZIP/DDRT | 19 | IR/LSADC | 30 | UART1 |
        | 9 | AIAO | 20 | I2C0/I2C1 | 31 | GPIO0−GPIO8 |
        | 10 | USB_DEVICE | 21 | IVE |  |  |

        ### Clock-gate and reset map (generated from the CRG registers)

        | Offset | Register | Description | Gate / reset fields |
        |---|---|---|---|
        | 0x028 | PERI_CRG10 | ARM9 frequency mode and reset configuration register | arm_core_srst_req |
        | 0x02C | PERI_CRG11 | VICAP/MIPI CTRL and sensor clock and reset configuration register | vi0_cken, vi0_srst_req, vi_hrst_req, vi_ch0_srst_req, mipi_srst_req, isp_core_srst_req, isp_cfg_srst_req, mipi_cken, mipi_core_srst_req, isp_cken, ... |
        | 0x034 | PERI_CRG13 | VDP clock and reset control register | vo_srst_req, vou_cfg_cken, vou_ppc_cken, vou_pcken, vo_out_cken, vou_acken, vou_hd_cken, vou_sd_cken, lcd_cken, dac_cken |
        | 0x038 | PERI_CRG14 | PWM clock and reset control register | pwm_srst_req, pwm_cken |
        | 0x040 | PERI_CRG16 | VEDU clock and soft reset control register | vedu_srst_req, vedu_cken |
        | 0x048 | PERI_CRG18 | VPSS clock and reset control register | vps_srst_req, vps_cken |
        | 0x05C | PERI_CRG23 | VGS clock and soft reset control register | vgs_srst_req, vgs_cken |
        | 0x060 | PERI_CRG24 | JPGE clock and soft reset control register | jpge_srst_req, jpge_cken |
        | 0x06C | PERI_CRG27 | IVE&HASH clock and soft reset control register | ive_srst_req, ive_cken, hash_srst_req, hash_cken |
        | 0x07C | PERI_CRG31 | LSADC & cipher clock and soft reset control register | cipher_srst_req, cipher_cken, sar_adc_srst_req |
        | 0x08C | PERI_CRG35 | AIAO clock and soft reset control register | aiao_srst_req, aiao_cken |
        | 0x0B8 | PERI_CRG46 | USB2.0 clock and soft reset control register | usb2_bus_cken, usb2_ohci48m_cken, usb2_ohci12m_cken, usb2_otg_utmi_cken, usb2_hst_phy_cken, usb2_utmi0_cken, usb2_phy_cken, usb2_bus_srst_req, usb2_utmi0_srst_req, usb2_hst_phy_srst_req, ... |
        | 0x0C0 | PERI_CRG48 | FMC clock and soft reset control register | fmc_srst_req, fmc_cken |
        | 0x0C4 | PERI_CRG49 | EMMC/SDIO0/SDIO1 clock and soft reset control register | sdio0_srst_req, sdio0_cken, sdio1_srst_req, sdio1_cken, emmc_srst_req, emmc_cken |
        | 0x0C8 | PERI_CRG50 | SDIO2 clock and soft reset control register | sdio2_srst_req, sdio2_cken |
        | 0x0D4 | PERI_CRG53 | GZIP clock and soft reset control register | gzip_cken, gzip_acken, gzip_pcken, gzip_srst_req |
        | 0x0D8 | PERI_CRG54 | DMAC/DDR TEST clock and soft reset control register | ddrtest_srst_req, ddrtest_cken, dmac_srst_req, dmac_cken |
        | 0x0E0 | PERI_CRG_PLL56 | GZIP reset status register | gzip_rst_ok |
        | 0x0E4 | PERI_CRG57 | Soft reset control register for other CRG interface modules | test_clk_en, rtc_srst_req, ir_srst_req, ssp0_srst_req, ssp1_srst_req, uart0_srst_req, uart1_srst_req, uart2_srst_req, ir_cken, ssp0_cken, ... |
        | 0x0EC | PERI_CRG59 | ETH clock and soft reset control register | hrst_eth_s, eth_cken, ext_fephy_srst_req |
        | 0x100 | PERI_CRG64 | RSA clock and soft reset control register | klad_srst_req, klad_cken, trng_srst_req, trng_cken, rsa_srst_req, rsa_cken |
        | 0x108 | PERI_CRG66 | APLL spread spectrum configuration register | apll_ssmod_cken, apll_ssmod_rst_req |
        | 0x110 | PERI_CRG68 | VPLL spread spectrum configuration register | vpll_ssmod_cken, vpll_ssmod_rst_req |
        | 0x118 | PERI_CRG70 | EPLL spread spectrum configuration register | epll_ssmod_cken, epll_ssmod_rst_req |

        Only fields whose names contain a clock-enable or reset keyword are listed; the field descriptions in the register pages give the polarity and the clocks they gate.

        ### Register blocks (generated from this description)

        | Base | Instance | Block | Register space |
        |---|---|---|---|
        | 0x10000000 | FMC | HiSilicon flash memory controller v100 (SPI NOR / SPI NAND) | 224 B |
        | 0x10030000 | DMAC | HiSilicon DMA controller (PL080-compatible, 4 or 8 channels) | 384 B |
        | 0x10040000 | VIC | Vectored interrupt controller (ARM PrimeCell PL190) | 4 KB |
        | 0x10050000 | ETH | HiSilicon femac v2 Fast Ethernet MAC with MDIO | 5184 B |
        | 0x10080000 | CIPHER | CIPHER (8 channels) | 5184 B |
        | 0x10090000 | HASH | HASH (SHA1 / SHA256 / HMAC) | 176 B |
        | 0x100C0000 | MMC0 | HiSilicon MMC/SD/SDIO controller (DesignWare-MMC based, himciv200) | 516 B |
        | 0x100D0000 | MMC1 | HiSilicon MMC/SD/SDIO controller (DesignWare-MMC based, himciv200) | 516 B |
        | 0x100E0000 | MMC2 | HiSilicon MMC/SD/SDIO controller (DesignWare-MMC based, himciv200) | 516 B |
        | 0x100F0000 | MMC3 | HiSilicon MMC/SD/SDIO controller (DesignWare-MMC based, himciv200) | 516 B |
        | 0x10110000 | OHCI | HiSilicon USB 2.0 host controller - OHCI | 88 B |
        | 0x10120000 | EHCI | HiSilicon USB 2.0 host controller - EHCI | 176 B |
        | 0x10130000 | USB_DEV | HiSilicon USB 2.0 device controller (DesignWare DWC_otg, device mode) | 3328 B |
        | 0x11200000 | DDRT | HiSilicon DDR test module | 132 B |
        | 0x11220000 | JPGE | HiSilicon JPEG encoder (JPGE, r004 register layout) | 4288 B |
        | 0x11230000 | IVE | HiSilicon intelligent video engine | 140 B |
        | 0x11240000 | VGS | VPSS / VGS job control registers (Hi3516C V300 / Hi3516E V100) | 792 B |
        | 0x11250000 | VPSS | VPSS / VGS job control registers (Hi3516C V300 / Hi3516E V100) | 792 B |
        | 0x11260000 | VEDU | HiSilicon VEDU, H.265/H.264 generation V2 (control registers, vendor-derived) | 3128 B |
        | 0x11300000 | MIPI | MIPI RX (sensor serial interface receiver, Hi3516C V300 / Hi3516E V100) | 5884 B |
        | 0x11310000 | AIAO | AIAO (audio input/output) | 8368 B |
        | 0x11320000 | ACODEC | Internal audio CODEC (Hi3516C V300 / Hi3516E V100) | 228 B |
        | 0x11380000 | VICAP | VICAP (video capture, Hi3516C V300 / Hi3516E V100) | 8444 B |
        | 0x11390000 | ISP | ISP (image signal processor, Hi3516C V300 / Hi3516E V100) | 269416 B |
        | 0x11400000 | VDP | VDP (video display processor, Hi3516C V300 / Hi3516E V100) | 62272 B |
        | 0x12000000 | TIMER0 | Timer Registers | 28 B |
        | 0x12000020 | TIMER1 | Timer Registers | 28 B |
        | 0x12001000 | TIMER2 | Timer Registers | 28 B |
        | 0x12001020 | TIMER3 | Timer Registers | 28 B |
        | 0x12010000 | CRG | Clock and reset generator (CRG), Hi3516C V300 / Hi3516E V100 | 284 B |
        | 0x12020000 | SYS_CTRL | System Controller Registers | 3824 B |
        | 0x12030000 | MISC_CTRL | Miscellaneous control (MISC_CTRL), Hi3516C V300 / Hi3516E V100 | 192 B |
        | 0x12040000 | IO_CONFIG | IO configuration: pin multiplexing (0x0..0x104) and pad control (0x800..0x92F), Hi3516C V300 / Hi3516E V100 | 2352 B |
        | 0x12060000 | DDRC | HiSilicon DDRC V2 (DDR2/DDR3 controller and DDR PHY, Hi3518E V20X / Hi3516C V200 / Hi3516A/D V100 / Hi3516C V300) | 5312 B |
        | 0x12068000 | DDR_PHY | DDR PHY, 28 nm T28 generation (Hi3516C V300 / Hi3516E V100) | 4212 B |
        | 0x12070800 | OTP_KEY_CTRL | OTP key control (key ladder) | 48 B |
        | 0x12078000 | HPM | HPM (hardware performance monitor, speed binning), Hi3516C V300 / Hi3516E V100 | 24 B |
        | 0x12080000 | WDG | Watchdog Registers | 3076 B |
        | 0x12090000 | RTC | HiSilicon SPI-bridged RTC (APB registers) | 164 B |
        | 0x12098000 | PWR | Power controller (always-on domain, Hi3516C V300 / Hi3516E V100) | 16 B |
        | 0x120B0000 | RSA | RSA (SEC_RSA modular exponentiation engine) | 120 B |
        | 0x120C0000 | TRNG | HISEC_TRNG_CTRL (true random number generator) | 540 B |
        | 0x120E0000 | LSADC | HiSilicon LSADC controller, 10-bit generation (2-3 channels) | 56 B |
        | 0x120F0000 | IR | HiSilicon IR receiver | 56 B |
        | 0x12100000 | UART0 | UART (ARM PrimeCell PL011) | 4 KB |
        | 0x12101000 | UART1 | UART (ARM PrimeCell PL011) | 4 KB |
        | 0x12102000 | UART2 | UART (ARM PrimeCell PL011) | 4 KB |
        | 0x12110000 | I2C0 | HiSilicon I2C Master Controller V2 (command-FIFO, timing-command sequencer) | 236 B |
        | 0x12112000 | I2C1 | HiSilicon I2C Master Controller V2 (command-FIFO, timing-command sequencer) | 236 B |
        | 0x12120000 | SPI0 | SPI Registers | 48 B |
        | 0x12121000 | SPI1 | SPI Registers | 48 B |
        | 0x12122000 | SPI_3WIRE | 3-wire SPI master (sensor control, spi_3wire) | 12 B |
        | 0x12130000 | PWM | HiSilicon PWM group | 128 B |
        | 0x12140000 | GPIO0 | ARM PL061 | 1053 B |
        | 0x12141000 | GPIO1 | ARM PL061 | 1053 B |
        | 0x12142000 | GPIO2 | ARM PL061 | 1053 B |
        | 0x12143000 | GPIO3 | ARM PL061 | 1053 B |
        | 0x12144000 | GPIO4 | ARM PL061 | 1053 B |
        | 0x12145000 | GPIO5 | ARM PL061 | 1053 B |
        | 0x12146000 | GPIO6 | ARM PL061 | 1053 B |
        | 0x12147000 | GPIO7 | ARM PL061 | 1053 B |
        | 0x12148000 | GPIO8 | ARM PL061 | 1053 B |

        The table is generated from the elaborated root (instances at their absolute addresses; register space is the span of the block's registers, not the data sheet window).

        <!-- overview:end -->
    ";

    eHISI_FMC           FMC             @ 0x10000000;
    eHISI_DMAC          DMAC            @ 0x10030000;
    eARM_PL190          VIC             @ 0x10040000;
    eHISI_FEMAC         ETH             @ 0x10050000;
    eHISI_CIPHER_MC     CIPHER          @ 0x10080000;
    eHISI_HASH          HASH            @ 0x10090000;
    eHISI_DWMMC         MMC0            @ 0x100C0000;
    eHISI_DWMMC         MMC1            @ 0x100D0000;
    eHISI_DWMMC         MMC2            @ 0x100E0000;
    eHISI_DWMMC         MMC3            @ 0x100F0000;
    eHISI_USB_OHCI      OHCI            @ 0x10110000;
    eHISI_USB_EHCI      EHCI            @ 0x10120000;
    eHISI_USB_DEVICE    USB_DEV         @ 0x10130000;
    eHISI_DDRT          DDRT            @ 0x11200000;
    eHISI_JPGE          JPGE            @ 0x11220000;
    eHISI_IVE           IVE             @ 0x11230000;
    eHISI_VPSS_V2      VPSS            @ 0x11250000;
    aHISI_VEDU_V2       VEDU            @ 0x11260000;
    eHISI_VPSS_V2      VGS             @ 0x11240000;
    eHISI_MIPI_RX_CV300 MIPI            @ 0x11300000;
    eHISI_AIAO          AIAO            @ 0x11310000;
    eHISI_AUDIO_CODEC   ACODEC          @ 0x11320000;
    eHISI_VICAP_CV300   VICAP           @ 0x11380000;
    eHISI_ISP_CV300     ISP             @ 0x11390000;
    eHISI_VDP_CV300     VDP             @ 0x11400000;
    eHISI_POWER_CTRL    PWR             @ 0x12098000;
    eHISI_IO_CONFIG_CV300 IO_CONFIG     @ 0x12040000;
    eCRG                CRG             @ 0x12010000;
    eMISC_CTRL          MISC_CTRL       @ 0x12030000;
    eHISI_DDRC_V2       DDRC            @ 0x12060000;
    eHISI_DDRC_T28_PHY  DDR_PHY         @ 0x12068000;
    eHISI_HPM           HPM             @ 0x12078000;
    eHISI_OTP_KEY_CTRL  OTP_KEY_CTRL    @ 0x12070800;
    eHISI_RTC_SPI       RTC             @ 0x12090000;
    eHISI_RSA           RSA             @ 0x120B0000;
    eHISI_TRNG          TRNG            @ 0x120C0000;
    eHISI_LSADC_V2      LSADC           @ 0x120E0000;
    eHISI_IR            IR              @ 0x120F0000;
    eHISI_I2C_V2        I2C0            @ 0x12110000;
    eHISI_I2C_V2        I2C1            @ 0x12112000;
    eARM_PL011          UART0           @ 0x12100000;
    eARM_PL011          UART1           @ 0x12101000;
    eARM_PL011          UART2           @ 0x12102000;
    eHISI_SPI           SPI0            @ 0x12120000;
    eHISI_SPI           SPI1            @ 0x12121000;
    eHISI_SPI_3WIRE     SPI_3WIRE       @ 0x12122000;
    eHISI_PWM_GRP       PWM             @ 0x12130000;
    eARM_PL061          GPIO0           @ 0x12140000;
    eARM_PL061          GPIO1           @ 0x12141000;
    eARM_PL061          GPIO2           @ 0x12142000;
    eARM_PL061          GPIO3           @ 0x12143000;
    eARM_PL061          GPIO4           @ 0x12144000;
    eARM_PL061          GPIO5           @ 0x12145000;
    eARM_PL061          GPIO6           @ 0x12146000;
    eARM_PL061          GPIO7           @ 0x12147000;
    eARM_PL061          GPIO8           @ 0x12148000;
    eHISI_TIMER_SP804   TIMER0          @ 0x12000000;
    eHISI_TIMER_SP804   TIMER1          @ 0x12000020;
    eHISI_TIMER_SP804   TIMER2          @ 0x12001000;
    eHISI_TIMER_SP804   TIMER3          @ 0x12001020;
    eHISI_WDG_SP805     WDG             @ 0x12080000;
    eSYS_CTRL           SYS_CTRL        @ 0x12020000;
};

