`include "defines.rdl"

`include "CRG.rdl"
`include "MISC_CTRL.rdl"
`include "../common/ARM_PL011.rdl"
`include "../common/ARM_PL061.rdl"
`include "../common/ARM_PL190.rdl"
`include "../common/HISI_AIAO.rdl"
`include "../common/HISI_AUDIO_CODEC.rdl"
`include "../common/HISI_CIPHER_MC.rdl"
`include "../common/HISI_DDRT.rdl"
`include "../common/HISI_DMAC.rdl"
`include "../common/HISI_DWMMC.rdl"
`include "../common/HISI_FEMAC.rdl"
`include "../common/HISI_FMC.rdl"
`include "../common/HISI_HASH.rdl"
`include "../common/HISI_I2C_V2.rdl"
`include "../common/HISI_IR.rdl"
`include "../common/HISI_ISP_CV300.rdl"
`include "../common/HISI_IVE.rdl"
`include "../common/HISI_JPGE.rdl"
`include "../common/HISI_LSADC_V2.rdl"
`include "../common/HISI_DDRC_V2.rdl"
`include "../common/HISI_DDRC_T28_PHY.rdl"
`include "../common/HISI_HPM.rdl"
`include "../common/HISI_MIPI_RX_CV300.rdl"
`include "../common/HISI_OTP_KEY_CTRL.rdl"
`include "../common/HISI_PWM.rdl"
`include "../common/HISI_RSA.rdl"
`include "../common/HISI_RTC_SPI.rdl"
`include "../common/HISI_RTC_SPI_V3.rdl"
`include "../common/HISI_SPI.rdl"
`include "../common/HISI_SPI_3WIRE.rdl"
`include "../common/HISI_SYS_CTRL.rdl"
`include "../common/HISI_TIMER_SP804.rdl"
`include "../common/HISI_TRNG.rdl"
`include "../common/HISI_USB_DEVICE.rdl"
`include "../common/HISI_USB_HOST.rdl"
`include "../common/HISI_VEDU_V2.rdl"
`include "../common/HISI_VPSS_V2.rdl"
`include "../common/HISI_POWER_CTRL.rdl"
`include "../common/HISI_IO_CONFIG_CV300.rdl"
`include "../common/HISI_VICAP_CV300.rdl"
`include "../common/HISI_VDP_CV300.rdl"
`include "../common/HISI_WDG_SP805.rdl"

addrmap hi3516cv300 {
    name = "hi3516cv300 registers";
    desc = "
        ## Datasheets

        * [Full Datasheet Hi3516CV300](assets/Hi3516CV300-Datasheet.pdf)
        * [Full Datasheet Hi3516CV300 and Hi3516EV100](assets/Hi3516CV300-Hi3516EV100-Datasheet.pdf)

        ## Diagrams

        ![Application Block Diagram](assets/Hi3516CV300-Application-Block-Diagram.png)
        ![Logic Block Diagram](assets/Hi3516CV300-Logic-Block-Diagram.png)

        <!-- overview:begin -->

        ### Diagrams

        ![Register blocks by function](assets/diagrams/hi3516cv300-blocks.svg)

        ### Interrupts (ARM926 VIC source numbers, data sheet Table 3-8)

        | # | Source | # | Source | # | Source |
        |---|---|---|---|---|---|
        | 0 | Global soft interrupt | 11 | FMC/eMMC | 22 | VICAP |
        | 1 | WatchDog | 12 | ETH | 23 | VDP |
        | 2 | RTC | 13 | CIPHER | 24 | VEDU |
        | 3 | Timer0/Timer1 | 14 | DMAC | 25 | UART2 |
        | 4 | Timer2/Timer3 | 15 | USB_EHCI | 26 | JPGE |
        | 5 | UART0 | 16 | USB_OHCI | 27 | SDIO1/SDIO2 |
        | 6 | SSP0 | 17 | VPSS | 28 | MIPI |
        | 7 | SSP1 | 18 | SDIO0 | 29 | VGS |
        | 8 | GZIP/DDRT | 19 | IR/LSADC | 30 | UART1 |
        | 9 | AIAO | 20 | I2C0/I2C1 | 31 | GPIO0−GPIO8 |
        | 10 | USB_DEVICE | 21 | IVE |  |  |

        ### Clock-gate and reset map (generated from the CRG registers)

        | Offset | Register | Description | Gate / reset fields |
        |---|---|---|---|
        | 0x028 | PERI_CRG10 | ARM9 frequency mode and reset configuration register | arm_core_srst_req |
        | 0x02C | PERI_CRG11 | VICAP/MIPI CTRL and sensor clock and reset configuration register | vi0_cken, vi0_srst_req, vi_hrst_req, vi_ch0_srst_req, mipi_srst_req, isp_core_srst_req, isp_cfg_srst_req, mipi_cken, mipi_core_srst_req, isp_cken, ... |
        | 0x034 | PERI_CRG13 | VDP clock and reset control register | vo_srst_req, vou_cfg_cken, vou_ppc_cken, vou_pcken, vo_out_cken, vou_acken, vou_hd_cken, vou_sd_cken, lcd_cken, dac_cken |
        | 0x038 | PERI_CRG14 | PWM clock and reset control register | pwm_srst_req, pwm_cken |
        | 0x040 | PERI_CRG16 | VEDU clock and soft reset control register | vedu_srst_req, vedu_cken |
        | 0x048 | PERI_CRG18 | VPSS clock and reset control register | vps_srst_req, vps_cken |
        | 0x05C | PERI_CRG23 | VGS clock and soft reset control register | vgs_srst_req, vgs_cken |
        | 0x060 | PERI_CRG24 | JPGE clock and soft reset control register | jpge_srst_req, jpge_cken |
        | 0x06C | PERI_CRG27 | IVE&HASH clock and soft reset control register | ive_srst_req, ive_cken, hash_srst_req, hash_cken |
        | 0x07C | PERI_CRG31 | LSADC & cipher clock and soft reset control register | cipher_srst_req, cipher_cken, sar_adc_srst_req |
        | 0x08C | PERI_CRG35 | AIAO clock and soft reset control register | aiao_srst_req, aiao_cken |
        | 0x0B8 | PERI_CRG46 | USB2.0 clock and soft reset control register | usb2_bus_cken, usb2_ohci48m_cken, usb2_ohci12m_cken, usb2_otg_utmi_cken, usb2_hst_phy_cken, usb2_utmi0_cken, usb2_phy_cken, usb2_bus_srst_req, usb2_utmi0_srst_req, usb2_hst_phy_srst_req, ... |
        | 0x0C0 | PERI_CRG48 | FMC clock and soft reset control register | fmc_srst_req, fmc_cken |
        | 0x0C4 | PERI_CRG49 | EMMC/SDIO0/SDIO1 clock and soft reset control register | sdio0_srst_req, sdio0_cken, sdio1_srst_req, sdio1_cken, emmc_srst_req, emmc_cken |
        | 0x0C8 | PERI_CRG50 | SDIO2 clock and soft reset control register | sdio2_srst_req, sdio2_cken |
        | 0x0D4 | PERI_CRG53 | GZIP clock and soft reset control register | gzip_cken, gzip_acken, gzip_pcken, gzip_srst_req |
        | 0x0D8 | PERI_CRG54 | DMAC/DDR TEST clock and soft reset control register | ddrtest_srst_req, ddrtest_cken, dmac_srst_req, dmac_cken |
        | 0x0E0 | PERI_CRG_PLL56 | GZIP reset status register | gzip_rst_ok |
        | 0x0E4 | PERI_CRG57 | Soft reset control register for other CRG interface modules | test_clk_en, rtc_srst_req, ir_srst_req, ssp0_srst_req, ssp1_srst_req, uart0_srst_req, uart1_srst_req, uart2_srst_req, ir_cken, ssp0_cken, ... |
        | 0x0EC | PERI_CRG59 | ETH clock and soft reset control register | hrst_eth_s, eth_cken, ext_fephy_srst_req |
        | 0x100 | PERI_CRG64 | RSA clock and soft reset control register | klad_srst_req, klad_cken, trng_srst_req, trng_cken, rsa_srst_req, rsa_cken |
        | 0x108 | PERI_CRG66 | APLL spread spectrum configuration register | apll_ssmod_cken, apll_ssmod_rst_req |
        | 0x110 | PERI_CRG68 | VPLL spread spectrum configuration register | vpll_ssmod_cken, vpll_ssmod_rst_req |
        | 0x118 | PERI_CRG70 | EPLL spread spectrum configuration register | epll_ssmod_cken, epll_ssmod_rst_req |

        Only fields whose names contain a clock-enable or reset keyword are listed; the field descriptions in the register pages give the polarity and the clocks they gate.

        ### Register blocks (generated from this description)

        | Base | Instance | Block | Register space |
        |---|---|---|---|
        | 0x10000000 | FMC | HiSilicon flash memory controller v100 (SPI NOR / SPI NAND) | 224 B |
        | 0x10030000 | DMAC | HiSilicon DMA controller (PL080-compatible, 4 or 8 channels) | 384 B |
        | 0x10040000 | VIC | Vectored interrupt controller (ARM PrimeCell PL190) | 4 KB |
        | 0x10050000 | ETH | HiSilicon femac v2 Fast Ethernet MAC with MDIO | 5184 B |
        | 0x10080000 | CIPHER | CIPHER (8 channels) | 5184 B |
        | 0x10090000 | HASH | HASH (SHA1 / SHA256 / HMAC) | 176 B |
        | 0x100C0000 | MMC0 | HiSilicon MMC/SD/SDIO controller (DesignWare-MMC based, himciv200) | 516 B |
        | 0x100D0000 | MMC1 | HiSilicon MMC/SD/SDIO controller (DesignWare-MMC based, himciv200) | 516 B |
        | 0x100E0000 | MMC2 | HiSilicon MMC/SD/SDIO controller (DesignWare-MMC based, himciv200) | 516 B |
        | 0x100F0000 | MMC3 | HiSilicon MMC/SD/SDIO controller (DesignWare-MMC based, himciv200) | 516 B |
        | 0x10110000 | OHCI | HiSilicon USB 2.0 host controller - OHCI | 88 B |
        | 0x10120000 | EHCI | HiSilicon USB 2.0 host controller - EHCI | 176 B |
        | 0x10130000 | USB_DEV | HiSilicon USB 2.0 device controller (DesignWare DWC_otg, device mode) | 3328 B |
        | 0x11200000 | DDRT | HiSilicon DDR test module | 132 B |
        | 0x11220000 | JPGE | HiSilicon JPEG encoder (JPGE, r004 register layout) | 4288 B |
        | 0x11230000 | IVE | HiSilicon intelligent video engine | 140 B |
        | 0x11240000 | VGS | VPSS / VGS job control registers (Hi3516C V300 / Hi3516E V100) | 792 B |
        | 0x11250000 | VPSS | VPSS / VGS job control registers (Hi3516C V300 / Hi3516E V100) | 792 B |
        | 0x11260000 | VEDU | HiSilicon VEDU, H.265/H.264 generation V2 (control registers, vendor-derived) | 3128 B |
        | 0x11300000 | MIPI | MIPI RX (sensor serial interface receiver, Hi3516C V300 / Hi3516E V100) | 5884 B |
        | 0x11310000 | AIAO | AIAO (audio input/output) | 8368 B |
        | 0x11320000 | ACODEC | Internal audio CODEC (Hi3516C V300 / Hi3516E V100) | 228 B |
        | 0x11380000 | VICAP | VICAP (video capture, Hi3516C V300 / Hi3516E V100) | 8444 B |
        | 0x11390000 | ISP | ISP (image signal processor, Hi3516C V300 / Hi3516E V100) | 269416 B |
        | 0x11400000 | VDP | VDP (video display processor, Hi3516C V300 / Hi3516E V100) | 62272 B |
        | 0x12000000 | TIMER0 | Timer Registers | 28 B |
        | 0x12000020 | TIMER1 | Timer Registers | 28 B |
        | 0x12001000 | TIMER2 | Timer Registers | 28 B |
        | 0x12001020 | TIMER3 | Timer Registers | 28 B |
        | 0x12010000 | CRG | Clock and reset generator (CRG), Hi3516C V300 / Hi3516E V100 | 284 B |
        | 0x12020000 | SYS_CTRL | System Controller Registers | 3824 B |
        | 0x12030000 | MISC_CTRL | Miscellaneous control (MISC_CTRL), Hi3516C V300 / Hi3516E V100 | 192 B |
        | 0x12040000 | IO_CONFIG | IO configuration: pin multiplexing (0x0..0x104) and pad control (0x800..0x92F), Hi3516C V300 / Hi3516E V100 | 2352 B |
        | 0x12060000 | DDRC | HiSilicon DDRC V2 (DDR2/DDR3 controller and DDR PHY, Hi3518E V20X / Hi3516C V200 / Hi3516A/D V100 / Hi3516C V300) | 5312 B |
        | 0x12068000 | DDR_PHY | DDR PHY, 28 nm T28 generation (Hi3516C V300 / Hi3516E V100) | 4212 B |
        | 0x12070800 | OTP_KEY_CTRL | OTP key control (key ladder) | 48 B |
        | 0x12078000 | HPM | HPM (hardware performance monitor, speed binning), Hi3516C V300 / Hi3516E V100 | 24 B |
        | 0x12080000 | WDG | Watchdog Registers | 3076 B |
        | 0x12090000 | RTC | HiSilicon SPI-bridged RTC (APB registers) | 164 B |
        | 0x12098000 | PWR | Power controller (always-on domain, Hi3516C V300 / Hi3516E V100) | 16 B |
        | 0x120B0000 | RSA | RSA (SEC_RSA modular exponentiation engine) | 120 B |
        | 0x120C0000 | TRNG | HISEC_TRNG_CTRL (true random number generator) | 540 B |
        | 0x120E0000 | LSADC | HiSilicon LSADC controller, 10-bit generation (2-3 channels) | 56 B |
        | 0x120F0000 | IR | HiSilicon IR receiver | 56 B |
        | 0x12100000 | UART0 | UART (ARM PrimeCell PL011) | 4 KB |
        | 0x12101000 | UART1 | UART (ARM PrimeCell PL011) | 4 KB |
        | 0x12102000 | UART2 | UART (ARM PrimeCell PL011) | 4 KB |
        | 0x12110000 | I2C0 | HiSilicon I2C Master Controller V2 (command-FIFO, timing-command sequencer) | 236 B |
        | 0x12112000 | I2C1 | HiSilicon I2C Master Controller V2 (command-FIFO, timing-command sequencer) | 236 B |
        | 0x12120000 | SPI0 | SPI Registers | 48 B |
        | 0x12121000 | SPI1 | SPI Registers | 48 B |
        | 0x12122000 | SPI_3WIRE | 3-wire SPI master (sensor control, spi_3wire) | 12 B |
        | 0x12130000 | PWM | HiSilicon PWM group | 128 B |
        | 0x12140000 | GPIO0 | ARM PL061 | 1053 B |
        | 0x12141000 | GPIO1 | ARM PL061 | 1053 B |
        | 0x12142000 | GPIO2 | ARM PL061 | 1053 B |
        | 0x12143000 | GPIO3 | ARM PL061 | 1053 B |
        | 0x12144000 | GPIO4 | ARM PL061 | 1053 B |
        | 0x12145000 | GPIO5 | ARM PL061 | 1053 B |
        | 0x12146000 | GPIO6 | ARM PL061 | 1053 B |
        | 0x12147000 | GPIO7 | ARM PL061 | 1053 B |
        | 0x12148000 | GPIO8 | ARM PL061 | 1053 B |

        The table is generated from the elaborated root (instances at their absolute addresses; register space is the span of the block's registers, not the data sheet window).

        <!-- overview:end -->
    ";

    eHISI_FMC           FMC             @ 0x10000000;
    eHISI_DMAC          DMAC            @ 0x10030000;
    eARM_PL190          VIC             @ 0x10040000;
    eHISI_FEMAC         ETH             @ 0x10050000;
    eHISI_CIPHER_MC     CIPHER          @ 0x10080000;
    eHISI_HASH          HASH            @ 0x10090000;
    eHISI_DWMMC         MMC0            @ 0x100C0000;
    eHISI_DWMMC         MMC1            @ 0x100D0000;
    eHISI_DWMMC         MMC2            @ 0x100E0000;
    eHISI_DWMMC         MMC3            @ 0x100F0000;
    eHISI_USB_OHCI      OHCI            @ 0x10110000;
    eHISI_USB_EHCI      EHCI            @ 0x10120000;
    eHISI_USB_DEVICE    USB_DEV         @ 0x10130000;
    eHISI_DDRT          DDRT            @ 0x11200000;
    eHISI_JPGE          JPGE            @ 0x11220000;
    eHISI_IVE           IVE             @ 0x11230000;
    eHISI_VPSS_V2      VPSS            @ 0x11250000;
    aHISI_VEDU_V2       VEDU            @ 0x11260000;
    eHISI_VPSS_V2      VGS             @ 0x11240000;
    eHISI_MIPI_RX_CV300 MIPI            @ 0x11300000;
    eHISI_AIAO          AIAO            @ 0x11310000;
    eHISI_AUDIO_CODEC   ACODEC          @ 0x11320000;
    eHISI_VICAP_CV300   VICAP           @ 0x11380000;
    eHISI_ISP_CV300     ISP             @ 0x11390000;
    eHISI_VDP_CV300     VDP             @ 0x11400000;
    eHISI_POWER_CTRL    PWR             @ 0x12098000;
    eHISI_IO_CONFIG_CV300 IO_CONFIG     @ 0x12040000;
    eCRG                CRG             @ 0x12010000;
    eMISC_CTRL          MISC_CTRL       @ 0x12030000;
    eHISI_DDRC_V2       DDRC            @ 0x12060000;
    eHISI_DDRC_T28_PHY  DDR_PHY         @ 0x12068000;
    eHISI_HPM           HPM             @ 0x12078000;
    eHISI_OTP_KEY_CTRL  OTP_KEY_CTRL    @ 0x12070800;
    eHISI_RTC_SPI       RTC             @ 0x12090000;
    eHISI_RSA           RSA             @ 0x120B0000;
    eHISI_TRNG          TRNG            @ 0x120C0000;
    eHISI_LSADC_V2      LSADC           @ 0x120E0000;
    eHISI_IR            IR              @ 0x120F0000;
    eHISI_I2C_V2        I2C0            @ 0x12110000;
    eHISI_I2C_V2        I2C1            @ 0x12112000;
    eARM_PL011          UART0           @ 0x12100000;
    eARM_PL011          UART1           @ 0x12101000;
    eARM_PL011          UART2           @ 0x12102000;
    eHISI_SPI           SPI0            @ 0x12120000;
    eHISI_SPI           SPI1            @ 0x12121000;
    eHISI_SPI_3WIRE     SPI_3WIRE       @ 0x12122000;
    eHISI_PWM_GRP       PWM             @ 0x12130000;
    eARM_PL061          GPIO0           @ 0x12140000;
    eARM_PL061          GPIO1           @ 0x12141000;
    eARM_PL061          GPIO2           @ 0x12142000;
    eARM_PL061          GPIO3           @ 0x12143000;
    eARM_PL061          GPIO4           @ 0x12144000;
    eARM_PL061          GPIO5           @ 0x12145000;
    eARM_PL061          GPIO6           @ 0x12146000;
    eARM_PL061          GPIO7           @ 0x12147000;
    eARM_PL061          GPIO8           @ 0x12148000;
    eHISI_TIMER_SP804   TIMER0          @ 0x12000000;
    eHISI_TIMER_SP804   TIMER1          @ 0x12000020;
    eHISI_TIMER_SP804   TIMER2          @ 0x12001000;
    eHISI_TIMER_SP804   TIMER3          @ 0x12001020;
    eHISI_WDG_SP805     WDG             @ 0x12080000;
    eSYS_CTRL           SYS_CTRL        @ 0x12020000;
};

