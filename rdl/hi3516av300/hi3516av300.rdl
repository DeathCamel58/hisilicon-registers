`include "defines.rdl"

`include "CRG.rdl"
`include "MISC_CTRL.rdl"

`include "../common/ARM_PL011.rdl"
`include "../common/ARM_PL061.rdl"
`include "../common/HISI_AIAO.rdl"
`include "../common/HISI_DDRT.rdl"
`include "../common/HISI_DMAC_V2.rdl"
`include "../common/HISI_DWMMC.rdl"
`include "../common/HISI_FEMAC.rdl"
`include "../common/HISI_FMC.rdl"
`include "../common/HISI_I2C_V2.rdl"
`include "../common/HISI_IR.rdl"
`include "../common/HISI_IVE.rdl"
`include "../common/HISI_JPGD_AV300.rdl"
`include "../common/HISI_JPGE_AV300.rdl"
`include "../common/HISI_LSADC_V2.rdl"
`include "../common/HISI_MIPI_RX_AV300.rdl"
`include "../common/HISI_OTP_USER.rdl"
`include "../common/HISI_PWM.rdl"
`include "../common/HISI_RSA.rdl"
`include "../common/HISI_RTC_SPI.rdl"
`include "../common/HISI_RTC_SPI_V3.rdl"
`include "../common/HISI_SCD_AV300.rdl"
`include "../common/HISI_SPACC.rdl"
`include "../common/HISI_SPI.rdl"
`include "../common/HISI_SPI_3WIRE.rdl"
`include "../common/HISI_SYS_CTRL.rdl"
`include "../common/HISI_TDE.rdl"
`include "../common/HISI_TIMER_SP804.rdl"
`include "../common/HISI_TRNG.rdl"
`include "../common/HISI_VDP_AV300.rdl"
`include "../common/HISI_VEDU_V3.rdl"
`include "../common/HISI_VGS.rdl"
`include "../common/HISI_VICAP_AV300.rdl"
`include "../common/HISI_VPSS.rdl"
`include "../common/HISI_WDG_SP805.rdl"

addrmap hi3516av300 {
    name = "hi3516av300 registers";
    desc = "
        ## Datasheets

        * [Full Datasheet](assets/Hi3516AV300-Datasheet.pdf)

        ## Diagrams

        ![Application Block Diagram](assets/Application-Block-Diagram.png)
        ![Logic Block Diagram](assets/Logic-Block-Diagram.png)

        ## Addresses

        | Start Address | End Address | Description                                                      | Documented Here |
        |---------------|-------------|------------------------------------------------------------------|-----------------|
        | 0x00000000    | 0x03FFFFFF  | When remapped: BOOTROM; Not remapped: points to on-chip RAM 64MB | &#10060;        |
        | 0x04000000    | 0x0400FFFF  | BOOTROM address space 64KB                                       | &#10060;        |
        | 0x04010000    | 0x04019AFF  | On chip RAM address space 40KB                                   | &#10060;        |
        | 0x0401B000    | 0x0FFFFFFF  | Reserved -                                                       | &#10060;        |
        | 0x10000000    | 0x1000FFFF  | FMC Register 64KB                                                | &#9989;         |
        | 0x10010000    | 0x1001FFFF  | ETH Register 64KB                                                | &#9989;         |
        | 0x10020000    | 0x1002FFFF  | SDIO Register 64KB                                               | &#9989;         |
        | 0x10030000    | 0x1003FFFF  | SCD registers 64KB (vendor-derived, UNVERIFIED registers at window offset 0xC000) | &#9888; vendor-derived |
        | 0x10040000    | 0x1005FFFF  | Reserved -                                                       | &#10060;        |
        | 0x10060000    | 0x1006FFFF  | DMAC registers 64KB                                                    | &#9989;         |
        | 0x10070000    | 0x1007FFFF  | KLAD registers 64KB                                                    | &#10060;        |
        | 0x10080000    | 0x1008FFFF  | RSA0 registers 64KB                                                    | &#9989;         |
        | 0x10090000    | 0x1009FFFF  | TRNG registers 64KB                                                    | &#9989;         |
        | 0x100A0000    | 0x100AFFFF  | Reserved -                                                             | &#10060;        |
        | 0x100B0000    | 0x100BFFFF  | OTP_USER registers 64KB                                                | &#9989;         |
        | 0x100C0000    | 0x100CFFFF  | SPACC registers 64KB                                                   | &#9989;         |
        | 0x100D0000    | 0x100DFFFF  | RSA1 registers 64KB                                                    | &#9989;         |
        | 0x100E0000    | 0x100EFFFF  | USB CTRL Register 64KB                                           | &#10060;        |
        | 0x100F0000    | 0x100FFFFF  | SDIO0 Register 64KB                                              | &#9989;         |
        | 0x10100000    | 0x1010FFFF  | eMMC Register 64KB                                               | &#9989;         |
        | 0x10110000    | 0x1011FFFF  | USB PHY Register 64KB                                            | &#10060;        |
        | 0x10120000    | 0x10FEFFFF  | Reserved -                                                       | &#10060;        |
        | 0x10FF0000    | 0x10FFFFFF  | IO Control Register 64KB                                         | &#10060;        |
        | 0x11000000    | 0x1100FFFF  | VIPROC Register 64KB                                             | &#10060;        |
        | 0x11040000    | 0x1104FFFF  | VPSS Register 64KB                                               | &#9989;         |
        | 0x11050000    | 0x110FFFFF  | Reserved -                                                       | &#10060;        |
        | 0x11100000    | 0x1110FFFF  | NNIE Register 64KB                                               | &#10060;        |
        | 0x11110000    | 0x1111FFFF  | GDC Register 64KB                                                | &#10060;        |
        | 0x11120000    | 0x111EFFFF  | Reserved -                                                       | &#10060;        |
        | 0x111F0000    | 0x111FFFFF  | IO Control Register 64KB                                         | &#10060;        |
        | 0x11200000    | 0x1120FFFF  | GZIP registers 64KB                                                    | &#10060;        |
        | 0x11210000    | 0x1121FFFF  | TDE registers 64KB                                                     | &#9989;         |
        | 0x11220000    | 0x1122FFFF  | JPGE registers 64KB                                                    | &#9989;        |
        | 0x11230000    | 0x1123FFFF  | IVE registers 64KB                                                     | &#9989;         |
        | 0x11240000    | 0x1124FFFF  | VGS registers 64KB                                                     | &#9989;        |
        | 0x11250000    | 0x1125FFFF  | DDRT registers 64KB                                                    | &#9989;         |
        | 0x11260000    | 0x1126FFFF  | JPGD registers 64KB (vendor-derived, UNVERIFIED registers)                | &#9888; vendor-derived |
        | 0x11270000    | 0x1127FFFF  | MIPI TX registers 64KB                                                 | &#10060;        |
        | 0x11280000    | 0x112EFFFF  | Reserved -                                                             | &#10060;        |
        | 0x112F0000    | 0x112FFFFF  | IO control registers 64KB                                                    | &#10060;        |
        | 0x11300000    | 0x1139FFFF  | VICAP registers 640KB                                                  | &#9989;         |
        | 0x113A0000    | 0x113AFFFF  | MIPI RX registers 64KB                                                 | &#9989;         |
        | 0x113B0000    | 0x113BFFFF  | AIAO registers 64KB                                                    | &#9989;         |
        | 0x113C0000    | 0x113CFFFF  | AudioCodec registers 64KB                                              | &#10060;        |
        | 0x113D0000    | 0x113FFFFF  | Reserved -                                                             | &#10060;        |
        | 0x11400000    | 0x1140FFFF  | HDMI PHY registers 64KB                                                | &#10060;        |
        | 0x11410000    | 0x1141FFFF  | Reserved -                                                       | &#10060;        |
        | 0x11420000    | 0x1142FFFF  | HDMI CTRL Register 64KB                                          | &#10060;        |
        | 0x11440000    | 0x1147FFFF  | VDP Register 64KB                                                | &#9989;         |
        | 0x11480000    | 0x114EFFFF  | Reserved -                                                       | &#10060;        |
        | 0x114F0000    | 0x114FFFFF  | IO Control Register 64KB                                         | &#10060;        |
        | 0x11500000    | 0x1150FFFF  | VEDU Register 64KB                                               | &#9989;         |
        | 0x11510000    | 0x11FFFFFF  | Reserved -                                                       | &#10060;        |
        | 0x12000000    | 0x12000FFF  | Timer0/Timer1 Register 64KB                                      | &#9989;         |
        | 0x12001000    | 0x12001FFF  | Timer2/Timer3 Register 64KB                                      | &#9989;         |
        | 0x12002000    | 0x12002FFF  | Timer4/Timer5 Register 64KB                                      | &#9989;         |
        | 0x12003000    | 0x12003FFF  | Timer6/Timer7 Register 64KB                                      | &#9989;         |
        | 0x12010000    | 0x1201FFFF  | CRG Register 64KB                                                | &#9989;         |
        | 0x12020000    | 0x1202FFFF  | SYS_CTRL Register 64KB                                           | &#9989;         |
        | 0x12030000    | 0x1203FFFF  | MISC registers 64KB                                                    | &#9989;         |
        | 0x12040000    | 0x1204FFFF  | SYSCNT registers 64KB                                                  | &#10060;        |
        | 0x12050000    | 0x12050FFF  | WDG0 registers 4KB                                                     | &#9989;         |
        | 0x12051000    | 0x12051FFF  | WDG1 registers 4KB                                                     | &#9989;         |
        | 0x12060000    | 0x1206FFFF  | DDRC registers 64KB                                                    | &#10060;        |
        | 0x12070000    | 0x1207FFFF  | PWM registers 64KB                                                     | &#9989;         |
        | 0x12080000    | 0x1208FFFF  | RTC registers 64KB                                                     | &#9989;         |
        | 0x12090000    | 0x1209FFFF  | PMC registers 64KB                                                     | &#10060;        |
        | 0x120A0000    | 0x120A0FFF  | UART0 registers 4KB                                                    | &#9989;         |
        | 0x120A1000    | 0x120A1FFF  | UART1 registers 4KB                                                    | &#9989;         |
        | 0x120A2000    | 0x120A2FFF  | UART2 registers 4KB                                                    | &#9989;         |
        | 0x120A3000    | 0x120A3FFF  | UART3 registers 4KB                                                    | &#9989;         |
        | 0x120A4000    | 0x120A4FFF  | UART4 registers 4KB                                                    | &#9989;         |
        | 0x120B0000    | 0x120B0FFF  | I2C0 registers 4KB                                                     | &#9989;        |
        | 0x120B1000    | 0x120B1FFF  | I2C1 registers 4KB                                                     | &#9989;        |
        | 0x120B2000    | 0x120B2FFF  | I2C2 registers 4KB                                                     | &#9989;        |
        | 0x120A0000    | 0x120A0FFF  | UART0 Register 64KB                                              | &#10060;        |
        | 0x120A1000    | 0x120A1FFF  | UART1 Register 64KB                                              | &#10060;        |
        | 0x120A2000    | 0x120A2FFF  | UART2 Register 64KB                                              | &#10060;        |
        | 0x120A3000    | 0x120A3FFF  | UART3 Register 64KB                                              | &#10060;        |
        | 0x120A4000    | 0x120A4FFF  | UART4 Register 64KB                                              | &#10060;        |
        | 0x120B0000    | 0x120B0FFF  | I2C0 Register 64KB                                               | &#9989;        |
        | 0x120B1000    | 0x120B1FFF  | I2C1 Register 64KB                                               | &#9989;        |
        | 0x120B2000    | 0x120B2FFF  | I2C2 Register 64KB                                               | &#9989;        |
        | 0x120B3000    | 0x120B3FFF  | I2C3 Register 64KB                                               | &#9989;        |
        | 0x120B4000    | 0x120B4FFF  | I2C4 Register 64KB                                               | &#9989;        |
        | 0x120B5000    | 0x120B5FFF  | I2C5 Register 64KB                                               | &#9989;        |
        | 0x120B6000    | 0x120B6FFF  | I2C6 Register 64KB                                               | &#9989;        |
        | 0x120B7000    | 0x120B7FFF  | I2C7 Register 64KB                                               | &#9989;        |
        | 0x120C0000    | 0x120C0FFF  | SPI0 Register 64KB                                               | &#9989;         |
        | 0x120C1000    | 0x120C1FFF  | SPI1 Register 64KB                                               | &#9989;         |
        | 0x120C2000    | 0x120C2FFF  | SPI2 Register 64KB                                               | &#9989;         |
        | 0x120C3000    | 0x120C3FFF  | 3 WIRE SPI Register 64KB                                         | &#9989;         |
        | 0x120D0000    | 0x120D0FFF  | GPIO0 Register 64KB                                              | &#9989;         |
        | 0x120D1000    | 0x120D1FFF  | GPIO1 Register 64KB                                              | &#9989;         |
        | 0x120D2000    | 0x120D2FFF  | GPIO2 Register 64KB                                              | &#9989;         |
        | 0x120D3000    | 0x120D3FFF  | GPIO3 Register 64KB                                              | &#9989;         |
        | 0x120D4000    | 0x120D4FFF  | GPIO4 registers 4KB                                                    | &#9989;         |
        | 0x120D5000    | 0x120D5FFF  | GPIO5 registers 4KB                                                    | &#9989;         |
        | 0x120D6000    | 0x120D6FFF  | GPIO6 registers 4KB                                                    | &#9989;         |
        | 0x120D7000    | 0x120D7FFF  | GPIO7 registers 4KB                                                    | &#9989;         |
        | 0x120D8000    | 0x120D8FFF  | GPIO8 registers 4KB                                                    | &#9989;         |
        | 0x120D9000    | 0x120D9FFF  | GPIO9 registers 4KB                                                    | &#9989;         |
        | 0x120DA000    | 0x120DAFFF  | GPIO10 registers 4KB                                                   | &#9989;         |
        | 0x120DB000    | 0x120DBFFF  | GPIO11 registers 4KB                                                   | &#9989;         |
        | 0x120E0000    | 0x120EFFFF  | LSADC registers 64KB                                                   | &#9989;         |
        | 0x120F0000    | 0x120FFFFF  | IR registers 64KB                                                      | &#9989;         |
        | 0x14000000    | 0x14FFFFFF  | FMC memory space 16MB                                                    | &#10060;        |
        | 0x80000000    | 0xFFFFFFFF  | DDR memory space 2GB                                                     | &#10060;        |

        <!-- overview:begin -->

        ### Diagrams

        ![Logic block diagram](assets/diagrams/hi3516av300-logic.svg)

        ![Register blocks by function](assets/diagrams/hi3516av300-blocks.svg)

        ![Clock tree](assets/diagrams/hi3516av300-clocks.svg)

        ![Boot flow](assets/diagrams/hi3516av300-boot.svg)

        ![Video pipeline](assets/diagrams/hi3516av300-video.svg)

        ![Interrupt topology](assets/diagrams/hi3516av300-irq.svg)

        ![Reset tree](assets/diagrams/hi3516av300-resets.svg)

        ![Storage, USB and Ethernet paths](assets/diagrams/hi3516av300-io.svg)

        ![DMA request lines](assets/diagrams/hi3516av300-dma.svg)

        ![Power domains](assets/diagrams/hi3516av300-power.svg)

        ![CRG register map](assets/diagrams/hi3516av300-crgmap.svg)

        ![IP editions across the camera family](assets/diagrams/hi3516av300-editions.svg)

        ### Variants and key specifications (Hi3516A V300 data sheet Issue 01 2019-09-15, Chinese; Hi3516D V300 data sheet Issue 01 2019-09-12, English; chapter 1)

        |  | Hi3516A V300 | Hi3516D V300 | Hi3516C V500 (brief data sheet Issue 01 2018-06-28) |
        |---|---|---|---|
        | Chip ID (SYSCTRL 0xEE0) | 0x3516A300 | 0x3516D300 | not published |
        | CPU | dual Cortex-A7 up to 900 MHz, 32 KB I + 32 KB D, 256 KB L2, NEON + FPU | same | same |
        | DDR | 32-bit DDR3 / DDR4, up to 16 Gbit, up to 2133 Mbit/s | 32-bit DDR3(L) / DDR4, up to 16 Gbit, up to 1800 Mbit/s | 16-bit DDR3(L) / DDR4, 8 Gbit max |
        | Video encode | H.264 BP/MP/HP, H.265 MP, SmartP; up to 3840 x 2160 (decode only of own streams); 2688 x 1944@30, 3840 x 2160@20; JPEG 16 MP@10; 50 Mbit/s | up to 3072 x 1728; 2688 x 1536@30, 2688 x 1944@20, 1080p@30 enc + 1080p@30 dec; JPEG 16 MP@10; 50 Mbit/s | VEDU up to 2304 wide |
        | AI | NNIE up to 1.0 TOPS, smart computing engine (tracking, face correction) | NNIE 1.0 TOPS | NNIE 0.5 TOPS |
        | Video input | 2 channels: first 3840 x 2160, second 2048 x 1536; DC 8/10/12/14-bit, BT.601/656/1120, MIPI / LVDS / sub-LVDS / HiSPi | first 2688 x 1944, second 2048 x 1536; same interfaces | 1 channel |
        | Video output | BT.656/BT.1120, 6/8-bit serial and 16/18/24-bit parallel LCD, 4-lane MIPI-DSI, HDMI 1.4 (1080p@60) | same | no HDMI, no MIPI-DSI |
        | Audio | 16-bit codec, mono differential MIC, single-ended dual input, I2S | same | same |
        | Peripherals | 5 UART, 8 I2C, 3 SPI + 3-wire SPI, 2-channel LSADC, 3 PWM, 2 SDIO 3.0 (3.3/1.8 V, one SD 3.0), 1 USB 2.0 host/device, RMII FE with TSO | same | same |
        | Flash | SPI NOR (1/2/4 wire, 256 MB), SPI NAND (24 bit/1 KB ECC, 1 GB), eMMC 4.5 (4-bit) | same | same |
        | Security | secure boot (PERISTAT[0] from OTP), memory isolation, AES / DES / 3DES / RSA, SHA1/256 + HMAC, TRNG, 8 kbit OTP | same | - |
        | Package | TFBGA 14 x 14 mm, 0.65 mm pitch, 367 pins | same | 12 x 12 mm, 280 balls |
        | Supply | core 0.9 V, I/O 3.3 V +-10%, DDR 1.5 / 1.2 V | core 0.9 V, I/O 3.3 V +-10%, DDR 1.5 (1.35) / 1.2 V | - |
        | SDK | Linux 4.9 | same | same |

        The C V500 column is from the brief data sheets only (docs/rdl-campaign/hi3516dv300-compare.md section 4); the sheets do not say whether the dies are identical. The Hi3516A V300 and Hi3516D V300 share the CRG, MISC_CTRL and address-map layout (docs/rdl-campaign/hi3516dv300-compare.md), so both folders use the same block types.

        ### Boot and upgrade modes (data sheet 1.4, Table 1-1)

        BOOT_SEL1 is the power-on latch of pin SENSOR0_RSTN, BOOT_SEL0 of pin MDCK (readable in SYSSTAT[5:4]); UPDATE_MODE is the level of GPIO0_0 at startup (0 = key pressed = upgrade).

        | UPDATE_MODE | BOOT_SEL1 | BOOT_SEL0 | Mode |
        |---|---|---|---|
        | 1 | 0 | 0 | boot from SPI NOR / SPI NAND |
        | 1 | 0 | 1 | boot from eMMC (4-bit only) |
        | 1 | 1 | 0 | burn SPI NOR / NAND image over the serial port |
        | 1 | 1 | 1 | burn eMMC image over the serial port |
        | 0 | X | 0 | upgrade SPI NOR / NAND from SDIO0 (SD card) or USB |
        | 0 | X | 1 | upgrade eMMC from SDIO0 (SD card) or USB |

        Secure boot: PERISTAT[0] (copied from the OTP secure-boot flag) selects secure mode, in which the BOOTROM verifies the U-Boot signature before running it. After reset the 0x00000000 window shows the BOOTROM until the remap is cleared, then the on-chip RAM.

        ### Memory map notes (data sheet 1.5, Table 1-2; identical in the Hi3516A V300 and Hi3516D V300 data sheets)

        | Window | Size | Function |
        |---|---|---|
        | 0x00000000-0x03FFFFFF | 64 MB | BOOTROM while the remap is active, then on-chip RAM |
        | 0x04000000 | 64 KB | BOOTROM |
        | 0x04010000 | 40 KB | on-chip RAM |
        | 0x14000000-0x14FFFFFF | 16 MB | FMC memory space |
        | 0x80000000-0xFFFFFFFF | 2 GB | DDR |

        Three I/O control windows appear in the map (0x10FF0000, 0x111F0000, 0x112F0000, 0x114F0000: 64 KB each); the data sheet has no register tables for them (the pad list is in a separate pinout document).

        ### Clocks (data sheet 3.2; identical in the Hi3516A V300 and Hi3516D V300 data sheets)

        XIN is a fixed 24 MHz crystal, RTC_XIN a 32.768 kHz crystal. Four PLLs with two PERI_CRG_PLLn registers each; FOUTVCO = 24 MHz x (fbdiv + frac/2^24) / refdiv with 800 MHz <= FOUTVCO <= 3.2 GHz, FOUTPOSTDIV = FOUTVCO / (pstdiv1 x pstdiv2) with pstdiv1 >= pstdiv2, FOUT1PH0 / 2 / 3 / 4 = FOUTVCO / (pstdiv1 x pstdiv2 x 2 / 4 / 6 / 8). Only the gray (programmable) PLL of the figure is user-configurable (the APLL, INFERRED from the CPU being its only consumer). Reprogram: switch to a non-PLL source, change the PLL, wait 0.1 ms, poll PERI_CRG_PLL122[10:0] for lock.

        | PLL | Config registers | Figure 3-3 values |
        |---|---|---|
        | APLL | PERI_CRG_PLL0 / PERI_CRG_PLL1 | VCO 1800 MHz, POSTDIV 900 MHz |
        | DPLL | PERI_CRG_PLL2 / PERI_CRG_PLL3 | VCO 2376 MHz, POSTDIV 594 MHz |
        | EPLL | PERI_CRG_PLL4 / PERI_CRG_PLL5 | VCO 1056 MHz, POSTDIV 528 MHz |
        | VPLL | PERI_CRG_PLL6 / PERI_CRG_PLL7 | VCO 1104 MHz, POSTDIV 552 MHz |

        Further clock choices in the figure (the text layer does not tie each to a PLL): 600 / 360 / 300 / 257 / 200 / 100 / 72 MHz, 450 / 150 / 50 MHz, 792 / 594 / 475 / 396 / 339 / 297 MHz, 54 / 27 MHz, 148.5 / 19.8 / 74.25 MHz, 1 / 2 / 3 / 6 MHz and 200 kHz dividers.

        | Module | Default | Selectable frequencies (MHz) |
        |---|---|---|
        | A7 | 24 | 24, 600, 792, 900 |
        | DDR | 24 | 24, 360, 396, 450 |
        | SYSAXI | 24 | 24, 198, 300 |
        | SYSCFG | 24 | 24, 148.5 |
        | SYSAPB | 24 | 24, 50 |
        | VPSS | 150 | 150, 300, 396, 475 |
        | VIPROC / VICAP | 300 | 150, 300, 396 (Hi3516A V300 also lists 475) |
        | VGS | 300 | 300, 396, 450, 475 |
        | IVE | 475 | 300, 396, 475 |
        | GDC | 300 | 300, 396, 450, 475 |
        | FMC | 24 | 24, 100, 150, 163, 200, 257, 300, 396 |
        | SDIO0 | 25 | 25, 50, 100 |
        | SDIO1 / eMMC | 50 | 25, 50, 100 |

        The newer sheets give no per-signal select-register table like the A V100 / A V200 sheets (Table 3-6); the select bits are in the PERI_CRG register descriptions of the RDL.

        ### Resets and power (data sheet 3.1, 3.10)

        Reset types: power-on reset (internal POR, low pulse longer than 12 XIN cycles), watchdog reset, global soft reset (system controller), per-module soft reset (PERI_CRG registers, not self-clearing); soft reset needs at least 360 system clocks to deassert and must not be repeated inside that window.

        Power: the PMC (0x12090000) controls the non-always-on supplies through PWR_SEQ0 / PWR_SEQ1 (PWR_EN, PWR_WAKEUP, PWR_STARTUP, PWR_BUTTON, PWR_RSTN pins): configurable wakeup polarity and sequence timing, RTC scheduled power-on, power-off by holding PWR_BUTTON 10 s; it runs from the RTC 32.768 kHz clock (RTC crystal and AVDD_BAT required). Also clock gating / frequency selects, module low power, DDR self-refresh, AVS.

        ### DMAC request lines (data sheet 3.6, Table 3-5 / 3-9; 8 channels, programmable priority, per-channel security attribute; identical in both data sheets)

        | Request lines | Peripheral | Select |
        |---|---|---|
        | 0-15 | I2C0..I2C7 RX / TX (line 2n = RX, 2n+1 = TX) |  |
        | 16-25 | UART0..UART4 RX / TX (16 + 2n = RX) |  |
        | 26-31 | SPI0..SPI2 RX / TX (26 + 2n = RX) |  |

        Fixed assignment (no select fields); transfer widths 8/16/32/64 bit, little endian only, linked-list transfers, software requests.

        ### Pin multiplexing

        The data sheet has no pin multiplexing register tables (the per-pad function list is in a separate pinout document, Hi35xx Vxxx_PINOUT_EN, not in the workspace), so no I/O control block is modeled and no pad table is given here.

        ### IP editions in the RDL (generated; same name = same IP edition, a different name = a different IP doing the same job)

        | Function | A V100 | D V100 | A V200 | 3519 V101 | A V300 | D V300 |
        |---|---|---|---|---|---|---|
        | CPU / interrupt | ARM_GIC400 | ARM_GIC400 | ARM_GIC400 | ARM_GIC400 | - | - |
        | DMA controller | DMAC | DMAC | DMAC | DMAC | DMAC_V2 | DMAC_V2 |
        | Timers / watchdog | TIMER_SP804, WDG_SP805 | TIMER_SP804, WDG_SP805 | TIMER_SP804, WDG_SP805 | TIMER_SP804, WDG_SP805 | TIMER_SP804, WDG_SP805 | TIMER_SP804, WDG_SP805 |
        | UART | ARM_PL011 | ARM_PL011 | ARM_PL011 | ARM_PL011 | ARM_PL011 | ARM_PL011 |
        | I2C | I2C_DW | I2C_DW | I2C_DW | I2C_DW | I2C_V2 | I2C_V2 |
        | SPI | SPI | SPI | SPI, SPI_3WIRE | SPI, SPI_3WIRE | SPI, SPI_3WIRE | SPI, SPI_3WIRE |
        | GPIO | ARM_PL061 | ARM_PL061 | ARM_PL061 | ARM_PL061 | ARM_PL061 | ARM_PL061 |
        | PWM | PWM_GRP | PWM_GRP | PWM_GRP | PWM_GRP | PWM_GRP | PWM_GRP |
        | LSADC / SAR ADC | LSADC | LSADC | LSADC_V2 | LSADC_V2 | LSADC_V2 | LSADC_V2 |
        | IR / RTC | IR, RTC_SPI | IR, RTC_SPI | IR, RTC_SPI | IR, RTC_SPI | IR, RTC_SPI | IR, RTC_SPI |
        | Ethernet | GMAC | GMAC | GMAC | GMAC | FEMAC | FEMAC |
        | USB | USB_DEVICE, USB_EHCI, USB_OHCI | USB_DEVICE, USB_EHCI, USB_OHCI | USB_DEVICE, USB_EHCI, USB_OHCI | USB_DEVICE, USB_EHCI, USB_OHCI | - | chip-local USB, chip-local USB2_PHY |
        | SD / eMMC | DWMMC | DWMMC | DWMMC | DWMMC | DWMMC | DWMMC |
        | Flash controller | NANDC, SFC_350, SNFC | NANDC, SFC_350, SNFC | FMC | FMC | FMC | FMC |
        | DDR controller | DDRC_V2 | DDRC_V2 | MDDRC | MDDRC | - | chip-local DDRC_AXI, chip-local DDRC_DMC, chip-local DDRC_PHY, chip-local DDRC_QOSB, chip-local DDRC_TZASC |
        | System / clock | CRG, MISC_CTRL, SYS_CTRL | CRG, MISC_CTRL, SYS_CTRL | MISC_CTRL, PERI_CRG, SYS_CTRL | MISC_CTRL, PERI_CRG, SYS_CTRL | CRG, MISC_CTRL, SYS_CTRL | CRG, chip-local MISC_CTRL, chip-local SYS_CTRL |
        | Pin control | IO_CONFIG | IO_CONFIG | MUX, PAD | MUX, PAD | - | - |
        | Security | CIPHER_MC | CIPHER_MC | CIPHER_MC, HASH, OTP_KEY_CTRL, RSA, TRNG | CIPHER_MC, HASH, OTP_KEY_CTRL, RSA, TRNG | OTP_USER, RSA, SPACC, TRNG | OTP_USER, RSA, SPACC, TRNG |
        | Audio | AIAO | AIAO | AIAO | AIAO | AIAO | AIAO, chip-local ACODEC |
        | VICAP / MIPI / ISP | MIPI_RX_AV100, VICAP_AV100 | MIPI_RX_AV100, VICAP_AV100 | ISP_AV200, MIPI_RX_AV200, VICAP_AV200 | ISP_AV200, MIPI_RX_AV200, VICAP_AV200 | MIPI_RX_AV300, VICAP_AV300 | chip-local MIPI_RX, chip-local MIPI_TX, chip-local VICAP |
        | VDP | VDP_AV100 | VDP_AV100 | VDP_AV200 | VDP_AV200 | VDP_AV300 | chip-local VDP |
        | VPSS / VGS / GDC | VGS, VPSS | VGS, VPSS | VGS, VPSS | VGS, VPSS | VGS, VPSS | - |
        | TDE / IVE / NNIE | IVE, TDE_G2 | IVE, TDE_G2 | IVE, TDE | IVE, TDE | IVE, TDE_G3 | - |
        | Video codec | JPGE, VEDU_V100, VEDU_V2 | JPGE, VEDU_V100, VEDU_V2 | JPGE, VEDU_V2 | JPGE, VEDU_V2 | JPGD_AV300, JPGE_AV300, VEDU_V3 | - |

        A V100 and D V100 share one register description (one data sheet). The A V200 and 3519 V101 use the same block types (the _AV200 ISP/VICAP/MIPI/VDP editions, MDDRC, FMC, PERI_CRG, MUX/PAD). The A V300 and D V300 are the next generation: DMAC_V2, I2C_V2, FEMAC, LSADC_V2, SPACC/RSA/OTP_USER, VEDU_V3 and the _AV300 editions; the D V300 root uses chip-local blocks extracted from its own data sheet where the A V300 root has shared editions or none (VICAP, VDP and CRG/MISC_CTRL registers are identical to the A V300 ones: docs/rdl-campaign/hi3516dv300-compare.md). Blocks that are absent in a column are absent from that root (not necessarily from the chip; see block-presence.csv).

        ### Interrupts (GIC interrupt IDs, data sheet interrupt table of the Chinese edition, section 3.4)

        | # | Source | # | Source | # | Source |
        |---|---|---|---|---|---|
        | 0-15 | SGI0-SGI15 (software generated) | 58 | GPIO10 | 86 | A7_PMUIRQ[0] |
        | 16-31 | Reserved | 59 | USB2.0 | 87 | AIAO |
        | 32 | WDG0 | 60 | DMAC | 88 | VICAP |
        | 33 | Timer0/Timer1 | 61 | FMC | 89 | MIPI Rx |
        | 34 | Timer2/Timer3 | 62 | SDIO0 | 90 | VDP_INT0 |
        | 35 | Timer4/Timer5 | 63 | SDIO1 | 91 | VDP_INT1 |
        | 36 | Timer6/Timer7 | 64 | ETH | 92 | HDMITX_AON |
        | 37 | RTC | 65 | DDR_SEC_INT | 93 | HDMITX_PWD |
        | 38 | UART0 | 66 | GZIP | 94 | HDMITX_SEC |
        | 39 | UART1 | 67 | TDE | 95 | MIPI Tx |
        | 40 | UART2 | 68 | JPGE | 96 | eMMC |
        | 41 | UART3 | 69 | IVE | 97 | LSADC |
        | 42 | UART4 | 70 | VGS | 98 | DDR |
        | 43 | I2C0 | 71 | DDRT | 99 | SCD |
        | 44 | I2C1 | 72 | VEDU | 100 | SPI0 |
        | 45 | I2C2 | 73 | NNIE | 101 | SPI1 |
        | 46 | I2C3 | 74 | GDC | 102 | SPI2 |
        | 47 | I2C4 | 75 | VPSS | 103 | SPACC_SEC_INT |
        | 48 | GPIO0 | 76 | VIPROC | 104 | SPACC_NOR_INT |
        | 49 | GPIO1 | 77 | JPGD | 105-106 | Reserved |
        | 50 | GPIO2 | 78 | A7_COMMTX[1] | 107 | IR |
        | 51 | GPIO3 | 79 | A7_COMMRX[1] | 108 | WDG1 |
        | 52 | GPIO4 | 80 | A7_PMUIRQ[1] | 109 | I2C5 |
        | 53 | GPIO5 | 81 | Reserved | 110 | I2C6 |
        | 54 | GPIO6 | 82 | Reserved | 111 | I2C7 |
        | 55 | GPIO7 | 83 | SOFTWARE_INT | 112 | GPIO11 |
        | 56 | GPIO8 | 84 | A7_COMMTX[0] | 113-127 | Reserved |
        | 57 | GPIO9 | 85 | A7_COMMRX[0] |  |  |

        ### Clock-gate and reset map (generated from the CRG registers)

        | Offset | Register | Description | Gate / reset fields |
        |---|---|---|---|
        | 0x078 | PERI_CRG30 | CPU frequency mode and reset configuration register | pclkdbg_cken, arm_core0_srst_req, arm_core1_srst_req, arm_dbg0_srst_req, arm_dbg1_srst_req, l2_srst_req, socdbg_srst_req, cs_srst_req |
        | 0x07C | PERI_CRG31 | DDR clock and reset configuration register | ddr_hipack_srst_req, ddr_apb_srst_req, ddr_cfg_cken, ddr_hipack_cken, ddr_apb_cken, ddr_cken |
        | 0x0A4 | PERI_CRG41 | VEDU clock and soft reset control register | vedu_srst_req, vedu_cken |
        | 0x0A8 | PERI_CRG42 | VPSS clock and soft reset control register | vpss_srst_req, vpss_cken |
        | 0x0AC | PERI_CRG43 | VGS clock and soft reset control register | vgs_srst_req, vgs_cken |
        | 0x0B0 | PERI_CRG44 | JPGE clock and soft reset control register | jpge_srst_req, jpge_cken |
        | 0x0B4 | PERI_CRG45 | GDC clock and soft reset control register | gdc_srst_req, gdc_cken |
        | 0x0B8 | PERI_CRG46 | TDE clock and soft reset control register | tde_srst_req, tde_cken |
        | 0x0C0 | PERI_CRG48 | IVE clock and soft reset control register | ive_srst_req, ive_cken, ive_cts_cken |
        | 0x0C4 | PERI_CRG49 | JPGD clock and soft reset control register | jpgd_srst_req, jpgd_cken |
        | 0x0C8 | PERI_CRG50 | SCD clock and soft reset control register | scd_srst_req, scd_cken |
        | 0x0F0 | PERI_CRG60 | SENSOR clock and soft reset control register | sensor0_cken, sensor0_srst_req, sensor1_cken, sensor1_srst_req |
        | 0x0F4 | PERI_CRG61 | VICAP clock and soft reset control register | vicap_ppc_pt0_cken, vicap_ppc_pt1_cken, vicap_ppc_ch0_cken, vicap_ppc_ch1_cken, vicap_ppc_ch2_cken, vicap_ppc_ch3_cken, vicap_p0_cken, vicap_p1_cken, vicap_ppc_cken, vicap_bus_cken, ... |
        | 0x0F8 | PERI_CRG62 | MIPI RX clock and soft reset control register | cil_cken, mipi_pix0_cken, mipi_pix1_cken, mipi_bus_cken, mipi_pix0_core_srst_req, mipi_pix1_core_srst_req, mipi_bus_srst_req |
        | 0x0FC | PERI_CRG63 | VIPROC clock and soft reset control register | viproc_cken, viproc_srst_req |
        | 0x100 | PERI_CRG64 | ISP clock and soft reset control register | isp0_cfg_srst_req, isp1_cfg_srst_req, isp2_cfg_srst_req, isp3_cfg_srst_req, isp0_core_srst_req, isp1_core_srst_req, isp2_core_srst_req, isp3_core_srst_req, isp0_cken, isp1_cken, ... |
        | 0x104 | PERI_CRG65 | LCD divider configuration register | lcd_cken |
        | 0x108 | PERI_CRG66 | VDP clock and soft reset control register | vdp_srst_req, vdp_pcken, vdp_acken, vdp_cfg_cken, vdp_hd_ppc_cken, vdp_hd_cken, vdp_bt_bp_cken, vdp_bt_cken, vdp_hdmi_cken, vdp_mipi_cken, ... |
        | 0x10C | PERI_CRG67 | MIPI TX clock and soft reset control register | mipitx_cken, mipitx_srst_req |
        | 0x110 | PERI_CRG68 | HDMI TX controller clock and soft reset control register | ssc_in_cken, ssc_bypass_cken, hdmitx_ctrl_osc_24m_cken, hdmitx_ctrl_cec_cken, hdmitx_ctrl_os_cken, hdmitx_ctrl_as_cken, hdmitx_ctrl_bus_srst_req, hdmitx_ctrl_srst_req, hdmitx_ctrl_cec_srst_req, hdmitx_ssc_srst_req, ... |
        | 0x114 | PERI_CRG69 | HDMI TX PHY clock and soft reset control register | phy_tmds_cken, hdmitx_phy_srst_req, phy_tmds_srst_req |
        | 0x140 | PERI_CRG80 | USB 2.0 clock and soft reset control register | usb2_phy_cken, usb2_vcc_srst_req, usb2_bus_cken, usb2_ref_cken, usb2_utmi_cken, usb2_phy_test_srst_req |
        | 0x144 | PERI_CRG81 | FMC clock and soft reset control register | fmc_srst_req, fmc_cken |
        | 0x148 | PERI_CRG82 | eMMC clock and soft reset control register | emmc_srst_req, emmc_cken |
        | 0x14C | PERI_CRG83 | eMMC DLL clock and soft reset control register | emmc_dll_cken, emmc_dll_srst_req, emmc_sap_dll_slave_en |
        | 0x154 | PERI_CRG85 | SDIO1 clock and soft reset control register | sdio1_srst_req, sdio1_cken |
        | 0x158 | PERI_CRG86 | SDIO1 DLL clock and soft reset control register | sdio1_dll_cken, sdio1_dll_srst_req, sdio1_sap_dll_slave_en |
        | 0x160 | PERI_CRG88 | SDIO0 clock and soft reset control register | sdio0_srst_req, sdio0_cken |
        | 0x164 | PERI_CRG89 | SDIO0 DLL clock and soft reset control register | sdio0_dll_cken, sdio0_dll_srst_req, sdio0_sap_dll_slave_en |
        | 0x16C | PERI_CRG91 | ETH interface clock and soft reset control register | hrst_eth_s, eth_cken_pre, ext_fephy_srst_req |
        | 0x190 | PERI_CRG100 | GZIP clock and soft reset control register | gzip_cken, gzip_acken, gzip_pcken, gzip_srst_req |
        | 0x194 | PERI_CRG101 | DMAC clock and soft reset control register | dmac_srst_req, dmac_apb_cken, dmac_cken |
        | 0x198 | PERI_CRG102 | DDRT clock and soft reset control register | ddrt_srst_req, ddrt_cken |
        | 0x19C | PERI_CRG103 | AIAO clock and reset control register | aiao_srst_req, aiao_cken, pop_srst_req, aiao_pll_cken |
        | 0x1A0 | PERI_CRG104 | SPACC/RSA/TRNG/KLAD clock and soft reset control register | klad_srst_req, klad_cken, trng_srst_req, trng_cken, rsa0_srst_req, rsa0_cken, rsa1_srst_req, rsa1_cken, spacc_srst_req_ini, spacc_cken |
        | 0x1A4 | PERI_CRG105 | AIAO MCLK2 clock configuration register | aiao_mclk2_cken |
        | 0x1A8 | PERI_CRG106 | AIAO MCLK1 clock configuration register | aiao_mclk1_cken |
        | 0x1AC | PERI_CRG107 | AIAO MCLK0 clock configuration register | aiao_mclk0_cken |
        | 0x1B8 | PERI_CRG110 | I2C/UART clock and reset control register | uart0_cken, uart1_cken, uart2_cken, uart3_cken, uart4_cken, uart0_srst_req, uart1_srst_req, uart2_srst_req, uart3_srst_req, uart4_srst_req, ... |
        | 0x1BC | PERI_CRG111 | ADC/UART/SPI/OTP/IR/PWM clock and soft reset control register | test_clk_en, otp_cken, lsadc_srst_req, rtc_srst_req, pmc_srst_req, pwm_srst_req, pwm_cken, ir_srst_req, ir_cken, spi0_cken, ... |
        | 0x1E4 | PERI_CRG_PLL121 | Reset status register | nnie_rst_ok, gzip_rst_ok, gdc_softrst_state, vpss_softrst_state, viproc_softrst_state, vgs_softrst_state, tde_softrst_state |

        Only fields whose names contain a clock-enable or reset keyword are listed; the field descriptions in the register pages give the polarity and the clocks they gate.

        ### Register blocks (generated from this description)

        | Base | Instance | Block | Register space |
        |---|---|---|---|
        | 0x10000000 | FMC | HiSilicon flash memory controller v100 (SPI NOR / SPI NAND) | 224 B |
        | 0x10010000 | ETH | HiSilicon femac v2 Fast Ethernet MAC with MDIO | 5184 B |
        | 0x10020000 | SDIO1 | HiSilicon MMC/SD/SDIO controller (DesignWare-MMC based, himciv200) | 516 B |
        | 0x1003C000 | SCD | HiSilicon SCD start-code detector, Hi3516A V300 generation (UNVERIFIED, vendor-derived) | 96 B |
        | 0x10060000 | DMAC | HiSilicon DMA controller V2 (EDMAC, 8 channels, 32 request lines) | 3844 B |
        | 0x10080000 | RSA0 | RSA (SEC_RSA modular exponentiation engine) | 120 B |
        | 0x10090000 | TRNG | HISEC_TRNG_CTRL (true random number generator) | 540 B |
        | 0x100B0000 | OTP_USER | OTP Ctrl user interface | 80 B |
        | 0x100C0000 | SPACC | SPACC (symmetric cipher + hash engine) | 3 KB |
        | 0x100D0000 | RSA1 | RSA (SEC_RSA modular exponentiation engine) | 120 B |
        | 0x100F0000 | SDIO0 | HiSilicon MMC/SD/SDIO controller (DesignWare-MMC based, himciv200) | 516 B |
        | 0x10100000 | EMMC | HiSilicon MMC/SD/SDIO controller (DesignWare-MMC based, himciv200) | 516 B |
        | 0x11040000 | VPSS | HiSilicon VPSS (registers not described) | 64 KB |
        | 0x11210000 | TDE | HiSilicon TDE, Hi3516A V300 generation (vendor-derived stubs) | 16408 B |
        | 0x11220000 | JPGE | HiSilicon JPEG encoder (JPGE), Hi3516A V300 generation (vendor-derived stubs) | 3 KB |
        | 0x11230000 | IVE | HiSilicon intelligent video engine | 148 B |
        | 0x11240000 | VGS | HiSilicon VGS (registers not described) | 64 KB |
        | 0x11250000 | DDRT | HiSilicon DDR test module | 132 B |
        | 0x11260000 | JPGD | HiSilicon JPEG decoder (JPGD), Hi3516A V300 generation (vendor-derived) | 1728 B |
        | 0x11300000 | VICAP | VICAP (video capture, Hi3516A V300) | 66092 B |
        | 0x113A0000 | MIPI | MIPI Rx (sensor serial interface receiver, Hi3516A V300) | 12284 B |
        | 0x113B0000 | AIAO | AIAO (audio input/output) | 8368 B |
        | 0x11440000 | VDP | VDP (video display processor, Hi3516A V300) | 69388 B |
        | 0x11500000 | VEDU | HiSilicon VEDU, Hi3516A V300 generation V3 (control registers, vendor-derived) | 12308 B |
        | 0x12000000 | TIMER0 | Timer Registers | 28 B |
        | 0x12000020 | TIMER1 | Timer Registers | 28 B |
        | 0x12001000 | TIMER2 | Timer Registers | 28 B |
        | 0x12001020 | TIMER3 | Timer Registers | 28 B |
        | 0x12002000 | TIMER4 | Timer Registers | 28 B |
        | 0x12002020 | TIMER5 | Timer Registers | 28 B |
        | 0x12003000 | TIMER6 | Timer Registers | 28 B |
        | 0x12003020 | TIMER7 | Timer Registers | 28 B |
        | 0x12010000 | CRG | Clock and reset generator (CRG), Hi3516A V300 | 492 B |
        | 0x12020000 | SYS_CTRL | System Controller Registers | 3824 B |
        | 0x12030000 | MISC_CTRL | Miscellaneous control (MISC_CTRL), Hi3516A V300 | 284 B |
        | 0x12050000 | WDG0 | Watchdog Registers | 3076 B |
        | 0x12051000 | WDG1 | Watchdog Registers | 3076 B |
        | 0x12070000 | PWM | HiSilicon PWM group | 64 B |
        | 0x12080000 | RTC | HiSilicon SPI-bridged RTC (APB registers) | 8 B |
        | 0x120A0000 | UART0 | UART (ARM PrimeCell PL011) | 4 KB |
        | 0x120A1000 | UART1 | UART (ARM PrimeCell PL011) | 4 KB |
        | 0x120A2000 | UART2 | UART (ARM PrimeCell PL011) | 4 KB |
        | 0x120A3000 | UART3 | UART (ARM PrimeCell PL011) | 4 KB |
        | 0x120A4000 | UART4 | UART (ARM PrimeCell PL011) | 4 KB |
        | 0x120B0000 | I2C0 | HiSilicon I2C Master Controller V2 (command-FIFO, timing-command sequencer) | 236 B |
        | 0x120B1000 | I2C1 | HiSilicon I2C Master Controller V2 (command-FIFO, timing-command sequencer) | 236 B |
        | 0x120B2000 | I2C2 | HiSilicon I2C Master Controller V2 (command-FIFO, timing-command sequencer) | 236 B |
        | 0x120B3000 | I2C3 | HiSilicon I2C Master Controller V2 (command-FIFO, timing-command sequencer) | 236 B |
        | 0x120B4000 | I2C4 | HiSilicon I2C Master Controller V2 (command-FIFO, timing-command sequencer) | 236 B |
        | 0x120B5000 | I2C5 | HiSilicon I2C Master Controller V2 (command-FIFO, timing-command sequencer) | 236 B |
        | 0x120B6000 | I2C6 | HiSilicon I2C Master Controller V2 (command-FIFO, timing-command sequencer) | 236 B |
        | 0x120B7000 | I2C7 | HiSilicon I2C Master Controller V2 (command-FIFO, timing-command sequencer) | 236 B |
        | 0x120C0000 | SPI0 | SPI Registers | 48 B |
        | 0x120C1000 | SPI1 | SPI Registers | 48 B |
        | 0x120C2000 | SPI2 | SPI Registers | 48 B |
        | 0x120C3000 | SPI_3WIRE | 3-wire SPI master (sensor control, spi_3wire) | 12 B |
        | 0x120D0000 | GPIO0 | ARM PL061 | 1053 B |
        | 0x120D1000 | GPIO1 | ARM PL061 | 1053 B |
        | 0x120D2000 | GPIO2 | ARM PL061 | 1053 B |
        | 0x120D3000 | GPIO3 | ARM PL061 | 1053 B |
        | 0x120D4000 | GPIO4 | ARM PL061 | 1053 B |
        | 0x120D5000 | GPIO5 | ARM PL061 | 1053 B |
        | 0x120D6000 | GPIO6 | ARM PL061 | 1053 B |
        | 0x120D7000 | GPIO7 | ARM PL061 | 1053 B |
        | 0x120D8000 | GPIO8 | ARM PL061 | 1053 B |
        | 0x120D9000 | GPIO9 | ARM PL061 | 1053 B |
        | 0x120DA000 | GPIO10 | ARM PL061 | 1053 B |
        | 0x120DB000 | GPIO11 | ARM PL061 | 1053 B |
        | 0x120E0000 | LSADC | HiSilicon LSADC controller, 10-bit generation (2-3 channels) | 52 B |
        | 0x120F0000 | IR | HiSilicon IR receiver | 56 B |

        The table is generated from the elaborated root (instances at their absolute addresses; register space is the span of the block's registers, not the data sheet window).

        <!-- overview:end -->
    ";

    eHISI_FMC           FMC             @ 0x10000000;
    eHISI_FEMAC         ETH             @ 0x10010000;
    eHISI_DWMMC         SDIO1           @ 0x10020000;
    eHISI_SCD_AV300     SCD             @ 0x1003C000;
    eHISI_DMAC_V2       DMAC            @ 0x10060000;
    eHISI_RSA           RSA0            @ 0x10080000;
    eHISI_TRNG          TRNG            @ 0x10090000;
    eHISI_OTP_USER      OTP_USER        @ 0x100B0000;
    eHISI_SPACC         SPACC           @ 0x100C0000;
    eHISI_RSA           RSA1            @ 0x100D0000;
    eHISI_DWMMC         SDIO0           @ 0x100F0000;
    eHISI_DWMMC         EMMC            @ 0x10100000;
    aHISI_VPSS          VPSS            @ 0x11040000;
    eHISI_TDE_G3          TDE             @ 0x11210000;
    eHISI_JPGE_AV300    JPGE            @ 0x11220000;
    eHISI_IVE           IVE             @ 0x11230000;
    eHISI_DDRT          DDRT            @ 0x11250000;
    eHISI_JPGD_AV300    JPGD            @ 0x11260000;
    eHISI_VICAP_AV300   VICAP           @ 0x11300000;
    eHISI_MIPI_RX_AV300 MIPI            @ 0x113A0000;
    eHISI_AIAO          AIAO            @ 0x113B0000;
    eHISI_VDP_AV300     VDP             @ 0x11440000;
    aHISI_VEDU_V3       VEDU            @ 0x11500000;
    aHISI_VGS           VGS             @ 0x11240000;
    eHISI_TIMER_SP804   TIMER0          @ 0x12000000;
    eHISI_TIMER_SP804   TIMER1          @ 0x12000020;
    eHISI_TIMER_SP804   TIMER2          @ 0x12001000;
    eHISI_TIMER_SP804   TIMER3          @ 0x12001020;
    eHISI_TIMER_SP804   TIMER4          @ 0x12002000;
    eHISI_TIMER_SP804   TIMER5          @ 0x12002020;
    eHISI_TIMER_SP804   TIMER6          @ 0x12003000;
    eHISI_TIMER_SP804   TIMER7          @ 0x12003020;
    eCRG                CRG             @ 0x12010000;
    eSYS_CTRL           SYS_CTRL        @ 0x12020000;
    eMISC_CTRL          MISC_CTRL       @ 0x12030000;
    eHISI_WDG_SP805     WDG0            @ 0x12050000;
    eHISI_WDG_SP805     WDG1            @ 0x12051000;
    eHISI_PWM_GRP       PWM             @ 0x12070000;
    eHISI_RTC_SPI       RTC             @ 0x12080000;
    eHISI_I2C_V2        I2C0            @ 0x120B0000;
    eHISI_I2C_V2        I2C1            @ 0x120B1000;
    eHISI_I2C_V2        I2C2            @ 0x120B2000;
    eHISI_I2C_V2        I2C3            @ 0x120B3000;
    eHISI_I2C_V2        I2C4            @ 0x120B4000;
    eHISI_I2C_V2        I2C5            @ 0x120B5000;
    eHISI_I2C_V2        I2C6            @ 0x120B6000;
    eHISI_I2C_V2        I2C7            @ 0x120B7000;
    eARM_PL011          UART0           @ 0x120A0000;
    eARM_PL011          UART1           @ 0x120A1000;
    eARM_PL011          UART2           @ 0x120A2000;
    eARM_PL011          UART3           @ 0x120A3000;
    eARM_PL011          UART4           @ 0x120A4000;
    eHISI_SPI           SPI0            @ 0x120C0000;
    eHISI_SPI           SPI1            @ 0x120C1000;
    eHISI_SPI           SPI2            @ 0x120C2000;
    eHISI_SPI_3WIRE     SPI_3WIRE       @ 0x120C3000;
    eARM_PL061          GPIO0           @ 0x120D0000;
    eARM_PL061          GPIO1           @ 0x120D1000;
    eARM_PL061          GPIO2           @ 0x120D2000;
    eARM_PL061          GPIO3           @ 0x120D3000;
    eARM_PL061          GPIO4           @ 0x120D4000;
    eARM_PL061          GPIO5           @ 0x120D5000;
    eARM_PL061          GPIO6           @ 0x120D6000;
    eARM_PL061          GPIO7           @ 0x120D7000;
    eARM_PL061          GPIO8           @ 0x120D8000;
    eARM_PL061          GPIO9           @ 0x120D9000;
    eARM_PL061          GPIO10          @ 0x120DA000;
    eARM_PL061          GPIO11          @ 0x120DB000;
    eHISI_LSADC_V2      LSADC           @ 0x120E0000;
    eHISI_IR            IR              @ 0x120F0000;
};
