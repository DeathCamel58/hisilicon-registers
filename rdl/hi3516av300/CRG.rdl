`ifndef HI3516AV300_CRG_RDL
`define HI3516AV300_CRG_RDL

regfile eCRG {
    name = "Clock and reset generator (CRG), Hi3516A V300";
    desc = "    PERI_CRG clock/reset generator registers at 0x12010000 (CRG). The names follow the HiSilicon scheme PERI_CRGn with offset = n x 4; the PLL registers are called PERI_CRG_PLLn (n = 0..7) and two status registers PERI_CRG_PLL121/122. Data sheet: Hi3516AV300 Professional Smart IP Camera SoC User Guide, document version 01 (2019-09-15), the original Chinese edition (watermarked), chapter 3.1 (reset), 3.2 (clock), register overview 3.2.5 and register descriptions 3.2.6 (printed pages 3-2..3-58). Only the registers listed in the data sheet exist here (55 registers). Read from the PDF text (pdftotext -raw, free of the watermark) and cross-checked with the layout dump `hi3516av300--Hi3516AV300-Datasheet.txt` lines 6432..9952. Checked on 2026-11-10.

    Reset: every module has a soft reset request bit: 1 = reset, 0 = deassert. The module reset is not released automatically, so software must write 0 again. After a global soft reset request the circuit needs at least 360 system clocks to complete; no new request may be issued meanwhile. The reset state of TDE, VGS, VIPROC, VPSS, GDC, GZIP and NNIE can be read back in PERI_CRG_PLL121.

    Clock tree facts for bring-up. XIN is a 24 MHz crystal, RTC_XIN 32.768 kHz. Four PLLs, each with two registers: APLL PERI_CRG_PLL0/1, DPLL PERI_CRG_PLL2/3, EPLL PERI_CRG_PLL4/5, VPLL PERI_CRG_PLL6/7. FOUTVCO = 24 MHz x (fbdiv + frac/2^24) / refdiv (must be 800 MHz..3.2 GHz), FOUTPOSTDIV = FOUTVCO / (postdiv1 x postdiv2) with postdiv1 >= postdiv2, further outputs FOUT1PH0/2/3/4 = VCO / (postdiv1 x postdiv2 x 2/4/6/8). Reset values give APLL 1800 MHz VCO / 900 MHz POSTDIV, DPLL 2376 / 594, EPLL 1056 / 528, VPLL 1104 / 552 MHz (data sheet Fig. 3-3). Fig. 3-3 marks the EPLL and VPLL (grey) as user-programmable and the APLL and DPLL as fixed. PLL change procedure (3.2.4.1): switch every consumer to a non-PLL (or another PLL) clock, change the PLL registers, wait 0.1 ms, poll PERI_CRG_PLL122 until the PLL reports locked (the data sheet says bits [10:0], only [3:0] exist), then switch back.
    Muxes (all reset to the 24 MHz crystal where there is one): Cortex-A7 PERI_CRG32[2:0] a7_cksel (24/600/792/900 MHz), DDR PERI_CRG32[5:3] ddr_cksel (24/360/396/450 MHz or EPLL POSTDIV), SYSAXI PERI_CRG32[7:6] (24/200/300 MHz), SYSCFG PERI_CRG32[8] (24/148.5 MHz), SYSAPB PERI_CRG32[10] (24/50 MHz); completion is reported in PERI_CRG120. UARTs: PERI_CRG111[18..22] uart0..4_cksel (0 = 24 MHz, 1 = 6 MHz), gates PERI_CRG110[0..4], resets PERI_CRG110[5..9]. FMC (SPI NOR/NAND): PERI_CRG81[4:2] fmc_cksel (24/100/150/163/200/257/300/396 MHz; 300 and 396 MHz DDR mode only; the chip clock is the selected clock / 2 in SDR mode, / 4 in DDR mode), gate bit 1, reset bit 0. eMMC PERI_CRG82[3:2] (01 = 100, 10 = 50, 11 = 25 MHz), SDIO1 PERI_CRG85[3:2], SDIO0 PERI_CRG88[3:2] (same encoding). Ethernet PERI_CRG91 (core clock bit 7: 100/54 MHz, PHY clock-out [5:4], RMII source bit 2, gate bit 1, MAC reset bit 0, PHY reset bit 3). USB 2.0 PERI_CRG80. PWM PERI_CRG111[9:8] (3/50/24/24 MHz). Timers: there is no CRG select; the SP804 timers count 3 MHz or the system APB clock according to SYS_CTRL SC_CTRL timeren0ov..timeren7ov (bits 16..23).

    Cross-checks: the vendor-derived Linux driver of the Hi3516DV300 (OpenIPC `clk-hi3516dv300.c`, CRG at 0x12010000, same register layout) uses sysaxi 0x80[7:6] {24m, 200m, 300m}, sysapb 0x80[10] {24m, 50m}, fmc 0x144[4:2] {24, 100, 150, 163, 200, 257, 300, 396}, mmc 0x148 (eMMC), 0x154 (SDIO1) and 0x160 (SDIO0) [3:2] {100m, 50m, 25m} with values 1..3, uart 0x1BC[18..22] {24m, 6m}, pwm 0x1BC[9:8], eth 0x16C[7] {100m, 54m}, gates 0x1B8 (UART bits 0..4, I2C bits 11..18), 0x1BC (SPI 12..14, PWM 7, ADC), 0x194 (DMAC bits 1, 2), all identical to this data sheet. No vendor U-Boot for the Hi3516AV300 is in the tree (the arch-hi3516a/av200/hi3519 headers are other chips), so nothing from U-Boot was used.

    Known data sheet inconsistencies recorded in the register descriptions: Table 3-2 lists SYSAXI 198 MHz but PERI_CRG32 says 200 MHz; IVE default 475 MHz in Table 3-2 but PERI_CRG40 ive_cksel resets to 2 (300 MHz); PERI_CRG40, PERI_CRG61 and PERI_CRG63 have reserved rows with a non-zero reset value (modelled as reserved_nz fields); PERI_CRG_PLL122[10:0] in the text vs [3:0] in the table; PERI_CRG120 omits the EPLL POSTDIV DDR setting and Table 3-2 does not list it for DDR at all; PERI_CRG41 bit 2 is named sed_cksel but is a clock gate; PERI_CRG86 bit 19 name truncated; PERI_CRG111 rtc_srst_req described as `t_cap`; the register overview table is numbered `Table 3-1` although that number is already used in 3.1.2. The text layout dump has watermark noise in field names (`Cosensor1_cken`, `budmac_ckenCo`, ...) that was repaired from the PDF text.";

    reg {
        name = "APLL configuration register 0";
        desc = "APLL configuration register 0.

APLL (Cortex-A7/system PLL). In data sheet Fig. 3-3 only the grey EPLL and VPLL are marked user-programmable; the APLL and DPLL have fixed configurations. FOUTVCO = 24 MHz x (fbdiv + frac/2^24) / refdiv; FOUTPOSTDIV = FOUTVCO / (postdiv1 x postdiv2). Reset: postdiv2 = 1, postdiv1 = 2, frac = 0; together with PERI_CRG_PLL1 (refdiv 1, fbdiv 75, integer mode) the APLL VCO runs at 1800 MHz and POSTDIV at 900 MHz (Fig. 3-3). Per Fig. 3-3 the APLL VCO output feeds the 600/360/300/257/200/100/72 MHz clocks and the POSTDIV output the 900 MHz and 450/150/50 MHz clocks.

Data sheet 3.2.6 PERI_CRG_PLL0 (offset 0x0, printed page 3-11, `hi3516av300--Hi3516AV300-Datasheet.txt` line 6614).";

        field {
            name = "apll_postdiv2";
            desc = "APLL second-stage output divider (postdiv2).";
            sw = rw;
            hw = r;
            reset = 0x1;
        } apll_postdiv2[30:28];

        field {
            name = "apll_postdiv1";
            desc = "APLL first-stage output divider (postdiv1).";
            sw = rw;
            hw = r;
            reset = 0x2;
        } apll_postdiv1[26:24];

        field {
            name = "apll_frac";
            desc = "APLL fractional part of the feedback multiplier (frac, 24 bits).";
            sw = rw;
            hw = r;
            reset = 0x0;
        } apll_frac[23:0];
    } PERI_CRG_PLL0 @ 0x0;

    reg {
        name = "APLL configuration register 1";
        desc = "APLL configuration register 1.

APLL configuration register 1: power-down/bypass controls, refdiv and the integer multiplier. Reset 0x0100104B = dsmpd 1 (integer mode, apll_frac ignored), refdiv 1, fbdiv 0x4B = 75 -> VCO 24 x 75 = 1800 MHz. FOUTPOSTDIV = VCO / (postdiv1 x postdiv2) = 900 MHz. Table 3-4 also lists FOUT1PH0, FOUT2, FOUT3, FOUT4 = FOUTVCO / (postdiv1 x postdiv2 x 2/4/6/8). The valid VCO range is 800 MHz to 3.2 GHz (data sheet Table 3-4) and postdiv1 >= postdiv2.

Data sheet 3.2.6 PERI_CRG_PLL1 (offset 0x4, printed page 3-11, `hi3516av300--Hi3516AV300-Datasheet.txt` line 6644).";

        enum PERI_CRG_PLL1_apll_bypass_enum {
            NOT_BYPASSED = 0 { name = "Not Bypassed"; desc = "Not bypassed"; };
            BYPASSED = 1 { name = "Bypassed"; desc = "Bypassed"; };
        };

        field {
            name = "apll_bypass";
            desc = "APLL clock divider bypass control. 0: not bypassed, 1: bypassed.";
            sw = rw;
            hw = r;
            encode = PERI_CRG_PLL1_apll_bypass_enum;
            reset = 0x0;
        } apll_bypass[26:26];

        enum PERI_CRG_PLL1_apll_dacpd_enum {
            NORMAL = 0 { name = "Normal"; desc = "Normal operation"; };
            POWER_DOWN = 1 { name = "Power Down"; desc = "Power down"; };
        };

        field {
            name = "apll_dacpd";
            desc = "APLL test signal control. 0: normal operation, 1: power down.";
            sw = rw;
            hw = r;
            encode = PERI_CRG_PLL1_apll_dacpd_enum;
            reset = 0x0;
        } apll_dacpd[25:25];

        enum PERI_CRG_PLL1_apll_dsmpd_enum {
            FRACTIONAL = 0 { name = "Fractional"; desc = "Fractional mode"; };
            INTEGER = 1 { name = "Integer"; desc = "Integer mode"; };
        };

        field {
            name = "apll_dsmpd";
            desc = "APLL fractional divider control. 0: fractional mode, 1: integer mode.";
            sw = rw;
            hw = r;
            encode = PERI_CRG_PLL1_apll_dsmpd_enum;
            reset = 0x1;
        } apll_dsmpd[24:24];

        enum PERI_CRG_PLL1_apll_pd_enum {
            NORMAL = 0 { name = "Normal"; desc = "Normal operation"; };
            POWER_DOWN = 1 { name = "Power Down"; desc = "Power down"; };
        };

        field {
            name = "apll_pd";
            desc = "APLL power-down control. 0: normal operation, 1: power down.";
            sw = rw;
            hw = r;
            encode = PERI_CRG_PLL1_apll_pd_enum;
            reset = 0x0;
        } apll_pd[23:23];

        enum PERI_CRG_PLL1_apll_postdivpd_enum {
            CLOCK_OUTPUT = 0 { name = "Clock Output"; desc = "Normal clock output"; };
            NO_CLOCK_OUTPUT = 1 { name = "No Clock Output"; desc = "No clock output (the VCO clock is powered down as well)"; };
        };

        field {
            name = "apll_postdivpd";
            desc = "APLL POSTDIV output power-down control. 0: normal clock output, 1: no clock output (the VCO clock is powered down as well).";
            sw = rw;
            hw = r;
            encode = PERI_CRG_PLL1_apll_postdivpd_enum;
            reset = 0x0;
        } apll_postdivpd[21:21];

        enum PERI_CRG_PLL1_apll_fout4phasepd_enum {
            CLOCK_OUTPUT = 0 { name = "Clock Output"; desc = "Normal clock output"; };
            NO_CLOCK_OUTPUT = 1 { name = "No Clock Output"; desc = "No clock output"; };
        };

        field {
            name = "apll_fout4phasepd";
            desc = "APLL FOUT output power-down control. 0: normal clock output, 1: no clock output.";
            sw = rw;
            hw = r;
            encode = PERI_CRG_PLL1_apll_fout4phasepd_enum;
            reset = 0x0;
        } apll_fout4phasepd[20:20];

        field {
            name = "apll_refdiv";
            desc = "APLL reference clock divider (refdiv).";
            sw = rw;
            hw = r;
            reset = 0x1;
        } apll_refdiv[17:12];

        field {
            name = "apll_fbdiv";
            desc = "APLL integer part of the feedback multiplier (fbdiv).";
            sw = rw;
            hw = r;
            reset = 0x4B;
        } apll_fbdiv[11:0];
    } PERI_CRG_PLL1 @ 0x4;

    reg {
        name = "DPLL configuration register 0";
        desc = "DPLL configuration register 0.

DPLL, fixed configuration. Reset: postdiv2 = 1, postdiv1 = 4, frac = 0.

Data sheet 3.2.6 PERI_CRG_PLL2 (offset 0x8, printed page 3-12, `hi3516av300--Hi3516AV300-Datasheet.txt` line 6708).";

        field {
            name = "dpll_postdiv2";
            desc = "DPLL second-stage output divider (postdiv2).";
            sw = rw;
            hw = r;
            reset = 0x1;
        } dpll_postdiv2[30:28];

        field {
            name = "dpll_postdiv1";
            desc = "DPLL first-stage output divider (postdiv1).";
            sw = rw;
            hw = r;
            reset = 0x4;
        } dpll_postdiv1[26:24];

        field {
            name = "dpll_frac";
            desc = "DPLL fractional part of the feedback multiplier (frac, 24 bits).";
            sw = rw;
            hw = r;
            reset = 0x0;
        } dpll_frac[23:0];
    } PERI_CRG_PLL2 @ 0x8;

    reg {
        name = "DPLL configuration register 1";
        desc = "DPLL configuration register 1.

DPLL configuration register 1. Reset 0x01001063 = integer mode, refdiv 1, fbdiv 0x63 = 99 -> VCO 24 x 99 = 2376 MHz and POSTDIV (/4) = 594 MHz (Fig. 3-3). The DPLL VCO output feeds the 792/594/475/396/339/297 MHz clocks (the Cortex-A7 792 MHz option and the 475/396/300-style media clocks); the POSTDIV output feeds the 148.5/74.25/54/27/19.8 MHz style clocks (grouping read from Fig. 3-3, low confidence).

Data sheet 3.2.6 PERI_CRG_PLL3 (offset 0xC, printed page 3-13, `hi3516av300--Hi3516AV300-Datasheet.txt` line 6736).";

        enum PERI_CRG_PLL3_dpll_bypass_enum {
            NOT_BYPASSED = 0 { name = "Not Bypassed"; desc = "Not bypassed"; };
            BYPASSED = 1 { name = "Bypassed"; desc = "Bypassed"; };
        };

        field {
            name = "dpll_bypass";
            desc = "DPLL clock divider bypass control. 0: not bypassed, 1: bypassed.";
            sw = rw;
            hw = r;
            encode = PERI_CRG_PLL3_dpll_bypass_enum;
            reset = 0x0;
        } dpll_bypass[26:26];

        enum PERI_CRG_PLL3_dpll_dacpd_enum {
            NORMAL = 0 { name = "Normal"; desc = "Normal operation"; };
            POWER_DOWN = 1 { name = "Power Down"; desc = "Power down"; };
        };

        field {
            name = "dpll_dacpd";
            desc = "DPLL test signal control. 0: normal operation, 1: power down.";
            sw = rw;
            hw = r;
            encode = PERI_CRG_PLL3_dpll_dacpd_enum;
            reset = 0x0;
        } dpll_dacpd[25:25];

        enum PERI_CRG_PLL3_dpll_dsmpd_enum {
            FRACTIONAL = 0 { name = "Fractional"; desc = "Fractional mode"; };
            INTEGER = 1 { name = "Integer"; desc = "Integer mode"; };
        };

        field {
            name = "dpll_dsmpd";
            desc = "DPLL fractional divider control. 0: fractional mode, 1: integer mode.";
            sw = rw;
            hw = r;
            encode = PERI_CRG_PLL3_dpll_dsmpd_enum;
            reset = 0x1;
        } dpll_dsmpd[24:24];

        enum PERI_CRG_PLL3_dpll_pd_enum {
            NORMAL = 0 { name = "Normal"; desc = "Normal operation"; };
            POWER_DOWN = 1 { name = "Power Down"; desc = "Power down"; };
        };

        field {
            name = "dpll_pd";
            desc = "DPLL power-down control. 0: normal operation, 1: power down.";
            sw = rw;
            hw = r;
            encode = PERI_CRG_PLL3_dpll_pd_enum;
            reset = 0x0;
        } dpll_pd[23:23];

        enum PERI_CRG_PLL3_dpll_postdivpd_enum {
            CLOCK_OUTPUT = 0 { name = "Clock Output"; desc = "Normal clock output"; };
            NO_CLOCK_OUTPUT = 1 { name = "No Clock Output"; desc = "No clock output (the VCO clock is powered down as well)"; };
        };

        field {
            name = "dpll_postdivpd";
            desc = "DPLL POSTDIV output power-down control. 0: normal clock output, 1: no clock output (the VCO clock is powered down as well).";
            sw = rw;
            hw = r;
            encode = PERI_CRG_PLL3_dpll_postdivpd_enum;
            reset = 0x0;
        } dpll_postdivpd[21:21];

        enum PERI_CRG_PLL3_dpll_fout4phasepd_enum {
            CLOCK_OUTPUT = 0 { name = "Clock Output"; desc = "Normal clock output"; };
            NO_CLOCK_OUTPUT = 1 { name = "No Clock Output"; desc = "No clock output"; };
        };

        field {
            name = "dpll_fout4phasepd";
            desc = "DPLL FOUT output power-down control. 0: normal clock output, 1: no clock output.";
            sw = rw;
            hw = r;
            encode = PERI_CRG_PLL3_dpll_fout4phasepd_enum;
            reset = 0x0;
        } dpll_fout4phasepd[20:20];

        field {
            name = "dpll_refdiv";
            desc = "DPLL reference clock divider (refdiv).";
            sw = rw;
            hw = r;
            reset = 0x1;
        } dpll_refdiv[17:12];

        field {
            name = "dpll_fbdiv";
            desc = "DPLL integer part of the feedback multiplier (fbdiv).";
            sw = rw;
            hw = r;
            reset = 0x63;
        } dpll_fbdiv[11:0];
    } PERI_CRG_PLL3 @ 0xC;

    reg {
        name = "EPLL configuration register 0";
        desc = "EPLL configuration register 0.

EPLL (user-programmable per Fig. 3-3). Reset: postdiv2 = 1, postdiv1 = 2, frac = 0. The EPLL POSTDIV output is a DDR clock option (PERI_CRG32 ddr_cksel = 4).

Data sheet 3.2.6 PERI_CRG_PLL4 (offset 0x10, printed page 3-13, `hi3516av300--Hi3516AV300-Datasheet.txt` line 6795).";

        field {
            name = "epll_postdiv2";
            desc = "EPLL second-stage output divider (postdiv2).";
            sw = rw;
            hw = r;
            reset = 0x1;
        } epll_postdiv2[30:28];

        field {
            name = "epll_postdiv1";
            desc = "EPLL first-stage output divider (postdiv1).";
            sw = rw;
            hw = r;
            reset = 0x2;
        } epll_postdiv1[26:24];

        field {
            name = "epll_frac";
            desc = "EPLL fractional part of the feedback multiplier (frac, 24 bits).";
            sw = rw;
            hw = r;
            reset = 0x0;
        } epll_frac[23:0];
    } PERI_CRG_PLL4 @ 0x10;

    reg {
        name = "EPLL configuration register 1";
        desc = "EPLL configuration register 1.

EPLL configuration register 1. Reset 0x0100102C = integer mode, refdiv 1, fbdiv 0x2C = 44 -> VCO 24 x 44 = 1056 MHz, POSTDIV (/2) = 528 MHz (Fig. 3-3). Reprogram it only while no clock consumer runs from it (see the PLL change procedure in the regfile description).

Data sheet 3.2.6 PERI_CRG_PLL5 (offset 0x14, printed page 3-14, `hi3516av300--Hi3516AV300-Datasheet.txt` line 6821).";

        enum PERI_CRG_PLL5_epll_bypass_enum {
            NOT_BYPASSED = 0 { name = "Not Bypassed"; desc = "Not bypassed"; };
            BYPASSED = 1 { name = "Bypassed"; desc = "Bypassed"; };
        };

        field {
            name = "epll_bypass";
            desc = "EPLL clock divider bypass control. 0: not bypassed, 1: bypassed.";
            sw = rw;
            hw = r;
            encode = PERI_CRG_PLL5_epll_bypass_enum;
            reset = 0x0;
        } epll_bypass[26:26];

        enum PERI_CRG_PLL5_epll_dacpd_enum {
            NORMAL = 0 { name = "Normal"; desc = "Normal operation"; };
            POWER_DOWN = 1 { name = "Power Down"; desc = "Power down"; };
        };

        field {
            name = "epll_dacpd";
            desc = "EPLL test signal control. 0: normal operation, 1: power down.";
            sw = rw;
            hw = r;
            encode = PERI_CRG_PLL5_epll_dacpd_enum;
            reset = 0x0;
        } epll_dacpd[25:25];

        enum PERI_CRG_PLL5_epll_dsmpd_enum {
            FRACTIONAL = 0 { name = "Fractional"; desc = "Fractional mode"; };
            INTEGER = 1 { name = "Integer"; desc = "Integer mode"; };
        };

        field {
            name = "epll_dsmpd";
            desc = "EPLL fractional divider control. 0: fractional mode, 1: integer mode.";
            sw = rw;
            hw = r;
            encode = PERI_CRG_PLL5_epll_dsmpd_enum;
            reset = 0x1;
        } epll_dsmpd[24:24];

        enum PERI_CRG_PLL5_epll_pd_enum {
            NORMAL = 0 { name = "Normal"; desc = "Normal operation"; };
            POWER_DOWN = 1 { name = "Power Down"; desc = "Power down"; };
        };

        field {
            name = "epll_pd";
            desc = "EPLL power-down control. 0: normal operation, 1: power down.";
            sw = rw;
            hw = r;
            encode = PERI_CRG_PLL5_epll_pd_enum;
            reset = 0x0;
        } epll_pd[23:23];

        enum PERI_CRG_PLL5_epll_postdivpd_enum {
            CLOCK_OUTPUT = 0 { name = "Clock Output"; desc = "Normal clock output"; };
            NO_CLOCK_OUTPUT = 1 { name = "No Clock Output"; desc = "No clock output (the VCO clock is powered down as well)"; };
        };

        field {
            name = "epll_postdivpd";
            desc = "EPLL POSTDIV output power-down control. 0: normal clock output, 1: no clock output (the VCO clock is powered down as well).";
            sw = rw;
            hw = r;
            encode = PERI_CRG_PLL5_epll_postdivpd_enum;
            reset = 0x0;
        } epll_postdivpd[21:21];

        enum PERI_CRG_PLL5_epll_fout4phasepd_enum {
            CLOCK_OUTPUT = 0 { name = "Clock Output"; desc = "Normal clock output"; };
            NO_CLOCK_OUTPUT = 1 { name = "No Clock Output"; desc = "No clock output"; };
        };

        field {
            name = "epll_fout4phasepd";
            desc = "EPLL FOUT output power-down control. 0: normal clock output, 1: no clock output.";
            sw = rw;
            hw = r;
            encode = PERI_CRG_PLL5_epll_fout4phasepd_enum;
            reset = 0x0;
        } epll_fout4phasepd[20:20];

        field {
            name = "epll_refdiv";
            desc = "EPLL reference clock divider (refdiv).";
            sw = rw;
            hw = r;
            reset = 0x1;
        } epll_refdiv[17:12];

        field {
            name = "epll_fbdiv";
            desc = "EPLL integer part of the feedback multiplier (fbdiv).";
            sw = rw;
            hw = r;
            reset = 0x2C;
        } epll_fbdiv[11:0];
    } PERI_CRG_PLL5 @ 0x14;

    reg {
        name = "VPLL configuration register 0";
        desc = "VPLL configuration register 0.

VPLL (video PLL, user-programmable per Fig. 3-3). Reset: postdiv2 = 1, postdiv1 = 2, frac = 0.

Data sheet 3.2.6 PERI_CRG_PLL6 (offset 0x18, printed page 3-15, `hi3516av300--Hi3516AV300-Datasheet.txt` line 6891).";

        field {
            name = "vpll_postdiv2";
            desc = "VPLL second-stage output divider (postdiv2).";
            sw = rw;
            hw = r;
            reset = 0x1;
        } vpll_postdiv2[30:28];

        field {
            name = "vpll_postdiv1";
            desc = "VPLL first-stage output divider (postdiv1).";
            sw = rw;
            hw = r;
            reset = 0x2;
        } vpll_postdiv1[26:24];

        field {
            name = "vpll_frac";
            desc = "VPLL fractional part of the feedback multiplier (frac, 24 bits).";
            sw = rw;
            hw = r;
            reset = 0x0;
        } vpll_frac[23:0];
    } PERI_CRG_PLL6 @ 0x18;

    reg {
        name = "VPLL configuration register 1";
        desc = "VPLL configuration register 1.

VPLL configuration register 1. Reset 0x0100102E = integer mode, refdiv 1, fbdiv 0x2E = 46 -> VCO 24 x 46 = 1104 MHz, POSTDIV (/2) = 552 MHz (Fig. 3-3). The VPLL PST and FOUT4 outputs are VDP clock sources (PERI_CRG66 vdp_hd_cksel).

Data sheet 3.2.6 PERI_CRG_PLL7 (offset 0x1C, printed page 3-15, `hi3516av300--Hi3516AV300-Datasheet.txt` line 6915).";

        enum PERI_CRG_PLL7_vpll_bypass_enum {
            NOT_BYPASSED = 0 { name = "Not Bypassed"; desc = "Not bypassed"; };
            BYPASSED = 1 { name = "Bypassed"; desc = "Bypassed"; };
        };

        field {
            name = "vpll_bypass";
            desc = "VPLL clock divider bypass control. 0: not bypassed, 1: bypassed.";
            sw = rw;
            hw = r;
            encode = PERI_CRG_PLL7_vpll_bypass_enum;
            reset = 0x0;
        } vpll_bypass[26:26];

        enum PERI_CRG_PLL7_vpll_dacpd_enum {
            NORMAL = 0 { name = "Normal"; desc = "Normal operation"; };
            POWER_DOWN = 1 { name = "Power Down"; desc = "Power down"; };
        };

        field {
            name = "vpll_dacpd";
            desc = "VPLL test signal control. 0: normal operation, 1: power down.";
            sw = rw;
            hw = r;
            encode = PERI_CRG_PLL7_vpll_dacpd_enum;
            reset = 0x0;
        } vpll_dacpd[25:25];

        enum PERI_CRG_PLL7_vpll_dsmpd_enum {
            FRACTIONAL = 0 { name = "Fractional"; desc = "Fractional mode"; };
            INTEGER = 1 { name = "Integer"; desc = "Integer mode"; };
        };

        field {
            name = "vpll_dsmpd";
            desc = "VPLL fractional divider control. 0: fractional mode, 1: integer mode.";
            sw = rw;
            hw = r;
            encode = PERI_CRG_PLL7_vpll_dsmpd_enum;
            reset = 0x1;
        } vpll_dsmpd[24:24];

        enum PERI_CRG_PLL7_vpll_pd_enum {
            NORMAL = 0 { name = "Normal"; desc = "Normal operation"; };
            POWER_DOWN = 1 { name = "Power Down"; desc = "Power down"; };
        };

        field {
            name = "vpll_pd";
            desc = "VPLL power-down control. 0: normal operation, 1: power down.";
            sw = rw;
            hw = r;
            encode = PERI_CRG_PLL7_vpll_pd_enum;
            reset = 0x0;
        } vpll_pd[23:23];

        enum PERI_CRG_PLL7_vpll_postdivpd_enum {
            CLOCK_OUTPUT = 0 { name = "Clock Output"; desc = "Normal clock output"; };
            NO_CLOCK_OUTPUT = 1 { name = "No Clock Output"; desc = "No clock output (the VCO clock is powered down as well)"; };
        };

        field {
            name = "vpll_postdivpd";
            desc = "VPLL POSTDIV output power-down control. 0: normal clock output, 1: no clock output (the VCO clock is powered down as well).";
            sw = rw;
            hw = r;
            encode = PERI_CRG_PLL7_vpll_postdivpd_enum;
            reset = 0x0;
        } vpll_postdivpd[21:21];

        enum PERI_CRG_PLL7_vpll_fout4phasepd_enum {
            CLOCK_OUTPUT = 0 { name = "Clock Output"; desc = "Normal clock output"; };
            NO_CLOCK_OUTPUT = 1 { name = "No Clock Output"; desc = "No clock output"; };
        };

        field {
            name = "vpll_fout4phasepd";
            desc = "VPLL FOUT output power-down control. 0: normal clock output, 1: no clock output.";
            sw = rw;
            hw = r;
            encode = PERI_CRG_PLL7_vpll_fout4phasepd_enum;
            reset = 0x0;
        } vpll_fout4phasepd[20:20];

        field {
            name = "vpll_refdiv";
            desc = "VPLL reference clock divider (refdiv).";
            sw = rw;
            hw = r;
            reset = 0x1;
        } vpll_refdiv[17:12];

        field {
            name = "vpll_fbdiv";
            desc = "VPLL integer part of the feedback multiplier (fbdiv).";
            sw = rw;
            hw = r;
            reset = 0x2E;
        } vpll_fbdiv[11:0];
    } PERI_CRG_PLL7 @ 0x1C;

    reg {
        name = "CPU frequency mode and reset configuration register";
        desc = "CPU frequency mode and reset configuration register.

Reset 0x5: arm_core1_srst_req = 1 (the second Cortex-A7 core starts held in reset), arm_core0_srst_req = 0 and pclkdbg_cken = 1. 1 = reset in every *_srst_req bit. The data sheet notes: not writable by a non-secure CPU in secure mode.

Data sheet 3.2.6 PERI_CRG30 (offset 0x78, printed page 3-16, `hi3516av300--Hi3516AV300-Datasheet.txt` line 6981).";

        enum PERI_CRG30_cs_srst_req_enum {
            DEASSERT_RESET = 0 { name = "Deassert Reset"; desc = "Deassert reset"; };
            ASSERT_RESET = 1 { name = "Assert Reset"; desc = "Reset"; };
        };

        field {
            name = "cs_srst_req";
            desc = "CS soft reset request. 0: deassert reset, 1: reset.";
            sw = rw;
            hw = r;
            encode = PERI_CRG30_cs_srst_req_enum;
            reset = 0x0;
        } cs_srst_req[10:10];

        enum PERI_CRG30_socdbg_srst_req_enum {
            DEASSERT_RESET = 0 { name = "Deassert Reset"; desc = "Deassert reset"; };
            ASSERT_RESET = 1 { name = "Assert Reset"; desc = "Reset"; };
        };

        field {
            name = "socdbg_srst_req";
            desc = "SOCDBG soft reset request. 0: deassert reset, 1: reset.";
            sw = rw;
            hw = r;
            encode = PERI_CRG30_socdbg_srst_req_enum;
            reset = 0x0;
        } socdbg_srst_req[9:9];

        enum PERI_CRG30_l2_srst_req_enum {
            DEASSERT_RESET = 0 { name = "Deassert Reset"; desc = "Deassert reset"; };
            ASSERT_RESET = 1 { name = "Assert Reset"; desc = "Reset"; };
        };

        field {
            name = "l2_srst_req";
            desc = "L2 soft reset request. 0: deassert reset, 1: reset.";
            sw = rw;
            hw = r;
            encode = PERI_CRG30_l2_srst_req_enum;
            reset = 0x0;
        } l2_srst_req[8:8];

        enum PERI_CRG30_arm_dbg1_srst_req_enum {
            DEASSERT_RESET = 0 { name = "Deassert Reset"; desc = "Deassert reset"; };
            ASSERT_RESET = 1 { name = "Assert Reset"; desc = "Reset"; };
        };

        field {
            name = "arm_dbg1_srst_req";
            desc = "ARM DBG1 soft reset request. 0: deassert reset, 1: reset.";
            sw = rw;
            hw = r;
            encode = PERI_CRG30_arm_dbg1_srst_req_enum;
            reset = 0x0;
        } arm_dbg1_srst_req[4:4];

        enum PERI_CRG30_arm_dbg0_srst_req_enum {
            DEASSERT_RESET = 0 { name = "Deassert Reset"; desc = "Deassert reset"; };
            ASSERT_RESET = 1 { name = "Assert Reset"; desc = "Reset"; };
        };

        field {
            name = "arm_dbg0_srst_req";
            desc = "ARM DBG0 soft reset request. 0: deassert reset, 1: reset.";
            sw = rw;
            hw = r;
            encode = PERI_CRG30_arm_dbg0_srst_req_enum;
            reset = 0x0;
        } arm_dbg0_srst_req[3:3];

        enum PERI_CRG30_arm_core1_srst_req_enum {
            DEASSERT_RESET = 0 { name = "Deassert Reset"; desc = "Deassert reset"; };
            ASSERT_RESET = 1 { name = "Assert Reset"; desc = "Reset"; };
        };

        field {
            name = "arm_core1_srst_req";
            desc = "ARM CORE1 soft reset request. 0: deassert reset, 1: reset.";
            sw = rw;
            hw = r;
            encode = PERI_CRG30_arm_core1_srst_req_enum;
            reset = 0x1;
        } arm_core1_srst_req[2:2];

        enum PERI_CRG30_arm_core0_srst_req_enum {
            DEASSERT_RESET = 0 { name = "Deassert Reset"; desc = "Deassert reset"; };
            ASSERT_RESET = 1 { name = "Assert Reset"; desc = "Reset"; };
        };

        field {
            name = "arm_core0_srst_req";
            desc = "ARM CORE0 soft reset request. 0: deassert reset, 1: reset.";
            sw = rw;
            hw = r;
            encode = PERI_CRG30_arm_core0_srst_req_enum;
            reset = 0x0;
        } arm_core0_srst_req[1:1];

        enum PERI_CRG30_pclkdbg_cken_enum {
            CLOCK_OFF = 0 { name = "Clock Off"; desc = "Clock off"; };
            CLOCK_ON = 1 { name = "Clock On"; desc = "Clock on"; };
        };

        field {
            name = "pclkdbg_cken";
            desc = "A7 PCLKDBG clock gate. 0: clock off, 1: clock on.";
            sw = rw;
            hw = r;
            encode = PERI_CRG30_pclkdbg_cken_enum;
            reset = 0x1;
        } pclkdbg_cken[0:0];
    } PERI_CRG30 @ 0x78;

    reg {
        name = "DDR clock and reset configuration register";
        desc = "DDR clock and reset configuration register.

DDR controller clocks and resets. Reset 0xF0: all four DDR clock gates on, resets deasserted. The data sheet notes: not writable by a non-secure CPU in secure mode.

Data sheet 3.2.6 PERI_CRG31 (offset 0x7C, printed page 3-17, `hi3516av300--Hi3516AV300-Datasheet.txt` line 7050).";

        enum PERI_CRG31_ddr_cken_enum {
            CLOCK_OFF = 0 { name = "Clock Off"; desc = "Clock off"; };
            CLOCK_ON = 1 { name = "Clock On"; desc = "Clock on"; };
        };

        field {
            name = "ddr_cken";
            desc = "DDR clock gate. 0: clock off, 1: clock on.";
            sw = rw;
            hw = r;
            encode = PERI_CRG31_ddr_cken_enum;
            reset = 0x1;
        } ddr_cken[7:7];

        enum PERI_CRG31_ddr_apb_cken_enum {
            CLOCK_OFF = 0 { name = "Clock Off"; desc = "Clock off"; };
            CLOCK_ON = 1 { name = "Clock On"; desc = "Clock on"; };
        };

        field {
            name = "ddr_apb_cken";
            desc = "DDR APB clock gate. 0: clock off, 1: clock on.";
            sw = rw;
            hw = r;
            encode = PERI_CRG31_ddr_apb_cken_enum;
            reset = 0x1;
        } ddr_apb_cken[6:6];

        enum PERI_CRG31_ddr_hipack_cken_enum {
            CLOCK_OFF = 0 { name = "Clock Off"; desc = "Clock off"; };
            CLOCK_ON = 1 { name = "Clock On"; desc = "Clock on"; };
        };

        field {
            name = "ddr_hipack_cken";
            desc = "DDR HiPACK clock gate. 0: clock off, 1: clock on.";
            sw = rw;
            hw = r;
            encode = PERI_CRG31_ddr_hipack_cken_enum;
            reset = 0x1;
        } ddr_hipack_cken[5:5];

        enum PERI_CRG31_ddr_cfg_cken_enum {
            CLOCK_OFF = 0 { name = "Clock Off"; desc = "Clock off"; };
            CLOCK_ON = 1 { name = "Clock On"; desc = "Clock on"; };
        };

        field {
            name = "ddr_cfg_cken";
            desc = "DDR CFG clock gate. 0: clock off, 1: clock on.";
            sw = rw;
            hw = r;
            encode = PERI_CRG31_ddr_cfg_cken_enum;
            reset = 0x1;
        } ddr_cfg_cken[4:4];

        enum PERI_CRG31_ddr_apb_srst_req_enum {
            DEASSERT_RESET = 0 { name = "Deassert Reset"; desc = "Deassert reset"; };
            ASSERT_RESET = 1 { name = "Assert Reset"; desc = "Reset"; };
        };

        field {
            name = "ddr_apb_srst_req";
            desc = "DDR APB soft reset request. 0: deassert reset, 1: reset.";
            sw = rw;
            hw = r;
            encode = PERI_CRG31_ddr_apb_srst_req_enum;
            reset = 0x0;
        } ddr_apb_srst_req[1:1];

        enum PERI_CRG31_ddr_hipack_srst_req_enum {
            DEASSERT_RESET = 0 { name = "Deassert Reset"; desc = "Deassert reset"; };
            ASSERT_RESET = 1 { name = "Assert Reset"; desc = "Reset"; };
        };

        field {
            name = "ddr_hipack_srst_req";
            desc = "DDR HiPACK soft reset request. 0: deassert reset, 1: reset.";
            sw = rw;
            hw = r;
            encode = PERI_CRG31_ddr_hipack_srst_req_enum;
            reset = 0x0;
        } ddr_hipack_srst_req[0:0];
    } PERI_CRG31 @ 0x7C;

    reg {
        name = "SoC clock selection register";
        desc = "SoC clock selection register.

All the selects reset to 0 = 24 MHz crystal, so the chip boots from the crystal and the boot code switches to the PLL clocks. After writing a select, poll the matching *_sc_seled field of PERI_CRG120. The selectable frequencies match data sheet Table 3-2 (A7: 24/600/792/900; DDR: 24/360/396/450 plus EPLL POSTDIV; SYSAXI: 24/200(198)/300; SYSCFG: 24/148.5; SYSAPB: 24/50 MHz). The vendor Linux driver (clk-hi3516dv300.c, same CRG layout) uses sysaxi 0x80[7:6] {24m, 200m, 300m} and sysapb 0x80[10] {24m, 50m}.

Data sheet 3.2.6 PERI_CRG32 (offset 0x80, printed page 3-18, `hi3516av300--Hi3516AV300-Datasheet.txt` line 7102).";

        enum PERI_CRG32_sysapb_cksel_enum {
            XTAL_24MHZ = 0 { name = "Xtal 24Mhz"; desc = "Crystal clock (24 MHz)"; };
            CLK_50MHZ = 1 { name = "Clk 50Mhz"; desc = "50 MHz"; };
        };

        field {
            name = "sysapb_cksel";
            desc = "SYSAPB clock select. System APB clock (parent of the UART/I2C/SPI/GPIO/timer/watchdog blocks; the SP804 timers count it when SC_CTRL timerenNov = 1). Switch completion is reported in PERI_CRG120 sysapb_sc_seled. 0: crystal clock (24 MHz), 1: 50 MHz.";
            sw = rw;
            hw = r;
            encode = PERI_CRG32_sysapb_cksel_enum;
            reset = 0x0;
        } sysapb_cksel[10:10];

        enum PERI_CRG32_syscfg_cksel_enum {
            XTAL_24MHZ = 0 { name = "Xtal 24Mhz"; desc = "Crystal clock (24 MHz)"; };
            CLK_148P5MHZ = 1 { name = "Clk 148P5Mhz"; desc = "148.5 MHz"; };
        };

        field {
            name = "syscfg_cksel";
            desc = "SYSCFG clock select. Switch completion is reported in PERI_CRG120 syscfg_sc_seled. 0: crystal clock (24 MHz), 1: 148.5 MHz.";
            sw = rw;
            hw = r;
            encode = PERI_CRG32_syscfg_cksel_enum;
            reset = 0x0;
        } syscfg_cksel[8:8];

        enum PERI_CRG32_sysaxi_cksel_enum {
            XTAL_24MHZ = 0 { name = "Xtal 24Mhz"; desc = "Crystal clock (24 MHz)"; };
            CLK_200MHZ = 1 { name = "Clk 200Mhz"; desc = "200 MHz"; };
            CLK_300MHZ = 2 { name = "Clk 300Mhz"; desc = "300 MHz"; };
            RESERVED_3 = 3 { name = "Reserved 3"; desc = "Reserved"; };
        };

        field {
            name = "sysaxi_cksel";
            desc = "SYSAXI clock select. Switch completion is reported in PERI_CRG120 sysaxi_sc_seled. The data sheet Table 3-2 lists 198 MHz for the 01 setting; this bit table (and the vendor Linux clock driver) say 200 MHz.";
            sw = rw;
            hw = r;
            encode = PERI_CRG32_sysaxi_cksel_enum;
            reset = 0x0;
        } sysaxi_cksel[7:6];

        enum PERI_CRG32_ddr_cksel_enum {
            XTAL_24MHZ = 0 { name = "Xtal 24Mhz"; desc = "Crystal clock (24 MHz)"; };
            CLK_360MHZ = 1 { name = "Clk 360Mhz"; desc = "360 MHz"; };
            CLK_396MHZ = 2 { name = "Clk 396Mhz"; desc = "396 MHz"; };
            CLK_450MHZ = 3 { name = "Clk 450Mhz"; desc = "450 MHz"; };
            EPLL_FOUTPOSTDIV = 4 { name = "Epll Foutpostdiv"; desc = "EPLL FOUTPOSTDIV clock"; };
            RESERVED_5 = 5 { name = "Reserved 5"; desc = "Reserved"; };
            RESERVED_6 = 6 { name = "Reserved 6"; desc = "Reserved"; };
            RESERVED_7 = 7 { name = "Reserved 7"; desc = "Reserved"; };
        };

        field {
            name = "ddr_cksel";
            desc = "DDR clock select. Switch completion is reported in PERI_CRG120 ddr_sc_seled. Option 4 takes the EPLL POSTDIV output (the EPLL is user-programmable).";
            sw = rw;
            hw = r;
            encode = PERI_CRG32_ddr_cksel_enum;
            reset = 0x0;
        } ddr_cksel[5:3];

        enum PERI_CRG32_a7_cksel_enum {
            XTAL_24MHZ = 0 { name = "Xtal 24Mhz"; desc = "Crystal clock (24 MHz)"; };
            CLK_600MHZ = 1 { name = "Clk 600Mhz"; desc = "600 MHz"; };
            CLK_792MHZ = 2 { name = "Clk 792Mhz"; desc = "792 MHz"; };
            CLK_900MHZ = 3 { name = "Clk 900Mhz"; desc = "900 MHz"; };
            RESERVED_4 = 4 { name = "Reserved 4"; desc = "Reserved"; };
            RESERVED_5 = 5 { name = "Reserved 5"; desc = "Reserved"; };
            RESERVED_6 = 6 { name = "Reserved 6"; desc = "Reserved"; };
            RESERVED_7 = 7 { name = "Reserved 7"; desc = "Reserved"; };
        };

        field {
            name = "a7_cksel";
            desc = "A7 clock select. Cortex-A7 core clock. Switch completion is reported in PERI_CRG120 a7_sc_seled.";
            sw = rw;
            hw = r;
            encode = PERI_CRG32_a7_cksel_enum;
            reset = 0x0;
        } a7_cksel[2:0];
    } PERI_CRG32 @ 0x80;

    reg {
        name = "Media function module frequency configuration register";
        desc = "Media function module frequency configuration register.

Media module frequency selects. Reset 0x00792CF0. Selecting 396 MHz for VPSS requires PERI_CRG61[25] (vicap_400m_cken) to be 1 first. Data sheet Table 3-2: VPSS 150/300/396/475 MHz (default 150), IVE 300/396/475, VGS and GDC 300/396/450/475 MHz (default 300).

Total reset value 0x00792CF0 (data sheet header; it includes the non-zero reset values of reserved rows, which are modelled as read-only fields: reserved_nz_20_20, reserved_nz_19_18, reserved_nz_14_13, reserved_nz_12_10).

Data sheet 3.2.6 PERI_CRG40 (offset 0xA0, printed page 3-19, `hi3516av300--Hi3516AV300-Datasheet.txt` line 7171).";

        enum PERI_CRG40_vpss_cksel_enum {
            CLK_475MHZ = 0 { name = "Clk 475Mhz"; desc = "475 MHz"; };
            CLK_396MHZ = 1 { name = "Clk 396Mhz"; desc = "396 MHz (set PERI_CRG61[25] to 1 first)"; };
            CLK_300MHZ = 2 { name = "Clk 300Mhz"; desc = "300 MHz"; };
            CLK_150MHZ = 3 { name = "Clk 150Mhz"; desc = "150 MHz"; };
            RESERVED_4 = 4 { name = "Reserved 4"; desc = "Reserved"; };
            RESERVED_5 = 5 { name = "Reserved 5"; desc = "Reserved"; };
            RESERVED_6 = 6 { name = "Reserved 6"; desc = "Reserved"; };
            RESERVED_7 = 7 { name = "Reserved 7"; desc = "Reserved"; };
        };

        field {
            name = "vpss_cksel";
            desc = "VPSS clock select.";
            sw = rw;
            hw = r;
            encode = PERI_CRG40_vpss_cksel_enum;
            reset = 0x3;
        } vpss_cksel[23:21];

        field {
            name = "reserved_nz_20_20";
            desc = "Reserved bits; the data sheet lists a non-zero reset value for this reserved row, which is part of the total reset value (reset 0x1).";
            sw = r;
            hw = na;
            reset = 0x1;
        } reserved_nz_20_20[20:20];

        field {
            name = "reserved_nz_19_18";
            desc = "Reserved bits; the data sheet lists a non-zero reset value for this reserved row, which is part of the total reset value (reset 0x2).";
            sw = r;
            hw = na;
            reset = 0x2;
        } reserved_nz_19_18[19:18];

        enum PERI_CRG40_ive_cksel_enum {
            CLK_475MHZ = 0 { name = "Clk 475Mhz"; desc = "475 MHz"; };
            CLK_396MHZ = 1 { name = "Clk 396Mhz"; desc = "396 MHz"; };
            CLK_300MHZ = 2 { name = "Clk 300Mhz"; desc = "300 MHz"; };
            RESERVED_3 = 3 { name = "Reserved 3"; desc = "Reserved"; };
            RESERVED_4 = 4 { name = "Reserved 4"; desc = "Reserved"; };
            RESERVED_5 = 5 { name = "Reserved 5"; desc = "Reserved"; };
            RESERVED_6 = 6 { name = "Reserved 6"; desc = "Reserved"; };
            RESERVED_7 = 7 { name = "Reserved 7"; desc = "Reserved"; };
        };

        field {
            name = "ive_cksel";
            desc = "IVE clock select. Reset value 2 selects 300 MHz, but data sheet Table 3-2 gives 475 MHz as the IVE default (data sheet inconsistency, the bit table is used).";
            sw = rw;
            hw = r;
            encode = PERI_CRG40_ive_cksel_enum;
            reset = 0x2;
        } ive_cksel[17:15];

        field {
            name = "reserved_nz_14_13";
            desc = "Reserved bits; the data sheet lists a non-zero reset value for this reserved row, which is part of the total reset value (reset 0x1).";
            sw = r;
            hw = na;
            reset = 0x1;
        } reserved_nz_14_13[14:13];

        field {
            name = "reserved_nz_12_10";
            desc = "Reserved bits; the data sheet lists a non-zero reset value for this reserved row, which is part of the total reset value (reset 0x3).";
            sw = r;
            hw = na;
            reset = 0x3;
        } reserved_nz_12_10[12:10];

        enum PERI_CRG40_vgs_cksel_enum {
            CLK_475MHZ = 0 { name = "Clk 475Mhz"; desc = "475 MHz"; };
            CLK_450MHZ = 1 { name = "Clk 450Mhz"; desc = "450 MHz"; };
            CLK_396MHZ = 2 { name = "Clk 396Mhz"; desc = "396 MHz"; };
            CLK_300MHZ = 3 { name = "Clk 300Mhz"; desc = "300 MHz"; };
            RESERVED_4 = 4 { name = "Reserved 4"; desc = "Reserved"; };
            RESERVED_5 = 5 { name = "Reserved 5"; desc = "Reserved"; };
            RESERVED_6 = 6 { name = "Reserved 6"; desc = "Reserved"; };
            RESERVED_7 = 7 { name = "Reserved 7"; desc = "Reserved"; };
        };

        field {
            name = "vgs_cksel";
            desc = "VGS clock select.";
            sw = rw;
            hw = r;
            encode = PERI_CRG40_vgs_cksel_enum;
            reset = 0x3;
        } vgs_cksel[8:6];

        enum PERI_CRG40_gdc_cksel_enum {
            CLK_475MHZ = 0 { name = "Clk 475Mhz"; desc = "475 MHz"; };
            CLK_450MHZ = 1 { name = "Clk 450Mhz"; desc = "450 MHz"; };
            CLK_396MHZ = 2 { name = "Clk 396Mhz"; desc = "396 MHz"; };
            CLK_300MHZ = 3 { name = "Clk 300Mhz"; desc = "300 MHz"; };
        };

        field {
            name = "gdc_cksel";
            desc = "GDC clock select.";
            sw = rw;
            hw = r;
            encode = PERI_CRG40_gdc_cksel_enum;
            reset = 0x3;
        } gdc_cksel[5:4];

        enum PERI_CRG40_pll_50m_cksel_enum {
            CLK_50MHZ = 0 { name = "Clk 50Mhz"; desc = "50 MHz derived from the APLL"; };
            CLK_50MHZ_2 = 1 { name = "Clk 50Mhz 2"; desc = "50 MHz derived from the EPLL"; };
        };

        field {
            name = "pll_50m_cksel";
            desc = "Source PLL of the 50 MHz clock. 0: 50 MHz derived from the APLL, 1: 50 MHz derived from the EPLL.";
            sw = rw;
            hw = r;
            encode = PERI_CRG40_pll_50m_cksel_enum;
            reset = 0x0;
        } pll_50m_cksel[0:0];
    } PERI_CRG40 @ 0xA0;

    reg {
        name = "VEDU clock and soft reset control register";
        desc = "VEDU clock and soft reset control register.

VEDU clock/reset. The field [2] is named sed_cksel in the bit table but is described as the SED clock gate (data sheet name/description mismatch; the access type RW and the clock-gate description are kept).

Data sheet 3.2.6 PERI_CRG41 (offset 0xA4, printed page 3-20, `hi3516av300--Hi3516AV300-Datasheet.txt` line 7254).";

        enum PERI_CRG41_sed_cksel_enum {
            CLOCK_OFF = 0 { name = "Clock Off"; desc = "Clock off"; };
            CLOCK_ON = 1 { name = "Clock On"; desc = "Clock on"; };
        };

        field {
            name = "sed_cksel";
            desc = "SED clock gate. 0: clock off, 1: clock on.";
            sw = rw;
            hw = r;
            encode = PERI_CRG41_sed_cksel_enum;
            reset = 0x0;
        } sed_cksel[2:2];

        enum PERI_CRG41_vedu_cken_enum {
            CLOCK_OFF = 0 { name = "Clock Off"; desc = "Clock off"; };
            CLOCK_ON = 1 { name = "Clock On"; desc = "Clock on"; };
        };

        field {
            name = "vedu_cken";
            desc = "VEDU clock gate. 0: clock off, 1: clock on.";
            sw = rw;
            hw = r;
            encode = PERI_CRG41_vedu_cken_enum;
            reset = 0x0;
        } vedu_cken[1:1];

        enum PERI_CRG41_vedu_srst_req_enum {
            DEASSERT_RESET = 0 { name = "Deassert Reset"; desc = "Deassert reset"; };
            ASSERT_RESET = 1 { name = "Assert Reset"; desc = "Reset"; };
        };

        field {
            name = "vedu_srst_req";
            desc = "VEDU soft reset request. 0: deassert reset, 1: reset.";
            sw = rw;
            hw = r;
            encode = PERI_CRG41_vedu_srst_req_enum;
            reset = 0x0;
        } vedu_srst_req[0:0];
    } PERI_CRG41 @ 0xA4;

    reg {
        name = "VPSS clock and soft reset control register";
        desc = "VPSS clock and soft reset control register.

VPSS clock/reset. vpss_online_cksel selects the clock in online mode (use together with MISC_CTRL6 viproc_vpss_online_mode).

Data sheet 3.2.6 PERI_CRG42 (offset 0xA8, printed page 3-20, `hi3516av300--Hi3516AV300-Datasheet.txt` line 7286).";

        enum PERI_CRG42_vpss_online_cksel_enum {
            OFFLINE_CLOCK = 0 { name = "Offline Clock"; desc = "PERI_CRG40 vpss_cksel (the offline clock is selected)"; };
            ONLINE_CLOCK = 1 { name = "Online Clock"; desc = "PERI_CRG63 viproc_cksel"; };
        };

        field {
            name = "vpss_online_cksel";
            desc = "VPSS online-mode clock select. Used together with MISC_CTRL6 viproc_vpss_online_mode. 0: PERI_CRG40 vpss_cksel (the offline clock is selected), 1: PERI_CRG63 viproc_cksel.";
            sw = rw;
            hw = r;
            encode = PERI_CRG42_vpss_online_cksel_enum;
            reset = 0x0;
        } vpss_online_cksel[2:2];

        enum PERI_CRG42_vpss_cken_enum {
            CLOCK_OFF = 0 { name = "Clock Off"; desc = "Clock off"; };
            CLOCK_ON = 1 { name = "Clock On"; desc = "Clock on"; };
        };

        field {
            name = "vpss_cken";
            desc = "VPSS clock gate. 0: clock off, 1: clock on.";
            sw = rw;
            hw = r;
            encode = PERI_CRG42_vpss_cken_enum;
            reset = 0x0;
        } vpss_cken[1:1];

        enum PERI_CRG42_vpss_srst_req_enum {
            DEASSERT_RESET = 0 { name = "Deassert Reset"; desc = "Deassert reset"; };
            ASSERT_RESET = 1 { name = "Assert Reset"; desc = "Reset"; };
        };

        field {
            name = "vpss_srst_req";
            desc = "VPSS soft reset request. 0: deassert reset, 1: reset.";
            sw = rw;
            hw = r;
            encode = PERI_CRG42_vpss_srst_req_enum;
            reset = 0x0;
        } vpss_srst_req[0:0];
    } PERI_CRG42 @ 0xA8;

    reg {
        name = "VGS clock and soft reset control register";
        desc = "VGS clock and soft reset control register.

VGS clock/reset. Reset 0x2: clock on.

Data sheet 3.2.6 PERI_CRG43 (offset 0xAC, printed page 3-21, `hi3516av300--Hi3516AV300-Datasheet.txt` line 7327).";

        enum PERI_CRG43_vgs_cken_enum {
            CLOCK_OFF = 0 { name = "Clock Off"; desc = "Clock off"; };
            CLOCK_ON = 1 { name = "Clock On"; desc = "Clock on"; };
        };

        field {
            name = "vgs_cken";
            desc = "VGS clock gate. 0: clock off, 1: clock on.";
            sw = rw;
            hw = r;
            encode = PERI_CRG43_vgs_cken_enum;
            reset = 0x1;
        } vgs_cken[1:1];

        enum PERI_CRG43_vgs_srst_req_enum {
            DEASSERT_RESET = 0 { name = "Deassert Reset"; desc = "Deassert reset"; };
            ASSERT_RESET = 1 { name = "Assert Reset"; desc = "Reset"; };
        };

        field {
            name = "vgs_srst_req";
            desc = "VGS soft reset request. 0: deassert reset, 1: reset.";
            sw = rw;
            hw = r;
            encode = PERI_CRG43_vgs_srst_req_enum;
            reset = 0x0;
        } vgs_srst_req[0:0];
    } PERI_CRG43 @ 0xAC;

    reg {
        name = "JPGE clock and soft reset control register";
        desc = "JPGE clock and soft reset control register.

Data sheet 3.2.6 PERI_CRG44 (offset 0xB0, printed page 3-21, `hi3516av300--Hi3516AV300-Datasheet.txt` line 7353).";

        enum PERI_CRG44_jpge_cken_enum {
            CLOCK_OFF = 0 { name = "Clock Off"; desc = "Clock off"; };
            CLOCK_ON = 1 { name = "Clock On"; desc = "Clock on"; };
        };

        field {
            name = "jpge_cken";
            desc = "JPGE clock gate. 0: clock off, 1: clock on.";
            sw = rw;
            hw = r;
            encode = PERI_CRG44_jpge_cken_enum;
            reset = 0x0;
        } jpge_cken[1:1];

        enum PERI_CRG44_jpge_srst_req_enum {
            DEASSERT_RESET = 0 { name = "Deassert Reset"; desc = "Deassert reset"; };
            ASSERT_RESET = 1 { name = "Assert Reset"; desc = "Reset"; };
        };

        field {
            name = "jpge_srst_req";
            desc = "JPGE soft reset request. 0: deassert reset, 1: reset.";
            sw = rw;
            hw = r;
            encode = PERI_CRG44_jpge_srst_req_enum;
            reset = 0x0;
        } jpge_srst_req[0:0];
    } PERI_CRG44 @ 0xB0;

    reg {
        name = "GDC clock and soft reset control register";
        desc = "GDC clock and soft reset control register.

Data sheet 3.2.6 PERI_CRG45 (offset 0xB4, printed page 3-22, `hi3516av300--Hi3516AV300-Datasheet.txt` line 7380).";

        enum PERI_CRG45_gdc_cken_enum {
            CLOCK_OFF = 0 { name = "Clock Off"; desc = "Clock off"; };
            CLOCK_ON = 1 { name = "Clock On"; desc = "Clock on"; };
        };

        field {
            name = "gdc_cken";
            desc = "GDC clock gate. 0: clock off, 1: clock on.";
            sw = rw;
            hw = r;
            encode = PERI_CRG45_gdc_cken_enum;
            reset = 0x0;
        } gdc_cken[1:1];

        enum PERI_CRG45_gdc_srst_req_enum {
            DEASSERT_RESET = 0 { name = "Deassert Reset"; desc = "Deassert reset"; };
            ASSERT_RESET = 1 { name = "Assert Reset"; desc = "Reset"; };
        };

        field {
            name = "gdc_srst_req";
            desc = "GDC soft reset request. 0: deassert reset, 1: reset.";
            sw = rw;
            hw = r;
            encode = PERI_CRG45_gdc_srst_req_enum;
            reset = 0x0;
        } gdc_srst_req[0:0];
    } PERI_CRG45 @ 0xB4;

    reg {
        name = "TDE clock and soft reset control register";
        desc = "TDE clock and soft reset control register.

Data sheet 3.2.6 PERI_CRG46 (offset 0xB8, printed page 3-22, `hi3516av300--Hi3516AV300-Datasheet.txt` line 7410).";

        enum PERI_CRG46_tde_cken_enum {
            CLOCK_OFF = 0 { name = "Clock Off"; desc = "Clock off"; };
            CLOCK_ON = 1 { name = "Clock On"; desc = "Clock on"; };
        };

        field {
            name = "tde_cken";
            desc = "TDE clock gate. 0: clock off, 1: clock on.";
            sw = rw;
            hw = r;
            encode = PERI_CRG46_tde_cken_enum;
            reset = 0x0;
        } tde_cken[1:1];

        enum PERI_CRG46_tde_srst_req_enum {
            DEASSERT_RESET = 0 { name = "Deassert Reset"; desc = "Deassert reset"; };
            ASSERT_RESET = 1 { name = "Assert Reset"; desc = "Reset"; };
        };

        field {
            name = "tde_srst_req";
            desc = "TDE soft reset request. 0: deassert reset, 1: reset.";
            sw = rw;
            hw = r;
            encode = PERI_CRG46_tde_srst_req_enum;
            reset = 0x0;
        } tde_srst_req[0:0];
    } PERI_CRG46 @ 0xB8;

    reg {
        name = "IVE clock and soft reset control register";
        desc = "IVE clock and soft reset control register.

IVE clock/reset. Reset 0x4: ive_cts_cken = 1, ive_cken = 0.

Data sheet 3.2.6 PERI_CRG48 (offset 0xC0, printed page 3-23, `hi3516av300--Hi3516AV300-Datasheet.txt` line 7438).";

        enum PERI_CRG48_ive_cts_cken_enum {
            CLOCK_OFF = 0 { name = "Clock Off"; desc = "Clock off"; };
            CLOCK_ON = 1 { name = "Clock On"; desc = "Clock on"; };
        };

        field {
            name = "ive_cts_cken";
            desc = "IVE clock tree gate (low-power setting). The IVE only gets a clock when this bit and ive_cken are both on. 0: clock off, 1: clock on.";
            sw = rw;
            hw = r;
            encode = PERI_CRG48_ive_cts_cken_enum;
            reset = 0x1;
        } ive_cts_cken[2:2];

        enum PERI_CRG48_ive_cken_enum {
            CLOCK_OFF = 0 { name = "Clock Off"; desc = "Clock off"; };
            CLOCK_ON = 1 { name = "Clock On"; desc = "Clock on"; };
        };

        field {
            name = "ive_cken";
            desc = "IVE clock gate. The IVE only gets a clock when this bit and ive_cts_cken are both on. 0: clock off, 1: clock on.";
            sw = rw;
            hw = r;
            encode = PERI_CRG48_ive_cken_enum;
            reset = 0x0;
        } ive_cken[1:1];

        enum PERI_CRG48_ive_srst_req_enum {
            DEASSERT_RESET = 0 { name = "Deassert Reset"; desc = "Deassert reset"; };
            ASSERT_RESET = 1 { name = "Assert Reset"; desc = "Reset"; };
        };

        field {
            name = "ive_srst_req";
            desc = "IVE soft reset request. 0: deassert reset, 1: reset.";
            sw = rw;
            hw = r;
            encode = PERI_CRG48_ive_srst_req_enum;
            reset = 0x0;
        } ive_srst_req[0:0];
    } PERI_CRG48 @ 0xC0;

    reg {
        name = "JPGD clock and soft reset control register";
        desc = "JPGD clock and soft reset control register.

Data sheet 3.2.6 PERI_CRG49 (offset 0xC4, printed page 3-23, `hi3516av300--Hi3516AV300-Datasheet.txt` line 7474).";

        enum PERI_CRG49_jpgd_cken_enum {
            CLOCK_OFF = 0 { name = "Clock Off"; desc = "Clock off"; };
            CLOCK_ON = 1 { name = "Clock On"; desc = "Clock on"; };
        };

        field {
            name = "jpgd_cken";
            desc = "JPGD clock gate. 0: clock off, 1: clock on.";
            sw = rw;
            hw = r;
            encode = PERI_CRG49_jpgd_cken_enum;
            reset = 0x0;
        } jpgd_cken[1:1];

        enum PERI_CRG49_jpgd_srst_req_enum {
            DEASSERT_RESET = 0 { name = "Deassert Reset"; desc = "Deassert reset"; };
            ASSERT_RESET = 1 { name = "Assert Reset"; desc = "Reset"; };
        };

        field {
            name = "jpgd_srst_req";
            desc = "JPGD soft reset request. 0: deassert reset, 1: reset.";
            sw = rw;
            hw = r;
            encode = PERI_CRG49_jpgd_srst_req_enum;
            reset = 0x0;
        } jpgd_srst_req[0:0];
    } PERI_CRG49 @ 0xC4;

    reg {
        name = "SENSOR clock and soft reset control register";
        desc = "SENSOR clock and soft reset control register.

Sensor reference clock outputs. Reset 0x41: both clock gates on (bits 6 and 0), clock select 0 = 74.25 MHz, resets deasserted. The bit table spells the bit 6 field `sensor1_cken`.

Data sheet 3.2.6 PERI_CRG60 (offset 0xF0, printed page 3-24, `hi3516av300--Hi3516AV300-Datasheet.txt` line 7506).";

        enum PERI_CRG60_sensor1_cksel_enum {
            CLK_74P25MHZ = 0 { name = "Clk 74P25Mhz"; desc = "74.25 MHz"; };
            CLK_72MHZ = 1 { name = "Clk 72Mhz"; desc = "72 MHz"; };
            CLK_54MHZ = 2 { name = "Clk 54Mhz"; desc = "54 MHz"; };
            CLK_50MHZ = 3 { name = "Clk 50Mhz"; desc = "50 MHz"; };
            CLK_24MHZ = 4 { name = "Clk 24Mhz"; desc = "24 MHz (data sheet wildcard row; value 0100)"; };
            CLK_24MHZ_2 = 5 { name = "Clk 24Mhz 2"; desc = "24 MHz (data sheet wildcard row; value 0101)"; };
            CLK_24MHZ_3 = 6 { name = "Clk 24Mhz 3"; desc = "24 MHz (data sheet wildcard row; value 0110)"; };
            CLK_24MHZ_4 = 7 { name = "Clk 24Mhz 4"; desc = "24 MHz (data sheet wildcard row; value 0111)"; };
            CLK_37P125MHZ = 8 { name = "Clk 37P125Mhz"; desc = "37.125 MHz"; };
            CLK_36MHZ = 9 { name = "Clk 36Mhz"; desc = "36 MHz"; };
            CLK_27MHZ = 10 { name = "Clk 27Mhz"; desc = "27 MHz"; };
            CLK_25MHZ = 11 { name = "Clk 25Mhz"; desc = "25 MHz"; };
            CLK_12MHZ = 12 { name = "Clk 12Mhz"; desc = "12 MHz (data sheet wildcard row; value 1100)"; };
            CLK_12MHZ_2 = 13 { name = "Clk 12Mhz 2"; desc = "12 MHz (data sheet wildcard row; value 1101)"; };
            CLK_12MHZ_3 = 14 { name = "Clk 12Mhz 3"; desc = "12 MHz (data sheet wildcard row; value 1110)"; };
            CLK_12MHZ_4 = 15 { name = "Clk 12Mhz 4"; desc = "12 MHz (data sheet wildcard row; value 1111)"; };
        };

        field {
            name = "sensor1_cksel";
            desc = "SENSOR1 CLKOUT (reference clock output to the sensor) frequency select. The wildcard rows 01XX and 11XX of the data sheet are expanded to all matching values.";
            sw = rw;
            hw = r;
            encode = PERI_CRG60_sensor1_cksel_enum;
            reset = 0x0;
        } sensor1_cksel[11:8];

        enum PERI_CRG60_sensor1_srst_req_enum {
            DEASSERT_RESET = 0 { name = "Deassert Reset"; desc = "Deassert reset"; };
            ASSERT_RESET = 1 { name = "Assert Reset"; desc = "Reset"; };
        };

        field {
            name = "sensor1_srst_req";
            desc = "SENSOR1 soft reset request. 0: deassert reset, 1: reset.";
            sw = rw;
            hw = r;
            encode = PERI_CRG60_sensor1_srst_req_enum;
            reset = 0x0;
        } sensor1_srst_req[7:7];

        enum PERI_CRG60_sensor1_cken_enum {
            CLOCK_OFF = 0 { name = "Clock Off"; desc = "Clock off"; };
            CLOCK_ON = 1 { name = "Clock On"; desc = "Clock on"; };
        };

        field {
            name = "sensor1_cken";
            desc = "SENSOR1 CLKOUT clock gate. 0: clock off, 1: clock on.";
            sw = rw;
            hw = r;
            encode = PERI_CRG60_sensor1_cken_enum;
            reset = 0x1;
        } sensor1_cken[6:6];

        enum PERI_CRG60_sensor0_cksel_enum {
            CLK_74P25MHZ = 0 { name = "Clk 74P25Mhz"; desc = "74.25 MHz"; };
            CLK_72MHZ = 1 { name = "Clk 72Mhz"; desc = "72 MHz"; };
            CLK_54MHZ = 2 { name = "Clk 54Mhz"; desc = "54 MHz"; };
            CLK_50MHZ = 3 { name = "Clk 50Mhz"; desc = "50 MHz"; };
            CLK_24MHZ = 4 { name = "Clk 24Mhz"; desc = "24 MHz (data sheet wildcard row; value 0100)"; };
            CLK_24MHZ_2 = 5 { name = "Clk 24Mhz 2"; desc = "24 MHz (data sheet wildcard row; value 0101)"; };
            CLK_24MHZ_3 = 6 { name = "Clk 24Mhz 3"; desc = "24 MHz (data sheet wildcard row; value 0110)"; };
            CLK_24MHZ_4 = 7 { name = "Clk 24Mhz 4"; desc = "24 MHz (data sheet wildcard row; value 0111)"; };
            CLK_37P125MHZ = 8 { name = "Clk 37P125Mhz"; desc = "37.125 MHz"; };
            CLK_36MHZ = 9 { name = "Clk 36Mhz"; desc = "36 MHz"; };
            CLK_27MHZ = 10 { name = "Clk 27Mhz"; desc = "27 MHz"; };
            CLK_25MHZ = 11 { name = "Clk 25Mhz"; desc = "25 MHz"; };
            CLK_12MHZ = 12 { name = "Clk 12Mhz"; desc = "12 MHz (data sheet wildcard row; value 1100)"; };
            CLK_12MHZ_2 = 13 { name = "Clk 12Mhz 2"; desc = "12 MHz (data sheet wildcard row; value 1101)"; };
            CLK_12MHZ_3 = 14 { name = "Clk 12Mhz 3"; desc = "12 MHz (data sheet wildcard row; value 1110)"; };
            CLK_12MHZ_4 = 15 { name = "Clk 12Mhz 4"; desc = "12 MHz (data sheet wildcard row; value 1111)"; };
        };

        field {
            name = "sensor0_cksel";
            desc = "SENSOR0 CLKOUT (reference clock output to the sensor) frequency select. The wildcard rows 01XX and 11XX of the data sheet are expanded to all matching values.";
            sw = rw;
            hw = r;
            encode = PERI_CRG60_sensor0_cksel_enum;
            reset = 0x0;
        } sensor0_cksel[5:2];

        enum PERI_CRG60_sensor0_srst_req_enum {
            DEASSERT_RESET = 0 { name = "Deassert Reset"; desc = "Deassert reset"; };
            ASSERT_RESET = 1 { name = "Assert Reset"; desc = "Reset"; };
        };

        field {
            name = "sensor0_srst_req";
            desc = "SENSOR0 soft reset request. 0: deassert reset, 1: reset.";
            sw = rw;
            hw = r;
            encode = PERI_CRG60_sensor0_srst_req_enum;
            reset = 0x0;
        } sensor0_srst_req[1:1];

        enum PERI_CRG60_sensor0_cken_enum {
            CLOCK_OFF = 0 { name = "Clock Off"; desc = "Clock off"; };
            CLOCK_ON = 1 { name = "Clock On"; desc = "Clock on"; };
        };

        field {
            name = "sensor0_cken";
            desc = "SENSOR0 CLKOUT clock gate. 0: clock off, 1: clock on.";
            sw = rw;
            hw = r;
            encode = PERI_CRG60_sensor0_cken_enum;
            reset = 0x1;
        } sensor0_cken[0:0];
    } PERI_CRG60 @ 0xF0;

    reg {
        name = "VICAP clock and soft reset control register";
        desc = "VICAP clock and soft reset control register.

VICAP clock/reset. The VICAP/PPC/Port clock selects reset to 4 = 300 MHz. Total reset value 0x1F920000: the bit table has reserved rows with non-zero reset ([31:26] = 0x07, [24] = 0x1), modelled as reserved_nz fields so that the register reset equals the header. The layout-dump extraction shows the header as `0x1F920000c` because of watermark noise.

Total reset value 0x1F920000 (data sheet header; it includes the non-zero reset values of reserved rows, which are modelled as read-only fields: reserved_nz_31_26, reserved_nz_24_24).

Data sheet 3.2.6 PERI_CRG61 (offset 0xF4, printed page 3-25, `hi3516av300--Hi3516AV300-Datasheet.txt` line 7585).";

        field {
            name = "reserved_nz_31_26";
            desc = "Reserved bits; the data sheet lists a non-zero reset value for this reserved row, which is part of the total reset value (reset 0x7).";
            sw = r;
            hw = na;
            reset = 0x7;
        } reserved_nz_31_26[31:26];

        enum PERI_CRG61_Vicap_400m_cken_enum {
            CLOCK_OFF = 0 { name = "Clock Off"; desc = "Clock off"; };
            CLOCK_ON = 1 { name = "Clock On"; desc = "Clock on"; };
        };

        field {
            name = "Vicap_400m_cken";
            desc = "VICAP 396 MHz clock gate (low-power setting). This gate must be on before VICAP, ISP, VPSS and VIPROC can select 396 MHz. 0: clock off, 1: clock on.";
            sw = rw;
            hw = r;
            encode = PERI_CRG61_Vicap_400m_cken_enum;
            reset = 0x1;
        } Vicap_400m_cken[25:25];

        field {
            name = "reserved_nz_24_24";
            desc = "Reserved bits; the data sheet lists a non-zero reset value for this reserved row, which is part of the total reset value (reset 0x1).";
            sw = r;
            hw = na;
            reset = 0x1;
        } reserved_nz_24_24[24:24];

        enum PERI_CRG61_vicap_ppc_cksel_enum {
            RESERVED_0 = 0 { name = "Reserved 0"; desc = "Reserved"; };
            RESERVED_1 = 1 { name = "Reserved 1"; desc = "Reserved"; };
            CLK_475MHZ = 2 { name = "Clk 475Mhz"; desc = "475 MHz"; };
            CLK_396MHZ = 3 { name = "Clk 396Mhz"; desc = "396 MHz (set PERI_CRG61[25] to 1 first)"; };
            CLK_300MHZ = 4 { name = "Clk 300Mhz"; desc = "300 MHz"; };
            CLK_150MHZ = 5 { name = "Clk 150Mhz"; desc = "150 MHz"; };
            RESERVED_6 = 6 { name = "Reserved 6"; desc = "Reserved"; };
            RESERVED_7 = 7 { name = "Reserved 7"; desc = "Reserved"; };
        };

        field {
            name = "vicap_ppc_cksel";
            desc = "VICAP PPC clock select.";
            sw = rw;
            hw = r;
            encode = PERI_CRG61_vicap_ppc_cksel_enum;
            reset = 0x4;
        } vicap_ppc_cksel[23:21];

        enum PERI_CRG61_vicap_p1_cksel_enum {
            CLK_475MHZ = 2 { name = "Clk 475Mhz"; desc = "475 MHz"; };
            CLK_396MHZ = 3 { name = "Clk 396Mhz"; desc = "396 MHz (set PERI_CRG61[25] to 1 first)"; };
            CLK_300MHZ = 4 { name = "Clk 300Mhz"; desc = "300 MHz"; };
            CLK_150MHZ = 5 { name = "Clk 150Mhz"; desc = "150 MHz"; };
            EXTERNAL_PIN = 7 { name = "External Pin"; desc = "External pin (CMOS) input clock"; };
        };

        field {
            name = "vicap_p1_cksel";
            desc = "VICAP Port1 clock select.";
            sw = rw;
            hw = r;
            encode = PERI_CRG61_vicap_p1_cksel_enum;
            reset = 0x4;
        } vicap_p1_cksel[20:18];

        enum PERI_CRG61_vicap_p0_cksel_enum {
            RESERVED_0 = 0 { name = "Reserved 0"; desc = "Reserved"; };
            RESERVED_1 = 1 { name = "Reserved 1"; desc = "Reserved"; };
            CLK_475MHZ = 2 { name = "Clk 475Mhz"; desc = "475 MHz"; };
            CLK_396MHZ = 3 { name = "Clk 396Mhz"; desc = "396 MHz (set PERI_CRG61[25] to 1 first)"; };
            CLK_300MHZ = 4 { name = "Clk 300Mhz"; desc = "300 MHz"; };
            CLK_150MHZ = 5 { name = "Clk 150Mhz"; desc = "150 MHz"; };
            RESERVED_6 = 6 { name = "Reserved 6"; desc = "Reserved"; };
            RESERVED_7 = 7 { name = "Reserved 7"; desc = "Reserved"; };
        };

        field {
            name = "vicap_p0_cksel";
            desc = "VICAP Port0 clock select.";
            sw = rw;
            hw = r;
            encode = PERI_CRG61_vicap_p0_cksel_enum;
            reset = 0x4;
        } vicap_p0_cksel[17:15];

        enum PERI_CRG61_vicap_cmos_pctrl_enum {
            NOT_INVERTED = 0 { name = "Not Inverted"; desc = "Clock not inverted"; };
            INVERTED = 1 { name = "Inverted"; desc = "Clock inverted"; };
        };

        field {
            name = "vicap_cmos_pctrl";
            desc = "Clock phase select of the CMOS input. 0: clock not inverted, 1: clock inverted.";
            sw = rw;
            hw = r;
            encode = PERI_CRG61_vicap_cmos_pctrl_enum;
            reset = 0x0;
        } vicap_cmos_pctrl[14:14];

        enum PERI_CRG61_vicap_bus_srst_req_enum {
            NOT_RESET = 0 { name = "Not Reset"; desc = "Not reset"; };
            ASSERT_RESET = 1 { name = "Assert Reset"; desc = "Reset"; };
        };

        field {
            name = "vicap_bus_srst_req";
            desc = "VICAP BUS soft reset request. 0: not reset, 1: reset.";
            sw = rw;
            hw = r;
            encode = PERI_CRG61_vicap_bus_srst_req_enum;
            reset = 0x0;
        } vicap_bus_srst_req[13:13];

        enum PERI_CRG61_vicap_ppc_srst_req_enum {
            NOT_RESET = 0 { name = "Not Reset"; desc = "Not reset"; };
            ASSERT_RESET = 1 { name = "Assert Reset"; desc = "Reset"; };
        };

        field {
            name = "vicap_ppc_srst_req";
            desc = "VICAP PPC soft reset request. 0: not reset, 1: reset.";
            sw = rw;
            hw = r;
            encode = PERI_CRG61_vicap_ppc_srst_req_enum;
            reset = 0x0;
        } vicap_ppc_srst_req[12:12];

        enum PERI_CRG61_vicap_p1_srst_req_enum {
            NOT_RESET = 0 { name = "Not Reset"; desc = "Not reset"; };
            ASSERT_RESET = 1 { name = "Assert Reset"; desc = "Reset"; };
        };

        field {
            name = "vicap_p1_srst_req";
            desc = "VICAP Port1 soft reset request. 0: not reset, 1: reset.";
            sw = rw;
            hw = r;
            encode = PERI_CRG61_vicap_p1_srst_req_enum;
            reset = 0x0;
        } vicap_p1_srst_req[11:11];

        enum PERI_CRG61_vicap_p0_srst_req_enum {
            NOT_RESET = 0 { name = "Not Reset"; desc = "Not reset"; };
            ASSERT_RESET = 1 { name = "Assert Reset"; desc = "Reset"; };
        };

        field {
            name = "vicap_p0_srst_req";
            desc = "VICAP Port0 soft reset request. 0: not reset, 1: reset.";
            sw = rw;
            hw = r;
            encode = PERI_CRG61_vicap_p0_srst_req_enum;
            reset = 0x0;
        } vicap_p0_srst_req[10:10];

        enum PERI_CRG61_vicap_bus_cken_enum {
            CLOCK_OFF = 0 { name = "Clock Off"; desc = "Clock off"; };
            CLOCK_ON = 1 { name = "Clock On"; desc = "Clock on"; };
        };

        field {
            name = "vicap_bus_cken";
            desc = "VICAP BUS clock gate. 0: clock off, 1: clock on.";
            sw = rw;
            hw = r;
            encode = PERI_CRG61_vicap_bus_cken_enum;
            reset = 0x0;
        } vicap_bus_cken[9:9];

        enum PERI_CRG61_vicap_ppc_cken_enum {
            CLOCK_OFF = 0 { name = "Clock Off"; desc = "Clock off"; };
            CLOCK_ON = 1 { name = "Clock On"; desc = "Clock on"; };
        };

        field {
            name = "vicap_ppc_cken";
            desc = "VICAP PPC clock gate. 0: clock off, 1: clock on.";
            sw = rw;
            hw = r;
            encode = PERI_CRG61_vicap_ppc_cken_enum;
            reset = 0x0;
        } vicap_ppc_cken[8:8];

        enum PERI_CRG61_vicap_p1_cken_enum {
            CLOCK_OFF = 0 { name = "Clock Off"; desc = "Clock off"; };
            CLOCK_ON = 1 { name = "Clock On"; desc = "Clock on"; };
        };

        field {
            name = "vicap_p1_cken";
            desc = "VICAP Port1 clock gate. 0: clock off, 1: clock on.";
            sw = rw;
            hw = r;
            encode = PERI_CRG61_vicap_p1_cken_enum;
            reset = 0x0;
        } vicap_p1_cken[7:7];

        enum PERI_CRG61_vicap_p0_cken_enum {
            CLOCK_OFF = 0 { name = "Clock Off"; desc = "Clock off"; };
            CLOCK_ON = 1 { name = "Clock On"; desc = "Clock on"; };
        };

        field {
            name = "vicap_p0_cken";
            desc = "VICAP Port0 clock gate. 0: clock off, 1: clock on.";
            sw = rw;
            hw = r;
            encode = PERI_CRG61_vicap_p0_cken_enum;
            reset = 0x0;
        } vicap_p0_cken[6:6];

        enum PERI_CRG61_vicap_ppc_ch3_cken_enum {
            CLOCK_OFF = 0 { name = "Clock Off"; desc = "Clock off"; };
            CLOCK_ON = 1 { name = "Clock On"; desc = "Clock on"; };
        };

        field {
            name = "vicap_ppc_ch3_cken";
            desc = "VICAP PPC CH3 clock gate (RAW format data only). 0: clock off, 1: clock on.";
            sw = rw;
            hw = r;
            encode = PERI_CRG61_vicap_ppc_ch3_cken_enum;
            reset = 0x0;
        } vicap_ppc_ch3_cken[5:5];

        enum PERI_CRG61_vicap_ppc_ch2_cken_enum {
            CLOCK_OFF = 0 { name = "Clock Off"; desc = "Clock off"; };
            CLOCK_ON = 1 { name = "Clock On"; desc = "Clock on"; };
        };

        field {
            name = "vicap_ppc_ch2_cken";
            desc = "VICAP PPC CH2 clock gate (YUV format data only). 0: clock off, 1: clock on.";
            sw = rw;
            hw = r;
            encode = PERI_CRG61_vicap_ppc_ch2_cken_enum;
            reset = 0x0;
        } vicap_ppc_ch2_cken[4:4];

        enum PERI_CRG61_vicap_ppc_ch1_cken_enum {
            CLOCK_OFF = 0 { name = "Clock Off"; desc = "Clock off"; };
            CLOCK_ON = 1 { name = "Clock On"; desc = "Clock on"; };
        };

        field {
            name = "vicap_ppc_ch1_cken";
            desc = "VICAP PPC CH1 clock gate (RAW format data only). 0: clock off, 1: clock on.";
            sw = rw;
            hw = r;
            encode = PERI_CRG61_vicap_ppc_ch1_cken_enum;
            reset = 0x0;
        } vicap_ppc_ch1_cken[3:3];

        enum PERI_CRG61_vicap_ppc_ch0_cken_enum {
            CLOCK_OFF = 0 { name = "Clock Off"; desc = "Clock off"; };
            CLOCK_ON = 1 { name = "Clock On"; desc = "Clock on"; };
        };

        field {
            name = "vicap_ppc_ch0_cken";
            desc = "VICAP PPC CH0 clock gate (RAW format data only). 0: clock off, 1: clock on.";
            sw = rw;
            hw = r;
            encode = PERI_CRG61_vicap_ppc_ch0_cken_enum;
            reset = 0x0;
        } vicap_ppc_ch0_cken[2:2];

        enum PERI_CRG61_vicap_ppc_pt1_cken_enum {
            CLOCK_OFF = 0 { name = "Clock Off"; desc = "Clock off"; };
            CLOCK_ON = 1 { name = "Clock On"; desc = "Clock on"; };
        };

        field {
            name = "vicap_ppc_pt1_cken";
            desc = "VICAP PPC PT1 clock gate (CMOS input only). 0: clock off, 1: clock on.";
            sw = rw;
            hw = r;
            encode = PERI_CRG61_vicap_ppc_pt1_cken_enum;
            reset = 0x0;
        } vicap_ppc_pt1_cken[1:1];

        enum PERI_CRG61_vicap_ppc_pt0_cken_enum {
            CLOCK_OFF = 0 { name = "Clock Off"; desc = "Clock off"; };
            CLOCK_ON = 1 { name = "Clock On"; desc = "Clock on"; };
        };

        field {
            name = "vicap_ppc_pt0_cken";
            desc = "VICAP PPC PT0 clock gate. 0: clock off, 1: clock on.";
            sw = rw;
            hw = r;
            encode = PERI_CRG61_vicap_ppc_pt0_cken_enum;
            reset = 0x0;
        } vicap_ppc_pt0_cken[0:0];
    } PERI_CRG61 @ 0xF4;

    reg {
        name = "MIPI RX clock and soft reset control register";
        desc = "MIPI RX clock and soft reset control register.

MIPI RX clock/reset. mipi_hs_pctrl: default normal (non-inverted) phase.

Data sheet 3.2.6 PERI_CRG62 (offset 0xF8, printed page 3-27, `hi3516av300--Hi3516AV300-Datasheet.txt` line 7759).";

        enum PERI_CRG62_mipi_hs_pctrl_enum {
            NOT_INVERTED = 0 { name = "Not Inverted"; desc = "Clock not inverted"; };
            INVERTED = 1 { name = "Inverted"; desc = "Clock inverted"; };
        };

        field {
            name = "mipi_hs_pctrl";
            desc = "Clock phase control of the MIPI RX PHY HS interface. Default is the normal (non-inverted) phase. 0: clock not inverted, 1: clock inverted.";
            sw = rw;
            hw = r;
            encode = PERI_CRG62_mipi_hs_pctrl_enum;
            reset = 0x0;
        } mipi_hs_pctrl[7:7];

        enum PERI_CRG62_mipi_bus_srst_req_enum {
            NOT_RESET = 0 { name = "Not Reset"; desc = "Not reset"; };
            ASSERT_RESET = 1 { name = "Assert Reset"; desc = "Reset"; };
        };

        field {
            name = "mipi_bus_srst_req";
            desc = "MIPI RX BUS logic soft reset request. 0: not reset, 1: reset.";
            sw = rw;
            hw = r;
            encode = PERI_CRG62_mipi_bus_srst_req_enum;
            reset = 0x0;
        } mipi_bus_srst_req[6:6];

        enum PERI_CRG62_mipi_pix1_core_srst_req_enum {
            NOT_RESET = 0 { name = "Not Reset"; desc = "Not reset"; };
            ASSERT_RESET = 1 { name = "Assert Reset"; desc = "Reset"; };
        };

        field {
            name = "mipi_pix1_core_srst_req";
            desc = "Soft reset request of the MIPI RX PIX1 CORE logic. 0: not reset, 1: reset.";
            sw = rw;
            hw = r;
            encode = PERI_CRG62_mipi_pix1_core_srst_req_enum;
            reset = 0x0;
        } mipi_pix1_core_srst_req[5:5];

        enum PERI_CRG62_mipi_pix0_core_srst_req_enum {
            NOT_RESET = 0 { name = "Not Reset"; desc = "Not reset"; };
            ASSERT_RESET = 1 { name = "Assert Reset"; desc = "Reset"; };
        };

        field {
            name = "mipi_pix0_core_srst_req";
            desc = "Soft reset request of the MIPI RX PIX0 CORE logic. 0: not reset, 1: reset.";
            sw = rw;
            hw = r;
            encode = PERI_CRG62_mipi_pix0_core_srst_req_enum;
            reset = 0x0;
        } mipi_pix0_core_srst_req[4:4];

        enum PERI_CRG62_mipi_bus_cken_enum {
            CLOCK_OFF = 0 { name = "Clock Off"; desc = "Clock off"; };
            CLOCK_ON = 1 { name = "Clock On"; desc = "Clock on"; };
        };

        field {
            name = "mipi_bus_cken";
            desc = "MIPI RX bus logic clock gate. 0: clock off, 1: clock on.";
            sw = rw;
            hw = r;
            encode = PERI_CRG62_mipi_bus_cken_enum;
            reset = 0x0;
        } mipi_bus_cken[3:3];

        enum PERI_CRG62_mipi_pix1_cken_enum {
            CLOCK_OFF = 0 { name = "Clock Off"; desc = "Clock off"; };
            CLOCK_ON = 1 { name = "Clock On"; desc = "Clock on"; };
        };

        field {
            name = "mipi_pix1_cken";
            desc = "MIPI RX PIX1 clock gate. 0: clock off, 1: clock on.";
            sw = rw;
            hw = r;
            encode = PERI_CRG62_mipi_pix1_cken_enum;
            reset = 0x0;
        } mipi_pix1_cken[2:2];

        enum PERI_CRG62_mipi_pix0_cken_enum {
            CLOCK_OFF = 0 { name = "Clock Off"; desc = "Clock off"; };
            CLOCK_ON = 1 { name = "Clock On"; desc = "Clock on"; };
        };

        field {
            name = "mipi_pix0_cken";
            desc = "MIPI RX PIX0 clock gate. 0: clock off, 1: clock on.";
            sw = rw;
            hw = r;
            encode = PERI_CRG62_mipi_pix0_cken_enum;
            reset = 0x0;
        } mipi_pix0_cken[1:1];

        enum PERI_CRG62_cil_cken_enum {
            CLOCK_OFF = 0 { name = "Clock Off"; desc = "Clock off"; };
            CLOCK_ON = 1 { name = "Clock On"; desc = "Clock on"; };
        };

        field {
            name = "cil_cken";
            desc = "MIPI RX CIL logic clock gate. 0: clock off, 1: clock on.";
            sw = rw;
            hw = r;
            encode = PERI_CRG62_cil_cken_enum;
            reset = 0x0;
        } cil_cken[0:0];
    } PERI_CRG62 @ 0xF8;

    reg {
        name = "VIPROC clock and soft reset control register";
        desc = "VIPROC clock and soft reset control register.

VIPROC clock/reset. Reset 0x6: viproc_cksel = 2 (300 MHz) plus reserved bit 2 set.

Total reset value 0x00000006 (data sheet header; it includes the non-zero reset values of reserved rows, which are modelled as read-only fields: reserved_nz_2_2).

Data sheet 3.2.6 PERI_CRG63 (offset 0xFC, printed page 3-28, `hi3516av300--Hi3516AV300-Datasheet.txt` line 7830).";

        enum PERI_CRG63_viproc_srst_req_enum {
            NOT_RESET = 0 { name = "Not Reset"; desc = "Not reset"; };
            ASSERT_RESET = 1 { name = "Assert Reset"; desc = "Reset"; };
        };

        field {
            name = "viproc_srst_req";
            desc = "VIPROC soft reset request. 0: not reset, 1: reset.";
            sw = rw;
            hw = r;
            encode = PERI_CRG63_viproc_srst_req_enum;
            reset = 0x0;
        } viproc_srst_req[5:5];

        enum PERI_CRG63_viproc_cken_enum {
            CLOCK_OFF = 0 { name = "Clock Off"; desc = "Clock off"; };
            CLOCK_ON = 1 { name = "Clock On"; desc = "Clock on"; };
        };

        field {
            name = "viproc_cken";
            desc = "VIPROC clock gate. 0: clock off, 1: clock on.";
            sw = rw;
            hw = r;
            encode = PERI_CRG63_viproc_cken_enum;
            reset = 0x0;
        } viproc_cken[4:4];

        enum PERI_CRG63_viproc_online_cksel_enum {
            OFFLINE = 0 { name = "Offline"; desc = "Offline: viproc_cksel"; };
            ONLINE = 1 { name = "Online"; desc = "Online: PERI_CRG64 isp0_cksel"; };
        };

        field {
            name = "viproc_online_cksel";
            desc = "VIPROC online-mode select. Used together with MISC_CTRL6 vicap_viproc_online_mode. 0: offline: viproc_cksel, 1: online: PERI_CRG64 isp0_cksel.";
            sw = rw;
            hw = r;
            encode = PERI_CRG63_viproc_online_cksel_enum;
            reset = 0x0;
        } viproc_online_cksel[3:3];

        field {
            name = "reserved_nz_2_2";
            desc = "Reserved bits; the data sheet lists a non-zero reset value for this reserved row, which is part of the total reset value (reset 0x1).";
            sw = r;
            hw = na;
            reset = 0x1;
        } reserved_nz_2_2[2:2];

        enum PERI_CRG63_viproc_cksel_enum {
            CLK_475MHZ = 0 { name = "Clk 475Mhz"; desc = "475 MHz"; };
            CLK_396MHZ = 1 { name = "Clk 396Mhz"; desc = "396 MHz (set PERI_CRG61[25] to 1 first)"; };
            CLK_300MHZ = 2 { name = "Clk 300Mhz"; desc = "300 MHz"; };
            CLK_150MHZ = 3 { name = "Clk 150Mhz"; desc = "150 MHz"; };
        };

        field {
            name = "viproc_cksel";
            desc = "VIPROC offline-mode clock select.";
            sw = rw;
            hw = r;
            encode = PERI_CRG63_viproc_cksel_enum;
            reset = 0x2;
        } viproc_cksel[1:0];
    } PERI_CRG63 @ 0xFC;

    reg {
        name = "ISP clock and soft reset control register";
        desc = "ISP clock and soft reset control register.

ISP clock/reset for the four ISP instances. Reset 0x924: all four cksel fields = 4 (300 MHz).

Data sheet 3.2.6 PERI_CRG64 (offset 0x100, printed page 3-29, `hi3516av300--Hi3516AV300-Datasheet.txt` line 7883).";

        enum PERI_CRG64_isp3_cken_enum {
            CLOCK_OFF = 0 { name = "Clock Off"; desc = "Clock off"; };
            CLOCK_ON = 1 { name = "Clock On"; desc = "Clock on"; };
        };

        field {
            name = "isp3_cken";
            desc = "ISP3 clock gate. 0: clock off, 1: clock on.";
            sw = rw;
            hw = r;
            encode = PERI_CRG64_isp3_cken_enum;
            reset = 0x0;
        } isp3_cken[23:23];

        enum PERI_CRG64_isp2_cken_enum {
            CLOCK_OFF = 0 { name = "Clock Off"; desc = "Clock off"; };
            CLOCK_ON = 1 { name = "Clock On"; desc = "Clock on"; };
        };

        field {
            name = "isp2_cken";
            desc = "ISP2 clock gate. 0: clock off, 1: clock on.";
            sw = rw;
            hw = r;
            encode = PERI_CRG64_isp2_cken_enum;
            reset = 0x0;
        } isp2_cken[22:22];

        enum PERI_CRG64_isp1_cken_enum {
            CLOCK_OFF = 0 { name = "Clock Off"; desc = "Clock off"; };
            CLOCK_ON = 1 { name = "Clock On"; desc = "Clock on"; };
        };

        field {
            name = "isp1_cken";
            desc = "ISP1 clock gate. 0: clock off, 1: clock on.";
            sw = rw;
            hw = r;
            encode = PERI_CRG64_isp1_cken_enum;
            reset = 0x0;
        } isp1_cken[21:21];

        enum PERI_CRG64_isp0_cken_enum {
            CLOCK_OFF = 0 { name = "Clock Off"; desc = "Clock off"; };
            CLOCK_ON = 1 { name = "Clock On"; desc = "Clock on"; };
        };

        field {
            name = "isp0_cken";
            desc = "ISP0 clock gate. 0: clock off, 1: clock on.";
            sw = rw;
            hw = r;
            encode = PERI_CRG64_isp0_cken_enum;
            reset = 0x0;
        } isp0_cken[20:20];

        enum PERI_CRG64_isp3_core_srst_req_enum {
            NOT_RESET = 0 { name = "Not Reset"; desc = "Not reset"; };
            ASSERT_RESET = 1 { name = "Assert Reset"; desc = "Reset"; };
        };

        field {
            name = "isp3_core_srst_req";
            desc = "ISP3 core soft reset request. 0: not reset, 1: reset.";
            sw = rw;
            hw = r;
            encode = PERI_CRG64_isp3_core_srst_req_enum;
            reset = 0x0;
        } isp3_core_srst_req[19:19];

        enum PERI_CRG64_isp2_core_srst_req_enum {
            NOT_RESET = 0 { name = "Not Reset"; desc = "Not reset"; };
            ASSERT_RESET = 1 { name = "Assert Reset"; desc = "Reset"; };
        };

        field {
            name = "isp2_core_srst_req";
            desc = "ISP2 core soft reset request. 0: not reset, 1: reset.";
            sw = rw;
            hw = r;
            encode = PERI_CRG64_isp2_core_srst_req_enum;
            reset = 0x0;
        } isp2_core_srst_req[18:18];

        enum PERI_CRG64_isp1_core_srst_req_enum {
            NOT_RESET = 0 { name = "Not Reset"; desc = "Not reset"; };
            ASSERT_RESET = 1 { name = "Assert Reset"; desc = "Reset"; };
        };

        field {
            name = "isp1_core_srst_req";
            desc = "ISP1 core soft reset request. 0: not reset, 1: reset.";
            sw = rw;
            hw = r;
            encode = PERI_CRG64_isp1_core_srst_req_enum;
            reset = 0x0;
        } isp1_core_srst_req[17:17];

        enum PERI_CRG64_isp0_core_srst_req_enum {
            NOT_RESET = 0 { name = "Not Reset"; desc = "Not reset"; };
            ASSERT_RESET = 1 { name = "Assert Reset"; desc = "Reset"; };
        };

        field {
            name = "isp0_core_srst_req";
            desc = "ISP0 core soft reset request. 0: not reset, 1: reset.";
            sw = rw;
            hw = r;
            encode = PERI_CRG64_isp0_core_srst_req_enum;
            reset = 0x0;
        } isp0_core_srst_req[16:16];

        enum PERI_CRG64_isp3_cfg_srst_req_enum {
            NOT_RESET = 0 { name = "Not Reset"; desc = "Not reset"; };
            ASSERT_RESET = 1 { name = "Assert Reset"; desc = "Reset"; };
        };

        field {
            name = "isp3_cfg_srst_req";
            desc = "ISP3 cfg soft reset request. 0: not reset, 1: reset.";
            sw = rw;
            hw = r;
            encode = PERI_CRG64_isp3_cfg_srst_req_enum;
            reset = 0x0;
        } isp3_cfg_srst_req[15:15];

        enum PERI_CRG64_isp2_cfg_srst_req_enum {
            NOT_RESET = 0 { name = "Not Reset"; desc = "Not reset"; };
            ASSERT_RESET = 1 { name = "Assert Reset"; desc = "Reset"; };
        };

        field {
            name = "isp2_cfg_srst_req";
            desc = "ISP2 cfg soft reset request. 0: not reset, 1: reset.";
            sw = rw;
            hw = r;
            encode = PERI_CRG64_isp2_cfg_srst_req_enum;
            reset = 0x0;
        } isp2_cfg_srst_req[14:14];

        enum PERI_CRG64_isp1_cfg_srst_req_enum {
            NOT_RESET = 0 { name = "Not Reset"; desc = "Not reset"; };
            ASSERT_RESET = 1 { name = "Assert Reset"; desc = "Reset"; };
        };

        field {
            name = "isp1_cfg_srst_req";
            desc = "ISP1 cfg soft reset request. 0: not reset, 1: reset.";
            sw = rw;
            hw = r;
            encode = PERI_CRG64_isp1_cfg_srst_req_enum;
            reset = 0x0;
        } isp1_cfg_srst_req[13:13];

        enum PERI_CRG64_isp0_cfg_srst_req_enum {
            NOT_RESET = 0 { name = "Not Reset"; desc = "Not reset"; };
            ASSERT_RESET = 1 { name = "Assert Reset"; desc = "Reset"; };
        };

        field {
            name = "isp0_cfg_srst_req";
            desc = "ISP0 cfg soft reset request. 0: not reset, 1: reset.";
            sw = rw;
            hw = r;
            encode = PERI_CRG64_isp0_cfg_srst_req_enum;
            reset = 0x0;
        } isp0_cfg_srst_req[12:12];

        enum PERI_CRG64_isp3_cksel_enum {
            RESERVED_0 = 0 { name = "Reserved 0"; desc = "Reserved"; };
            RESERVED_1 = 1 { name = "Reserved 1"; desc = "Reserved"; };
            CLK_475MHZ = 2 { name = "Clk 475Mhz"; desc = "475 MHz"; };
            CLK_396MHZ = 3 { name = "Clk 396Mhz"; desc = "396 MHz (set PERI_CRG61[25] to 1 first)"; };
            CLK_300MHZ = 4 { name = "Clk 300Mhz"; desc = "300 MHz"; };
            CLK_150MHZ = 5 { name = "Clk 150Mhz"; desc = "150 MHz"; };
            RESERVED_6 = 6 { name = "Reserved 6"; desc = "Reserved"; };
            RESERVED_7 = 7 { name = "Reserved 7"; desc = "Reserved"; };
        };

        field {
            name = "isp3_cksel";
            desc = "ISP3 clock select.";
            sw = rw;
            hw = r;
            encode = PERI_CRG64_isp3_cksel_enum;
            reset = 0x4;
        } isp3_cksel[11:9];

        enum PERI_CRG64_isp2_cksel_enum {
            RESERVED_0 = 0 { name = "Reserved 0"; desc = "Reserved"; };
            RESERVED_1 = 1 { name = "Reserved 1"; desc = "Reserved"; };
            CLK_475MHZ = 2 { name = "Clk 475Mhz"; desc = "475 MHz"; };
            CLK_396MHZ = 3 { name = "Clk 396Mhz"; desc = "396 MHz (set PERI_CRG61[25] to 1 first)"; };
            CLK_300MHZ = 4 { name = "Clk 300Mhz"; desc = "300 MHz"; };
            CLK_150MHZ = 5 { name = "Clk 150Mhz"; desc = "150 MHz"; };
            RESERVED_6 = 6 { name = "Reserved 6"; desc = "Reserved"; };
            RESERVED_7 = 7 { name = "Reserved 7"; desc = "Reserved"; };
        };

        field {
            name = "isp2_cksel";
            desc = "ISP2 clock select.";
            sw = rw;
            hw = r;
            encode = PERI_CRG64_isp2_cksel_enum;
            reset = 0x4;
        } isp2_cksel[8:6];

        enum PERI_CRG64_isp1_cksel_enum {
            RESERVED_0 = 0 { name = "Reserved 0"; desc = "Reserved"; };
            RESERVED_1 = 1 { name = "Reserved 1"; desc = "Reserved"; };
            CLK_475MHZ = 2 { name = "Clk 475Mhz"; desc = "475 MHz"; };
            CLK_396MHZ = 3 { name = "Clk 396Mhz"; desc = "396 MHz (set PERI_CRG61[25] to 1 first)"; };
            CLK_300MHZ = 4 { name = "Clk 300Mhz"; desc = "300 MHz"; };
            CLK_150MHZ = 5 { name = "Clk 150Mhz"; desc = "150 MHz"; };
            RESERVED_6 = 6 { name = "Reserved 6"; desc = "Reserved"; };
            RESERVED_7 = 7 { name = "Reserved 7"; desc = "Reserved"; };
        };

        field {
            name = "isp1_cksel";
            desc = "ISP1 clock select.";
            sw = rw;
            hw = r;
            encode = PERI_CRG64_isp1_cksel_enum;
            reset = 0x4;
        } isp1_cksel[5:3];

        enum PERI_CRG64_isp0_cksel_enum {
            RESERVED_0 = 0 { name = "Reserved 0"; desc = "Reserved"; };
            RESERVED_1 = 1 { name = "Reserved 1"; desc = "Reserved"; };
            CLK_475MHZ = 2 { name = "Clk 475Mhz"; desc = "475 MHz"; };
            CLK_396MHZ = 3 { name = "Clk 396Mhz"; desc = "396 MHz (set PERI_CRG61[25] to 1 first)"; };
            CLK_300MHZ = 4 { name = "Clk 300Mhz"; desc = "300 MHz"; };
            CLK_150MHZ = 5 { name = "Clk 150Mhz"; desc = "150 MHz"; };
            RESERVED_6 = 6 { name = "Reserved 6"; desc = "Reserved"; };
            RESERVED_7 = 7 { name = "Reserved 7"; desc = "Reserved"; };
        };

        field {
            name = "isp0_cksel";
            desc = "ISP0 clock select.";
            sw = rw;
            hw = r;
            encode = PERI_CRG64_isp0_cksel_enum;
            reset = 0x4;
        } isp0_cksel[2:0];
    } PERI_CRG64 @ 0x100;

    reg {
        name = "LCD divider configuration register";
        desc = "LCD divider configuration register.

LCD divider. Reset 0x000FFFFF.

Data sheet 3.2.6 PERI_CRG65 (offset 0x104, printed page 3-31, `hi3516av300--Hi3516AV300-Datasheet.txt` line 8028).";

        enum PERI_CRG65_lcd_cken_enum {
            CLOCK_OFF = 0 { name = "Clock Off"; desc = "Clock off"; };
            CLOCK_ON = 1 { name = "Clock On"; desc = "Clock on"; };
        };

        field {
            name = "lcd_cken";
            desc = "LCD divider clock gate. 0: clock off, 1: clock on.";
            sw = rw;
            hw = r;
            encode = PERI_CRG65_lcd_cken_enum;
            reset = 0x0;
        } lcd_cken[27:27];

        field {
            name = "lcd_div";
            desc = "LCD divided clock, configurable. For a target frequency X (MHz): lcd_div = (X / 1188) * 2^27; maximum 75 MHz.";
            sw = rw;
            hw = r;
            reset = 0xFFFFF;
        } lcd_div[26:0];
    } PERI_CRG65 @ 0x104;

    reg {
        name = "VDP clock and soft reset control register";
        desc = "VDP clock and soft reset control register.

VDP clock/reset. Reset 0x00304000: vdp_hd_cksel = 1 (VPLL FOUT4), vdp_out_pctrl = 1 (output clock inverted) and vdp_hd_ppc_cksel = 1 (150 MHz).

Data sheet 3.2.6 PERI_CRG66 (offset 0x108, printed page 3-32, `hi3516av300--Hi3516AV300-Datasheet.txt` line 8058).";

        field {
            name = "vdp_hd_hdmi_clk_div";
            desc = "VDP HD channel HDMI clock divider. N: divide by N+1.";
            sw = rw;
            hw = r;
            reset = 0x0;
        } vdp_hd_hdmi_clk_div[29:25];

        enum PERI_CRG66_vdp_hd_cksel_enum {
            VPLL_POSTDIV = 0 { name = "Vpll Postdiv"; desc = "VPLL POSTDIV clock"; };
            VPLL_FOUT4 = 1 { name = "Vpll Fout4"; desc = "VPLL FOUT4 clock"; };
            CLK_297MHZ = 2 { name = "Clk 297Mhz"; desc = "297 MHz"; };
            CLK_74P25MHZ = 3 { name = "Clk 74P25Mhz"; desc = "74.25 MHz"; };
            CLK_108MHZ = 4 { name = "Clk 108Mhz"; desc = "108 MHz"; };
            CLK_27MHZ = 5 { name = "Clk 27Mhz"; desc = "27 MHz"; };
            LCD_DIVIDER = 6 { name = "Lcd Divider"; desc = "LCD divider clock"; };
            CLK_148P5MHZ = 10 { name = "Clk 148P5Mhz"; desc = "148.5 MHz"; };
            CLK_37P125MHZ = 11 { name = "Clk 37P125Mhz"; desc = "37.125 MHz"; };
            CLK_54MHZ = 12 { name = "Clk 54Mhz"; desc = "54 MHz"; };
            CLK_13P5MHZ = 13 { name = "Clk 13P5Mhz"; desc = "13.5 MHz"; };
        };

        field {
            name = "vdp_hd_cksel";
            desc = "VDP HD clock source select.";
            sw = rw;
            hw = r;
            encode = PERI_CRG66_vdp_hd_cksel_enum;
            reset = 0x1;
        } vdp_hd_cksel[24:21];

        enum PERI_CRG66_vdp_out_pctrl_enum {
            NOT_INVERTED = 0 { name = "Not Inverted"; desc = "Clock not inverted"; };
            INVERTED = 1 { name = "Inverted"; desc = "Clock inverted"; };
        };

        field {
            name = "vdp_out_pctrl";
            desc = "Phase control of the VDP output clock (chip output clock). Inverted by default. 0: clock not inverted, 1: clock inverted.";
            sw = rw;
            hw = r;
            encode = PERI_CRG66_vdp_out_pctrl_enum;
            reset = 0x1;
        } vdp_out_pctrl[20:20];

        enum PERI_CRG66_vdp_mipi_tx_cken_enum {
            CLOCK_OFF = 0 { name = "Clock Off"; desc = "Clock off"; };
            CLOCK_ON = 1 { name = "Clock On"; desc = "Clock on"; };
        };

        field {
            name = "vdp_mipi_tx_cken";
            desc = "VDP_MIPI TX clock gate. 0: clock off, 1: clock on.";
            sw = rw;
            hw = r;
            encode = PERI_CRG66_vdp_mipi_tx_cken_enum;
            reset = 0x0;
        } vdp_mipi_tx_cken[19:19];

        enum PERI_CRG66_vdp_hdmi_tx_cken_enum {
            CLOCK_OFF = 0 { name = "Clock Off"; desc = "Clock off"; };
            CLOCK_ON = 1 { name = "Clock On"; desc = "Clock on"; };
        };

        field {
            name = "vdp_hdmi_tx_cken";
            desc = "VDP_HDMI TX clock gate. 0: clock off, 1: clock on.";
            sw = rw;
            hw = r;
            encode = PERI_CRG66_vdp_hdmi_tx_cken_enum;
            reset = 0x0;
        } vdp_hdmi_tx_cken[18:18];

        enum PERI_CRG66_vdp_hd_ppc_cksel_enum {
            CLK_300MHZ = 0 { name = "Clk 300Mhz"; desc = "300 MHz"; };
            CLK_150MHZ = 1 { name = "Clk 150Mhz"; desc = "150 MHz"; };
        };

        field {
            name = "vdp_hd_ppc_cksel";
            desc = "VDP HD working clock select. 0: 300 MHz, 1: 150 MHz.";
            sw = rw;
            hw = r;
            encode = PERI_CRG66_vdp_hd_ppc_cksel_enum;
            reset = 0x1;
        } vdp_hd_ppc_cksel[14:14];

        enum PERI_CRG66_hd_div_mode_enum {
            DIV1 = 0 { name = "Div1"; desc = "Not divided"; };
            DIV2 = 1 { name = "Div2"; desc = "Divide by 2"; };
            DIV3 = 2 { name = "Div3"; desc = "Divide by 3"; };
            DIV4 = 3 { name = "Div4"; desc = "Divide by 4"; };
        };

        field {
            name = "hd_div_mode";
            desc = "VDP HD channel clock divider ratio.";
            sw = rw;
            hw = r;
            encode = PERI_CRG66_hd_div_mode_enum;
            reset = 0x0;
        } hd_div_mode[13:12];

        enum PERI_CRG66_vdp_mipi_cken_enum {
            CLOCK_OFF = 0 { name = "Clock Off"; desc = "Clock off"; };
            CLOCK_ON = 1 { name = "Clock On"; desc = "Clock on"; };
        };

        field {
            name = "vdp_mipi_cken";
            desc = "VDP_MIPI TX clock gate. 0: clock off, 1: clock on.";
            sw = rw;
            hw = r;
            encode = PERI_CRG66_vdp_mipi_cken_enum;
            reset = 0x0;
        } vdp_mipi_cken[11:11];

        enum PERI_CRG66_vdp_hdmi_cken_enum {
            CLOCK_OFF = 0 { name = "Clock Off"; desc = "Clock off"; };
            CLOCK_ON = 1 { name = "Clock On"; desc = "Clock on"; };
        };

        field {
            name = "vdp_hdmi_cken";
            desc = "VDP_HDMI clock gate. 0: clock off, 1: clock on.";
            sw = rw;
            hw = r;
            encode = PERI_CRG66_vdp_hdmi_cken_enum;
            reset = 0x0;
        } vdp_hdmi_cken[10:10];

        enum PERI_CRG66_vdp_bt_cken_enum {
            CLOCK_OFF = 0 { name = "Clock Off"; desc = "Clock off"; };
            CLOCK_ON = 1 { name = "Clock On"; desc = "Clock on"; };
        };

        field {
            name = "vdp_bt_cken";
            desc = "VDP BT.1120/BT.656 clock gate. 0: clock off, 1: clock on.";
            sw = rw;
            hw = r;
            encode = PERI_CRG66_vdp_bt_cken_enum;
            reset = 0x0;
        } vdp_bt_cken[9:9];

        enum PERI_CRG66_vdp_bt_bp_cken_enum {
            CLOCK_OFF = 0 { name = "Clock Off"; desc = "Clock off"; };
            CLOCK_ON = 1 { name = "Clock On"; desc = "Clock on"; };
        };

        field {
            name = "vdp_bt_bp_cken";
            desc = "VDP bt_bp clock gate. 0: clock off, 1: clock on.";
            sw = rw;
            hw = r;
            encode = PERI_CRG66_vdp_bt_bp_cken_enum;
            reset = 0x0;
        } vdp_bt_bp_cken[8:8];

        enum PERI_CRG66_vdp_hd_cken_enum {
            CLOCK_OFF = 0 { name = "Clock Off"; desc = "Clock off"; };
            CLOCK_ON = 1 { name = "Clock On"; desc = "Clock on"; };
        };

        field {
            name = "vdp_hd_cken";
            desc = "VDP HD clock gate. 0: clock off, 1: clock on.";
            sw = rw;
            hw = r;
            encode = PERI_CRG66_vdp_hd_cken_enum;
            reset = 0x0;
        } vdp_hd_cken[6:6];

        enum PERI_CRG66_vdp_hd_ppc_cken_enum {
            CLOCK_OFF = 0 { name = "Clock Off"; desc = "Clock off"; };
            CLOCK_ON = 1 { name = "Clock On"; desc = "Clock on"; };
        };

        field {
            name = "vdp_hd_ppc_cken";
            desc = "VDP HD working clock gate. 0: clock off, 1: clock on.";
            sw = rw;
            hw = r;
            encode = PERI_CRG66_vdp_hd_ppc_cken_enum;
            reset = 0x0;
        } vdp_hd_ppc_cken[5:5];

        enum PERI_CRG66_vdp_cfg_cken_enum {
            CLOCK_OFF = 0 { name = "Clock Off"; desc = "Clock off"; };
            CLOCK_ON = 1 { name = "Clock On"; desc = "Clock on"; };
        };

        field {
            name = "vdp_cfg_cken";
            desc = "VDP configuration clock gate. 0: clock off, 1: clock on.";
            sw = rw;
            hw = r;
            encode = PERI_CRG66_vdp_cfg_cken_enum;
            reset = 0x0;
        } vdp_cfg_cken[3:3];

        enum PERI_CRG66_vdp_acken_enum {
            CLOCK_OFF = 0 { name = "Clock Off"; desc = "Clock off"; };
            CLOCK_ON = 1 { name = "Clock On"; desc = "Clock on"; };
        };

        field {
            name = "vdp_acken";
            desc = "VDP AXI bus clock gate. 0: clock off, 1: clock on.";
            sw = rw;
            hw = r;
            encode = PERI_CRG66_vdp_acken_enum;
            reset = 0x0;
        } vdp_acken[2:2];

        enum PERI_CRG66_vdp_pcken_enum {
            CLOCK_OFF = 0 { name = "Clock Off"; desc = "Clock off"; };
            CLOCK_ON = 1 { name = "Clock On"; desc = "Clock on"; };
        };

        field {
            name = "vdp_pcken";
            desc = "VDP APB clock gate. 0: clock off, 1: clock on.";
            sw = rw;
            hw = r;
            encode = PERI_CRG66_vdp_pcken_enum;
            reset = 0x0;
        } vdp_pcken[1:1];

        enum PERI_CRG66_vdp_srst_req_enum {
            NOT_RESET = 0 { name = "Not Reset"; desc = "Not reset"; };
            ASSERT_RESET = 1 { name = "Assert Reset"; desc = "Reset"; };
        };

        field {
            name = "vdp_srst_req";
            desc = "VDP soft reset request. 0: not reset, 1: reset.";
            sw = rw;
            hw = r;
            encode = PERI_CRG66_vdp_srst_req_enum;
            reset = 0x0;
        } vdp_srst_req[0:0];
    } PERI_CRG66 @ 0x108;

    reg {
        name = "MIPI TX clock and soft reset control register";
        desc = "MIPI TX clock and soft reset control register.

MIPI TX clock/reset. Reset 0x4: mipitx_ref_cksel = 1 (27 MHz).

Data sheet 3.2.6 PERI_CRG67 (offset 0x10C, printed page 3-34, `hi3516av300--Hi3516AV300-Datasheet.txt` line 8212).";

        enum PERI_CRG67_mipitxphy_clk_pctrl_enum {
            NOT_INVERTED = 0 { name = "Not Inverted"; desc = "Clock not inverted"; };
            INVERTED = 1 { name = "Inverted"; desc = "Clock inverted"; };
        };

        field {
            name = "mipitxphy_clk_pctrl";
            desc = "MIPI TX PHY interface clock phase control. 0: clock not inverted, 1: clock inverted.";
            sw = rw;
            hw = r;
            encode = PERI_CRG67_mipitxphy_clk_pctrl_enum;
            reset = 0x0;
        } mipitxphy_clk_pctrl[3:3];

        enum PERI_CRG67_mipitx_ref_cksel_enum {
            CLK_19P8MHZ = 0 { name = "Clk 19P8Mhz"; desc = "19.8 MHz"; };
            CLK_27MHZ = 1 { name = "Clk 27Mhz"; desc = "27 MHz"; };
        };

        field {
            name = "mipitx_ref_cksel";
            desc = "MIPI TX PHY REF clock select. 0: 19.8 MHz, 1: 27 MHz.";
            sw = rw;
            hw = r;
            encode = PERI_CRG67_mipitx_ref_cksel_enum;
            reset = 0x1;
        } mipitx_ref_cksel[2:2];

        enum PERI_CRG67_mipitx_srst_req_enum {
            NOT_RESET = 0 { name = "Not Reset"; desc = "Not reset"; };
            ASSERT_RESET = 1 { name = "Assert Reset"; desc = "Reset"; };
        };

        field {
            name = "mipitx_srst_req";
            desc = "MIPI TX CTRL soft reset request. 0: not reset, 1: reset.";
            sw = rw;
            hw = r;
            encode = PERI_CRG67_mipitx_srst_req_enum;
            reset = 0x0;
        } mipitx_srst_req[1:1];

        enum PERI_CRG67_mipitx_cken_enum {
            CLOCK_OFF = 0 { name = "Clock Off"; desc = "Clock off"; };
            CLOCK_ON = 1 { name = "Clock On"; desc = "Clock on"; };
        };

        field {
            name = "mipitx_cken";
            desc = "MIPI TX CTRL clock gate. 0: clock off, 1: clock on.";
            sw = rw;
            hw = r;
            encode = PERI_CRG67_mipitx_cken_enum;
            reset = 0x0;
        } mipitx_cken[0:0];
    } PERI_CRG67 @ 0x10C;

    reg {
        name = "HDMI TX controller clock and soft reset control register";
        desc = "HDMI TX controller clock and soft reset control register.

Data sheet 3.2.6 PERI_CRG68 (offset 0x110, printed page 3-34, `hi3516av300--Hi3516AV300-Datasheet.txt` line 8254).";

        enum PERI_CRG68_ssc_bypass_clk_sel_enum {
            CLK_SSC_BYPASS_OCC = 0 { name = "Clk Ssc Bypass Occ"; desc = "Clk_ssc_bypass_occ clock"; };
            VDP_CLOCK = 1 { name = "Vdp Clock"; desc = "Clock supplied by the VDP"; };
        };

        field {
            name = "ssc_bypass_clk_sel";
            desc = "HDMI TX SSC bypass clock select. 0: clk_ssc_bypass_occ clock, 1: clock supplied by the VDP.";
            sw = rw;
            hw = r;
            encode = PERI_CRG68_ssc_bypass_clk_sel_enum;
            reset = 0x0;
        } ssc_bypass_clk_sel[19:19];

        enum PERI_CRG68_hdmitx_pxl_cken_enum {
            CLOCK_GATE_OFF = 0 { name = "Clock Gate Off"; desc = "Clock gate off"; };
            CLOCK_GATE_ON = 1 { name = "Clock Gate On"; desc = "Clock gate on"; };
        };

        field {
            name = "hdmitx_pxl_cken";
            desc = "HDMI TX PXL clock gate. 0: clock gate off, 1: clock gate on.";
            sw = rw;
            hw = r;
            encode = PERI_CRG68_hdmitx_pxl_cken_enum;
            reset = 0x0;
        } hdmitx_pxl_cken[16:16];

        field {
            name = "ssc_clk_div";
            desc = "HDMI TX SSC clock divider (1 to 16). n: divide by n+1.";
            sw = rw;
            hw = r;
            reset = 0x0;
        } ssc_clk_div[13:10];

        enum PERI_CRG68_hdmitx_ssc_srst_req_enum {
            NOT_RESET = 0 { name = "Not Reset"; desc = "Not reset"; };
            ASSERT_RESET = 1 { name = "Assert Reset"; desc = "Reset"; };
        };

        field {
            name = "hdmitx_ssc_srst_req";
            desc = "HDMI SSC divider soft reset request. 0: not reset, 1: reset.";
            sw = rw;
            hw = r;
            encode = PERI_CRG68_hdmitx_ssc_srst_req_enum;
            reset = 0x0;
        } hdmitx_ssc_srst_req[9:9];

        enum PERI_CRG68_hdmitx_ctrl_cec_srst_req_enum {
            NOT_RESET = 0 { name = "Not Reset"; desc = "Not reset"; };
            ASSERT_RESET = 1 { name = "Assert Reset"; desc = "Reset"; };
        };

        field {
            name = "hdmitx_ctrl_cec_srst_req";
            desc = "HDMI TX CTRL CEC soft reset request. 0: not reset, 1: reset.";
            sw = rw;
            hw = r;
            encode = PERI_CRG68_hdmitx_ctrl_cec_srst_req_enum;
            reset = 0x0;
        } hdmitx_ctrl_cec_srst_req[8:8];

        enum PERI_CRG68_hdmitx_ctrl_srst_req_enum {
            NOT_RESET = 0 { name = "Not Reset"; desc = "Not reset"; };
            ASSERT_RESET = 1 { name = "Assert Reset"; desc = "Reset"; };
        };

        field {
            name = "hdmitx_ctrl_srst_req";
            desc = "HDMI TX soft reset request. 0: not reset, 1: reset.";
            sw = rw;
            hw = r;
            encode = PERI_CRG68_hdmitx_ctrl_srst_req_enum;
            reset = 0x0;
        } hdmitx_ctrl_srst_req[7:7];

        enum PERI_CRG68_hdmitx_ctrl_bus_srst_req_enum {
            NOT_RESET = 0 { name = "Not Reset"; desc = "Not reset"; };
            ASSERT_RESET = 1 { name = "Assert Reset"; desc = "Reset"; };
        };

        field {
            name = "hdmitx_ctrl_bus_srst_req";
            desc = "HDMI TX bus soft reset request. 0: not reset, 1: reset.";
            sw = rw;
            hw = r;
            encode = PERI_CRG68_hdmitx_ctrl_bus_srst_req_enum;
            reset = 0x0;
        } hdmitx_ctrl_bus_srst_req[6:6];

        enum PERI_CRG68_hdmitx_ctrl_as_cken_enum {
            OFF = 0 { name = "Off"; desc = "Off"; };
            ON = 1 { name = "On"; desc = "On"; };
        };

        field {
            name = "hdmitx_ctrl_as_cken";
            desc = "HDMI TX AS clock gate. 0: off, 1: on.";
            sw = rw;
            hw = r;
            encode = PERI_CRG68_hdmitx_ctrl_as_cken_enum;
            reset = 0x0;
        } hdmitx_ctrl_as_cken[5:5];

        enum PERI_CRG68_hdmitx_ctrl_os_cken_enum {
            OFF = 0 { name = "Off"; desc = "Off"; };
            ON = 1 { name = "On"; desc = "On"; };
        };

        field {
            name = "hdmitx_ctrl_os_cken";
            desc = "HDMI TX OS 60M clock gate. 0: off, 1: on.";
            sw = rw;
            hw = r;
            encode = PERI_CRG68_hdmitx_ctrl_os_cken_enum;
            reset = 0x0;
        } hdmitx_ctrl_os_cken[4:4];

        enum PERI_CRG68_hdmitx_ctrl_cec_cken_enum {
            OFF = 0 { name = "Off"; desc = "Off"; };
            ON = 1 { name = "On"; desc = "On"; };
        };

        field {
            name = "hdmitx_ctrl_cec_cken";
            desc = "HDMI TX CTRL CEC clock gate. 0: off, 1: on.";
            sw = rw;
            hw = r;
            encode = PERI_CRG68_hdmitx_ctrl_cec_cken_enum;
            reset = 0x0;
        } hdmitx_ctrl_cec_cken[3:3];

        enum PERI_CRG68_hdmitx_ctrl_osc_24m_cken_enum {
            OFF = 0 { name = "Off"; desc = "Off"; };
            ON = 1 { name = "On"; desc = "On"; };
        };

        field {
            name = "hdmitx_ctrl_osc_24m_cken";
            desc = "HDMI TX OS 24M clock gate. 0: off, 1: on.";
            sw = rw;
            hw = r;
            encode = PERI_CRG68_hdmitx_ctrl_osc_24m_cken_enum;
            reset = 0x0;
        } hdmitx_ctrl_osc_24m_cken[2:2];

        enum PERI_CRG68_ssc_bypass_cken_enum {
            OFF = 0 { name = "Off"; desc = "Off"; };
            ON = 1 { name = "On"; desc = "On"; };
        };

        field {
            name = "ssc_bypass_cken";
            desc = "HDMI TX SSC BYPASS clock gate. 0: off, 1: on.";
            sw = rw;
            hw = r;
            encode = PERI_CRG68_ssc_bypass_cken_enum;
            reset = 0x0;
        } ssc_bypass_cken[1:1];

        enum PERI_CRG68_ssc_in_cken_enum {
            OFF = 0 { name = "Off"; desc = "Off"; };
            ON = 1 { name = "On"; desc = "On"; };
        };

        field {
            name = "ssc_in_cken";
            desc = "HDMI TX SSC clock gate. 0: off, 1: on.";
            sw = rw;
            hw = r;
            encode = PERI_CRG68_ssc_in_cken_enum;
            reset = 0x0;
        } ssc_in_cken[0:0];
    } PERI_CRG68 @ 0x110;

    reg {
        name = "HDMI TX PHY clock and soft reset control register";
        desc = "HDMI TX PHY clock and soft reset control register.

Data sheet 3.2.6 PERI_CRG69 (offset 0x114, printed page 3-36, `hi3516av300--Hi3516AV300-Datasheet.txt` line 8363).";

        field {
            name = "tmds_clk_div";
            desc = "HDMI TX PHY TMDS clock divider (1 to 8). n: divide by n+1.";
            sw = rw;
            hw = r;
            reset = 0x0;
        } tmds_clk_div[8:6];

        enum PERI_CRG69_phy_tmds_srst_req_enum {
            NOT_RESET = 0 { name = "Not Reset"; desc = "Not reset"; };
            ASSERT_RESET = 1 { name = "Assert Reset"; desc = "Reset"; };
        };

        field {
            name = "phy_tmds_srst_req";
            desc = "HDMI TX PHY TMDS divider soft reset request. 0: not reset, 1: reset.";
            sw = rw;
            hw = r;
            encode = PERI_CRG69_phy_tmds_srst_req_enum;
            reset = 0x0;
        } phy_tmds_srst_req[5:5];

        enum PERI_CRG69_hdmitx_phy_srst_req_enum {
            NOT_RESET = 0 { name = "Not Reset"; desc = "Not reset"; };
            ASSERT_RESET = 1 { name = "Assert Reset"; desc = "Reset"; };
        };

        field {
            name = "hdmitx_phy_srst_req";
            desc = "HDMI TX PHY soft reset request. 0: not reset, 1: reset.";
            sw = rw;
            hw = r;
            encode = PERI_CRG69_hdmitx_phy_srst_req_enum;
            reset = 0x0;
        } hdmitx_phy_srst_req[4:4];

        enum PERI_CRG69_phy_tmds_cken_enum {
            OFF = 0 { name = "Off"; desc = "Off"; };
            ON = 1 { name = "On"; desc = "On"; };
        };

        field {
            name = "phy_tmds_cken";
            desc = "HDMI TX PHY TMDS clock gate. 0: off, 1: on.";
            sw = rw;
            hw = r;
            encode = PERI_CRG69_phy_tmds_cken_enum;
            reset = 0x0;
        } phy_tmds_cken[0:0];
    } PERI_CRG69 @ 0x114;

    reg {
        name = "USB 2.0 clock and soft reset control register";
        desc = "USB 2.0 clock and soft reset control register.

USB 2.0 clock/reset. Reset 0x530F: clocks on, usb2_phy_test_srst_req, usb2_vcc_srst_req, usb2_phy_port_treq and usb2_phy_req all 1 (in reset). The order of releasing the PHY POR (usb2_phy_req), the PHY port reset (usb2_phy_port_treq) and the controller resets is not given in this register description (see the USB chapter); MISC_CTRL8 holds the USB controller options.

Data sheet 3.2.6 PERI_CRG80 (offset 0x140, printed page 3-36, `hi3516av300--Hi3516AV300-Datasheet.txt` line 8407).";

        enum PERI_CRG80_usb2_utmi_pctrl_enum {
            NOT_INVERTED = 0 { name = "Not Inverted"; desc = "Clock not inverted"; };
            INVERTED = 1 { name = "Inverted"; desc = "Clock inverted"; };
        };

        field {
            name = "usb2_utmi_pctrl";
            desc = "USB2.0 UTMI clock phase control. 0: clock not inverted, 1: clock inverted.";
            sw = rw;
            hw = r;
            encode = PERI_CRG80_usb2_utmi_pctrl_enum;
            reset = 0x0;
        } usb2_utmi_pctrl[15:15];

        enum PERI_CRG80_usb2_phy_test_srst_req_enum {
            DEASSERT_RESET = 0 { name = "Deassert Reset"; desc = "Deassert reset"; };
            ASSERT_RESET = 1 { name = "Assert Reset"; desc = "Reset"; };
        };

        field {
            name = "usb2_phy_test_srst_req";
            desc = "USB2.0 PHY TEST soft reset request. 0: deassert reset, 1: reset.";
            sw = rw;
            hw = r;
            encode = PERI_CRG80_usb2_phy_test_srst_req_enum;
            reset = 0x1;
        } usb2_phy_test_srst_req[14:14];

        enum PERI_CRG80_usb2_utmi_cksel_enum {
            PHY_CLOCK = 0 { name = "Phy Clock"; desc = "USB 2.0 PHY clock"; };
            INTERNAL_60MHZ = 1 { name = "Internal 60Mhz"; desc = "Internal 60 MHz"; };
        };

        field {
            name = "usb2_utmi_cksel";
            desc = "USB2.0 UTMI clock source select. 0: USB 2.0 PHY clock, 1: internal 60 MHz.";
            sw = rw;
            hw = r;
            encode = PERI_CRG80_usb2_utmi_cksel_enum;
            reset = 0x0;
        } usb2_utmi_cksel[13:13];

        enum PERI_CRG80_usb2_utmi_cken_enum {
            CLOCK_OFF = 0 { name = "Clock Off"; desc = "Clock off"; };
            CLOCK_ON = 1 { name = "Clock On"; desc = "Clock on"; };
        };

        field {
            name = "usb2_utmi_cken";
            desc = "USB2.0 controller UTMI clock gate. 0: clock off, 1: clock on.";
            sw = rw;
            hw = r;
            encode = PERI_CRG80_usb2_utmi_cken_enum;
            reset = 0x1;
        } usb2_utmi_cken[12:12];

        enum PERI_CRG80_usb2_ref_cken_enum {
            CLOCK_OFF = 0 { name = "Clock Off"; desc = "Clock off"; };
            CLOCK_ON = 1 { name = "Clock On"; desc = "Clock on"; };
        };

        field {
            name = "usb2_ref_cken";
            desc = "USB2.0 controller REF clock gate. 0: clock off, 1: clock on.";
            sw = rw;
            hw = r;
            encode = PERI_CRG80_usb2_ref_cken_enum;
            reset = 0x1;
        } usb2_ref_cken[9:9];

        enum PERI_CRG80_usb2_bus_cken_enum {
            CLOCK_OFF = 0 { name = "Clock Off"; desc = "Clock off"; };
            CLOCK_ON = 1 { name = "Clock On"; desc = "Clock on"; };
        };

        field {
            name = "usb2_bus_cken";
            desc = "USB2.0 controller bus clock gate. 0: clock off, 1: clock on.";
            sw = rw;
            hw = r;
            encode = PERI_CRG80_usb2_bus_cken_enum;
            reset = 0x1;
        } usb2_bus_cken[8:8];

        enum PERI_CRG80_usb2_vcc_srst_req_enum {
            NOT_RESET = 0 { name = "Not Reset"; desc = "Not reset"; };
            ASSERT_RESET = 1 { name = "Assert Reset"; desc = "Reset"; };
        };

        field {
            name = "usb2_vcc_srst_req";
            desc = "USB2.0 controller VCC soft reset request. 0: not reset, 1: reset.";
            sw = rw;
            hw = r;
            encode = PERI_CRG80_usb2_vcc_srst_req_enum;
            reset = 0x1;
        } usb2_vcc_srst_req[3:3];

        enum PERI_CRG80_usb2_phy_cken_enum {
            CLOCK_OFF = 0 { name = "Clock Off"; desc = "Clock off"; };
            CLOCK_ON = 1 { name = "Clock On"; desc = "Clock on"; };
        };

        field {
            name = "usb2_phy_cken";
            desc = "USB2.0 PHY reference clock gate. 0: clock off, 1: clock on.";
            sw = rw;
            hw = r;
            encode = PERI_CRG80_usb2_phy_cken_enum;
            reset = 0x1;
        } usb2_phy_cken[2:2];

        enum PERI_CRG80_usb2_phy_port_treq_enum {
            NOT_RESET = 0 { name = "Not Reset"; desc = "Not reset"; };
            ASSERT_RESET = 1 { name = "Assert Reset"; desc = "Reset"; };
        };

        field {
            name = "usb2_phy_port_treq";
            desc = "USB2.0 PHY TPOR soft reset request. 0: not reset, 1: reset.";
            sw = rw;
            hw = r;
            encode = PERI_CRG80_usb2_phy_port_treq_enum;
            reset = 0x1;
        } usb2_phy_port_treq[1:1];

        enum PERI_CRG80_usb2_phy_req_enum {
            NOT_RESET = 0 { name = "Not Reset"; desc = "Not reset"; };
            ASSERT_RESET = 1 { name = "Assert Reset"; desc = "Reset"; };
        };

        field {
            name = "usb2_phy_req";
            desc = "USB2.0 PHY POR soft reset request. 0: not reset, 1: reset.";
            sw = rw;
            hw = r;
            encode = PERI_CRG80_usb2_phy_req_enum;
            reset = 0x1;
        } usb2_phy_req[0:0];
    } PERI_CRG80 @ 0x140;

    reg {
        name = "FMC clock and soft reset control register";
        desc = "FMC clock and soft reset control register.

FMC (SPI NOR/NAND controller) clock/reset. Reset 0x2: 24 MHz, clock on. The chip clock is the selected clock divided by 2 in SDR mode and by 4 in DDR mode, so 396 MHz DDR gives a 99 MHz flash clock. The vendor Linux driver uses fmc_mux at 0x144[4:2] with the same eight frequencies and the gate at bit 1.

Data sheet 3.2.6 PERI_CRG81 (offset 0x144, printed page 3-38, `hi3516av300--Hi3516AV300-Datasheet.txt` line 8493).";

        enum PERI_CRG81_fmc_cksel_enum {
            CLK_24MHZ = 0 { name = "Clk 24Mhz"; desc = "24 MHz"; };
            CLK_100MHZ = 1 { name = "Clk 100Mhz"; desc = "100 MHz"; };
            CLK_150MHZ = 2 { name = "Clk 150Mhz"; desc = "150 MHz"; };
            CLK_163MHZ = 3 { name = "Clk 163Mhz"; desc = "163 MHz"; };
            CLK_200MHZ = 4 { name = "Clk 200Mhz"; desc = "200 MHz"; };
            CLK_257MHZ = 5 { name = "Clk 257Mhz"; desc = "257 MHz"; };
            CLK_300MHZ = 6 { name = "Clk 300Mhz"; desc = "300 MHz (DDR mode only)"; };
            CLK_396MHZ = 7 { name = "Clk 396Mhz"; desc = "396 MHz (DDR mode only)"; };
        };

        field {
            name = "fmc_cksel";
            desc = "FMC clock source select. In SDR mode the actual clock is the selected clock divided by 2; in DDR mode it is divided by 4. The vendor Linux clock driver uses the same table {24, 100, 150, 163, 200, 257, 300, 396 MHz}.";
            sw = rw;
            hw = r;
            encode = PERI_CRG81_fmc_cksel_enum;
            reset = 0x0;
        } fmc_cksel[4:2];

        enum PERI_CRG81_fmc_cken_enum {
            CLOCK_OFF = 0 { name = "Clock Off"; desc = "Clock off"; };
            CLOCK_ON = 1 { name = "Clock On"; desc = "Clock on"; };
        };

        field {
            name = "fmc_cken";
            desc = "FMC clock gate. 0: clock off, 1: clock on.";
            sw = rw;
            hw = r;
            encode = PERI_CRG81_fmc_cken_enum;
            reset = 0x1;
        } fmc_cken[1:1];

        enum PERI_CRG81_fmc_srst_req_enum {
            DEASSERT_RESET = 0 { name = "Deassert Reset"; desc = "Deassert reset"; };
            ASSERT_RESET = 1 { name = "Assert Reset"; desc = "Reset"; };
        };

        field {
            name = "fmc_srst_req";
            desc = "FMC soft reset request. 0: deassert reset, 1: reset.";
            sw = rw;
            hw = r;
            encode = PERI_CRG81_fmc_srst_req_enum;
            reset = 0x0;
        } fmc_srst_req[0:0];
    } PERI_CRG81 @ 0x144;

    reg {
        name = "eMMC clock and soft reset control register";
        desc = "eMMC clock and soft reset control register.

eMMC clock/reset. Reset 0xA: emmc_cksel = 2 (50 MHz, as the Table 3-2 default), clock on. The vendor Linux table is {100m, 50m, 25m} at 0x148[3:2] with values 1, 2, 3, gate bit 1.

Data sheet 3.2.6 PERI_CRG82 (offset 0x148, printed page 3-38, `hi3516av300--Hi3516AV300-Datasheet.txt` line 8541).";

        enum PERI_CRG82_emmc_cksel_enum {
            RESERVED_0 = 0 { name = "Reserved 0"; desc = "Reserved"; };
            CLK_100MHZ = 1 { name = "Clk 100Mhz"; desc = "100 MHz"; };
            CLK_50MHZ = 2 { name = "Clk 50Mhz"; desc = "50 MHz"; };
            CLK_25MHZ = 3 { name = "Clk 25Mhz"; desc = "25 MHz"; };
        };

        field {
            name = "emmc_cksel";
            desc = "EMMC working clock select.";
            sw = rw;
            hw = r;
            encode = PERI_CRG82_emmc_cksel_enum;
            reset = 0x2;
        } emmc_cksel[3:2];

        enum PERI_CRG82_emmc_cken_enum {
            CLOCK_OFF = 0 { name = "Clock Off"; desc = "Clock off"; };
            CLOCK_ON = 1 { name = "Clock On"; desc = "Clock on"; };
        };

        field {
            name = "emmc_cken";
            desc = "EMMC clock gate. 0: clock off, 1: clock on.";
            sw = rw;
            hw = r;
            encode = PERI_CRG82_emmc_cken_enum;
            reset = 0x1;
        } emmc_cken[1:1];

        enum PERI_CRG82_emmc_srst_req_enum {
            DEASSERT_RESET = 0 { name = "Deassert Reset"; desc = "Deassert reset"; };
            ASSERT_RESET = 1 { name = "Assert Reset"; desc = "Reset"; };
        };

        field {
            name = "emmc_srst_req";
            desc = "EMMC soft reset request. 0: deassert reset, 1: reset.";
            sw = rw;
            hw = r;
            encode = PERI_CRG82_emmc_srst_req_enum;
            reset = 0x0;
        } emmc_srst_req[0:0];
    } PERI_CRG82 @ 0x148;

    reg {
        name = "eMMC DLL clock and soft reset control register";
        desc = "eMMC DLL clock and soft reset control register.

eMMC DLL control (sample delay line). Reset 0x00030001: sap_dll_bypass = 1, sap_dll_dllmode = 1, emmc_dll_cken = 1.

Data sheet 3.2.6 PERI_CRG83 (offset 0x14C, printed page 3-39, `hi3516av300--Hi3516AV300-Datasheet.txt` line 8575).";

        enum PERI_CRG83_emmc_sap_dll_slave_en_enum {
            SLAVE_STOPPED = 0 { name = "Slave Stopped"; desc = "Slave stopped"; };
            SLAVE_RUNNING = 1 { name = "Slave Running"; desc = "Slave running"; };
        };

        field {
            name = "emmc_sap_dll_slave_en";
            desc = "Slave delay line enable of EMMC_SAP_DLL. 0: slave stopped, 1: slave running.";
            sw = rw;
            hw = r;
            encode = PERI_CRG83_emmc_sap_dll_slave_en_enum;
            reset = 0x0;
        } emmc_sap_dll_slave_en[19:19];

        enum PERI_CRG83_emmc_sap_dll_stop_enum {
            DETECT_ENABLED = 0 { name = "Detect Enabled"; desc = "Clock detection enabled"; };
            DETECT_DISABLED = 1 { name = "Detect Disabled"; desc = "Clock detection disabled"; };
        };

        field {
            name = "emmc_sap_dll_stop";
            desc = "EMMC_SAP_DLL MASTER clock-period calculation stop signal. 0: clock detection enabled, 1: clock detection disabled.";
            sw = rw;
            hw = r;
            encode = PERI_CRG83_emmc_sap_dll_stop_enum;
            reset = 0x0;
        } emmc_sap_dll_stop[18:18];

        enum PERI_CRG83_emmc_sap_dll_bypass_enum {
            NORMAL = 0 { name = "Normal"; desc = "Normal mode"; };
            SLAVE_LINE_BYPASS = 1 { name = "Slave Line Bypass"; desc = "Slave line bypass"; };
        };

        field {
            name = "emmc_sap_dll_bypass";
            desc = "EMMC_SAP_DLL SLAVE LINE bypass. 0: normal mode, 1: slave line bypass.";
            sw = rw;
            hw = r;
            encode = PERI_CRG83_emmc_sap_dll_bypass_enum;
            reset = 0x1;
        } emmc_sap_dll_bypass[17:17];

        enum PERI_CRG83_emmc_sap_dll_dllmode_enum {
            NORMAL = 0 { name = "Normal"; desc = "Normal mode"; };
            DLLSSEL_CONTROLLED = 1 { name = "Dllssel Controlled"; desc = "SLAVE LINE controlled by EMMC_SAP_DLL_dllssel"; };
        };

        field {
            name = "emmc_sap_dll_dllmode";
            desc = "EMMC_SAP_DLL mode select. 0: normal mode, 1: SLAVE LINE controlled by EMMC_SAP_DLL_dllssel.";
            sw = rw;
            hw = r;
            encode = PERI_CRG83_emmc_sap_dll_dllmode_enum;
            reset = 0x1;
        } emmc_sap_dll_dllmode[16:16];

        field {
            name = "emmc_sap_dll_dllssel";
            desc = "EMMC_SAP_DLL SLAVE LINE delay stage select; valid when EMMC_SAP_DLL_dllmode is 1.";
            sw = rw;
            hw = r;
            reset = 0x0;
        } emmc_sap_dll_dllssel[15:8];

        field {
            name = "emmc_sap_dll_tune";
            desc = "EMMC SAP DLL SLAVE tap calibration. 0000 and 1000: no calibration; 0001..0111: add 1..7 delay stages; 1001..1111: remove 1..7 delay stages.";
            sw = rw;
            hw = r;
            reset = 0x0;
        } emmc_sap_dll_tune[7:4];

        enum PERI_CRG83_emmc_dll_srst_req_enum {
            DEASSERT_RESET = 0 { name = "Deassert Reset"; desc = "Deassert reset"; };
            ASSERT_RESET = 1 { name = "Assert Reset"; desc = "Reset"; };
        };

        field {
            name = "emmc_dll_srst_req";
            desc = "EMMC_SAP_DLL soft reset request. 0: deassert reset, 1: reset.";
            sw = rw;
            hw = r;
            encode = PERI_CRG83_emmc_dll_srst_req_enum;
            reset = 0x0;
        } emmc_dll_srst_req[1:1];

        enum PERI_CRG83_emmc_dll_cken_enum {
            CLOCK_OFF = 0 { name = "Clock Off"; desc = "Clock off"; };
            CLOCK_ON = 1 { name = "Clock On"; desc = "Clock on"; };
        };

        field {
            name = "emmc_dll_cken";
            desc = "EMMC_SAP_DLL clock gate. 0: clock off, 1: clock on.";
            sw = rw;
            hw = r;
            encode = PERI_CRG83_emmc_dll_cken_enum;
            reset = 0x1;
        } emmc_dll_cken[0:0];
    } PERI_CRG83 @ 0x14C;

    reg {
        name = "eMMC DLL status register";
        desc = "eMMC DLL status register.

eMMC DLL status. emmc_sap_dll_mdly_tap is spelled `EMMC_SAP_DLL` in the layout dump and `emmc_sap_dll_mdly_tap` (name wrapped over two lines) in the PDF text.

Data sheet 3.2.6 PERI_CRG84 (offset 0x150, printed page 3-40, `hi3516av300--Hi3516AV300-Datasheet.txt` line 8674).";

        enum PERI_CRG84_emmc_sap_dll_overflow_enum {
            NOT_OVERFLOWED = 0 { name = "Not Overflowed"; desc = "EMMC_SAP_DLL MASTER not overflowed"; };
            OVERFLOWED = 1 { name = "Overflowed"; desc = "EMMC_SAP_DLL MASTER overflowed"; };
        };

        field {
            name = "emmc_sap_dll_overflow";
            desc = "EMMC_SAP_DLL MASTER overflow status. 0: EMMC_SAP_DLL MASTER not overflowed, 1: EMMC_SAP_DLL MASTER overflowed.";
            sw = r;
            hw = w;
            encode = PERI_CRG84_emmc_sap_dll_overflow_enum;
            reset = 0x0;
        } emmc_sap_dll_overflow[10:10];

        enum PERI_CRG84_emmc_sap_dll_ready_enum {
            NOT_READY = 0 { name = "Not Ready"; desc = "EMMC_SAP_DLL SLAVE not ready"; };
            READY = 1 { name = "Ready"; desc = "EMMC_SAP_DLL SLAVE ready"; };
        };

        field {
            name = "emmc_sap_dll_ready";
            desc = "EMMC_SAP_DLL SLAVE ready status. 0: EMMC_SAP_DLL SLAVE not ready, 1: EMMC_SAP_DLL SLAVE ready.";
            sw = r;
            hw = w;
            encode = PERI_CRG84_emmc_sap_dll_ready_enum;
            reset = 0x0;
        } emmc_sap_dll_ready[9:9];

        enum PERI_CRG84_emmc_sap_dll_locked_enum {
            NOT_LOCKED = 0 { name = "Not Locked"; desc = "EMMC_SAP_DLL MASTER not locked"; };
            LOCKED = 1 { name = "Locked"; desc = "EMMC_SAP_DLL MASTER locked"; };
        };

        field {
            name = "emmc_sap_dll_locked";
            desc = "EMMC_SAP_DLL MASTER lock signal. 0: EMMC_SAP_DLL MASTER not locked, 1: EMMC_SAP_DLL MASTER locked.";
            sw = r;
            hw = w;
            encode = PERI_CRG84_emmc_sap_dll_locked_enum;
            reset = 0x0;
        } emmc_sap_dll_locked[8:8];

        field {
            name = "emmc_sap_dll_mdly_tap";
            desc = "EMMC_SAP_DLL MASTER LINE tap value.";
            sw = r;
            hw = w;
            reset = 0x0;
        } emmc_sap_dll_mdly_tap[7:0];
    } PERI_CRG84 @ 0x150;

    reg {
        name = "SDIO1 clock and soft reset control register";
        desc = "SDIO1 clock and soft reset control register.

SDIO1 clock/reset. Reset 0xA: sdio1_cksel = 2 (50 MHz, Table 3-2 default), clock on. Vendor Linux: mmc at 0x154[3:2].

Data sheet 3.2.6 PERI_CRG85 (offset 0x154, printed page 3-41, `hi3516av300--Hi3516AV300-Datasheet.txt` line 8717).";

        enum PERI_CRG85_sdio1_cksel_enum {
            RESERVED_0 = 0 { name = "Reserved 0"; desc = "Reserved"; };
            CLK_100MHZ = 1 { name = "Clk 100Mhz"; desc = "100 MHz"; };
            CLK_50MHZ = 2 { name = "Clk 50Mhz"; desc = "50 MHz"; };
            CLK_25MHZ = 3 { name = "Clk 25Mhz"; desc = "25 MHz"; };
        };

        field {
            name = "sdio1_cksel";
            desc = "SDIO1 working clock select.";
            sw = rw;
            hw = r;
            encode = PERI_CRG85_sdio1_cksel_enum;
            reset = 0x2;
        } sdio1_cksel[3:2];

        enum PERI_CRG85_sdio1_cken_enum {
            CLOCK_OFF = 0 { name = "Clock Off"; desc = "Clock off"; };
            CLOCK_ON = 1 { name = "Clock On"; desc = "Clock on"; };
        };

        field {
            name = "sdio1_cken";
            desc = "SDIO1 clock gate. 0: clock off, 1: clock on.";
            sw = rw;
            hw = r;
            encode = PERI_CRG85_sdio1_cken_enum;
            reset = 0x1;
        } sdio1_cken[1:1];

        enum PERI_CRG85_sdio1_srst_req_enum {
            DEASSERT_RESET = 0 { name = "Deassert Reset"; desc = "Deassert reset"; };
            ASSERT_RESET = 1 { name = "Assert Reset"; desc = "Reset"; };
        };

        field {
            name = "sdio1_srst_req";
            desc = "SDIO1 soft reset request. 0: deassert reset, 1: reset.";
            sw = rw;
            hw = r;
            encode = PERI_CRG85_sdio1_srst_req_enum;
            reset = 0x0;
        } sdio1_srst_req[0:0];
    } PERI_CRG85 @ 0x154;

    reg {
        name = "SDIO1 DLL clock and soft reset control register";
        desc = "SDIO1 DLL clock and soft reset control register.

SDIO1 DLL control. Reset 0x00030001 as PERI_CRG83. The bit 19 name is printed `sdio1_sap_dll_slave_` (truncated); `sdio1_sap_dll_slave_en` is assumed from the eMMC/SDIO0 siblings.

Data sheet 3.2.6 PERI_CRG86 (offset 0x158, printed page 3-41, `hi3516av300--Hi3516AV300-Datasheet.txt` line 8757).";

        enum PERI_CRG86_sdio1_sap_dll_slave_en_enum {
            SLAVE_STOPPED = 0 { name = "Slave Stopped"; desc = "Slave stopped"; };
            SLAVE_RUNNING = 1 { name = "Slave Running"; desc = "Slave running"; };
        };

        field {
            name = "sdio1_sap_dll_slave_en";
            desc = "Slave delay line enable of SDIO1_SAP_DLL. 0: slave stopped, 1: slave running.";
            sw = rw;
            hw = r;
            encode = PERI_CRG86_sdio1_sap_dll_slave_en_enum;
            reset = 0x0;
        } sdio1_sap_dll_slave_en[19:19];

        enum PERI_CRG86_sdio1_sap_dll_stop_enum {
            DETECT_ENABLED = 0 { name = "Detect Enabled"; desc = "Clock detection enabled"; };
            DETECT_DISABLED = 1 { name = "Detect Disabled"; desc = "Clock detection disabled"; };
        };

        field {
            name = "sdio1_sap_dll_stop";
            desc = "SDIO1_SAP_DLL MASTER clock-period calculation stop signal. 0: clock detection enabled, 1: clock detection disabled.";
            sw = rw;
            hw = r;
            encode = PERI_CRG86_sdio1_sap_dll_stop_enum;
            reset = 0x0;
        } sdio1_sap_dll_stop[18:18];

        enum PERI_CRG86_sdio1_sap_dll_bypass_enum {
            NORMAL = 0 { name = "Normal"; desc = "Normal mode"; };
            SLAVE_LINE_BYPASS = 1 { name = "Slave Line Bypass"; desc = "Slave line bypass"; };
        };

        field {
            name = "sdio1_sap_dll_bypass";
            desc = "SDIO1_SAP_DLL SLAVE LINE bypass. 0: normal mode, 1: slave line bypass.";
            sw = rw;
            hw = r;
            encode = PERI_CRG86_sdio1_sap_dll_bypass_enum;
            reset = 0x1;
        } sdio1_sap_dll_bypass[17:17];

        enum PERI_CRG86_sdio1_sap_dll_dllmode_enum {
            NORMAL = 0 { name = "Normal"; desc = "Normal mode"; };
            DLLSSEL_CONTROLLED = 1 { name = "Dllssel Controlled"; desc = "SLAVE LINE controlled by SDIO1_SAP_DLL_dllssel"; };
        };

        field {
            name = "sdio1_sap_dll_dllmode";
            desc = "SDIO1_SAP_DLL mode select. 0: normal mode, 1: SLAVE LINE controlled by SDIO1_SAP_DLL_dllssel.";
            sw = rw;
            hw = r;
            encode = PERI_CRG86_sdio1_sap_dll_dllmode_enum;
            reset = 0x1;
        } sdio1_sap_dll_dllmode[16:16];

        field {
            name = "sdio1_sap_dll_dllssel";
            desc = "SDIO1_SAP_DLL SLAVE LINE delay stage select; valid when SDIO1_SAP_DLL_dllmode is 1.";
            sw = rw;
            hw = r;
            reset = 0x0;
        } sdio1_sap_dll_dllssel[15:8];

        field {
            name = "sdio1_sap_dll_tune";
            desc = "SDIO1 SAP DLL SLAVE tap calibration. 0000 and 1000: no calibration; 0001..0111: add 1..7 delay stages; 1001..1111: remove 1..7 delay stages.";
            sw = rw;
            hw = r;
            reset = 0x0;
        } sdio1_sap_dll_tune[7:4];

        enum PERI_CRG86_sdio1_dll_srst_req_enum {
            DEASSERT_RESET = 0 { name = "Deassert Reset"; desc = "Deassert reset"; };
            ASSERT_RESET = 1 { name = "Assert Reset"; desc = "Reset"; };
        };

        field {
            name = "sdio1_dll_srst_req";
            desc = "SDIO1_SAP_DLL soft reset request. 0: deassert reset, 1: reset.";
            sw = rw;
            hw = r;
            encode = PERI_CRG86_sdio1_dll_srst_req_enum;
            reset = 0x0;
        } sdio1_dll_srst_req[1:1];

        enum PERI_CRG86_sdio1_dll_cken_enum {
            CLOCK_OFF = 0 { name = "Clock Off"; desc = "Clock off"; };
            CLOCK_ON = 1 { name = "Clock On"; desc = "Clock on"; };
        };

        field {
            name = "sdio1_dll_cken";
            desc = "SDIO1_SAP_DLL clock gate. 0: clock off, 1: clock on.";
            sw = rw;
            hw = r;
            encode = PERI_CRG86_sdio1_dll_cken_enum;
            reset = 0x1;
        } sdio1_dll_cken[0:0];
    } PERI_CRG86 @ 0x158;

    reg {
        name = "SDIO1 DLL status register";
        desc = "SDIO1 DLL status register.

SDIO1 DLL status.

Data sheet 3.2.6 PERI_CRG87 (offset 0x15C, printed page 3-43, `hi3516av300--Hi3516AV300-Datasheet.txt` line 8857).";

        enum PERI_CRG87_sdio1_sap_dll_overflow_enum {
            NOT_OVERFLOWED = 0 { name = "Not Overflowed"; desc = "SDIO1_SAP_DLL MASTER not overflowed"; };
            OVERFLOWED = 1 { name = "Overflowed"; desc = "SDIO1_SAP_DLL MASTER overflowed"; };
        };

        field {
            name = "sdio1_sap_dll_overflow";
            desc = "SDIO1_SAP_DLL MASTER overflow status. 0: SDIO1_SAP_DLL MASTER not overflowed, 1: SDIO1_SAP_DLL MASTER overflowed.";
            sw = r;
            hw = w;
            encode = PERI_CRG87_sdio1_sap_dll_overflow_enum;
            reset = 0x0;
        } sdio1_sap_dll_overflow[10:10];

        enum PERI_CRG87_sdio1_sap_dll_ready_enum {
            NOT_READY = 0 { name = "Not Ready"; desc = "SDIO1_SAP_DLL SLAVE not ready"; };
            READY = 1 { name = "Ready"; desc = "SDIO1_SAP_DLL SLAVE ready"; };
        };

        field {
            name = "sdio1_sap_dll_ready";
            desc = "SDIO1_SAP_DLL SLAVE ready status. 0: SDIO1_SAP_DLL SLAVE not ready, 1: SDIO1_SAP_DLL SLAVE ready.";
            sw = r;
            hw = w;
            encode = PERI_CRG87_sdio1_sap_dll_ready_enum;
            reset = 0x0;
        } sdio1_sap_dll_ready[9:9];

        enum PERI_CRG87_sdio1_sap_dll_locked_enum {
            NOT_LOCKED = 0 { name = "Not Locked"; desc = "SDIO1_SAP_DLL MASTER not locked"; };
            LOCKED = 1 { name = "Locked"; desc = "SDIO1_SAP_DLL MASTER locked"; };
        };

        field {
            name = "sdio1_sap_dll_locked";
            desc = "SDIO1_SAP_DLL MASTER lock signal. 0: SDIO1_SAP_DLL MASTER not locked, 1: SDIO1_SAP_DLL MASTER locked.";
            sw = r;
            hw = w;
            encode = PERI_CRG87_sdio1_sap_dll_locked_enum;
            reset = 0x0;
        } sdio1_sap_dll_locked[8:8];

        field {
            name = "sdio1_sap_dll_mdly_tap";
            desc = "SDIO1_SAP_DLL MASTER LINE tap value.";
            sw = r;
            hw = w;
            reset = 0x0;
        } sdio1_sap_dll_mdly_tap[7:0];
    } PERI_CRG87 @ 0x15C;

    reg {
        name = "SDIO0 clock and soft reset control register";
        desc = "SDIO0 clock and soft reset control register.

SDIO0 clock/reset. Reset 0xE: sdio0_cksel = 3 (25 MHz, Table 3-2 default), clock on. Vendor Linux: mmc at 0x160[3:2].

Data sheet 3.2.6 PERI_CRG88 (offset 0x160, printed page 3-43, `hi3516av300--Hi3516AV300-Datasheet.txt` line 8900).";

        enum PERI_CRG88_sdio0_cksel_enum {
            RESERVED_0 = 0 { name = "Reserved 0"; desc = "Reserved"; };
            CLK_100MHZ = 1 { name = "Clk 100Mhz"; desc = "100 MHz"; };
            CLK_50MHZ = 2 { name = "Clk 50Mhz"; desc = "50 MHz"; };
            CLK_25MHZ = 3 { name = "Clk 25Mhz"; desc = "25 MHz"; };
        };

        field {
            name = "sdio0_cksel";
            desc = "SDIO0 working clock select.";
            sw = rw;
            hw = r;
            encode = PERI_CRG88_sdio0_cksel_enum;
            reset = 0x3;
        } sdio0_cksel[3:2];

        enum PERI_CRG88_sdio0_cken_enum {
            CLOCK_OFF = 0 { name = "Clock Off"; desc = "Clock off"; };
            CLOCK_ON = 1 { name = "Clock On"; desc = "Clock on"; };
        };

        field {
            name = "sdio0_cken";
            desc = "SDIO0 clock gate. 0: clock off, 1: clock on.";
            sw = rw;
            hw = r;
            encode = PERI_CRG88_sdio0_cken_enum;
            reset = 0x1;
        } sdio0_cken[1:1];

        enum PERI_CRG88_sdio0_srst_req_enum {
            DEASSERT_RESET = 0 { name = "Deassert Reset"; desc = "Deassert reset"; };
            ASSERT_RESET = 1 { name = "Assert Reset"; desc = "Reset"; };
        };

        field {
            name = "sdio0_srst_req";
            desc = "SDIO0 soft reset request. 0: deassert reset, 1: reset.";
            sw = rw;
            hw = r;
            encode = PERI_CRG88_sdio0_srst_req_enum;
            reset = 0x0;
        } sdio0_srst_req[0:0];
    } PERI_CRG88 @ 0x160;

    reg {
        name = "SDIO0 DLL clock and soft reset control register";
        desc = "SDIO0 DLL clock and soft reset control register.

SDIO0 DLL control. Reset 0x00030001 as PERI_CRG83.

Data sheet 3.2.6 PERI_CRG89 (offset 0x164, printed page 3-44, `hi3516av300--Hi3516AV300-Datasheet.txt` line 8936).";

        enum PERI_CRG89_sdio0_sap_dll_slave_en_enum {
            SLAVE_STOPPED = 0 { name = "Slave Stopped"; desc = "Slave stopped"; };
            SLAVE_RUNNING = 1 { name = "Slave Running"; desc = "Slave running"; };
        };

        field {
            name = "sdio0_sap_dll_slave_en";
            desc = "Slave delay line enable of SDIO0_SAP_DLL. 0: slave stopped, 1: slave running.";
            sw = rw;
            hw = r;
            encode = PERI_CRG89_sdio0_sap_dll_slave_en_enum;
            reset = 0x0;
        } sdio0_sap_dll_slave_en[19:19];

        enum PERI_CRG89_sdio0_sap_dll_stop_enum {
            DETECT_ENABLED = 0 { name = "Detect Enabled"; desc = "Clock detection enabled"; };
            DETECT_DISABLED = 1 { name = "Detect Disabled"; desc = "Clock detection disabled"; };
        };

        field {
            name = "sdio0_sap_dll_stop";
            desc = "SDIO0_SAP_DLL MASTER clock-period calculation stop signal. 0: clock detection enabled, 1: clock detection disabled.";
            sw = rw;
            hw = r;
            encode = PERI_CRG89_sdio0_sap_dll_stop_enum;
            reset = 0x0;
        } sdio0_sap_dll_stop[18:18];

        enum PERI_CRG89_sdio0_sap_dll_bypass_enum {
            NORMAL = 0 { name = "Normal"; desc = "Normal mode"; };
            SLAVE_LINE_BYPASS = 1 { name = "Slave Line Bypass"; desc = "Slave line bypass"; };
        };

        field {
            name = "sdio0_sap_dll_bypass";
            desc = "SDIO0_SAP_DLL SLAVE LINE bypass. 0: normal mode, 1: slave line bypass.";
            sw = rw;
            hw = r;
            encode = PERI_CRG89_sdio0_sap_dll_bypass_enum;
            reset = 0x1;
        } sdio0_sap_dll_bypass[17:17];

        enum PERI_CRG89_sdio0_sap_dll_dllmode_enum {
            NORMAL = 0 { name = "Normal"; desc = "Normal mode"; };
            DLLSSEL_CONTROLLED = 1 { name = "Dllssel Controlled"; desc = "SLAVE LINE controlled by SDIO0_SAP_DLL_dllssel"; };
        };

        field {
            name = "sdio0_sap_dll_dllmode";
            desc = "SDIO0_SAP_DLL mode select. 0: normal mode, 1: SLAVE LINE controlled by SDIO0_SAP_DLL_dllssel.";
            sw = rw;
            hw = r;
            encode = PERI_CRG89_sdio0_sap_dll_dllmode_enum;
            reset = 0x1;
        } sdio0_sap_dll_dllmode[16:16];

        field {
            name = "sdio0_sap_dll_dllssel";
            desc = "SDIO0_SAP_DLL SLAVE LINE delay stage select; valid when SDIO0_SAP_DLL_dllmode is 1.";
            sw = rw;
            hw = r;
            reset = 0x0;
        } sdio0_sap_dll_dllssel[15:8];

        field {
            name = "sdio0_sap_dll_tune";
            desc = "SDIO0 SAP DLL SLAVE tap calibration. 0000 and 1000: no calibration; 0001..0111: add 1..7 delay stages; 1001..1111: remove 1..7 delay stages.";
            sw = rw;
            hw = r;
            reset = 0x0;
        } sdio0_sap_dll_tune[7:4];

        enum PERI_CRG89_sdio0_dll_srst_req_enum {
            DEASSERT_RESET = 0 { name = "Deassert Reset"; desc = "Deassert reset"; };
            ASSERT_RESET = 1 { name = "Assert Reset"; desc = "Reset"; };
        };

        field {
            name = "sdio0_dll_srst_req";
            desc = "SDIO0_SAP_DLL soft reset request. 0: deassert reset, 1: reset.";
            sw = rw;
            hw = r;
            encode = PERI_CRG89_sdio0_dll_srst_req_enum;
            reset = 0x0;
        } sdio0_dll_srst_req[1:1];

        enum PERI_CRG89_sdio0_dll_cken_enum {
            CLOCK_OFF = 0 { name = "Clock Off"; desc = "Clock off"; };
            CLOCK_ON = 1 { name = "Clock On"; desc = "Clock on"; };
        };

        field {
            name = "sdio0_dll_cken";
            desc = "SDIO0_SAP_DLL clock gate. 0: clock off, 1: clock on.";
            sw = rw;
            hw = r;
            encode = PERI_CRG89_sdio0_dll_cken_enum;
            reset = 0x1;
        } sdio0_dll_cken[0:0];
    } PERI_CRG89 @ 0x164;

    reg {
        name = "SDIO0 DLL status register";
        desc = "SDIO0 DLL status register.

SDIO0 DLL status.

Data sheet 3.2.6 PERI_CRG90 (offset 0x168, printed page 3-45, `hi3516av300--Hi3516AV300-Datasheet.txt` line 9025).";

        enum PERI_CRG90_sdio0_sap_dll_overflow_enum {
            NOT_OVERFLOWED = 0 { name = "Not Overflowed"; desc = "SDIO0_SAP_DLL MASTER not overflowed"; };
            OVERFLOWED = 1 { name = "Overflowed"; desc = "SDIO0_SAP_DLL MASTER overflowed"; };
        };

        field {
            name = "sdio0_sap_dll_overflow";
            desc = "SDIO0_SAP_DLL MASTER overflow status. 0: SDIO0_SAP_DLL MASTER not overflowed, 1: SDIO0_SAP_DLL MASTER overflowed.";
            sw = r;
            hw = w;
            encode = PERI_CRG90_sdio0_sap_dll_overflow_enum;
            reset = 0x0;
        } sdio0_sap_dll_overflow[10:10];

        enum PERI_CRG90_sdio0_sap_dll_ready_enum {
            NOT_READY = 0 { name = "Not Ready"; desc = "SDIO0_SAP_DLL SLAVE not ready"; };
            READY = 1 { name = "Ready"; desc = "SDIO0_SAP_DLL SLAVE ready"; };
        };

        field {
            name = "sdio0_sap_dll_ready";
            desc = "SDIO0_SAP_DLL SLAVE ready status. 0: SDIO0_SAP_DLL SLAVE not ready, 1: SDIO0_SAP_DLL SLAVE ready.";
            sw = r;
            hw = w;
            encode = PERI_CRG90_sdio0_sap_dll_ready_enum;
            reset = 0x0;
        } sdio0_sap_dll_ready[9:9];

        enum PERI_CRG90_sdio0_sap_dll_locked_enum {
            NOT_LOCKED = 0 { name = "Not Locked"; desc = "SDIO0_SAP_DLL MASTER not locked"; };
            LOCKED = 1 { name = "Locked"; desc = "SDIO0_SAP_DLL MASTER locked"; };
        };

        field {
            name = "sdio0_sap_dll_locked";
            desc = "SDIO0_SAP_DLL MASTER lock signal. 0: SDIO0_SAP_DLL MASTER not locked, 1: SDIO0_SAP_DLL MASTER locked.";
            sw = r;
            hw = w;
            encode = PERI_CRG90_sdio0_sap_dll_locked_enum;
            reset = 0x0;
        } sdio0_sap_dll_locked[8:8];

        field {
            name = "sdio0_sap_dll_mdly_tap";
            desc = "SDIO0_SAP_DLL MASTER LINE tap value.";
            sw = r;
            hw = w;
            reset = 0x0;
        } sdio0_sap_dll_mdly_tap[7:0];
    } PERI_CRG90 @ 0x168;

    reg {
        name = "ETH interface clock and soft reset control register";
        desc = "ETH interface clock and soft reset control register.

Ethernet MAC/PHY interface clock and reset. Reset 0x2: clock on, MAC reset deasserted. Bit 0 is named hrst_eth_s and bit 1 eth_cken_pre in the bit table. ethcore_cksel (bit 7) selects 100 MHz or 54 MHz (vendor Linux eth mux at 0x16C[7] {100m, 54m}, gate bit 1); ethphy_cksel [5:4] selects the PHY clock-out (25/24/27 MHz); eth_rmiick_sel (bit 2) selects the RMII clock source; ext_fephy_srst_req (bit 3) resets the integrated PHY.

Data sheet 3.2.6 PERI_CRG91 (offset 0x16C, printed page 3-46, `hi3516av300--Hi3516AV300-Datasheet.txt` line 9073).";

        enum PERI_CRG91_ethcore_cksel_enum {
            CLK_100MHZ = 0 { name = "Clk 100Mhz"; desc = "100 MHz"; };
            CLK_54MHZ = 1 { name = "Clk 54Mhz"; desc = "54 MHz"; };
        };

        field {
            name = "ethcore_cksel";
            desc = "ETH clock source select. 0: 100 MHz, 1: 54 MHz.";
            sw = rw;
            hw = r;
            encode = PERI_CRG91_ethcore_cksel_enum;
            reset = 0x0;
        } ethcore_cksel[7:7];

        enum PERI_CRG91_ethphy_cksel_enum {
            CLK_25MHZ = 0 { name = "Clk 25Mhz"; desc = "25 MHz"; };
            CLK_24MHZ = 1 { name = "Clk 24Mhz"; desc = "24 MHz"; };
            CLK_27MHZ = 2 { name = "Clk 27Mhz"; desc = "27 MHz (data sheet wildcard row; value 10)"; };
            CLK_27MHZ_2 = 3 { name = "Clk 27Mhz 2"; desc = "27 MHz (data sheet wildcard row; value 11)"; };
        };

        field {
            name = "ethphy_cksel";
            desc = "ETHPHY CLOCK OUT clock source select. Data sheet: 00 = 25 MHz, 01 = 24 MHz, 1X = 27 MHz; the 1X row is expanded to values 2 and 3.";
            sw = rw;
            hw = r;
            encode = PERI_CRG91_ethphy_cksel_enum;
            reset = 0x0;
        } ethphy_cksel[5:4];

        enum PERI_CRG91_ext_fephy_srst_req_enum {
            DEASSERT_RESET = 0 { name = "Deassert Reset"; desc = "Deassert reset"; };
            ASSERT_RESET = 1 { name = "Assert Reset"; desc = "Reset"; };
        };

        field {
            name = "ext_fephy_srst_req";
            desc = "EPHY soft reset request. 0: deassert reset, 1: reset.";
            sw = rw;
            hw = r;
            encode = PERI_CRG91_ext_fephy_srst_req_enum;
            reset = 0x0;
        } ext_fephy_srst_req[3:3];

        enum PERI_CRG91_eth_rmiick_sel_enum {
            CRG = 0 { name = "Crg"; desc = "Internal CRG clock"; };
            PAD = 1 { name = "Pad"; desc = "Clock input from the PAD"; };
        };

        field {
            name = "eth_rmiick_sel";
            desc = "ETH RMII CLK clock source select. 0: internal CRG clock, 1: clock input from the PAD.";
            sw = rw;
            hw = r;
            encode = PERI_CRG91_eth_rmiick_sel_enum;
            reset = 0x0;
        } eth_rmiick_sel[2:2];

        enum PERI_CRG91_eth_cken_pre_enum {
            CLOCK_OFF = 0 { name = "Clock Off"; desc = "Clock off"; };
            CLOCK_ON = 1 { name = "Clock On"; desc = "Clock on"; };
        };

        field {
            name = "eth_cken_pre";
            desc = "ETH clock gate. 0: clock off, 1: clock on.";
            sw = rw;
            hw = r;
            encode = PERI_CRG91_eth_cken_pre_enum;
            reset = 0x1;
        } eth_cken_pre[1:1];

        enum PERI_CRG91_hrst_eth_s_enum {
            DEASSERT_RESET = 0 { name = "Deassert Reset"; desc = "Deassert reset"; };
            ASSERT_RESET = 1 { name = "Assert Reset"; desc = "Reset"; };
        };

        field {
            name = "hrst_eth_s";
            desc = "ETH soft reset request. 0: deassert reset, 1: reset.";
            sw = rw;
            hw = r;
            encode = PERI_CRG91_hrst_eth_s_enum;
            reset = 0x0;
        } hrst_eth_s[0:0];
    } PERI_CRG91 @ 0x16C;

    reg {
        name = "GZIP clock and soft reset control register";
        desc = "GZIP clock and soft reset control register.

GZIP clock/reset. Reset 0x7: clocks on, reset deasserted; the reset status is in PERI_CRG_PLL121 gzip_rst_ok.

Data sheet 3.2.6 PERI_CRG100 (offset 0x190, printed page 3-46, `hi3516av300--Hi3516AV300-Datasheet.txt` line 9127).";

        enum PERI_CRG100_gzip_srst_req_enum {
            DEASSERT_RESET = 0 { name = "Deassert Reset"; desc = "Deassert reset"; };
            ASSERT_RESET = 1 { name = "Assert Reset"; desc = "Reset"; };
        };

        field {
            name = "gzip_srst_req";
            desc = "GZIP soft reset request. 0: deassert reset, 1: reset.";
            sw = rw;
            hw = r;
            encode = PERI_CRG100_gzip_srst_req_enum;
            reset = 0x0;
        } gzip_srst_req[3:3];

        enum PERI_CRG100_gzip_pcken_enum {
            CLOCK_OFF = 0 { name = "Clock Off"; desc = "Clock off"; };
            CLOCK_ON = 1 { name = "Clock On"; desc = "Clock on"; };
        };

        field {
            name = "gzip_pcken";
            desc = "GZIP APB clock gate. 0: clock off, 1: clock on.";
            sw = rw;
            hw = r;
            encode = PERI_CRG100_gzip_pcken_enum;
            reset = 0x1;
        } gzip_pcken[2:2];

        enum PERI_CRG100_gzip_acken_enum {
            CLOCK_OFF = 0 { name = "Clock Off"; desc = "Clock off"; };
            CLOCK_ON = 1 { name = "Clock On"; desc = "Clock on"; };
        };

        field {
            name = "gzip_acken";
            desc = "GZIP AXI clock gate. 0: clock off, 1: clock on.";
            sw = rw;
            hw = r;
            encode = PERI_CRG100_gzip_acken_enum;
            reset = 0x1;
        } gzip_acken[1:1];

        enum PERI_CRG100_gzip_cken_enum {
            CLOCK_OFF = 0 { name = "Clock Off"; desc = "Clock off"; };
            CLOCK_ON = 1 { name = "Clock On"; desc = "Clock on"; };
        };

        field {
            name = "gzip_cken";
            desc = "GZIP clock gate. 0: clock off, 1: clock on.";
            sw = rw;
            hw = r;
            encode = PERI_CRG100_gzip_cken_enum;
            reset = 0x1;
        } gzip_cken[0:0];
    } PERI_CRG100 @ 0x190;

    reg {
        name = "DMAC clock and soft reset control register";
        desc = "DMAC clock and soft reset control register.

DMAC clock/reset. Reset 0x6: AXI and APB gates on (vendor Linux gates at 0x194 bits 1 and 2).

Data sheet 3.2.6 PERI_CRG101 (offset 0x194, printed page 3-47, `hi3516av300--Hi3516AV300-Datasheet.txt` line 9166).";

        enum PERI_CRG101_dmac_cken_enum {
            CLOCK_OFF = 0 { name = "Clock Off"; desc = "Clock off"; };
            CLOCK_ON = 1 { name = "Clock On"; desc = "Clock on"; };
        };

        field {
            name = "dmac_cken";
            desc = "DMAC AXI clock gate. 0: clock off, 1: clock on.";
            sw = rw;
            hw = r;
            encode = PERI_CRG101_dmac_cken_enum;
            reset = 0x1;
        } dmac_cken[2:2];

        enum PERI_CRG101_dmac_apb_cken_enum {
            CLOCK_OFF = 0 { name = "Clock Off"; desc = "Clock off"; };
            CLOCK_ON = 1 { name = "Clock On"; desc = "Clock on"; };
        };

        field {
            name = "dmac_apb_cken";
            desc = "DMAC APB clock gate. 0: clock off, 1: clock on.";
            sw = rw;
            hw = r;
            encode = PERI_CRG101_dmac_apb_cken_enum;
            reset = 0x1;
        } dmac_apb_cken[1:1];

        enum PERI_CRG101_dmac_srst_req_enum {
            NOT_RESET = 0 { name = "Not Reset"; desc = "Not reset"; };
            ASSERT_RESET = 1 { name = "Assert Reset"; desc = "Reset"; };
        };

        field {
            name = "dmac_srst_req";
            desc = "DMAC soft reset request. 0: not reset, 1: reset.";
            sw = rw;
            hw = r;
            encode = PERI_CRG101_dmac_srst_req_enum;
            reset = 0x0;
        } dmac_srst_req[0:0];
    } PERI_CRG101 @ 0x194;

    reg {
        name = "DDRT clock and soft reset control register";
        desc = "DDRT clock and soft reset control register.

DDRT clock/reset.

Data sheet 3.2.6 PERI_CRG102 (offset 0x198, printed page 3-48, `hi3516av300--Hi3516AV300-Datasheet.txt` line 9199).";

        enum PERI_CRG102_ddrt_cken_enum {
            CLOCK_OFF = 0 { name = "Clock Off"; desc = "Clock off"; };
            CLOCK_ON = 1 { name = "Clock On"; desc = "Clock on"; };
        };

        field {
            name = "ddrt_cken";
            desc = "DDRT clock gate. 0: clock off, 1: clock on.";
            sw = rw;
            hw = r;
            encode = PERI_CRG102_ddrt_cken_enum;
            reset = 0x0;
        } ddrt_cken[1:1];

        enum PERI_CRG102_ddrt_srst_req_enum {
            DEASSERT_RESET = 0 { name = "Deassert Reset"; desc = "Deassert reset"; };
            ASSERT_RESET = 1 { name = "Assert Reset"; desc = "Reset"; };
        };

        field {
            name = "ddrt_srst_req";
            desc = "DDRT soft reset request. 0: deassert reset, 1: reset.";
            sw = rw;
            hw = r;
            encode = PERI_CRG102_ddrt_srst_req_enum;
            reset = 0x0;
        } ddrt_srst_req[0:0];
    } PERI_CRG102 @ 0x198;

    reg {
        name = "AIAO clock and reset control register";
        desc = "AIAO clock and reset control register.

AIAO clock/reset. pop_srst_req resets the anti-pop (pop noise suppression) logic.

Data sheet 3.2.6 PERI_CRG103 (offset 0x19C, printed page 3-48, `hi3516av300--Hi3516AV300-Datasheet.txt` line 9220).";

        enum PERI_CRG103_aiao_pll_cken_enum {
            CLOCK_OFF = 0 { name = "Clock Off"; desc = "Clock off"; };
            CLOCK_ON = 1 { name = "Clock On"; desc = "Clock on"; };
        };

        field {
            name = "aiao_pll_cken";
            desc = "AIAO PLL clock gate. 0: clock off, 1: clock on.";
            sw = rw;
            hw = r;
            encode = PERI_CRG103_aiao_pll_cken_enum;
            reset = 0x0;
        } aiao_pll_cken[3:3];

        enum PERI_CRG103_pop_srst_req_enum {
            DEASSERT_RESET = 0 { name = "Deassert Reset"; desc = "Deassert reset"; };
            ASSERT_RESET = 1 { name = "Assert Reset"; desc = "Reset"; };
        };

        field {
            name = "pop_srst_req";
            desc = "Anti-pop (pop noise suppression) soft reset request. 0: deassert reset, 1: reset.";
            sw = rw;
            hw = r;
            encode = PERI_CRG103_pop_srst_req_enum;
            reset = 0x0;
        } pop_srst_req[2:2];

        enum PERI_CRG103_aiao_cken_enum {
            CLOCK_OFF = 0 { name = "Clock Off"; desc = "Clock off"; };
            CLOCK_ON = 1 { name = "Clock On"; desc = "Clock on"; };
        };

        field {
            name = "aiao_cken";
            desc = "AIAO clock gate. 0: clock off, 1: clock on.";
            sw = rw;
            hw = r;
            encode = PERI_CRG103_aiao_cken_enum;
            reset = 0x0;
        } aiao_cken[1:1];

        enum PERI_CRG103_aiao_srst_req_enum {
            DEASSERT_RESET = 0 { name = "Deassert Reset"; desc = "Deassert reset"; };
            ASSERT_RESET = 1 { name = "Assert Reset"; desc = "Reset"; };
        };

        field {
            name = "aiao_srst_req";
            desc = "AIAO soft reset request. 0: deassert reset, 1: reset.";
            sw = rw;
            hw = r;
            encode = PERI_CRG103_aiao_srst_req_enum;
            reset = 0x0;
        } aiao_srst_req[0:0];
    } PERI_CRG103 @ 0x19C;

    reg {
        name = "SPACC/RSA/TRNG/KLAD clock and soft reset control register";
        desc = "SPACC/RSA/TRNG/KLAD clock and soft reset control register.

Crypto block clocks/resets. Reset 0x2AA: all five clock gates on, resets deasserted. spacc_srst_req_ini is printed with that name in the bit table. The data sheet notes: not writable by a non-secure CPU in secure mode.

Data sheet 3.2.6 PERI_CRG104 (offset 0x1A0, printed page 3-49, `hi3516av300--Hi3516AV300-Datasheet.txt` line 9264).";

        enum PERI_CRG104_spacc_cken_enum {
            CLOCK_OFF = 0 { name = "Clock Off"; desc = "Clock off"; };
            CLOCK_ON = 1 { name = "Clock On"; desc = "Clock on"; };
        };

        field {
            name = "spacc_cken";
            desc = "SPACC clock gate. 0: clock off, 1: clock on.";
            sw = rw;
            hw = r;
            encode = PERI_CRG104_spacc_cken_enum;
            reset = 0x1;
        } spacc_cken[9:9];

        enum PERI_CRG104_spacc_srst_req_ini_enum {
            DEASSERT_RESET = 0 { name = "Deassert Reset"; desc = "Deassert reset"; };
            ASSERT_RESET = 1 { name = "Assert Reset"; desc = "Reset"; };
        };

        field {
            name = "spacc_srst_req_ini";
            desc = "SPACC soft reset request. 0: deassert reset, 1: reset.";
            sw = rw;
            hw = r;
            encode = PERI_CRG104_spacc_srst_req_ini_enum;
            reset = 0x0;
        } spacc_srst_req_ini[8:8];

        enum PERI_CRG104_rsa1_cken_enum {
            CLOCK_OFF = 0 { name = "Clock Off"; desc = "Clock off"; };
            CLOCK_ON = 1 { name = "Clock On"; desc = "Clock on"; };
        };

        field {
            name = "rsa1_cken";
            desc = "RSA1 clock gate. 0: clock off, 1: clock on.";
            sw = rw;
            hw = r;
            encode = PERI_CRG104_rsa1_cken_enum;
            reset = 0x1;
        } rsa1_cken[7:7];

        enum PERI_CRG104_rsa1_srst_req_enum {
            DEASSERT_RESET = 0 { name = "Deassert Reset"; desc = "Deassert reset"; };
            ASSERT_RESET = 1 { name = "Assert Reset"; desc = "Reset"; };
        };

        field {
            name = "rsa1_srst_req";
            desc = "RSA1 soft reset request. 0: deassert reset, 1: reset.";
            sw = rw;
            hw = r;
            encode = PERI_CRG104_rsa1_srst_req_enum;
            reset = 0x0;
        } rsa1_srst_req[6:6];

        enum PERI_CRG104_rsa0_cken_enum {
            CLOCK_OFF = 0 { name = "Clock Off"; desc = "Clock off"; };
            CLOCK_ON = 1 { name = "Clock On"; desc = "Clock on"; };
        };

        field {
            name = "rsa0_cken";
            desc = "RSA0 clock gate. 0: clock off, 1: clock on.";
            sw = rw;
            hw = r;
            encode = PERI_CRG104_rsa0_cken_enum;
            reset = 0x1;
        } rsa0_cken[5:5];

        enum PERI_CRG104_rsa0_srst_req_enum {
            DEASSERT_RESET = 0 { name = "Deassert Reset"; desc = "Deassert reset"; };
            ASSERT_RESET = 1 { name = "Assert Reset"; desc = "Reset"; };
        };

        field {
            name = "rsa0_srst_req";
            desc = "RSA0 soft reset request. 0: deassert reset, 1: reset.";
            sw = rw;
            hw = r;
            encode = PERI_CRG104_rsa0_srst_req_enum;
            reset = 0x0;
        } rsa0_srst_req[4:4];

        enum PERI_CRG104_trng_cken_enum {
            CLOCK_OFF = 0 { name = "Clock Off"; desc = "Clock off"; };
            CLOCK_ON = 1 { name = "Clock On"; desc = "Clock on"; };
        };

        field {
            name = "trng_cken";
            desc = "TRNG clock gate. 0: clock off, 1: clock on.";
            sw = rw;
            hw = r;
            encode = PERI_CRG104_trng_cken_enum;
            reset = 0x1;
        } trng_cken[3:3];

        enum PERI_CRG104_trng_srst_req_enum {
            DEASSERT_RESET = 0 { name = "Deassert Reset"; desc = "Deassert reset"; };
            ASSERT_RESET = 1 { name = "Assert Reset"; desc = "Reset"; };
        };

        field {
            name = "trng_srst_req";
            desc = "TRNG soft reset request. 0: deassert reset, 1: reset.";
            sw = rw;
            hw = r;
            encode = PERI_CRG104_trng_srst_req_enum;
            reset = 0x0;
        } trng_srst_req[2:2];

        enum PERI_CRG104_klad_cken_enum {
            CLOCK_OFF = 0 { name = "Clock Off"; desc = "Clock off"; };
            CLOCK_ON = 1 { name = "Clock On"; desc = "Clock on"; };
        };

        field {
            name = "klad_cken";
            desc = "KLAD clock gate. 0: clock off, 1: clock on.";
            sw = rw;
            hw = r;
            encode = PERI_CRG104_klad_cken_enum;
            reset = 0x1;
        } klad_cken[1:1];

        enum PERI_CRG104_klad_srst_req_enum {
            DEASSERT_RESET = 0 { name = "Deassert Reset"; desc = "Deassert reset"; };
            ASSERT_RESET = 1 { name = "Assert Reset"; desc = "Reset"; };
        };

        field {
            name = "klad_srst_req";
            desc = "KLAD soft reset request. 0: deassert reset, 1: reset.";
            sw = rw;
            hw = r;
            encode = PERI_CRG104_klad_srst_req_enum;
            reset = 0x0;
        } klad_srst_req[0:0];
    } PERI_CRG104 @ 0x1A0;

    reg {
        name = "AIAO MCLK2 clock configuration register";
        desc = "AIAO MCLK2 clock configuration register.

AIAO MCLK2 divider. Reset 0x001FFFFF; the 27-bit divider field resets to 0x1FFFFF and the gate to off. The data sheet gives the formula but not the source clock of the divider (low confidence on its reference).

Data sheet 3.2.6 PERI_CRG105 (offset 0x1A4, printed page 3-50, `hi3516av300--Hi3516AV300-Datasheet.txt` line 9339).";

        enum PERI_CRG105_aiao_mclk2_cken_enum {
            CLOCK_OFF = 0 { name = "Clock Off"; desc = "Clock off"; };
            CLOCK_ON = 1 { name = "Clock On"; desc = "Clock on"; };
        };

        field {
            name = "aiao_mclk2_cken";
            desc = "AIAO MCLK2 divider clock gate. 0: clock off, 1: clock on.";
            sw = rw;
            hw = r;
            encode = PERI_CRG105_aiao_mclk2_cken_enum;
            reset = 0x0;
        } aiao_mclk2_cken[27:27];

        field {
            name = "aiao_mclk2_div";
            desc = "AIAO MCLK2 divided clock, configurable. For a target frequency X (MHz): aiao_mclk2_div = (X / 1188) * 2^27; maximum 75 MHz.";
            sw = rw;
            hw = r;
            reset = 0x1FFFFF;
        } aiao_mclk2_div[26:0];
    } PERI_CRG105 @ 0x1A4;

    reg {
        name = "AIAO MCLK1 clock configuration register";
        desc = "AIAO MCLK1 clock configuration register.

AIAO MCLK1 divider; same layout as PERI_CRG105.

Data sheet 3.2.6 PERI_CRG106 (offset 0x1A8, printed page 3-50, `hi3516av300--Hi3516AV300-Datasheet.txt` line 9366).";

        enum PERI_CRG106_aiao_mclk1_cken_enum {
            CLOCK_OFF = 0 { name = "Clock Off"; desc = "Clock off"; };
            CLOCK_ON = 1 { name = "Clock On"; desc = "Clock on"; };
        };

        field {
            name = "aiao_mclk1_cken";
            desc = "AIAO MCLK1 divider clock gate. 0: clock off, 1: clock on.";
            sw = rw;
            hw = r;
            encode = PERI_CRG106_aiao_mclk1_cken_enum;
            reset = 0x0;
        } aiao_mclk1_cken[27:27];

        field {
            name = "aiao_mclk1_div";
            desc = "AIAO MCLK1 divided clock, configurable. For a target frequency X (MHz): aiao_mclk1_div = (X / 1188) * 2^27; maximum 75 MHz.";
            sw = rw;
            hw = r;
            reset = 0x1FFFFF;
        } aiao_mclk1_div[26:0];
    } PERI_CRG106 @ 0x1A8;

    reg {
        name = "AIAO MCLK0 clock configuration register";
        desc = "AIAO MCLK0 clock configuration register.

AIAO MCLK0 divider; same layout as PERI_CRG105.

Data sheet 3.2.6 PERI_CRG107 (offset 0x1AC, printed page 3-51, `hi3516av300--Hi3516AV300-Datasheet.txt` line 9399).";

        enum PERI_CRG107_aiao_mclk0_cken_enum {
            CLOCK_OFF = 0 { name = "Clock Off"; desc = "Clock off"; };
            CLOCK_ON = 1 { name = "Clock On"; desc = "Clock on"; };
        };

        field {
            name = "aiao_mclk0_cken";
            desc = "AIAO MCLK0 divider clock gate. 0: clock off, 1: clock on.";
            sw = rw;
            hw = r;
            encode = PERI_CRG107_aiao_mclk0_cken_enum;
            reset = 0x0;
        } aiao_mclk0_cken[27:27];

        field {
            name = "aiao_mclk0_div";
            desc = "AIAO MCLK0 divided clock, configurable. For a target frequency X (MHz): aiao_mclk0_div = (X / 1188) * 2^27; maximum 75 MHz.";
            sw = rw;
            hw = r;
            reset = 0x1FFFFF;
        } aiao_mclk0_div[26:0];
    } PERI_CRG107 @ 0x1AC;

    reg {
        name = "I2C/UART clock and reset control register";
        desc = "I2C/UART clock and reset control register.

I2C and UART clock gates and soft resets (I2C0..I2C7, UART0..UART4). Reset 0x0007F81F: all gates on, resets deasserted. The vendor Linux driver uses the gates at 0x1B8: UART0..4 bits 0..4, I2C0..7 bits 11..18.

Data sheet 3.2.6 PERI_CRG110 (offset 0x1B8, printed page 3-51, `hi3516av300--Hi3516AV300-Datasheet.txt` line 9423).";

        enum PERI_CRG110_i2c7_srst_req_enum {
            DEASSERT_RESET = 0 { name = "Deassert Reset"; desc = "Deassert reset"; };
            ASSERT_RESET = 1 { name = "Assert Reset"; desc = "Reset"; };
        };

        field {
            name = "i2c7_srst_req";
            desc = "I2C7 soft reset request. 0: deassert reset, 1: reset.";
            sw = rw;
            hw = r;
            encode = PERI_CRG110_i2c7_srst_req_enum;
            reset = 0x0;
        } i2c7_srst_req[26:26];

        enum PERI_CRG110_i2c6_srst_req_enum {
            DEASSERT_RESET = 0 { name = "Deassert Reset"; desc = "Deassert reset"; };
            ASSERT_RESET = 1 { name = "Assert Reset"; desc = "Reset"; };
        };

        field {
            name = "i2c6_srst_req";
            desc = "I2C6 soft reset request. 0: deassert reset, 1: reset.";
            sw = rw;
            hw = r;
            encode = PERI_CRG110_i2c6_srst_req_enum;
            reset = 0x0;
        } i2c6_srst_req[25:25];

        enum PERI_CRG110_i2c5_srst_req_enum {
            DEASSERT_RESET = 0 { name = "Deassert Reset"; desc = "Deassert reset"; };
            ASSERT_RESET = 1 { name = "Assert Reset"; desc = "Reset"; };
        };

        field {
            name = "i2c5_srst_req";
            desc = "I2C5 soft reset request. 0: deassert reset, 1: reset.";
            sw = rw;
            hw = r;
            encode = PERI_CRG110_i2c5_srst_req_enum;
            reset = 0x0;
        } i2c5_srst_req[24:24];

        enum PERI_CRG110_i2c4_srst_req_enum {
            DEASSERT_RESET = 0 { name = "Deassert Reset"; desc = "Deassert reset"; };
            ASSERT_RESET = 1 { name = "Assert Reset"; desc = "Reset"; };
        };

        field {
            name = "i2c4_srst_req";
            desc = "I2C4 soft reset request. 0: deassert reset, 1: reset.";
            sw = rw;
            hw = r;
            encode = PERI_CRG110_i2c4_srst_req_enum;
            reset = 0x0;
        } i2c4_srst_req[23:23];

        enum PERI_CRG110_i2c3_srst_req_enum {
            DEASSERT_RESET = 0 { name = "Deassert Reset"; desc = "Deassert reset"; };
            ASSERT_RESET = 1 { name = "Assert Reset"; desc = "Reset"; };
        };

        field {
            name = "i2c3_srst_req";
            desc = "I2C3 soft reset request. 0: deassert reset, 1: reset.";
            sw = rw;
            hw = r;
            encode = PERI_CRG110_i2c3_srst_req_enum;
            reset = 0x0;
        } i2c3_srst_req[22:22];

        enum PERI_CRG110_i2c2_srst_req_enum {
            DEASSERT_RESET = 0 { name = "Deassert Reset"; desc = "Deassert reset"; };
            ASSERT_RESET = 1 { name = "Assert Reset"; desc = "Reset"; };
        };

        field {
            name = "i2c2_srst_req";
            desc = "I2C2 soft reset request. 0: deassert reset, 1: reset.";
            sw = rw;
            hw = r;
            encode = PERI_CRG110_i2c2_srst_req_enum;
            reset = 0x0;
        } i2c2_srst_req[21:21];

        enum PERI_CRG110_i2c1_srst_req_enum {
            DEASSERT_RESET = 0 { name = "Deassert Reset"; desc = "Deassert reset"; };
            ASSERT_RESET = 1 { name = "Assert Reset"; desc = "Reset"; };
        };

        field {
            name = "i2c1_srst_req";
            desc = "I2C1 soft reset request. 0: deassert reset, 1: reset.";
            sw = rw;
            hw = r;
            encode = PERI_CRG110_i2c1_srst_req_enum;
            reset = 0x0;
        } i2c1_srst_req[20:20];

        enum PERI_CRG110_i2c0_srst_req_enum {
            DEASSERT_RESET = 0 { name = "Deassert Reset"; desc = "Deassert reset"; };
            ASSERT_RESET = 1 { name = "Assert Reset"; desc = "Reset"; };
        };

        field {
            name = "i2c0_srst_req";
            desc = "I2C0 soft reset request. 0: deassert reset, 1: reset.";
            sw = rw;
            hw = r;
            encode = PERI_CRG110_i2c0_srst_req_enum;
            reset = 0x0;
        } i2c0_srst_req[19:19];

        enum PERI_CRG110_i2c7_cken_enum {
            CLOCK_OFF = 0 { name = "Clock Off"; desc = "Clock off"; };
            CLOCK_ON = 1 { name = "Clock On"; desc = "Clock on"; };
        };

        field {
            name = "i2c7_cken";
            desc = "I2C7 clock gate. 0: clock off, 1: clock on.";
            sw = rw;
            hw = r;
            encode = PERI_CRG110_i2c7_cken_enum;
            reset = 0x1;
        } i2c7_cken[18:18];

        enum PERI_CRG110_i2c6_cken_enum {
            CLOCK_OFF = 0 { name = "Clock Off"; desc = "Clock off"; };
            CLOCK_ON = 1 { name = "Clock On"; desc = "Clock on"; };
        };

        field {
            name = "i2c6_cken";
            desc = "I2C6 clock gate. 0: clock off, 1: clock on.";
            sw = rw;
            hw = r;
            encode = PERI_CRG110_i2c6_cken_enum;
            reset = 0x1;
        } i2c6_cken[17:17];

        enum PERI_CRG110_i2c5_cken_enum {
            CLOCK_OFF = 0 { name = "Clock Off"; desc = "Clock off"; };
            CLOCK_ON = 1 { name = "Clock On"; desc = "Clock on"; };
        };

        field {
            name = "i2c5_cken";
            desc = "I2C5 clock gate. 0: clock off, 1: clock on.";
            sw = rw;
            hw = r;
            encode = PERI_CRG110_i2c5_cken_enum;
            reset = 0x1;
        } i2c5_cken[16:16];

        enum PERI_CRG110_i2c4_cken_enum {
            CLOCK_OFF = 0 { name = "Clock Off"; desc = "Clock off"; };
            CLOCK_ON = 1 { name = "Clock On"; desc = "Clock on"; };
        };

        field {
            name = "i2c4_cken";
            desc = "I2C4 clock gate. 0: clock off, 1: clock on.";
            sw = rw;
            hw = r;
            encode = PERI_CRG110_i2c4_cken_enum;
            reset = 0x1;
        } i2c4_cken[15:15];

        enum PERI_CRG110_i2c3_cken_enum {
            CLOCK_OFF = 0 { name = "Clock Off"; desc = "Clock off"; };
            CLOCK_ON = 1 { name = "Clock On"; desc = "Clock on"; };
        };

        field {
            name = "i2c3_cken";
            desc = "I2C3 clock gate. 0: clock off, 1: clock on.";
            sw = rw;
            hw = r;
            encode = PERI_CRG110_i2c3_cken_enum;
            reset = 0x1;
        } i2c3_cken[14:14];

        enum PERI_CRG110_i2c2_cken_enum {
            CLOCK_OFF = 0 { name = "Clock Off"; desc = "Clock off"; };
            CLOCK_ON = 1 { name = "Clock On"; desc = "Clock on"; };
        };

        field {
            name = "i2c2_cken";
            desc = "I2C2 clock gate. 0: clock off, 1: clock on.";
            sw = rw;
            hw = r;
            encode = PERI_CRG110_i2c2_cken_enum;
            reset = 0x1;
        } i2c2_cken[13:13];

        enum PERI_CRG110_i2c1_cken_enum {
            CLOCK_OFF = 0 { name = "Clock Off"; desc = "Clock off"; };
            CLOCK_ON = 1 { name = "Clock On"; desc = "Clock on"; };
        };

        field {
            name = "i2c1_cken";
            desc = "I2C1 clock gate. 0: clock off, 1: clock on.";
            sw = rw;
            hw = r;
            encode = PERI_CRG110_i2c1_cken_enum;
            reset = 0x1;
        } i2c1_cken[12:12];

        enum PERI_CRG110_i2c0_cken_enum {
            CLOCK_OFF = 0 { name = "Clock Off"; desc = "Clock off"; };
            CLOCK_ON = 1 { name = "Clock On"; desc = "Clock on"; };
        };

        field {
            name = "i2c0_cken";
            desc = "I2C0 clock gate. 0: clock off, 1: clock on.";
            sw = rw;
            hw = r;
            encode = PERI_CRG110_i2c0_cken_enum;
            reset = 0x1;
        } i2c0_cken[11:11];

        enum PERI_CRG110_uart4_srst_req_enum {
            DEASSERT_RESET = 0 { name = "Deassert Reset"; desc = "Deassert reset"; };
            ASSERT_RESET = 1 { name = "Assert Reset"; desc = "Reset"; };
        };

        field {
            name = "uart4_srst_req";
            desc = "UART4 soft reset request. 0: deassert reset, 1: reset.";
            sw = rw;
            hw = r;
            encode = PERI_CRG110_uart4_srst_req_enum;
            reset = 0x0;
        } uart4_srst_req[9:9];

        enum PERI_CRG110_uart3_srst_req_enum {
            DEASSERT_RESET = 0 { name = "Deassert Reset"; desc = "Deassert reset"; };
            ASSERT_RESET = 1 { name = "Assert Reset"; desc = "Reset"; };
        };

        field {
            name = "uart3_srst_req";
            desc = "UART3 soft reset request. 0: deassert reset, 1: reset.";
            sw = rw;
            hw = r;
            encode = PERI_CRG110_uart3_srst_req_enum;
            reset = 0x0;
        } uart3_srst_req[8:8];

        enum PERI_CRG110_uart2_srst_req_enum {
            DEASSERT_RESET = 0 { name = "Deassert Reset"; desc = "Deassert reset"; };
            ASSERT_RESET = 1 { name = "Assert Reset"; desc = "Reset"; };
        };

        field {
            name = "uart2_srst_req";
            desc = "UART2 soft reset request. 0: deassert reset, 1: reset.";
            sw = rw;
            hw = r;
            encode = PERI_CRG110_uart2_srst_req_enum;
            reset = 0x0;
        } uart2_srst_req[7:7];

        enum PERI_CRG110_uart1_srst_req_enum {
            DEASSERT_RESET = 0 { name = "Deassert Reset"; desc = "Deassert reset"; };
            ASSERT_RESET = 1 { name = "Assert Reset"; desc = "Reset"; };
        };

        field {
            name = "uart1_srst_req";
            desc = "UART1 soft reset request. 0: deassert reset, 1: reset.";
            sw = rw;
            hw = r;
            encode = PERI_CRG110_uart1_srst_req_enum;
            reset = 0x0;
        } uart1_srst_req[6:6];

        enum PERI_CRG110_uart0_srst_req_enum {
            DEASSERT_RESET = 0 { name = "Deassert Reset"; desc = "Deassert reset"; };
            ASSERT_RESET = 1 { name = "Assert Reset"; desc = "Reset"; };
        };

        field {
            name = "uart0_srst_req";
            desc = "UART0 soft reset request. 0: deassert reset, 1: reset.";
            sw = rw;
            hw = r;
            encode = PERI_CRG110_uart0_srst_req_enum;
            reset = 0x0;
        } uart0_srst_req[5:5];

        enum PERI_CRG110_uart4_cken_enum {
            CLOCK_OFF = 0 { name = "Clock Off"; desc = "Clock off"; };
            CLOCK_ON = 1 { name = "Clock On"; desc = "Clock on"; };
        };

        field {
            name = "uart4_cken";
            desc = "UART4 clock gate. 0: clock off, 1: clock on.";
            sw = rw;
            hw = r;
            encode = PERI_CRG110_uart4_cken_enum;
            reset = 0x1;
        } uart4_cken[4:4];

        enum PERI_CRG110_uart3_cken_enum {
            CLOCK_OFF = 0 { name = "Clock Off"; desc = "Clock off"; };
            CLOCK_ON = 1 { name = "Clock On"; desc = "Clock on"; };
        };

        field {
            name = "uart3_cken";
            desc = "UART3 clock gate. 0: clock off, 1: clock on.";
            sw = rw;
            hw = r;
            encode = PERI_CRG110_uart3_cken_enum;
            reset = 0x1;
        } uart3_cken[3:3];

        enum PERI_CRG110_uart2_cken_enum {
            CLOCK_OFF = 0 { name = "Clock Off"; desc = "Clock off"; };
            CLOCK_ON = 1 { name = "Clock On"; desc = "Clock on"; };
        };

        field {
            name = "uart2_cken";
            desc = "UART2 clock gate. 0: clock off, 1: clock on.";
            sw = rw;
            hw = r;
            encode = PERI_CRG110_uart2_cken_enum;
            reset = 0x1;
        } uart2_cken[2:2];

        enum PERI_CRG110_uart1_cken_enum {
            CLOCK_OFF = 0 { name = "Clock Off"; desc = "Clock off"; };
            CLOCK_ON = 1 { name = "Clock On"; desc = "Clock on"; };
        };

        field {
            name = "uart1_cken";
            desc = "UART1 clock gate. 0: clock off, 1: clock on.";
            sw = rw;
            hw = r;
            encode = PERI_CRG110_uart1_cken_enum;
            reset = 0x1;
        } uart1_cken[1:1];

        enum PERI_CRG110_uart0_cken_enum {
            CLOCK_OFF = 0 { name = "Clock Off"; desc = "Clock off"; };
            CLOCK_ON = 1 { name = "Clock On"; desc = "Clock on"; };
        };

        field {
            name = "uart0_cken";
            desc = "UART0 clock gate. 0: clock off, 1: clock on.";
            sw = rw;
            hw = r;
            encode = PERI_CRG110_uart0_cken_enum;
            reset = 0x1;
        } uart0_cken[0:0];
    } PERI_CRG110 @ 0x1B8;

    reg {
        name = "ADC/UART/SPI/OTP/IR/PWM clock and soft reset control register";
        desc = "ADC/UART/SPI/OTP/IR/PWM clock and soft reset control register.

ADC/UART/SPI/OTP/IR/PWM clock gates, selects and resets. Reset 0x01807883. Each of the five UARTs has its own clock select (uart0_cksel..uart4_cksel, bits 18..22): 0 = 24 MHz, 1 = 6 MHz; the vendor Linux driver uses uart mux at 0x1BC[18..22] {24m, 6m}, SPI gates at bits 12..14, PWM mux 0x1BC[9:8] {3m, 50m, 24m, 24m} and gate bit 7. The description of rtc_srst_req (bit 3) reads `t_cap soft reset request` (data sheet text).

Data sheet 3.2.6 PERI_CRG111 (offset 0x1BC, printed page 3-54, `hi3516av300--Hi3516AV300-Datasheet.txt` line 9605).";

        enum PERI_CRG111_wire3_spi_srst_req_enum {
            DEASSERT_RESET = 0 { name = "Deassert Reset"; desc = "Deassert reset"; };
            ASSERT_RESET = 1 { name = "Assert Reset"; desc = "Reset"; };
        };

        field {
            name = "wire3_spi_srst_req";
            desc = "3Wire SPI soft reset request. 0: deassert reset, 1: reset.";
            sw = rw;
            hw = r;
            encode = PERI_CRG111_wire3_spi_srst_req_enum;
            reset = 0x0;
        } wire3_spi_srst_req[25:25];

        enum PERI_CRG111_wire3_spi_cken_enum {
            CLOCK_OFF = 0 { name = "Clock Off"; desc = "Clock off"; };
            CLOCK_ON = 1 { name = "Clock On"; desc = "Clock on"; };
        };

        field {
            name = "wire3_spi_cken";
            desc = "3Wire SPI clock gate. 0: clock off, 1: clock on.";
            sw = rw;
            hw = r;
            encode = PERI_CRG111_wire3_spi_cken_enum;
            reset = 0x1;
        } wire3_spi_cken[24:24];

        enum PERI_CRG111_adc_cken_enum {
            CLOCK_OFF = 0 { name = "Clock Off"; desc = "Clock off"; };
            CLOCK_ON = 1 { name = "Clock On"; desc = "Clock on"; };
        };

        field {
            name = "adc_cken";
            desc = "ADC clock gate. 0: clock off, 1: clock on.";
            sw = rw;
            hw = r;
            encode = PERI_CRG111_adc_cken_enum;
            reset = 0x1;
        } adc_cken[23:23];

        enum PERI_CRG111_uart4_cksel_enum {
            CLK_24MHZ = 0 { name = "Clk 24Mhz"; desc = "24 MHz"; };
            CLK_6MHZ = 1 { name = "Clk 6Mhz"; desc = "6 MHz"; };
        };

        field {
            name = "uart4_cksel";
            desc = "UART4 clock select. 0: 24 MHz, 1: 6 MHz.";
            sw = rw;
            hw = r;
            encode = PERI_CRG111_uart4_cksel_enum;
            reset = 0x0;
        } uart4_cksel[22:22];

        enum PERI_CRG111_uart3_cksel_enum {
            CLK_24MHZ = 0 { name = "Clk 24Mhz"; desc = "24 MHz"; };
            CLK_6MHZ = 1 { name = "Clk 6Mhz"; desc = "6 MHz"; };
        };

        field {
            name = "uart3_cksel";
            desc = "UART3 clock select. 0: 24 MHz, 1: 6 MHz.";
            sw = rw;
            hw = r;
            encode = PERI_CRG111_uart3_cksel_enum;
            reset = 0x0;
        } uart3_cksel[21:21];

        enum PERI_CRG111_uart2_cksel_enum {
            CLK_24MHZ = 0 { name = "Clk 24Mhz"; desc = "24 MHz"; };
            CLK_6MHZ = 1 { name = "Clk 6Mhz"; desc = "6 MHz"; };
        };

        field {
            name = "uart2_cksel";
            desc = "UART2 clock select. 0: 24 MHz, 1: 6 MHz.";
            sw = rw;
            hw = r;
            encode = PERI_CRG111_uart2_cksel_enum;
            reset = 0x0;
        } uart2_cksel[20:20];

        enum PERI_CRG111_uart1_cksel_enum {
            CLK_24MHZ = 0 { name = "Clk 24Mhz"; desc = "24 MHz"; };
            CLK_6MHZ = 1 { name = "Clk 6Mhz"; desc = "6 MHz"; };
        };

        field {
            name = "uart1_cksel";
            desc = "UART1 clock select. 0: 24 MHz, 1: 6 MHz.";
            sw = rw;
            hw = r;
            encode = PERI_CRG111_uart1_cksel_enum;
            reset = 0x0;
        } uart1_cksel[19:19];

        enum PERI_CRG111_uart0_cksel_enum {
            CLK_24MHZ = 0 { name = "Clk 24Mhz"; desc = "24 MHz"; };
            CLK_6MHZ = 1 { name = "Clk 6Mhz"; desc = "6 MHz"; };
        };

        field {
            name = "uart0_cksel";
            desc = "UART0 clock select. 0: 24 MHz, 1: 6 MHz.";
            sw = rw;
            hw = r;
            encode = PERI_CRG111_uart0_cksel_enum;
            reset = 0x0;
        } uart0_cksel[18:18];

        enum PERI_CRG111_spi2_srst_req_enum {
            DEASSERT_RESET = 0 { name = "Deassert Reset"; desc = "Deassert reset"; };
            ASSERT_RESET = 1 { name = "Assert Reset"; desc = "Reset"; };
        };

        field {
            name = "spi2_srst_req";
            desc = "SPI2 soft reset request. 0: deassert reset, 1: reset.";
            sw = rw;
            hw = r;
            encode = PERI_CRG111_spi2_srst_req_enum;
            reset = 0x0;
        } spi2_srst_req[17:17];

        enum PERI_CRG111_spi1_srst_req_enum {
            DEASSERT_RESET = 0 { name = "Deassert Reset"; desc = "Deassert reset"; };
            ASSERT_RESET = 1 { name = "Assert Reset"; desc = "Reset"; };
        };

        field {
            name = "spi1_srst_req";
            desc = "SPI1 soft reset request. 0: deassert reset, 1: reset.";
            sw = rw;
            hw = r;
            encode = PERI_CRG111_spi1_srst_req_enum;
            reset = 0x0;
        } spi1_srst_req[16:16];

        enum PERI_CRG111_spi0_srst_req_enum {
            DEASSERT_RESET = 0 { name = "Deassert Reset"; desc = "Deassert reset"; };
            ASSERT_RESET = 1 { name = "Assert Reset"; desc = "Reset"; };
        };

        field {
            name = "spi0_srst_req";
            desc = "SPI0 soft reset request. 0: deassert reset, 1: reset.";
            sw = rw;
            hw = r;
            encode = PERI_CRG111_spi0_srst_req_enum;
            reset = 0x0;
        } spi0_srst_req[15:15];

        enum PERI_CRG111_spi2_cken_enum {
            CLOCK_OFF = 0 { name = "Clock Off"; desc = "Clock off"; };
            CLOCK_ON = 1 { name = "Clock On"; desc = "Clock on"; };
        };

        field {
            name = "spi2_cken";
            desc = "SPI2 clock gate. 0: clock off, 1: clock on.";
            sw = rw;
            hw = r;
            encode = PERI_CRG111_spi2_cken_enum;
            reset = 0x1;
        } spi2_cken[14:14];

        enum PERI_CRG111_spi1_cken_enum {
            CLOCK_OFF = 0 { name = "Clock Off"; desc = "Clock off"; };
            CLOCK_ON = 1 { name = "Clock On"; desc = "Clock on"; };
        };

        field {
            name = "spi1_cken";
            desc = "SPI1 clock gate. 0: clock off, 1: clock on.";
            sw = rw;
            hw = r;
            encode = PERI_CRG111_spi1_cken_enum;
            reset = 0x1;
        } spi1_cken[13:13];

        enum PERI_CRG111_spi0_cken_enum {
            CLOCK_OFF = 0 { name = "Clock Off"; desc = "Clock off"; };
            CLOCK_ON = 1 { name = "Clock On"; desc = "Clock on"; };
        };

        field {
            name = "spi0_cken";
            desc = "SPI0 clock gate. 0: clock off, 1: clock on.";
            sw = rw;
            hw = r;
            encode = PERI_CRG111_spi0_cken_enum;
            reset = 0x1;
        } spi0_cken[12:12];

        enum PERI_CRG111_ir_cken_enum {
            CLOCK_OFF = 0 { name = "Clock Off"; desc = "Clock off"; };
            CLOCK_ON = 1 { name = "Clock On"; desc = "Clock on"; };
        };

        field {
            name = "ir_cken";
            desc = "IR clock gate. 0: clock off, 1: clock on.";
            sw = rw;
            hw = r;
            encode = PERI_CRG111_ir_cken_enum;
            reset = 0x1;
        } ir_cken[11:11];

        enum PERI_CRG111_ir_srst_req_enum {
            DEASSERT_RESET = 0 { name = "Deassert Reset"; desc = "Deassert reset"; };
            ASSERT_RESET = 1 { name = "Assert Reset"; desc = "Reset"; };
        };

        field {
            name = "ir_srst_req";
            desc = "IR soft reset request. 0: deassert reset, 1: reset.";
            sw = rw;
            hw = r;
            encode = PERI_CRG111_ir_srst_req_enum;
            reset = 0x0;
        } ir_srst_req[10:10];

        enum PERI_CRG111_pwm_cksel_enum {
            CLK_3MHZ = 0 { name = "Clk 3Mhz"; desc = "3 MHz"; };
            CLK_50MHZ = 1 { name = "Clk 50Mhz"; desc = "50 MHz"; };
            CLK_24MHZ = 2 { name = "Clk 24Mhz"; desc = "24 MHz (data sheet wildcard row; value 10)"; };
            CLK_24MHZ_2 = 3 { name = "Clk 24Mhz 2"; desc = "24 MHz (data sheet wildcard row; value 11)"; };
        };

        field {
            name = "pwm_cksel";
            desc = "PWM clock select. Data sheet: 00 = 3 MHz, 01 = 50 MHz, 1X = 24 MHz; the 1X row is expanded to values 2 and 3, as in the vendor Linux table {3m, 50m, 24m, 24m}.";
            sw = rw;
            hw = r;
            encode = PERI_CRG111_pwm_cksel_enum;
            reset = 0x0;
        } pwm_cksel[9:8];

        enum PERI_CRG111_pwm_cken_enum {
            CLOCK_OFF = 0 { name = "Clock Off"; desc = "Clock off"; };
            CLOCK_ON = 1 { name = "Clock On"; desc = "Clock on"; };
        };

        field {
            name = "pwm_cken";
            desc = "PWM clock gate. 0: clock off, 1: clock on.";
            sw = rw;
            hw = r;
            encode = PERI_CRG111_pwm_cken_enum;
            reset = 0x1;
        } pwm_cken[7:7];

        enum PERI_CRG111_pwm_srst_req_enum {
            DEASSERT_RESET = 0 { name = "Deassert Reset"; desc = "Deassert reset"; };
            ASSERT_RESET = 1 { name = "Assert Reset"; desc = "Reset"; };
        };

        field {
            name = "pwm_srst_req";
            desc = "PWM soft reset request. 0: deassert reset, 1: reset.";
            sw = rw;
            hw = r;
            encode = PERI_CRG111_pwm_srst_req_enum;
            reset = 0x0;
        } pwm_srst_req[6:6];

        enum PERI_CRG111_pmc_srst_req_enum {
            DEASSERT_RESET = 0 { name = "Deassert Reset"; desc = "Deassert reset"; };
            ASSERT_RESET = 1 { name = "Assert Reset"; desc = "Reset"; };
        };

        field {
            name = "pmc_srst_req";
            desc = "PMC soft reset request. 0: deassert reset, 1: reset.";
            sw = rw;
            hw = r;
            encode = PERI_CRG111_pmc_srst_req_enum;
            reset = 0x0;
        } pmc_srst_req[4:4];

        enum PERI_CRG111_rtc_srst_req_enum {
            DEASSERT_RESET = 0 { name = "Deassert Reset"; desc = "Deassert reset"; };
            ASSERT_RESET = 1 { name = "Assert Reset"; desc = "Reset"; };
        };

        field {
            name = "rtc_srst_req";
            desc = "t_cap soft reset request. 0: deassert reset, 1: reset.";
            sw = rw;
            hw = r;
            encode = PERI_CRG111_rtc_srst_req_enum;
            reset = 0x0;
        } rtc_srst_req[3:3];

        enum PERI_CRG111_lsadc_srst_req_enum {
            DEASSERT_RESET = 0 { name = "Deassert Reset"; desc = "Deassert reset"; };
            ASSERT_RESET = 1 { name = "Assert Reset"; desc = "Reset"; };
        };

        field {
            name = "lsadc_srst_req";
            desc = "LSADC soft reset request. 0: deassert reset, 1: reset.";
            sw = rw;
            hw = r;
            encode = PERI_CRG111_lsadc_srst_req_enum;
            reset = 0x0;
        } lsadc_srst_req[2:2];

        enum PERI_CRG111_otp_cken_enum {
            CLOCK_OFF = 0 { name = "Clock Off"; desc = "Clock off"; };
            CLOCK_ON = 1 { name = "Clock On"; desc = "Clock on"; };
        };

        field {
            name = "otp_cken";
            desc = "OTP clock gate. 0: clock off, 1: clock on.";
            sw = rw;
            hw = r;
            encode = PERI_CRG111_otp_cken_enum;
            reset = 0x1;
        } otp_cken[1:1];

        enum PERI_CRG111_test_clk_en_enum {
            TEST_CLOCKS_OFF = 0 { name = "Test Clocks Off"; desc = "All test clocks off"; };
            TEST_CLOCKS_ON = 1 { name = "Test Clocks On"; desc = "All test clocks on"; };
        };

        field {
            name = "test_clk_en";
            desc = "Test clock enable. 0: all test clocks off, 1: all test clocks on.";
            sw = rw;
            hw = r;
            encode = PERI_CRG111_test_clk_en_enum;
            reset = 0x1;
        } test_clk_en[0:0];
    } PERI_CRG111 @ 0x1BC;

    reg {
        name = "SoC frequency indication register";
        desc = "SoC frequency indication register.

Shows which clock each mux of PERI_CRG32/PERI_CRG81 currently uses (switch complete). The ddr_sc_seled table does not list the EPLL POSTDIV setting 4 that ddr_cksel has (data sheet omission).

Data sheet 3.2.6 PERI_CRG120 (offset 0x1E0, printed page 3-56, `hi3516av300--Hi3516AV300-Datasheet.txt` line 9768).";

        enum PERI_CRG120_fmc_sc_seled_enum {
            CLK_24MHZ = 0 { name = "Clk 24Mhz"; desc = "24 MHz"; };
            CLK_100MHZ = 1 { name = "Clk 100Mhz"; desc = "100 MHz"; };
            CLK_150MHZ = 2 { name = "Clk 150Mhz"; desc = "150 MHz"; };
            CLK_163MHZ = 3 { name = "Clk 163Mhz"; desc = "163 MHz"; };
            CLK_200MHZ = 4 { name = "Clk 200Mhz"; desc = "200 MHz"; };
            CLK_257MHZ = 5 { name = "Clk 257Mhz"; desc = "257 MHz"; };
            CLK_300MHZ = 6 { name = "Clk 300Mhz"; desc = "300 MHz"; };
            CLK_396MHZ = 7 { name = "Clk 396Mhz"; desc = "396 MHz"; };
        };

        field {
            name = "fmc_sc_seled";
            desc = "FMC clock switch-complete indication.";
            sw = r;
            hw = w;
            encode = PERI_CRG120_fmc_sc_seled_enum;
            reset = 0x0;
        } fmc_sc_seled[14:12];

        enum PERI_CRG120_sysapb_sc_seled_enum {
            XTAL_24MHZ = 0 { name = "Xtal 24Mhz"; desc = "Crystal clock (24 MHz)"; };
            CLK_50MHZ = 1 { name = "Clk 50Mhz"; desc = "50 MHz"; };
        };

        field {
            name = "sysapb_sc_seled";
            desc = "SYSAPB clock switch-complete indication. 0: crystal clock (24 MHz), 1: 50 MHz.";
            sw = r;
            hw = w;
            encode = PERI_CRG120_sysapb_sc_seled_enum;
            reset = 0x0;
        } sysapb_sc_seled[10:10];

        enum PERI_CRG120_syscfg_sc_seled_enum {
            XTAL_24MHZ = 0 { name = "Xtal 24Mhz"; desc = "Crystal clock (24 MHz)"; };
            CLK_148P5MHZ = 1 { name = "Clk 148P5Mhz"; desc = "148.5 MHz"; };
        };

        field {
            name = "syscfg_sc_seled";
            desc = "SYSCFG clock switch-complete indication. 0: crystal clock (24 MHz), 1: 148.5 MHz.";
            sw = r;
            hw = w;
            encode = PERI_CRG120_syscfg_sc_seled_enum;
            reset = 0x0;
        } syscfg_sc_seled[8:8];

        enum PERI_CRG120_sysaxi_sc_seled_enum {
            XTAL_24MHZ = 0 { name = "Xtal 24Mhz"; desc = "Crystal clock (24 MHz)"; };
            CLK_200MHZ = 1 { name = "Clk 200Mhz"; desc = "200 MHz"; };
            CLK_300MHZ = 2 { name = "Clk 300Mhz"; desc = "300 MHz"; };
            RESERVED_3 = 3 { name = "Reserved 3"; desc = "Reserved"; };
        };

        field {
            name = "sysaxi_sc_seled";
            desc = "SYSAXI clock switch-complete indication.";
            sw = r;
            hw = w;
            encode = PERI_CRG120_sysaxi_sc_seled_enum;
            reset = 0x0;
        } sysaxi_sc_seled[7:6];

        enum PERI_CRG120_ddr_sc_seled_enum {
            XTAL_24MHZ = 0 { name = "Xtal 24Mhz"; desc = "Crystal clock (24 MHz)"; };
            CLK_360MHZ = 1 { name = "Clk 360Mhz"; desc = "360 MHz"; };
            CLK_396MHZ = 2 { name = "Clk 396Mhz"; desc = "396 MHz"; };
            CLK_450MHZ = 3 { name = "Clk 450Mhz"; desc = "450 MHz"; };
            RESERVED_4 = 4 { name = "Reserved 4"; desc = "Reserved"; };
            RESERVED_5 = 5 { name = "Reserved 5"; desc = "Reserved"; };
            RESERVED_6 = 6 { name = "Reserved 6"; desc = "Reserved"; };
            RESERVED_7 = 7 { name = "Reserved 7"; desc = "Reserved"; };
        };

        field {
            name = "ddr_sc_seled";
            desc = "DDR clock switch-complete indication.";
            sw = r;
            hw = w;
            encode = PERI_CRG120_ddr_sc_seled_enum;
            reset = 0x0;
        } ddr_sc_seled[5:3];

        enum PERI_CRG120_a7_sc_seled_enum {
            XTAL_24MHZ = 0 { name = "Xtal 24Mhz"; desc = "Crystal clock (24 MHz)"; };
            CLK_600MHZ = 1 { name = "Clk 600Mhz"; desc = "600 MHz"; };
            CLK_792MHZ = 2 { name = "Clk 792Mhz"; desc = "792 MHz"; };
            CLK_900MHZ = 3 { name = "Clk 900Mhz"; desc = "900 MHz"; };
            RESERVED_7 = 7 { name = "Reserved 7"; desc = "Reserved"; };
        };

        field {
            name = "a7_sc_seled";
            desc = "A7 clock switch-complete indication.";
            sw = r;
            hw = w;
            encode = PERI_CRG120_a7_sc_seled_enum;
            reset = 0x0;
        } a7_sc_seled[2:0];
    } PERI_CRG120 @ 0x1E0;

    reg {
        name = "Reset status register";
        desc = "Reset status register.

Soft reset status; the name `PERI_CRG_PLL121` is the data sheet name although this is not a PLL register. 0: reset deasserted successfully, 1: still in reset.

Data sheet 3.2.6 PERI_CRG_PLL121 (offset 0x1E4, printed page 3-57, `hi3516av300--Hi3516AV300-Datasheet.txt` line 9853).";

        enum PERI_CRG_PLL121_tde_softrst_state_enum {
            DEASSERTED = 0 { name = "Deasserted"; desc = "Reset deasserted"; };
            ASSERT_RESET = 1 { name = "Assert Reset"; desc = "Reset"; };
        };

        field {
            name = "tde_softrst_state";
            desc = "TDE reset status. 0: reset deasserted, 1: reset.";
            sw = r;
            hw = w;
            encode = PERI_CRG_PLL121_tde_softrst_state_enum;
            reset = 0x0;
        } tde_softrst_state[6:6];

        enum PERI_CRG_PLL121_vgs_softrst_state_enum {
            DEASSERTED = 0 { name = "Deasserted"; desc = "Reset deasserted"; };
            ASSERT_RESET = 1 { name = "Assert Reset"; desc = "Reset"; };
        };

        field {
            name = "vgs_softrst_state";
            desc = "VGS reset status. 0: reset deasserted, 1: reset.";
            sw = r;
            hw = w;
            encode = PERI_CRG_PLL121_vgs_softrst_state_enum;
            reset = 0x0;
        } vgs_softrst_state[5:5];

        enum PERI_CRG_PLL121_viproc_softrst_state_enum {
            DEASSERTED = 0 { name = "Deasserted"; desc = "Reset deasserted"; };
            ASSERT_RESET = 1 { name = "Assert Reset"; desc = "Reset"; };
        };

        field {
            name = "viproc_softrst_state";
            desc = "VIPROC reset status. 0: reset deasserted, 1: reset.";
            sw = r;
            hw = w;
            encode = PERI_CRG_PLL121_viproc_softrst_state_enum;
            reset = 0x0;
        } viproc_softrst_state[4:4];

        enum PERI_CRG_PLL121_vpss_softrst_state_enum {
            DEASSERTED = 0 { name = "Deasserted"; desc = "Reset deasserted"; };
            ASSERT_RESET = 1 { name = "Assert Reset"; desc = "Reset"; };
        };

        field {
            name = "vpss_softrst_state";
            desc = "VPSS reset status. 0: reset deasserted, 1: reset.";
            sw = r;
            hw = w;
            encode = PERI_CRG_PLL121_vpss_softrst_state_enum;
            reset = 0x0;
        } vpss_softrst_state[3:3];

        enum PERI_CRG_PLL121_gdc_softrst_state_enum {
            DEASSERTED = 0 { name = "Deasserted"; desc = "Reset deasserted"; };
            ASSERT_RESET = 1 { name = "Assert Reset"; desc = "Reset"; };
        };

        field {
            name = "gdc_softrst_state";
            desc = "GDC reset status. 0: reset deasserted, 1: reset.";
            sw = r;
            hw = w;
            encode = PERI_CRG_PLL121_gdc_softrst_state_enum;
            reset = 0x0;
        } gdc_softrst_state[2:2];

        enum PERI_CRG_PLL121_gzip_rst_ok_enum {
            DEASSERTED = 0 { name = "Deasserted"; desc = "Reset deasserted"; };
            ASSERT_RESET = 1 { name = "Assert Reset"; desc = "Reset"; };
        };

        field {
            name = "gzip_rst_ok";
            desc = "GZIP reset status. 0: reset deasserted, 1: reset.";
            sw = r;
            hw = w;
            encode = PERI_CRG_PLL121_gzip_rst_ok_enum;
            reset = 0x0;
        } gzip_rst_ok[1:1];

        enum PERI_CRG_PLL121_nnie_rst_ok_enum {
            DEASSERTED = 0 { name = "Deasserted"; desc = "Reset deasserted"; };
            ASSERT_RESET = 1 { name = "Assert Reset"; desc = "Reset"; };
        };

        field {
            name = "nnie_rst_ok";
            desc = "NNIE reset status. 0: reset deasserted, 1: reset.";
            sw = r;
            hw = w;
            encode = PERI_CRG_PLL121_nnie_rst_ok_enum;
            reset = 0x0;
        } nnie_rst_ok[0:0];
    } PERI_CRG_PLL121 @ 0x1E4;

    reg {
        name = "PLL lock status register";
        desc = "PLL lock status register.

PLL lock status, bit per PLL (APLL 0, DPLL 1, VPLL 2, EPLL 3). The PLL change procedure in data sheet 3.2.4.1 says to observe `PERI_CRG_PLL122[10:0]` but only bits [3:0] are defined (the others are reserved).

Data sheet 3.2.6 PERI_CRG_PLL122 (offset 0x1E8, printed page 3-58, `hi3516av300--Hi3516AV300-Datasheet.txt` line 9911).";

        enum PERI_CRG_PLL122_epll_lock_enum {
            UNLOCKED = 0 { name = "Unlocked"; desc = "Unlocked"; };
            LOCKED = 1 { name = "Locked"; desc = "Locked"; };
        };

        field {
            name = "epll_lock";
            desc = "EPLL lock status. 0: unlocked, 1: locked.";
            sw = r;
            hw = w;
            encode = PERI_CRG_PLL122_epll_lock_enum;
            reset = 0x0;
        } epll_lock[3:3];

        enum PERI_CRG_PLL122_vpll_lock_enum {
            UNLOCKED = 0 { name = "Unlocked"; desc = "Unlocked"; };
            LOCKED = 1 { name = "Locked"; desc = "Locked"; };
        };

        field {
            name = "vpll_lock";
            desc = "VPLL lock status. 0: unlocked, 1: locked.";
            sw = r;
            hw = w;
            encode = PERI_CRG_PLL122_vpll_lock_enum;
            reset = 0x0;
        } vpll_lock[2:2];

        enum PERI_CRG_PLL122_dpll_lock_enum {
            UNLOCKED = 0 { name = "Unlocked"; desc = "Unlocked"; };
            LOCKED = 1 { name = "Locked"; desc = "Locked"; };
        };

        field {
            name = "dpll_lock";
            desc = "DPLL lock status. 0: unlocked, 1: locked.";
            sw = r;
            hw = w;
            encode = PERI_CRG_PLL122_dpll_lock_enum;
            reset = 0x0;
        } dpll_lock[1:1];

        enum PERI_CRG_PLL122_apll_lock_enum {
            UNLOCKED = 0 { name = "Unlocked"; desc = "Unlocked"; };
            LOCKED = 1 { name = "Locked"; desc = "Locked"; };
        };

        field {
            name = "apll_lock";
            desc = "APLL lock status. 0: unlocked, 1: locked.";
            sw = r;
            hw = w;
            encode = PERI_CRG_PLL122_apll_lock_enum;
            reset = 0x0;
        } apll_lock[0:0];
    } PERI_CRG_PLL122 @ 0x1E8;

};

`endif
