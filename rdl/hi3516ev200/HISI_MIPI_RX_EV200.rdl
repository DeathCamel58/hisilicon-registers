`ifndef HISI_MIPI_RX_EV200_RDL
`define HISI_MIPI_RX_EV200_RDL

regfile eHISI_MIPI_RX_EV200 {
    name = "MIPI RX / LVDS / sub-LVDS receiver (D-PHY + controller), Hi3516E V200 generation";
    desc = "
    Window 0x11240000 (0x10000), GIC SPI 45 (INTID 77); sensor clock PERI_CRG 0x120100F0 [5:2] (0x0 74.25 MHz, 0x1 72, 0x2 54, 0x3 24, 0x4 37.125, 0x5 36, 0x6 27, 0x7 12 MHz), MIPI_RX clock/reset PERI_CRG 0x120100F8, work-mode register MISC 0x12028018.
    Evidence class: **PROVEN (layout)** - register offsets, field names and bit positions are taken from the register header `mipi_rx_reg.h` of the open-source `open_mipi_rx` driver (sources/openhisilicon/kernel/mipi_rx) that OpenIPC loads on Hi3516E V200/V300 and Goke GK7205V200 boards (`#if defined(hi3516ev200)` branches select this generation: one PHY, MIPI_CTRL_INT mask 0x00030003, LVDS_CTRL_INT mask 0x0f110000). **GUESS** - access types (read-only guessed from the names _ST/_INT/STATIS/INT_RAW/TEST_OUT, everything else rw) and every reset value (the header has none, nothing is listed).
    Layout: PHY configuration block 0x000..0x1FC, system registers 0x808..0xFF8 (PHY_EN, LANE_EN, colorbar generator, interrupt), then one controller instance per sensor device (MIPI_RX_MAX_DEV_NUM = 1 for this chip: controller 0 only) with the MIPI protocol controller at 0x1004..0x12FC and the LVDS/sub-LVDS controller at 0x1300..0x1FFC.
    The register block is the same family as the Hi3516C V500 / Hi3516D V300 MIPI_RX (the same header exists under mipi_rx/hi3516cv500), not the Hi3516C V300 block of rdl/hi3516cv300 (HISI_MIPI_RX_CV300).
    ";

    reg {
        name = "PHY_MODE_LINK";
        desc = "PHY_MODE_LINK at window offset 0x0 (vendor header mipi_rx_reg.h, type U_PHY_MODE_LINK). Layout PROVEN from the vendor header; access type GUESS (read-write), reset unknown.";
        field {
            name = "phy0_rg_en_d";
            desc = "Bits [3:0] of PHY_MODE_LINK."; sw = rw; hw = r;
        } phy0_rg_en_d[3:0];
        field {
            name = "phy0_rg_en_clk0";
            desc = "Bits [4:4] of PHY_MODE_LINK."; sw = rw; hw = r;
        } phy0_rg_en_clk0[4:4];
        field {
            name = "phy0_rg_en_clk1";
            desc = "Bits [5:5] of PHY_MODE_LINK."; sw = rw; hw = r;
        } phy0_rg_en_clk1[5:5];
        field {
            name = "phy0_rg_en_cmos";
            desc = "Bits [8:8] of PHY_MODE_LINK."; sw = rw; hw = r;
        } phy0_rg_en_cmos[8:8];
        field {
            name = "phy0_rg_en_lp0";
            desc = "Bits [12:12] of PHY_MODE_LINK."; sw = rw; hw = r;
        } phy0_rg_en_lp0[12:12];
        field {
            name = "phy0_rg_en_lp1";
            desc = "Bits [13:13] of PHY_MODE_LINK."; sw = rw; hw = r;
        } phy0_rg_en_lp1[13:13];
        field {
            name = "phy0_rg_faclk0_en";
            desc = "Bits [16:16] of PHY_MODE_LINK."; sw = rw; hw = r;
        } phy0_rg_faclk0_en[16:16];
        field {
            name = "phy0_rg_faclk1_en";
            desc = "Bits [17:17] of PHY_MODE_LINK."; sw = rw; hw = r;
        } phy0_rg_faclk1_en[17:17];
        field {
            name = "phy0_rg_en_2l2l";
            desc = "Bits [20:20] of PHY_MODE_LINK."; sw = rw; hw = r;
        } phy0_rg_en_2l2l[20:20];
        field {
            name = "phy0_rg_mipi_mode0";
            desc = "Bits [24:24] of PHY_MODE_LINK."; sw = rw; hw = r;
        } phy0_rg_mipi_mode0[24:24];
        field {
            name = "phy0_rg_mipi_mode1";
            desc = "Bits [25:25] of PHY_MODE_LINK."; sw = rw; hw = r;
        } phy0_rg_mipi_mode1[25:25];
    } PHY_MODE_LINK @ 0x0;

    reg {
        name = "PHY_SKEW_LINK";
        desc = "PHY_SKEW_LINK at window offset 0x4 (vendor header mipi_rx_reg.h, type U_PHY_SKEW_LINK). Layout PROVEN from the vendor header; access type GUESS (read-write), reset unknown.";
        field {
            name = "phy0_clk0_skew";
            desc = "Bits [2:0] of PHY_SKEW_LINK."; sw = rw; hw = r;
        } phy0_clk0_skew[2:0];
        field {
            name = "phy0_clk1_skew";
            desc = "Bits [6:4] of PHY_SKEW_LINK."; sw = rw; hw = r;
        } phy0_clk1_skew[6:4];
        field {
            name = "phy0_d0_skew";
            desc = "Bits [10:8] of PHY_SKEW_LINK."; sw = rw; hw = r;
        } phy0_d0_skew[10:8];
        field {
            name = "phy0_d1_skew";
            desc = "Bits [14:12] of PHY_SKEW_LINK."; sw = rw; hw = r;
        } phy0_d1_skew[14:12];
        field {
            name = "phy0_d2_skew";
            desc = "Bits [18:16] of PHY_SKEW_LINK."; sw = rw; hw = r;
        } phy0_d2_skew[18:16];
        field {
            name = "phy0_d3_skew";
            desc = "Bits [22:20] of PHY_SKEW_LINK."; sw = rw; hw = r;
        } phy0_d3_skew[22:20];
    } PHY_SKEW_LINK @ 0x4;

    reg {
        name = "PHY_EN_LINK";
        desc = "PHY_EN_LINK at window offset 0xC (vendor header mipi_rx_reg.h, type U_PHY_EN_LINK). Layout PROVEN from the vendor header; access type GUESS (read-write), reset unknown.";
        field {
            name = "phy_da_d0_valid";
            desc = "Bits [0:0] of PHY_EN_LINK."; sw = rw; hw = r;
        } phy_da_d0_valid[0:0];
        field {
            name = "phy_da_d1_valid";
            desc = "Bits [1:1] of PHY_EN_LINK."; sw = rw; hw = r;
        } phy_da_d1_valid[1:1];
        field {
            name = "phy_da_d2_valid";
            desc = "Bits [2:2] of PHY_EN_LINK."; sw = rw; hw = r;
        } phy_da_d2_valid[2:2];
        field {
            name = "phy_da_d3_valid";
            desc = "Bits [3:3] of PHY_EN_LINK."; sw = rw; hw = r;
        } phy_da_d3_valid[3:3];
        field {
            name = "phy_d0_term_en";
            desc = "Bits [8:8] of PHY_EN_LINK."; sw = rw; hw = r;
        } phy_d0_term_en[8:8];
        field {
            name = "phy_d1_term_en";
            desc = "Bits [9:9] of PHY_EN_LINK."; sw = rw; hw = r;
        } phy_d1_term_en[9:9];
        field {
            name = "phy_d2_term_en";
            desc = "Bits [10:10] of PHY_EN_LINK."; sw = rw; hw = r;
        } phy_d2_term_en[10:10];
        field {
            name = "phy_d3_term_en";
            desc = "Bits [11:11] of PHY_EN_LINK."; sw = rw; hw = r;
        } phy_d3_term_en[11:11];
        field {
            name = "phy_clk0_term_en";
            desc = "Bits [12:12] of PHY_EN_LINK."; sw = rw; hw = r;
        } phy_clk0_term_en[12:12];
        field {
            name = "phy_clk1_term_en";
            desc = "Bits [13:13] of PHY_EN_LINK."; sw = rw; hw = r;
        } phy_clk1_term_en[13:13];
    } PHY_EN_LINK @ 0xC;

    reg {
        name = "PHY_CFG_LINK";
        desc = "PHY_CFG_LINK at window offset 0x14 (vendor header mipi_rx_reg.h, type U_PHY_CFG_LINK). Layout PROVEN from the vendor header; access type GUESS (read-write), reset unknown.";
        field {
            name = "phy0_da_ulpb";
            desc = "Bits [3:0] of PHY_CFG_LINK."; sw = rw; hw = r;
        } phy0_da_ulpb[3:0];
        field {
            name = "phy0_da_ulpb_ck0";
            desc = "Bits [4:4] of PHY_CFG_LINK."; sw = rw; hw = r;
        } phy0_da_ulpb_ck0[4:4];
        field {
            name = "phy0_da_ulpb_ck1";
            desc = "Bits [5:5] of PHY_CFG_LINK."; sw = rw; hw = r;
        } phy0_da_ulpb_ck1[5:5];
        field {
            name = "phy0_rg_it_lp";
            desc = "Bits [9:8] of PHY_CFG_LINK."; sw = rw; hw = r;
        } phy0_rg_it_lp[9:8];
        field {
            name = "phy0_rg_it_ck";
            desc = "Bits [11:10] of PHY_CFG_LINK."; sw = rw; hw = r;
        } phy0_rg_it_ck[11:10];
        field {
            name = "phy0_rg_it_dt";
            desc = "Bits [13:12] of PHY_CFG_LINK."; sw = rw; hw = r;
        } phy0_rg_it_dt[13:12];
        field {
            name = "phy0_rg_sa_en";
            desc = "Bits [14:14] of PHY_CFG_LINK."; sw = rw; hw = r;
        } phy0_rg_sa_en[14:14];
    } PHY_CFG_LINK @ 0x14;

    reg {
        name = "PHY_DATA_LINK";
        desc = "PHY_DATA_LINK at window offset 0x18 (vendor header mipi_rx_reg.h, type U_PHY_DATA_LINK). Layout PROVEN from the vendor header; access type GUESS (read-write), reset unknown.";
        field {
            name = "phy_data0_mipi";
            desc = "Bits [7:0] of PHY_DATA_LINK."; sw = rw; hw = r;
        } phy_data0_mipi[7:0];
        field {
            name = "phy_data1_mipi";
            desc = "Bits [15:8] of PHY_DATA_LINK."; sw = rw; hw = r;
        } phy_data1_mipi[15:8];
        field {
            name = "phy_data2_mipi";
            desc = "Bits [23:16] of PHY_DATA_LINK."; sw = rw; hw = r;
        } phy_data2_mipi[23:16];
        field {
            name = "phy_data3_mipi";
            desc = "Bits [31:24] of PHY_DATA_LINK."; sw = rw; hw = r;
        } phy_data3_mipi[31:24];
    } PHY_DATA_LINK @ 0x18;

    reg {
        name = "PHY_PH_MIPI_LINK";
        desc = "PHY_PH_MIPI_LINK at window offset 0x1C (vendor header mipi_rx_reg.h, type U_PHY_PH_MIPI_LINK). Layout PROVEN from the vendor header; access type GUESS (read-write), reset unknown.";
        field {
            name = "phy_ph0_mipi";
            desc = "Bits [7:0] of PHY_PH_MIPI_LINK."; sw = rw; hw = r;
        } phy_ph0_mipi[7:0];
        field {
            name = "phy_ph1_mipi";
            desc = "Bits [15:8] of PHY_PH_MIPI_LINK."; sw = rw; hw = r;
        } phy_ph1_mipi[15:8];
        field {
            name = "phy_ph2_mipi";
            desc = "Bits [23:16] of PHY_PH_MIPI_LINK."; sw = rw; hw = r;
        } phy_ph2_mipi[23:16];
        field {
            name = "phy_ph3_mipi";
            desc = "Bits [31:24] of PHY_PH_MIPI_LINK."; sw = rw; hw = r;
        } phy_ph3_mipi[31:24];
    } PHY_PH_MIPI_LINK @ 0x1C;

    reg {
        name = "PHY_DATA_MIPI_LINK";
        desc = "PHY_DATA_MIPI_LINK at window offset 0x20 (vendor header mipi_rx_reg.h, type U_PHY_DATA_MIPI_LINK). Layout PROVEN from the vendor header; access type GUESS (read-write), reset unknown.";
        field {
            name = "phy_data0_mipi_hs";
            desc = "Bits [7:0] of PHY_DATA_MIPI_LINK."; sw = rw; hw = r;
        } phy_data0_mipi_hs[7:0];
        field {
            name = "phy_data1_mipi_hs";
            desc = "Bits [15:8] of PHY_DATA_MIPI_LINK."; sw = rw; hw = r;
        } phy_data1_mipi_hs[15:8];
        field {
            name = "phy_data2_mipi_hs";
            desc = "Bits [23:16] of PHY_DATA_MIPI_LINK."; sw = rw; hw = r;
        } phy_data2_mipi_hs[23:16];
        field {
            name = "phy_data3_mipi_hs";
            desc = "Bits [31:24] of PHY_DATA_MIPI_LINK."; sw = rw; hw = r;
        } phy_data3_mipi_hs[31:24];
    } PHY_DATA_MIPI_LINK @ 0x20;

    reg {
        name = "PHY_SYNC_DCT_LINK";
        desc = "PHY_SYNC_DCT_LINK at window offset 0x24 (vendor header mipi_rx_reg.h, type U_PHY_SYNC_DCT_LINK). Layout PROVEN from the vendor header; access type GUESS (read-write), reset unknown.";
        field {
            name = "cil_raw_type0";
            desc = "Bits [2:0] of PHY_SYNC_DCT_LINK."; sw = rw; hw = r;
        } cil_raw_type0[2:0];
        field {
            name = "cil_code_big_endian0";
            desc = "Bits [8:8] of PHY_SYNC_DCT_LINK."; sw = rw; hw = r;
        } cil_code_big_endian0[8:8];
        field {
            name = "cil_raw_type1";
            desc = "Bits [14:12] of PHY_SYNC_DCT_LINK."; sw = rw; hw = r;
        } cil_raw_type1[14:12];
        field {
            name = "cil_code_big_endian1";
            desc = "Bits [20:20] of PHY_SYNC_DCT_LINK."; sw = rw; hw = r;
        } cil_code_big_endian1[20:20];
        field {
            name = "cil_sync_det_mode";
            desc = "Bits [25:25] of PHY_SYNC_DCT_LINK."; sw = rw; hw = r;
        } cil_sync_det_mode[25:25];
    } PHY_SYNC_DCT_LINK @ 0x24;

    reg {
        name = "PHY_SYNC_SOF0_LINK";
        desc = "PHY_SYNC_SOF0_LINK at window offset 0x30 (vendor header mipi_rx_reg.h, type U_PHY_SYNC_SOF0_LINK). Layout PROVEN from the vendor header; access type GUESS (read-write), reset unknown.";
        field {
            name = "cil_sof0_word4_0";
            desc = "Bits [15:0] of PHY_SYNC_SOF0_LINK."; sw = rw; hw = r;
        } cil_sof0_word4_0[15:0];
        field {
            name = "cil_sof1_word4_0";
            desc = "Bits [31:16] of PHY_SYNC_SOF0_LINK."; sw = rw; hw = r;
        } cil_sof1_word4_0[31:16];
    } PHY_SYNC_SOF0_LINK @ 0x30;

    reg {
        name = "PHY_SYNC_SOF1_LINK";
        desc = "PHY_SYNC_SOF1_LINK at window offset 0x34 (vendor header mipi_rx_reg.h, type U_PHY_SYNC_SOF1_LINK). Layout PROVEN from the vendor header; access type GUESS (read-write), reset unknown.";
        field {
            name = "cil_sof0_word4_1";
            desc = "Bits [15:0] of PHY_SYNC_SOF1_LINK."; sw = rw; hw = r;
        } cil_sof0_word4_1[15:0];
        field {
            name = "cil_sof1_word4_1";
            desc = "Bits [31:16] of PHY_SYNC_SOF1_LINK."; sw = rw; hw = r;
        } cil_sof1_word4_1[31:16];
    } PHY_SYNC_SOF1_LINK @ 0x34;

    reg {
        name = "PHY_SYNC_SOF2_LINK";
        desc = "PHY_SYNC_SOF2_LINK at window offset 0x38 (vendor header mipi_rx_reg.h, type U_PHY_SYNC_SOF2_LINK). Layout PROVEN from the vendor header; access type GUESS (read-write), reset unknown.";
        field {
            name = "cil_sof0_word4_2";
            desc = "Bits [15:0] of PHY_SYNC_SOF2_LINK."; sw = rw; hw = r;
        } cil_sof0_word4_2[15:0];
        field {
            name = "cil_sof1_word4_2";
            desc = "Bits [31:16] of PHY_SYNC_SOF2_LINK."; sw = rw; hw = r;
        } cil_sof1_word4_2[31:16];
    } PHY_SYNC_SOF2_LINK @ 0x38;

    reg {
        name = "PHY_SYNC_SOF3_LINK";
        desc = "PHY_SYNC_SOF3_LINK at window offset 0x3C (vendor header mipi_rx_reg.h, type U_PHY_SYNC_SOF3_LINK). Layout PROVEN from the vendor header; access type GUESS (read-write), reset unknown.";
        field {
            name = "cil_sof0_word4_3";
            desc = "Bits [15:0] of PHY_SYNC_SOF3_LINK."; sw = rw; hw = r;
        } cil_sof0_word4_3[15:0];
        field {
            name = "cil_sof1_word4_3";
            desc = "Bits [31:16] of PHY_SYNC_SOF3_LINK."; sw = rw; hw = r;
        } cil_sof1_word4_3[31:16];
    } PHY_SYNC_SOF3_LINK @ 0x3C;

    reg {
        name = "PHY_OUT_VALID_LINK";
        desc = "PHY_OUT_VALID_LINK at window offset 0x40 (vendor header mipi_rx_reg.h, type U_PHY_OUT_VALID_LINK). Layout PROVEN from the vendor header; access type GUESS (read-write), reset unknown.";
        field {
            name = "cil_lvds_out_valid";
            desc = "Bits [3:0] of PHY_OUT_VALID_LINK."; sw = rw; hw = r;
        } cil_lvds_out_valid[3:0];
        field {
            name = "cil_mipi_out_valid";
            desc = "Bits [7:4] of PHY_OUT_VALID_LINK."; sw = rw; hw = r;
        } cil_mipi_out_valid[7:4];
    } PHY_OUT_VALID_LINK @ 0x40;

    reg {
        name = "PHY_DATA_LVDS_LINK";
        desc = "PHY_DATA_LVDS_LINK at window offset 0x44 (vendor header mipi_rx_reg.h, type U_PHY_DATA_LVDS_LINK). Layout PROVEN from the vendor header; access type GUESS (read-write), reset unknown.";
        field {
            name = "phy_data0_lvds_hs";
            desc = "Bits [7:0] of PHY_DATA_LVDS_LINK."; sw = rw; hw = r;
        } phy_data0_lvds_hs[7:0];
        field {
            name = "phy_data1_lvds_hs";
            desc = "Bits [15:8] of PHY_DATA_LVDS_LINK."; sw = rw; hw = r;
        } phy_data1_lvds_hs[15:8];
        field {
            name = "phy_data2_lvds_hs";
            desc = "Bits [23:16] of PHY_DATA_LVDS_LINK."; sw = rw; hw = r;
        } phy_data2_lvds_hs[23:16];
        field {
            name = "phy_data3_lvds_hs";
            desc = "Bits [31:24] of PHY_DATA_LVDS_LINK."; sw = rw; hw = r;
        } phy_data3_lvds_hs[31:24];
    } PHY_DATA_LVDS_LINK @ 0x44;

    reg {
        name = "PHY_PIX_PUM_LINK";
        desc = "PHY_PIX_PUM_LINK at window offset 0x54 (vendor header mipi_rx_reg.h, type U_PHY_PIX_PUM_LINK). Layout PROVEN from the vendor header; access type GUESS (read-write), reset unknown.";
        field {
            name = "phy_lane02_pix_num";
            desc = "Bits [15:0] of PHY_PIX_PUM_LINK."; sw = rw; hw = r;
        } phy_lane02_pix_num[15:0];
        field {
            name = "phy_lane13_pix_num";
            desc = "Bits [31:16] of PHY_PIX_PUM_LINK."; sw = rw; hw = r;
        } phy_lane13_pix_num[31:16];
    } PHY_PIX_PUM_LINK @ 0x54;

    reg {
        name = "PHY_SYNC_SOL0_LINK";
        desc = "PHY_SYNC_SOL0_LINK at window offset 0x60 (vendor header mipi_rx_reg.h, type U_PHY_SYNC_SOL0_LINK). Layout PROVEN from the vendor header; access type GUESS (read-write), reset unknown.";
        field {
            name = "cil_sol0_word4_0";
            desc = "Bits [15:0] of PHY_SYNC_SOL0_LINK."; sw = rw; hw = r;
        } cil_sol0_word4_0[15:0];
        field {
            name = "cil_sol1_word4_0";
            desc = "Bits [31:16] of PHY_SYNC_SOL0_LINK."; sw = rw; hw = r;
        } cil_sol1_word4_0[31:16];
    } PHY_SYNC_SOL0_LINK @ 0x60;

    reg {
        name = "PHY_SYNC_SOL1_LINK";
        desc = "PHY_SYNC_SOL1_LINK at window offset 0x64 (vendor header mipi_rx_reg.h, type U_PHY_SYNC_SOL1_LINK). Layout PROVEN from the vendor header; access type GUESS (read-write), reset unknown.";
        field {
            name = "cil_sol0_word4_1";
            desc = "Bits [15:0] of PHY_SYNC_SOL1_LINK."; sw = rw; hw = r;
        } cil_sol0_word4_1[15:0];
        field {
            name = "cil_sol1_word4_1";
            desc = "Bits [31:16] of PHY_SYNC_SOL1_LINK."; sw = rw; hw = r;
        } cil_sol1_word4_1[31:16];
    } PHY_SYNC_SOL1_LINK @ 0x64;

    reg {
        name = "PHY_SYNC_SOL2_LINK";
        desc = "PHY_SYNC_SOL2_LINK at window offset 0x68 (vendor header mipi_rx_reg.h, type U_PHY_SYNC_SOL2_LINK). Layout PROVEN from the vendor header; access type GUESS (read-write), reset unknown.";
        field {
            name = "cil_sol0_word4_2";
            desc = "Bits [15:0] of PHY_SYNC_SOL2_LINK."; sw = rw; hw = r;
        } cil_sol0_word4_2[15:0];
        field {
            name = "cil_sol1_word4_2";
            desc = "Bits [31:16] of PHY_SYNC_SOL2_LINK."; sw = rw; hw = r;
        } cil_sol1_word4_2[31:16];
    } PHY_SYNC_SOL2_LINK @ 0x68;

    reg {
        name = "PHY_SYNC_SOL3_LINK";
        desc = "PHY_SYNC_SOL3_LINK at window offset 0x6C (vendor header mipi_rx_reg.h, type U_PHY_SYNC_SOL3_LINK). Layout PROVEN from the vendor header; access type GUESS (read-write), reset unknown.";
        field {
            name = "cil_sol0_word4_3";
            desc = "Bits [15:0] of PHY_SYNC_SOL3_LINK."; sw = rw; hw = r;
        } cil_sol0_word4_3[15:0];
        field {
            name = "cil_sol1_word4_3";
            desc = "Bits [31:16] of PHY_SYNC_SOL3_LINK."; sw = rw; hw = r;
        } cil_sol1_word4_3[31:16];
    } PHY_SYNC_SOL3_LINK @ 0x6C;

    reg {
        name = "CIL_TIMEOUT_LINK";
        desc = "CIL_TIMEOUT_LINK at window offset 0x100 (vendor header mipi_rx_reg.h, type U_CIL_TIMEOUT_LINK). Layout PROVEN from the vendor header; access type GUESS (read-write), reset unknown.";
        field {
            name = "cil_timeout_cyc";
            desc = "Bits [23:0] of CIL_TIMEOUT_LINK."; sw = rw; hw = r;
        } cil_timeout_cyc[23:0];
        field {
            name = "cil_timeout_en_ck";
            desc = "Bits [30:30] of CIL_TIMEOUT_LINK."; sw = rw; hw = r;
        } cil_timeout_en_ck[30:30];
        field {
            name = "cil_timeout_en_d";
            desc = "Bits [31:31] of CIL_TIMEOUT_LINK."; sw = rw; hw = r;
        } cil_timeout_en_d[31:31];
    } CIL_TIMEOUT_LINK @ 0x100;

    reg {
        name = "CIL_FSM0_LINK";
        desc = "CIL_FSM0_LINK at window offset 0x104 (vendor header mipi_rx_reg.h, type U_CIL_FSM0_LINK). Layout PROVEN from the vendor header; access type GUESS (read-write), reset unknown.";
        field {
            name = "cil_cyc_clk_lp00";
            desc = "Bits [5:0] of CIL_FSM0_LINK."; sw = rw; hw = r;
        } cil_cyc_clk_lp00[5:0];
        field {
            name = "cil_cyc_clk_hs0";
            desc = "Bits [13:8] of CIL_FSM0_LINK."; sw = rw; hw = r;
        } cil_cyc_clk_hs0[13:8];
        field {
            name = "cil_cyc_clk_hs_exit";
            desc = "Bits [21:16] of CIL_FSM0_LINK."; sw = rw; hw = r;
        } cil_cyc_clk_hs_exit[21:16];
        field {
            name = "cil_cyc_clk_hs_trail";
            desc = "Bits [29:24] of CIL_FSM0_LINK."; sw = rw; hw = r;
        } cil_cyc_clk_hs_trail[29:24];
    } CIL_FSM0_LINK @ 0x104;

    reg {
        name = "CIL_FSM_ST0_LINK";
        desc = "CIL_FSM_ST0_LINK at window offset 0x108 (vendor header mipi_rx_reg.h, type U_CIL_FSM_ST0_LINK). Layout PROVEN from the vendor header; access type GUESS (read-only from the name), reset unknown.";
        field {
            name = "cil_cur_st_d0";
            desc = "Bits [3:0] of CIL_FSM_ST0_LINK."; sw = r; hw = w;
        } cil_cur_st_d0[3:0];
        field {
            name = "cil_nxt_st_d0";
            desc = "Bits [7:4] of CIL_FSM_ST0_LINK."; sw = r; hw = w;
        } cil_nxt_st_d0[7:4];
        field {
            name = "cil_cur_st_d1";
            desc = "Bits [11:8] of CIL_FSM_ST0_LINK."; sw = r; hw = w;
        } cil_cur_st_d1[11:8];
        field {
            name = "cil_nxt_st_d1";
            desc = "Bits [15:12] of CIL_FSM_ST0_LINK."; sw = r; hw = w;
        } cil_nxt_st_d1[15:12];
        field {
            name = "cil_cur_st_d2";
            desc = "Bits [19:16] of CIL_FSM_ST0_LINK."; sw = r; hw = w;
        } cil_cur_st_d2[19:16];
        field {
            name = "cil_nxt_st_d2";
            desc = "Bits [23:20] of CIL_FSM_ST0_LINK."; sw = r; hw = w;
        } cil_nxt_st_d2[23:20];
        field {
            name = "cil_cur_st_d3";
            desc = "Bits [27:24] of CIL_FSM_ST0_LINK."; sw = r; hw = w;
        } cil_cur_st_d3[27:24];
        field {
            name = "cil_nxt_st_d3";
            desc = "Bits [31:28] of CIL_FSM_ST0_LINK."; sw = r; hw = w;
        } cil_nxt_st_d3[31:28];
    } CIL_FSM_ST0_LINK @ 0x108;

    reg {
        name = "CIL_FSM_ST1_LINK";
        desc = "CIL_FSM_ST1_LINK at window offset 0x10C (vendor header mipi_rx_reg.h, type U_CIL_FSM_ST1_LINK). Layout PROVEN from the vendor header; access type GUESS (read-only from the name), reset unknown.";
        field {
            name = "cil_cur_st_ck";
            desc = "Bits [3:0] of CIL_FSM_ST1_LINK."; sw = r; hw = w;
        } cil_cur_st_ck[3:0];
        field {
            name = "cil_nxt_st_ck";
            desc = "Bits [7:4] of CIL_FSM_ST1_LINK."; sw = r; hw = w;
        } cil_nxt_st_ck[7:4];
    } CIL_FSM_ST1_LINK @ 0x10C;

    reg {
        name = "PHY_ST0_LINK";
        desc = "PHY_ST0_LINK at window offset 0x110 (vendor header mipi_rx_reg.h, type U_PHY_ST0_LINK). Layout PROVEN from the vendor header; access type GUESS (read-write), reset unknown.";
        field {
            name = "physt0_rg_en_d";
            desc = "Bits [3:0] of PHY_ST0_LINK."; sw = rw; hw = r;
        } physt0_rg_en_d[3:0];
        field {
            name = "physt0_rg_en_clk0";
            desc = "Bits [4:4] of PHY_ST0_LINK."; sw = rw; hw = r;
        } physt0_rg_en_clk0[4:4];
        field {
            name = "physt0_rg_en_clk1";
            desc = "Bits [5:5] of PHY_ST0_LINK."; sw = rw; hw = r;
        } physt0_rg_en_clk1[5:5];
        field {
            name = "physt0_rg_en_cmos";
            desc = "Bits [8:8] of PHY_ST0_LINK."; sw = rw; hw = r;
        } physt0_rg_en_cmos[8:8];
        field {
            name = "physt0_rg_en_lp0";
            desc = "Bits [12:12] of PHY_ST0_LINK."; sw = rw; hw = r;
        } physt0_rg_en_lp0[12:12];
        field {
            name = "physt0_rg_en_lp1";
            desc = "Bits [13:13] of PHY_ST0_LINK."; sw = rw; hw = r;
        } physt0_rg_en_lp1[13:13];
        field {
            name = "physt0_rg_faclk0_en";
            desc = "Bits [16:16] of PHY_ST0_LINK."; sw = rw; hw = r;
        } physt0_rg_faclk0_en[16:16];
        field {
            name = "physt0_rg_faclk1_en";
            desc = "Bits [17:17] of PHY_ST0_LINK."; sw = rw; hw = r;
        } physt0_rg_faclk1_en[17:17];
        field {
            name = "physt0_rg_en_2l2l";
            desc = "Bits [20:20] of PHY_ST0_LINK."; sw = rw; hw = r;
        } physt0_rg_en_2l2l[20:20];
        field {
            name = "physt0_rg_mipi_mode0";
            desc = "Bits [24:24] of PHY_ST0_LINK."; sw = rw; hw = r;
        } physt0_rg_mipi_mode0[24:24];
        field {
            name = "physt0_rg_mipi_mode1";
            desc = "Bits [25:25] of PHY_ST0_LINK."; sw = rw; hw = r;
        } physt0_rg_mipi_mode1[25:25];
    } PHY_ST0_LINK @ 0x110;

    reg {
        name = "PHY_ST1_LINK";
        desc = "PHY_ST1_LINK at window offset 0x114 (vendor header mipi_rx_reg.h, type U_PHY_ST1_LINK). Layout PROVEN from the vendor header; access type GUESS (read-write), reset unknown.";
        field {
            name = "physt0_clk0_skew";
            desc = "Bits [2:0] of PHY_ST1_LINK."; sw = rw; hw = r;
        } physt0_clk0_skew[2:0];
        field {
            name = "physt0_clk1_skew";
            desc = "Bits [6:4] of PHY_ST1_LINK."; sw = rw; hw = r;
        } physt0_clk1_skew[6:4];
        field {
            name = "physt0_d0_skew";
            desc = "Bits [10:8] of PHY_ST1_LINK."; sw = rw; hw = r;
        } physt0_d0_skew[10:8];
        field {
            name = "physt0_d1_skew";
            desc = "Bits [14:12] of PHY_ST1_LINK."; sw = rw; hw = r;
        } physt0_d1_skew[14:12];
        field {
            name = "physt0_d2_skew";
            desc = "Bits [18:16] of PHY_ST1_LINK."; sw = rw; hw = r;
        } physt0_d2_skew[18:16];
        field {
            name = "physt0_d3_skew";
            desc = "Bits [22:20] of PHY_ST1_LINK."; sw = rw; hw = r;
        } physt0_d3_skew[22:20];
    } PHY_ST1_LINK @ 0x114;

    reg {
        name = "PHY_ST2_LINK";
        desc = "PHY_ST2_LINK at window offset 0x118 (vendor header mipi_rx_reg.h, type U_PHY_ST2_LINK). Layout PROVEN from the vendor header; access type GUESS (read-write), reset unknown.";
        field {
            name = "physt_da_d0_valid";
            desc = "Bits [0:0] of PHY_ST2_LINK."; sw = rw; hw = r;
        } physt_da_d0_valid[0:0];
        field {
            name = "physt_da_d1_valid";
            desc = "Bits [1:1] of PHY_ST2_LINK."; sw = rw; hw = r;
        } physt_da_d1_valid[1:1];
        field {
            name = "physt_da_d2_valid";
            desc = "Bits [2:2] of PHY_ST2_LINK."; sw = rw; hw = r;
        } physt_da_d2_valid[2:2];
        field {
            name = "physt_da_d3_valid";
            desc = "Bits [3:3] of PHY_ST2_LINK."; sw = rw; hw = r;
        } physt_da_d3_valid[3:3];
        field {
            name = "physt_d0_term_en";
            desc = "Bits [8:8] of PHY_ST2_LINK."; sw = rw; hw = r;
        } physt_d0_term_en[8:8];
        field {
            name = "physt_d1_term_en";
            desc = "Bits [9:9] of PHY_ST2_LINK."; sw = rw; hw = r;
        } physt_d1_term_en[9:9];
        field {
            name = "physt_d2_term_en";
            desc = "Bits [10:10] of PHY_ST2_LINK."; sw = rw; hw = r;
        } physt_d2_term_en[10:10];
        field {
            name = "physt_d3_term_en";
            desc = "Bits [11:11] of PHY_ST2_LINK."; sw = rw; hw = r;
        } physt_d3_term_en[11:11];
        field {
            name = "physt_clk0_term_en";
            desc = "Bits [12:12] of PHY_ST2_LINK."; sw = rw; hw = r;
        } physt_clk0_term_en[12:12];
        field {
            name = "physt_clk1_term_en";
            desc = "Bits [13:13] of PHY_ST2_LINK."; sw = rw; hw = r;
        } physt_clk1_term_en[13:13];
    } PHY_ST2_LINK @ 0x118;

    reg {
        name = "PHY_ST3_LINK";
        desc = "PHY_ST3_LINK at window offset 0x11C (vendor header mipi_rx_reg.h, type U_PHY_ST3_LINK). Layout PROVEN from the vendor header; access type GUESS (read-write), reset unknown.";
        field {
            name = "physt0_da_ulpb";
            desc = "Bits [3:0] of PHY_ST3_LINK."; sw = rw; hw = r;
        } physt0_da_ulpb[3:0];
        field {
            name = "physt0_da_ulpb_ck0";
            desc = "Bits [4:4] of PHY_ST3_LINK."; sw = rw; hw = r;
        } physt0_da_ulpb_ck0[4:4];
        field {
            name = "physt0_da_ulpb_ck1";
            desc = "Bits [5:5] of PHY_ST3_LINK."; sw = rw; hw = r;
        } physt0_da_ulpb_ck1[5:5];
        field {
            name = "physt0_rg_it_lp";
            desc = "Bits [9:8] of PHY_ST3_LINK."; sw = rw; hw = r;
        } physt0_rg_it_lp[9:8];
        field {
            name = "physt0_rg_it_ck";
            desc = "Bits [11:10] of PHY_ST3_LINK."; sw = rw; hw = r;
        } physt0_rg_it_ck[11:10];
        field {
            name = "physt0_rg_it_dt";
            desc = "Bits [13:12] of PHY_ST3_LINK."; sw = rw; hw = r;
        } physt0_rg_it_dt[13:12];
        field {
            name = "physt0_rg_sa_en";
            desc = "Bits [14:14] of PHY_ST3_LINK."; sw = rw; hw = r;
        } physt0_rg_sa_en[14:14];
    } PHY_ST3_LINK @ 0x11C;

    reg {
        name = "CIL_FSM1_LINK";
        desc = "CIL_FSM1_LINK at window offset 0x12C (vendor header mipi_rx_reg.h, type U_CIL_FSM1_LINK). Layout PROVEN from the vendor header; access type GUESS (read-write), reset unknown.";
        field {
            name = "cil_cyc_data_lp00";
            desc = "Bits [5:0] of CIL_FSM1_LINK."; sw = rw; hw = r;
        } cil_cyc_data_lp00[5:0];
        field {
            name = "cil_cyc_data_hs0";
            desc = "Bits [13:8] of CIL_FSM1_LINK."; sw = rw; hw = r;
        } cil_cyc_data_hs0[13:8];
        field {
            name = "cil_cyc_data_hs_exit";
            desc = "Bits [21:16] of CIL_FSM1_LINK."; sw = rw; hw = r;
        } cil_cyc_data_hs_exit[21:16];
        field {
            name = "cil_cyc_data_hs_trail";
            desc = "Bits [29:24] of CIL_FSM1_LINK."; sw = rw; hw = r;
        } cil_cyc_data_hs_trail[29:24];
    } CIL_FSM1_LINK @ 0x12C;

    reg {
        name = "MIPI_CIL_INT_RAW_LINK";
        desc = "MIPI_CIL_INT_RAW_LINK at window offset 0x1F0 (vendor header mipi_rx_reg.h, type U_MIPI_CIL_INT_RAW_LINK). Layout PROVEN from the vendor header; access type GUESS (read-only from the name), reset unknown.";
        field {
            name = "err0_escape_d0_raw";
            desc = "Bits [0:0] of MIPI_CIL_INT_RAW_LINK."; sw = r; hw = w;
        } err0_escape_d0_raw[0:0];
        field {
            name = "err0_escape_d1_raw";
            desc = "Bits [1:1] of MIPI_CIL_INT_RAW_LINK."; sw = r; hw = w;
        } err0_escape_d1_raw[1:1];
        field {
            name = "err0_escape_d2_raw";
            desc = "Bits [2:2] of MIPI_CIL_INT_RAW_LINK."; sw = r; hw = w;
        } err0_escape_d2_raw[2:2];
        field {
            name = "err0_escape_d3_raw";
            desc = "Bits [3:3] of MIPI_CIL_INT_RAW_LINK."; sw = r; hw = w;
        } err0_escape_d3_raw[3:3];
        field {
            name = "err0_escape_ck0_raw";
            desc = "Bits [4:4] of MIPI_CIL_INT_RAW_LINK."; sw = r; hw = w;
        } err0_escape_ck0_raw[4:4];
        field {
            name = "err0_timeout_d0_raw";
            desc = "Bits [8:8] of MIPI_CIL_INT_RAW_LINK."; sw = r; hw = w;
        } err0_timeout_d0_raw[8:8];
        field {
            name = "err0_timeout_d1_raw";
            desc = "Bits [9:9] of MIPI_CIL_INT_RAW_LINK."; sw = r; hw = w;
        } err0_timeout_d1_raw[9:9];
        field {
            name = "err0_timeout_d2_raw";
            desc = "Bits [10:10] of MIPI_CIL_INT_RAW_LINK."; sw = r; hw = w;
        } err0_timeout_d2_raw[10:10];
        field {
            name = "err0_timeout_d3_raw";
            desc = "Bits [11:11] of MIPI_CIL_INT_RAW_LINK."; sw = r; hw = w;
        } err0_timeout_d3_raw[11:11];
        field {
            name = "err0_timeout_ck0_raw";
            desc = "Bits [12:12] of MIPI_CIL_INT_RAW_LINK."; sw = r; hw = w;
        } err0_timeout_ck0_raw[12:12];
    } MIPI_CIL_INT_RAW_LINK @ 0x1F0;

    reg {
        name = "MIPI_CIL_INT_LINK";
        desc = "MIPI_CIL_INT_LINK at window offset 0x1F4 (vendor header mipi_rx_reg.h, type U_MIPI_CIL_INT_LINK). Layout PROVEN from the vendor header; access type GUESS (read-write), reset unknown.";
        field {
            name = "err0_escape_d0_st";
            desc = "Bits [0:0] of MIPI_CIL_INT_LINK."; sw = rw; hw = r;
        } err0_escape_d0_st[0:0];
        field {
            name = "err0_escape_d1_st";
            desc = "Bits [1:1] of MIPI_CIL_INT_LINK."; sw = rw; hw = r;
        } err0_escape_d1_st[1:1];
        field {
            name = "err0_escape_d2_st";
            desc = "Bits [2:2] of MIPI_CIL_INT_LINK."; sw = rw; hw = r;
        } err0_escape_d2_st[2:2];
        field {
            name = "err0_escape_d3_st";
            desc = "Bits [3:3] of MIPI_CIL_INT_LINK."; sw = rw; hw = r;
        } err0_escape_d3_st[3:3];
        field {
            name = "err0_escape_ck0_st";
            desc = "Bits [4:4] of MIPI_CIL_INT_LINK."; sw = rw; hw = r;
        } err0_escape_ck0_st[4:4];
        field {
            name = "err0_escape_ck1_st";
            desc = "Bits [5:5] of MIPI_CIL_INT_LINK."; sw = rw; hw = r;
        } err0_escape_ck1_st[5:5];
        field {
            name = "err0_timeout_d0_st";
            desc = "Bits [8:8] of MIPI_CIL_INT_LINK."; sw = rw; hw = r;
        } err0_timeout_d0_st[8:8];
        field {
            name = "err0_timeout_d1_st";
            desc = "Bits [9:9] of MIPI_CIL_INT_LINK."; sw = rw; hw = r;
        } err0_timeout_d1_st[9:9];
        field {
            name = "err0_timeout_d2_st";
            desc = "Bits [10:10] of MIPI_CIL_INT_LINK."; sw = rw; hw = r;
        } err0_timeout_d2_st[10:10];
        field {
            name = "err0_timeout_d3_st";
            desc = "Bits [11:11] of MIPI_CIL_INT_LINK."; sw = rw; hw = r;
        } err0_timeout_d3_st[11:11];
        field {
            name = "err0_timeout_ck0_st";
            desc = "Bits [12:12] of MIPI_CIL_INT_LINK."; sw = rw; hw = r;
        } err0_timeout_ck0_st[12:12];
        field {
            name = "err0_timeout_ck1_st";
            desc = "Bits [13:13] of MIPI_CIL_INT_LINK."; sw = rw; hw = r;
        } err0_timeout_ck1_st[13:13];
    } MIPI_CIL_INT_LINK @ 0x1F4;

    reg {
        name = "MIPI_CIL_INT_MSK_LINK";
        desc = "MIPI_CIL_INT_MSK_LINK at window offset 0x1F8 (vendor header mipi_rx_reg.h, type U_MIPI_CIL_INT_MSK_LINK). Layout PROVEN from the vendor header; access type GUESS (read-write), reset unknown.";
        field {
            name = "err3_escape_d0_msk";
            desc = "Bits [0:0] of MIPI_CIL_INT_MSK_LINK."; sw = rw; hw = r;
        } err3_escape_d0_msk[0:0];
        field {
            name = "err3_escape_d1_msk";
            desc = "Bits [1:1] of MIPI_CIL_INT_MSK_LINK."; sw = rw; hw = r;
        } err3_escape_d1_msk[1:1];
        field {
            name = "err3_escape_d2_msk";
            desc = "Bits [2:2] of MIPI_CIL_INT_MSK_LINK."; sw = rw; hw = r;
        } err3_escape_d2_msk[2:2];
        field {
            name = "err3_escape_d3_msk";
            desc = "Bits [3:3] of MIPI_CIL_INT_MSK_LINK."; sw = rw; hw = r;
        } err3_escape_d3_msk[3:3];
        field {
            name = "err3_escape_ck0_msk";
            desc = "Bits [4:4] of MIPI_CIL_INT_MSK_LINK."; sw = rw; hw = r;
        } err3_escape_ck0_msk[4:4];
        field {
            name = "err3_escape_ck1_msk";
            desc = "Bits [5:5] of MIPI_CIL_INT_MSK_LINK."; sw = rw; hw = r;
        } err3_escape_ck1_msk[5:5];
        field {
            name = "err3_timeout_d0_msk";
            desc = "Bits [8:8] of MIPI_CIL_INT_MSK_LINK."; sw = rw; hw = r;
        } err3_timeout_d0_msk[8:8];
        field {
            name = "err3_timeout_d1_msk";
            desc = "Bits [9:9] of MIPI_CIL_INT_MSK_LINK."; sw = rw; hw = r;
        } err3_timeout_d1_msk[9:9];
        field {
            name = "err3_timeout_d2_msk";
            desc = "Bits [10:10] of MIPI_CIL_INT_MSK_LINK."; sw = rw; hw = r;
        } err3_timeout_d2_msk[10:10];
        field {
            name = "err3_timeout_d3_msk";
            desc = "Bits [11:11] of MIPI_CIL_INT_MSK_LINK."; sw = rw; hw = r;
        } err3_timeout_d3_msk[11:11];
        field {
            name = "err3_timeout_ck0_msk";
            desc = "Bits [12:12] of MIPI_CIL_INT_MSK_LINK."; sw = rw; hw = r;
        } err3_timeout_ck0_msk[12:12];
        field {
            name = "err3_timeout_ck1_msk";
            desc = "Bits [13:13] of MIPI_CIL_INT_MSK_LINK."; sw = rw; hw = r;
        } err3_timeout_ck1_msk[13:13];
    } MIPI_CIL_INT_MSK_LINK @ 0x1F8;

    reg {
        name = "PHY_EN";
        desc = "PHY_EN at window offset 0x808 (vendor header mipi_rx_reg.h, type U_PHY_EN). Layout PROVEN from the vendor header; access type GUESS (read-write), reset unknown.";
        field {
            name = "phy0_en";
            desc = "Bits [0:0] of PHY_EN."; sw = rw; hw = r;
        } phy0_en[0:0];
        field {
            name = "d_p_swap_data0";
            desc = "Bits [4:4] of PHY_EN."; sw = rw; hw = r;
        } d_p_swap_data0[4:4];
        field {
            name = "d_p_swap_data1";
            desc = "Bits [5:5] of PHY_EN."; sw = rw; hw = r;
        } d_p_swap_data1[5:5];
        field {
            name = "d_p_swap_data2";
            desc = "Bits [6:6] of PHY_EN."; sw = rw; hw = r;
        } d_p_swap_data2[6:6];
        field {
            name = "d_p_swap_data3";
            desc = "Bits [7:7] of PHY_EN."; sw = rw; hw = r;
        } d_p_swap_data3[7:7];
        field {
            name = "d_p_swap_clk";
            desc = "Bits [8:8] of PHY_EN."; sw = rw; hw = r;
        } d_p_swap_clk[8:8];
    } PHY_EN @ 0x808;

    reg {
        name = "LANE_EN";
        desc = "LANE_EN at window offset 0x80C (vendor header mipi_rx_reg.h, type U_LANE_EN). Layout PROVEN from the vendor header; access type GUESS (read-write), reset unknown.";
        field {
            name = "lane0_en";
            desc = "Bits [0:0] of LANE_EN."; sw = rw; hw = r;
        } lane0_en[0:0];
        field {
            name = "lane1_en";
            desc = "Bits [1:1] of LANE_EN."; sw = rw; hw = r;
        } lane1_en[1:1];
        field {
            name = "lane2_en";
            desc = "Bits [2:2] of LANE_EN."; sw = rw; hw = r;
        } lane2_en[2:2];
        field {
            name = "lane3_en";
            desc = "Bits [3:3] of LANE_EN."; sw = rw; hw = r;
        } lane3_en[3:3];
    } LANE_EN @ 0x80C;

    reg {
        name = "PHY_CIL_CTRL";
        desc = "PHY_CIL_CTRL at window offset 0x810 (vendor header mipi_rx_reg.h, type U_PHY_CIL_CTRL). Layout PROVEN from the vendor header; access type GUESS (read-write), reset unknown.";
        field {
            name = "phycil0_cken";
            desc = "Bits [0:0] of PHY_CIL_CTRL."; sw = rw; hw = r;
        } phycil0_cken[0:0];
        field {
            name = "cil0_rst_req";
            desc = "Bits [8:8] of PHY_CIL_CTRL."; sw = rw; hw = r;
        } cil0_rst_req[8:8];
    } PHY_CIL_CTRL @ 0x810;

    reg {
        name = "PHYCFG_MODE";
        desc = "PHYCFG_MODE at window offset 0x818 (vendor header mipi_rx_reg.h, type U_PHYCFG_MODE). Layout PROVEN from the vendor header; access type GUESS (read-write), reset unknown.";
        field {
            name = "phycil0_0_cfg_mode";
            desc = "Bits [2:0] of PHYCFG_MODE."; sw = rw; hw = r;
        } phycil0_0_cfg_mode[2:0];
        field {
            name = "phycil0_cfg_mode_sel";
            desc = "Bits [3:3] of PHYCFG_MODE."; sw = rw; hw = r;
        } phycil0_cfg_mode_sel[3:3];
    } PHYCFG_MODE @ 0x818;

    reg {
        name = "PHYCFG_EN";
        desc = "PHYCFG_EN at window offset 0x81C (vendor header mipi_rx_reg.h, type U_PHYCFG_EN). Layout PROVEN from the vendor header; access type GUESS (read-write), reset unknown.";
        field {
            name = "phycil0_cfg_en";
            desc = "Bits [0:0] of PHYCFG_EN."; sw = rw; hw = r;
        } phycil0_cfg_en[0:0];
    } PHYCFG_EN @ 0x81C;

    reg {
        name = "CHN0_MEM_CTRL";
        desc = "CHN0_MEM_CTRL at window offset 0x820 (vendor header mipi_rx_reg.h, type U_CHN0_MEM_CTRL). Layout PROVEN from the vendor header; access type GUESS (read-write), reset unknown.";
        field {
            name = "chn0_mem_ck_gt";
            desc = "Bits [0:0] of CHN0_MEM_CTRL."; sw = rw; hw = r;
        } chn0_mem_ck_gt[0:0];
        field {
            name = "chn0_mem_emasa";
            desc = "Bits [4:4] of CHN0_MEM_CTRL."; sw = rw; hw = r;
        } chn0_mem_emasa[4:4];
        field {
            name = "chn0_mem_ret1n";
            desc = "Bits [5:5] of CHN0_MEM_CTRL."; sw = rw; hw = r;
        } chn0_mem_ret1n[5:5];
        field {
            name = "chn0_mem_colldisn";
            desc = "Bits [6:6] of CHN0_MEM_CTRL."; sw = rw; hw = r;
        } chn0_mem_colldisn[6:6];
        field {
            name = "chn0_mem_emaa";
            desc = "Bits [10:8] of CHN0_MEM_CTRL."; sw = rw; hw = r;
        } chn0_mem_emaa[10:8];
        field {
            name = "chn0_mem_emab";
            desc = "Bits [14:12] of CHN0_MEM_CTRL."; sw = rw; hw = r;
        } chn0_mem_emab[14:12];
    } CHN0_MEM_CTRL @ 0x820;

    reg {
        name = "CHN0_CLR_EN";
        desc = "CHN0_CLR_EN at window offset 0x824 (vendor header mipi_rx_reg.h, type U_CHN0_CLR_EN). Layout PROVEN from the vendor header; access type GUESS (read-write), reset unknown.";
        field {
            name = "chn0_clr_en_lvds";
            desc = "Bits [0:0] of CHN0_CLR_EN."; sw = rw; hw = r;
        } chn0_clr_en_lvds[0:0];
        field {
            name = "chn0_clr_en_align";
            desc = "Bits [1:1] of CHN0_CLR_EN."; sw = rw; hw = r;
        } chn0_clr_en_align[1:1];
    } CHN0_CLR_EN @ 0x824;

    reg {
        name = "MIPI_TEST_PHY";
        desc = "MIPI_TEST_PHY at window offset 0x880 (vendor header mipi_rx_reg.h, type U_MIPI_TEST_PHY). Layout PROVEN from the vendor header; access type GUESS (read-write), reset unknown.";
        field {
            name = "test_phy_en";
            desc = "Bits [0:0] of MIPI_TEST_PHY."; sw = rw; hw = r;
        } test_phy_en[0:0];
        field {
            name = "test_phy_srst_req";
            desc = "Bits [4:4] of MIPI_TEST_PHY."; sw = rw; hw = r;
        } test_phy_srst_req[4:4];
    } MIPI_TEST_PHY @ 0x880;

    reg {
        name = "COLORBAR_CTRL_LINK0";
        desc = "COLORBAR_CTRL_LINK0 at window offset 0x900 (vendor header mipi_rx_reg.h, type U_COLORBAR_CTRL_LINK0). Layout PROVEN from the vendor header; access type GUESS (read-write), reset unknown.";
        field {
            name = "colorbar0_en";
            desc = "Bits [0:0] of COLORBAR_CTRL_LINK0."; sw = rw; hw = r;
        } colorbar0_en[0:0];
        field {
            name = "colorbar0_mode";
            desc = "Bits [1:1] of COLORBAR_CTRL_LINK0."; sw = rw; hw = r;
        } colorbar0_mode[1:1];
        field {
            name = "colorbar0_pattern";
            desc = "Bits [2:2] of COLORBAR_CTRL_LINK0."; sw = rw; hw = r;
        } colorbar0_pattern[2:2];
        field {
            name = "colorbar0_line_init";
            desc = "Bits [3:3] of COLORBAR_CTRL_LINK0."; sw = rw; hw = r;
        } colorbar0_line_init[3:3];
        field {
            name = "colorbar0_width";
            desc = "Bits [13:4] of COLORBAR_CTRL_LINK0."; sw = rw; hw = r;
        } colorbar0_width[13:4];
    } COLORBAR_CTRL_LINK0 @ 0x900;

    reg {
        name = "COLORBAR_INIT_LINK0";
        desc = "COLORBAR_INIT_LINK0 at window offset 0x904 (vendor header mipi_rx_reg.h, type U_COLORBAR_INIT_LINK0). Layout PROVEN from the vendor header; access type GUESS (read-write), reset unknown.";
        field {
            name = "colorbar0_data_init";
            desc = "Bits [11:0] of COLORBAR_INIT_LINK0."; sw = rw; hw = r;
        } colorbar0_data_init[11:0];
        field {
            name = "colorbar0_data_inc";
            desc = "Bits [27:16] of COLORBAR_INIT_LINK0."; sw = rw; hw = r;
        } colorbar0_data_inc[27:16];
    } COLORBAR_INIT_LINK0 @ 0x904;

    reg {
        name = "COLORBAR_V_BLK_LINK0";
        desc = "COLORBAR_V_BLK_LINK0 at window offset 0x908 (vendor header mipi_rx_reg.h, type U_COLORBAR_V_BLK_LINK0). Layout PROVEN from the vendor header; access type GUESS (read-write), reset unknown.";
        field {
            name = "colorbar0_vertical_blk";
            desc = "Bits [19:0] of COLORBAR_V_BLK_LINK0."; sw = rw; hw = r;
        } colorbar0_vertical_blk[19:0];
    } COLORBAR_V_BLK_LINK0 @ 0x908;

    reg {
        name = "COLORBAR_H_BLK_LINK0";
        desc = "COLORBAR_H_BLK_LINK0 at window offset 0x90C (vendor header mipi_rx_reg.h, type U_COLORBAR_H_BLK_LINK0). Layout PROVEN from the vendor header; access type GUESS (read-write), reset unknown.";
        field {
            name = "colorbar0_line_blk";
            desc = "Bits [19:0] of COLORBAR_H_BLK_LINK0."; sw = rw; hw = r;
        } colorbar0_line_blk[19:0];
    } COLORBAR_H_BLK_LINK0 @ 0x90C;

    reg {
        name = "COLORBAR_IMG_SIZE_LINK0";
        desc = "COLORBAR_IMG_SIZE_LINK0 at window offset 0x910 (vendor header mipi_rx_reg.h, type U_COLORBAR_IMG_SIZE_LINK0). Layout PROVEN from the vendor header; access type GUESS (read-write), reset unknown.";
        field {
            name = "colorbar0_imgwidth";
            desc = "Bits [15:0] of COLORBAR_IMG_SIZE_LINK0."; sw = rw; hw = r;
        } colorbar0_imgwidth[15:0];
        field {
            name = "colorbar0_imgheight";
            desc = "Bits [31:16] of COLORBAR_IMG_SIZE_LINK0."; sw = rw; hw = r;
        } colorbar0_imgheight[31:16];
    } COLORBAR_IMG_SIZE_LINK0 @ 0x910;

    reg {
        name = "COLORBAR_SYNC_CODE0_LINK0";
        desc = "COLORBAR_SYNC_CODE0_LINK0 at window offset 0x914 (vendor header mipi_rx_reg.h, type U_COLORBAR_SYNC_CODE0_LINK0). Layout PROVEN from the vendor header; access type GUESS (read-write), reset unknown.";
        field {
            name = "colorbar0_sof";
            desc = "Bits [11:0] of COLORBAR_SYNC_CODE0_LINK0."; sw = rw; hw = r;
        } colorbar0_sof[11:0];
        field {
            name = "colorbar0_eof";
            desc = "Bits [27:16] of COLORBAR_SYNC_CODE0_LINK0."; sw = rw; hw = r;
        } colorbar0_eof[27:16];
    } COLORBAR_SYNC_CODE0_LINK0 @ 0x914;

    reg {
        name = "COLORBAR_SYNC_CODE1_LINK0";
        desc = "COLORBAR_SYNC_CODE1_LINK0 at window offset 0x918 (vendor header mipi_rx_reg.h, type U_COLORBAR_SYNC_CODE1_LINK0). Layout PROVEN from the vendor header; access type GUESS (read-write), reset unknown.";
        field {
            name = "colorbar0_sol";
            desc = "Bits [11:0] of COLORBAR_SYNC_CODE1_LINK0."; sw = rw; hw = r;
        } colorbar0_sol[11:0];
        field {
            name = "colorbar0_eol";
            desc = "Bits [27:16] of COLORBAR_SYNC_CODE1_LINK0."; sw = rw; hw = r;
        } colorbar0_eol[27:16];
    } COLORBAR_SYNC_CODE1_LINK0 @ 0x918;

    reg {
        name = "PHY0_TEST_OUT";
        desc = "PHY0_TEST_OUT at window offset 0xA00 (vendor header mipi_rx_reg.h, type U_PHY0_TEST_OUT). Layout PROVEN from the vendor header; access type GUESS (read-only from the name), reset unknown.";
        field {
            name = "test_phy0_resault";
            desc = "Bits [3:0] of PHY0_TEST_OUT."; sw = r; hw = w;
        } test_phy0_resault[3:0];
        field {
            name = "test_phy0_compare";
            desc = "Bits [7:4] of PHY0_TEST_OUT."; sw = r; hw = w;
        } test_phy0_compare[7:4];
        field {
            name = "test_phy0_done";
            desc = "Bits [11:8] of PHY0_TEST_OUT."; sw = r; hw = w;
        } test_phy0_done[11:8];
    } PHY0_TEST_OUT @ 0xA00;

    reg {
        name = "MIPI_INT_RAW";
        desc = "MIPI_INT_RAW at window offset 0xFF0 (vendor header mipi_rx_reg.h, type U_MIPI_INT_RAW). Layout PROVEN from the vendor header; access type GUESS (read-only from the name), reset unknown.";
        field {
            name = "int_phycil0_raw";
            desc = "Bits [0:0] of MIPI_INT_RAW."; sw = r; hw = w;
        } int_phycil0_raw[0:0];
        field {
            name = "int_chn0_raw";
            desc = "Bits [4:4] of MIPI_INT_RAW."; sw = r; hw = w;
        } int_chn0_raw[4:4];
    } MIPI_INT_RAW @ 0xFF0;

    reg {
        name = "MIPI_INT_ST";
        desc = "MIPI_INT_ST at window offset 0xFF4 (vendor header mipi_rx_reg.h, type U_MIPI_INT_ST). Layout PROVEN from the vendor header; access type GUESS (read-only from the name), reset unknown.";
        field {
            name = "int_phycil0_st";
            desc = "Bits [0:0] of MIPI_INT_ST."; sw = r; hw = w;
        } int_phycil0_st[0:0];
        field {
            name = "int_chn0_st";
            desc = "Bits [4:4] of MIPI_INT_ST."; sw = r; hw = w;
        } int_chn0_st[4:4];
    } MIPI_INT_ST @ 0xFF4;

    reg {
        name = "MIPI_INT_MSK";
        desc = "MIPI_INT_MSK at window offset 0xFF8 (vendor header mipi_rx_reg.h, type U_MIPI_INT_MSK). Layout PROVEN from the vendor header; access type GUESS (read-write), reset unknown.";
        field {
            name = "int_phycil0_mask";
            desc = "Bits [0:0] of MIPI_INT_MSK."; sw = rw; hw = r;
        } int_phycil0_mask[0:0];
        field {
            name = "int_chn0_mask";
            desc = "Bits [4:4] of MIPI_INT_MSK."; sw = rw; hw = r;
        } int_chn0_mask[4:4];
    } MIPI_INT_MSK @ 0xFF8;

    reg {
        name = "MIPI_LANES_NUM";
        desc = "MIPI_LANES_NUM at window offset 0x1004 (vendor header mipi_rx_reg.h, type U_MIPI_LANES_NUM). Layout PROVEN from the vendor header; access type GUESS (read-write), reset unknown.";
        field {
            name = "lane_num";
            desc = "Bits [2:0] of MIPI_LANES_NUM."; sw = rw; hw = r;
        } lane_num[2:0];
    } MIPI_LANES_NUM @ 0x1004;

    reg {
        name = "MIPI_MAIN_INT_ST";
        desc = "MIPI_MAIN_INT_ST at window offset 0x100C (vendor header mipi_rx_reg.h, type U_MIPI_MAIN_INT_ST). Layout PROVEN from the vendor header; access type GUESS (read-only from the name), reset unknown.";
        field {
            name = "status_int_pkt_fatal";
            desc = "Bits [1:1] of MIPI_MAIN_INT_ST."; sw = r; hw = w;
        } status_int_pkt_fatal[1:1];
        field {
            name = "status_int_frame_fatal";
            desc = "Bits [2:2] of MIPI_MAIN_INT_ST."; sw = r; hw = w;
        } status_int_frame_fatal[2:2];
        field {
            name = "status_int_pkt";
            desc = "Bits [17:17] of MIPI_MAIN_INT_ST."; sw = r; hw = w;
        } status_int_pkt[17:17];
        field {
            name = "status_int_line";
            desc = "Bits [18:18] of MIPI_MAIN_INT_ST."; sw = r; hw = w;
        } status_int_line[18:18];
    } MIPI_MAIN_INT_ST @ 0x100C;

    reg {
        name = "MIPI_DI_1";
        desc = "MIPI_DI_1 at window offset 0x1010 (vendor header mipi_rx_reg.h, type U_MIPI_DI_1). Layout PROVEN from the vendor header; access type GUESS (read-write), reset unknown.";
        field {
            name = "di0_dt";
            desc = "Bits [5:0] of MIPI_DI_1."; sw = rw; hw = r;
        } di0_dt[5:0];
        field {
            name = "di0_vc";
            desc = "Bits [7:6] of MIPI_DI_1."; sw = rw; hw = r;
        } di0_vc[7:6];
        field {
            name = "di1_dt";
            desc = "Bits [13:8] of MIPI_DI_1."; sw = rw; hw = r;
        } di1_dt[13:8];
        field {
            name = "di1_vc";
            desc = "Bits [15:14] of MIPI_DI_1."; sw = rw; hw = r;
        } di1_vc[15:14];
        field {
            name = "di2_dt";
            desc = "Bits [21:16] of MIPI_DI_1."; sw = rw; hw = r;
        } di2_dt[21:16];
        field {
            name = "di2_vc";
            desc = "Bits [23:22] of MIPI_DI_1."; sw = rw; hw = r;
        } di2_vc[23:22];
        field {
            name = "di3_dt";
            desc = "Bits [29:24] of MIPI_DI_1."; sw = rw; hw = r;
        } di3_dt[29:24];
        field {
            name = "di3_vc";
            desc = "Bits [31:30] of MIPI_DI_1."; sw = rw; hw = r;
        } di3_vc[31:30];
    } MIPI_DI_1 @ 0x1010;

    reg {
        name = "MIPI_DI_2";
        desc = "MIPI_DI_2 at window offset 0x1014 (vendor header mipi_rx_reg.h, type U_MIPI_DI_2). Layout PROVEN from the vendor header; access type GUESS (read-write), reset unknown.";
        field {
            name = "di4_dt";
            desc = "Bits [5:0] of MIPI_DI_2."; sw = rw; hw = r;
        } di4_dt[5:0];
        field {
            name = "di4_vc";
            desc = "Bits [7:6] of MIPI_DI_2."; sw = rw; hw = r;
        } di4_vc[7:6];
        field {
            name = "di5_dt";
            desc = "Bits [13:8] of MIPI_DI_2."; sw = rw; hw = r;
        } di5_dt[13:8];
        field {
            name = "di5_vc";
            desc = "Bits [15:14] of MIPI_DI_2."; sw = rw; hw = r;
        } di5_vc[15:14];
        field {
            name = "di6_dt";
            desc = "Bits [21:16] of MIPI_DI_2."; sw = rw; hw = r;
        } di6_dt[21:16];
        field {
            name = "di6_vc";
            desc = "Bits [23:22] of MIPI_DI_2."; sw = rw; hw = r;
        } di6_vc[23:22];
        field {
            name = "di7_dt";
            desc = "Bits [29:24] of MIPI_DI_2."; sw = rw; hw = r;
        } di7_dt[29:24];
        field {
            name = "di7_vc";
            desc = "Bits [31:30] of MIPI_DI_2."; sw = rw; hw = r;
        } di7_vc[31:30];
    } MIPI_DI_2 @ 0x1014;

    reg {
        name = "MIPI_PKT_INTR_ST";
        desc = "MIPI_PKT_INTR_ST at window offset 0x1060 (vendor header mipi_rx_reg.h, type U_MIPI_PKT_INTR_ST). Layout PROVEN from the vendor header; access type GUESS (read-only from the name), reset unknown.";
        field {
            name = "vc0_err_crc";
            desc = "Bits [0:0] of MIPI_PKT_INTR_ST."; sw = r; hw = w;
        } vc0_err_crc[0:0];
        field {
            name = "vc1_err_crc";
            desc = "Bits [1:1] of MIPI_PKT_INTR_ST."; sw = r; hw = w;
        } vc1_err_crc[1:1];
        field {
            name = "vc2_err_crc";
            desc = "Bits [2:2] of MIPI_PKT_INTR_ST."; sw = r; hw = w;
        } vc2_err_crc[2:2];
        field {
            name = "vc3_err_crc";
            desc = "Bits [3:3] of MIPI_PKT_INTR_ST."; sw = r; hw = w;
        } vc3_err_crc[3:3];
        field {
            name = "err_ecc_double";
            desc = "Bits [16:16] of MIPI_PKT_INTR_ST."; sw = r; hw = w;
        } err_ecc_double[16:16];
    } MIPI_PKT_INTR_ST @ 0x1060;

    reg {
        name = "MIPI_PKT_INTR_MSK";
        desc = "MIPI_PKT_INTR_MSK at window offset 0x1064 (vendor header mipi_rx_reg.h, type U_MIPI_PKT_INTR_MSK). Layout PROVEN from the vendor header; access type GUESS (read-write), reset unknown.";
        field {
            name = "mask_vc0_err_crc";
            desc = "Bits [0:0] of MIPI_PKT_INTR_MSK."; sw = rw; hw = r;
        } mask_vc0_err_crc[0:0];
        field {
            name = "mask_vc1_err_crc";
            desc = "Bits [1:1] of MIPI_PKT_INTR_MSK."; sw = rw; hw = r;
        } mask_vc1_err_crc[1:1];
        field {
            name = "mask_vc2_err_crc";
            desc = "Bits [2:2] of MIPI_PKT_INTR_MSK."; sw = rw; hw = r;
        } mask_vc2_err_crc[2:2];
        field {
            name = "mask_vc3_err_crc";
            desc = "Bits [3:3] of MIPI_PKT_INTR_MSK."; sw = rw; hw = r;
        } mask_vc3_err_crc[3:3];
        field {
            name = "mask_err_ecc_double";
            desc = "Bits [16:16] of MIPI_PKT_INTR_MSK."; sw = rw; hw = r;
        } mask_err_ecc_double[16:16];
    } MIPI_PKT_INTR_MSK @ 0x1064;

    reg {
        name = "MIPI_PKT_INTR_FORCE";
        desc = "MIPI_PKT_INTR_FORCE at window offset 0x1068 (vendor header mipi_rx_reg.h, type U_MIPI_PKT_INTR_FORCE). Layout PROVEN from the vendor header; access type GUESS (read-write), reset unknown.";
        field {
            name = "force_vc0_err_crc";
            desc = "Bits [0:0] of MIPI_PKT_INTR_FORCE."; sw = rw; hw = r;
        } force_vc0_err_crc[0:0];
        field {
            name = "force_vc1_err_crc";
            desc = "Bits [1:1] of MIPI_PKT_INTR_FORCE."; sw = rw; hw = r;
        } force_vc1_err_crc[1:1];
        field {
            name = "force_vc2_err_crc";
            desc = "Bits [2:2] of MIPI_PKT_INTR_FORCE."; sw = rw; hw = r;
        } force_vc2_err_crc[2:2];
        field {
            name = "force_vc3_err_crc";
            desc = "Bits [3:3] of MIPI_PKT_INTR_FORCE."; sw = rw; hw = r;
        } force_vc3_err_crc[3:3];
        field {
            name = "force_err_ecc_double";
            desc = "Bits [16:16] of MIPI_PKT_INTR_FORCE."; sw = rw; hw = r;
        } force_err_ecc_double[16:16];
    } MIPI_PKT_INTR_FORCE @ 0x1068;

    reg {
        name = "MIPI_PKT_INTR2_ST";
        desc = "MIPI_PKT_INTR2_ST at window offset 0x1070 (vendor header mipi_rx_reg.h, type U_MIPI_PKT_INTR2_ST). Layout PROVEN from the vendor header; access type GUESS (read-only from the name), reset unknown.";
        field {
            name = "err_id_vc0";
            desc = "Bits [0:0] of MIPI_PKT_INTR2_ST."; sw = r; hw = w;
        } err_id_vc0[0:0];
        field {
            name = "err_id_vc1";
            desc = "Bits [1:1] of MIPI_PKT_INTR2_ST."; sw = r; hw = w;
        } err_id_vc1[1:1];
        field {
            name = "err_id_vc2";
            desc = "Bits [2:2] of MIPI_PKT_INTR2_ST."; sw = r; hw = w;
        } err_id_vc2[2:2];
        field {
            name = "err_id_vc3";
            desc = "Bits [3:3] of MIPI_PKT_INTR2_ST."; sw = r; hw = w;
        } err_id_vc3[3:3];
        field {
            name = "vc0_err_ecc_corrected";
            desc = "Bits [16:16] of MIPI_PKT_INTR2_ST."; sw = r; hw = w;
        } vc0_err_ecc_corrected[16:16];
        field {
            name = "vc1_err_ecc_corrected";
            desc = "Bits [17:17] of MIPI_PKT_INTR2_ST."; sw = r; hw = w;
        } vc1_err_ecc_corrected[17:17];
        field {
            name = "vc2_err_ecc_corrected";
            desc = "Bits [18:18] of MIPI_PKT_INTR2_ST."; sw = r; hw = w;
        } vc2_err_ecc_corrected[18:18];
        field {
            name = "vc3_err_ecc_corrected";
            desc = "Bits [19:19] of MIPI_PKT_INTR2_ST."; sw = r; hw = w;
        } vc3_err_ecc_corrected[19:19];
    } MIPI_PKT_INTR2_ST @ 0x1070;

    reg {
        name = "MIPI_PKT_INTR2_MSK";
        desc = "MIPI_PKT_INTR2_MSK at window offset 0x1074 (vendor header mipi_rx_reg.h, type U_MIPI_PKT_INTR2_MSK). Layout PROVEN from the vendor header; access type GUESS (read-write), reset unknown.";
        field {
            name = "mask_err_id_vc0";
            desc = "Bits [0:0] of MIPI_PKT_INTR2_MSK."; sw = rw; hw = r;
        } mask_err_id_vc0[0:0];
        field {
            name = "mask_err_id_vc1";
            desc = "Bits [1:1] of MIPI_PKT_INTR2_MSK."; sw = rw; hw = r;
        } mask_err_id_vc1[1:1];
        field {
            name = "mask_err_id_vc2";
            desc = "Bits [2:2] of MIPI_PKT_INTR2_MSK."; sw = rw; hw = r;
        } mask_err_id_vc2[2:2];
        field {
            name = "mask_err_id_vc3";
            desc = "Bits [3:3] of MIPI_PKT_INTR2_MSK."; sw = rw; hw = r;
        } mask_err_id_vc3[3:3];
        field {
            name = "mask_vc0_err_ecc_corrected";
            desc = "Bits [16:16] of MIPI_PKT_INTR2_MSK."; sw = rw; hw = r;
        } mask_vc0_err_ecc_corrected[16:16];
        field {
            name = "mask_vc1_err_ecc_corrected";
            desc = "Bits [17:17] of MIPI_PKT_INTR2_MSK."; sw = rw; hw = r;
        } mask_vc1_err_ecc_corrected[17:17];
        field {
            name = "mask_vc2_err_ecc_corrected";
            desc = "Bits [18:18] of MIPI_PKT_INTR2_MSK."; sw = rw; hw = r;
        } mask_vc2_err_ecc_corrected[18:18];
        field {
            name = "mask_vc3_err_ecc_corrected";
            desc = "Bits [19:19] of MIPI_PKT_INTR2_MSK."; sw = rw; hw = r;
        } mask_vc3_err_ecc_corrected[19:19];
    } MIPI_PKT_INTR2_MSK @ 0x1074;

    reg {
        name = "MIPI_PKT_INTR2_FORCE";
        desc = "MIPI_PKT_INTR2_FORCE at window offset 0x1078 (vendor header mipi_rx_reg.h, type U_MIPI_PKT_INTR2_FORCE). Layout PROVEN from the vendor header; access type GUESS (read-write), reset unknown.";
        field {
            name = "force_err_id_vc0";
            desc = "Bits [0:0] of MIPI_PKT_INTR2_FORCE."; sw = rw; hw = r;
        } force_err_id_vc0[0:0];
        field {
            name = "force_err_id_vc1";
            desc = "Bits [1:1] of MIPI_PKT_INTR2_FORCE."; sw = rw; hw = r;
        } force_err_id_vc1[1:1];
        field {
            name = "force_err_id_vc2";
            desc = "Bits [2:2] of MIPI_PKT_INTR2_FORCE."; sw = rw; hw = r;
        } force_err_id_vc2[2:2];
        field {
            name = "force_err_id_vc3";
            desc = "Bits [3:3] of MIPI_PKT_INTR2_FORCE."; sw = rw; hw = r;
        } force_err_id_vc3[3:3];
        field {
            name = "force_vc0_err_ecc_corrected";
            desc = "Bits [16:16] of MIPI_PKT_INTR2_FORCE."; sw = rw; hw = r;
        } force_vc0_err_ecc_corrected[16:16];
        field {
            name = "force_vc1_err_ecc_corrected";
            desc = "Bits [17:17] of MIPI_PKT_INTR2_FORCE."; sw = rw; hw = r;
        } force_vc1_err_ecc_corrected[17:17];
        field {
            name = "force_vc2_err_ecc_corrected";
            desc = "Bits [18:18] of MIPI_PKT_INTR2_FORCE."; sw = rw; hw = r;
        } force_vc2_err_ecc_corrected[18:18];
        field {
            name = "force_vc3_err_ecc_corrected";
            desc = "Bits [19:19] of MIPI_PKT_INTR2_FORCE."; sw = rw; hw = r;
        } force_vc3_err_ecc_corrected[19:19];
    } MIPI_PKT_INTR2_FORCE @ 0x1078;

    reg {
        name = "MIPI_FRAME_INTR_ST";
        desc = "MIPI_FRAME_INTR_ST at window offset 0x1080 (vendor header mipi_rx_reg.h, type U_MIPI_FRAME_INTR_ST). Layout PROVEN from the vendor header; access type GUESS (read-only from the name), reset unknown.";
        field {
            name = "err_f_bndry_match_vc0";
            desc = "Bits [0:0] of MIPI_FRAME_INTR_ST."; sw = r; hw = w;
        } err_f_bndry_match_vc0[0:0];
        field {
            name = "err_f_bndry_match_vc1";
            desc = "Bits [1:1] of MIPI_FRAME_INTR_ST."; sw = r; hw = w;
        } err_f_bndry_match_vc1[1:1];
        field {
            name = "err_f_bndry_match_vc2";
            desc = "Bits [2:2] of MIPI_FRAME_INTR_ST."; sw = r; hw = w;
        } err_f_bndry_match_vc2[2:2];
        field {
            name = "err_f_bndry_match_vc3";
            desc = "Bits [3:3] of MIPI_FRAME_INTR_ST."; sw = r; hw = w;
        } err_f_bndry_match_vc3[3:3];
        field {
            name = "err_f_seq_vc0";
            desc = "Bits [8:8] of MIPI_FRAME_INTR_ST."; sw = r; hw = w;
        } err_f_seq_vc0[8:8];
        field {
            name = "err_f_seq_vc1";
            desc = "Bits [9:9] of MIPI_FRAME_INTR_ST."; sw = r; hw = w;
        } err_f_seq_vc1[9:9];
        field {
            name = "err_f_seq_vc2";
            desc = "Bits [10:10] of MIPI_FRAME_INTR_ST."; sw = r; hw = w;
        } err_f_seq_vc2[10:10];
        field {
            name = "err_f_seq_vc3";
            desc = "Bits [11:11] of MIPI_FRAME_INTR_ST."; sw = r; hw = w;
        } err_f_seq_vc3[11:11];
        field {
            name = "err_frame_data_vc0";
            desc = "Bits [16:16] of MIPI_FRAME_INTR_ST."; sw = r; hw = w;
        } err_frame_data_vc0[16:16];
        field {
            name = "err_frame_data_vc1";
            desc = "Bits [17:17] of MIPI_FRAME_INTR_ST."; sw = r; hw = w;
        } err_frame_data_vc1[17:17];
        field {
            name = "err_frame_data_vc2";
            desc = "Bits [18:18] of MIPI_FRAME_INTR_ST."; sw = r; hw = w;
        } err_frame_data_vc2[18:18];
        field {
            name = "err_frame_data_vc3";
            desc = "Bits [19:19] of MIPI_FRAME_INTR_ST."; sw = r; hw = w;
        } err_frame_data_vc3[19:19];
    } MIPI_FRAME_INTR_ST @ 0x1080;

    reg {
        name = "MIPI_FRAME_INTR_MSK";
        desc = "MIPI_FRAME_INTR_MSK at window offset 0x1084 (vendor header mipi_rx_reg.h, type U_MIPI_FRAME_INTR_MSK). Layout PROVEN from the vendor header; access type GUESS (read-write), reset unknown.";
        field {
            name = "mask_err_f_bndry_match_vc0";
            desc = "Bits [0:0] of MIPI_FRAME_INTR_MSK."; sw = rw; hw = r;
        } mask_err_f_bndry_match_vc0[0:0];
        field {
            name = "mask_err_f_bndry_match_vc1";
            desc = "Bits [1:1] of MIPI_FRAME_INTR_MSK."; sw = rw; hw = r;
        } mask_err_f_bndry_match_vc1[1:1];
        field {
            name = "mask_err_f_bndry_match_vc2";
            desc = "Bits [2:2] of MIPI_FRAME_INTR_MSK."; sw = rw; hw = r;
        } mask_err_f_bndry_match_vc2[2:2];
        field {
            name = "mask_err_f_bndry_match_vc3";
            desc = "Bits [3:3] of MIPI_FRAME_INTR_MSK."; sw = rw; hw = r;
        } mask_err_f_bndry_match_vc3[3:3];
        field {
            name = "mask_err_f_seq_vc0";
            desc = "Bits [8:8] of MIPI_FRAME_INTR_MSK."; sw = rw; hw = r;
        } mask_err_f_seq_vc0[8:8];
        field {
            name = "mask_err_f_seq_vc1";
            desc = "Bits [9:9] of MIPI_FRAME_INTR_MSK."; sw = rw; hw = r;
        } mask_err_f_seq_vc1[9:9];
        field {
            name = "mask_err_f_seq_vc2";
            desc = "Bits [10:10] of MIPI_FRAME_INTR_MSK."; sw = rw; hw = r;
        } mask_err_f_seq_vc2[10:10];
        field {
            name = "mask_err_f_seq_vc3";
            desc = "Bits [11:11] of MIPI_FRAME_INTR_MSK."; sw = rw; hw = r;
        } mask_err_f_seq_vc3[11:11];
        field {
            name = "mask_err_frame_data_vc0";
            desc = "Bits [16:16] of MIPI_FRAME_INTR_MSK."; sw = rw; hw = r;
        } mask_err_frame_data_vc0[16:16];
        field {
            name = "mask_err_frame_data_vc1";
            desc = "Bits [17:17] of MIPI_FRAME_INTR_MSK."; sw = rw; hw = r;
        } mask_err_frame_data_vc1[17:17];
        field {
            name = "mask_err_frame_data_vc2";
            desc = "Bits [18:18] of MIPI_FRAME_INTR_MSK."; sw = rw; hw = r;
        } mask_err_frame_data_vc2[18:18];
        field {
            name = "mask_err_frame_data_vc3";
            desc = "Bits [19:19] of MIPI_FRAME_INTR_MSK."; sw = rw; hw = r;
        } mask_err_frame_data_vc3[19:19];
    } MIPI_FRAME_INTR_MSK @ 0x1084;

    reg {
        name = "MIPI_FRAME_INTR_FORCE";
        desc = "MIPI_FRAME_INTR_FORCE at window offset 0x1088 (vendor header mipi_rx_reg.h, type U_MIPI_FRAME_INTR_FORCE). Layout PROVEN from the vendor header; access type GUESS (read-write), reset unknown.";
        field {
            name = "force_err_f_bndry_match_vc0";
            desc = "Bits [0:0] of MIPI_FRAME_INTR_FORCE."; sw = rw; hw = r;
        } force_err_f_bndry_match_vc0[0:0];
        field {
            name = "force_err_f_bndry_match_vc1";
            desc = "Bits [1:1] of MIPI_FRAME_INTR_FORCE."; sw = rw; hw = r;
        } force_err_f_bndry_match_vc1[1:1];
        field {
            name = "force_err_f_bndry_match_vc2";
            desc = "Bits [2:2] of MIPI_FRAME_INTR_FORCE."; sw = rw; hw = r;
        } force_err_f_bndry_match_vc2[2:2];
        field {
            name = "force_err_f_bndry_match_vc3";
            desc = "Bits [3:3] of MIPI_FRAME_INTR_FORCE."; sw = rw; hw = r;
        } force_err_f_bndry_match_vc3[3:3];
        field {
            name = "force_err_f_seq_vc0";
            desc = "Bits [8:8] of MIPI_FRAME_INTR_FORCE."; sw = rw; hw = r;
        } force_err_f_seq_vc0[8:8];
        field {
            name = "force_err_f_seq_vc1";
            desc = "Bits [9:9] of MIPI_FRAME_INTR_FORCE."; sw = rw; hw = r;
        } force_err_f_seq_vc1[9:9];
        field {
            name = "force_err_f_seq_vc2";
            desc = "Bits [10:10] of MIPI_FRAME_INTR_FORCE."; sw = rw; hw = r;
        } force_err_f_seq_vc2[10:10];
        field {
            name = "force_err_f_seq_vc3";
            desc = "Bits [11:11] of MIPI_FRAME_INTR_FORCE."; sw = rw; hw = r;
        } force_err_f_seq_vc3[11:11];
        field {
            name = "force_err_frame_data_vc0";
            desc = "Bits [16:16] of MIPI_FRAME_INTR_FORCE."; sw = rw; hw = r;
        } force_err_frame_data_vc0[16:16];
        field {
            name = "force_err_frame_data_vc1";
            desc = "Bits [17:17] of MIPI_FRAME_INTR_FORCE."; sw = rw; hw = r;
        } force_err_frame_data_vc1[17:17];
        field {
            name = "force_err_frame_data_vc2";
            desc = "Bits [18:18] of MIPI_FRAME_INTR_FORCE."; sw = rw; hw = r;
        } force_err_frame_data_vc2[18:18];
        field {
            name = "force_err_frame_data_vc3";
            desc = "Bits [19:19] of MIPI_FRAME_INTR_FORCE."; sw = rw; hw = r;
        } force_err_frame_data_vc3[19:19];
    } MIPI_FRAME_INTR_FORCE @ 0x1088;

    reg {
        name = "MIPI_LINE_INTR_ST";
        desc = "MIPI_LINE_INTR_ST at window offset 0x1090 (vendor header mipi_rx_reg.h, type U_MIPI_LINE_INTR_ST). Layout PROVEN from the vendor header; access type GUESS (read-only from the name), reset unknown.";
        field {
            name = "err_l_bndry_match_di0";
            desc = "Bits [0:0] of MIPI_LINE_INTR_ST."; sw = r; hw = w;
        } err_l_bndry_match_di0[0:0];
        field {
            name = "err_l_bndry_match_di1";
            desc = "Bits [1:1] of MIPI_LINE_INTR_ST."; sw = r; hw = w;
        } err_l_bndry_match_di1[1:1];
        field {
            name = "err_l_bndry_match_di2";
            desc = "Bits [2:2] of MIPI_LINE_INTR_ST."; sw = r; hw = w;
        } err_l_bndry_match_di2[2:2];
        field {
            name = "err_l_bndry_match_di3";
            desc = "Bits [3:3] of MIPI_LINE_INTR_ST."; sw = r; hw = w;
        } err_l_bndry_match_di3[3:3];
        field {
            name = "err_l_bndry_match_di4";
            desc = "Bits [4:4] of MIPI_LINE_INTR_ST."; sw = r; hw = w;
        } err_l_bndry_match_di4[4:4];
        field {
            name = "err_l_bndry_match_di5";
            desc = "Bits [5:5] of MIPI_LINE_INTR_ST."; sw = r; hw = w;
        } err_l_bndry_match_di5[5:5];
        field {
            name = "err_l_bndry_match_di6";
            desc = "Bits [6:6] of MIPI_LINE_INTR_ST."; sw = r; hw = w;
        } err_l_bndry_match_di6[6:6];
        field {
            name = "err_l_bndry_match_di7";
            desc = "Bits [7:7] of MIPI_LINE_INTR_ST."; sw = r; hw = w;
        } err_l_bndry_match_di7[7:7];
        field {
            name = "err_l_seq_di0";
            desc = "Bits [16:16] of MIPI_LINE_INTR_ST."; sw = r; hw = w;
        } err_l_seq_di0[16:16];
        field {
            name = "err_l_seq_di1";
            desc = "Bits [17:17] of MIPI_LINE_INTR_ST."; sw = r; hw = w;
        } err_l_seq_di1[17:17];
        field {
            name = "err_l_seq_di2";
            desc = "Bits [18:18] of MIPI_LINE_INTR_ST."; sw = r; hw = w;
        } err_l_seq_di2[18:18];
        field {
            name = "err_l_seq_di3";
            desc = "Bits [19:19] of MIPI_LINE_INTR_ST."; sw = r; hw = w;
        } err_l_seq_di3[19:19];
        field {
            name = "err_l_seq_di4";
            desc = "Bits [20:20] of MIPI_LINE_INTR_ST."; sw = r; hw = w;
        } err_l_seq_di4[20:20];
        field {
            name = "err_l_seq_di5";
            desc = "Bits [21:21] of MIPI_LINE_INTR_ST."; sw = r; hw = w;
        } err_l_seq_di5[21:21];
        field {
            name = "err_l_seq_di6";
            desc = "Bits [22:22] of MIPI_LINE_INTR_ST."; sw = r; hw = w;
        } err_l_seq_di6[22:22];
        field {
            name = "err_l_seq_di7";
            desc = "Bits [23:23] of MIPI_LINE_INTR_ST."; sw = r; hw = w;
        } err_l_seq_di7[23:23];
    } MIPI_LINE_INTR_ST @ 0x1090;

    reg {
        name = "MIPI_LINE_INTR_MSK";
        desc = "MIPI_LINE_INTR_MSK at window offset 0x1094 (vendor header mipi_rx_reg.h, type U_MIPI_LINE_INTR_MSK). Layout PROVEN from the vendor header; access type GUESS (read-write), reset unknown.";
        field {
            name = "mask_err_l_bndry_match_di0";
            desc = "Bits [0:0] of MIPI_LINE_INTR_MSK."; sw = rw; hw = r;
        } mask_err_l_bndry_match_di0[0:0];
        field {
            name = "mask_err_l_bndry_match_di1";
            desc = "Bits [1:1] of MIPI_LINE_INTR_MSK."; sw = rw; hw = r;
        } mask_err_l_bndry_match_di1[1:1];
        field {
            name = "mask_err_l_bndry_match_di2";
            desc = "Bits [2:2] of MIPI_LINE_INTR_MSK."; sw = rw; hw = r;
        } mask_err_l_bndry_match_di2[2:2];
        field {
            name = "mask_err_l_bndry_match_di3";
            desc = "Bits [3:3] of MIPI_LINE_INTR_MSK."; sw = rw; hw = r;
        } mask_err_l_bndry_match_di3[3:3];
        field {
            name = "mask_err_l_bndry_match_di4";
            desc = "Bits [4:4] of MIPI_LINE_INTR_MSK."; sw = rw; hw = r;
        } mask_err_l_bndry_match_di4[4:4];
        field {
            name = "mask_err_l_bndry_match_di5";
            desc = "Bits [5:5] of MIPI_LINE_INTR_MSK."; sw = rw; hw = r;
        } mask_err_l_bndry_match_di5[5:5];
        field {
            name = "mask_err_l_bndry_match_di6";
            desc = "Bits [6:6] of MIPI_LINE_INTR_MSK."; sw = rw; hw = r;
        } mask_err_l_bndry_match_di6[6:6];
        field {
            name = "mask_err_l_bndry_match_di7";
            desc = "Bits [7:7] of MIPI_LINE_INTR_MSK."; sw = rw; hw = r;
        } mask_err_l_bndry_match_di7[7:7];
        field {
            name = "mask_err_l_seq_di0";
            desc = "Bits [16:16] of MIPI_LINE_INTR_MSK."; sw = rw; hw = r;
        } mask_err_l_seq_di0[16:16];
        field {
            name = "mask_err_l_seq_di1";
            desc = "Bits [17:17] of MIPI_LINE_INTR_MSK."; sw = rw; hw = r;
        } mask_err_l_seq_di1[17:17];
        field {
            name = "mask_err_l_seq_di2";
            desc = "Bits [18:18] of MIPI_LINE_INTR_MSK."; sw = rw; hw = r;
        } mask_err_l_seq_di2[18:18];
        field {
            name = "mask_err_l_seq_di3";
            desc = "Bits [19:19] of MIPI_LINE_INTR_MSK."; sw = rw; hw = r;
        } mask_err_l_seq_di3[19:19];
        field {
            name = "mask_err_l_seq_di4";
            desc = "Bits [20:20] of MIPI_LINE_INTR_MSK."; sw = rw; hw = r;
        } mask_err_l_seq_di4[20:20];
        field {
            name = "mask_err_l_seq_di5";
            desc = "Bits [21:21] of MIPI_LINE_INTR_MSK."; sw = rw; hw = r;
        } mask_err_l_seq_di5[21:21];
        field {
            name = "mask_err_l_seq_di6";
            desc = "Bits [22:22] of MIPI_LINE_INTR_MSK."; sw = rw; hw = r;
        } mask_err_l_seq_di6[22:22];
        field {
            name = "mask_err_l_seq_di7";
            desc = "Bits [23:23] of MIPI_LINE_INTR_MSK."; sw = rw; hw = r;
        } mask_err_l_seq_di7[23:23];
    } MIPI_LINE_INTR_MSK @ 0x1094;

    reg {
        name = "MIPI_LINE_INTR_FORCE";
        desc = "MIPI_LINE_INTR_FORCE at window offset 0x1098 (vendor header mipi_rx_reg.h, type U_MIPI_LINE_INTR_FORCE). Layout PROVEN from the vendor header; access type GUESS (read-write), reset unknown.";
        field {
            name = "force_err_l_bndry_match_di0";
            desc = "Bits [0:0] of MIPI_LINE_INTR_FORCE."; sw = rw; hw = r;
        } force_err_l_bndry_match_di0[0:0];
        field {
            name = "force_err_l_bndry_match_di1";
            desc = "Bits [1:1] of MIPI_LINE_INTR_FORCE."; sw = rw; hw = r;
        } force_err_l_bndry_match_di1[1:1];
        field {
            name = "force_err_l_bndry_match_di2";
            desc = "Bits [2:2] of MIPI_LINE_INTR_FORCE."; sw = rw; hw = r;
        } force_err_l_bndry_match_di2[2:2];
        field {
            name = "force_err_l_bndry_match_di3";
            desc = "Bits [3:3] of MIPI_LINE_INTR_FORCE."; sw = rw; hw = r;
        } force_err_l_bndry_match_di3[3:3];
        field {
            name = "force_err_l_bndry_match_di4";
            desc = "Bits [4:4] of MIPI_LINE_INTR_FORCE."; sw = rw; hw = r;
        } force_err_l_bndry_match_di4[4:4];
        field {
            name = "force_err_l_bndry_match_di5";
            desc = "Bits [5:5] of MIPI_LINE_INTR_FORCE."; sw = rw; hw = r;
        } force_err_l_bndry_match_di5[5:5];
        field {
            name = "force_err_l_bndry_match_di6";
            desc = "Bits [6:6] of MIPI_LINE_INTR_FORCE."; sw = rw; hw = r;
        } force_err_l_bndry_match_di6[6:6];
        field {
            name = "force_err_l_bndry_match_di7";
            desc = "Bits [7:7] of MIPI_LINE_INTR_FORCE."; sw = rw; hw = r;
        } force_err_l_bndry_match_di7[7:7];
        field {
            name = "force_err_l_seq_di0";
            desc = "Bits [16:16] of MIPI_LINE_INTR_FORCE."; sw = rw; hw = r;
        } force_err_l_seq_di0[16:16];
        field {
            name = "force_err_l_seq_di1";
            desc = "Bits [17:17] of MIPI_LINE_INTR_FORCE."; sw = rw; hw = r;
        } force_err_l_seq_di1[17:17];
        field {
            name = "force_err_l_seq_di2";
            desc = "Bits [18:18] of MIPI_LINE_INTR_FORCE."; sw = rw; hw = r;
        } force_err_l_seq_di2[18:18];
        field {
            name = "force_err_l_seq_di3";
            desc = "Bits [19:19] of MIPI_LINE_INTR_FORCE."; sw = rw; hw = r;
        } force_err_l_seq_di3[19:19];
        field {
            name = "force_err_l_seq_di4";
            desc = "Bits [20:20] of MIPI_LINE_INTR_FORCE."; sw = rw; hw = r;
        } force_err_l_seq_di4[20:20];
        field {
            name = "force_err_l_seq_di5";
            desc = "Bits [21:21] of MIPI_LINE_INTR_FORCE."; sw = rw; hw = r;
        } force_err_l_seq_di5[21:21];
        field {
            name = "force_err_l_seq_di6";
            desc = "Bits [22:22] of MIPI_LINE_INTR_FORCE."; sw = rw; hw = r;
        } force_err_l_seq_di6[22:22];
        field {
            name = "force_err_l_seq_di7";
            desc = "Bits [23:23] of MIPI_LINE_INTR_FORCE."; sw = rw; hw = r;
        } force_err_l_seq_di7[23:23];
    } MIPI_LINE_INTR_FORCE @ 0x1098;

    reg {
        name = "MIPI_USERDEF_DT";
        desc = "MIPI_USERDEF_DT at window offset 0x1100 (vendor header mipi_rx_reg.h, type U_MIPI_USERDEF_DT). Layout PROVEN from the vendor header; access type GUESS (read-write), reset unknown.";
        field {
            name = "user_def0_dt";
            desc = "Bits [2:0] of MIPI_USERDEF_DT."; sw = rw; hw = r;
        } user_def0_dt[2:0];
        field {
            name = "user_def1_dt";
            desc = "Bits [6:4] of MIPI_USERDEF_DT."; sw = rw; hw = r;
        } user_def1_dt[6:4];
        field {
            name = "user_def2_dt";
            desc = "Bits [10:8] of MIPI_USERDEF_DT."; sw = rw; hw = r;
        } user_def2_dt[10:8];
        field {
            name = "user_def3_dt";
            desc = "Bits [14:12] of MIPI_USERDEF_DT."; sw = rw; hw = r;
        } user_def3_dt[14:12];
    } MIPI_USERDEF_DT @ 0x1100;

    reg {
        name = "MIPI_USER_DEF";
        desc = "MIPI_USER_DEF at window offset 0x1104 (vendor header mipi_rx_reg.h, type U_MIPI_USER_DEF). Layout PROVEN from the vendor header; access type GUESS (read-write), reset unknown.";
        field {
            name = "user_def0";
            desc = "Bits [5:0] of MIPI_USER_DEF."; sw = rw; hw = r;
        } user_def0[5:0];
        field {
            name = "user_def1";
            desc = "Bits [13:8] of MIPI_USER_DEF."; sw = rw; hw = r;
        } user_def1[13:8];
        field {
            name = "user_def2";
            desc = "Bits [21:16] of MIPI_USER_DEF."; sw = rw; hw = r;
        } user_def2[21:16];
        field {
            name = "user_def3";
            desc = "Bits [29:24] of MIPI_USER_DEF."; sw = rw; hw = r;
        } user_def3[29:24];
    } MIPI_USER_DEF @ 0x1104;

    reg {
        name = "MIPI_CTRL_MODE_HS";
        desc = "MIPI_CTRL_MODE_HS at window offset 0x1108 (vendor header mipi_rx_reg.h, type U_MIPI_CTRL_MODE_HS). Layout PROVEN from the vendor header; access type GUESS (read-write), reset unknown.";
        field {
            name = "hdr_mode";
            desc = "Bits [0:0] of MIPI_CTRL_MODE_HS."; sw = rw; hw = r;
        } hdr_mode[0:0];
        field {
            name = "vc_mode";
            desc = "Bits [4:4] of MIPI_CTRL_MODE_HS."; sw = rw; hw = r;
        } vc_mode[4:4];
        field {
            name = "user_def_en";
            desc = "Bits [8:8] of MIPI_CTRL_MODE_HS."; sw = rw; hw = r;
        } user_def_en[8:8];
        field {
            name = "lane0_location";
            desc = "Bits [14:12] of MIPI_CTRL_MODE_HS."; sw = rw; hw = r;
        } lane0_location[14:12];
    } MIPI_CTRL_MODE_HS @ 0x1108;

    reg {
        name = "MIPI_VHEND_DELAY";
        desc = "MIPI_VHEND_DELAY at window offset 0x110C (vendor header mipi_rx_reg.h, type U_MIPI_VHEND_DELAY). Layout PROVEN from the vendor header; access type GUESS (read-write), reset unknown.";
        field {
            name = "vend_delay";
            desc = "Bits [11:0] of MIPI_VHEND_DELAY."; sw = rw; hw = r;
        } vend_delay[11:0];
        field {
            name = "hend_delay";
            desc = "Bits [23:16] of MIPI_VHEND_DELAY."; sw = rw; hw = r;
        } hend_delay[23:16];
    } MIPI_VHEND_DELAY @ 0x110C;

    reg {
        name = "MIPI_DOL_ID_CODE0";
        desc = "MIPI_DOL_ID_CODE0 at window offset 0x1200 (vendor header mipi_rx_reg.h, type U_MIPI_DOL_ID_CODE0). Layout PROVEN from the vendor header; access type GUESS (read-write), reset unknown.";
        field {
            name = "id_code_reg0";
            desc = "Bits [15:0] of MIPI_DOL_ID_CODE0."; sw = rw; hw = r;
        } id_code_reg0[15:0];
        field {
            name = "id_code_reg1";
            desc = "Bits [31:16] of MIPI_DOL_ID_CODE0."; sw = rw; hw = r;
        } id_code_reg1[31:16];
    } MIPI_DOL_ID_CODE0 @ 0x1200;

    reg {
        name = "MIPI_DOL_ID_CODE1";
        desc = "MIPI_DOL_ID_CODE1 at window offset 0x1204 (vendor header mipi_rx_reg.h, type U_MIPI_DOL_ID_CODE1). Layout PROVEN from the vendor header; access type GUESS (read-write), reset unknown.";
        field {
            name = "id_code_reg2";
            desc = "Bits [15:0] of MIPI_DOL_ID_CODE1."; sw = rw; hw = r;
        } id_code_reg2[15:0];
        field {
            name = "id_code_reg3";
            desc = "Bits [31:16] of MIPI_DOL_ID_CODE1."; sw = rw; hw = r;
        } id_code_reg3[31:16];
    } MIPI_DOL_ID_CODE1 @ 0x1204;

    reg {
        name = "MIPI_DOL_ID_CODE2";
        desc = "MIPI_DOL_ID_CODE2 at window offset 0x1208 (vendor header mipi_rx_reg.h, type U_MIPI_DOL_ID_CODE2). Layout PROVEN from the vendor header; access type GUESS (read-write), reset unknown.";
        field {
            name = "id_code_reg4";
            desc = "Bits [15:0] of MIPI_DOL_ID_CODE2."; sw = rw; hw = r;
        } id_code_reg4[15:0];
        field {
            name = "id_code_reg5";
            desc = "Bits [31:16] of MIPI_DOL_ID_CODE2."; sw = rw; hw = r;
        } id_code_reg5[31:16];
    } MIPI_DOL_ID_CODE2 @ 0x1208;

    reg {
        name = "MIPI_CROP_START_CHN0";
        desc = "MIPI_CROP_START_CHN0 at window offset 0x1210 (vendor header mipi_rx_reg.h, type U_MIPI_CROP_START_CHN0). Layout PROVEN from the vendor header; access type GUESS (read-write), reset unknown.";
        field {
            name = "mipi_start_x_chn0";
            desc = "Bits [15:0] of MIPI_CROP_START_CHN0."; sw = rw; hw = r;
        } mipi_start_x_chn0[15:0];
        field {
            name = "mipi_start_y_chn0";
            desc = "Bits [31:16] of MIPI_CROP_START_CHN0."; sw = rw; hw = r;
        } mipi_start_y_chn0[31:16];
    } MIPI_CROP_START_CHN0 @ 0x1210;

    reg {
        name = "MIPI_CROP_START_CHN1";
        desc = "MIPI_CROP_START_CHN1 at window offset 0x1214 (vendor header mipi_rx_reg.h, type U_MIPI_CROP_START_CHN1). Layout PROVEN from the vendor header; access type GUESS (read-write), reset unknown.";
        field {
            name = "mipi_start_x_chn1";
            desc = "Bits [15:0] of MIPI_CROP_START_CHN1."; sw = rw; hw = r;
        } mipi_start_x_chn1[15:0];
        field {
            name = "mipi_start_y_chn1";
            desc = "Bits [31:16] of MIPI_CROP_START_CHN1."; sw = rw; hw = r;
        } mipi_start_y_chn1[31:16];
    } MIPI_CROP_START_CHN1 @ 0x1214;

    reg {
        name = "MIPI_IMGSIZE";
        desc = "MIPI_IMGSIZE at window offset 0x1224 (vendor header mipi_rx_reg.h, type U_MIPI_IMGSIZE). Layout PROVEN from the vendor header; access type GUESS (read-write), reset unknown.";
        field {
            name = "mipi_imgwidth";
            desc = "Bits [15:0] of MIPI_IMGSIZE."; sw = rw; hw = r;
        } mipi_imgwidth[15:0];
        field {
            name = "mipi_imgheight";
            desc = "Bits [31:16] of MIPI_IMGSIZE."; sw = rw; hw = r;
        } mipi_imgheight[31:16];
    } MIPI_IMGSIZE @ 0x1224;

    reg {
        name = "MIPI_CTRL_MODE_PIXEL";
        desc = "MIPI_CTRL_MODE_PIXEL at window offset 0x1230 (vendor header mipi_rx_reg.h, type U_MIPI_CTRL_MODE_PIXEL). Layout PROVEN from the vendor header; access type GUESS (read-write), reset unknown.";
        field {
            name = "crop_en";
            desc = "Bits [0:0] of MIPI_CTRL_MODE_PIXEL."; sw = rw; hw = r;
        } crop_en[0:0];
        field {
            name = "mipi_dol_mode";
            desc = "Bits [4:4] of MIPI_CTRL_MODE_PIXEL."; sw = rw; hw = r;
        } mipi_dol_mode[4:4];
        field {
            name = "rx2mode";
            desc = "Bits [8:8] of MIPI_CTRL_MODE_PIXEL."; sw = rw; hw = r;
        } rx2mode[8:8];
        field {
            name = "data_merge_mode";
            desc = "Bits [10:9] of MIPI_CTRL_MODE_PIXEL."; sw = rw; hw = r;
        } data_merge_mode[10:9];
        field {
            name = "sync_clear_en";
            desc = "Bits [11:11] of MIPI_CTRL_MODE_PIXEL."; sw = rw; hw = r;
        } sync_clear_en[11:11];
        field {
            name = "stagger_hdr_mode";
            desc = "Bits [12:12] of MIPI_CTRL_MODE_PIXEL."; sw = rw; hw = r;
        } stagger_hdr_mode[12:12];
        field {
            name = "stagger_frm_num";
            desc = "Bits [14:13] of MIPI_CTRL_MODE_PIXEL."; sw = rw; hw = r;
        } stagger_frm_num[14:13];
        field {
            name = "dummy_line_detect";
            desc = "Bits [15:15] of MIPI_CTRL_MODE_PIXEL."; sw = rw; hw = r;
        } dummy_line_detect[15:15];
        field {
            name = "mipi_double_pix_en";
            desc = "Bits [16:16] of MIPI_CTRL_MODE_PIXEL."; sw = rw; hw = r;
        } mipi_double_pix_en[16:16];
        field {
            name = "mipi_double_yuv_en";
            desc = "Bits [17:17] of MIPI_CTRL_MODE_PIXEL."; sw = rw; hw = r;
        } mipi_double_yuv_en[17:17];
        field {
            name = "mipi_yuv_422_en";
            desc = "Bits [18:18] of MIPI_CTRL_MODE_PIXEL."; sw = rw; hw = r;
        } mipi_yuv_422_en[18:18];
        field {
            name = "mipi_yuv_420_nolegacy_en";
            desc = "Bits [19:19] of MIPI_CTRL_MODE_PIXEL."; sw = rw; hw = r;
        } mipi_yuv_420_nolegacy_en[19:19];
        field {
            name = "mipi_yuv_420_legacy_en";
            desc = "Bits [20:20] of MIPI_CTRL_MODE_PIXEL."; sw = rw; hw = r;
        } mipi_yuv_420_legacy_en[20:20];
        field {
            name = "mipi_yuv_420_nolegacy_init";
            desc = "Bits [21:21] of MIPI_CTRL_MODE_PIXEL."; sw = rw; hw = r;
        } mipi_yuv_420_nolegacy_init[21:21];
        field {
            name = "mipi_yuv420_even_detect";
            desc = "Bits [22:22] of MIPI_CTRL_MODE_PIXEL."; sw = rw; hw = r;
        } mipi_yuv420_even_detect[22:22];
    } MIPI_CTRL_MODE_PIXEL @ 0x1230;

    reg {
        name = "MIPI_DUMMY_PIX_REG";
        desc = "MIPI_DUMMY_PIX_REG at window offset 0x1240 (vendor header mipi_rx_reg.h, type U_MIPI_DUMMY_PIX_REG). Layout PROVEN from the vendor header; access type GUESS (read-write), reset unknown.";
        field {
            name = "dummy_pix_reg";
            desc = "Bits [15:0] of MIPI_DUMMY_PIX_REG."; sw = rw; hw = r;
        } dummy_pix_reg[15:0];
    } MIPI_DUMMY_PIX_REG @ 0x1240;

    reg {
        name = "MIPI_IMGSIZE0_STATIS";
        desc = "MIPI_IMGSIZE0_STATIS at window offset 0x1250 (vendor header mipi_rx_reg.h, type U_MIPI_IMGSIZE0_STATIS). Layout PROVEN from the vendor header; access type GUESS (read-only from the name), reset unknown.";
        field {
            name = "imgwidth_statis_vc0";
            desc = "Bits [15:0] of MIPI_IMGSIZE0_STATIS."; sw = r; hw = w;
        } imgwidth_statis_vc0[15:0];
        field {
            name = "imgheight_statis_vc0";
            desc = "Bits [31:16] of MIPI_IMGSIZE0_STATIS."; sw = r; hw = w;
        } imgheight_statis_vc0[31:16];
    } MIPI_IMGSIZE0_STATIS @ 0x1250;

    reg {
        name = "MIPI_IMGSIZE1_STATIS";
        desc = "MIPI_IMGSIZE1_STATIS at window offset 0x1254 (vendor header mipi_rx_reg.h, type U_MIPI_IMGSIZE1_STATIS). Layout PROVEN from the vendor header; access type GUESS (read-only from the name), reset unknown.";
        field {
            name = "imgwidth_statis_vc1";
            desc = "Bits [15:0] of MIPI_IMGSIZE1_STATIS."; sw = r; hw = w;
        } imgwidth_statis_vc1[15:0];
        field {
            name = "imgheight_statis_vc1";
            desc = "Bits [31:16] of MIPI_IMGSIZE1_STATIS."; sw = r; hw = w;
        } imgheight_statis_vc1[31:16];
    } MIPI_IMGSIZE1_STATIS @ 0x1254;

    reg {
        name = "MIPI_CTRL_INT_RAW";
        desc = "MIPI_CTRL_INT_RAW at window offset 0x12F0 (vendor header mipi_rx_reg.h, type U_MIPI_CTRL_INT_RAW). Layout PROVEN from the vendor header; access type GUESS (read-only from the name), reset unknown.";
        field {
            name = "int_cfifo_wrerr_raw";
            desc = "Bits [0:0] of MIPI_CTRL_INT_RAW."; sw = r; hw = w;
        } int_cfifo_wrerr_raw[0:0];
        field {
            name = "int_dfifo_wrerr_raw";
            desc = "Bits [1:1] of MIPI_CTRL_INT_RAW."; sw = r; hw = w;
        } int_dfifo_wrerr_raw[1:1];
        field {
            name = "int_vsync_raw";
            desc = "Bits [4:4] of MIPI_CTRL_INT_RAW."; sw = r; hw = w;
        } int_vsync_raw[4:4];
        field {
            name = "int_cfifo_rderr_raw";
            desc = "Bits [16:16] of MIPI_CTRL_INT_RAW."; sw = r; hw = w;
        } int_cfifo_rderr_raw[16:16];
        field {
            name = "int_dfifo_rderr_raw";
            desc = "Bits [17:17] of MIPI_CTRL_INT_RAW."; sw = r; hw = w;
        } int_dfifo_rderr_raw[17:17];
    } MIPI_CTRL_INT_RAW @ 0x12F0;

    reg {
        name = "MIPI_CTRL_INT";
        desc = "MIPI_CTRL_INT at window offset 0x12F4 (vendor header mipi_rx_reg.h, type U_MIPI_CTRL_INT). Layout PROVEN from the vendor header; access type GUESS (read-only from the name), reset unknown.";
        field {
            name = "int_cfifo_wrerr_st";
            desc = "Bits [0:0] of MIPI_CTRL_INT."; sw = r; hw = w;
        } int_cfifo_wrerr_st[0:0];
        field {
            name = "int_dfifo_wrerr_st";
            desc = "Bits [1:1] of MIPI_CTRL_INT."; sw = r; hw = w;
        } int_dfifo_wrerr_st[1:1];
        field {
            name = "int_vsync_st";
            desc = "Bits [4:4] of MIPI_CTRL_INT."; sw = r; hw = w;
        } int_vsync_st[4:4];
        field {
            name = "int_cfifo_rderr_st";
            desc = "Bits [16:16] of MIPI_CTRL_INT."; sw = r; hw = w;
        } int_cfifo_rderr_st[16:16];
        field {
            name = "int_dfifo_rderr_st";
            desc = "Bits [17:17] of MIPI_CTRL_INT."; sw = r; hw = w;
        } int_dfifo_rderr_st[17:17];
    } MIPI_CTRL_INT @ 0x12F4;

    reg {
        name = "MIPI_CTRL_INT_MSK";
        desc = "MIPI_CTRL_INT_MSK at window offset 0x12F8 (vendor header mipi_rx_reg.h, type U_MIPI_CTRL_INT_MSK). Layout PROVEN from the vendor header; access type GUESS (read-write), reset unknown.";
        field {
            name = "int_cfifo_wrerr_msk";
            desc = "Bits [0:0] of MIPI_CTRL_INT_MSK."; sw = rw; hw = r;
        } int_cfifo_wrerr_msk[0:0];
        field {
            name = "int_dfifo_wrerr_msk";
            desc = "Bits [1:1] of MIPI_CTRL_INT_MSK."; sw = rw; hw = r;
        } int_dfifo_wrerr_msk[1:1];
        field {
            name = "int_vsync_msk";
            desc = "Bits [4:4] of MIPI_CTRL_INT_MSK."; sw = rw; hw = r;
        } int_vsync_msk[4:4];
        field {
            name = "int_cfifo_rderr_msk";
            desc = "Bits [16:16] of MIPI_CTRL_INT_MSK."; sw = rw; hw = r;
        } int_cfifo_rderr_msk[16:16];
        field {
            name = "int_dfifo_rderr_msk";
            desc = "Bits [17:17] of MIPI_CTRL_INT_MSK."; sw = rw; hw = r;
        } int_dfifo_rderr_msk[17:17];
    } MIPI_CTRL_INT_MSK @ 0x12F8;

    reg {
        name = "LVDS_WDR";
        desc = "LVDS_WDR at window offset 0x1300 (vendor header mipi_rx_reg.h, type U_LVDS_WDR). Layout PROVEN from the vendor header; access type GUESS (read-write), reset unknown.";
        field {
            name = "lvds_wdr_en";
            desc = "Bits [0:0] of LVDS_WDR."; sw = rw; hw = r;
        } lvds_wdr_en[0:0];
        field {
            name = "lvds_wdr_num";
            desc = "Bits [5:4] of LVDS_WDR."; sw = rw; hw = r;
        } lvds_wdr_num[5:4];
        field {
            name = "lvds_wdr_mode";
            desc = "Bits [11:8] of LVDS_WDR."; sw = rw; hw = r;
        } lvds_wdr_mode[11:8];
        field {
            name = "lvds_wdr_id_shift";
            desc = "Bits [15:12] of LVDS_WDR."; sw = rw; hw = r;
        } lvds_wdr_id_shift[15:12];
    } LVDS_WDR @ 0x1300;

    reg {
        name = "LVDS_DOLSCD_HBLK";
        desc = "LVDS_DOLSCD_HBLK at window offset 0x1304 (vendor header mipi_rx_reg.h, type U_LVDS_DOLSCD_HBLK). Layout PROVEN from the vendor header; access type GUESS (read-write), reset unknown.";
        field {
            name = "dol_hblank1";
            desc = "Bits [15:0] of LVDS_DOLSCD_HBLK."; sw = rw; hw = r;
        } dol_hblank1[15:0];
        field {
            name = "dol_hblank2";
            desc = "Bits [31:16] of LVDS_DOLSCD_HBLK."; sw = rw; hw = r;
        } dol_hblank2[31:16];
    } LVDS_DOLSCD_HBLK @ 0x1304;

    reg {
        name = "LVDS_CTRL";
        desc = "LVDS_CTRL at window offset 0x1308 (vendor header mipi_rx_reg.h, type U_LVDS_CTRL). Layout PROVEN from the vendor header; access type GUESS (read-write), reset unknown.";
        field {
            name = "lvds_sync_mode";
            desc = "Bits [0:0] of LVDS_CTRL."; sw = rw; hw = r;
        } lvds_sync_mode[0:0];
        field {
            name = "lvds_raw_type";
            desc = "Bits [6:4] of LVDS_CTRL."; sw = rw; hw = r;
        } lvds_raw_type[6:4];
        field {
            name = "lvds_pix_big_endian";
            desc = "Bits [8:8] of LVDS_CTRL."; sw = rw; hw = r;
        } lvds_pix_big_endian[8:8];
        field {
            name = "lvds_code_big_endian";
            desc = "Bits [9:9] of LVDS_CTRL."; sw = rw; hw = r;
        } lvds_code_big_endian[9:9];
        field {
            name = "lvds_crop_en";
            desc = "Bits [12:12] of LVDS_CTRL."; sw = rw; hw = r;
        } lvds_crop_en[12:12];
    } LVDS_CTRL @ 0x1308;

    reg {
        name = "LVDS_IMGSIZE";
        desc = "LVDS_IMGSIZE at window offset 0x130C (vendor header mipi_rx_reg.h, type U_LVDS_IMGSIZE). Layout PROVEN from the vendor header; access type GUESS (read-write), reset unknown.";
        field {
            name = "lvds_imgwidth_lane";
            desc = "Bits [15:0] of LVDS_IMGSIZE."; sw = rw; hw = r;
        } lvds_imgwidth_lane[15:0];
        field {
            name = "lvds_imgheight";
            desc = "Bits [31:16] of LVDS_IMGSIZE."; sw = rw; hw = r;
        } lvds_imgheight[31:16];
    } LVDS_IMGSIZE @ 0x130C;

    reg {
        name = "LVDS_CROP_START0";
        desc = "LVDS_CROP_START0 at window offset 0x1310 (vendor header mipi_rx_reg.h, type U_LVDS_CROP_START0). Layout PROVEN from the vendor header; access type GUESS (read-write), reset unknown.";
        field {
            name = "lvds_start_x0_lane";
            desc = "Bits [15:0] of LVDS_CROP_START0."; sw = rw; hw = r;
        } lvds_start_x0_lane[15:0];
        field {
            name = "lvds_start_y0";
            desc = "Bits [31:16] of LVDS_CROP_START0."; sw = rw; hw = r;
        } lvds_start_y0[31:16];
    } LVDS_CROP_START0 @ 0x1310;

    reg {
        name = "LVDS_CROP_START1";
        desc = "LVDS_CROP_START1 at window offset 0x1314 (vendor header mipi_rx_reg.h, type U_LVDS_CROP_START1). Layout PROVEN from the vendor header; access type GUESS (read-write), reset unknown.";
        field {
            name = "lvds_start_x1_lane";
            desc = "Bits [15:0] of LVDS_CROP_START1."; sw = rw; hw = r;
        } lvds_start_x1_lane[15:0];
        field {
            name = "lvds_start_y1";
            desc = "Bits [31:16] of LVDS_CROP_START1."; sw = rw; hw = r;
        } lvds_start_y1[31:16];
    } LVDS_CROP_START1 @ 0x1314;

    reg {
        name = "LVDS_LI_WORD0";
        desc = "LVDS_LI_WORD0 at window offset 0x1720 (vendor header mipi_rx_reg.h, type U_LVDS_LI_WORD0). Layout PROVEN from the vendor header; access type GUESS (read-write), reset unknown.";
        field {
            name = "li_word0_0";
            desc = "Bits [15:0] of LVDS_LI_WORD0."; sw = rw; hw = r;
        } li_word0_0[15:0];
        field {
            name = "li_word0_1";
            desc = "Bits [31:16] of LVDS_LI_WORD0."; sw = rw; hw = r;
        } li_word0_1[31:16];
    } LVDS_LI_WORD0 @ 0x1720;

    reg {
        name = "LVDS_LI_WORD1";
        desc = "LVDS_LI_WORD1 at window offset 0x1724 (vendor header mipi_rx_reg.h, type U_LVDS_LI_WORD1). Layout PROVEN from the vendor header; access type GUESS (read-write), reset unknown.";
        field {
            name = "li_word1_0";
            desc = "Bits [15:0] of LVDS_LI_WORD1."; sw = rw; hw = r;
        } li_word1_0[15:0];
        field {
            name = "li_word1_1";
            desc = "Bits [31:16] of LVDS_LI_WORD1."; sw = rw; hw = r;
        } li_word1_1[31:16];
    } LVDS_LI_WORD1 @ 0x1724;

    reg {
        name = "LVDS_SYNC_BORD0";
        desc = "LVDS_SYNC_BORD0 at window offset 0x1730 (vendor header mipi_rx_reg.h, type U_LVDS_SYNC_BORD0). Layout PROVEN from the vendor header; access type GUESS (read-write), reset unknown.";
        field {
            name = "sync_bord0_lane0";
            desc = "Bits [3:0] of LVDS_SYNC_BORD0."; sw = rw; hw = r;
        } sync_bord0_lane0[3:0];
        field {
            name = "sync_bord0_lane1";
            desc = "Bits [7:4] of LVDS_SYNC_BORD0."; sw = rw; hw = r;
        } sync_bord0_lane1[7:4];
        field {
            name = "sync_bord0_lane2";
            desc = "Bits [11:8] of LVDS_SYNC_BORD0."; sw = rw; hw = r;
        } sync_bord0_lane2[11:8];
        field {
            name = "sync_bord0_lane3";
            desc = "Bits [15:12] of LVDS_SYNC_BORD0."; sw = rw; hw = r;
        } sync_bord0_lane3[15:12];
    } LVDS_SYNC_BORD0 @ 0x1730;

    reg {
        name = "LVDS_LANE_IMGSIZE_STATIS";
        desc = "LVDS_LANE_IMGSIZE_STATIS at window offset 0x1740 (vendor header mipi_rx_reg.h, type U_LVDS_LANE_IMGSIZE_STATIS). Layout PROVEN from the vendor header; access type GUESS (read-only from the name), reset unknown.";
        field {
            name = "lane_imgwidth";
            desc = "Bits [15:0] of LVDS_LANE_IMGSIZE_STATIS."; sw = r; hw = w;
        } lane_imgwidth[15:0];
        field {
            name = "lane_imgheight";
            desc = "Bits [31:16] of LVDS_LANE_IMGSIZE_STATIS."; sw = r; hw = w;
        } lane_imgheight[31:16];
    } LVDS_LANE_IMGSIZE_STATIS[4] @ 0x1740 += 0x4;

    reg {
        name = "LVDS_IMGSIZE0_STATIS";
        desc = "LVDS_IMGSIZE0_STATIS at window offset 0x1780 (vendor header mipi_rx_reg.h, type U_LVDS_IMGSIZE0_STATIS). Layout PROVEN from the vendor header; access type GUESS (read-only from the name), reset unknown.";
        field {
            name = "lvds_imgwidth0";
            desc = "Bits [15:0] of LVDS_IMGSIZE0_STATIS."; sw = r; hw = w;
        } lvds_imgwidth0[15:0];
        field {
            name = "lvds_imgheight0";
            desc = "Bits [31:16] of LVDS_IMGSIZE0_STATIS."; sw = r; hw = w;
        } lvds_imgheight0[31:16];
    } LVDS_IMGSIZE0_STATIS @ 0x1780;

    reg {
        name = "LVDS_IMGSIZE1_STATIS";
        desc = "LVDS_IMGSIZE1_STATIS at window offset 0x1784 (vendor header mipi_rx_reg.h, type U_LVDS_IMGSIZE1_STATIS). Layout PROVEN from the vendor header; access type GUESS (read-only from the name), reset unknown.";
        field {
            name = "lvds_imgwidth1";
            desc = "Bits [15:0] of LVDS_IMGSIZE1_STATIS."; sw = r; hw = w;
        } lvds_imgwidth1[15:0];
        field {
            name = "lvds_imgheight1";
            desc = "Bits [31:16] of LVDS_IMGSIZE1_STATIS."; sw = r; hw = w;
        } lvds_imgheight1[31:16];
    } LVDS_IMGSIZE1_STATIS @ 0x1784;

    reg {
        name = "LVDS_LANE_ORDERS0";
        desc = "LVDS_LANE_ORDERS0 at window offset 0x1790 (vendor header mipi_rx_reg.h, type U_LVDS_LANE_ORDERS0). Layout PROVEN from the vendor header; access type GUESS (read-write), reset unknown.";
        field {
            name = "lvds_lane0_id";
            desc = "Bits [3:0] of LVDS_LANE_ORDERS0."; sw = rw; hw = r;
        } lvds_lane0_id[3:0];
        field {
            name = "lvds_lane1_id";
            desc = "Bits [7:4] of LVDS_LANE_ORDERS0."; sw = rw; hw = r;
        } lvds_lane1_id[7:4];
        field {
            name = "lvds_lane2_id";
            desc = "Bits [11:8] of LVDS_LANE_ORDERS0."; sw = rw; hw = r;
        } lvds_lane2_id[11:8];
        field {
            name = "lvds_lane3_id";
            desc = "Bits [15:12] of LVDS_LANE_ORDERS0."; sw = rw; hw = r;
        } lvds_lane3_id[15:12];
    } LVDS_LANE_ORDERS0 @ 0x1790;

    reg {
        name = "LVDS_CTRL_INT_RAW";
        desc = "LVDS_CTRL_INT_RAW at window offset 0x17F0 (vendor header mipi_rx_reg.h, type U_LVDS_CTRL_INT_RAW). Layout PROVEN from the vendor header; access type GUESS (read-only from the name), reset unknown.";
        field {
            name = "lane0_sync_err_raw";
            desc = "Bits [0:0] of LVDS_CTRL_INT_RAW."; sw = r; hw = w;
        } lane0_sync_err_raw[0:0];
        field {
            name = "lane1_sync_err_raw";
            desc = "Bits [1:1] of LVDS_CTRL_INT_RAW."; sw = r; hw = w;
        } lane1_sync_err_raw[1:1];
        field {
            name = "lane2_sync_err_raw";
            desc = "Bits [2:2] of LVDS_CTRL_INT_RAW."; sw = r; hw = w;
        } lane2_sync_err_raw[2:2];
        field {
            name = "lane3_sync_err_raw";
            desc = "Bits [3:3] of LVDS_CTRL_INT_RAW."; sw = r; hw = w;
        } lane3_sync_err_raw[3:3];
        field {
            name = "link0_wr_err_raw";
            desc = "Bits [16:16] of LVDS_CTRL_INT_RAW."; sw = r; hw = w;
        } link0_wr_err_raw[16:16];
        field {
            name = "link0_rd_err_raw";
            desc = "Bits [20:20] of LVDS_CTRL_INT_RAW."; sw = r; hw = w;
        } link0_rd_err_raw[20:20];
        field {
            name = "lvds_state_err_raw";
            desc = "Bits [24:24] of LVDS_CTRL_INT_RAW."; sw = r; hw = w;
        } lvds_state_err_raw[24:24];
        field {
            name = "pop_err_raw";
            desc = "Bits [25:25] of LVDS_CTRL_INT_RAW."; sw = r; hw = w;
        } pop_err_raw[25:25];
        field {
            name = "cmd_wr_err_raw";
            desc = "Bits [26:26] of LVDS_CTRL_INT_RAW."; sw = r; hw = w;
        } cmd_wr_err_raw[26:26];
        field {
            name = "cmd_rd_err_raw";
            desc = "Bits [27:27] of LVDS_CTRL_INT_RAW."; sw = r; hw = w;
        } cmd_rd_err_raw[27:27];
        field {
            name = "lvds_vsync_raw";
            desc = "Bits [28:28] of LVDS_CTRL_INT_RAW."; sw = r; hw = w;
        } lvds_vsync_raw[28:28];
    } LVDS_CTRL_INT_RAW @ 0x17F0;

    reg {
        name = "LVDS_CTRL_INT";
        desc = "LVDS_CTRL_INT at window offset 0x17F4 (vendor header mipi_rx_reg.h, type U_LVDS_CTRL_INT). Layout PROVEN from the vendor header; access type GUESS (read-only from the name), reset unknown.";
        field {
            name = "lane0_sync_err_st";
            desc = "Bits [0:0] of LVDS_CTRL_INT."; sw = r; hw = w;
        } lane0_sync_err_st[0:0];
        field {
            name = "lane1_sync_err_st";
            desc = "Bits [1:1] of LVDS_CTRL_INT."; sw = r; hw = w;
        } lane1_sync_err_st[1:1];
        field {
            name = "lane2_sync_err_st";
            desc = "Bits [2:2] of LVDS_CTRL_INT."; sw = r; hw = w;
        } lane2_sync_err_st[2:2];
        field {
            name = "lane3_sync_err_st";
            desc = "Bits [3:3] of LVDS_CTRL_INT."; sw = r; hw = w;
        } lane3_sync_err_st[3:3];
        field {
            name = "link0_wr_err_st";
            desc = "Bits [16:16] of LVDS_CTRL_INT."; sw = r; hw = w;
        } link0_wr_err_st[16:16];
        field {
            name = "link0_rd_err_st";
            desc = "Bits [20:20] of LVDS_CTRL_INT."; sw = r; hw = w;
        } link0_rd_err_st[20:20];
        field {
            name = "lvds_state_err_st";
            desc = "Bits [24:24] of LVDS_CTRL_INT."; sw = r; hw = w;
        } lvds_state_err_st[24:24];
        field {
            name = "pop_err_st";
            desc = "Bits [25:25] of LVDS_CTRL_INT."; sw = r; hw = w;
        } pop_err_st[25:25];
        field {
            name = "cmd_wr_err_st";
            desc = "Bits [26:26] of LVDS_CTRL_INT."; sw = r; hw = w;
        } cmd_wr_err_st[26:26];
        field {
            name = "cmd_rd_err_st";
            desc = "Bits [27:27] of LVDS_CTRL_INT."; sw = r; hw = w;
        } cmd_rd_err_st[27:27];
        field {
            name = "lvds_vsync_st";
            desc = "Bits [28:28] of LVDS_CTRL_INT."; sw = r; hw = w;
        } lvds_vsync_st[28:28];
    } LVDS_CTRL_INT @ 0x17F4;

    reg {
        name = "LVDS_CTRL_INT_MSK";
        desc = "LVDS_CTRL_INT_MSK at window offset 0x17F8 (vendor header mipi_rx_reg.h, type U_LVDS_CTRL_INT_MSK). Layout PROVEN from the vendor header; access type GUESS (read-write), reset unknown.";
        field {
            name = "lane0_sync_err_msk";
            desc = "Bits [0:0] of LVDS_CTRL_INT_MSK."; sw = rw; hw = r;
        } lane0_sync_err_msk[0:0];
        field {
            name = "lane1_sync_err_msk";
            desc = "Bits [1:1] of LVDS_CTRL_INT_MSK."; sw = rw; hw = r;
        } lane1_sync_err_msk[1:1];
        field {
            name = "lane2_sync_err_msk";
            desc = "Bits [2:2] of LVDS_CTRL_INT_MSK."; sw = rw; hw = r;
        } lane2_sync_err_msk[2:2];
        field {
            name = "lane3_sync_err_msk";
            desc = "Bits [3:3] of LVDS_CTRL_INT_MSK."; sw = rw; hw = r;
        } lane3_sync_err_msk[3:3];
        field {
            name = "link0_wr_err_msk";
            desc = "Bits [16:16] of LVDS_CTRL_INT_MSK."; sw = rw; hw = r;
        } link0_wr_err_msk[16:16];
        field {
            name = "link0_rd_err_msk";
            desc = "Bits [20:20] of LVDS_CTRL_INT_MSK."; sw = rw; hw = r;
        } link0_rd_err_msk[20:20];
        field {
            name = "lvds_state_err_msk";
            desc = "Bits [24:24] of LVDS_CTRL_INT_MSK."; sw = rw; hw = r;
        } lvds_state_err_msk[24:24];
        field {
            name = "pop_err_msk";
            desc = "Bits [25:25] of LVDS_CTRL_INT_MSK."; sw = rw; hw = r;
        } pop_err_msk[25:25];
        field {
            name = "cmd_wr_err_msk";
            desc = "Bits [26:26] of LVDS_CTRL_INT_MSK."; sw = rw; hw = r;
        } cmd_wr_err_msk[26:26];
        field {
            name = "cmd_rd_err_msk";
            desc = "Bits [27:27] of LVDS_CTRL_INT_MSK."; sw = rw; hw = r;
        } cmd_rd_err_msk[27:27];
        field {
            name = "lvds_vsync_msk";
            desc = "Bits [28:28] of LVDS_CTRL_INT_MSK."; sw = rw; hw = r;
        } lvds_vsync_msk[28:28];
    } LVDS_CTRL_INT_MSK @ 0x17F8;

    reg {
        name = "LANE_ID0_CHN0";
        desc = "LANE_ID0_CHN0 at window offset 0x1800 (vendor header mipi_rx_reg.h, type U_LANE_ID0_CHN). Layout PROVEN from the vendor header; access type GUESS (read-write), reset unknown.";
        field {
            name = "lane0_id";
            desc = "Bits [3:0] of LANE_ID0_CHN0."; sw = rw; hw = r;
        } lane0_id[3:0];
        field {
            name = "lane1_id";
            desc = "Bits [7:4] of LANE_ID0_CHN0."; sw = rw; hw = r;
        } lane1_id[7:4];
        field {
            name = "lane2_id";
            desc = "Bits [11:8] of LANE_ID0_CHN0."; sw = rw; hw = r;
        } lane2_id[11:8];
        field {
            name = "lane3_id";
            desc = "Bits [15:12] of LANE_ID0_CHN0."; sw = rw; hw = r;
        } lane3_id[15:12];
    } LANE_ID0_CHN0 @ 0x1800;

    reg {
        name = "ALIGN_INT_RAW";
        desc = "ALIGN_INT_RAW at window offset 0x18F0 (vendor header mipi_rx_reg.h, type U_ALIGN_INT_RAW). Layout PROVEN from the vendor header; access type GUESS (read-only from the name), reset unknown.";
        field {
            name = "err_full_raw";
            desc = "Bits [0:0] of ALIGN_INT_RAW."; sw = r; hw = w;
        } err_full_raw[0:0];
        field {
            name = "err_lane0_raw";
            desc = "Bits [1:1] of ALIGN_INT_RAW."; sw = r; hw = w;
        } err_lane0_raw[1:1];
        field {
            name = "err_lane1_raw";
            desc = "Bits [2:2] of ALIGN_INT_RAW."; sw = r; hw = w;
        } err_lane1_raw[2:2];
        field {
            name = "err_lane2_raw";
            desc = "Bits [3:3] of ALIGN_INT_RAW."; sw = r; hw = w;
        } err_lane2_raw[3:3];
        field {
            name = "err_lane3_raw";
            desc = "Bits [4:4] of ALIGN_INT_RAW."; sw = r; hw = w;
        } err_lane3_raw[4:4];
    } ALIGN_INT_RAW @ 0x18F0;

    reg {
        name = "ALIGN_INT";
        desc = "ALIGN_INT at window offset 0x18F4 (vendor header mipi_rx_reg.h, type U_ALIGN_INT). Layout PROVEN from the vendor header; access type GUESS (read-only from the name), reset unknown.";
        field {
            name = "err_full_st";
            desc = "Bits [0:0] of ALIGN_INT."; sw = r; hw = w;
        } err_full_st[0:0];
        field {
            name = "err_lane0_st";
            desc = "Bits [1:1] of ALIGN_INT."; sw = r; hw = w;
        } err_lane0_st[1:1];
        field {
            name = "err_lane1_st";
            desc = "Bits [2:2] of ALIGN_INT."; sw = r; hw = w;
        } err_lane1_st[2:2];
        field {
            name = "err_lane2_st";
            desc = "Bits [3:3] of ALIGN_INT."; sw = r; hw = w;
        } err_lane2_st[3:3];
        field {
            name = "err_lane3_st";
            desc = "Bits [4:4] of ALIGN_INT."; sw = r; hw = w;
        } err_lane3_st[4:4];
    } ALIGN_INT @ 0x18F4;

    reg {
        name = "ALIGN_INT_MSK";
        desc = "ALIGN_INT_MSK at window offset 0x18F8 (vendor header mipi_rx_reg.h, type U_ALIGN_INT_MSK). Layout PROVEN from the vendor header; access type GUESS (read-write), reset unknown.";
        field {
            name = "err_full_mask";
            desc = "Bits [0:0] of ALIGN_INT_MSK."; sw = rw; hw = r;
        } err_full_mask[0:0];
        field {
            name = "err_lane0_mask";
            desc = "Bits [1:1] of ALIGN_INT_MSK."; sw = rw; hw = r;
        } err_lane0_mask[1:1];
        field {
            name = "err_lane1_mask";
            desc = "Bits [2:2] of ALIGN_INT_MSK."; sw = rw; hw = r;
        } err_lane1_mask[2:2];
        field {
            name = "err_lane2_mask";
            desc = "Bits [3:3] of ALIGN_INT_MSK."; sw = rw; hw = r;
        } err_lane2_mask[3:3];
        field {
            name = "err_lane3_mask";
            desc = "Bits [4:4] of ALIGN_INT_MSK."; sw = rw; hw = r;
        } err_lane3_mask[4:4];
    } ALIGN_INT_MSK @ 0x18F8;

    reg {
        name = "CHN_INT_RAW";
        desc = "CHN_INT_RAW at window offset 0x1FF0 (vendor header mipi_rx_reg.h, type U_CHN_INT_RAW). Layout PROVEN from the vendor header; access type GUESS (read-only from the name), reset unknown.";
        field {
            name = "int_lvds_ctrl_raw";
            desc = "Bits [0:0] of CHN_INT_RAW."; sw = r; hw = w;
        } int_lvds_ctrl_raw[0:0];
        field {
            name = "int_mipi_csi_raw";
            desc = "Bits [1:1] of CHN_INT_RAW."; sw = r; hw = w;
        } int_mipi_csi_raw[1:1];
        field {
            name = "int_mipi_ctrl_raw";
            desc = "Bits [2:2] of CHN_INT_RAW."; sw = r; hw = w;
        } int_mipi_ctrl_raw[2:2];
        field {
            name = "int_data_align_raw";
            desc = "Bits [3:3] of CHN_INT_RAW."; sw = r; hw = w;
        } int_data_align_raw[3:3];
    } CHN_INT_RAW @ 0x1FF0;

    reg {
        name = "CHN_INT";
        desc = "CHN_INT at window offset 0x1FF4 (vendor header mipi_rx_reg.h, type U_CHN_INT). Layout PROVEN from the vendor header; access type GUESS (read-only from the name), reset unknown.";
        field {
            name = "int_lvds_ctrl_st";
            desc = "Bits [0:0] of CHN_INT."; sw = r; hw = w;
        } int_lvds_ctrl_st[0:0];
        field {
            name = "int_mipi_csi_st";
            desc = "Bits [1:1] of CHN_INT."; sw = r; hw = w;
        } int_mipi_csi_st[1:1];
        field {
            name = "int_mipi_ctrl_st";
            desc = "Bits [2:2] of CHN_INT."; sw = r; hw = w;
        } int_mipi_ctrl_st[2:2];
        field {
            name = "int_data_align_st";
            desc = "Bits [3:3] of CHN_INT."; sw = r; hw = w;
        } int_data_align_st[3:3];
    } CHN_INT @ 0x1FF4;

    reg {
        name = "CHN_INT_MASK";
        desc = "CHN_INT_MASK at window offset 0x1FF8 (vendor header mipi_rx_reg.h, type U_CHN_INT_MASK). Layout PROVEN from the vendor header; access type GUESS (read-write), reset unknown.";
        field {
            name = "int_lvds_ctrl_mask";
            desc = "Bits [0:0] of CHN_INT_MASK."; sw = rw; hw = r;
        } int_lvds_ctrl_mask[0:0];
        field {
            name = "int_mipi_csi_mask";
            desc = "Bits [1:1] of CHN_INT_MASK."; sw = rw; hw = r;
        } int_mipi_csi_mask[1:1];
        field {
            name = "int_mipi_ctrl_mask";
            desc = "Bits [2:2] of CHN_INT_MASK."; sw = rw; hw = r;
        } int_mipi_ctrl_mask[2:2];
        field {
            name = "int_data_align_mask";
            desc = "Bits [3:3] of CHN_INT_MASK."; sw = rw; hw = r;
        } int_data_align_mask[3:3];
    } CHN_INT_MASK @ 0x1FF8;

    regfile {
        name = "LVDS this-frame sync codes";
        desc = "16 sync-code entries of 0x20 bytes (vendor struct lvds_sync_code_cfg_t, mipi_rx_reg.h): SOF at +0, EOF at +8, SOL at +0x10, EOL at +0x18. Layout PROVEN from the vendor header; access/reset GUESS.";
        reg {
            name = "LVDS this-frame sync code SOF";
            desc = "Sync code SOF (lanes 0/1 as in the vendor union U_LVDS_LANE_SOF_01)."; 
            field { name = "lane_sof_0"; desc = "Bits [15:0]."; sw = rw; hw = r; } lane_sof_0[15:0];
            field { name = "lane_sof_1"; desc = "Bits [31:16]."; sw = rw; hw = r; } lane_sof_1[31:16];
        } SOF @ 0x0;
        reg {
            name = "LVDS this-frame sync code EOF";
            desc = "Sync code EOF (lanes 0/1 as in the vendor union U_LVDS_LANE_EOF_01)."; 
            field { name = "lane_eof_0"; desc = "Bits [15:0]."; sw = rw; hw = r; } lane_eof_0[15:0];
            field { name = "lane_eof_1"; desc = "Bits [31:16]."; sw = rw; hw = r; } lane_eof_1[31:16];
        } EOF @ 0x8;
        reg {
            name = "LVDS this-frame sync code SOL";
            desc = "Sync code SOL (lanes 0/1 as in the vendor union U_LVDS_LANE_SOL_01)."; 
            field { name = "lane_sol_0"; desc = "Bits [15:0]."; sw = rw; hw = r; } lane_sol_0[15:0];
            field { name = "lane_sol_1"; desc = "Bits [31:16]."; sw = rw; hw = r; } lane_sol_1[31:16];
        } SOL @ 0x10;
        reg {
            name = "LVDS this-frame sync code EOL";
            desc = "Sync code EOL (lanes 0/1 as in the vendor union U_LVDS_LANE_EOL_01)."; 
            field { name = "lane_eol_0"; desc = "Bits [15:0]."; sw = rw; hw = r; } lane_eol_0[15:0];
            field { name = "lane_eol_1"; desc = "Bits [31:16]."; sw = rw; hw = r; } lane_eol_1[31:16];
        } EOL @ 0x18;
    } LVDS_THIS_FRAME_SYNC[16] @ 0x1320 += 0x20;

    regfile {
        name = "LVDS next-frame sync codes";
        desc = "16 sync-code entries of 0x20 bytes (vendor struct lvds_sync_code_cfg_t, mipi_rx_reg.h): SOF at +0, EOF at +8, SOL at +0x10, EOL at +0x18. Layout PROVEN from the vendor header; access/reset GUESS.";
        reg {
            name = "LVDS next-frame sync code SOF";
            desc = "Sync code SOF (lanes 0/1 as in the vendor union U_LVDS_LANE_SOF_01)."; 
            field { name = "lane_sof_0"; desc = "Bits [15:0]."; sw = rw; hw = r; } lane_sof_0[15:0];
            field { name = "lane_sof_1"; desc = "Bits [31:16]."; sw = rw; hw = r; } lane_sof_1[31:16];
        } SOF @ 0x0;
        reg {
            name = "LVDS next-frame sync code EOF";
            desc = "Sync code EOF (lanes 0/1 as in the vendor union U_LVDS_LANE_EOF_01)."; 
            field { name = "lane_eof_0"; desc = "Bits [15:0]."; sw = rw; hw = r; } lane_eof_0[15:0];
            field { name = "lane_eof_1"; desc = "Bits [31:16]."; sw = rw; hw = r; } lane_eof_1[31:16];
        } EOF @ 0x8;
        reg {
            name = "LVDS next-frame sync code SOL";
            desc = "Sync code SOL (lanes 0/1 as in the vendor union U_LVDS_LANE_SOL_01)."; 
            field { name = "lane_sol_0"; desc = "Bits [15:0]."; sw = rw; hw = r; } lane_sol_0[15:0];
            field { name = "lane_sol_1"; desc = "Bits [31:16]."; sw = rw; hw = r; } lane_sol_1[31:16];
        } SOL @ 0x10;
        reg {
            name = "LVDS next-frame sync code EOL";
            desc = "Sync code EOL (lanes 0/1 as in the vendor union U_LVDS_LANE_EOL_01)."; 
            field { name = "lane_eol_0"; desc = "Bits [15:0]."; sw = rw; hw = r; } lane_eol_0[15:0];
            field { name = "lane_eol_1"; desc = "Bits [31:16]."; sw = rw; hw = r; } lane_eol_1[31:16];
        } EOL @ 0x18;
    } LVDS_NEXT_FRAME_SYNC[16] @ 0x1520 += 0x20;

};
`endif