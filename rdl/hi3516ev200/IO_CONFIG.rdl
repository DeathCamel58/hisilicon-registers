`ifndef HI3516EV200_IO_CONFIG_RDL
`define HI3516EV200_IO_CONFIG_RDL

`ifndef HI3516EV200_EIO_CONFIG_AHB_RDL
`define HI3516EV200_EIO_CONFIG_AHB_RDL

regfile eIO_CONFIG_AHB {
    name = "IO configuration (pin mux + pad control), AHB/peripheral pads (SFC, eMMC/SDIO, USB, IR, SPI1), Hi3516E V200";
    desc = "Base 0x100C0000. One 32-bit register per pad: [3:0] function select, [8]/[9] pull-up/pull-down, [10] slew, [7:4] drive strength (cijliu-uboot hisi_hi3516ev200.c IO_CFG_* macros); pad names for the VIO block are INFERRED from the function written by the vendor sys_config.ko (GPIO numbers and data sheet pin names are not available), so only pads some vendor code touches are listed. Confidence legend (no hardware was read for this block): PROVEN = offset and bits are used by vendor source code or by the vendor boot binary (Xiongmai stock U-Boot of a Hi3516E V200 camera) exactly as described; INFERRED = deduced from naming, from sibling chips or from a value without a bit map; GUESS = plausible only.";

    reg {
        name = "IR_IN pad: IR receive input pad";
        desc = "PAD_08 - IR_IN pad: IR receive input pad. Confidence **INFERRED**. Evidence: openhisilicon sys_config ir_mux(): 0x1D02 selects IR_IN (0 = GPIO0_0, 1 = UPDATE_MODE, 2 = IR_IN). Hardware not read; reset values unknown.";
        field { name = "func"; desc = "Pin function select (value 0 = GPIO/primary function; the vendor writes 1, 2, 3 or 7 for the alternates, see the evidence). [INFERRED]"; sw = rw; hw = r; } func[3:0];
        field { name = "pull_up"; desc = "Pull-up enable (IO_CFG_PULL_UP = BIT(8) in cijliu-uboot). [INFERRED]"; sw = rw; hw = r; } pull_up[8:8];
        field { name = "pull_down"; desc = "Pull-down enable (IO_CFG_PULL_DOWN = BIT(9)). [INFERRED]"; sw = rw; hw = r; } pull_down[9:9];
        field { name = "slew"; desc = "Slew-rate select (IO_CFG_SR = BIT(10)). [INFERRED]"; sw = rw; hw = r; } slew[10:10];
        field { name = "drive"; desc = "Drive strength (IO_CFG_DRV_STR_SEL, [7:4]); vendor values 0x1..0x7. [INFERRED]"; sw = rw; hw = r; } drive[7:4];
        field { name = "hi_cfg"; desc = "Bits 11/12: Schmitt/input-enable style bits; vendor mux writes (0x1000 / 0x1C00 / 0x1D00 / 0x1A00) always set bit 12. [GUESS]"; sw = rw; hw = r; } hi_cfg[12:11];
    } PAD_08 @ 0x8;

    reg {
        name = "SFC_CLK / EMMC_CLK pad: SFC clock (eMMC clock when booting from eMMC)";
        desc = "PAD_14 - SFC_CLK / EMMC_CLK pad: SFC clock (eMMC clock when booting from eMMC). Confidence **PROVEN**. Evidence: cijliu-uboot hifmc_hi3516ev200.c writes 0x401 (sfc_clk); hisi_hi3516ev200.c REG_CTRL_EMMC_CLK = 0x14. Hardware not read; reset values unknown.";
        field { name = "func"; desc = "Pin function select (value 0 = GPIO/primary function; the vendor writes 1, 2, 3 or 7 for the alternates, see the evidence). [PROVEN]"; sw = rw; hw = r; } func[3:0];
        field { name = "pull_up"; desc = "Pull-up enable (IO_CFG_PULL_UP = BIT(8) in cijliu-uboot). [INFERRED]"; sw = rw; hw = r; } pull_up[8:8];
        field { name = "pull_down"; desc = "Pull-down enable (IO_CFG_PULL_DOWN = BIT(9)). [INFERRED]"; sw = rw; hw = r; } pull_down[9:9];
        field { name = "slew"; desc = "Slew-rate select (IO_CFG_SR = BIT(10)). [INFERRED]"; sw = rw; hw = r; } slew[10:10];
        field { name = "drive"; desc = "Drive strength (IO_CFG_DRV_STR_SEL, [7:4]); vendor values 0x1..0x7. [INFERRED]"; sw = rw; hw = r; } drive[7:4];
        field { name = "hi_cfg"; desc = "Bits 11/12: Schmitt/input-enable style bits; vendor mux writes (0x1000 / 0x1C00 / 0x1D00 / 0x1A00) always set bit 12. [GUESS]"; sw = rw; hw = r; } hi_cfg[12:11];
    } PAD_14 @ 0x14;

    reg {
        name = "SFC_HOLD_IO0 / EMMC_CMD pad: SFC hold/IO0 (eMMC CMD)";
        desc = "PAD_18 - SFC_HOLD_IO0 / EMMC_CMD pad: SFC hold/IO0 (eMMC CMD). Confidence **PROVEN**. Evidence: hifmc_hi3516ev200.c 0x461; REG_CTRL_EMMC_CMD = 0x18. Hardware not read; reset values unknown.";
        field { name = "func"; desc = "Pin function select (value 0 = GPIO/primary function; the vendor writes 1, 2, 3 or 7 for the alternates, see the evidence). [PROVEN]"; sw = rw; hw = r; } func[3:0];
        field { name = "pull_up"; desc = "Pull-up enable (IO_CFG_PULL_UP = BIT(8) in cijliu-uboot). [INFERRED]"; sw = rw; hw = r; } pull_up[8:8];
        field { name = "pull_down"; desc = "Pull-down enable (IO_CFG_PULL_DOWN = BIT(9)). [INFERRED]"; sw = rw; hw = r; } pull_down[9:9];
        field { name = "slew"; desc = "Slew-rate select (IO_CFG_SR = BIT(10)). [INFERRED]"; sw = rw; hw = r; } slew[10:10];
        field { name = "drive"; desc = "Drive strength (IO_CFG_DRV_STR_SEL, [7:4]); vendor values 0x1..0x7. [INFERRED]"; sw = rw; hw = r; } drive[7:4];
        field { name = "hi_cfg"; desc = "Bits 11/12: Schmitt/input-enable style bits; vendor mux writes (0x1000 / 0x1C00 / 0x1D00 / 0x1A00) always set bit 12. [GUESS]"; sw = rw; hw = r; } hi_cfg[12:11];
    } PAD_18 @ 0x18;

    reg {
        name = "SFC_MISO_IO1 / EMMC_DATA0 pad: SFC MISO/IO1 (eMMC D0)";
        desc = "PAD_1C - SFC_MISO_IO1 / EMMC_DATA0 pad: SFC MISO/IO1 (eMMC D0). Confidence **PROVEN**. Evidence: hifmc_hi3516ev200.c 0x461; REG_CTRL_EMMC_DATA0 = 0x1C. Hardware not read; reset values unknown.";
        field { name = "func"; desc = "Pin function select (value 0 = GPIO/primary function; the vendor writes 1, 2, 3 or 7 for the alternates, see the evidence). [PROVEN]"; sw = rw; hw = r; } func[3:0];
        field { name = "pull_up"; desc = "Pull-up enable (IO_CFG_PULL_UP = BIT(8) in cijliu-uboot). [INFERRED]"; sw = rw; hw = r; } pull_up[8:8];
        field { name = "pull_down"; desc = "Pull-down enable (IO_CFG_PULL_DOWN = BIT(9)). [INFERRED]"; sw = rw; hw = r; } pull_down[9:9];
        field { name = "slew"; desc = "Slew-rate select (IO_CFG_SR = BIT(10)). [INFERRED]"; sw = rw; hw = r; } slew[10:10];
        field { name = "drive"; desc = "Drive strength (IO_CFG_DRV_STR_SEL, [7:4]); vendor values 0x1..0x7. [INFERRED]"; sw = rw; hw = r; } drive[7:4];
        field { name = "hi_cfg"; desc = "Bits 11/12: Schmitt/input-enable style bits; vendor mux writes (0x1000 / 0x1C00 / 0x1D00 / 0x1A00) always set bit 12. [GUESS]"; sw = rw; hw = r; } hi_cfg[12:11];
    } PAD_1C @ 0x1C;

    reg {
        name = "SFC_WP_IO2 / EMMC_DATA3 pad: SFC WP/IO2 (eMMC D3)";
        desc = "PAD_20 - SFC_WP_IO2 / EMMC_DATA3 pad: SFC WP/IO2 (eMMC D3). Confidence **PROVEN**. Evidence: hifmc_hi3516ev200.c 0x461; REG_CTRL_EMMC_DATA3 = 0x20. Hardware not read; reset values unknown.";
        field { name = "func"; desc = "Pin function select (value 0 = GPIO/primary function; the vendor writes 1, 2, 3 or 7 for the alternates, see the evidence). [PROVEN]"; sw = rw; hw = r; } func[3:0];
        field { name = "pull_up"; desc = "Pull-up enable (IO_CFG_PULL_UP = BIT(8) in cijliu-uboot). [INFERRED]"; sw = rw; hw = r; } pull_up[8:8];
        field { name = "pull_down"; desc = "Pull-down enable (IO_CFG_PULL_DOWN = BIT(9)). [INFERRED]"; sw = rw; hw = r; } pull_down[9:9];
        field { name = "slew"; desc = "Slew-rate select (IO_CFG_SR = BIT(10)). [INFERRED]"; sw = rw; hw = r; } slew[10:10];
        field { name = "drive"; desc = "Drive strength (IO_CFG_DRV_STR_SEL, [7:4]); vendor values 0x1..0x7. [INFERRED]"; sw = rw; hw = r; } drive[7:4];
        field { name = "hi_cfg"; desc = "Bits 11/12: Schmitt/input-enable style bits; vendor mux writes (0x1000 / 0x1C00 / 0x1D00 / 0x1A00) always set bit 12. [GUESS]"; sw = rw; hw = r; } hi_cfg[12:11];
    } PAD_20 @ 0x20;

    reg {
        name = "SFC_MOSI_IO3 / EMMC_DATA2 pad: SFC MOSI/IO3 (eMMC D2)";
        desc = "PAD_24 - SFC_MOSI_IO3 / EMMC_DATA2 pad: SFC MOSI/IO3 (eMMC D2). Confidence **PROVEN**. Evidence: hifmc_hi3516ev200.c 0x461; REG_CTRL_EMMC_DATA2 = 0x24. Hardware not read; reset values unknown.";
        field { name = "func"; desc = "Pin function select (value 0 = GPIO/primary function; the vendor writes 1, 2, 3 or 7 for the alternates, see the evidence). [PROVEN]"; sw = rw; hw = r; } func[3:0];
        field { name = "pull_up"; desc = "Pull-up enable (IO_CFG_PULL_UP = BIT(8) in cijliu-uboot). [INFERRED]"; sw = rw; hw = r; } pull_up[8:8];
        field { name = "pull_down"; desc = "Pull-down enable (IO_CFG_PULL_DOWN = BIT(9)). [INFERRED]"; sw = rw; hw = r; } pull_down[9:9];
        field { name = "slew"; desc = "Slew-rate select (IO_CFG_SR = BIT(10)). [INFERRED]"; sw = rw; hw = r; } slew[10:10];
        field { name = "drive"; desc = "Drive strength (IO_CFG_DRV_STR_SEL, [7:4]); vendor values 0x1..0x7. [INFERRED]"; sw = rw; hw = r; } drive[7:4];
        field { name = "hi_cfg"; desc = "Bits 11/12: Schmitt/input-enable style bits; vendor mux writes (0x1000 / 0x1C00 / 0x1D00 / 0x1A00) always set bit 12. [GUESS]"; sw = rw; hw = r; } hi_cfg[12:11];
    } PAD_24 @ 0x24;

    reg {
        name = "SFC_CSN / EMMC_DATA1 pad: SFC chip select (eMMC D1)";
        desc = "PAD_28 - SFC_CSN / EMMC_DATA1 pad: SFC chip select (eMMC D1). Confidence **PROVEN**. Evidence: hifmc_hi3516ev200.c 0x461; REG_CTRL_EMMC_DATA1 = 0x28. Hardware not read; reset values unknown.";
        field { name = "func"; desc = "Pin function select (value 0 = GPIO/primary function; the vendor writes 1, 2, 3 or 7 for the alternates, see the evidence). [PROVEN]"; sw = rw; hw = r; } func[3:0];
        field { name = "pull_up"; desc = "Pull-up enable (IO_CFG_PULL_UP = BIT(8) in cijliu-uboot). [INFERRED]"; sw = rw; hw = r; } pull_up[8:8];
        field { name = "pull_down"; desc = "Pull-down enable (IO_CFG_PULL_DOWN = BIT(9)). [INFERRED]"; sw = rw; hw = r; } pull_down[9:9];
        field { name = "slew"; desc = "Slew-rate select (IO_CFG_SR = BIT(10)). [INFERRED]"; sw = rw; hw = r; } slew[10:10];
        field { name = "drive"; desc = "Drive strength (IO_CFG_DRV_STR_SEL, [7:4]); vendor values 0x1..0x7. [INFERRED]"; sw = rw; hw = r; } drive[7:4];
        field { name = "hi_cfg"; desc = "Bits 11/12: Schmitt/input-enable style bits; vendor mux writes (0x1000 / 0x1C00 / 0x1D00 / 0x1A00) always set bit 12. [GUESS]"; sw = rw; hw = r; } hi_cfg[12:11];
    } PAD_28 @ 0x28;

    reg {
        name = "SDIO0_CLK pad: SDIO0 clock";
        desc = "PAD_40 - SDIO0_CLK pad: SDIO0 clock. Confidence **PROVEN**. Evidence: hisi_hi3516ev200.c REG_CTRL_SDIO0_CLK = 0x40; vendor boot table 0x451. Hardware not read; reset values unknown.";
        field { name = "func"; desc = "Pin function select (value 0 = GPIO/primary function; the vendor writes 1, 2, 3 or 7 for the alternates, see the evidence). [PROVEN]"; sw = rw; hw = r; } func[3:0];
        field { name = "pull_up"; desc = "Pull-up enable (IO_CFG_PULL_UP = BIT(8) in cijliu-uboot). [INFERRED]"; sw = rw; hw = r; } pull_up[8:8];
        field { name = "pull_down"; desc = "Pull-down enable (IO_CFG_PULL_DOWN = BIT(9)). [INFERRED]"; sw = rw; hw = r; } pull_down[9:9];
        field { name = "slew"; desc = "Slew-rate select (IO_CFG_SR = BIT(10)). [INFERRED]"; sw = rw; hw = r; } slew[10:10];
        field { name = "drive"; desc = "Drive strength (IO_CFG_DRV_STR_SEL, [7:4]); vendor values 0x1..0x7. [INFERRED]"; sw = rw; hw = r; } drive[7:4];
        field { name = "hi_cfg"; desc = "Bits 11/12: Schmitt/input-enable style bits; vendor mux writes (0x1000 / 0x1C00 / 0x1D00 / 0x1A00) always set bit 12. [GUESS]"; sw = rw; hw = r; } hi_cfg[12:11];
    } PAD_40 @ 0x40;

    reg {
        name = "SDIO0_CMD pad: SDIO0 command";
        desc = "PAD_44 - SDIO0_CMD pad: SDIO0 command. Confidence **PROVEN**. Evidence: hisi_hi3516ev200.c REG_CTRL_SDIO0_CMD = 0x44; boot table 0x571. Hardware not read; reset values unknown.";
        field { name = "func"; desc = "Pin function select (value 0 = GPIO/primary function; the vendor writes 1, 2, 3 or 7 for the alternates, see the evidence). [PROVEN]"; sw = rw; hw = r; } func[3:0];
        field { name = "pull_up"; desc = "Pull-up enable (IO_CFG_PULL_UP = BIT(8) in cijliu-uboot). [INFERRED]"; sw = rw; hw = r; } pull_up[8:8];
        field { name = "pull_down"; desc = "Pull-down enable (IO_CFG_PULL_DOWN = BIT(9)). [INFERRED]"; sw = rw; hw = r; } pull_down[9:9];
        field { name = "slew"; desc = "Slew-rate select (IO_CFG_SR = BIT(10)). [INFERRED]"; sw = rw; hw = r; } slew[10:10];
        field { name = "drive"; desc = "Drive strength (IO_CFG_DRV_STR_SEL, [7:4]); vendor values 0x1..0x7. [INFERRED]"; sw = rw; hw = r; } drive[7:4];
        field { name = "hi_cfg"; desc = "Bits 11/12: Schmitt/input-enable style bits; vendor mux writes (0x1000 / 0x1C00 / 0x1D00 / 0x1A00) always set bit 12. [GUESS]"; sw = rw; hw = r; } hi_cfg[12:11];
    } PAD_44 @ 0x44;

    reg {
        name = "SDIO0_D0 pad: SDIO0 data 0";
        desc = "PAD_48 - SDIO0_D0 pad: SDIO0 data 0. Confidence **PROVEN**. Evidence: hisi_hi3516ev200.c = 0x48; boot table 0x571. Hardware not read; reset values unknown.";
        field { name = "func"; desc = "Pin function select (value 0 = GPIO/primary function; the vendor writes 1, 2, 3 or 7 for the alternates, see the evidence). [PROVEN]"; sw = rw; hw = r; } func[3:0];
        field { name = "pull_up"; desc = "Pull-up enable (IO_CFG_PULL_UP = BIT(8) in cijliu-uboot). [INFERRED]"; sw = rw; hw = r; } pull_up[8:8];
        field { name = "pull_down"; desc = "Pull-down enable (IO_CFG_PULL_DOWN = BIT(9)). [INFERRED]"; sw = rw; hw = r; } pull_down[9:9];
        field { name = "slew"; desc = "Slew-rate select (IO_CFG_SR = BIT(10)). [INFERRED]"; sw = rw; hw = r; } slew[10:10];
        field { name = "drive"; desc = "Drive strength (IO_CFG_DRV_STR_SEL, [7:4]); vendor values 0x1..0x7. [INFERRED]"; sw = rw; hw = r; } drive[7:4];
        field { name = "hi_cfg"; desc = "Bits 11/12: Schmitt/input-enable style bits; vendor mux writes (0x1000 / 0x1C00 / 0x1D00 / 0x1A00) always set bit 12. [GUESS]"; sw = rw; hw = r; } hi_cfg[12:11];
    } PAD_48 @ 0x48;

    reg {
        name = "SDIO0_D1 pad: SDIO0 data 1";
        desc = "PAD_4C - SDIO0_D1 pad: SDIO0 data 1. Confidence **PROVEN**. Evidence: hisi_hi3516ev200.c = 0x4C; boot table 0x571. Hardware not read; reset values unknown.";
        field { name = "func"; desc = "Pin function select (value 0 = GPIO/primary function; the vendor writes 1, 2, 3 or 7 for the alternates, see the evidence). [PROVEN]"; sw = rw; hw = r; } func[3:0];
        field { name = "pull_up"; desc = "Pull-up enable (IO_CFG_PULL_UP = BIT(8) in cijliu-uboot). [INFERRED]"; sw = rw; hw = r; } pull_up[8:8];
        field { name = "pull_down"; desc = "Pull-down enable (IO_CFG_PULL_DOWN = BIT(9)). [INFERRED]"; sw = rw; hw = r; } pull_down[9:9];
        field { name = "slew"; desc = "Slew-rate select (IO_CFG_SR = BIT(10)). [INFERRED]"; sw = rw; hw = r; } slew[10:10];
        field { name = "drive"; desc = "Drive strength (IO_CFG_DRV_STR_SEL, [7:4]); vendor values 0x1..0x7. [INFERRED]"; sw = rw; hw = r; } drive[7:4];
        field { name = "hi_cfg"; desc = "Bits 11/12: Schmitt/input-enable style bits; vendor mux writes (0x1000 / 0x1C00 / 0x1D00 / 0x1A00) always set bit 12. [GUESS]"; sw = rw; hw = r; } hi_cfg[12:11];
    } PAD_4C @ 0x4C;

    reg {
        name = "SDIO0_D2 pad: SDIO0 data 2";
        desc = "PAD_50 - SDIO0_D2 pad: SDIO0 data 2. Confidence **PROVEN**. Evidence: hisi_hi3516ev200.c = 0x50; boot table 0x571. Hardware not read; reset values unknown.";
        field { name = "func"; desc = "Pin function select (value 0 = GPIO/primary function; the vendor writes 1, 2, 3 or 7 for the alternates, see the evidence). [PROVEN]"; sw = rw; hw = r; } func[3:0];
        field { name = "pull_up"; desc = "Pull-up enable (IO_CFG_PULL_UP = BIT(8) in cijliu-uboot). [INFERRED]"; sw = rw; hw = r; } pull_up[8:8];
        field { name = "pull_down"; desc = "Pull-down enable (IO_CFG_PULL_DOWN = BIT(9)). [INFERRED]"; sw = rw; hw = r; } pull_down[9:9];
        field { name = "slew"; desc = "Slew-rate select (IO_CFG_SR = BIT(10)). [INFERRED]"; sw = rw; hw = r; } slew[10:10];
        field { name = "drive"; desc = "Drive strength (IO_CFG_DRV_STR_SEL, [7:4]); vendor values 0x1..0x7. [INFERRED]"; sw = rw; hw = r; } drive[7:4];
        field { name = "hi_cfg"; desc = "Bits 11/12: Schmitt/input-enable style bits; vendor mux writes (0x1000 / 0x1C00 / 0x1D00 / 0x1A00) always set bit 12. [GUESS]"; sw = rw; hw = r; } hi_cfg[12:11];
    } PAD_50 @ 0x50;

    reg {
        name = "SDIO0_D3 pad: SDIO0 data 3";
        desc = "PAD_54 - SDIO0_D3 pad: SDIO0 data 3. Confidence **PROVEN**. Evidence: hisi_hi3516ev200.c = 0x54; boot table 0x571. Hardware not read; reset values unknown.";
        field { name = "func"; desc = "Pin function select (value 0 = GPIO/primary function; the vendor writes 1, 2, 3 or 7 for the alternates, see the evidence). [PROVEN]"; sw = rw; hw = r; } func[3:0];
        field { name = "pull_up"; desc = "Pull-up enable (IO_CFG_PULL_UP = BIT(8) in cijliu-uboot). [INFERRED]"; sw = rw; hw = r; } pull_up[8:8];
        field { name = "pull_down"; desc = "Pull-down enable (IO_CFG_PULL_DOWN = BIT(9)). [INFERRED]"; sw = rw; hw = r; } pull_down[9:9];
        field { name = "slew"; desc = "Slew-rate select (IO_CFG_SR = BIT(10)). [INFERRED]"; sw = rw; hw = r; } slew[10:10];
        field { name = "drive"; desc = "Drive strength (IO_CFG_DRV_STR_SEL, [7:4]); vendor values 0x1..0x7. [INFERRED]"; sw = rw; hw = r; } drive[7:4];
        field { name = "hi_cfg"; desc = "Bits 11/12: Schmitt/input-enable style bits; vendor mux writes (0x1000 / 0x1C00 / 0x1D00 / 0x1A00) always set bit 12. [GUESS]"; sw = rw; hw = r; } hi_cfg[12:11];
    } PAD_54 @ 0x54;

    reg {
        name = "EMMC_DS pad: eMMC data strobe";
        desc = "PAD_58 - EMMC_DS pad: eMMC data strobe. Confidence **PROVEN**. Evidence: hisi_hi3516ev200.c REG_CTRL_EMMC_DS = 0x58. Hardware not read; reset values unknown.";
        field { name = "func"; desc = "Pin function select (value 0 = GPIO/primary function; the vendor writes 1, 2, 3 or 7 for the alternates, see the evidence). [PROVEN]"; sw = rw; hw = r; } func[3:0];
        field { name = "pull_up"; desc = "Pull-up enable (IO_CFG_PULL_UP = BIT(8) in cijliu-uboot). [INFERRED]"; sw = rw; hw = r; } pull_up[8:8];
        field { name = "pull_down"; desc = "Pull-down enable (IO_CFG_PULL_DOWN = BIT(9)). [INFERRED]"; sw = rw; hw = r; } pull_down[9:9];
        field { name = "slew"; desc = "Slew-rate select (IO_CFG_SR = BIT(10)). [INFERRED]"; sw = rw; hw = r; } slew[10:10];
        field { name = "drive"; desc = "Drive strength (IO_CFG_DRV_STR_SEL, [7:4]); vendor values 0x1..0x7. [INFERRED]"; sw = rw; hw = r; } drive[7:4];
        field { name = "hi_cfg"; desc = "Bits 11/12: Schmitt/input-enable style bits; vendor mux writes (0x1000 / 0x1C00 / 0x1D00 / 0x1A00) always set bit 12. [GUESS]"; sw = rw; hw = r; } hi_cfg[12:11];
    } PAD_58 @ 0x58;

    reg {
        name = "EMMC_RST pad: eMMC reset";
        desc = "PAD_5C - EMMC_RST pad: eMMC reset. Confidence **PROVEN**. Evidence: hisi_hi3516ev200.c REG_CTRL_EMMC_RST = 0x5C; boot table 0x531. Hardware not read; reset values unknown.";
        field { name = "func"; desc = "Pin function select (value 0 = GPIO/primary function; the vendor writes 1, 2, 3 or 7 for the alternates, see the evidence). [PROVEN]"; sw = rw; hw = r; } func[3:0];
        field { name = "pull_up"; desc = "Pull-up enable (IO_CFG_PULL_UP = BIT(8) in cijliu-uboot). [INFERRED]"; sw = rw; hw = r; } pull_up[8:8];
        field { name = "pull_down"; desc = "Pull-down enable (IO_CFG_PULL_DOWN = BIT(9)). [INFERRED]"; sw = rw; hw = r; } pull_down[9:9];
        field { name = "slew"; desc = "Slew-rate select (IO_CFG_SR = BIT(10)). [INFERRED]"; sw = rw; hw = r; } slew[10:10];
        field { name = "drive"; desc = "Drive strength (IO_CFG_DRV_STR_SEL, [7:4]); vendor values 0x1..0x7. [INFERRED]"; sw = rw; hw = r; } drive[7:4];
        field { name = "hi_cfg"; desc = "Bits 11/12: Schmitt/input-enable style bits; vendor mux writes (0x1000 / 0x1C00 / 0x1D00 / 0x1A00) always set bit 12. [GUESS]"; sw = rw; hw = r; } hi_cfg[12:11];
    } PAD_5C @ 0x5C;

    reg {
        name = "SDIO1_CLK pad: SDIO1 clock (also SFC alternate pin set)";
        desc = "PAD_60 - SDIO1_CLK pad: SDIO1 clock (also SFC alternate pin set). Confidence **PROVEN**. Evidence: hifmc_hi3516ev200.c hi3516ev200_io_config_spi_sdio(): 0x461. Hardware not read; reset values unknown.";
        field { name = "func"; desc = "Pin function select (value 0 = GPIO/primary function; the vendor writes 1, 2, 3 or 7 for the alternates, see the evidence). [PROVEN]"; sw = rw; hw = r; } func[3:0];
        field { name = "pull_up"; desc = "Pull-up enable (IO_CFG_PULL_UP = BIT(8) in cijliu-uboot). [INFERRED]"; sw = rw; hw = r; } pull_up[8:8];
        field { name = "pull_down"; desc = "Pull-down enable (IO_CFG_PULL_DOWN = BIT(9)). [INFERRED]"; sw = rw; hw = r; } pull_down[9:9];
        field { name = "slew"; desc = "Slew-rate select (IO_CFG_SR = BIT(10)). [INFERRED]"; sw = rw; hw = r; } slew[10:10];
        field { name = "drive"; desc = "Drive strength (IO_CFG_DRV_STR_SEL, [7:4]); vendor values 0x1..0x7. [INFERRED]"; sw = rw; hw = r; } drive[7:4];
        field { name = "hi_cfg"; desc = "Bits 11/12: Schmitt/input-enable style bits; vendor mux writes (0x1000 / 0x1C00 / 0x1D00 / 0x1A00) always set bit 12. [GUESS]"; sw = rw; hw = r; } hi_cfg[12:11];
    } PAD_60 @ 0x60;

    reg {
        name = "SDIO1_CMD pad: SDIO1 command";
        desc = "PAD_64 - SDIO1_CMD pad: SDIO1 command. Confidence **PROVEN**. Evidence: hifmc 0x561. Hardware not read; reset values unknown.";
        field { name = "func"; desc = "Pin function select (value 0 = GPIO/primary function; the vendor writes 1, 2, 3 or 7 for the alternates, see the evidence). [PROVEN]"; sw = rw; hw = r; } func[3:0];
        field { name = "pull_up"; desc = "Pull-up enable (IO_CFG_PULL_UP = BIT(8) in cijliu-uboot). [INFERRED]"; sw = rw; hw = r; } pull_up[8:8];
        field { name = "pull_down"; desc = "Pull-down enable (IO_CFG_PULL_DOWN = BIT(9)). [INFERRED]"; sw = rw; hw = r; } pull_down[9:9];
        field { name = "slew"; desc = "Slew-rate select (IO_CFG_SR = BIT(10)). [INFERRED]"; sw = rw; hw = r; } slew[10:10];
        field { name = "drive"; desc = "Drive strength (IO_CFG_DRV_STR_SEL, [7:4]); vendor values 0x1..0x7. [INFERRED]"; sw = rw; hw = r; } drive[7:4];
        field { name = "hi_cfg"; desc = "Bits 11/12: Schmitt/input-enable style bits; vendor mux writes (0x1000 / 0x1C00 / 0x1D00 / 0x1A00) always set bit 12. [GUESS]"; sw = rw; hw = r; } hi_cfg[12:11];
    } PAD_64 @ 0x64;

    reg {
        name = "SDIO1_D0 pad: SDIO1 data 0";
        desc = "PAD_68 - SDIO1_D0 pad: SDIO1 data 0. Confidence **PROVEN**. Evidence: hifmc 0x461. Hardware not read; reset values unknown.";
        field { name = "func"; desc = "Pin function select (value 0 = GPIO/primary function; the vendor writes 1, 2, 3 or 7 for the alternates, see the evidence). [PROVEN]"; sw = rw; hw = r; } func[3:0];
        field { name = "pull_up"; desc = "Pull-up enable (IO_CFG_PULL_UP = BIT(8) in cijliu-uboot). [INFERRED]"; sw = rw; hw = r; } pull_up[8:8];
        field { name = "pull_down"; desc = "Pull-down enable (IO_CFG_PULL_DOWN = BIT(9)). [INFERRED]"; sw = rw; hw = r; } pull_down[9:9];
        field { name = "slew"; desc = "Slew-rate select (IO_CFG_SR = BIT(10)). [INFERRED]"; sw = rw; hw = r; } slew[10:10];
        field { name = "drive"; desc = "Drive strength (IO_CFG_DRV_STR_SEL, [7:4]); vendor values 0x1..0x7. [INFERRED]"; sw = rw; hw = r; } drive[7:4];
        field { name = "hi_cfg"; desc = "Bits 11/12: Schmitt/input-enable style bits; vendor mux writes (0x1000 / 0x1C00 / 0x1D00 / 0x1A00) always set bit 12. [GUESS]"; sw = rw; hw = r; } hi_cfg[12:11];
    } PAD_68 @ 0x68;

    reg {
        name = "SDIO1_D1 pad: SDIO1 data 1";
        desc = "PAD_6C - SDIO1_D1 pad: SDIO1 data 1. Confidence **PROVEN**. Evidence: hifmc 0x561. Hardware not read; reset values unknown.";
        field { name = "func"; desc = "Pin function select (value 0 = GPIO/primary function; the vendor writes 1, 2, 3 or 7 for the alternates, see the evidence). [PROVEN]"; sw = rw; hw = r; } func[3:0];
        field { name = "pull_up"; desc = "Pull-up enable (IO_CFG_PULL_UP = BIT(8) in cijliu-uboot). [INFERRED]"; sw = rw; hw = r; } pull_up[8:8];
        field { name = "pull_down"; desc = "Pull-down enable (IO_CFG_PULL_DOWN = BIT(9)). [INFERRED]"; sw = rw; hw = r; } pull_down[9:9];
        field { name = "slew"; desc = "Slew-rate select (IO_CFG_SR = BIT(10)). [INFERRED]"; sw = rw; hw = r; } slew[10:10];
        field { name = "drive"; desc = "Drive strength (IO_CFG_DRV_STR_SEL, [7:4]); vendor values 0x1..0x7. [INFERRED]"; sw = rw; hw = r; } drive[7:4];
        field { name = "hi_cfg"; desc = "Bits 11/12: Schmitt/input-enable style bits; vendor mux writes (0x1000 / 0x1C00 / 0x1D00 / 0x1A00) always set bit 12. [GUESS]"; sw = rw; hw = r; } hi_cfg[12:11];
    } PAD_6C @ 0x6C;

    reg {
        name = "SDIO1_D2 pad: SDIO1 data 2";
        desc = "PAD_70 - SDIO1_D2 pad: SDIO1 data 2. Confidence **PROVEN**. Evidence: hifmc 0x531. Hardware not read; reset values unknown.";
        field { name = "func"; desc = "Pin function select (value 0 = GPIO/primary function; the vendor writes 1, 2, 3 or 7 for the alternates, see the evidence). [PROVEN]"; sw = rw; hw = r; } func[3:0];
        field { name = "pull_up"; desc = "Pull-up enable (IO_CFG_PULL_UP = BIT(8) in cijliu-uboot). [INFERRED]"; sw = rw; hw = r; } pull_up[8:8];
        field { name = "pull_down"; desc = "Pull-down enable (IO_CFG_PULL_DOWN = BIT(9)). [INFERRED]"; sw = rw; hw = r; } pull_down[9:9];
        field { name = "slew"; desc = "Slew-rate select (IO_CFG_SR = BIT(10)). [INFERRED]"; sw = rw; hw = r; } slew[10:10];
        field { name = "drive"; desc = "Drive strength (IO_CFG_DRV_STR_SEL, [7:4]); vendor values 0x1..0x7. [INFERRED]"; sw = rw; hw = r; } drive[7:4];
        field { name = "hi_cfg"; desc = "Bits 11/12: Schmitt/input-enable style bits; vendor mux writes (0x1000 / 0x1C00 / 0x1D00 / 0x1A00) always set bit 12. [GUESS]"; sw = rw; hw = r; } hi_cfg[12:11];
    } PAD_70 @ 0x70;

    reg {
        name = "SDIO1_D3 pad: SDIO1 data 3";
        desc = "PAD_74 - SDIO1_D3 pad: SDIO1 data 3. Confidence **PROVEN**. Evidence: hifmc 0x461. Hardware not read; reset values unknown.";
        field { name = "func"; desc = "Pin function select (value 0 = GPIO/primary function; the vendor writes 1, 2, 3 or 7 for the alternates, see the evidence). [PROVEN]"; sw = rw; hw = r; } func[3:0];
        field { name = "pull_up"; desc = "Pull-up enable (IO_CFG_PULL_UP = BIT(8) in cijliu-uboot). [INFERRED]"; sw = rw; hw = r; } pull_up[8:8];
        field { name = "pull_down"; desc = "Pull-down enable (IO_CFG_PULL_DOWN = BIT(9)). [INFERRED]"; sw = rw; hw = r; } pull_down[9:9];
        field { name = "slew"; desc = "Slew-rate select (IO_CFG_SR = BIT(10)). [INFERRED]"; sw = rw; hw = r; } slew[10:10];
        field { name = "drive"; desc = "Drive strength (IO_CFG_DRV_STR_SEL, [7:4]); vendor values 0x1..0x7. [INFERRED]"; sw = rw; hw = r; } drive[7:4];
        field { name = "hi_cfg"; desc = "Bits 11/12: Schmitt/input-enable style bits; vendor mux writes (0x1000 / 0x1C00 / 0x1D00 / 0x1A00) always set bit 12. [GUESS]"; sw = rw; hw = r; } hi_cfg[12:11];
    } PAD_74 @ 0x74;

    reg {
        name = "USB_VBUS pad: USB overcurrent/VBUS input pad";
        desc = "PAD_7C - USB_VBUS pad: USB overcurrent/VBUS input pad. Confidence **PROVEN**. Evidence: phy-hi3516ev200-usb.c USB_VBUS_IO_CONFIG_REG 0x100C007C = 0x531 (dtsi vbus_offset 0x7c). Hardware not read; reset values unknown.";
        field { name = "func"; desc = "Pin function select (value 0 = GPIO/primary function; the vendor writes 1, 2, 3 or 7 for the alternates, see the evidence). [PROVEN]"; sw = rw; hw = r; } func[3:0];
        field { name = "pull_up"; desc = "Pull-up enable (IO_CFG_PULL_UP = BIT(8) in cijliu-uboot). [INFERRED]"; sw = rw; hw = r; } pull_up[8:8];
        field { name = "pull_down"; desc = "Pull-down enable (IO_CFG_PULL_DOWN = BIT(9)). [INFERRED]"; sw = rw; hw = r; } pull_down[9:9];
        field { name = "slew"; desc = "Slew-rate select (IO_CFG_SR = BIT(10)). [INFERRED]"; sw = rw; hw = r; } slew[10:10];
        field { name = "drive"; desc = "Drive strength (IO_CFG_DRV_STR_SEL, [7:4]); vendor values 0x1..0x7. [INFERRED]"; sw = rw; hw = r; } drive[7:4];
        field { name = "hi_cfg"; desc = "Bits 11/12: Schmitt/input-enable style bits; vendor mux writes (0x1000 / 0x1C00 / 0x1D00 / 0x1A00) always set bit 12. [GUESS]"; sw = rw; hw = r; } hi_cfg[12:11];
    } PAD_7C @ 0x7C;

    reg {
        name = "USB_PWREN pad: USB power enable output pad";
        desc = "PAD_80 - USB_PWREN pad: USB power enable output pad. Confidence **PROVEN**. Evidence: phy-hi3516ev200-usb.c USB_PWREN_CONFIG_REG 0x100C0080 = 0x1 (dtsi pwren_offset 0x80, pwren_val 1). Hardware not read; reset values unknown.";
        field { name = "func"; desc = "Pin function select (value 0 = GPIO/primary function; the vendor writes 1, 2, 3 or 7 for the alternates, see the evidence). [PROVEN]"; sw = rw; hw = r; } func[3:0];
        field { name = "pull_up"; desc = "Pull-up enable (IO_CFG_PULL_UP = BIT(8) in cijliu-uboot). [INFERRED]"; sw = rw; hw = r; } pull_up[8:8];
        field { name = "pull_down"; desc = "Pull-down enable (IO_CFG_PULL_DOWN = BIT(9)). [INFERRED]"; sw = rw; hw = r; } pull_down[9:9];
        field { name = "slew"; desc = "Slew-rate select (IO_CFG_SR = BIT(10)). [INFERRED]"; sw = rw; hw = r; } slew[10:10];
        field { name = "drive"; desc = "Drive strength (IO_CFG_DRV_STR_SEL, [7:4]); vendor values 0x1..0x7. [INFERRED]"; sw = rw; hw = r; } drive[7:4];
        field { name = "hi_cfg"; desc = "Bits 11/12: Schmitt/input-enable style bits; vendor mux writes (0x1000 / 0x1C00 / 0x1D00 / 0x1A00) always set bit 12. [GUESS]"; sw = rw; hw = r; } hi_cfg[12:11];
    } PAD_80 @ 0x80;

    reg {
        name = "SPI1 pad 84: SPI1 pin group (spi1_pin_mux 0x1431)";
        desc = "PAD_84 - SPI1 pad 84: SPI1 pin group (spi1_pin_mux 0x1431). Confidence **INFERRED**. Evidence: openhisilicon sys_config spi1_pin_mux(). Hardware not read; reset values unknown.";
        field { name = "func"; desc = "Pin function select (value 0 = GPIO/primary function; the vendor writes 1, 2, 3 or 7 for the alternates, see the evidence). [INFERRED]"; sw = rw; hw = r; } func[3:0];
        field { name = "pull_up"; desc = "Pull-up enable (IO_CFG_PULL_UP = BIT(8) in cijliu-uboot). [INFERRED]"; sw = rw; hw = r; } pull_up[8:8];
        field { name = "pull_down"; desc = "Pull-down enable (IO_CFG_PULL_DOWN = BIT(9)). [INFERRED]"; sw = rw; hw = r; } pull_down[9:9];
        field { name = "slew"; desc = "Slew-rate select (IO_CFG_SR = BIT(10)). [INFERRED]"; sw = rw; hw = r; } slew[10:10];
        field { name = "drive"; desc = "Drive strength (IO_CFG_DRV_STR_SEL, [7:4]); vendor values 0x1..0x7. [INFERRED]"; sw = rw; hw = r; } drive[7:4];
        field { name = "hi_cfg"; desc = "Bits 11/12: Schmitt/input-enable style bits; vendor mux writes (0x1000 / 0x1C00 / 0x1D00 / 0x1A00) always set bit 12. [GUESS]"; sw = rw; hw = r; } hi_cfg[12:11];
    } PAD_84 @ 0x84;

    reg {
        name = "SPI1 pad 88: SPI1 pin group (0x1011)";
        desc = "PAD_88 - SPI1 pad 88: SPI1 pin group (0x1011). Confidence **INFERRED**. Evidence: same Hardware not read; reset values unknown.";
        field { name = "func"; desc = "Pin function select (value 0 = GPIO/primary function; the vendor writes 1, 2, 3 or 7 for the alternates, see the evidence). [INFERRED]"; sw = rw; hw = r; } func[3:0];
        field { name = "pull_up"; desc = "Pull-up enable (IO_CFG_PULL_UP = BIT(8) in cijliu-uboot). [INFERRED]"; sw = rw; hw = r; } pull_up[8:8];
        field { name = "pull_down"; desc = "Pull-down enable (IO_CFG_PULL_DOWN = BIT(9)). [INFERRED]"; sw = rw; hw = r; } pull_down[9:9];
        field { name = "slew"; desc = "Slew-rate select (IO_CFG_SR = BIT(10)). [INFERRED]"; sw = rw; hw = r; } slew[10:10];
        field { name = "drive"; desc = "Drive strength (IO_CFG_DRV_STR_SEL, [7:4]); vendor values 0x1..0x7. [INFERRED]"; sw = rw; hw = r; } drive[7:4];
        field { name = "hi_cfg"; desc = "Bits 11/12: Schmitt/input-enable style bits; vendor mux writes (0x1000 / 0x1C00 / 0x1D00 / 0x1A00) always set bit 12. [GUESS]"; sw = rw; hw = r; } hi_cfg[12:11];
    } PAD_88 @ 0x88;

    reg {
        name = "SPI1 pad 8C: SPI1 pin group (0x1011)";
        desc = "PAD_8C - SPI1 pad 8C: SPI1 pin group (0x1011). Confidence **INFERRED**. Evidence: same Hardware not read; reset values unknown.";
        field { name = "func"; desc = "Pin function select (value 0 = GPIO/primary function; the vendor writes 1, 2, 3 or 7 for the alternates, see the evidence). [INFERRED]"; sw = rw; hw = r; } func[3:0];
        field { name = "pull_up"; desc = "Pull-up enable (IO_CFG_PULL_UP = BIT(8) in cijliu-uboot). [INFERRED]"; sw = rw; hw = r; } pull_up[8:8];
        field { name = "pull_down"; desc = "Pull-down enable (IO_CFG_PULL_DOWN = BIT(9)). [INFERRED]"; sw = rw; hw = r; } pull_down[9:9];
        field { name = "slew"; desc = "Slew-rate select (IO_CFG_SR = BIT(10)). [INFERRED]"; sw = rw; hw = r; } slew[10:10];
        field { name = "drive"; desc = "Drive strength (IO_CFG_DRV_STR_SEL, [7:4]); vendor values 0x1..0x7. [INFERRED]"; sw = rw; hw = r; } drive[7:4];
        field { name = "hi_cfg"; desc = "Bits 11/12: Schmitt/input-enable style bits; vendor mux writes (0x1000 / 0x1C00 / 0x1D00 / 0x1A00) always set bit 12. [GUESS]"; sw = rw; hw = r; } hi_cfg[12:11];
    } PAD_8C @ 0x8C;

    reg {
        name = "SPI1 pad 90: SPI1 pin group (0x1001)";
        desc = "PAD_90 - SPI1 pad 90: SPI1 pin group (0x1001). Confidence **INFERRED**. Evidence: same Hardware not read; reset values unknown.";
        field { name = "func"; desc = "Pin function select (value 0 = GPIO/primary function; the vendor writes 1, 2, 3 or 7 for the alternates, see the evidence). [INFERRED]"; sw = rw; hw = r; } func[3:0];
        field { name = "pull_up"; desc = "Pull-up enable (IO_CFG_PULL_UP = BIT(8) in cijliu-uboot). [INFERRED]"; sw = rw; hw = r; } pull_up[8:8];
        field { name = "pull_down"; desc = "Pull-down enable (IO_CFG_PULL_DOWN = BIT(9)). [INFERRED]"; sw = rw; hw = r; } pull_down[9:9];
        field { name = "slew"; desc = "Slew-rate select (IO_CFG_SR = BIT(10)). [INFERRED]"; sw = rw; hw = r; } slew[10:10];
        field { name = "drive"; desc = "Drive strength (IO_CFG_DRV_STR_SEL, [7:4]); vendor values 0x1..0x7. [INFERRED]"; sw = rw; hw = r; } drive[7:4];
        field { name = "hi_cfg"; desc = "Bits 11/12: Schmitt/input-enable style bits; vendor mux writes (0x1000 / 0x1C00 / 0x1D00 / 0x1A00) always set bit 12. [GUESS]"; sw = rw; hw = r; } hi_cfg[12:11];
    } PAD_90 @ 0x90;

    reg {
        name = "GPIO / I2C1 helper pad: Pad cleared to 0x1000 by i2c1_pin_mux()/spi0_pin_mux()";
        desc = "PAD_9C - GPIO / I2C1 helper pad: Pad cleared to 0x1000 by i2c1_pin_mux()/spi0_pin_mux(). Confidence **INFERRED**. Evidence: openhisilicon sys_config (function 0, bit 12 set). Hardware not read; reset values unknown.";
        field { name = "func"; desc = "Pin function select (value 0 = GPIO/primary function; the vendor writes 1, 2, 3 or 7 for the alternates, see the evidence). [INFERRED]"; sw = rw; hw = r; } func[3:0];
        field { name = "pull_up"; desc = "Pull-up enable (IO_CFG_PULL_UP = BIT(8) in cijliu-uboot). [INFERRED]"; sw = rw; hw = r; } pull_up[8:8];
        field { name = "pull_down"; desc = "Pull-down enable (IO_CFG_PULL_DOWN = BIT(9)). [INFERRED]"; sw = rw; hw = r; } pull_down[9:9];
        field { name = "slew"; desc = "Slew-rate select (IO_CFG_SR = BIT(10)). [INFERRED]"; sw = rw; hw = r; } slew[10:10];
        field { name = "drive"; desc = "Drive strength (IO_CFG_DRV_STR_SEL, [7:4]); vendor values 0x1..0x7. [INFERRED]"; sw = rw; hw = r; } drive[7:4];
        field { name = "hi_cfg"; desc = "Bits 11/12: Schmitt/input-enable style bits; vendor mux writes (0x1000 / 0x1C00 / 0x1D00 / 0x1A00) always set bit 12. [GUESS]"; sw = rw; hw = r; } hi_cfg[12:11];
    } PAD_9C @ 0x9C;

};
`endif

`ifndef HI3516EV200_EIO_CONFIG_CORE_RDL
`define HI3516EV200_EIO_CONFIG_CORE_RDL

regfile eIO_CONFIG_CORE {
    name = "IO configuration (pin mux + pad control), core pads (LSADC, GPIO1), Hi3516E V200";
    desc = "Base 0x120C0000. One 32-bit register per pad: [3:0] function select, [8]/[9] pull-up/pull-down, [10] slew, [7:4] drive strength (cijliu-uboot hisi_hi3516ev200.c IO_CFG_* macros); pad names for the VIO block are INFERRED from the function written by the vendor sys_config.ko (GPIO numbers and data sheet pin names are not available), so only pads some vendor code touches are listed. Confidence legend (no hardware was read for this block): PROVEN = offset and bits are used by vendor source code or by the vendor boot binary (Xiongmai stock U-Boot of a Hi3516E V200 camera) exactly as described; INFERRED = deduced from naming, from sibling chips or from a value without a bit map; GUESS = plausible only.";

    reg {
        name = "LSADC_CH0 pad: LSADC channel 0 (GPIO1_0 when function 0)";
        desc = "PAD_00 - LSADC_CH0 pad: LSADC channel 0 (GPIO1_0 when function 0). Confidence **PROVEN**. Evidence: openhisilicon sys_config lsadc_mux(): 0x1001 selects LSADC_CH0. Hardware not read; reset values unknown.";
        field { name = "func"; desc = "Pin function select (value 0 = GPIO/primary function; the vendor writes 1, 2, 3 or 7 for the alternates, see the evidence). [PROVEN]"; sw = rw; hw = r; } func[3:0];
        field { name = "pull_up"; desc = "Pull-up enable (IO_CFG_PULL_UP = BIT(8) in cijliu-uboot). [INFERRED]"; sw = rw; hw = r; } pull_up[8:8];
        field { name = "pull_down"; desc = "Pull-down enable (IO_CFG_PULL_DOWN = BIT(9)). [INFERRED]"; sw = rw; hw = r; } pull_down[9:9];
        field { name = "slew"; desc = "Slew-rate select (IO_CFG_SR = BIT(10)). [INFERRED]"; sw = rw; hw = r; } slew[10:10];
        field { name = "drive"; desc = "Drive strength (IO_CFG_DRV_STR_SEL, [7:4]); vendor values 0x1..0x7. [INFERRED]"; sw = rw; hw = r; } drive[7:4];
        field { name = "hi_cfg"; desc = "Bits 11/12: Schmitt/input-enable style bits; vendor mux writes (0x1000 / 0x1C00 / 0x1D00 / 0x1A00) always set bit 12. [GUESS]"; sw = rw; hw = r; } hi_cfg[12:11];
    } PAD_00 @ 0x0;

    reg {
        name = "LSADC_CH1 pad: LSADC channel 1 (GPIO1_1 when function 0)";
        desc = "PAD_04 - LSADC_CH1 pad: LSADC channel 1 (GPIO1_1 when function 0). Confidence **PROVEN**. Evidence: lsadc_mux(): 0x1001 selects LSADC_CH1. Hardware not read; reset values unknown.";
        field { name = "func"; desc = "Pin function select (value 0 = GPIO/primary function; the vendor writes 1, 2, 3 or 7 for the alternates, see the evidence). [PROVEN]"; sw = rw; hw = r; } func[3:0];
        field { name = "pull_up"; desc = "Pull-up enable (IO_CFG_PULL_UP = BIT(8) in cijliu-uboot). [INFERRED]"; sw = rw; hw = r; } pull_up[8:8];
        field { name = "pull_down"; desc = "Pull-down enable (IO_CFG_PULL_DOWN = BIT(9)). [INFERRED]"; sw = rw; hw = r; } pull_down[9:9];
        field { name = "slew"; desc = "Slew-rate select (IO_CFG_SR = BIT(10)). [INFERRED]"; sw = rw; hw = r; } slew[10:10];
        field { name = "drive"; desc = "Drive strength (IO_CFG_DRV_STR_SEL, [7:4]); vendor values 0x1..0x7. [INFERRED]"; sw = rw; hw = r; } drive[7:4];
        field { name = "hi_cfg"; desc = "Bits 11/12: Schmitt/input-enable style bits; vendor mux writes (0x1000 / 0x1C00 / 0x1D00 / 0x1A00) always set bit 12. [GUESS]"; sw = rw; hw = r; } hi_cfg[12:11];
    } PAD_04 @ 0x4;

    reg {
        name = "unknown pad 20: Written 0x433 by the vendor boot table (PHY/pad related)";
        desc = "PAD_20 - unknown pad 20: Written 0x433 by the vendor boot table (PHY/pad related). Confidence **INFERRED**. Evidence: cijliu-uboot reg_info.bin, last entries before the iocfg2 block. Hardware not read; reset values unknown.";
        field { name = "func"; desc = "Pin function select (value 0 = GPIO/primary function; the vendor writes 1, 2, 3 or 7 for the alternates, see the evidence). [INFERRED]"; sw = rw; hw = r; } func[3:0];
        field { name = "pull_up"; desc = "Pull-up enable (IO_CFG_PULL_UP = BIT(8) in cijliu-uboot). [INFERRED]"; sw = rw; hw = r; } pull_up[8:8];
        field { name = "pull_down"; desc = "Pull-down enable (IO_CFG_PULL_DOWN = BIT(9)). [INFERRED]"; sw = rw; hw = r; } pull_down[9:9];
        field { name = "slew"; desc = "Slew-rate select (IO_CFG_SR = BIT(10)). [INFERRED]"; sw = rw; hw = r; } slew[10:10];
        field { name = "drive"; desc = "Drive strength (IO_CFG_DRV_STR_SEL, [7:4]); vendor values 0x1..0x7. [INFERRED]"; sw = rw; hw = r; } drive[7:4];
        field { name = "hi_cfg"; desc = "Bits 11/12: Schmitt/input-enable style bits; vendor mux writes (0x1000 / 0x1C00 / 0x1D00 / 0x1A00) always set bit 12. [GUESS]"; sw = rw; hw = r; } hi_cfg[12:11];
    } PAD_20 @ 0x20;

};
`endif

`ifndef HI3516EV200_EIO_CONFIG_VIO_RDL
`define HI3516EV200_EIO_CONFIG_VIO_RDL

regfile eIO_CONFIG_VIO {
    name = "IO configuration (pin mux + pad control), video-IO pads (VI/MIPI, sensor clock/reset, I2C0..2, SPI0), Hi3516E V200";
    desc = "Base 0x112C0000. One 32-bit register per pad: [3:0] function select, [8]/[9] pull-up/pull-down, [10] slew, [7:4] drive strength (cijliu-uboot hisi_hi3516ev200.c IO_CFG_* macros); pad names for the VIO block are INFERRED from the function written by the vendor sys_config.ko (GPIO numbers and data sheet pin names are not available), so only pads some vendor code touches are listed. Confidence legend (no hardware was read for this block): PROVEN = offset and bits are used by vendor source code or by the vendor boot binary (Xiongmai stock U-Boot of a Hi3516E V200 camera) exactly as described; INFERRED = deduced from naming, from sibling chips or from a value without a bit map; GUESS = plausible only.";

    reg {
        name = "VI_D0 pad: VI / MIPI RX pad 0";
        desc = "PAD_00 - VI_D0 pad: VI / MIPI RX pad 0. Confidence **INFERRED**. Evidence: openhisilicon sys_config vi_mipi_rx_mux(): 0x1000 (function 0 = MIPI RX) for pads 0x00..0x14; vi_bt1120_mode_mux 0x1001; vi_raw_mode_mux 0x1002. Hardware not read; reset values unknown.";
        field { name = "func"; desc = "Pin function select (value 0 = GPIO/primary function; the vendor writes 1, 2, 3 or 7 for the alternates, see the evidence). [INFERRED]"; sw = rw; hw = r; } func[3:0];
        field { name = "pull_up"; desc = "Pull-up enable (IO_CFG_PULL_UP = BIT(8) in cijliu-uboot). [INFERRED]"; sw = rw; hw = r; } pull_up[8:8];
        field { name = "pull_down"; desc = "Pull-down enable (IO_CFG_PULL_DOWN = BIT(9)). [INFERRED]"; sw = rw; hw = r; } pull_down[9:9];
        field { name = "slew"; desc = "Slew-rate select (IO_CFG_SR = BIT(10)). [INFERRED]"; sw = rw; hw = r; } slew[10:10];
        field { name = "drive"; desc = "Drive strength (IO_CFG_DRV_STR_SEL, [7:4]); vendor values 0x1..0x7. [INFERRED]"; sw = rw; hw = r; } drive[7:4];
        field { name = "hi_cfg"; desc = "Bits 11/12: Schmitt/input-enable style bits; vendor mux writes (0x1000 / 0x1C00 / 0x1D00 / 0x1A00) always set bit 12. [GUESS]"; sw = rw; hw = r; } hi_cfg[12:11];
    } PAD_00 @ 0x0;

    reg {
        name = "VI_D1 pad: VI / MIPI RX pad 1";
        desc = "PAD_04 - VI_D1 pad: VI / MIPI RX pad 1. Confidence **INFERRED**. Evidence: same Hardware not read; reset values unknown.";
        field { name = "func"; desc = "Pin function select (value 0 = GPIO/primary function; the vendor writes 1, 2, 3 or 7 for the alternates, see the evidence). [INFERRED]"; sw = rw; hw = r; } func[3:0];
        field { name = "pull_up"; desc = "Pull-up enable (IO_CFG_PULL_UP = BIT(8) in cijliu-uboot). [INFERRED]"; sw = rw; hw = r; } pull_up[8:8];
        field { name = "pull_down"; desc = "Pull-down enable (IO_CFG_PULL_DOWN = BIT(9)). [INFERRED]"; sw = rw; hw = r; } pull_down[9:9];
        field { name = "slew"; desc = "Slew-rate select (IO_CFG_SR = BIT(10)). [INFERRED]"; sw = rw; hw = r; } slew[10:10];
        field { name = "drive"; desc = "Drive strength (IO_CFG_DRV_STR_SEL, [7:4]); vendor values 0x1..0x7. [INFERRED]"; sw = rw; hw = r; } drive[7:4];
        field { name = "hi_cfg"; desc = "Bits 11/12: Schmitt/input-enable style bits; vendor mux writes (0x1000 / 0x1C00 / 0x1D00 / 0x1A00) always set bit 12. [GUESS]"; sw = rw; hw = r; } hi_cfg[12:11];
    } PAD_04 @ 0x4;

    reg {
        name = "VI_D2 pad: VI / MIPI RX pad 2";
        desc = "PAD_08 - VI_D2 pad: VI / MIPI RX pad 2. Confidence **INFERRED**. Evidence: same Hardware not read; reset values unknown.";
        field { name = "func"; desc = "Pin function select (value 0 = GPIO/primary function; the vendor writes 1, 2, 3 or 7 for the alternates, see the evidence). [INFERRED]"; sw = rw; hw = r; } func[3:0];
        field { name = "pull_up"; desc = "Pull-up enable (IO_CFG_PULL_UP = BIT(8) in cijliu-uboot). [INFERRED]"; sw = rw; hw = r; } pull_up[8:8];
        field { name = "pull_down"; desc = "Pull-down enable (IO_CFG_PULL_DOWN = BIT(9)). [INFERRED]"; sw = rw; hw = r; } pull_down[9:9];
        field { name = "slew"; desc = "Slew-rate select (IO_CFG_SR = BIT(10)). [INFERRED]"; sw = rw; hw = r; } slew[10:10];
        field { name = "drive"; desc = "Drive strength (IO_CFG_DRV_STR_SEL, [7:4]); vendor values 0x1..0x7. [INFERRED]"; sw = rw; hw = r; } drive[7:4];
        field { name = "hi_cfg"; desc = "Bits 11/12: Schmitt/input-enable style bits; vendor mux writes (0x1000 / 0x1C00 / 0x1D00 / 0x1A00) always set bit 12. [GUESS]"; sw = rw; hw = r; } hi_cfg[12:11];
    } PAD_08 @ 0x8;

    reg {
        name = "VI_D3 pad: VI / MIPI RX pad 3";
        desc = "PAD_0C - VI_D3 pad: VI / MIPI RX pad 3. Confidence **INFERRED**. Evidence: same Hardware not read; reset values unknown.";
        field { name = "func"; desc = "Pin function select (value 0 = GPIO/primary function; the vendor writes 1, 2, 3 or 7 for the alternates, see the evidence). [INFERRED]"; sw = rw; hw = r; } func[3:0];
        field { name = "pull_up"; desc = "Pull-up enable (IO_CFG_PULL_UP = BIT(8) in cijliu-uboot). [INFERRED]"; sw = rw; hw = r; } pull_up[8:8];
        field { name = "pull_down"; desc = "Pull-down enable (IO_CFG_PULL_DOWN = BIT(9)). [INFERRED]"; sw = rw; hw = r; } pull_down[9:9];
        field { name = "slew"; desc = "Slew-rate select (IO_CFG_SR = BIT(10)). [INFERRED]"; sw = rw; hw = r; } slew[10:10];
        field { name = "drive"; desc = "Drive strength (IO_CFG_DRV_STR_SEL, [7:4]); vendor values 0x1..0x7. [INFERRED]"; sw = rw; hw = r; } drive[7:4];
        field { name = "hi_cfg"; desc = "Bits 11/12: Schmitt/input-enable style bits; vendor mux writes (0x1000 / 0x1C00 / 0x1D00 / 0x1A00) always set bit 12. [GUESS]"; sw = rw; hw = r; } hi_cfg[12:11];
    } PAD_0C @ 0xC;

    reg {
        name = "VI_D4 pad: VI / MIPI RX pad 4";
        desc = "PAD_10 - VI_D4 pad: VI / MIPI RX pad 4. Confidence **INFERRED**. Evidence: same Hardware not read; reset values unknown.";
        field { name = "func"; desc = "Pin function select (value 0 = GPIO/primary function; the vendor writes 1, 2, 3 or 7 for the alternates, see the evidence). [INFERRED]"; sw = rw; hw = r; } func[3:0];
        field { name = "pull_up"; desc = "Pull-up enable (IO_CFG_PULL_UP = BIT(8) in cijliu-uboot). [INFERRED]"; sw = rw; hw = r; } pull_up[8:8];
        field { name = "pull_down"; desc = "Pull-down enable (IO_CFG_PULL_DOWN = BIT(9)). [INFERRED]"; sw = rw; hw = r; } pull_down[9:9];
        field { name = "slew"; desc = "Slew-rate select (IO_CFG_SR = BIT(10)). [INFERRED]"; sw = rw; hw = r; } slew[10:10];
        field { name = "drive"; desc = "Drive strength (IO_CFG_DRV_STR_SEL, [7:4]); vendor values 0x1..0x7. [INFERRED]"; sw = rw; hw = r; } drive[7:4];
        field { name = "hi_cfg"; desc = "Bits 11/12: Schmitt/input-enable style bits; vendor mux writes (0x1000 / 0x1C00 / 0x1D00 / 0x1A00) always set bit 12. [GUESS]"; sw = rw; hw = r; } hi_cfg[12:11];
    } PAD_10 @ 0x10;

    reg {
        name = "VI_D5 pad: VI / MIPI RX pad 5";
        desc = "PAD_14 - VI_D5 pad: VI / MIPI RX pad 5. Confidence **INFERRED**. Evidence: same Hardware not read; reset values unknown.";
        field { name = "func"; desc = "Pin function select (value 0 = GPIO/primary function; the vendor writes 1, 2, 3 or 7 for the alternates, see the evidence). [INFERRED]"; sw = rw; hw = r; } func[3:0];
        field { name = "pull_up"; desc = "Pull-up enable (IO_CFG_PULL_UP = BIT(8) in cijliu-uboot). [INFERRED]"; sw = rw; hw = r; } pull_up[8:8];
        field { name = "pull_down"; desc = "Pull-down enable (IO_CFG_PULL_DOWN = BIT(9)). [INFERRED]"; sw = rw; hw = r; } pull_down[9:9];
        field { name = "slew"; desc = "Slew-rate select (IO_CFG_SR = BIT(10)). [INFERRED]"; sw = rw; hw = r; } slew[10:10];
        field { name = "drive"; desc = "Drive strength (IO_CFG_DRV_STR_SEL, [7:4]); vendor values 0x1..0x7. [INFERRED]"; sw = rw; hw = r; } drive[7:4];
        field { name = "hi_cfg"; desc = "Bits 11/12: Schmitt/input-enable style bits; vendor mux writes (0x1000 / 0x1C00 / 0x1D00 / 0x1A00) always set bit 12. [GUESS]"; sw = rw; hw = r; } hi_cfg[12:11];
    } PAD_14 @ 0x14;

    reg {
        name = "SENSOR_CLK pad: Sensor master clock output";
        desc = "PAD_28 - SENSOR_CLK pad: Sensor master clock output. Confidence **INFERRED**. Evidence: sys_config sensor_cfg_for_mipi_sensor_mux(): 0x1001 (function 1); raw variant sets 0x1002. Hardware not read; reset values unknown.";
        field { name = "func"; desc = "Pin function select (value 0 = GPIO/primary function; the vendor writes 1, 2, 3 or 7 for the alternates, see the evidence). [INFERRED]"; sw = rw; hw = r; } func[3:0];
        field { name = "pull_up"; desc = "Pull-up enable (IO_CFG_PULL_UP = BIT(8) in cijliu-uboot). [INFERRED]"; sw = rw; hw = r; } pull_up[8:8];
        field { name = "pull_down"; desc = "Pull-down enable (IO_CFG_PULL_DOWN = BIT(9)). [INFERRED]"; sw = rw; hw = r; } pull_down[9:9];
        field { name = "slew"; desc = "Slew-rate select (IO_CFG_SR = BIT(10)). [INFERRED]"; sw = rw; hw = r; } slew[10:10];
        field { name = "drive"; desc = "Drive strength (IO_CFG_DRV_STR_SEL, [7:4]); vendor values 0x1..0x7. [INFERRED]"; sw = rw; hw = r; } drive[7:4];
        field { name = "hi_cfg"; desc = "Bits 11/12: Schmitt/input-enable style bits; vendor mux writes (0x1000 / 0x1C00 / 0x1D00 / 0x1A00) always set bit 12. [GUESS]"; sw = rw; hw = r; } hi_cfg[12:11];
    } PAD_28 @ 0x28;

    reg {
        name = "SENSOR_RSTN pad: Sensor reset output";
        desc = "PAD_2C - SENSOR_RSTN pad: Sensor reset output. Confidence **INFERRED**. Evidence: same Hardware not read; reset values unknown.";
        field { name = "func"; desc = "Pin function select (value 0 = GPIO/primary function; the vendor writes 1, 2, 3 or 7 for the alternates, see the evidence). [INFERRED]"; sw = rw; hw = r; } func[3:0];
        field { name = "pull_up"; desc = "Pull-up enable (IO_CFG_PULL_UP = BIT(8) in cijliu-uboot). [INFERRED]"; sw = rw; hw = r; } pull_up[8:8];
        field { name = "pull_down"; desc = "Pull-down enable (IO_CFG_PULL_DOWN = BIT(9)). [INFERRED]"; sw = rw; hw = r; } pull_down[9:9];
        field { name = "slew"; desc = "Slew-rate select (IO_CFG_SR = BIT(10)). [INFERRED]"; sw = rw; hw = r; } slew[10:10];
        field { name = "drive"; desc = "Drive strength (IO_CFG_DRV_STR_SEL, [7:4]); vendor values 0x1..0x7. [INFERRED]"; sw = rw; hw = r; } drive[7:4];
        field { name = "hi_cfg"; desc = "Bits 11/12: Schmitt/input-enable style bits; vendor mux writes (0x1000 / 0x1C00 / 0x1D00 / 0x1A00) always set bit 12. [GUESS]"; sw = rw; hw = r; } hi_cfg[12:11];
    } PAD_2C @ 0x2C;

    reg {
        name = "I2C0_SCL pad: I2C0 SCL (MIPI sensors)";
        desc = "PAD_30 - I2C0_SCL pad: I2C0 SCL (MIPI sensors). Confidence **INFERRED**. Evidence: sys_config i2c0_pin_mux(): 0x1D01 (function 1). Hardware not read; reset values unknown.";
        field { name = "func"; desc = "Pin function select (value 0 = GPIO/primary function; the vendor writes 1, 2, 3 or 7 for the alternates, see the evidence). [INFERRED]"; sw = rw; hw = r; } func[3:0];
        field { name = "pull_up"; desc = "Pull-up enable (IO_CFG_PULL_UP = BIT(8) in cijliu-uboot). [INFERRED]"; sw = rw; hw = r; } pull_up[8:8];
        field { name = "pull_down"; desc = "Pull-down enable (IO_CFG_PULL_DOWN = BIT(9)). [INFERRED]"; sw = rw; hw = r; } pull_down[9:9];
        field { name = "slew"; desc = "Slew-rate select (IO_CFG_SR = BIT(10)). [INFERRED]"; sw = rw; hw = r; } slew[10:10];
        field { name = "drive"; desc = "Drive strength (IO_CFG_DRV_STR_SEL, [7:4]); vendor values 0x1..0x7. [INFERRED]"; sw = rw; hw = r; } drive[7:4];
        field { name = "hi_cfg"; desc = "Bits 11/12: Schmitt/input-enable style bits; vendor mux writes (0x1000 / 0x1C00 / 0x1D00 / 0x1A00) always set bit 12. [GUESS]"; sw = rw; hw = r; } hi_cfg[12:11];
    } PAD_30 @ 0x30;

    reg {
        name = "I2C0_SDA pad: I2C0 SDA (MIPI sensors)";
        desc = "PAD_34 - I2C0_SDA pad: I2C0 SDA (MIPI sensors). Confidence **INFERRED**. Evidence: same Hardware not read; reset values unknown.";
        field { name = "func"; desc = "Pin function select (value 0 = GPIO/primary function; the vendor writes 1, 2, 3 or 7 for the alternates, see the evidence). [INFERRED]"; sw = rw; hw = r; } func[3:0];
        field { name = "pull_up"; desc = "Pull-up enable (IO_CFG_PULL_UP = BIT(8) in cijliu-uboot). [INFERRED]"; sw = rw; hw = r; } pull_up[8:8];
        field { name = "pull_down"; desc = "Pull-down enable (IO_CFG_PULL_DOWN = BIT(9)). [INFERRED]"; sw = rw; hw = r; } pull_down[9:9];
        field { name = "slew"; desc = "Slew-rate select (IO_CFG_SR = BIT(10)). [INFERRED]"; sw = rw; hw = r; } slew[10:10];
        field { name = "drive"; desc = "Drive strength (IO_CFG_DRV_STR_SEL, [7:4]); vendor values 0x1..0x7. [INFERRED]"; sw = rw; hw = r; } drive[7:4];
        field { name = "hi_cfg"; desc = "Bits 11/12: Schmitt/input-enable style bits; vendor mux writes (0x1000 / 0x1C00 / 0x1D00 / 0x1A00) always set bit 12. [GUESS]"; sw = rw; hw = r; } hi_cfg[12:11];
    } PAD_34 @ 0x34;

    reg {
        name = "I2C2_SDA / SPI0 pad: I2C2 SDA (function 1, 0x1C01)";
        desc = "PAD_38 - I2C2_SDA / SPI0 pad: I2C2 SDA (function 1, 0x1C01). Confidence **INFERRED**. Evidence: sys_config i2c2_pin_mux(); SPI0 uses 0x1037 on this pad (spi0_pin_mux_gk7205v200). Hardware not read; reset values unknown.";
        field { name = "func"; desc = "Pin function select (value 0 = GPIO/primary function; the vendor writes 1, 2, 3 or 7 for the alternates, see the evidence). [INFERRED]"; sw = rw; hw = r; } func[3:0];
        field { name = "pull_up"; desc = "Pull-up enable (IO_CFG_PULL_UP = BIT(8) in cijliu-uboot). [INFERRED]"; sw = rw; hw = r; } pull_up[8:8];
        field { name = "pull_down"; desc = "Pull-down enable (IO_CFG_PULL_DOWN = BIT(9)). [INFERRED]"; sw = rw; hw = r; } pull_down[9:9];
        field { name = "slew"; desc = "Slew-rate select (IO_CFG_SR = BIT(10)). [INFERRED]"; sw = rw; hw = r; } slew[10:10];
        field { name = "drive"; desc = "Drive strength (IO_CFG_DRV_STR_SEL, [7:4]); vendor values 0x1..0x7. [INFERRED]"; sw = rw; hw = r; } drive[7:4];
        field { name = "hi_cfg"; desc = "Bits 11/12: Schmitt/input-enable style bits; vendor mux writes (0x1000 / 0x1C00 / 0x1D00 / 0x1A00) always set bit 12. [GUESS]"; sw = rw; hw = r; } hi_cfg[12:11];
    } PAD_38 @ 0x38;

    reg {
        name = "I2C2_SCL / SPI0 pad: I2C2 SCL (function 1)";
        desc = "PAD_3C - I2C2_SCL / SPI0 pad: I2C2 SCL (function 1). Confidence **INFERRED**. Evidence: same Hardware not read; reset values unknown.";
        field { name = "func"; desc = "Pin function select (value 0 = GPIO/primary function; the vendor writes 1, 2, 3 or 7 for the alternates, see the evidence). [INFERRED]"; sw = rw; hw = r; } func[3:0];
        field { name = "pull_up"; desc = "Pull-up enable (IO_CFG_PULL_UP = BIT(8) in cijliu-uboot). [INFERRED]"; sw = rw; hw = r; } pull_up[8:8];
        field { name = "pull_down"; desc = "Pull-down enable (IO_CFG_PULL_DOWN = BIT(9)). [INFERRED]"; sw = rw; hw = r; } pull_down[9:9];
        field { name = "slew"; desc = "Slew-rate select (IO_CFG_SR = BIT(10)). [INFERRED]"; sw = rw; hw = r; } slew[10:10];
        field { name = "drive"; desc = "Drive strength (IO_CFG_DRV_STR_SEL, [7:4]); vendor values 0x1..0x7. [INFERRED]"; sw = rw; hw = r; } drive[7:4];
        field { name = "hi_cfg"; desc = "Bits 11/12: Schmitt/input-enable style bits; vendor mux writes (0x1000 / 0x1C00 / 0x1D00 / 0x1A00) always set bit 12. [GUESS]"; sw = rw; hw = r; } hi_cfg[12:11];
    } PAD_3C @ 0x3C;

    reg {
        name = "SPI0 pad 40: SPI0 pin (0x1037)";
        desc = "PAD_40 - SPI0 pad 40: SPI0 pin (0x1037). Confidence **INFERRED**. Evidence: spi0_pin_mux_gk7205v200(). Hardware not read; reset values unknown.";
        field { name = "func"; desc = "Pin function select (value 0 = GPIO/primary function; the vendor writes 1, 2, 3 or 7 for the alternates, see the evidence). [INFERRED]"; sw = rw; hw = r; } func[3:0];
        field { name = "pull_up"; desc = "Pull-up enable (IO_CFG_PULL_UP = BIT(8) in cijliu-uboot). [INFERRED]"; sw = rw; hw = r; } pull_up[8:8];
        field { name = "pull_down"; desc = "Pull-down enable (IO_CFG_PULL_DOWN = BIT(9)). [INFERRED]"; sw = rw; hw = r; } pull_down[9:9];
        field { name = "slew"; desc = "Slew-rate select (IO_CFG_SR = BIT(10)). [INFERRED]"; sw = rw; hw = r; } slew[10:10];
        field { name = "drive"; desc = "Drive strength (IO_CFG_DRV_STR_SEL, [7:4]); vendor values 0x1..0x7. [INFERRED]"; sw = rw; hw = r; } drive[7:4];
        field { name = "hi_cfg"; desc = "Bits 11/12: Schmitt/input-enable style bits; vendor mux writes (0x1000 / 0x1C00 / 0x1D00 / 0x1A00) always set bit 12. [GUESS]"; sw = rw; hw = r; } hi_cfg[12:11];
    } PAD_40 @ 0x40;

    reg {
        name = "GPIO pad 44: Used as the audio codec/amplifier reset GPIO (0x1A00 = function 0)";
        desc = "PAD_44 - GPIO pad 44: Used as the audio codec/amplifier reset GPIO (0x1A00 = function 0). Confidence **INFERRED**. Evidence: sys_config aic31_reset_gk7205v200_sck()/i2c2_pin_mux(). Hardware not read; reset values unknown.";
        field { name = "func"; desc = "Pin function select (value 0 = GPIO/primary function; the vendor writes 1, 2, 3 or 7 for the alternates, see the evidence). [INFERRED]"; sw = rw; hw = r; } func[3:0];
        field { name = "pull_up"; desc = "Pull-up enable (IO_CFG_PULL_UP = BIT(8) in cijliu-uboot). [INFERRED]"; sw = rw; hw = r; } pull_up[8:8];
        field { name = "pull_down"; desc = "Pull-down enable (IO_CFG_PULL_DOWN = BIT(9)). [INFERRED]"; sw = rw; hw = r; } pull_down[9:9];
        field { name = "slew"; desc = "Slew-rate select (IO_CFG_SR = BIT(10)). [INFERRED]"; sw = rw; hw = r; } slew[10:10];
        field { name = "drive"; desc = "Drive strength (IO_CFG_DRV_STR_SEL, [7:4]); vendor values 0x1..0x7. [INFERRED]"; sw = rw; hw = r; } drive[7:4];
        field { name = "hi_cfg"; desc = "Bits 11/12: Schmitt/input-enable style bits; vendor mux writes (0x1000 / 0x1C00 / 0x1D00 / 0x1A00) always set bit 12. [GUESS]"; sw = rw; hw = r; } hi_cfg[12:11];
    } PAD_44 @ 0x44;

    reg {
        name = "raw sensor pad 48: Raw CMOS sensor pad (0x1A02)";
        desc = "PAD_48 - raw sensor pad 48: Raw CMOS sensor pad (0x1A02). Confidence **INFERRED**. Evidence: sys_config sensor_cfg_for_raw_sensor_mux(). Hardware not read; reset values unknown.";
        field { name = "func"; desc = "Pin function select (value 0 = GPIO/primary function; the vendor writes 1, 2, 3 or 7 for the alternates, see the evidence). [INFERRED]"; sw = rw; hw = r; } func[3:0];
        field { name = "pull_up"; desc = "Pull-up enable (IO_CFG_PULL_UP = BIT(8) in cijliu-uboot). [INFERRED]"; sw = rw; hw = r; } pull_up[8:8];
        field { name = "pull_down"; desc = "Pull-down enable (IO_CFG_PULL_DOWN = BIT(9)). [INFERRED]"; sw = rw; hw = r; } pull_down[9:9];
        field { name = "slew"; desc = "Slew-rate select (IO_CFG_SR = BIT(10)). [INFERRED]"; sw = rw; hw = r; } slew[10:10];
        field { name = "drive"; desc = "Drive strength (IO_CFG_DRV_STR_SEL, [7:4]); vendor values 0x1..0x7. [INFERRED]"; sw = rw; hw = r; } drive[7:4];
        field { name = "hi_cfg"; desc = "Bits 11/12: Schmitt/input-enable style bits; vendor mux writes (0x1000 / 0x1C00 / 0x1D00 / 0x1A00) always set bit 12. [GUESS]"; sw = rw; hw = r; } hi_cfg[12:11];
    } PAD_48 @ 0x48;

    reg {
        name = "I2C2 raw alt pad 58: I2C2 for raw sensors (0x1002)";
        desc = "PAD_58 - I2C2 raw alt pad 58: I2C2 for raw sensors (0x1002). Confidence **INFERRED**. Evidence: sys_config i2c2_for_vi_raw_sensor_pin_mux(). Hardware not read; reset values unknown.";
        field { name = "func"; desc = "Pin function select (value 0 = GPIO/primary function; the vendor writes 1, 2, 3 or 7 for the alternates, see the evidence). [INFERRED]"; sw = rw; hw = r; } func[3:0];
        field { name = "pull_up"; desc = "Pull-up enable (IO_CFG_PULL_UP = BIT(8) in cijliu-uboot). [INFERRED]"; sw = rw; hw = r; } pull_up[8:8];
        field { name = "pull_down"; desc = "Pull-down enable (IO_CFG_PULL_DOWN = BIT(9)). [INFERRED]"; sw = rw; hw = r; } pull_down[9:9];
        field { name = "slew"; desc = "Slew-rate select (IO_CFG_SR = BIT(10)). [INFERRED]"; sw = rw; hw = r; } slew[10:10];
        field { name = "drive"; desc = "Drive strength (IO_CFG_DRV_STR_SEL, [7:4]); vendor values 0x1..0x7. [INFERRED]"; sw = rw; hw = r; } drive[7:4];
        field { name = "hi_cfg"; desc = "Bits 11/12: Schmitt/input-enable style bits; vendor mux writes (0x1000 / 0x1C00 / 0x1D00 / 0x1A00) always set bit 12. [GUESS]"; sw = rw; hw = r; } hi_cfg[12:11];
    } PAD_58 @ 0x58;

    reg {
        name = "I2C2 raw alt pad 5C: I2C2 for raw sensors (0x1002)";
        desc = "PAD_5C - I2C2 raw alt pad 5C: I2C2 for raw sensors (0x1002). Confidence **INFERRED**. Evidence: same Hardware not read; reset values unknown.";
        field { name = "func"; desc = "Pin function select (value 0 = GPIO/primary function; the vendor writes 1, 2, 3 or 7 for the alternates, see the evidence). [INFERRED]"; sw = rw; hw = r; } func[3:0];
        field { name = "pull_up"; desc = "Pull-up enable (IO_CFG_PULL_UP = BIT(8) in cijliu-uboot). [INFERRED]"; sw = rw; hw = r; } pull_up[8:8];
        field { name = "pull_down"; desc = "Pull-down enable (IO_CFG_PULL_DOWN = BIT(9)). [INFERRED]"; sw = rw; hw = r; } pull_down[9:9];
        field { name = "slew"; desc = "Slew-rate select (IO_CFG_SR = BIT(10)). [INFERRED]"; sw = rw; hw = r; } slew[10:10];
        field { name = "drive"; desc = "Drive strength (IO_CFG_DRV_STR_SEL, [7:4]); vendor values 0x1..0x7. [INFERRED]"; sw = rw; hw = r; } drive[7:4];
        field { name = "hi_cfg"; desc = "Bits 11/12: Schmitt/input-enable style bits; vendor mux writes (0x1000 / 0x1C00 / 0x1D00 / 0x1A00) always set bit 12. [GUESS]"; sw = rw; hw = r; } hi_cfg[12:11];
    } PAD_5C @ 0x5C;

    reg {
        name = "I2C0 raw alt pad 60: I2C0 for raw sensors (0x1002)";
        desc = "PAD_60 - I2C0 raw alt pad 60: I2C0 for raw sensors (0x1002). Confidence **INFERRED**. Evidence: sys_config i2c0_for_vi_raw_sensor_pin_mux(). Hardware not read; reset values unknown.";
        field { name = "func"; desc = "Pin function select (value 0 = GPIO/primary function; the vendor writes 1, 2, 3 or 7 for the alternates, see the evidence). [INFERRED]"; sw = rw; hw = r; } func[3:0];
        field { name = "pull_up"; desc = "Pull-up enable (IO_CFG_PULL_UP = BIT(8) in cijliu-uboot). [INFERRED]"; sw = rw; hw = r; } pull_up[8:8];
        field { name = "pull_down"; desc = "Pull-down enable (IO_CFG_PULL_DOWN = BIT(9)). [INFERRED]"; sw = rw; hw = r; } pull_down[9:9];
        field { name = "slew"; desc = "Slew-rate select (IO_CFG_SR = BIT(10)). [INFERRED]"; sw = rw; hw = r; } slew[10:10];
        field { name = "drive"; desc = "Drive strength (IO_CFG_DRV_STR_SEL, [7:4]); vendor values 0x1..0x7. [INFERRED]"; sw = rw; hw = r; } drive[7:4];
        field { name = "hi_cfg"; desc = "Bits 11/12: Schmitt/input-enable style bits; vendor mux writes (0x1000 / 0x1C00 / 0x1D00 / 0x1A00) always set bit 12. [GUESS]"; sw = rw; hw = r; } hi_cfg[12:11];
    } PAD_60 @ 0x60;

    reg {
        name = "I2C0 raw alt pad 64: I2C0 for raw sensors (0x1002)";
        desc = "PAD_64 - I2C0 raw alt pad 64: I2C0 for raw sensors (0x1002). Confidence **INFERRED**. Evidence: same Hardware not read; reset values unknown.";
        field { name = "func"; desc = "Pin function select (value 0 = GPIO/primary function; the vendor writes 1, 2, 3 or 7 for the alternates, see the evidence). [INFERRED]"; sw = rw; hw = r; } func[3:0];
        field { name = "pull_up"; desc = "Pull-up enable (IO_CFG_PULL_UP = BIT(8) in cijliu-uboot). [INFERRED]"; sw = rw; hw = r; } pull_up[8:8];
        field { name = "pull_down"; desc = "Pull-down enable (IO_CFG_PULL_DOWN = BIT(9)). [INFERRED]"; sw = rw; hw = r; } pull_down[9:9];
        field { name = "slew"; desc = "Slew-rate select (IO_CFG_SR = BIT(10)). [INFERRED]"; sw = rw; hw = r; } slew[10:10];
        field { name = "drive"; desc = "Drive strength (IO_CFG_DRV_STR_SEL, [7:4]); vendor values 0x1..0x7. [INFERRED]"; sw = rw; hw = r; } drive[7:4];
        field { name = "hi_cfg"; desc = "Bits 11/12: Schmitt/input-enable style bits; vendor mux writes (0x1000 / 0x1C00 / 0x1D00 / 0x1A00) always set bit 12. [GUESS]"; sw = rw; hw = r; } hi_cfg[12:11];
    } PAD_64 @ 0x64;

    reg {
        name = "I2C1_SCL pad: I2C1 SCL (function 1, 0x1C01)";
        desc = "PAD_A0 - I2C1_SCL pad: I2C1 SCL (function 1, 0x1C01). Confidence **INFERRED**. Evidence: sys_config i2c1_pin_mux(). Hardware not read; reset values unknown.";
        field { name = "func"; desc = "Pin function select (value 0 = GPIO/primary function; the vendor writes 1, 2, 3 or 7 for the alternates, see the evidence). [INFERRED]"; sw = rw; hw = r; } func[3:0];
        field { name = "pull_up"; desc = "Pull-up enable (IO_CFG_PULL_UP = BIT(8) in cijliu-uboot). [INFERRED]"; sw = rw; hw = r; } pull_up[8:8];
        field { name = "pull_down"; desc = "Pull-down enable (IO_CFG_PULL_DOWN = BIT(9)). [INFERRED]"; sw = rw; hw = r; } pull_down[9:9];
        field { name = "slew"; desc = "Slew-rate select (IO_CFG_SR = BIT(10)). [INFERRED]"; sw = rw; hw = r; } slew[10:10];
        field { name = "drive"; desc = "Drive strength (IO_CFG_DRV_STR_SEL, [7:4]); vendor values 0x1..0x7. [INFERRED]"; sw = rw; hw = r; } drive[7:4];
        field { name = "hi_cfg"; desc = "Bits 11/12: Schmitt/input-enable style bits; vendor mux writes (0x1000 / 0x1C00 / 0x1D00 / 0x1A00) always set bit 12. [GUESS]"; sw = rw; hw = r; } hi_cfg[12:11];
    } PAD_A0 @ 0xA0;

    reg {
        name = "I2C1_SDA pad: I2C1 SDA (function 1, 0x1C01)";
        desc = "PAD_A4 - I2C1_SDA pad: I2C1 SDA (function 1, 0x1C01). Confidence **INFERRED**. Evidence: same Hardware not read; reset values unknown.";
        field { name = "func"; desc = "Pin function select (value 0 = GPIO/primary function; the vendor writes 1, 2, 3 or 7 for the alternates, see the evidence). [INFERRED]"; sw = rw; hw = r; } func[3:0];
        field { name = "pull_up"; desc = "Pull-up enable (IO_CFG_PULL_UP = BIT(8) in cijliu-uboot). [INFERRED]"; sw = rw; hw = r; } pull_up[8:8];
        field { name = "pull_down"; desc = "Pull-down enable (IO_CFG_PULL_DOWN = BIT(9)). [INFERRED]"; sw = rw; hw = r; } pull_down[9:9];
        field { name = "slew"; desc = "Slew-rate select (IO_CFG_SR = BIT(10)). [INFERRED]"; sw = rw; hw = r; } slew[10:10];
        field { name = "drive"; desc = "Drive strength (IO_CFG_DRV_STR_SEL, [7:4]); vendor values 0x1..0x7. [INFERRED]"; sw = rw; hw = r; } drive[7:4];
        field { name = "hi_cfg"; desc = "Bits 11/12: Schmitt/input-enable style bits; vendor mux writes (0x1000 / 0x1C00 / 0x1D00 / 0x1A00) always set bit 12. [GUESS]"; sw = rw; hw = r; } hi_cfg[12:11];
    } PAD_A4 @ 0xA4;

};
`endif

`endif
