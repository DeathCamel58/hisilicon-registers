`ifndef HI3516EV200_MISC_CTRL_RDL
`define HI3516EV200_MISC_CTRL_RDL

regfile eMISC_CTRL {
    name = "Miscellaneous control (MISC_CTRL), Hi3516E V200 (vendor-code reconstruction, partial)";
    desc = "Base 0x12028000 (DT of the Fast-Ethernet MDIO node, openhisilicon sys_config reg_misc_base ioremap(0x12028000, 0x8000), cijliu-uboot MISC_REG_BASE). Confidence legend (no hardware was read for this block): PROVEN = offset and bits are used by vendor source code or by the vendor boot binary (Xiongmai stock U-Boot of a Hi3516E V200 camera) exactly as described; INFERRED = deduced from naming, from sibling chips or from a value without a bit map; GUESS = plausible only.";

    reg {
        name = "Memory/master select (comment: VGS&GZIP, VEDU&Boot RAM)";
        desc = "MISC_CTRL0 - Memory/master select (comment: VGS&GZIP, VEDU&Boot RAM). Confidence **INFERRED**. Evidence: openhisilicon sys_config sys_ctl() writes 0 with the vendor comment 'VGS&GZIP, VEDU&Boot Ram'. Hardware not read; reset values unknown.";
        field { name = "mem_sel"; desc = "Written 0 by sys_config.ko. [GUESS]"; sw = rw; hw = r; } mem_sel[31:0];
    } MISC_CTRL0 @ 0x0;

    reg {
        name = "USB PHY trim value (OTP shadow)";
        desc = "MISC_CTRL1 - USB PHY trim value (OTP shadow). Confidence **INFERRED**. Evidence: cijliu-uboot phy-hi3516ev200-usb.c USB_TRIM_BASE_REG 0x12028004, mask 0x1F, accepted 0x09..0x1D, written to the PHY trim field; DTS trim_otp_addr = 0x12028004. Hardware not read; reset values unknown.";
        field { name = "usb_trim"; desc = "OTP-provided USB PHY trim code. [INFERRED]"; sw = rw; hw = r; } usb_trim[4:0];
    } MISC_CTRL1 @ 0x4;

    reg {
        name = "VGS/GZIP control";
        desc = "MISC_CTRL4 - VGS/GZIP control. Confidence **INFERRED**. Evidence: openhisilicon sys_config sys_ctl() writes 0x35 with the comment 'VGS GZIP'. Hardware not read; reset values unknown.";
        field { name = "vgs_gzip_cfg"; desc = "0x35 written by sys_config.ko. [GUESS]"; sw = rw; hw = r; } vgs_gzip_cfg[31:0];
    } MISC_CTRL4 @ 0x10;

    reg {
        name = "MIPI_RX work mode";
        desc = "MISC_CTRL6 - MIPI_RX work mode. Confidence **PROVEN**. Evidence: openhisilicon mipi_rx_hal.c MIPI_RX_WORK_MODE_ADDR 0x12028018. Hardware not read; reset values unknown.";
        field { name = "mipi_work_mode"; desc = "Combo-mode (MIPI/LVDS/sub-LVDS/HiSPi) select of the MIPI_RX block; field layout not shown here. [INFERRED]"; sw = rw; hw = r; } mipi_work_mode[31:0];
    } MISC_CTRL6 @ 0x18;

    reg {
        name = "USB2 control 0";
        desc = "MISC_CTRL7 - USB2 control 0. Confidence **INFERRED**. Evidence: cijliu-uboot platform.h REG_USB2_CTRL0 = MISC_CTRL7; not used by the vendor U-Boot USB driver on this chip. Hardware not read; reset values unknown.";
        field { name = "usb2_ctrl0"; desc = "Unused by the vendor boot path. [GUESS]"; sw = rw; hw = r; } usb2_ctrl0[31:0];
    } MISC_CTRL7 @ 0x1C;

    reg {
        name = "Fast-Ethernet PHY control 0";
        desc = "MISC_CTRL8 - Fast-Ethernet PHY control 0. Confidence **INFERRED**. Evidence: cijliu-uboot platform.h REG_FEPHY_CTRL0 = MISC_CTRL8. Hardware not read; reset values unknown.";
        field { name = "fephy_ctrl0"; desc = "Internal PHY control; no bit usage seen in the vendor sources. [GUESS]"; sw = rw; hw = r; } fephy_ctrl0[31:0];
    } MISC_CTRL8 @ 0x20;

    reg {
        name = "Fast-Ethernet PHY control 1";
        desc = "MISC_CTRL9 - Fast-Ethernet PHY control 1. Confidence **PROVEN**. Evidence: hi3516ev200.dtsi mdio node reg 0x12028024; cijliu-uboot drivers/net/hisfv300/sys.c: bit 2 = internal PHY clock enable, bit 3 = internal PHY reset. NOTE the vendor sys.c adds this offset to SYS_CTRL_REG_BASE (0x12020024), DT and platform.h place it in MISC (0x12028024); treated as a vendor U-Boot macro slip. Hardware not read; reset values unknown.";
        field { name = "fephy_clk_en"; desc = "Internal PHY clock enable. [PROVEN]"; sw = rw; hw = r; } fephy_clk_en[2:2];
        field { name = "fephy_rst"; desc = "Internal PHY reset (1 = reset). [PROVEN]"; sw = rw; hw = r; } fephy_rst[3:3];
    } MISC_CTRL9 @ 0x24;

    reg {
        name = "eMMC/SDIO pad control 17 (INFERRED)";
        desc = "MISC_CTRL17 - eMMC/SDIO pad control 17 (INFERRED). Confidence **INFERRED**. Evidence: cijliu-uboot platform.h MISC_CTRL17 (0x44) and EMMC_ISO_EN / RG_EMMC_LHEN_IN defined for MISC_CTRL18; used by the eMMC boot path. Hardware not read; reset values unknown.";
        field { name = "misc_ctrl17"; desc = "Role unknown. [GUESS]"; sw = rw; hw = r; } misc_ctrl17[31:0];
    } MISC_CTRL17 @ 0x44;

    reg {
        name = "eMMC isolation / level-hold control";
        desc = "MISC_CTRL18 - eMMC isolation / level-hold control. Confidence **INFERRED**. Evidence: cijliu-uboot platform.h: EMMC_ISO_EN = BIT(16), RG_EMMC_LHEN_IN = 0x3F << 17. Hardware not read; reset values unknown.";
        field { name = "emmc_iso_en"; desc = "eMMC pad isolation enable. [INFERRED]"; sw = rw; hw = r; } emmc_iso_en[16:16];
        field { name = "rg_emmc_lhen_in"; desc = "eMMC level-hold enable mask. [INFERRED]"; sw = rw; hw = r; } rg_emmc_lhen_in[22:17];
    } MISC_CTRL18 @ 0x48;

    reg {
        name = "VI/VPSS online-mode switch";
        desc = "MISC_CTRL22 - VI/VPSS online-mode switch. Confidence **INFERRED**. Evidence: openhisilicon sys_config set_vi_vpss_mode(): 0x58 = 1 in all three online modes. Hardware not read; reset values unknown.";
        field { name = "mode"; desc = "1 written for every VI/VPSS online/offline mode. [GUESS]"; sw = rw; hw = r; } mode[31:0];
    } MISC_CTRL22 @ 0x58;

    reg {
        name = "VI/VPSS master priority 0";
        desc = "MISC_CTRL28 - VI/VPSS master priority 0. Confidence **INFERRED**. Evidence: sys_config set_vi_vpss_mode(): 0x123 in all modes. Hardware not read; reset values unknown.";
        field { name = "prio"; desc = "0x123 written by sys_config.ko. [GUESS]"; sw = rw; hw = r; } prio[31:0];
    } MISC_CTRL28 @ 0x70;

    reg {
        name = "VI/VPSS master priority 1";
        desc = "MISC_CTRL31 - VI/VPSS master priority 1. Confidence **INFERRED**. Evidence: sys_config set_vi_vpss_mode(): 0x123 in all modes. Hardware not read; reset values unknown.";
        field { name = "prio"; desc = "0x123 written by sys_config.ko. [GUESS]"; sw = rw; hw = r; } prio[31:0];
    } MISC_CTRL31 @ 0x7C;

    reg {
        name = "Bus master QoS table 0 (VI/VPSS online mode)";
        desc = "MISC_CTRL32 - Bus master QoS table 0 (VI/VPSS online mode). Confidence **INFERRED**. Evidence: sys_config set_vi_vpss_mode() and the vendor boot table: 0x00060005. Hardware not read; reset values unknown.";
        field { name = "qos0"; desc = "0x00060005 (all online/offline modes). [GUESS]"; sw = rw; hw = r; } qos0[31:0];
    } MISC_CTRL32 @ 0x80;

    reg {
        name = "Bus master QoS table 1";
        desc = "MISC_CTRL33 - Bus master QoS table 1. Confidence **INFERRED**. Evidence: sys_config set_vi_vpss_mode(): 0x54755676 (VI offline / VPSS offline or online), 0x44654766 (VI online/VPSS offline), 0x54655766 (both online); vendor boot table 0x54555766. Hardware not read; reset values unknown.";
        field { name = "qos1"; desc = "Per-master priority nibbles; value depends on the online mode. [GUESS]"; sw = rw; hw = r; } qos1[31:0];
    } MISC_CTRL33 @ 0x84;

    reg {
        name = "Bus master QoS table 2";
        desc = "MISC_CTRL34 - Bus master QoS table 2. Confidence **INFERRED**. Evidence: sys_config set_vi_vpss_mode(): 0x6. Hardware not read; reset values unknown.";
        field { name = "qos2"; desc = "0x6. [GUESS]"; sw = rw; hw = r; } qos2[31:0];
    } MISC_CTRL34 @ 0x88;

    reg {
        name = "Bus master QoS table 3";
        desc = "MISC_CTRL36 - Bus master QoS table 3. Confidence **INFERRED**. Evidence: sys_config set_vi_vpss_mode(): 0x00070005. Hardware not read; reset values unknown.";
        field { name = "qos3"; desc = "0x00070005. [GUESS]"; sw = rw; hw = r; } qos3[31:0];
    } MISC_CTRL36 @ 0x90;

    reg {
        name = "Bus master QoS table 4";
        desc = "MISC_CTRL37 - Bus master QoS table 4. Confidence **INFERRED**. Evidence: sys_config set_vi_vpss_mode(): 0x54665677 / 0x54655777 / 0x54755777 by mode; vendor boot table 0x54664777. Hardware not read; reset values unknown.";
        field { name = "qos4"; desc = "Per-master priority nibbles; value depends on the online mode. [GUESS]"; sw = rw; hw = r; } qos4[31:0];
    } MISC_CTRL37 @ 0x94;

    reg {
        name = "Bus master QoS table 5";
        desc = "MISC_CTRL38 - Bus master QoS table 5. Confidence **INFERRED**. Evidence: sys_config set_vi_vpss_mode(): 0x6. Hardware not read; reset values unknown.";
        field { name = "qos5"; desc = "0x6. [GUESS]"; sw = rw; hw = r; } qos5[31:0];
    } MISC_CTRL38 @ 0x98;

    reg {
        name = "Boot-time control (INFERRED)";
        desc = "MISC_CTRL45 - Boot-time control (INFERRED). Confidence **INFERRED**. Evidence: Vendor boot table writes 0xC3200000. Hardware not read; reset values unknown.";
        field { name = "ctrl"; desc = "0xC3200000 at boot. [GUESS]"; sw = rw; hw = r; } ctrl[31:0];
    } MISC_CTRL45 @ 0xB4;

    reg {
        name = "Temperature sensor status 0";
        desc = "MISC_CTRL47 - Temperature sensor status 0. Confidence **PROVEN**. Evidence: cijliu-uboot lowlevel_init_v300.c get_temperature(): TSENSOR_STATUS0 0x120280BC, [9:0] raw code; T = ((code - 117) * 212 >> 10) - 40 degC, clamped -40 (code <= 117) .. 110 (code >= 841). Hardware not read; reset values unknown.";
        field { name = "tsensor_code"; desc = "Raw temperature-sensor code. [PROVEN]"; sw = rw; hw = r; } tsensor_code[9:0];
    } MISC_CTRL47 @ 0xBC;

    reg {
        name = "Boot-time control 2 (INFERRED)";
        desc = "MISC_CTRL52 - Boot-time control 2 (INFERRED). Confidence **INFERRED**. Evidence: Vendor boot table writes 0x60000111. Hardware not read; reset values unknown.";
        field { name = "ctrl"; desc = "0x60000111 at boot. [GUESS]"; sw = rw; hw = r; } ctrl[31:0];
    } MISC_CTRL52 @ 0xD0;

    reg {
        name = "HPM (silicon speed monitor) core 0/1";
        desc = "MISC_CTRL54 - HPM (silicon speed monitor) core 0/1. Confidence **PROVEN**. Evidence: cijliu-uboot lowlevel_init_v300.c get_hpm_value(): HPM_CORE_REG0 0x120280D8: [9:0] and [25:16] are two 10-bit ring-oscillator counts; averaged over four samples and used for the SVB core-voltage choice. Hardware not read; reset values unknown.";
        field { name = "hpm0"; desc = "HPM count 0. [PROVEN]"; sw = rw; hw = r; } hpm0[9:0];
        field { name = "hpm1"; desc = "HPM count 1. [PROVEN]"; sw = rw; hw = r; } hpm1[25:16];
    } MISC_CTRL54 @ 0xD8;

    reg {
        name = "HPM core 2/3";
        desc = "MISC_CTRL55 - HPM core 2/3. Confidence **PROVEN**. Evidence: cijliu-uboot lowlevel_init_v300.c get_hpm_value(): HPM_CORE_REG1 0x120280DC, same layout as 0xD8. Hardware not read; reset values unknown.";
        field { name = "hpm2"; desc = "HPM count 2. [PROVEN]"; sw = rw; hw = r; } hpm2[9:0];
        field { name = "hpm3"; desc = "HPM count 3. [PROVEN]"; sw = rw; hw = r; } hpm3[25:16];
    } MISC_CTRL55 @ 0xDC;

};
`endif
