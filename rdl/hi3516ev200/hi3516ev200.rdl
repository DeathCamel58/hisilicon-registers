`include "defines.rdl"

`include "CRG.rdl"
`include "SYSCNT.rdl"
`include "MISC_CTRL.rdl"
`include "SYS_CTRL.rdl"
`include "IO_CONFIG.rdl"
`include "../common/ARM_PL011.rdl"
`include "../common/ARM_PL061.rdl"
`include "../common/HISI_ACODEC_V4.rdl"
`include "../common/HISI_AIAO.rdl"
`include "../common/HISI_RSA.rdl"
`include "../common/HISI_SPACC.rdl"
`include "../common/HISI_DDR_V4.rdl"
`include "../common/HISI_GZIP_V4.rdl"
`include "../common/HISI_KLAD_V4.rdl"
`include "../common/HISI_OTP_USER.rdl"
`include "../common/HISI_FEMAC.rdl"
`include "../common/HISI_FMC.rdl"
`include "../common/HISI_I2C_V2.rdl"
`include "../common/HISI_ISP_V4.rdl"
`include "../common/HISI_IVE.rdl"
`include "../common/HISI_MIPI_RX_V4.rdl"
`include "../common/HISI_LSADC_V2.rdl"
`include "../common/HISI_PWM.rdl"
`include "../common/HISI_SPI.rdl"
`include "../common/HISI_TIMER_SP804.rdl"
`include "../common/HISI_TRNG.rdl"
`include "../common/HISI_VIDEO_V4.rdl"
`include "../common/HISI_WDG_SP805.rdl"

addrmap hi3516ev200 {
    name = "hi3516ev200 registers";
    desc = "
        ## Status

        Reconstructed from vendor source and binaries, **no data sheet register chapter and no hardware read** (docs/research/hi3516ev200-blocks.md in the hi3520d-nvr workspace). Brief data sheets only: Hi3516E V200 / V300 Economical HD IP Camera SoC, Issue 03 (2019-05-15), no memory map in them.
        Chip: ARM Cortex-A7 (GIC at 0x10300000, generic timer 50 MHz), DDR at 0x40000000, SPI flash window 0x14000000. Chip name constant in the vendor U-Boot: 0x003516E200.

        Evidence sources: vendor U-Boot (cijliu-uboot, arch-hi3516ev200 + drivers), OpenIPC vendor-style kernel DT (hi3516ev200.dtsi), the open-source osdrv replacement modules (openhisilicon kernel/*), the vendor boot table that is identical in the stock Xiongmai U-Boot of an EV200 camera.

        Confidence per register file: see the desc of every register. Blocks present on the chip but not listed here (no register layout established): SDHCI MMC0/MMC1 0x10010000/0x10020000, DWC3 USB 0x10030000 + USB2 PHY 0x100D0000, SPACC/cipher 0x10050000, KLAD 0x10060000, RSA 0x10070000, OTP 0x10090000, EDMAC 0x100B0000, AIAO 0x100E0000, ACODEC 0x100F0000, GIC 0x10300000, VI 0x11000000/0x11200000, ISP 0x11220000, VO 0x11280000, VGS 0x11300000, GZIP 0x11310000, IVE 0x11320000, DDRT 0x11330000, VPSS 0x11400000, VEDU 0x11410000, JPGE 0x11420000, RTC 0x120E0000.

        <!-- overview:begin -->

        ### Diagrams

        ![Register blocks by function](assets/diagrams/hi3516ev200-blocks.svg)

        ### Clock-gate and reset map (generated from the CRG registers)

        | Offset | Register | Description | Gate / reset fields |
        |---|---|---|---|
        | 0x0F0 | PERI_CRG60 | Sensor clock/reset | sns0_clk_en, sns0_srst, sns1_clk_en |
        | 0x0F8 | PERI_CRG62 | MIPI_RX clock and reset | mipi_ck_en0, mipi_clk_en, mipi_ck_en3, mipi_core_srst, mipi_bus_srst |
        | 0x140 | PERI_CRG80 | USB2 controller and PHY clock/reset | usb2_phy_xo_cken, usb2_vcc_srst_req, usb2_phy_pll_cken, usb2_bus_cken, usb2_ref_cken, usb2_phy_apb_rst, usb2_phy_apb_cken, usb2_utmi_cken |
        | 0x144 | PERI_CRG81 | FMC | fmc_srst, fmc_clk_en |
        | 0x16C | PERI_CRG91 | Ethernet MAC | eth_srst, eth_clk_en, eth_phy_rst |
        | 0x190 | PERI_CRG100 | GZIP clock | gzip_clk_en |
        | 0x194 | PERI_CRG101 | EDMAC clock/reset | edmac_srst, edmac_clk_en, edmac_axi_clk_en |
        | 0x1A0 | PERI_CRG104 | Crypto engines clock/reset | klad_srst, klad_clk_en, trng_srst, trng_clk_en, rsa_srst, rsa_clk_en, cipher_srst, cipher_clk_en |
        | 0x1B8 | PERI_CRG110 | UART/I2C clock gates and resets | uart0_clk_en, uart1_clk_en, uart2_clk_en, i2c0_clk_en, i2c1_clk_en, i2c2_clk_en |
        | 0x1BC | PERI_CRG111 | SPI/LSADC clocks, UART clock selects | lsadc_clk_en, otp_clk_en, lsadc_srst, spi0_clk_en, spi1_clk_en |
        | 0x1F4 | PERI_CRG125 | eMMC/SDIO0 controller clock, reset and sample DLL control | mmc0_sampl_dll_slave_en, mmc0_srst, mmc0_clk_en, mmc0_drv_dll_srst |
        | 0x22C | PERI_CRG139 | SDIO1 controller clock, reset and sample DLL control | mmc1_sampl_dll_slave_en, mmc1_srst, mmc1_clk_en, mmc1_drv_dll_srst |

        Only fields whose names contain a clock-enable or reset keyword are listed; the field descriptions in the register pages give the polarity and the clocks they gate.

        ### Register blocks (generated from this description)

        | Base | Instance | Block | Register space |
        |---|---|---|---|
        | 0x10000000 | FMC | HiSilicon flash memory controller v100 (SPI NOR / SPI NAND) | 224 B |
        | 0x10040000 | ETH | HiSilicon femac v2 Fast Ethernet MAC with MDIO | 5184 B |
        | 0x10050000 | CIPHER | SPACC (symmetric cipher + hash engine) | 3 KB |
        | 0x10060000 | KLAD | Key ladder (KLAD), Hi3516E V200 / V300 generation | 48 B |
        | 0x10070000 | RSA | RSA (SEC_RSA modular exponentiation engine) | 152 B |
        | 0x10080000 | TRNG | HISEC_TRNG_CTRL (true random number generator) | 540 B |
        | 0x10090000 | OTP_USER | OTP Ctrl user interface | 80 B |
        | 0x100C0000 | IO_CONFIG_AHB | IO configuration (pin mux + pad control), AHB/peripheral pads (SFC, eMMC/SDIO, USB, IR, SPI1), Hi3516E V200 | 160 B |
        | 0x100E0000 | AIAO | AIAO (audio input/output) | 8368 B |
        | 0x100F0000 | ACODEC | Internal audio codec (ACODEC), Hi3516E V200 / V300 generation | 224 B |
        | 0x11010000 | VICAP_CH | ISP VICAP channel registers (Hi3516E V200 generation) | 540 B |
        | 0x11020000 | ISP_FE | ISP front end registers (Hi3516E V200 generation) | 45336 B |
        | 0x11200000 | VIPROC | VI processing (VIPROC) registers (Hi3516E V200 generation) | 1920 B |
        | 0x11220000 | ISP_BE | ISP back end registers (Hi3516E V200 generation) | 32384 B |
        | 0x11240000 | MIPI_RX | MIPI RX / LVDS / sub-LVDS receiver (D-PHY + controller), Hi3516E V200 generation | 8188 B |
        | 0x112C0000 | IO_CONFIG_VIO | IO configuration (pin mux + pad control), video-IO pads (VI/MIPI, sensor clock/reset, I2C0..2, SPI0), Hi3516E V200 | 168 B |
        | 0x11300000 | VGS | VGS (graphics/scaler, also serves TDE calls) control registers, V4 | 820 B |
        | 0x11310000 | GZIP | Hardware gzip decompressor (GZIP), Hi3516E V200 / V300 generation | 16388 B |
        | 0x11320000 | IVE | HiSilicon intelligent video engine | 148 B |
        | 0x11400000 | VPSS | VPSS control and channel registers, V4 | 1796 B |
        | 0x11410000 | VEDU | VEDU (H.264/H.265 encoder) control registers, V4 | 12308 B |
        | 0x11420000 | JPGE | JPGE (JPEG encoder) control registers, V4 | 3088 B |
        | 0x12000000 | TIMER0 | Timer Registers | 28 B |
        | 0x12000020 | TIMER1 | Timer Registers | 28 B |
        | 0x12001000 | TIMER2 | Timer Registers | 28 B |
        | 0x12001020 | TIMER3 | Timer Registers | 28 B |
        | 0x12010000 | CRG | Clock and reset generator (CRG), Hi3516E V200 (vendor-code reconstruction, partial) | 560 B |
        | 0x12020000 | SYS_CTRL | System controller (SYS_CTRL), Hi3516E V200 (vendor-code reconstruction, partial) | 3812 B |
        | 0x12028000 | MISC_CTRL | Miscellaneous control (MISC_CTRL), Hi3516E V200 (vendor-code reconstruction, partial) | 224 B |
        | 0x12030000 | WDG | Watchdog Registers | 3076 B |
        | 0x12040000 | UART0 | UART (ARM PrimeCell PL011) | 4 KB |
        | 0x12041000 | UART1 | UART (ARM PrimeCell PL011) | 4 KB |
        | 0x12042000 | UART2 | UART (ARM PrimeCell PL011) | 4 KB |
        | 0x12050000 | SYSCNT | System counter (ARM generic timer counter control frame), Hi3516E V200 | 36 B |
        | 0x12060000 | I2C0 | HiSilicon I2C Master Controller V2 (command-FIFO, timing-command sequencer) | 236 B |
        | 0x12061000 | I2C1 | HiSilicon I2C Master Controller V2 (command-FIFO, timing-command sequencer) | 236 B |
        | 0x12062000 | I2C2 | HiSilicon I2C Master Controller V2 (command-FIFO, timing-command sequencer) | 236 B |
        | 0x12070000 | SPI0 | SPI Registers | 48 B |
        | 0x12071000 | SPI1 | SPI Registers | 48 B |
        | 0x12080000 | PWM | HiSilicon PWM group | 128 B |
        | 0x120A0000 | LSADC | HiSilicon LSADC controller, 10-bit generation (2-3 channels) | 56 B |
        | 0x120B0000 | GPIO0 | ARM PL061 | 1053 B |
        | 0x120B1000 | GPIO1 | ARM PL061 | 1053 B |
        | 0x120B2000 | GPIO2 | ARM PL061 | 1053 B |
        | 0x120B3000 | GPIO3 | ARM PL061 | 1053 B |
        | 0x120B4000 | GPIO4 | ARM PL061 | 1053 B |
        | 0x120B5000 | GPIO5 | ARM PL061 | 1053 B |
        | 0x120B6000 | GPIO6 | ARM PL061 | 1053 B |
        | 0x120B7000 | GPIO7 | ARM PL061 | 1053 B |
        | 0x120B8000 | GPIO8 | ARM PL061 | 1053 B |
        | 0x120B9000 | GPIO9 | ARM PL061 | 1053 B |
        | 0x120C0000 | IO_CONFIG_CORE | IO configuration (pin mux + pad control), core pads (LSADC, GPIO1), Hi3516E V200 | 36 B |
        | 0x120D0000 | DDR_AXI | DDR AXI/QoS switch (window 0x120D0000), Hi3516E V200 | 17156 B |
        | 0x120D8000 | DDR_DMC | DDR DMC (DDRC V520), Hi3516E V200 (window 0x120D8000) | 1196 B |
        | 0x120DC000 | DDR_PHY | DDR PHY (T28), Hi3516E V200 (window 0x120DC000, extends to 0x120DD000) | 4212 B |

        The table is generated from the elaborated root (instances at their absolute addresses; register space is the span of the block's registers, not the data sheet window).

        <!-- overview:end -->
    ";

    eHISI_FMC              FMC            @ 0x10000000;
    eHISI_FEMAC            ETH            @ 0x10040000;
    eHISI_TRNG             TRNG           @ 0x10080000;
    eIO_CONFIG_AHB         IO_CONFIG_AHB  @ 0x100C0000;
    eHISI_MIPI_RX_V4       MIPI_RX        @ 0x11240000;
    eIO_CONFIG_VIO         IO_CONFIG_VIO  @ 0x112C0000;
    eHISI_TIMER_SP804      TIMER0         @ 0x12000000;
    eHISI_TIMER_SP804      TIMER1         @ 0x12000020;
    eHISI_TIMER_SP804      TIMER2         @ 0x12001000;
    eHISI_TIMER_SP804      TIMER3         @ 0x12001020;
    eCRG                   CRG            @ 0x12010000;
    eSYS_CTRL_EV200        SYS_CTRL       @ 0x12020000;
    eMISC_CTRL             MISC_CTRL      @ 0x12028000;
    eHISI_WDG_SP805        WDG            @ 0x12030000;
    eARM_PL011             UART0          @ 0x12040000;
    eARM_PL011             UART1          @ 0x12041000;
    eARM_PL011             UART2          @ 0x12042000;
    eHISI_I2C_V2           I2C0           @ 0x12060000;
    eHISI_I2C_V2           I2C1           @ 0x12061000;
    eHISI_I2C_V2           I2C2           @ 0x12062000;
    eHISI_SPI              SPI0           @ 0x12070000;
    eHISI_SPI              SPI1           @ 0x12071000;
    eHISI_PWM_GRP          PWM            @ 0x12080000;
    eHISI_LSADC_V2         LSADC          @ 0x120A0000;
    eARM_PL061             GPIO0          @ 0x120B0000;
    eARM_PL061             GPIO1          @ 0x120B1000;
    eARM_PL061             GPIO2          @ 0x120B2000;
    eARM_PL061             GPIO3          @ 0x120B3000;
    eARM_PL061             GPIO4          @ 0x120B4000;
    eARM_PL061             GPIO5          @ 0x120B5000;
    eARM_PL061             GPIO6          @ 0x120B6000;
    eARM_PL061             GPIO7          @ 0x120B7000;
    eARM_PL061             GPIO8          @ 0x120B8000;
    eARM_PL061             GPIO9          @ 0x120B9000;
    eIO_CONFIG_CORE        IO_CONFIG_CORE @ 0x120C0000;
    eDDR_AXI_V4            DDR_AXI        @ 0x120D0000;
    eDDR_DMC_V4            DDR_DMC        @ 0x120D8000;
    eDDR_PHY_V4            DDR_PHY        @ 0x120DC000;
    eSYSCNT_EV200          SYSCNT         @ 0x12050000;
    eHISI_KLAD_V4          KLAD           @ 0x10060000;
    eHISI_OTP_USER         OTP_USER       @ 0x10090000;
    eHISI_GZIP_V4          GZIP           @ 0x11310000;
    eHISI_SPACC            CIPHER         @ 0x10050000;
    eHISI_RSA              RSA            @ 0x10070000;
    eHISI_AIAO             AIAO           @ 0x100E0000;
    eHISI_ACODEC_V4        ACODEC         @ 0x100F0000;
    eISP_VICAP_CH_V4       VICAP_CH       @ 0x11010000;
    eISP_FE_V4             ISP_FE         @ 0x11020000;
    eVIPROC_V4             VIPROC         @ 0x11200000;
    eISP_BE_V4             ISP_BE         @ 0x11220000;
    eHISI_IVE              IVE            @ 0x11320000;
    eVGS_V4                VGS            @ 0x11300000;
    eVPSS_V4               VPSS           @ 0x11400000;
    eVEDU_V4               VEDU           @ 0x11410000;
    eJPGE_V4               JPGE           @ 0x11420000;
};
