`include "defines.rdl"

`include "CRG.rdl"
`include "SYSCNT.rdl"
`include "MISC_CTRL.rdl"
`include "SYS_CTRL.rdl"
`include "IO_CONFIG.rdl"
`include "../common/ARM_PL011.rdl"
`include "../common/ARM_PL061.rdl"
`include "../common/HISI_ACODEC_V4.rdl"
`include "../common/HISI_AIAO.rdl"
`include "../common/HISI_RSA.rdl"
`include "../common/HISI_SPACC.rdl"
`include "../common/HISI_DDR_V4.rdl"
`include "../common/HISI_GZIP_V4.rdl"
`include "../common/HISI_KLAD_V4.rdl"
`include "../common/HISI_OTP_USER.rdl"
`include "../common/HISI_FEMAC.rdl"
`include "../common/HISI_FMC.rdl"
`include "../common/HISI_I2C_V2.rdl"
`include "../common/HISI_ISP_V4.rdl"
`include "../common/HISI_IVE.rdl"
`include "../common/HISI_MIPI_RX_V4.rdl"
`include "../common/HISI_LSADC_V2.rdl"
`include "../common/HISI_PWM.rdl"
`include "../common/HISI_SPI.rdl"
`include "../common/HISI_TIMER_SP804.rdl"
`include "../common/HISI_TRNG.rdl"
`include "../common/HISI_VIDEO_V4.rdl"
`include "../common/HISI_WDG_SP805.rdl"

addrmap hi3516ev200 {
    name = "hi3516ev200 registers";
    desc = "
        ## Status

        Reconstructed from vendor source and binaries, **no data sheet register chapter and no hardware read** (docs/research/hi3516ev200-blocks.md in the hi3520d-nvr workspace). Brief data sheets only: Hi3516E V200 / V300 Economical HD IP Camera SoC, Issue 03 (2019-05-15), no memory map in them.
        Chip: ARM Cortex-A7 (GIC at 0x10300000, generic timer 50 MHz), DDR at 0x40000000, SPI flash window 0x14000000. Chip name constant in the vendor U-Boot: 0x003516E200.

        Evidence sources: vendor U-Boot (cijliu-uboot, arch-hi3516ev200 + drivers), OpenIPC vendor-style kernel DT (hi3516ev200.dtsi), the open-source osdrv replacement modules (openhisilicon kernel/*), the vendor boot table that is identical in the stock Xiongmai U-Boot of an EV200 camera.

        Confidence per register file: see the desc of every register. Blocks present on the chip but not listed here (no register layout established): SDHCI MMC0/MMC1 0x10010000/0x10020000, DWC3 USB 0x10030000 + USB2 PHY 0x100D0000, SPACC/cipher 0x10050000, KLAD 0x10060000, RSA 0x10070000, OTP 0x10090000, EDMAC 0x100B0000, AIAO 0x100E0000, ACODEC 0x100F0000, GIC 0x10300000, VI 0x11000000/0x11200000, ISP 0x11220000, VO 0x11280000, VGS 0x11300000, GZIP 0x11310000, IVE 0x11320000, DDRT 0x11330000, VPSS 0x11400000, VEDU 0x11410000, JPGE 0x11420000, RTC 0x120E0000.

        <!-- overview:begin -->

        ### Diagrams

        ![Logic block diagram](assets/diagrams/hi3516ev200-logic.svg)

        ![Register blocks by function](assets/diagrams/hi3516ev200-blocks.svg)

        ![Clock tree](assets/diagrams/hi3516ev200-clocks.svg)

        ![Boot flow](assets/diagrams/hi3516ev200-boot.svg)

        ![Video pipeline](assets/diagrams/hi3516ev200-video.svg)

        ![Reset tree](assets/diagrams/hi3516ev200-resets.svg)

        ![Storage, USB and Ethernet paths](assets/diagrams/hi3516ev200-io.svg)

        ![DMA request lines](assets/diagrams/hi3516ev200-dma.svg)

        ### Sources and what is missing

        There is no Hi3516E V200 data sheet with a register chapter, memory map, interrupt table, DMA table or pin list in the workspace. The material is: the brief data sheet (Issue 03, 2019-05-15, 7 pages, key specifications and one block diagram), the Hi3518E V300 brief data sheet, the Hi3516E V300 data sheet (same SoC generation, shared blocks), and vendor-derived evidence (vendor U-Boot, OpenIPC device tree, open-source SDK modules; docs/research/hi3516ev200-blocks.md). Everything below marked VENDOR-DERIVED or INFERRED rests on those; nothing was read from an EV200. Missing: PLL and clock-select frequencies read from hardware, the pad and pin list, the boot-pin names, an interrupt table printed by the vendor, and register chapters for most blocks.

        ### Variants and key specifications (brief data sheets)

        Hi3516E V200 (economical HD IP camera, this folder) and Hi3518E V300 (consumer camera) have the same specifications except the microphone input. The chip ID register (SYS_CTRL 0xEE0) reads 0x3516E200 for the V200 and 0x3518E300 for the V300 in the vendor temperature-control module (INFERRED same register map). The Hi3516E V300 is the larger sibling (folder hi3516ev300).

        | | Hi3516E V200 | Hi3518E V300 |
        |---|---|---|
        | CPU | Cortex-A7 up to 900 MHz, NEON + FPU, 32 KB I + 32 KB D L1, 128 KB L2 | same |
        | DDR | built-in 512 Mbit DDR2, 16-bit, 1.8 V | built-in 512 Mbit DDR2, 16-bit |
        | Video encode | H.264 BP/MP/HP, H.265 MP, MJPEG/JPEG; up to 2304 x 1296; 2048 x 1536@20 + 720 x 576@20, 2304 x 1296@20 + 720 x 576@20, 1920 x 1080@30 + 720 x 576@30; JPEG 3M@5; 8 ROIs; up to 60 Mbit/s | same |
        | Video input | 8/10/12-bit Bayer DC timing, MIPI, LVDS / sub-LVDS, HiSPi; up to 2304 x 1296; programmable sensor clock out | same |
        | Video output | 6/8-bit LCD, BT.656 / BT.1120 | 6/8-bit LCD, BT.656 |
        | Audio | integrated codec 16-bit, mono MIC / line-in, mono line-out, I2S | dual MIC / line-in, mono line-out, I2S |
        | Storage and network | SPI NOR (256 MB max), SPI NAND (1 GB max), eMMC 4.5 4-bit; 1 x SDIO 2.0 + 1 x SD 2.0; USB 2.0 host / device; FE PHY with TSO | same |
        | Peripherals | RTC, POR, 2-channel LSADC, 3 UART, I2C, SPI, GPIO, 4 PWM | same |
        | Security | AES, RSA, SHA1/SHA256/HMAC, 32 kbit OTP, TRNG, secure boot | same |
        | Package and power | QFN 9 x 9 mm, 88 pins, 0.35 mm pitch; core 0.9 V, I/O 3.3 V, SDRAM 1.8 V; 700 mW typical (1080P30 / 3M20) | same |

        ### Boot (brief data sheet; VENDOR-DERIVED strap bits)

        The brief data sheet states: boot from SPI NOR, SPI NAND or eMMC, with secure boot. The boot-pin names, the serial / SD / USB burn modes and the strap-to-mode table of the V300 (BOOT_SEL1, BOOT_SEL0, UPDATE_MODE) are not given for the V200. The vendor U-Boot reads SYS_CTRL SC_SYSSTAT (0x8C): bit 4 selects SPI flash or eMMC, bit 7 the NOR 4-byte address mode, bit 10 SPI NAND, bit 16 the SPI pad alternate (SFC on the SDIO1 pads). The boot ROM loads stage 1 into on-chip SRAM at 0x04010500, which replays a 248-entry register table (DDR, clocks, pads) before the main U-Boot runs.

        ### DMA request lines (INFERRED from the Hi3516E V300 data sheet Table 3-8)

        The vendor device tree describes an EDMAC (hiedmacv310) with four channels and 32 request lines at 0x100B0000. The line assignment below is the V300 table; the vendor notes agree for UART1/2 (18-21) and SPI0/1 (26-29); the other lines (I2C, UART0) are INFERRED.

        | ID | Peripheral | ID | Peripheral | ID | Peripheral |
        |---|---|---|---|---|---|
        | 0 | I2C0 RX | 16 | UART0 RX | 26 | SPI0 RX |
        | 1 | I2C0 TX | 17 | UART0 TX | 27 | SPI0 TX |
        | 2 | I2C1 RX | 18 | UART1 RX | 28 | SPI1 RX |
        | 3 | I2C1 TX | 19 | UART1 TX | 29 | SPI1 TX |
        | 4 | I2C2 RX | 20 | UART2 RX | 6-15, 22-25, 30-31 | reserved |
        | 5 | I2C2 TX | 21 | UART2 TX | | |

        ### Pinmux function summary (VENDOR-DERIVED)

        The pad registers are in three banks (IO config ahb 0x100C0000, core 0x120C0000, vio 0x112C0000, 52 pad registers in the RDL), one 32-bit word per pad: [3:0] function, [7:4] drive, [8] pull-up, [9] pull-down, [10] slew (INFERRED from U-Boot pad code). No pin names exist in any source.

        | Function | Bank and pad offsets | Note |
        |---|---|---|
        | VI / MIPI pads | vio 0x00 - 0x14 | function 0 = MIPI RX, 1 = BT.1120, 2 = raw |
        | Sensor clock and reset | vio 0x28, 0x2C | function 1 |
        | I2C0 | vio 0x30, 0x34 | function 1 |
        | I2C2 or SPI0 | vio 0x38, 0x3C | function 1 or 7 |
        | I2C1 | vio 0xA0, 0xA4 | |
        | IR input | ahb 0x08 | function 2 |
        | LSADC | core 0x00, 0x04 | function 1 |

        ### Power and reset domains (VENDOR-DERIVED)

        * The brief data sheet lists the integrated POR, RTC and audio codec and the supply levels (core 0.9 V, I/O 3.3 V, SDRAM 1.8 V). It has no PMC, PWR_SEQ or power-domain description; the V200 has no PMC block in the RDL (the V300 data sheet describes one at 0x120F0000).
        * A runtime adaptive-voltage-scaling module in the vendor SDK reads the HPM word (SYS_CTRL 0x15C) and the temperature sensor (MISC 0xBC) and drives a PWM channel to set the core voltage: 992 mV for HPM up to 190, 812 mV from HPM 310, a linear value in between (vendor-code constants).
        * Resets: the CRG holds a reset bit next to the clock-enable bit of every block (map below); the SYS_CTRL SC_SYSRES register (offset 0x04) is the vendor reboot path. The two-level scheme of the V300 data sheet is assumed (INFERRED).

        ### Clock selections (VENDOR-DERIVED)

        PERI_CRG32 (0x80): bit 6 selects SYSAXI (24 / 200 MHz), bit 10 SYSAPB (24 / 50 MHz); boot code writes 0x559 and polls the status register 0x1E0. FMC (0x144 [4:2]): 24 / 100 / 150 / 200 / 300 / 360 MHz. FEMAC (0x16C): bit 7 core clock 100 / 54 MHz. MMC0 (0x1F4) and MMC1 (0x22C): select [26:24] 100 kHz / 400 kHz / 25 / 50 / 90 / 112 / 150 MHz. Sensor clock (0xF0 [5:2]): 74.25 / 72 / 54 / 24 / 37.125 / 36 / 27 / 12 MHz. UART clocks (0x1BC bits 18-20): 24 or 6 MHz. PLL registers PERI_CRG_PLL0..7 are INFERRED words; the boot ROM programs the PLLs and no EV200 source reads them.

        ### Bus matrix

        No source describes the interconnect or the DDR QoS groups of the V200 in text. The vendor boot table programs 12 DDRC AXI QoS ports (0x120D0200 - 0x120D02B4) and the MISC bus QoS words (0x80 - 0x98); the V300 data sheet names the masters of those words (see the hi3516ev300 bus diagram); the assignment is assumed equal (INFERRED), so no separate figure is drawn.

        ### Interrupts (GIC interrupt IDs; VENDOR-DERIVED, names from the Hi3516E V300 data sheet Table 3-6)

        GIC INTID = SPI number + 32. Every row not marked with an asterisk was checked against the vendor device tree (OpenIPC hi3516ev200.dtsi, docs/research/hi3516ev200-blocks.md): its SPI number equals the V300 data sheet bit minus 32. Rows marked * are not in the vendor device tree and are taken from the Hi3516E V300 table (same block, INFERRED for the V200). No V200 data sheet interrupt table exists in the workspace.

        | # | Source | # | Source | # | Source |
        |---|---|---|---|---|---|
        | 0-31 | CPU internal (SGI / PPI) | 52 | GPIO4 | 73 | Reserved |
        | 32 | RTC | 53 | GPIO5 | 74 | AIAO |
        | 33 | SOFTWARE | 54 | GPIO6 | 75 | VICAP (the ISP shares this line) |
        | 34 | WDG | 55 | GPIO7 | 76 | VIPROC |
        | 35 | Reserved | 56 | GPIO8 | 77 | MIPI_RX |
        | 36 | LSADC | 57 | GPIO9* | 78 | VPSS |
        | 37 | Timer0/Timer1 | 58 | Reserved | 79 | VEDU |
        | 38 | Timer2/Timer3 | 59 | Reserved | 80 | JPGE |
        | 39 | UART0 | 60 | Reserved | 81 | VGS |
        | 40 | UART1 | 61 | Reserved | 82 | GZIP |
        | 41 | UART2 | 62 | SDIO0 (MMC0) | 83 | IVE |
        | 42 | Reserved | 63 | SDIO1 (MMC1) | 84 | Reserved |
        | 43 | I2C0* | 64 | FMC* | 85 | DDRT* |
        | 44 | I2C1* | 65 | ETH (FEMAC) | 86 | DDR_ERR* |
        | 45 | I2C2* | 66 | SPACC (cipher + hash, one IRQ) | 87 | Reserved |
        | 46 | SPI0 | 67 | Reserved | 88 | A7_COMMTX* |
        | 47 | SPI1 | 68 | Reserved | 89 | A7_COMMRX* |
        | 48 | GPIO0 | 69 | Reserved | 90 | A7_PMUIRQ |
        | 49 | GPIO1 | 70 | DMA (EDMAC) | 91 | FE PHY* |
        | 50 | GPIO2 | 71 | USB2 | 92-95 | Reserved |
        | 51 | GPIO3* | 72 | VDP |  |  |

        ### Clock-gate and reset map (generated from the CRG registers)

        | Offset | Register | Description | Gate / reset fields |
        |---|---|---|---|
        | 0x0F0 | PERI_CRG60 | Sensor clock/reset | sns0_clk_en, sns0_srst, sns1_clk_en |
        | 0x0F8 | PERI_CRG62 | MIPI_RX clock and reset | mipi_ck_en0, mipi_clk_en, mipi_ck_en3, mipi_core_srst, mipi_bus_srst |
        | 0x140 | PERI_CRG80 | USB2 controller and PHY clock/reset | usb2_phy_xo_cken, usb2_vcc_srst_req, usb2_phy_pll_cken, usb2_bus_cken, usb2_ref_cken, usb2_phy_apb_rst, usb2_phy_apb_cken, usb2_utmi_cken |
        | 0x144 | PERI_CRG81 | FMC | fmc_srst, fmc_clk_en |
        | 0x16C | PERI_CRG91 | Ethernet MAC | eth_srst, eth_clk_en, eth_phy_rst |
        | 0x190 | PERI_CRG100 | GZIP clock | gzip_clk_en |
        | 0x194 | PERI_CRG101 | EDMAC clock/reset | edmac_srst, edmac_clk_en, edmac_axi_clk_en |
        | 0x1A0 | PERI_CRG104 | Crypto engines clock/reset | klad_srst, klad_clk_en, trng_srst, trng_clk_en, rsa_srst, rsa_clk_en, cipher_srst, cipher_clk_en |
        | 0x1B8 | PERI_CRG110 | UART/I2C clock gates and resets | uart0_clk_en, uart1_clk_en, uart2_clk_en, i2c0_clk_en, i2c1_clk_en, i2c2_clk_en |
        | 0x1BC | PERI_CRG111 | SPI/LSADC clocks, UART clock selects | lsadc_clk_en, otp_clk_en, lsadc_srst, spi0_clk_en, spi1_clk_en |
        | 0x1F4 | PERI_CRG125 | eMMC/SDIO0 controller clock, reset and sample DLL control | mmc0_sampl_dll_slave_en, mmc0_srst, mmc0_clk_en, mmc0_drv_dll_srst |
        | 0x22C | PERI_CRG139 | SDIO1 controller clock, reset and sample DLL control | mmc1_sampl_dll_slave_en, mmc1_srst, mmc1_clk_en, mmc1_drv_dll_srst |

        Only fields whose names contain a clock-enable or reset keyword are listed; the field descriptions in the register pages give the polarity and the clocks they gate.

        ### Register blocks (generated from this description)

        | Base | Instance | Block | Register space |
        |---|---|---|---|
        | 0x10000000 | FMC | HiSilicon flash memory controller v100 (SPI NOR / SPI NAND) | 224 B |
        | 0x10040000 | ETH | HiSilicon femac v2 Fast Ethernet MAC with MDIO | 5184 B |
        | 0x10050000 | CIPHER | SPACC (symmetric cipher + hash engine) | 3 KB |
        | 0x10060000 | KLAD | Key ladder (KLAD), Hi3516E V200 / V300 generation | 48 B |
        | 0x10070000 | RSA | RSA (SEC_RSA modular exponentiation engine) | 152 B |
        | 0x10080000 | TRNG | HISEC_TRNG_CTRL (true random number generator) | 540 B |
        | 0x10090000 | OTP_USER | OTP Ctrl user interface | 80 B |
        | 0x100C0000 | IO_CONFIG_AHB | IO configuration (pin mux + pad control), AHB/peripheral pads (SFC, eMMC/SDIO, USB, IR, SPI1), Hi3516E V200 | 160 B |
        | 0x100E0000 | AIAO | AIAO (audio input/output) | 8368 B |
        | 0x100F0000 | ACODEC | Internal audio codec (ACODEC), Hi3516E V200 / V300 generation | 224 B |
        | 0x11010000 | VICAP_CH | ISP VICAP channel registers (Hi3516E V200 generation) | 540 B |
        | 0x11020000 | ISP_FE | ISP front end registers (Hi3516E V200 generation) | 45336 B |
        | 0x11200000 | VIPROC | VI processing (VIPROC) registers (Hi3516E V200 generation) | 1920 B |
        | 0x11220000 | ISP_BE | ISP back end registers (Hi3516E V200 generation) | 32384 B |
        | 0x11240000 | MIPI_RX | MIPI RX / LVDS / sub-LVDS receiver (D-PHY + controller), Hi3516E V200 generation | 8188 B |
        | 0x112C0000 | IO_CONFIG_VIO | IO configuration (pin mux + pad control), video-IO pads (VI/MIPI, sensor clock/reset, I2C0..2, SPI0), Hi3516E V200 | 168 B |
        | 0x11300000 | VGS | VGS (graphics/scaler, also serves TDE calls) control registers, V4 | 820 B |
        | 0x11310000 | GZIP | Hardware gzip decompressor (GZIP), Hi3516E V200 / V300 generation | 16388 B |
        | 0x11320000 | IVE | HiSilicon intelligent video engine | 148 B |
        | 0x11400000 | VPSS | VPSS control and channel registers, V4 | 1796 B |
        | 0x11410000 | VEDU | VEDU (H.264/H.265 encoder) control registers, V4 | 12308 B |
        | 0x11420000 | JPGE | JPGE (JPEG encoder) control registers, V4 | 3088 B |
        | 0x12000000 | TIMER0 | Timer Registers | 28 B |
        | 0x12000020 | TIMER1 | Timer Registers | 28 B |
        | 0x12001000 | TIMER2 | Timer Registers | 28 B |
        | 0x12001020 | TIMER3 | Timer Registers | 28 B |
        | 0x12010000 | CRG | Clock and reset generator (CRG), Hi3516E V200 (vendor-code reconstruction, partial) | 560 B |
        | 0x12020000 | SYS_CTRL | System controller (SYS_CTRL), Hi3516E V200 (vendor-code reconstruction, partial) | 3812 B |
        | 0x12028000 | MISC_CTRL | Miscellaneous control (MISC_CTRL), Hi3516E V200 (vendor-code reconstruction, partial) | 224 B |
        | 0x12030000 | WDG | Watchdog Registers | 3076 B |
        | 0x12040000 | UART0 | UART (ARM PrimeCell PL011) | 4 KB |
        | 0x12041000 | UART1 | UART (ARM PrimeCell PL011) | 4 KB |
        | 0x12042000 | UART2 | UART (ARM PrimeCell PL011) | 4 KB |
        | 0x12050000 | SYSCNT | System counter (ARM generic timer counter control frame), Hi3516E V200 | 36 B |
        | 0x12060000 | I2C0 | HiSilicon I2C Master Controller V2 (command-FIFO, timing-command sequencer) | 236 B |
        | 0x12061000 | I2C1 | HiSilicon I2C Master Controller V2 (command-FIFO, timing-command sequencer) | 236 B |
        | 0x12062000 | I2C2 | HiSilicon I2C Master Controller V2 (command-FIFO, timing-command sequencer) | 236 B |
        | 0x12070000 | SPI0 | SPI Registers | 48 B |
        | 0x12071000 | SPI1 | SPI Registers | 48 B |
        | 0x12080000 | PWM | HiSilicon PWM group | 128 B |
        | 0x120A0000 | LSADC | HiSilicon LSADC controller, 10-bit generation (2-3 channels) | 56 B |
        | 0x120B0000 | GPIO0 | ARM PL061 | 1053 B |
        | 0x120B1000 | GPIO1 | ARM PL061 | 1053 B |
        | 0x120B2000 | GPIO2 | ARM PL061 | 1053 B |
        | 0x120B3000 | GPIO3 | ARM PL061 | 1053 B |
        | 0x120B4000 | GPIO4 | ARM PL061 | 1053 B |
        | 0x120B5000 | GPIO5 | ARM PL061 | 1053 B |
        | 0x120B6000 | GPIO6 | ARM PL061 | 1053 B |
        | 0x120B7000 | GPIO7 | ARM PL061 | 1053 B |
        | 0x120B8000 | GPIO8 | ARM PL061 | 1053 B |
        | 0x120B9000 | GPIO9 | ARM PL061 | 1053 B |
        | 0x120C0000 | IO_CONFIG_CORE | IO configuration (pin mux + pad control), core pads (LSADC, GPIO1), Hi3516E V200 | 36 B |
        | 0x120D0000 | DDR_AXI | DDR AXI/QoS switch (window 0x120D0000), Hi3516E V200 | 17156 B |
        | 0x120D8000 | DDR_DMC | DDR DMC (DDRC V520), Hi3516E V200 (window 0x120D8000) | 1196 B |
        | 0x120DC000 | DDR_PHY | DDR PHY (T28), Hi3516E V200 (window 0x120DC000, extends to 0x120DD000) | 4212 B |

        The table is generated from the elaborated root (instances at their absolute addresses; register space is the span of the block's registers, not the data sheet window).

        <!-- overview:end -->
    ";

    eHISI_FMC              FMC            @ 0x10000000;
    eHISI_FEMAC            ETH            @ 0x10040000;
    eHISI_TRNG             TRNG           @ 0x10080000;
    eIO_CONFIG_AHB         IO_CONFIG_AHB  @ 0x100C0000;
    eHISI_MIPI_RX_V4       MIPI_RX        @ 0x11240000;
    eIO_CONFIG_VIO         IO_CONFIG_VIO  @ 0x112C0000;
    eHISI_TIMER_SP804      TIMER0         @ 0x12000000;
    eHISI_TIMER_SP804      TIMER1         @ 0x12000020;
    eHISI_TIMER_SP804      TIMER2         @ 0x12001000;
    eHISI_TIMER_SP804      TIMER3         @ 0x12001020;
    eCRG                   CRG            @ 0x12010000;
    eSYS_CTRL_EV200        SYS_CTRL       @ 0x12020000;
    eMISC_CTRL             MISC_CTRL      @ 0x12028000;
    eHISI_WDG_SP805        WDG            @ 0x12030000;
    eARM_PL011             UART0          @ 0x12040000;
    eARM_PL011             UART1          @ 0x12041000;
    eARM_PL011             UART2          @ 0x12042000;
    eHISI_I2C_V2           I2C0           @ 0x12060000;
    eHISI_I2C_V2           I2C1           @ 0x12061000;
    eHISI_I2C_V2           I2C2           @ 0x12062000;
    eHISI_SPI              SPI0           @ 0x12070000;
    eHISI_SPI              SPI1           @ 0x12071000;
    eHISI_PWM_GRP          PWM            @ 0x12080000;
    eHISI_LSADC_V2         LSADC          @ 0x120A0000;
    eARM_PL061             GPIO0          @ 0x120B0000;
    eARM_PL061             GPIO1          @ 0x120B1000;
    eARM_PL061             GPIO2          @ 0x120B2000;
    eARM_PL061             GPIO3          @ 0x120B3000;
    eARM_PL061             GPIO4          @ 0x120B4000;
    eARM_PL061             GPIO5          @ 0x120B5000;
    eARM_PL061             GPIO6          @ 0x120B6000;
    eARM_PL061             GPIO7          @ 0x120B7000;
    eARM_PL061             GPIO8          @ 0x120B8000;
    eARM_PL061             GPIO9          @ 0x120B9000;
    eIO_CONFIG_CORE        IO_CONFIG_CORE @ 0x120C0000;
    eDDR_AXI_V4            DDR_AXI        @ 0x120D0000;
    eDDR_DMC_V4            DDR_DMC        @ 0x120D8000;
    eDDR_PHY_V4            DDR_PHY        @ 0x120DC000;
    eSYSCNT_EV200          SYSCNT         @ 0x12050000;
    eHISI_KLAD_V4          KLAD           @ 0x10060000;
    eHISI_OTP_USER         OTP_USER       @ 0x10090000;
    eHISI_GZIP_V4          GZIP           @ 0x11310000;
    eHISI_SPACC            CIPHER         @ 0x10050000;
    eHISI_RSA              RSA            @ 0x10070000;
    eHISI_AIAO             AIAO           @ 0x100E0000;
    eHISI_ACODEC_V4        ACODEC         @ 0x100F0000;
    eISP_VICAP_CH_V4       VICAP_CH       @ 0x11010000;
    eISP_FE_V4             ISP_FE         @ 0x11020000;
    eVIPROC_V4             VIPROC         @ 0x11200000;
    eISP_BE_V4             ISP_BE         @ 0x11220000;
    eHISI_IVE              IVE            @ 0x11320000;
    eVGS_V4                VGS            @ 0x11300000;
    eVPSS_V4               VPSS           @ 0x11400000;
    eVEDU_V4               VEDU           @ 0x11410000;
    eJPGE_V4               JPGE           @ 0x11420000;
};
