`ifndef HI3516EV200_SYSCNT_RDL
`define HI3516EV200_SYSCNT_RDL

regfile eSYSCNT_EV200 {
    name = "System counter (ARM generic timer counter control frame), Hi3516E V200";
    desc = "Window 0x12050000 (0x100 mapped by hi3516ev200_sys.ko SYS_HAL_Init). PROVEN: cijliu-uboot arch-hi3516ev200/platform.h defines SYSCNT_REG_BASE 0x12050000 with SYSCNT_ENABLE_REG (CNTCR) at +0x0 and SYSCNT_FREQ_REG (CNTFID0) at +0x20, SYSCNT_FREQ = 50000000 (U-Boot enables the counter and sets the frequency before the generic timer is used); the vendor DT carries clock-frequency 50000000 for the armv7-timer. INFERRED: the remaining registers follow the ARM CoreSight system-counter layout (CNTSR 0x4, CNTCV 0x8/0xC). The same header also reuses 0x12050000 as IO_CONFIG_REG_BASE (a copy-paste in the vendor header; the real pad windows are 0x100C0000, 0x120C0000, 0x112C0000). Hardware not read.";

    reg {
        name = "Counter control";
        desc = "CNTCR [PROVEN offset and role: U-Boot SYSCNT_ENABLE_REG].";
        field { name = "en"; desc = "Counter enable [PROVEN role, bit position INFERRED from the ARM layout]"; sw = rw; hw = r; } en[0:0];
    } CNTCR @ 0x0;

    reg {
        name = "Counter status";
        desc = "CNTSR [INFERRED from the ARM system-counter layout].";
        field { name = "status"; desc = "Status [INFERRED]"; sw = r; hw = w; } status[31:0];
    } CNTSR @ 0x4;

    reg {
        name = "Counter value low";
        desc = "CNTCV low word [INFERRED from the ARM layout].";
        field { name = "cntcv_lo"; desc = "Counter value [INFERRED]"; sw = rw; hw = rw; } cntcv_lo[31:0];
    } CNTCV_LO @ 0x8;

    reg {
        name = "Counter value high";
        desc = "CNTCV high word [INFERRED from the ARM layout].";
        field { name = "cntcv_hi"; desc = "Counter value [INFERRED]"; sw = rw; hw = rw; } cntcv_hi[31:0];
    } CNTCV_HI @ 0xC;

    reg {
        name = "Base frequency 0";
        desc = "CNTFID0 [PROVEN offset: U-Boot SYSCNT_FREQ_REG, value 50000000 = 50 MHz written by U-Boot].";
        field { name = "freq"; desc = "Counter frequency in Hz (50000000) [PROVEN]"; sw = rw; hw = r; } freq[31:0];
    } CNTFID0 @ 0x20;
};
`endif
