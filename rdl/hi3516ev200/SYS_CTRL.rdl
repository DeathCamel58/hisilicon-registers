`ifndef HI3516EV200_SYS_CTRL_RDL
`define HI3516EV200_SYS_CTRL_RDL

regfile eSYS_CTRL_EV200 {
    name = "System controller (SYS_CTRL), Hi3516E V200 (vendor-code reconstruction, partial)";
    desc = "Base 0x12020000 (hi3516ev200.dtsi hisilicon,sysctrl; boot-ROM start flag and strap status). Confidence legend (no hardware was read for this block): PROVEN = offset and bits are used by vendor source code or by the vendor boot binary (Xiongmai stock U-Boot of a Hi3516E V200 camera) exactly as described; INFERRED = deduced from naming, from sibling chips or from a value without a bit map; GUESS = plausible only.";

    reg {
        name = "System control";
        desc = "SC_CTRL - System control. Confidence **PROVEN**. Evidence: cijliu-uboot platform.h: bit 8 = remap clear (SC_CTRL_REMAP_CLEAR), bit 16 = timer0 clock select (0 = 3 MHz, 1 = bus clock). Bits 19 and 20 added 2026-11-11 from the camhi-motor.ko probe (see fields). Hardware not read; reset values unknown.";
        field { name = "remap_clear"; desc = "Write 1 to clear the boot-ROM remap. [PROVEN]"; sw = rw; hw = r; } remap_clear[8:8];
        field { name = "timer0_clk_sel"; desc = "SP804 timer 0 clock: 0 = 3 MHz, 1 = bus clock. [PROVEN]"; sw = rw; hw = r; } timer0_clk_sel[16:16];
        field { name = "timer2_clk_sel"; desc = "SP804 timer 2 clock select (0 = 3 MHz). Source: vendor module camhi-motor.ko (Hi3516E V200 osdrv, probe: read-modify-write of SC_CTRL at 0x12020000 clearing mask 0x180000, then SP804 timer at 0x12001000 loaded with 3000 and run at 3 MHz: 3000000 / rate). Bit assignment of bit 19 to timer 2 INFERRED from the 0x180000 mask and the 3 MHz timing; confidence MEDIUM; not verified on hardware."; sw = rw; hw = r; } timer2_clk_sel[19:19];
        field { name = "bit20_unk"; desc = "Unknown purpose, vendor-observed only: cleared together with bit 19 by camhi-motor.ko probe (mask 0x180000). Confidence LOW, not verified on hardware."; sw = rw; hw = r; } bit20_unk[20:20];
    } SC_CTRL @ 0x0;

    reg {
        name = "System soft reset";
        desc = "SC_SYSRES - System soft reset. Confidence **PROVEN**. Evidence: hi3516ev200.dtsi sysctrl reboot-offset = 0x4; platform.h REG_SC_SYSRES. Hardware not read; reset values unknown.";
        field { name = "sysres"; desc = "Any write resets the system (SYS_CTRL and pinmux are kept only across a soft reset per the other chips; not verified here). [PROVEN]"; sw = rw; hw = r; } sysres[31:0];
    } SC_SYSRES @ 0x4;

    reg {
        name = "System status / boot strap";
        desc = "SC_SYSSTAT - System status / boot strap. Confidence **PROVEN**. Evidence: cijliu-uboot platform.h macros: bit 4 boot medium (0 SPI, 1 eMMC), bit 7 NOR address mode (0 = 3-byte, 1 = 4-byte), bit 10 SPI device type (0 NOR, 1 NAND), bit 11 NF boot bus width, bit 16 SPI input select (SFC pins on the SDIO1 pads when 1, see hifmc_hi3516ev200.c). Hardware not read; reset values unknown.";
        field { name = "boot_mode"; desc = "Boot medium: 0 = SPI flash, 1 = eMMC. [PROVEN]"; sw = rw; hw = r; } boot_mode[4:4];
        field { name = "nor_addr4"; desc = "SPI NOR 4-byte address mode strap. [PROVEN]"; sw = rw; hw = r; } nor_addr4[7:7];
        field { name = "spi_nand"; desc = "SPI flash type strap: 1 = SPI NAND. [PROVEN]"; sw = rw; hw = r; } spi_nand[10:10];
        field { name = "nf_bootbw"; desc = "NAND boot bus width strap. [PROVEN]"; sw = rw; hw = r; } nf_bootbw[11:11];
        field { name = "spi_input_sel"; desc = "1 = SFC signals routed to the SDIO1 pads. [PROVEN]"; sw = rw; hw = r; } spi_input_sel[16:16];
    } SC_SYSSTAT @ 0x8C;

    reg {
        name = "DDR hardware training result (PHY0 rank 0)";
        desc = "SC_DDR_HW_RANK0 - DDR hardware training result (PHY0 rank 0). Confidence **PROVEN**. Evidence: cijliu-uboot ddr_training_custom.h SYSCTRL_DDR_HW_PHY0_RANK0; also written 0x1000176D by the boot table. Hardware not read; reset values unknown.";
        field { name = "ddr_hw_phy0_rank0"; desc = "Vendor DDR trainer scratch word. [PROVEN]"; sw = rw; hw = r; } ddr_hw_phy0_rank0[31:0];
    } SC_DDR_HW_RANK0 @ 0x90;

    reg {
        name = "DDR hardware training result (PHY0 rank 1)";
        desc = "SC_DDR_HW_RANK1 - DDR hardware training result (PHY0 rank 1). Confidence **PROVEN**. Evidence: ddr_training_custom.h SYSCTRL_DDR_HW_PHY0_RANK1; boot table writes 0. Hardware not read; reset values unknown.";
        field { name = "ddr_hw_phy0_rank1"; desc = "Vendor DDR trainer scratch word. [PROVEN]"; sw = rw; hw = r; } ddr_hw_phy0_rank1[31:0];
    } SC_DDR_HW_RANK1 @ 0x94;

    reg {
        name = "AVS PWM channel select";
        desc = "SC_PM_PWM_SEL - Confidence **PROVEN** for the use (hi3516ev200_pm.ko temp_ctrl_init: ldr [0x1202009C], and 0xF, then ioremap(0x12080000 + (value << 5) + 4 and + 0xC): the low nibble selects which PWM channel (PWM0..3, stride 0x20) carries the core-voltage duty written by the runtime AVS timer; values above 3 are rejected). The same word is the DDR trainer scratch SC_DDR_HW_PHY1_RANK1 in the vendor U-Boot (ddr_training_custom.h SYSCTRL_DDR_HW_PHY1_RANK1 0x9C), so the nibble is a boot-code hand-over (INFERRED: filled by the vendor U-Boot/board table). Hardware not read; reset values unknown.";
        field { name = "pwm_chn"; desc = "Core-voltage PWM channel 0..3 [PROVEN use, INFERRED producer]"; sw = rw; hw = r; } pwm_chn[3:0];
    } SC_PM_PWM_SEL @ 0x9C;

    reg {
        name = "DDR training configuration";
        desc = "SC_DDR_TRAINING_CFG - DDR training configuration. Confidence **PROVEN**. Evidence: ddr_training_custom.h SYSCTRL_DDR_TRAINING_CFG; boot table writes 0xFFFBFFFE (training items disabled mask). Hardware not read; reset values unknown.";
        field { name = "ddr_training_cfg"; desc = "Training item enable mask. [PROVEN]"; sw = rw; hw = r; } ddr_training_cfg[31:0];
    } SC_DDR_TRAINING_CFG @ 0xA0;

    reg {
        name = "DDR training configuration (secure)";
        desc = "SC_DDR_TRAINING_CFG_SEC - DDR training configuration (secure). Confidence **PROVEN**. Evidence: ddr_training_custom.h; boot table writes 0xFFFFFFFF. Hardware not read; reset values unknown.";
        field { name = "ddr_training_cfg_sec"; desc = "Training item enable mask 2. [PROVEN]"; sw = rw; hw = r; } ddr_training_cfg_sec[31:0];
    } SC_DDR_TRAINING_CFG_SEC @ 0xA4;

    reg {
        name = "DDRT test pattern";
        desc = "SC_DDRT_PATTERN - DDRT test pattern. Confidence **PROVEN**. Evidence: ddr_training_custom.h SYSCTRL_DDRT_PATTERN; boot table writes 0xA669A669. Hardware not read; reset values unknown.";
        field { name = "ddrt_pattern"; desc = "DDRT pattern seed. [PROVEN]"; sw = rw; hw = r; } ddrt_pattern[31:0];
    } SC_DDRT_PATTERN @ 0xA8;

    reg {
        name = "DDR training status";
        desc = "SC_DDR_TRAINING_STAT - DDR training status. Confidence **PROVEN**. Evidence: ddr_training_custom.h SYSCTRL_DDR_TRAINING_STAT. Hardware not read; reset values unknown.";
        field { name = "ddr_training_stat"; desc = "Training result flags. [PROVEN]"; sw = rw; hw = r; } ddr_training_stat[31:0];
    } SC_DDR_TRAINING_STAT @ 0xB0;

    reg {
        name = "DDR training version flag";
        desc = "SC_DDR_TRAINING_VERSION - DDR training version flag. Confidence **PROVEN**. Evidence: ddr_training_custom.h SYSCTRL_DDR_TRAINING_VERSION_FLAG. Hardware not read; reset values unknown.";
        field { name = "ddr_training_version"; desc = "Trainer version flag. [PROVEN]"; sw = rw; hw = r; } ddr_training_version[31:0];
    } SC_DDR_TRAINING_VERSION @ 0xB4;

    reg {
        name = "General register 0";
        desc = "SC_GEN0 - General register 0. Confidence **PROVEN**. Evidence: platform.h REG_SC_GEN0. Hardware not read; reset values unknown.";
        field { name = "gen0"; desc = "Software scratch. [PROVEN]"; sw = rw; hw = r; } gen0[31:0];
    } SC_GEN0 @ 0x138;

    reg {
        name = "General register 1 (boot-ROM start flag)";
        desc = "SC_GEN1 - General register 1 (boot-ROM start flag). Confidence **PROVEN**. Evidence: platform.h REG_START_FLAG = SYS_CTRL + REG_SC_GEN1, START_MAGIC 0x444F574E ('DOWN') is written by the boot ROM when serial/USB download starts. Hardware not read; reset values unknown.";
        field { name = "start_flag"; desc = "0x444F574E when the boot ROM entered download mode. [PROVEN]"; sw = rw; hw = r; } start_flag[31:0];
    } SC_GEN1 @ 0x13C;

    reg {
        name = "General register 2";
        desc = "SC_GEN2 - General register 2. Confidence **PROVEN**. Evidence: platform.h REG_SC_GEN2. Hardware not read; reset values unknown.";
        field { name = "gen2"; desc = "Software scratch. [PROVEN]"; sw = rw; hw = r; } gen2[31:0];
    } SC_GEN2 @ 0x140;

    reg {
        name = "General register 3";
        desc = "SC_GEN3 - General register 3. Confidence **PROVEN**. Evidence: platform.h REG_SC_GEN3. Hardware not read; reset values unknown.";
        field { name = "gen3"; desc = "Software scratch. [PROVEN]"; sw = rw; hw = r; } gen3[31:0];
    } SC_GEN3 @ 0x144;

    reg {
        name = "General register 4";
        desc = "SC_GEN4 - General register 4. Confidence **PROVEN**. Evidence: platform.h REG_SC_GEN4. Hardware not read; reset values unknown.";
        field { name = "gen4"; desc = "Software scratch. [PROVEN]"; sw = rw; hw = r; } gen4[31:0];
    } SC_GEN4 @ 0x148;

    reg {
        name = "General register 9";
        desc = "SC_GEN9 - General register 9. Confidence **PROVEN**. Evidence: platform.h REG_SC_GEN9. Hardware not read; reset values unknown.";
        field { name = "gen9"; desc = "Software scratch. [PROVEN]"; sw = rw; hw = r; } gen9[31:0];
    } SC_GEN9 @ 0x154;

    reg {
        name = "SVB core voltage / speed bin";
        desc = "SC_SVB_VOLT - SVB core voltage / speed bin. Confidence **PROVEN**. Evidence: cijliu-uboot lowlevel_init_v300.c SYS_CTRL_VOLT_REG 0x12020158 (core-voltage request in mV from HPM: 992 below code 190, 812 above 310, linear between) and phy-hi3516ev200-usb.c USB_SVB_BASE_REG (reads it, field [27:24] updated for the USB PHY: predev 5 for >= 0x2BC .. predev 2 for < 0x44C). Hardware not read; reset values unknown.";
        field { name = "svb_volt"; desc = "Core-voltage value (mV), width INFERRED. [INFERRED]"; sw = rw; hw = r; } svb_volt[9:0];
        field { name = "usb_predev"; desc = "USB PHY predev code (written by the vendor USB init). [PROVEN]"; sw = rw; hw = r; } usb_predev[27:24];
    } SC_SVB_VOLT @ 0x158;

    reg {
        name = "HPM check result";
        desc = "SC_HPM_CHECK - HPM check result. Confidence **PROVEN**. Evidence: lowlevel_init_v300.c HPM_CHECK_REG 0x1202015C: [24:16] sys_hpm_core (clamped 150..350), bit 26 hpm_core_err. Hardware not read; reset values unknown.";
        field { name = "sys_hpm_core"; desc = "Averaged HPM value (clamped to 150..350). [PROVEN]"; sw = rw; hw = r; } sys_hpm_core[24:16];
        field { name = "hpm_core_err"; desc = "HPM value out of range. [PROVEN]"; sw = rw; hw = r; } hpm_core_err[26:26];
    } SC_HPM_CHECK @ 0x15C;

    reg {
        name = "Unknown, cleared by boot code";
        desc = "SC_UNKNOWN160 - Unknown, cleared by boot code. Confidence **GUESS**. Evidence: XM boot table writes 0. Hardware not read; reset values unknown.";
        field { name = "v"; desc = "Unknown. [GUESS]"; sw = rw; hw = r; } v[31:0];
    } SC_UNKNOWN160 @ 0x160;

    reg {
        name = "SVB version";
        desc = "SC_SVB_VER - SVB version. Confidence **PROVEN**. Evidence: lowlevel_init_v300.c SVB_VER_REG 0x12020168; SVB_VER_16EV200 = 0x10; the boot table also writes 3 to a 3-bit field at bit 0 (attr 0x3D). Hardware not read; reset values unknown.";
        field { name = "svb_ver"; desc = "Version code (0x10 for Hi3516E V200 in the U-Boot source). [INFERRED]"; sw = rw; hw = r; } svb_ver[7:0];
    } SC_SVB_VER @ 0x168;


    reg {
        name = "Chip ID";
        desc = "SC_SYSID - Confidence **PROVEN** for offset and use: hi3516ev200_pm.ko temp_ctrl_init maps 0x12020EE0 and compares it with 0x3516E200 (Hi3516E V200), 0x3516E300 (Hi3516E V300), 0x3518E300 (Hi3518E V300) and 0x3516D200 (Hi3516D V200) to pick the voltage formula; hi3516ev200_sys.ko GetChipID reads the same word; the vendor U-Boot chip constant is 0x003516E200. Hardware not read.";
        field { name = "chip_id"; desc = "Chip identifier word, 0x3516E200 on this chip [PROVEN compare constant]"; sw = r; hw = w; } chip_id[31:0];
    } SC_SYSID @ 0xEE0;
};
`endif
