`include "defines.rdl"

`include "CRG.rdl"
`include "IO_CONFIG.rdl"
`include "../common/ARM_PL011.rdl"
`include "../common/ARM_PL061.rdl"
`include "../common/ARM_PL190.rdl"
`include "../common/HISI_CIPHER_MC.rdl"
`include "../common/HISI_DDRC.rdl"
`include "../common/HISI_DDRT.rdl"
`include "../common/HISI_DMAC.rdl"
`include "../common/HISI_DWMMC.rdl"
`include "../common/HISI_FEMAC.rdl"
`include "../common/HISI_I2C.rdl"
`include "../common/HISI_IR.rdl"
`include "../common/HISI_IVE.rdl"
`include "../common/HISI_JPGE.rdl"
`include "../common/HISI_MOTION_DETECT.rdl"
`include "../common/HISI_NANDC.rdl"
`include "../common/HISI_PWM.rdl"
`include "../common/HISI_RTC_SPI.rdl"
`include "../common/HISI_SAR_ADC.rdl"
`include "../common/HISI_SFC_350.rdl"
`include "../common/HISI_SPI.rdl"
`include "../common/HISI_SYS_CTRL.rdl"
`include "../common/HISI_TDE.rdl"
`include "../common/HISI_TIMER_SP804.rdl"
`include "../common/HISI_USB_HOST.rdl"
`include "../common/HISI_VDP_CV100.rdl"
`include "../common/HISI_VEDU.rdl"
`include "../common/HISI_VICAP_CV100.rdl"
`include "../common/HISI_VPSS.rdl"
`include "../common/HISI_WDG_SP805.rdl"

addrmap hi3516cv100 {
    name = "hi3516cv100 registers";
    desc = "
        ## Datasheets

        * [Full Datasheet](assets/Hi3516C-Datasheet.pdf)

        ## Diagrams

        ![Application Block Diagram](assets/Application-Block-Diagram.png)
        ![Logic Block Diagram](assets/Logic-Block-Diagram.png)

        ## Addresses

        | Start Address | End Address | Description                                                                         | Documented Here |
        |---------------|-------------|-------------------------------------------------------------------------------------|-----------------|
        | 0xA0000000    | 0xFFFFFFFF  | Reserved None None                                                                  | &#10060;        |
        | 0x80000000    | 0x8FFFFFFF  | Address space for connecting the DDR to an external DDR 256 MB                      | &#10060;        |
        | 0x5C000000    | 0x7FFFFFFF  | Reserved None None                                                                  | &#10060;        |
        | 0x58000000    | 0x5BFFFFFF  | Storage space of the SPI flash 64 MB                                                | &#10060;        |
        | 0x54000000    | 0x57FFFFFF  | Reserved None None                                                                  | &#10060;        |
        | 0x50000000    | 0x53FFFFFF  | Storage space of the NAND flash 64 MB                                               | &#10060;        |
        | 0x206E0000    | 0x4FFFFFFF  | Reserved None None                                                                  | &#10060;        |
        | 0x206D0000    | 0x206DFFFF  | DDR test module 64 KB                                                               | &#9989;         |
        | 0x206C0000    | 0x206CFFFF  | Motion detection (MD) register 64 KB                                                | &#9989;         |
        | 0x20670000    | 0x206BFFFF  | Reserved None None                                                                  | &#10060;        |
        | 0x20660000    | 0x2066FFFF  | JPEG encoder (JPGE)register 64 KB                                                   | &#9989;        |
        | 0x20630000    | 0x2065FFFF  | Reserved None None                                                                  | &#10060;        |
        | 0x20620000    | 0x2062FFFF  | Video encoding (VENC) register 64 KB                                                | &#9989;         |
        | 0x20610000    | 0x2061FFFF  | Two-dimensional engine (TDE) register 64 KB                                         | &#9989;         |
        | 0x20600000    | 0x2060FFFF  | Video process subsystem (VPSS) register 64 KB                                       | &#9989;         |
        | 0x205F0000    | 0x205FFFFF  | Reserved None None                                                                  | &#10060;        |
        | 0x205E0000    | 0x205EFFFF  | IVE register 64 KB                                                                  | &#9989;         |
        | 0x205D0000    | 0x205DFFFF  | Reserved None None                                                                  | &#10060;        |
        | 0x205C0000    | 0x205CFFFF  | Video display (VDP) register 64 KB                                                  | &#9989;         |
        | 0x20580000    | 0x205BFFFF  | Video capture (VICAP) register2 56 KB                                               | &#9989;         |
        | 0x20200000    | 0x2057FFFF  | Reserved None None                                                                  | &#10060;        |
        | 0x201F0000    | 0x201FFFFF  | GPIO11 register 64 KB                                                               | &#9989;         |
        | 0x201E0000    | 0x201EFFFF  | GPIO10 register 64 KB                                                               | &#9989;         |
        | 0x201D0000    | 0x201DFFFF  | GPIO9 register 64 KB                                                                | &#9989;         |
        | 0x201C0000    | 0x201CFFFF  | GPIO8 register 64 KB                                                                | &#9989;         |
        | 0x201B0000    | 0x201BFFFF  | GPIO7 register 64 KB                                                                | &#9989;         |
        | 0x201A0000    | 0x201AFFFF  | GPIO6 register 64 KB                                                                | &#9989;         |
        | 0x20190000    | 0x2019FFFF  | GPIO5 register 64 KB                                                                | &#9989;         |
        | 0x20180000    | 0x2018FFFF  | GPIO4 register 64 KB                                                                | &#9989;         |
        | 0x20170000    | 0x2017FFFF  | GPIO3 register 64 KB                                                                | &#9989;         |
        | 0x20160000    | 0x2016FFFF  | GPIO2 register 64 KB                                                                | &#9989;         |
        | 0x20150000    | 0x2015FFFF  | GPIO1 register 64 KB                                                                | &#9989;         |
        | 0x20140000    | 0x2014FFFF  | GPIO0 register 64 KB                                                                | &#9989;         |
        | 0x20130000    | 0x2013FFFF  | PWM0/1 register 64 KB                                                               | &#9989;         |
        | 0x20120000    | 0x2012FFFF  | DDR_PHY register 64 KB                                                              | &#9989;         |
        | 0x20110000    | 0x2011FFFF  | DDRC register 64 KB                                                                 | &#9989;         |
        | 0x20100000    | 0x2010FFFF  | Reserved 64 KB                                                                      | &#10060;        |
        | 0x200F0000    | 0x200FFFFF  | IO configuration register 64 KB                                                     | &#9989;         |
        | 0x200E0000    | 0x200EFFFF  | SPI1 register 64 KB                                                                 | &#9989;         |
        | 0x200D0000    | 0x200DFFFF  | I2C register 64 KB                                                                  | &#9989;         |
        | 0x200C0000    | 0x200CFFFF  | SPI0 register 64 KB                                                                 | &#9989;         |
        | 0x200B0000    | 0x200BFFFF  | Successive approximation (SAR) ADC register 64 KB                                   | &#9989;         |
        | 0x200A0000    | 0x200AFFFF  | UART2 register 64 KB                                                                | &#9989;         |
        | 0x20090000    | 0x2009FFFF  | UART1 register 64 KB                                                                | &#9989;         |
        | 0x20080000    | 0x2008FFFF  | UART0 register 64 KB                                                                | &#9989;         |
        | 0x20070000    | 0x2007FFFF  | IR register 64 KB                                                                   | &#9989;         |
        | 0x20060000    | 0x2006FFFF  | RTC register 64 KB                                                                  | &#9989;         |
        | 0x20050000    | 0x2005FFFF  | SYS_CTRL register 64 KB                                                             | &#9989;         |
        | 0x20040000    | 0x2004FFFF  | WDG register 64 KB                                                                  | &#9989;         |
        | 0x20030000    | 0x2003FFFF  | CRG register 64 KB                                                                  | &#9989;         |
        | 0x20020000    | 0x2002FFFF  | Reserved 64 KB                                                                      | &#10060;        |
        | 0x20010000    | 0x2001FFFF  | Timer2/3 register 64 KB                                                             | &#9989;         |
        | 0x20000000    | 0x2000FFFF  | Timer0/1 register 64 KB                                                             | &#9989;         |
        | 0x10150000    | 0x1FFFFFFF  | Reserved None None                                                                  | &#10060;        |
        | 0x10140000    | 0x1014FFFF  | Vector interrupt controller (VIC) register 64 KB                                    | &#9989;         |
        | 0x100E0000    | 0x1013FFFF  | Reserved None None                                                                  | &#10060;        |
        | 0x100D0000    | 0x100DFFFF  | Direct memory access control (DMAC) register 64 KB                                  | &#9989;         |
        | 0x100C0000    | 0x100CFFFF  | CIPHER register 64 KB                                                               | &#9989;         |
        | 0x100B0000    | 0x100BFFFF  | USB enhanced host controller interface (EHCI) register 64 KB                        | &#9989;         |
        | 0x100A0000    | 0x100AFFFF  | USB open host controller interface (OHCI) register 64 KB                            | &#9989;         |
        | 0x10090000    | 0x1009FFFF  | Ethernet (ETH) register 64 KB                                                       | &#9989;         |
        | 0x10050000    | 0x1008FFFF  | Reserved None None                                                                  | &#10060;        |
        | 0x10040000    | 0x1004FFFF  | Sonic input/output 64 KB                                                            | &#10060;        |
        | 0x10030000    | 0x1003FFFF  | Reserved None None                                                                  | &#10060;        |
        | 0x10020000    | 0x1002FFFF  | SDIO register 64 KB                                                                 | &#9989;         |
        | 0x10010000    | 0x1001FFFF  | SPI NOR flash register 64 KB                                                        | &#9989;         |
        | 0x10000000    | 0x1000FFFF  | NAND flash register 64 KB                                                           | &#9989;         |
        | 0x04000000    | 0x0FFFFFFF  | Reserved None None                                                                  | &#10060;        |
        | 0x00000000    | 0x03FFFFFF  | During address remapping, the address space points to the boot address space. 64 MB | &#10060;        |

        <!-- overview:begin -->

        ### Diagrams

        ![Register blocks by function](assets/diagrams/hi3516cv100-blocks.svg)

        ### Interrupts (ARM926 VIC source numbers, data sheet Table 3-21)

        | # | Source | # | Source | # | Source |
        |---|---|---|---|---|---|
        | 0 | Global software interrupt | 11 | SFC | 22 | VICAP |
        | 1 | WDT interrupt when periphctrl0 bit[31] is 0 | 12 | ETH | 23 | VOU |
        | 2 | RTC interrupt when periphctrl0 bit[31] is 0 | 13 | CIPHER | 24 | VEDU |
        | 3 | Timer0/Timer1 | 14 | DMAC | 25 | UART2 |
        | 4 | Timer2/Timer3 | 15 | USB_EHCI | 26 | JPGE |
        | 5 | UART0/UART1 | 16 | USB_OHCI | 27 | TDE |
        | 6 | SSP0 | 17 | VPSS | 28 | MDU/DDRT |
        | 7 | SSP1 | 18 | SDIO | 29 | GPIO0/GPIO1/GPIO2/GPIO11 |
        | 8 | NANDC | 19 | IR/SAR_ADC | 30 | GPIO3/GPIO4/GPIO5/GPIO10 |
        | 9 | SIO | 20 | I2C | 31 | GPIO6/GPIO7/GPIO8/GPIO9 |
        | 10 | Temper_Cap | 21 | IVE |  |  |

        ### Clock-gate and reset map (generated from the CRG registers)

        | Offset | Register | Description | Gate / reset fields |
        |---|---|---|---|
        | 0x028 | PERI_CRG10 | ARM9/DDR frequency mode and reset configuration register | cpu_srst_req |
        | 0x02C | PERI_CRG11 | VICAP clock and reset configuration register | vi_hrst_req, vi1_hcken, vi_rst_req, vi_cken, isp_rst_req, isp_cken |
        | 0x034 | PERI_CRG13 | VOU clock and reset control register | vo_hrst_req, vo_hd_srst_req, vo_sd_srst_req, vou_hcken, vou_hd_cken, vou_sd_cken |
        | 0x038 | PERI_CRG14 | PWM clock and reset control register | pwm_srst_req, pwm_cken |
        | 0x040 | PERI_CRG16 | VEDU clock and soft reset control register | vedu_srst_req, vedu0_cken |
        | 0x048 | PERI_CRG18 | VPSS clock and reset control register | vps_srst_req, vps_cken |
        | 0x058 | PERI_CRG22 | TDE clock and soft reset control register | tde_srst_req, tde_cken |
        | 0x060 | PERI_CRG24 | JPGE clock and soft reset control register | jpge_srst_req, jpge_cken |
        | 0x068 | PERI_CRG26 | MDU clock and soft reset control register | mdu_srst_req, mdu_cken |
        | 0x06C | PERI_CRG27 | VAPU clock and soft reset control register | vapu_srst_req, vapu_cken |
        | 0x07C | PERI_CRG31 | CIPHER clock and soft reset control register | cipher_srst_req, cipher_cken |
        | 0x080 | PERI_CRG32 | SAR ADC control register | sar_adc_srst_req, sar_adc_cken |
        | 0x08C | PERI_CRG35 | SIO clock and soft reset control register | sio_srst_req, sio_cken, adac_srst_req |
        | 0x0B8 | PERI_CRG46 | USB clock and soft reset control register | usb_ahb_srst_req, usb_cken |
        | 0x0C0 | PERI_CRG48 | SFC clock and soft reset control register | sfc_srst_req, sfc_cken |
        | 0x0C4 | PERI_CRG49 | SDIO clock and soft reset control register | sdio_srst_req, sdio_cken |
        | 0x0CC | PERI_CRG51 | ETH interface clock and soft reset control register | hrst_eth_s, eth_cken |
        | 0x0D0 | PERI_CRG52 | NANDC clock and soft reset control register | nfc_srst_req, nfc_cken |
        | 0x0D8 | PERI_CRG54 | DDRTEST clock and soft reset control register | efuse_srst_req, efuse_cken, ddrtest_srst_req, ddrtest_cken |
        | 0x0E0 | PERI_CRG56 | DMA clock and soft reset control register | dma_srst_req, dma_cken |
        | 0x0E4 | PERI_CRG57 | Soft reset control register for other CRG interface modules | test_clk_en, i2c_srst_req, t_cap_srst_req, ir_srst_req, ssp0_srst_req, ssp1_srst_req, uart0_srst_req, uart1_srst_req, uart2_srst_req, ir_cken, ... |
        | 0x0F4 | PERI_CRG61 | Speed monitor control register | osc_clk_en, osc_en |

        Only fields whose names contain a clock-enable or reset keyword are listed; the field descriptions in the register pages give the polarity and the clocks they gate.

        ### Register blocks (generated from this description)

        | Base | Instance | Block | Register space |
        |---|---|---|---|
        | 0x10000000 | NANDC | HiSilicon parallel NAND flash controller (hinfc300/301/504 family) | 156 B |
        | 0x10010000 | SFC | System Flash Controller Registers | 1088 B |
        | 0x10020000 | SDIO | HiSilicon MMC/SD/SDIO controller (DesignWare-MMC based, himciv200) | 260 B |
        | 0x10090000 | ETH | HiSilicon femac v2 Fast Ethernet MAC with MDIO | 5184 B |
        | 0x100A0000 | OHCI | HiSilicon USB 2.0 host controller - OHCI | 92 B |
        | 0x100B0000 | EHCI | HiSilicon USB 2.0 host controller - EHCI | 176 B |
        | 0x100C0000 | CIPHER | CIPHER (8 channels) | 5184 B |
        | 0x100D0000 | DMAC | HiSilicon DMA controller (PL080-compatible, 4 or 8 channels) | 384 B |
        | 0x10140000 | VIC | Vectored interrupt controller (ARM PrimeCell PL190) | 4 KB |
        | 0x20000000 | TIMER0 | Timer Registers | 28 B |
        | 0x20000020 | TIMER1 | Timer Registers | 28 B |
        | 0x20010000 | TIMER2 | Timer Registers | 28 B |
        | 0x20010020 | TIMER3 | Timer Registers | 28 B |
        | 0x20030000 | CRG | Clock and reset generator (CRG), Hi3516C V100 | 252 B |
        | 0x20040000 | WDG | Watchdog Registers | 3076 B |
        | 0x20050000 | SYS_CTRL | System Controller Registers | 3824 B |
        | 0x20060000 | RTC | HiSilicon SPI-bridged RTC (APB registers) | 164 B |
        | 0x20070000 | IR | HiSilicon IR receiver | 56 B |
        | 0x20080000 | UART0 | UART (ARM PrimeCell PL011) | 4 KB |
        | 0x20090000 | UART1 | UART (ARM PrimeCell PL011) | 4 KB |
        | 0x200A0000 | UART2 | UART (ARM PrimeCell PL011) | 4 KB |
        | 0x200B0000 | SAR_ADC | HiSilicon SAR ADC (10-bit, 2 channels, first generation) | 32 B |
        | 0x200C0000 | SPI0 | SPI Registers | 48 B |
        | 0x200D0000 | I2C | HiSilicon I2C Master Controller | 32 B |
        | 0x200E0000 | SPI1 | SPI Registers | 48 B |
        | 0x200F0000 | IO_CONFIG | IO configuration (pin multiplexing), Hi3516C V100 | 380 B |
        | 0x20110000 | DDRC | DDRC Registers | 656 B |
        | 0x20120000 | DDR_PHY | DDR PHY (Synopsys DWC DDR PHY PUB) registers | 1600 B |
        | 0x20130000 | PWM | HiSilicon PWM group | 96 B |
        | 0x20140000 | GPIO0 | ARM PL061 | 1053 B |
        | 0x20150000 | GPIO1 | ARM PL061 | 1053 B |
        | 0x20160000 | GPIO2 | ARM PL061 | 1053 B |
        | 0x20170000 | GPIO3 | ARM PL061 | 1053 B |
        | 0x20180000 | GPIO4 | ARM PL061 | 1053 B |
        | 0x20190000 | GPIO5 | ARM PL061 | 1053 B |
        | 0x201A0000 | GPIO6 | ARM PL061 | 1053 B |
        | 0x201B0000 | GPIO7 | ARM PL061 | 1053 B |
        | 0x201C0000 | GPIO8 | ARM PL061 | 1053 B |
        | 0x201D0000 | GPIO9 | ARM PL061 | 1053 B |
        | 0x201E0000 | GPIO10 | ARM PL061 | 1053 B |
        | 0x201F0000 | GPIO11 | ARM PL061 | 1053 B |
        | 0x20580000 | VICAP | VICAP (video capture, Hi3516C V100 / Hi3518 V100 / Hi3518E V100) | 65788 B |
        | 0x205C0000 | VDP | VDP (video display processor, Hi3516C V100 / Hi3518 V100) | 52768 B |
        | 0x205E0000 | IVE | HiSilicon intelligent video engine | 28 B |
        | 0x20600000 | VPSS | HiSilicon VPSS (registers not described) | 64 KB |
        | 0x20610000 | TDE | HiSilicon TDE, Hi3518 / Hi3516C V100 generation (vendor-derived) | 72 B |
        | 0x20620000 | VEDU | HiSilicon VEDU (registers not described) | 64 KB |
        | 0x20660000 | JPGE | HiSilicon JPEG encoder (JPGE, r004 register layout) | 4288 B |
        | 0x206C0000 | MOTION_DETECT | Motion Detect Unit Registers | 188 B |
        | 0x206D0000 | DDRT | HiSilicon DDR test module | 132 B |

        The table is generated from the elaborated root (instances at their absolute addresses; register space is the span of the block's registers, not the data sheet window).

        <!-- overview:end -->
    ";

    eHISI_NANDC         NANDC           @ 0x10000000;
    eHISI_SFC_350       SFC             @ 0x10010000;
    eHISI_DWMMC         SDIO            @ 0x10020000;
    eHISI_FEMAC         ETH             @ 0x10090000;
    eHISI_USB_OHCI      OHCI            @ 0x100A0000;
    eHISI_USB_EHCI      EHCI            @ 0x100B0000;
    eHISI_CIPHER_MC     CIPHER          @ 0x100C0000;
    eHISI_DMAC          DMAC            @ 0x100D0000;
    eARM_PL190          VIC             @ 0x10140000;
    eHISI_TIMER_SP804   TIMER0          @ 0x20000000;
    eHISI_TIMER_SP804   TIMER1          @ 0x20000020;
    eHISI_TIMER_SP804   TIMER2          @ 0x20010000;
    eHISI_TIMER_SP804   TIMER3          @ 0x20010020;
    eCRG                CRG             @ 0x20030000;
    eHISI_WDG_SP805     WDG             @ 0x20040000;
    eSYS_CTRL           SYS_CTRL        @ 0x20050000;
    eHISI_RTC_SPI       RTC             @ 0x20060000;
    eHISI_IR            IR              @ 0x20070000;
    eARM_PL011          UART0           @ 0x20080000;
    eARM_PL011          UART1           @ 0x20090000;
    eARM_PL011          UART2           @ 0x200A0000;
    eHISI_SAR_ADC       SAR_ADC         @ 0x200B0000;
    eHISI_SPI           SPI0            @ 0x200C0000;
    eHISI_I2C           I2C             @ 0x200D0000;
    eHISI_SPI           SPI1            @ 0x200E0000;
    eIO_CONFIG          IO_CONFIG       @ 0x200F0000;
    eDDRC               DDRC            @ 0x20110000;
    eDDRC_PUB_PHY       DDR_PHY         @ 0x20120000;
    eHISI_PWM_GRP       PWM             @ 0x20130000;
    eARM_PL061          GPIO0           @ 0x20140000;
    eARM_PL061          GPIO1           @ 0x20150000;
    eARM_PL061          GPIO2           @ 0x20160000;
    eARM_PL061          GPIO3           @ 0x20170000;
    eARM_PL061          GPIO4           @ 0x20180000;
    eARM_PL061          GPIO5           @ 0x20190000;
    eARM_PL061          GPIO6           @ 0x201A0000;
    eARM_PL061          GPIO7           @ 0x201B0000;
    eARM_PL061          GPIO8           @ 0x201C0000;
    eARM_PL061          GPIO9           @ 0x201D0000;
    eARM_PL061          GPIO10          @ 0x201E0000;
    eARM_PL061          GPIO11          @ 0x201F0000;
    eHISI_VICAP_CV100   VICAP           @ 0x20580000;
    eHISI_VDP_CV100     VDP             @ 0x205C0000;
    eHISI_IVE           IVE             @ 0x205E0000;
    aHISI_VPSS          VPSS            @ 0x20600000;
    eHISI_TDE_G0          TDE             @ 0x20610000;
    aHISI_VEDU          VEDU            @ 0x20620000;
    eHISI_JPGE          JPGE            @ 0x20660000;
    eMOTION_DETECT      MOTION_DETECT   @ 0x206C0000;
    eHISI_DDRT          DDRT            @ 0x206D0000;
};

