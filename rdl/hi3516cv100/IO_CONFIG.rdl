`ifndef HI3516CV100_IO_CONFIG_RDL
`define HI3516CV100_IO_CONFIG_RDL

regfile eIO_CONFIG {
    name = "IO configuration (pin multiplexing), Hi3516C V100";
    desc = "
    The `muxctrl_regN` pin multiplexing control registers of the Hi3516C V100 at 0x200F0000 (DS Table 1-1 `IO configuration register`, 64 KB). One register per pin, 95 registers (muxctrl_reg0..muxctrl_reg94, offsets 0x000..0x178, 4 bytes apart), 1 to 3 bits each; the field value selects the pin function, the reset value 0 selects the function listed first (usually the GPIO or the primary function, see each register); all other bits read as 0. Values the data sheet does not list are reserved.
    Strap pins: BOOT_SEL on MDCK (muxctrl_reg29 value 3), SFC_ADDR_MODE on SFC_CLK (muxctrl_reg42 value 2) and NF_BOOT_PIN0..3 on NF_REN/NF_CLE/NF_ALE/NF_WEN (muxctrl_reg60/63/64/65 value 2) are boot configuration inputs sampled at power-on (DS 1.3, 2.2).
    Source: Hi3516C HD IP Camera SoC Data Sheet, Issue 00B02 (2013-02-05), section 2.3 (Table 2-33 summary, `hi3516cv100--Hi3516C-Datasheet.txt` lines 3045-6095). Only the English edition is available (no Chinese original in the tree). Four rows the text dump lost at page breaks or in a header with an empty name cell (muxctrl_reg16, reg21, reg33, reg40) were read by hand from the dump lines given in those registers. No vendor code in the tree writes these registers (the Hi3518/Hi3516C U-Boot and kernel only define the base address), so the enum values are data-sheet only. The register set and all pin functions are identical to the Hi3518A V100 (rdl/hi3518v100/IO_CONFIG.rdl), which is the same silicon generation.
    ";

    reg {
        name = "Multiplexing control register for the SHUTTER_TRIG pin";
        desc = "muxctrl_reg0 is a multiplexing control register for the SHUTTER_TRIG pin.

Data sheet 2.3.2 muxctrl_reg0 (offset 0x0, printed page 2-44, `hi3516cv100--Hi3516C-Datasheet.txt` line 3235).";

        enum muxctrl_reg0_muxctrl_reg0_enum {
            GPIO1_0 = 0 { name = "Gpio1 0"; desc = "GPIO1_0"; };
            SHUTTER_TRIG = 1 { name = "Shutter Trig"; desc = "SHUTTER_TRIG"; };
        };

        field {
            name = "muxctrl_reg0";
            desc = "Multiplexing for the SHUTTER_TRIG pin.";
            sw = rw;
            hw = r;
            encode = muxctrl_reg0_muxctrl_reg0_enum;
            reset = 0x0;
        } muxctrl_reg0[0:0];
    } muxctrl_reg0 @ 0x0;

    reg {
        name = "Multiplexing control register for the SDIO_CCLK_OUT pin";
        desc = "muxctrl_reg1 is a multiplexing control register for the SDIO_CCLK_OUT pin.

Data sheet 2.3.2 muxctrl_reg1 (offset 0x4, printed page 2-45, `hi3516cv100--Hi3516C-Datasheet.txt` line 3270).";

        enum muxctrl_reg1_muxctrl_reg1_enum {
            GPIO1_1 = 0 { name = "Gpio1 1"; desc = "GPIO1_1"; };
            SDIO_CCLK_OUT = 1 { name = "Sdio Cclk Out"; desc = "SDIO_CCLK_OUT"; };
        };

        field {
            name = "muxctrl_reg1";
            desc = "Multiplexing for the SDIO_CCLK_OUT pin.";
            sw = rw;
            hw = r;
            encode = muxctrl_reg1_muxctrl_reg1_enum;
            reset = 0x0;
        } muxctrl_reg1[0:0];
    } muxctrl_reg1 @ 0x4;

    reg {
        name = "Multiplexing control register for the SENSOR_CLK pin";
        desc = "muxctrl_reg2 is a multiplexing control register for the SENSOR_CLK pin.

Data sheet 2.3.2 muxctrl_reg2 (offset 0x8, printed page 2-45, `hi3516cv100--Hi3516C-Datasheet.txt` line 3294).";

        enum muxctrl_reg2_muxctrl_reg2_enum {
            GPIO1_2 = 0 { name = "Gpio1 2"; desc = "GPIO1_2"; };
            SENSOR_CLK = 1 { name = "Sensor Clk"; desc = "SENSOR_CLK"; };
        };

        field {
            name = "muxctrl_reg2";
            desc = "Multiplexing for the SENSOR_CLK pin.";
            sw = rw;
            hw = r;
            encode = muxctrl_reg2_muxctrl_reg2_enum;
            reset = 0x0;
        } muxctrl_reg2[0:0];
    } muxctrl_reg2 @ 0x8;

    reg {
        name = "Multiplexing control register for the SPI0_SCLK pin";
        desc = "muxctrl_reg3 is a multiplexing control register for the SPI0_SCLK pin. Hi3516C HD IP Camera SoC

Data sheet 2.3.2 muxctrl_reg3 (offset 0xC, printed page 2-46, `hi3516cv100--Hi3516C-Datasheet.txt` line 3331).";

        enum muxctrl_reg3_muxctrl_reg3_enum {
            GPIO1_4 = 0 { name = "Gpio1 4"; desc = "GPIO1_4"; };
            SPI0_SCLK = 1 { name = "Spi0 Sclk"; desc = "SPI0_SCLK"; };
        };

        field {
            name = "muxctrl_reg3";
            desc = "Multiplexing for the SPI0_SCLK pin.";
            sw = rw;
            hw = r;
            encode = muxctrl_reg3_muxctrl_reg3_enum;
            reset = 0x0;
        } muxctrl_reg3[0:0];
    } muxctrl_reg3 @ 0xC;

    reg {
        name = "Multiplexing control register for the SPI0_SDO pin";
        desc = "muxctrl_reg4 is a multiplexing control register for the SPI0_SDO pin.

Data sheet 2.3.2 muxctrl_reg4 (offset 0x10, printed page 2-46, `hi3516cv100--Hi3516C-Datasheet.txt` line 3359).";

        enum muxctrl_reg4_muxctrl_reg4_enum {
            GPIO1_5 = 0 { name = "Gpio1 5"; desc = "GPIO1_5"; };
            SPI0_SDO = 1 { name = "Spi0 Sdo"; desc = "SPI0_SDO"; };
        };

        field {
            name = "muxctrl_reg4";
            desc = "Multiplexing for the SPI0_SDO pin.";
            sw = rw;
            hw = r;
            encode = muxctrl_reg4_muxctrl_reg4_enum;
            reset = 0x0;
        } muxctrl_reg4[0:0];
    } muxctrl_reg4 @ 0x10;

    reg {
        name = "Multiplexing control register for the SPI0_SDI pin";
        desc = "muxctrl_reg5 is a multiplexing control register for the SPI0_SDI pin. Hi3516C HD IP Camera SoC

Data sheet 2.3.2 muxctrl_reg5 (offset 0x14, printed page 2-47, `hi3516cv100--Hi3516C-Datasheet.txt` line 3397).";

        enum muxctrl_reg5_muxctrl_reg5_enum {
            GPIO1_6 = 0 { name = "Gpio1 6"; desc = "GPIO1_6"; };
            SPI0_SDI = 1 { name = "Spi0 Sdi"; desc = "SPI0_SDI"; };
        };

        field {
            name = "muxctrl_reg5";
            desc = "Multiplexing for the SPI0_SDI pin.";
            sw = rw;
            hw = r;
            encode = muxctrl_reg5_muxctrl_reg5_enum;
            reset = 0x0;
        } muxctrl_reg5[0:0];
    } muxctrl_reg5 @ 0x14;

    reg {
        name = "Multiplexing control register for the I2C_SDA pin";
        desc = "muxctrl_reg6 is a multiplexing control register for the I2C_SDA pin.

Data sheet 2.3.2 muxctrl_reg6 (offset 0x18, printed page 2-47, `hi3516cv100--Hi3516C-Datasheet.txt` line 3422).";

        enum muxctrl_reg6_muxctrl_reg6_enum {
            GPIO2_0 = 0 { name = "Gpio2 0"; desc = "GPIO2_0"; };
            I2C_SDA = 1 { name = "I2C Sda"; desc = "I2C_SDA"; };
        };

        field {
            name = "muxctrl_reg6";
            desc = "Multiplexing for the I2C_SDA pin.";
            sw = rw;
            hw = r;
            encode = muxctrl_reg6_muxctrl_reg6_enum;
            reset = 0x0;
        } muxctrl_reg6[0:0];
    } muxctrl_reg6 @ 0x18;

    reg {
        name = "Multiplexing control register for the I2C_SCL pin";
        desc = "muxctrl_reg7 is a multiplexing control register for the I2C_SCL pin. Hi3516C HD IP Camera SoC

Data sheet 2.3.2 muxctrl_reg7 (offset 0x1C, printed page 2-48, `hi3516cv100--Hi3516C-Datasheet.txt` line 3459).";

        enum muxctrl_reg7_muxctrl_reg7_enum {
            GPIO2_1 = 0 { name = "Gpio2 1"; desc = "GPIO2_1"; };
            I2C_SCL = 1 { name = "I2C Scl"; desc = "I2C_SCL"; };
        };

        field {
            name = "muxctrl_reg7";
            desc = "Multiplexing for the I2C_SCL pin.";
            sw = rw;
            hw = r;
            encode = muxctrl_reg7_muxctrl_reg7_enum;
            reset = 0x0;
        } muxctrl_reg7[0:0];
    } muxctrl_reg7 @ 0x1C;

    reg {
        name = "Multiplexing control register for the UART1_RTSN pin";
        desc = "muxctrl_reg8 is a multiplexing control register for the UART1_RTSN pin.

Data sheet 2.3.2 muxctrl_reg8 (offset 0x20, printed page 2-48, `hi3516cv100--Hi3516C-Datasheet.txt` line 3486).";

        enum muxctrl_reg8_muxctrl_reg8_enum {
            GPIO2_2 = 0 { name = "Gpio2 2"; desc = "GPIO2_2"; };
            UART1_RTSN = 1 { name = "Uart1 Rtsn"; desc = "UART1_RTSN"; };
        };

        field {
            name = "muxctrl_reg8";
            desc = "Multiplexing for the UART1_RTSN pin.";
            sw = rw;
            hw = r;
            encode = muxctrl_reg8_muxctrl_reg8_enum;
            reset = 0x0;
        } muxctrl_reg8[0:0];
    } muxctrl_reg8 @ 0x20;

    reg {
        name = "Multiplexing control register for the UART1_RXD pin";
        desc = "muxctrl_reg9 is a multiplexing control register for the UART1_RXD pin. Hi3516C HD IP Camera SoC

Data sheet 2.3.2 muxctrl_reg9 (offset 0x24, printed page 2-49, `hi3516cv100--Hi3516C-Datasheet.txt` line 3520).";

        enum muxctrl_reg9_muxctrl_reg9_enum {
            GPIO2_3 = 0 { name = "Gpio2 3"; desc = "GPIO2_3"; };
            UART1_RXD = 1 { name = "Uart1 Rxd"; desc = "UART1_RXD"; };
        };

        field {
            name = "muxctrl_reg9";
            desc = "Multiplexing for the UART1_RXD pin.";
            sw = rw;
            hw = r;
            encode = muxctrl_reg9_muxctrl_reg9_enum;
            reset = 0x0;
        } muxctrl_reg9[0:0];
    } muxctrl_reg9 @ 0x24;

    reg {
        name = "Multiplexing control register for the UART1_CTSN pin";
        desc = "muxctrl_reg10 is a multiplexing control register for the UART1_CTSN pin.

Data sheet 2.3.2 muxctrl_reg10 (offset 0x28, printed page 2-49, `hi3516cv100--Hi3516C-Datasheet.txt` line 3548).";

        enum muxctrl_reg10_muxctrl_reg10_enum {
            GPIO2_4 = 0 { name = "Gpio2 4"; desc = "GPIO2_4"; };
            UART1_CTSN = 1 { name = "Uart1 Ctsn"; desc = "UART1_CTSN"; };
        };

        field {
            name = "muxctrl_reg10";
            desc = "Multiplexing for the UART1_CTSN pin.";
            sw = rw;
            hw = r;
            encode = muxctrl_reg10_muxctrl_reg10_enum;
            reset = 0x0;
        } muxctrl_reg10[0:0];
    } muxctrl_reg10 @ 0x28;

    reg {
        name = "Multiplexing control register for the UART1_TXD pin";
        desc = "muxctrl_reg11 is a multiplexing control register for the UART1_TXD pin. Hi3516C HD IP Camera SoC

Data sheet 2.3.2 muxctrl_reg11 (offset 0x2C, printed page 2-50, `hi3516cv100--Hi3516C-Datasheet.txt` line 3583).";

        enum muxctrl_reg11_muxctrl_reg11_enum {
            GPIO2_5 = 0 { name = "Gpio2 5"; desc = "GPIO2_5"; };
            UART1_TXD = 1 { name = "Uart1 Txd"; desc = "UART1_TXD"; };
        };

        field {
            name = "muxctrl_reg11";
            desc = "Multiplexing for the UART1_TXD pin.";
            sw = rw;
            hw = r;
            encode = muxctrl_reg11_muxctrl_reg11_enum;
            reset = 0x0;
        } muxctrl_reg11[0:0];
    } muxctrl_reg11 @ 0x2C;

    reg {
        name = "Multiplexing control register for the MII_CRS pin";
        desc = "muxctrl_reg12 is a multiplexing control register for the MII_CRS pin.

Data sheet 2.3.2 muxctrl_reg12 (offset 0x30, printed page 2-50, `hi3516cv100--Hi3516C-Datasheet.txt` line 3610).";

        enum muxctrl_reg12_muxctrl_reg12_enum {
            GPIO3_0 = 0 { name = "Gpio3 0"; desc = "GPIO3_0"; };
            MII_CRS = 1 { name = "Mii Crs"; desc = "MII_CRS"; };
            VOU1120_DATA10 = 2 { name = "Vou1120 Data10"; desc = "VOU1120_DATA10"; };
        };

        field {
            name = "muxctrl_reg12";
            desc = "Multiplexing for the MII_CRS pin. Other values: reserved.";
            sw = rw;
            hw = r;
            encode = muxctrl_reg12_muxctrl_reg12_enum;
            reset = 0x0;
        } muxctrl_reg12[1:0];
    } muxctrl_reg12 @ 0x30;

    reg {
        name = "Multiplexing control register for the MII_COL pin";
        desc = "muxctrl_reg13 is a multiplexing control register for the MII_COL pin. Hi3516C HD IP Camera SoC

Data sheet 2.3.2 muxctrl_reg13 (offset 0x34, printed page 2-51, `hi3516cv100--Hi3516C-Datasheet.txt` line 3650).";

        enum muxctrl_reg13_muxctrl_reg13_enum {
            GPIO3_1 = 0 { name = "Gpio3 1"; desc = "GPIO3_1"; };
            MII_COL = 1 { name = "Mii Col"; desc = "MII_COL"; };
            VOU1120_DATA9 = 2 { name = "Vou1120 Data9"; desc = "VOU1120_DATA9"; };
        };

        field {
            name = "muxctrl_reg13";
            desc = "Multiplexing for the MII_COL pin. Other values: reserved.";
            sw = rw;
            hw = r;
            encode = muxctrl_reg13_muxctrl_reg13_enum;
            reset = 0x0;
        } muxctrl_reg13[1:0];
    } muxctrl_reg13 @ 0x34;

    reg {
        name = "Multiplexing control register for the MII_RXD3 pin";
        desc = "muxctrl_reg14 is a multiplexing control register for the MII_RXD3 pin.

Data sheet 2.3.2 muxctrl_reg14 (offset 0x38, printed page 2-51, `hi3516cv100--Hi3516C-Datasheet.txt` line 3680).";

        enum muxctrl_reg14_muxctrl_reg14_enum {
            GPIO4_3 = 0 { name = "Gpio4 3"; desc = "GPIO4_3"; };
            MII_RXD3 = 1 { name = "Mii Rxd3"; desc = "MII_RXD3"; };
            VOU1120_DATA15 = 2 { name = "Vou1120 Data15"; desc = "VOU1120_DATA15"; };
        };

        field {
            name = "muxctrl_reg14";
            desc = "Multiplexing for the MII_RXD3 pin. Other values: reserved.";
            sw = rw;
            hw = r;
            encode = muxctrl_reg14_muxctrl_reg14_enum;
            reset = 0x0;
        } muxctrl_reg14[1:0];
    } muxctrl_reg14 @ 0x38;

    reg {
        name = "Multiplexing control register for the MII_RXD2 pin";
        desc = "muxctrl_reg15 is a multiplexing control register for the MII_RXD2 pin. Hi3516C HD IP Camera SoC

Data sheet 2.3.2 muxctrl_reg15 (offset 0x3C, printed page 2-52, `hi3516cv100--Hi3516C-Datasheet.txt` line 3719).";

        enum muxctrl_reg15_muxctrl_reg15_enum {
            GPIO4_2 = 0 { name = "Gpio4 2"; desc = "GPIO4_2"; };
            MII_RXD2 = 1 { name = "Mii Rxd2"; desc = "MII_RXD2"; };
            VOU1120_DATA11 = 2 { name = "Vou1120 Data11"; desc = "VOU1120_DATA11"; };
        };

        field {
            name = "muxctrl_reg15";
            desc = "Multiplexing for the MII_RXD2 pin. Other values: reserved.";
            sw = rw;
            hw = r;
            encode = muxctrl_reg15_muxctrl_reg15_enum;
            reset = 0x0;
        } muxctrl_reg15[1:0];
    } muxctrl_reg15 @ 0x3C;

    reg {
        name = "Multiplexing control register for the MII_RXD1 pin";
        desc = "muxctrl_reg16 is a multiplexing control register for the MII_RXD1 pin.

Data sheet 2.3.2 muxctrl_reg16 (offset 0x40, printed page 2-52, `hi3516cv100--Hi3516C-Datasheet.txt` line 3748).";

        enum muxctrl_reg16_muxctrl_reg16_enum {
            GPIO4_1 = 0 { name = "Gpio4 1"; desc = "GPIO4_1"; };
            MII_RXD1 = 1 { name = "Mii Rxd1"; desc = "MII_RXD1"; };
            VOU1120_DATA8 = 2 { name = "Vou1120 Data8"; desc = "VOU1120_DATA8"; };
        };

        field {
            name = "muxctrl_reg16";
            desc = "Multiplexing for the MII_RXD1 pin. Other values: reserved.";
            sw = rw;
            hw = r;
            encode = muxctrl_reg16_muxctrl_reg16_enum;
            reset = 0x0;
        } muxctrl_reg16[1:0];
    } muxctrl_reg16 @ 0x40;

    reg {
        name = "Multiplexing control register for the MII_RXD0 pin";
        desc = "muxctrl_reg17 is a multiplexing control register for the MII_RXD0 pin. Hi3516C HD IP Camera SoC

Data sheet 2.3.2 muxctrl_reg17 (offset 0x44, printed page 2-53, `hi3516cv100--Hi3516C-Datasheet.txt` line 3789).";

        enum muxctrl_reg17_muxctrl_reg17_enum {
            GPIO4_0 = 0 { name = "Gpio4 0"; desc = "GPIO4_0"; };
            MII_RXD0 = 1 { name = "Mii Rxd0"; desc = "MII_RXD0"; };
            VOU1120_DATA12 = 2 { name = "Vou1120 Data12"; desc = "VOU1120_DATA12"; };
        };

        field {
            name = "muxctrl_reg17";
            desc = "Multiplexing for the MII_RXD0 pin. Other values: reserved.";
            sw = rw;
            hw = r;
            encode = muxctrl_reg17_muxctrl_reg17_enum;
            reset = 0x0;
        } muxctrl_reg17[1:0];
    } muxctrl_reg17 @ 0x44;

    reg {
        name = "Multiplexing control register for the MII_TXD3 pin";
        desc = "muxctrl_reg18 is a multiplexing control register for the MII_TXD3 pin.

Data sheet 2.3.2 muxctrl_reg18 (offset 0x48, printed page 2-53, `hi3516cv100--Hi3516C-Datasheet.txt` line 3810).";

        enum muxctrl_reg18_muxctrl_reg18_enum {
            GPIO4_7 = 0 { name = "Gpio4 7"; desc = "GPIO4_7"; };
            MII_TXD3 = 1 { name = "Mii Txd3"; desc = "MII_TXD3"; };
            VOU1120_DATA3 = 2 { name = "Vou1120 Data3"; desc = "VOU1120_DATA3"; };
        };

        field {
            name = "muxctrl_reg18";
            desc = "Multiplexing for the MII_TXD3 pin. Other values: reserved.";
            sw = rw;
            hw = r;
            encode = muxctrl_reg18_muxctrl_reg18_enum;
            reset = 0x0;
        } muxctrl_reg18[1:0];
    } muxctrl_reg18 @ 0x48;

    reg {
        name = "Multiplexing control register for the MII_TXD2 pin";
        desc = "muxctrl_reg19 is a multiplexing control register for the MII_TXD2 pin.

Data sheet 2.3.2 muxctrl_reg19 (offset 0x4C, printed page 2-53, `hi3516cv100--Hi3516C-Datasheet.txt` line 3831).";

        enum muxctrl_reg19_muxctrl_reg19_enum {
            GPIO4_6 = 0 { name = "Gpio4 6"; desc = "GPIO4_6"; };
            MII_TXD2 = 1 { name = "Mii Txd2"; desc = "MII_TXD2"; };
            VOU1120_DATA13 = 2 { name = "Vou1120 Data13"; desc = "VOU1120_DATA13"; };
        };

        field {
            name = "muxctrl_reg19";
            desc = "Multiplexing for the MII_TXD2 pin. Other values: reserved.";
            sw = rw;
            hw = r;
            encode = muxctrl_reg19_muxctrl_reg19_enum;
            reset = 0x0;
        } muxctrl_reg19[1:0];
    } muxctrl_reg19 @ 0x4C;

    reg {
        name = "Multiplexing control register for the MII_TXD1 pin";
        desc = "muxctrl_reg20 is a multiplexing control register for the MII_TXD1 pin.

Data sheet 2.3.2 muxctrl_reg20 (offset 0x50, printed page 2-54, `hi3516cv100--Hi3516C-Datasheet.txt` line 3863).";

        enum muxctrl_reg20_muxctrl_reg20_enum {
            GPIO4_5 = 0 { name = "Gpio4 5"; desc = "GPIO4_5"; };
            MII_TXD1 = 1 { name = "Mii Txd1"; desc = "MII_TXD1"; };
            VOU1120_DATA0 = 2 { name = "Vou1120 Data0"; desc = "VOU1120_DATA0"; };
        };

        field {
            name = "muxctrl_reg20";
            desc = "Multiplexing for the MII_TXD1 pin. Other values: reserved.";
            sw = rw;
            hw = r;
            encode = muxctrl_reg20_muxctrl_reg20_enum;
            reset = 0x0;
        } muxctrl_reg20[1:0];
    } muxctrl_reg20 @ 0x50;

    reg {
        name = "Multiplexing control register for the MII_TXD0 pin";
        desc = "muxctrl_reg21 is a multiplexing control register for the MII_TXD0 pin.

Data sheet 2.3.2 muxctrl_reg21 (offset 0x54, printed page 2-54, `hi3516cv100--Hi3516C-Datasheet.txt` line 3884).";

        enum muxctrl_reg21_muxctrl_reg21_enum {
            GPIO4_4 = 0 { name = "Gpio4 4"; desc = "GPIO4_4"; };
            MII_TXD0 = 1 { name = "Mii Txd0"; desc = "MII_TXD0"; };
            VOU1120_DATA4 = 2 { name = "Vou1120 Data4"; desc = "VOU1120_DATA4"; };
        };

        field {
            name = "muxctrl_reg21";
            desc = "Multiplexing for the MII_TXD0 pin. Other values: reserved.";
            sw = rw;
            hw = r;
            encode = muxctrl_reg21_muxctrl_reg21_enum;
            reset = 0x0;
        } muxctrl_reg21[1:0];
    } muxctrl_reg21 @ 0x54;

    reg {
        name = "Multiplexing control register for the MII_RXCK pin";
        desc = "muxctrl_reg22 is a multiplexing control register for the MII_RXCK pin.

Data sheet 2.3.2 muxctrl_reg22 (offset 0x58, printed page 2-55, `hi3516cv100--Hi3516C-Datasheet.txt` line 3914).";

        enum muxctrl_reg22_muxctrl_reg22_enum {
            GPIO3_2 = 0 { name = "Gpio3 2"; desc = "GPIO3_2"; };
            MII_RXCK = 1 { name = "Mii Rxck"; desc = "MII_RXCK"; };
            VOU1120_CLK = 2 { name = "Vou1120 Clk"; desc = "VOU1120_CLK"; };
        };

        field {
            name = "muxctrl_reg22";
            desc = "Multiplexing for the MII_RXCK pin. Other values: reserved.";
            sw = rw;
            hw = r;
            encode = muxctrl_reg22_muxctrl_reg22_enum;
            reset = 0x0;
        } muxctrl_reg22[1:0];
    } muxctrl_reg22 @ 0x58;

    reg {
        name = "Multiplexing control register for the MII_TXCK pin";
        desc = "muxctrl_reg23 is a multiplexing control register for the MII_TXCK pin.

Data sheet 2.3.2 muxctrl_reg23 (offset 0x5C, printed page 2-55, `hi3516cv100--Hi3516C-Datasheet.txt` line 3936).";

        enum muxctrl_reg23_muxctrl_reg23_enum {
            GPIO3_3 = 0 { name = "Gpio3 3"; desc = "GPIO3_3"; };
            MII_TXCK = 1 { name = "Mii Txck"; desc = "MII_TXCK"; };
            VOU1120_DATA7 = 2 { name = "Vou1120 Data7"; desc = "VOU1120_DATA7"; };
            RMII_CLK = 3 { name = "Rmii Clk"; desc = "RMII_CLK"; };
        };

        field {
            name = "muxctrl_reg23";
            desc = "Multiplexing for the MII_TXCK pin.";
            sw = rw;
            hw = r;
            encode = muxctrl_reg23_muxctrl_reg23_enum;
            reset = 0x0;
        } muxctrl_reg23[1:0];
    } muxctrl_reg23 @ 0x5C;

    reg {
        name = "Multiplexing control register for the MII_RXDV pin";
        desc = "muxctrl_reg24 is a multiplexing control register for the MII_RXDV pin. Hi3516C HD IP Camera SoC

Data sheet 2.3.2 muxctrl_reg24 (offset 0x60, printed page 2-56, `hi3516cv100--Hi3516C-Datasheet.txt` line 3966).";

        enum muxctrl_reg24_muxctrl_reg24_enum {
            GPIO3_4 = 0 { name = "Gpio3 4"; desc = "GPIO3_4"; };
            MII_RXDV = 1 { name = "Mii Rxdv"; desc = "MII_RXDV"; };
            VOU1120_DATA1 = 2 { name = "Vou1120 Data1"; desc = "VOU1120_DATA1"; };
        };

        field {
            name = "muxctrl_reg24";
            desc = "Multiplexing for the MII_RXDV pin. Other values: reserved.";
            sw = rw;
            hw = r;
            encode = muxctrl_reg24_muxctrl_reg24_enum;
            reset = 0x0;
        } muxctrl_reg24[1:0];
    } muxctrl_reg24 @ 0x60;

    reg {
        name = "Multiplexing control register for the MII_TXEN pin";
        desc = "muxctrl_reg25 is a multiplexing control register for the MII_TXEN pin.

Data sheet 2.3.2 muxctrl_reg25 (offset 0x64, printed page 2-56, `hi3516cv100--Hi3516C-Datasheet.txt` line 3987).";

        enum muxctrl_reg25_muxctrl_reg25_enum {
            GPIO3_5 = 0 { name = "Gpio3 5"; desc = "GPIO3_5"; };
            MII_TXEN = 1 { name = "Mii Txen"; desc = "MII_TXEN"; };
            VOU1120_DATA5 = 2 { name = "Vou1120 Data5"; desc = "VOU1120_DATA5"; };
        };

        field {
            name = "muxctrl_reg25";
            desc = "Multiplexing for the MII_TXEN pin. Other values: reserved.";
            sw = rw;
            hw = r;
            encode = muxctrl_reg25_muxctrl_reg25_enum;
            reset = 0x0;
        } muxctrl_reg25[1:0];
    } muxctrl_reg25 @ 0x64;

    reg {
        name = "Multiplexing control register for the MII_TXER pin";
        desc = "muxctrl_reg26 is a multiplexing control register for the MII_TXER pin.

Data sheet 2.3.2 muxctrl_reg26 (offset 0x68, printed page 2-56, `hi3516cv100--Hi3516C-Datasheet.txt` line 4008).";

        enum muxctrl_reg26_muxctrl_reg26_enum {
            GPIO2_6 = 0 { name = "Gpio2 6"; desc = "GPIO2_6"; };
            MII_TXER = 1 { name = "Mii Txer"; desc = "MII_TXER"; };
        };

        field {
            name = "muxctrl_reg26";
            desc = "Multiplexing for the MII_TXER pin.";
            sw = rw;
            hw = r;
            encode = muxctrl_reg26_muxctrl_reg26_enum;
            reset = 0x0;
        } muxctrl_reg26[0:0];
    } muxctrl_reg26 @ 0x68;

    reg {
        name = "Multiplexing control register for the MII_RXER pin";
        desc = "muxctrl_reg27 is a multiplexing control register for the MII_RXER pin.

Data sheet 2.3.2 muxctrl_reg27 (offset 0x6C, printed page 2-57, `hi3516cv100--Hi3516C-Datasheet.txt` line 4038).";

        enum muxctrl_reg27_muxctrl_reg27_enum {
            GPIO2_7 = 0 { name = "Gpio2 7"; desc = "GPIO2_7"; };
            MII_RXER = 1 { name = "Mii Rxer"; desc = "MII_RXER"; };
        };

        field {
            name = "muxctrl_reg27";
            desc = "Multiplexing for the MII_RXER pin.";
            sw = rw;
            hw = r;
            encode = muxctrl_reg27_muxctrl_reg27_enum;
            reset = 0x0;
        } muxctrl_reg27[0:0];
    } muxctrl_reg27 @ 0x6C;

    reg {
        name = "Multiplexing control register for the EPHY_CLK pin";
        desc = "muxctrl_reg28 is a multiplexing control register for the EPHY_CLK pin.

Data sheet 2.3.2 muxctrl_reg28 (offset 0x70, printed page 2-57, `hi3516cv100--Hi3516C-Datasheet.txt` line 4058).";

        enum muxctrl_reg28_muxctrl_reg28_enum {
            GPIO1_3 = 0 { name = "Gpio1 3"; desc = "GPIO1_3"; };
            EPHY_CLK = 1 { name = "Ephy Clk"; desc = "EPHY_CLK"; };
            VOU1120_DATA2 = 2 { name = "Vou1120 Data2"; desc = "VOU1120_DATA2"; };
        };

        field {
            name = "muxctrl_reg28";
            desc = "Multiplexing for the EPHY_CLK pin. Other values: reserved.";
            sw = rw;
            hw = r;
            encode = muxctrl_reg28_muxctrl_reg28_enum;
            reset = 0x0;
        } muxctrl_reg28[1:0];
    } muxctrl_reg28 @ 0x70;

    reg {
        name = "Multiplexing control register for the MDCK pin";
        desc = "muxctrl_reg29 is a multiplexing control register for the MDCK pin.

Value 3 (BOOT_SEL) is the boot medium strap sampled at power-on: 0 = SPI NOR flash on the SFC, 1 = NAND flash on the NANDC (DS 1.3.1/1.3.2).

Data sheet 2.3.2 muxctrl_reg29 (offset 0x74, printed page 2-58, `hi3516cv100--Hi3516C-Datasheet.txt` line 4086).";

        enum muxctrl_reg29_muxctrl_reg29_enum {
            GPIO3_6 = 0 { name = "Gpio3 6"; desc = "GPIO3_6"; };
            MDCK = 1 { name = "Mdck"; desc = "MDCK"; };
            VOU1120_DATA6 = 2 { name = "Vou1120 Data6"; desc = "VOU1120_DATA6"; };
            BOOT_SEL = 3 { name = "Boot Sel"; desc = "BOOT_SEL"; };
        };

        field {
            name = "muxctrl_reg29";
            desc = "Multiplexing for the MDCK pin.";
            sw = rw;
            hw = r;
            encode = muxctrl_reg29_muxctrl_reg29_enum;
            reset = 0x0;
        } muxctrl_reg29[1:0];
    } muxctrl_reg29 @ 0x74;

    reg {
        name = "Multiplexing control register for the MDIO pin";
        desc = "muxctrl_reg30 is a multiplexing control register for the MDIO pin.

Data sheet 2.3.2 muxctrl_reg30 (offset 0x78, printed page 2-58, `hi3516cv100--Hi3516C-Datasheet.txt` line 4108).";

        enum muxctrl_reg30_muxctrl_reg30_enum {
            GPIO3_7 = 0 { name = "Gpio3 7"; desc = "GPIO3_7"; };
            MDIO = 1 { name = "Mdio"; desc = "MDIO"; };
            VOU1120_DATA14 = 2 { name = "Vou1120 Data14"; desc = "VOU1120_DATA14"; };
        };

        field {
            name = "muxctrl_reg30";
            desc = "Multiplexing for the MDIO pin. Other values: reserved.";
            sw = rw;
            hw = r;
            encode = muxctrl_reg30_muxctrl_reg30_enum;
            reset = 0x0;
        } muxctrl_reg30[1:0];
    } muxctrl_reg30 @ 0x78;

    reg {
        name = "Multiplexing control register for the FLASH_TRIG pin";
        desc = "muxctrl_reg31 is a multiplexing control register for the FLASH_TRIG pin. Hi3516C HD IP Camera SoC

Data sheet 2.3.2 muxctrl_reg31 (offset 0x7C, printed page 2-59, `hi3516cv100--Hi3516C-Datasheet.txt` line 4140).";

        enum muxctrl_reg31_muxctrl_reg31_enum {
            GPIO1_7 = 0 { name = "Gpio1 7"; desc = "GPIO1_7"; };
            FLASH_TRIG = 1 { name = "Flash Trig"; desc = "FLASH_TRIG"; };
        };

        field {
            name = "muxctrl_reg31";
            desc = "Multiplexing for the FLASH_TRIG pin.";
            sw = rw;
            hw = r;
            encode = muxctrl_reg31_muxctrl_reg31_enum;
            reset = 0x0;
        } muxctrl_reg31[0:0];
    } muxctrl_reg31 @ 0x7C;

    reg {
        name = "Multiplexing control register for the SDIO_CARD_DETECT pin";
        desc = "muxctrl_reg32 is a multiplexing control register for the SDIO_CARD_DETECT pin.

Data sheet 2.3.2 muxctrl_reg32 (offset 0x80, printed page 2-59, `hi3516cv100--Hi3516C-Datasheet.txt` line 4160).";

        enum muxctrl_reg32_muxctrl_reg32_enum {
            GPIO6_0 = 0 { name = "Gpio6 0"; desc = "GPIO6_0"; };
            SDIO_CARD_DETECT = 1 { name = "Sdio Card Detect"; desc = "SDIO_CARD_DETECT"; };
        };

        field {
            name = "muxctrl_reg32";
            desc = "Multiplexing for the SDIO_CARD_DETECT pin.";
            sw = rw;
            hw = r;
            encode = muxctrl_reg32_muxctrl_reg32_enum;
            reset = 0x0;
        } muxctrl_reg32[0:0];
    } muxctrl_reg32 @ 0x80;

    reg {
        name = "Multiplexing control register for the SDIO_CARD_POWER_EN pin";
        desc = "muxctrl_reg33 is a multiplexing control register for the SDIO_CARD_POWER_EN pin.

Data sheet 2.3.2 muxctrl_reg33 (offset 0x84, printed page 2-59, `hi3516cv100--Hi3516C-Datasheet.txt` line 4181).";

        enum muxctrl_reg33_muxctrl_reg33_enum {
            GPIO6_1 = 0 { name = "Gpio6 1"; desc = "GPIO6_1"; };
            SDIO_CARD_POWER = 1 { name = "Sdio Card Power"; desc = "SDIO_CARD_POWER_EN"; };
        };

        field {
            name = "muxctrl_reg33";
            desc = "Multiplexing for the SDIO_CARD_POWER_EN pin.";
            sw = rw;
            hw = r;
            encode = muxctrl_reg33_muxctrl_reg33_enum;
            reset = 0x0;
        } muxctrl_reg33[0:0];
    } muxctrl_reg33 @ 0x84;

    reg {
        name = "Multiplexing control register for the SDIO_CWPR pin";
        desc = "muxctrl_reg34 is a multiplexing control register for the SDIO_CWPR pin.

Data sheet 2.3.2 muxctrl_reg34 (offset 0x88, printed page 2-60, `hi3516cv100--Hi3516C-Datasheet.txt` line 4210).";

        enum muxctrl_reg34_muxctrl_reg34_enum {
            GPIO6_2 = 0 { name = "Gpio6 2"; desc = "GPIO6_2"; };
            SDIO_CWPR = 1 { name = "Sdio Cwpr"; desc = "SDIO_CWPR"; };
        };

        field {
            name = "muxctrl_reg34";
            desc = "Multiplexing for the SDIO_CWPR pin.";
            sw = rw;
            hw = r;
            encode = muxctrl_reg34_muxctrl_reg34_enum;
            reset = 0x0;
        } muxctrl_reg34[0:0];
    } muxctrl_reg34 @ 0x88;

    reg {
        name = "Multiplexing control register for the SDIO_CCMD pin";
        desc = "muxctrl_reg35 is a multiplexing control register for the SDIO_CCMD pin.

Data sheet 2.3.2 muxctrl_reg35 (offset 0x8C, printed page 2-60, `hi3516cv100--Hi3516C-Datasheet.txt` line 4231).";

        enum muxctrl_reg35_muxctrl_reg35_enum {
            GPIO6_3 = 0 { name = "Gpio6 3"; desc = "GPIO6_3"; };
            SDIO_CCMD = 1 { name = "Sdio Ccmd"; desc = "SDIO_CCMD"; };
        };

        field {
            name = "muxctrl_reg35";
            desc = "Multiplexing for the SDIO_CCMD pin.";
            sw = rw;
            hw = r;
            encode = muxctrl_reg35_muxctrl_reg35_enum;
            reset = 0x0;
        } muxctrl_reg35[0:0];
    } muxctrl_reg35 @ 0x8C;

    reg {
        name = "Multiplexing control register for the SDIO_CDATA0 pin";
        desc = "muxctrl_reg36 is a multiplexing control register for the SDIO_CDATA0 pin. Hi3516C HD IP Camera SoC

Data sheet 2.3.2 muxctrl_reg36 (offset 0x90, printed page 2-61, `hi3516cv100--Hi3516C-Datasheet.txt` line 4262).";

        enum muxctrl_reg36_muxctrl_reg36_enum {
            GPIO6_4 = 0 { name = "Gpio6 4"; desc = "GPIO6_4"; };
            SDIO_CDATA0 = 1 { name = "Sdio Cdata0"; desc = "SDIO_CDATA0"; };
            CLK_TEST_OUT0 = 2 { name = "Clk Test Out0"; desc = "CLK_TEST_OUT0"; };
            CLK_TEST_OUT1 = 3 { name = "Clk Test Out1"; desc = "CLK_TEST_OUT1"; };
            CLK_TEST_OUT2 = 4 { name = "Clk Test Out2"; desc = "CLK_TEST_OUT2"; };
            CLK_TEST_OUT3 = 5 { name = "Clk Test Out3"; desc = "CLK_TEST_OUT3"; };
        };

        field {
            name = "muxctrl_reg36";
            desc = "Multiplexing for the SDIO_CDATA0 pin. Other values: reserved.";
            sw = rw;
            hw = r;
            encode = muxctrl_reg36_muxctrl_reg36_enum;
            reset = 0x0;
        } muxctrl_reg36[2:0];
    } muxctrl_reg36 @ 0x90;

    reg {
        name = "Multiplexing control register for the SDIO_CDATA1 pin";
        desc = "muxctrl_reg37 is a multiplexing control register for the SDIO_CDATA1 pin.

Data sheet 2.3.2 muxctrl_reg37 (offset 0x94, printed page 2-61, `hi3516cv100--Hi3516C-Datasheet.txt` line 4287).";

        enum muxctrl_reg37_muxctrl_reg37_enum {
            PLL_TEST_OUT0 = 0 { name = "Pll Test Out0"; desc = "PLL_TEST_OUT0"; };
            SDIO_CDATA1 = 1 { name = "Sdio Cdata1"; desc = "SDIO_CDATA1"; };
            GPIO6_5 = 2 { name = "Gpio6 5"; desc = "GPIO6_5"; };
            PLL_TEST_OUT1 = 3 { name = "Pll Test Out1"; desc = "PLL_TEST_OUT1"; };
            PLL_TEST_OUT2 = 4 { name = "Pll Test Out2"; desc = "PLL_TEST_OUT2"; };
            PLL_TEST_OUT3 = 5 { name = "Pll Test Out3"; desc = "PLL_TEST_OUT3"; };
            RTC_TEST_CLK = 6 { name = "Rtc Test Clk"; desc = "RTC_TEST_CLK"; };
        };

        field {
            name = "muxctrl_reg37";
            desc = "Multiplexing for the SDIO_CDATA1 pin. Other values: reserved.";
            sw = rw;
            hw = r;
            encode = muxctrl_reg37_muxctrl_reg37_enum;
            reset = 0x0;
        } muxctrl_reg37[2:0];
    } muxctrl_reg37 @ 0x94;

    reg {
        name = "Multiplexing control register for the SDIO_CDATA2 pin";
        desc = "muxctrl_reg38 is a multiplexing control register for the SDIO_CDATA2 pin. Hi3516C HD IP Camera SoC

Data sheet 2.3.2 muxctrl_reg38 (offset 0x98, printed page 2-62, `hi3516cv100--Hi3516C-Datasheet.txt` line 4321).";

        enum muxctrl_reg38_muxctrl_reg38_enum {
            GPIO6_6 = 0 { name = "Gpio6 6"; desc = "GPIO6_6"; };
            SDIO_CDATA2 = 1 { name = "Sdio Cdata2"; desc = "SDIO_CDATA2"; };
        };

        field {
            name = "muxctrl_reg38";
            desc = "Multiplexing for the SDIO_CDATA2 pin.";
            sw = rw;
            hw = r;
            encode = muxctrl_reg38_muxctrl_reg38_enum;
            reset = 0x0;
        } muxctrl_reg38[0:0];
    } muxctrl_reg38 @ 0x98;

    reg {
        name = "Multiplexing control register for the SDIO_CDATA3 pin";
        desc = "muxctrl_reg39 is a multiplexing control register for the SDIO_CDATA3 pin.

Data sheet 2.3.2 muxctrl_reg39 (offset 0x9C, printed page 2-62, `hi3516cv100--Hi3516C-Datasheet.txt` line 4341).";

        enum muxctrl_reg39_muxctrl_reg39_enum {
            GPIO6_7 = 0 { name = "Gpio6 7"; desc = "GPIO6_7"; };
            SDIO_CDATA3 = 1 { name = "Sdio Cdata3"; desc = "SDIO_CDATA3"; };
        };

        field {
            name = "muxctrl_reg39";
            desc = "Multiplexing for the SDIO_CDATA3 pin.";
            sw = rw;
            hw = r;
            encode = muxctrl_reg39_muxctrl_reg39_enum;
            reset = 0x0;
        } muxctrl_reg39[0:0];
    } muxctrl_reg39 @ 0x9C;

    reg {
        name = "Multiplexing control register for the SFC_DIO pin";
        desc = "muxctrl_reg40 is a multiplexing control register for the SFC_DIO pin.

Data sheet 2.3.2 muxctrl_reg40 (offset 0xA0, printed page 2-62, `hi3516cv100--Hi3516C-Datasheet.txt` line 4362).";

        enum muxctrl_reg40_muxctrl_reg40_enum {
            SFC_DIO = 0 { name = "Sfc Dio"; desc = "SFC_DIO"; };
            GPIO7_0 = 1 { name = "Gpio7 0"; desc = "GPIO7_0"; };
        };

        field {
            name = "muxctrl_reg40";
            desc = "Multiplexing for the SFC_DIO pin.";
            sw = rw;
            hw = r;
            encode = muxctrl_reg40_muxctrl_reg40_enum;
            reset = 0x0;
        } muxctrl_reg40[0:0];
    } muxctrl_reg40 @ 0xA0;

    reg {
        name = "Multiplexing control register for the SFC_WP_IO2 pin";
        desc = "muxctrl_reg41 is a multiplexing control register for the SFC_WP_IO2 pin.

Data sheet 2.3.2 muxctrl_reg41 (offset 0xA4, printed page 2-63, `hi3516cv100--Hi3516C-Datasheet.txt` line 4391).";

        enum muxctrl_reg41_muxctrl_reg41_enum {
            SFC_WP_IO2 = 0 { name = "Sfc Wp Io2"; desc = "SFC_WP_IO2"; };
            GPIO7_1 = 1 { name = "Gpio7 1"; desc = "GPIO7_1"; };
        };

        field {
            name = "muxctrl_reg41";
            desc = "Multiplexing for the SFC_WP_IO2 pin.";
            sw = rw;
            hw = r;
            encode = muxctrl_reg41_muxctrl_reg41_enum;
            reset = 0x0;
        } muxctrl_reg41[0:0];
    } muxctrl_reg41 @ 0xA4;

    reg {
        name = "Multiplexing control register for the SFC_CLK pin";
        desc = "muxctrl_reg42 is a multiplexing control register for the SFC_CLK pin.

Value 2 (SFC_ADDR_MODE) is the SFC default address-mode strap sampled at power-on: 0 = 3-byte, 1 = 4-byte address mode (DS 2.2 pin table).

Data sheet 2.3.2 muxctrl_reg42 (offset 0xA8, printed page 2-63, `hi3516cv100--Hi3516C-Datasheet.txt` line 4412).";

        enum muxctrl_reg42_muxctrl_reg42_enum {
            SFC_CLK = 0 { name = "Sfc Clk"; desc = "SFC_CLK"; };
            GPIO7_2 = 1 { name = "Gpio7 2"; desc = "GPIO7_2"; };
            SFC_ADDR_MODE = 2 { name = "Sfc Addr Mode"; desc = "SFC_ADDR_MODE"; };
        };

        field {
            name = "muxctrl_reg42";
            desc = "Multiplexing for the SFC_CLK pin. Other values: reserved.";
            sw = rw;
            hw = r;
            encode = muxctrl_reg42_muxctrl_reg42_enum;
            reset = 0x0;
        } muxctrl_reg42[1:0];
    } muxctrl_reg42 @ 0xA8;

    reg {
        name = "Multiplexing control register for the SFC_DOI pin";
        desc = "muxctrl_reg43 is a multiplexing control register for the SFC_DOI pin. Hi3516C HD IP Camera SoC

Data sheet 2.3.2 muxctrl_reg43 (offset 0xAC, printed page 2-64, `hi3516cv100--Hi3516C-Datasheet.txt` line 4444).";

        enum muxctrl_reg43_muxctrl_reg43_enum {
            SFC_DOI = 0 { name = "Sfc Doi"; desc = "SFC_DOI"; };
            GPIO7_3 = 1 { name = "Gpio7 3"; desc = "GPIO7_3"; };
        };

        field {
            name = "muxctrl_reg43";
            desc = "Multiplexing for the SFC_DOI pin.";
            sw = rw;
            hw = r;
            encode = muxctrl_reg43_muxctrl_reg43_enum;
            reset = 0x0;
        } muxctrl_reg43[0:0];
    } muxctrl_reg43 @ 0xAC;

    reg {
        name = "Multiplexing control register for the SFC_HOLD_IO3 pin";
        desc = "muxctrl_reg44 is a multiplexing control register for the SFC_HOLD_IO3 pin.

Data sheet 2.3.2 muxctrl_reg44 (offset 0xB0, printed page 2-64, `hi3516cv100--Hi3516C-Datasheet.txt` line 4471).";

        enum muxctrl_reg44_muxctrl_reg44_enum {
            SFC_HOLD_IO3 = 0 { name = "Sfc Hold Io3"; desc = "SFC_HOLD_IO3"; };
            GPIO7_4 = 1 { name = "Gpio7 4"; desc = "GPIO7_4"; };
        };

        field {
            name = "muxctrl_reg44";
            desc = "Multiplexing for the SFC_HOLD_IO3 pin.";
            sw = rw;
            hw = r;
            encode = muxctrl_reg44_muxctrl_reg44_enum;
            reset = 0x0;
        } muxctrl_reg44[0:0];
    } muxctrl_reg44 @ 0xB0;

    reg {
        name = "Multiplexing control register for the USB_OVRCUR pin";
        desc = "muxctrl_reg45 is a multiplexing control register for the USB_OVRCUR pin. Hi3516C HD IP Camera SoC

Data sheet 2.3.2 muxctrl_reg45 (offset 0xB4, printed page 2-65, `hi3516cv100--Hi3516C-Datasheet.txt` line 4509).";

        enum muxctrl_reg45_muxctrl_reg45_enum {
            GPIO5_0 = 0 { name = "Gpio5 0"; desc = "GPIO5_0"; };
            USB_OVRCUR = 1 { name = "Usb Ovrcur"; desc = "USB_OVRCUR"; };
        };

        field {
            name = "muxctrl_reg45";
            desc = "Multiplexing for the USB_OVRCUR pin.";
            sw = rw;
            hw = r;
            encode = muxctrl_reg45_muxctrl_reg45_enum;
            reset = 0x0;
        } muxctrl_reg45[0:0];
    } muxctrl_reg45 @ 0xB4;

    reg {
        name = "Multiplexing control register for the USB_PWREN pin";
        desc = "muxctrl_reg46 is a multiplexing control register for the USB_PWREN pin.

Data sheet 2.3.2 muxctrl_reg46 (offset 0xB8, printed page 2-65, `hi3516cv100--Hi3516C-Datasheet.txt` line 4534).";

        enum muxctrl_reg46_muxctrl_reg46_enum {
            GPIO5_1 = 0 { name = "Gpio5 1"; desc = "GPIO5_1"; };
            USB_PWREN = 1 { name = "Usb Pwren"; desc = "USB_PWREN"; };
        };

        field {
            name = "muxctrl_reg46";
            desc = "Multiplexing for the USB_PWREN pin.";
            sw = rw;
            hw = r;
            encode = muxctrl_reg46_muxctrl_reg46_enum;
            reset = 0x0;
        } muxctrl_reg46[0:0];
    } muxctrl_reg46 @ 0xB8;

    reg {
        name = "Multiplexing control register for the PWM_OUT0 pin";
        desc = "muxctrl_reg47 is a multiplexing control register for the PWM_OUT0 pin. Hi3516C HD IP Camera SoC

Data sheet 2.3.2 muxctrl_reg47 (offset 0xBC, printed page 2-66, `hi3516cv100--Hi3516C-Datasheet.txt` line 4568).";

        enum muxctrl_reg47_muxctrl_reg47_enum {
            GPIO5_2 = 0 { name = "Gpio5 2"; desc = "GPIO5_2"; };
            PWM_OUT0 = 1 { name = "Pwm Out0"; desc = "PWM_OUT0"; };
        };

        field {
            name = "muxctrl_reg47";
            desc = "Multiplexing for the PWM_OUT0 pin.";
            sw = rw;
            hw = r;
            encode = muxctrl_reg47_muxctrl_reg47_enum;
            reset = 0x0;
        } muxctrl_reg47[0:0];
    } muxctrl_reg47 @ 0xBC;

    reg {
        name = "Multiplexing control register for the PWM_OUT1 pin";
        desc = "muxctrl_reg48 is a multiplexing control register for the PWM_OUT1 pin.

Data sheet 2.3.2 muxctrl_reg48 (offset 0xC0, printed page 2-66, `hi3516cv100--Hi3516C-Datasheet.txt` line 4594).";

        enum muxctrl_reg48_muxctrl_reg48_enum {
            GPIO5_3 = 0 { name = "Gpio5 3"; desc = "GPIO5_3"; };
            PWM_OUT1 = 1 { name = "Pwm Out1"; desc = "PWM_OUT1"; };
        };

        field {
            name = "muxctrl_reg48";
            desc = "Multiplexing for the PWM_OUT1 pin.";
            sw = rw;
            hw = r;
            encode = muxctrl_reg48_muxctrl_reg48_enum;
            reset = 0x0;
        } muxctrl_reg48[0:0];
    } muxctrl_reg48 @ 0xC0;

    reg {
        name = "Multiplexing control register for the IR_IN pin";
        desc = "muxctrl_reg49 is a multiplexing control register for the IR_IN pin. Hi3516C HD IP Camera SoC

Data sheet 2.3.2 muxctrl_reg49 (offset 0xC4, printed page 2-67, `hi3516cv100--Hi3516C-Datasheet.txt` line 4629).";

        enum muxctrl_reg49_muxctrl_reg49_enum {
            IR = 0 { name = "Ir"; desc = "IR_IN"; };
            GPIO7_5 = 1 { name = "Gpio7 5"; desc = "GPIO7_5"; };
        };

        field {
            name = "muxctrl_reg49";
            desc = "Multiplexing for the IR_IN pin.";
            sw = rw;
            hw = r;
            encode = muxctrl_reg49_muxctrl_reg49_enum;
            reset = 0x0;
        } muxctrl_reg49[0:0];
    } muxctrl_reg49 @ 0xC4;

    reg {
        name = "Multiplexing control register for the NF_DQ0 pin";
        desc = "muxctrl_reg50 is a multiplexing control register for the NF_DQ0 pin.

Data sheet 2.3.2 muxctrl_reg50 (offset 0xC8, printed page 2-67, `hi3516cv100--Hi3516C-Datasheet.txt` line 4656).";

        enum muxctrl_reg50_muxctrl_reg50_enum {
            NF_DQ0 = 0 { name = "Nf Dq0"; desc = "NF_DQ0"; };
            GPIO9_0 = 1 { name = "Gpio9 0"; desc = "GPIO9_0"; };
        };

        field {
            name = "muxctrl_reg50";
            desc = "Multiplexing for the NF_DQ0 pin.";
            sw = rw;
            hw = r;
            encode = muxctrl_reg50_muxctrl_reg50_enum;
            reset = 0x0;
        } muxctrl_reg50[0:0];
    } muxctrl_reg50 @ 0xC8;

    reg {
        name = "Multiplexing control register for the NF_DQ1 pin";
        desc = "muxctrl_reg51 is a multiplexing control register for the NF_DQ1 pin. Hi3516C HD IP Camera SoC

Data sheet 2.3.2 muxctrl_reg51 (offset 0xCC, printed page 2-68, `hi3516cv100--Hi3516C-Datasheet.txt` line 4692).";

        enum muxctrl_reg51_muxctrl_reg51_enum {
            NF_DQ1 = 0 { name = "Nf Dq1"; desc = "NF_DQ1"; };
            GPIO9_1 = 1 { name = "Gpio9 1"; desc = "GPIO9_1"; };
        };

        field {
            name = "muxctrl_reg51";
            desc = "Multiplexing for the NF_DQ1 pin.";
            sw = rw;
            hw = r;
            encode = muxctrl_reg51_muxctrl_reg51_enum;
            reset = 0x0;
        } muxctrl_reg51[0:0];
    } muxctrl_reg51 @ 0xCC;

    reg {
        name = "Multiplexing control register for the NF_DQ2 pin";
        desc = "muxctrl_reg52 is a multiplexing control register for the NF_DQ2 pin.

Data sheet 2.3.2 muxctrl_reg52 (offset 0xD0, printed page 2-68, `hi3516cv100--Hi3516C-Datasheet.txt` line 4719).";

        enum muxctrl_reg52_muxctrl_reg52_enum {
            NF_DQ2 = 0 { name = "Nf Dq2"; desc = "NF_DQ2"; };
            GPIO9_2 = 1 { name = "Gpio9 2"; desc = "GPIO9_2"; };
        };

        field {
            name = "muxctrl_reg52";
            desc = "Multiplexing for the NF_DQ2 pin.";
            sw = rw;
            hw = r;
            encode = muxctrl_reg52_muxctrl_reg52_enum;
            reset = 0x0;
        } muxctrl_reg52[0:0];
    } muxctrl_reg52 @ 0xD0;

    reg {
        name = "Multiplexing control register for the NF_DQ3 pin";
        desc = "muxctrl_reg53 is a multiplexing control register for the NF_DQ3 pin. Hi3516C HD IP Camera SoC

Data sheet 2.3.2 muxctrl_reg53 (offset 0xD4, printed page 2-69, `hi3516cv100--Hi3516C-Datasheet.txt` line 4753).";

        enum muxctrl_reg53_muxctrl_reg53_enum {
            NF_DQ3 = 0 { name = "Nf Dq3"; desc = "NF_DQ3"; };
            GPIO9_3 = 1 { name = "Gpio9 3"; desc = "GPIO9_3"; };
        };

        field {
            name = "muxctrl_reg53";
            desc = "Multiplexing for the NF_DQ3 pin.";
            sw = rw;
            hw = r;
            encode = muxctrl_reg53_muxctrl_reg53_enum;
            reset = 0x0;
        } muxctrl_reg53[0:0];
    } muxctrl_reg53 @ 0xD4;

    reg {
        name = "Multiplexing control register for the NF_DQ4 pin";
        desc = "muxctrl_reg54 is a multiplexing control register for the NF_DQ4 pin.

Data sheet 2.3.2 muxctrl_reg54 (offset 0xD8, printed page 2-69, `hi3516cv100--Hi3516C-Datasheet.txt` line 4778).";

        enum muxctrl_reg54_muxctrl_reg54_enum {
            NF_DQ4 = 0 { name = "Nf Dq4"; desc = "NF_DQ4"; };
            GPIO9_4 = 1 { name = "Gpio9 4"; desc = "GPIO9_4"; };
        };

        field {
            name = "muxctrl_reg54";
            desc = "Multiplexing for the NF_DQ4 pin.";
            sw = rw;
            hw = r;
            encode = muxctrl_reg54_muxctrl_reg54_enum;
            reset = 0x0;
        } muxctrl_reg54[0:0];
    } muxctrl_reg54 @ 0xD8;

    reg {
        name = "Multiplexing control register for the NF_DQ5 pin";
        desc = "muxctrl_reg55 is a multiplexing control register for the NF_DQ5 pin. Hi3516C HD IP Camera SoC

Data sheet 2.3.2 muxctrl_reg55 (offset 0xDC, printed page 2-70, `hi3516cv100--Hi3516C-Datasheet.txt` line 4813).";

        enum muxctrl_reg55_muxctrl_reg55_enum {
            NF_DQ5 = 0 { name = "Nf Dq5"; desc = "NF_DQ5"; };
            GPIO9_5 = 1 { name = "Gpio9 5"; desc = "GPIO9_5"; };
        };

        field {
            name = "muxctrl_reg55";
            desc = "Multiplexing for the NF_DQ5 pin.";
            sw = rw;
            hw = r;
            encode = muxctrl_reg55_muxctrl_reg55_enum;
            reset = 0x0;
        } muxctrl_reg55[0:0];
    } muxctrl_reg55 @ 0xDC;

    reg {
        name = "Multiplexing control register for the NF_DQ6 pin";
        desc = "muxctrl_reg56 is a multiplexing control register for the NF_DQ6 pin.

Data sheet 2.3.2 muxctrl_reg56 (offset 0xE0, printed page 2-70, `hi3516cv100--Hi3516C-Datasheet.txt` line 4838).";

        enum muxctrl_reg56_muxctrl_reg56_enum {
            NF_DQ6 = 0 { name = "Nf Dq6"; desc = "NF_DQ6"; };
            GPIO9_6 = 1 { name = "Gpio9 6"; desc = "GPIO9_6"; };
        };

        field {
            name = "muxctrl_reg56";
            desc = "Multiplexing for the NF_DQ6 pin.";
            sw = rw;
            hw = r;
            encode = muxctrl_reg56_muxctrl_reg56_enum;
            reset = 0x0;
        } muxctrl_reg56[0:0];
    } muxctrl_reg56 @ 0xE0;

    reg {
        name = "Multiplexing control register for the NF_DQ7 pin";
        desc = "muxctrl_reg57 is a multiplexing control register for the NF_DQ7 pin. Hi3516C HD IP Camera SoC

Data sheet 2.3.2 muxctrl_reg57 (offset 0xE4, printed page 2-71, `hi3516cv100--Hi3516C-Datasheet.txt` line 4875).";

        enum muxctrl_reg57_muxctrl_reg57_enum {
            NF_DQ7 = 0 { name = "Nf Dq7"; desc = "NF_DQ7"; };
            GPIO9_7 = 1 { name = "Gpio9 7"; desc = "GPIO9_7"; };
        };

        field {
            name = "muxctrl_reg57";
            desc = "Multiplexing for the NF_DQ7 pin.";
            sw = rw;
            hw = r;
            encode = muxctrl_reg57_muxctrl_reg57_enum;
            reset = 0x0;
        } muxctrl_reg57[0:0];
    } muxctrl_reg57 @ 0xE4;

    reg {
        name = "Multiplexing control register for the NF_RDY0 pin";
        desc = "muxctrl_reg58 is a multiplexing control register for the NF_RDY0 pin.

Data sheet 2.3.2 muxctrl_reg58 (offset 0xE8, printed page 2-71, `hi3516cv100--Hi3516C-Datasheet.txt` line 4901).";

        enum muxctrl_reg58_muxctrl_reg58_enum {
            NF_RDY0 = 0 { name = "Nf Rdy0"; desc = "NF_RDY0"; };
            GPIO8_0 = 1 { name = "Gpio8 0"; desc = "GPIO8_0"; };
        };

        field {
            name = "muxctrl_reg58";
            desc = "Multiplexing for the NF_RDY0 pin.";
            sw = rw;
            hw = r;
            encode = muxctrl_reg58_muxctrl_reg58_enum;
            reset = 0x0;
        } muxctrl_reg58[0:0];
    } muxctrl_reg58 @ 0xE8;

    reg {
        name = "Multiplexing control register for the NF_RDY1 pin";
        desc = "muxctrl_reg59 is a multiplexing control register for the NF_RDY1 pin. Hi3516C HD IP Camera SoC

Data sheet 2.3.2 muxctrl_reg59 (offset 0xEC, printed page 2-72, `hi3516cv100--Hi3516C-Datasheet.txt` line 4938).";

        enum muxctrl_reg59_muxctrl_reg59_enum {
            NF_RDY1 = 0 { name = "Nf Rdy1"; desc = "NF_RDY1"; };
            GPIO8_1 = 1 { name = "Gpio8 1"; desc = "GPIO8_1"; };
        };

        field {
            name = "muxctrl_reg59";
            desc = "Multiplexing for the NF_RDY1 pin.";
            sw = rw;
            hw = r;
            encode = muxctrl_reg59_muxctrl_reg59_enum;
            reset = 0x0;
        } muxctrl_reg59[0:0];
    } muxctrl_reg59 @ 0xEC;

    reg {
        name = "Multiplexing control register for the NF_REN pin";
        desc = "muxctrl_reg60 is a multiplexing control register for the NF_REN pin.

Value 2 (NF_BOOT_PIN0) is one of the NAND flash type straps (NF_BOOT_PIN0..4, 5-bit code locked at power-on: page size, ECC type, block size, address cycles; DS 2.2 pin table).

Data sheet 2.3.2 muxctrl_reg60 (offset 0xF0, printed page 2-72, `hi3516cv100--Hi3516C-Datasheet.txt` line 4963).";

        enum muxctrl_reg60_muxctrl_reg60_enum {
            NF_REN = 0 { name = "Nf Ren"; desc = "NF_REN"; };
            GPIO8_2 = 1 { name = "Gpio8 2"; desc = "GPIO8_2"; };
            NF_BOOT_PIN0 = 2 { name = "Nf Boot Pin0"; desc = "NF_BOOT_PIN0"; };
        };

        field {
            name = "muxctrl_reg60";
            desc = "Multiplexing for the NF_REN pin. Other values: reserved.";
            sw = rw;
            hw = r;
            encode = muxctrl_reg60_muxctrl_reg60_enum;
            reset = 0x0;
        } muxctrl_reg60[1:0];
    } muxctrl_reg60 @ 0xF0;

    reg {
        name = "Multiplexing control register for the NF_CSN0 pin";
        desc = "muxctrl_reg61 is a multiplexing control register for the NF_CSN0 pin. Hi3516C HD IP Camera SoC

Data sheet 2.3.2 muxctrl_reg61 (offset 0xF4, printed page 2-73, `hi3516cv100--Hi3516C-Datasheet.txt` line 5000).";

        enum muxctrl_reg61_muxctrl_reg61_enum {
            NF_CSN0 = 0 { name = "Nf Csn0"; desc = "NF_CSN0"; };
            GPIO8_3 = 1 { name = "Gpio8 3"; desc = "GPIO8_3"; };
        };

        field {
            name = "muxctrl_reg61";
            desc = "Multiplexing for the NF_CSN0 pin.";
            sw = rw;
            hw = r;
            encode = muxctrl_reg61_muxctrl_reg61_enum;
            reset = 0x0;
        } muxctrl_reg61[0:0];
    } muxctrl_reg61 @ 0xF4;

    reg {
        name = "Multiplexing control register for the NF_CSN1 pin";
        desc = "muxctrl_reg62 is a multiplexing control register for the NF_CSN1 pin.

Data sheet 2.3.2 muxctrl_reg62 (offset 0xF8, printed page 2-73, `hi3516cv100--Hi3516C-Datasheet.txt` line 5028).";

        enum muxctrl_reg62_muxctrl_reg62_enum {
            NF_CSN1 = 0 { name = "Nf Csn1"; desc = "NF_CSN1"; };
            GPIO8_4 = 1 { name = "Gpio8 4"; desc = "GPIO8_4"; };
        };

        field {
            name = "muxctrl_reg62";
            desc = "Multiplexing for the NF_CSN1 pin.";
            sw = rw;
            hw = r;
            encode = muxctrl_reg62_muxctrl_reg62_enum;
            reset = 0x0;
        } muxctrl_reg62[0:0];
    } muxctrl_reg62 @ 0xF8;

    reg {
        name = "Multiplexing control register for the NF_CLE pin";
        desc = "muxctrl_reg63 is a multiplexing control register for the NF_CLE pin. Hi3516C HD IP Camera SoC

Value 2 (NF_BOOT_PIN1): NAND flash type strap, see muxctrl_reg60.

Data sheet 2.3.2 muxctrl_reg63 (offset 0xFC, printed page 2-74, `hi3516cv100--Hi3516C-Datasheet.txt` line 5066).";

        enum muxctrl_reg63_muxctrl_reg63_enum {
            NF_CLE = 0 { name = "Nf Cle"; desc = "NF_CLE"; };
            GPIO8_5 = 1 { name = "Gpio8 5"; desc = "GPIO8_5"; };
            NF_BOOT_PIN1 = 2 { name = "Nf Boot Pin1"; desc = "NF_BOOT_PIN1"; };
        };

        field {
            name = "muxctrl_reg63";
            desc = "Multiplexing for the NF_CLE pin. Other values: reserved.";
            sw = rw;
            hw = r;
            encode = muxctrl_reg63_muxctrl_reg63_enum;
            reset = 0x0;
        } muxctrl_reg63[1:0];
    } muxctrl_reg63 @ 0xFC;

    reg {
        name = "Multiplexing control register for the NF_ALE pin";
        desc = "muxctrl_reg64 is a multiplexing control register for the NF_ALE pin.

Value 2 (NF_BOOT_PIN2): NAND flash type strap, see muxctrl_reg60.

Data sheet 2.3.2 muxctrl_reg64 (offset 0x100, printed page 2-74, `hi3516cv100--Hi3516C-Datasheet.txt` line 5095).";

        enum muxctrl_reg64_muxctrl_reg64_enum {
            NF_ALE = 0 { name = "Nf Ale"; desc = "NF_ALE"; };
            GPIO8_6 = 1 { name = "Gpio8 6"; desc = "GPIO8_6"; };
            NF_BOOT_PIN2 = 2 { name = "Nf Boot Pin2"; desc = "NF_BOOT_PIN2"; };
        };

        field {
            name = "muxctrl_reg64";
            desc = "Multiplexing for the NF_ALE pin. Other values: reserved.";
            sw = rw;
            hw = r;
            encode = muxctrl_reg64_muxctrl_reg64_enum;
            reset = 0x0;
        } muxctrl_reg64[1:0];
    } muxctrl_reg64 @ 0x100;

    reg {
        name = "Multiplexing control register for the NF_WEN pin";
        desc = "muxctrl_reg65 is a multiplexing control register for the NF_WEN pin. Hi3516C HD IP Camera SoC

Value 2 (NF_BOOT_PIN3): NAND flash type strap, see muxctrl_reg60.

Data sheet 2.3.2 muxctrl_reg65 (offset 0x104, printed page 2-75, `hi3516cv100--Hi3516C-Datasheet.txt` line 5132).";

        enum muxctrl_reg65_muxctrl_reg65_enum {
            NF_WEN = 0 { name = "Nf Wen"; desc = "NF_WEN"; };
            GPIO8_7 = 1 { name = "Gpio8 7"; desc = "GPIO8_7"; };
            NF_BOOT_PIN3 = 2 { name = "Nf Boot Pin3"; desc = "NF_BOOT_PIN3"; };
        };

        field {
            name = "muxctrl_reg65";
            desc = "Multiplexing for the NF_WEN pin. Other values: reserved.";
            sw = rw;
            hw = r;
            encode = muxctrl_reg65_muxctrl_reg65_enum;
            reset = 0x0;
        } muxctrl_reg65[1:0];
    } muxctrl_reg65 @ 0x104;

    reg {
        name = "Multiplexing control register for the UART2_RXD pin";
        desc = "muxctrl_reg66 is a multiplexing control register for the UART2_RXD pin.

Data sheet 2.3.2 muxctrl_reg66 (offset 0x108, printed page 2-75, `hi3516cv100--Hi3516C-Datasheet.txt` line 5162).";

        enum muxctrl_reg66_muxctrl_reg66_enum {
            GPIO7_6 = 0 { name = "Gpio7 6"; desc = "GPIO7_6"; };
            UART2_RXD = 1 { name = "Uart2 Rxd"; desc = "UART2_RXD"; };
        };

        field {
            name = "muxctrl_reg66";
            desc = "Multiplexing for the UART2_RXD pin.";
            sw = rw;
            hw = r;
            encode = muxctrl_reg66_muxctrl_reg66_enum;
            reset = 0x0;
        } muxctrl_reg66[0:0];
    } muxctrl_reg66 @ 0x108;

    reg {
        name = "Multiplexing control register for the UART2_TXD pin";
        desc = "muxctrl_reg67 is a multiplexing control register for the UART2_TXD pin. Hi3516C HD IP Camera SoC

Data sheet 2.3.2 muxctrl_reg67 (offset 0x10C, printed page 2-76, `hi3516cv100--Hi3516C-Datasheet.txt` line 5200).";

        enum muxctrl_reg67_muxctrl_reg67_enum {
            GPIO7_7 = 0 { name = "Gpio7 7"; desc = "GPIO7_7"; };
            UART2_TXD = 1 { name = "Uart2 Txd"; desc = "UART2_TXD"; };
        };

        field {
            name = "muxctrl_reg67";
            desc = "Multiplexing for the UART2_TXD pin.";
            sw = rw;
            hw = r;
            encode = muxctrl_reg67_muxctrl_reg67_enum;
            reset = 0x0;
        } muxctrl_reg67[0:0];
    } muxctrl_reg67 @ 0x10C;

    reg {
        name = "Multiplexing control register for the SPI1_SCLK pin";
        desc = "muxctrl_reg68 is a multiplexing control register for the SPI1_SCLK pin.

Data sheet 2.3.2 muxctrl_reg68 (offset 0x110, printed page 2-76, `hi3516cv100--Hi3516C-Datasheet.txt` line 5227).";

        enum muxctrl_reg68_muxctrl_reg68_enum {
            GPIO5_4 = 0 { name = "Gpio5 4"; desc = "GPIO5_4"; };
            SPI1_SCLK = 1 { name = "Spi1 Sclk"; desc = "SPI1_SCLK"; };
        };

        field {
            name = "muxctrl_reg68";
            desc = "Multiplexing for the SPI1_SCLK pin.";
            sw = rw;
            hw = r;
            encode = muxctrl_reg68_muxctrl_reg68_enum;
            reset = 0x0;
        } muxctrl_reg68[0:0];
    } muxctrl_reg68 @ 0x110;

    reg {
        name = "Multiplexing control register for the SPI1_SDO pin";
        desc = "muxctrl_reg69 is a multiplexing control register for the SPI1_SDO pin. Hi3516C HD IP Camera SoC

Data sheet 2.3.2 muxctrl_reg69 (offset 0x114, printed page 2-77, `hi3516cv100--Hi3516C-Datasheet.txt` line 5265).";

        enum muxctrl_reg69_muxctrl_reg69_enum {
            GPIO5_5 = 0 { name = "Gpio5 5"; desc = "GPIO5_5"; };
            SPI1_SDO = 1 { name = "Spi1 Sdo"; desc = "SPI1_SDO"; };
        };

        field {
            name = "muxctrl_reg69";
            desc = "Multiplexing for the SPI1_SDO pin.";
            sw = rw;
            hw = r;
            encode = muxctrl_reg69_muxctrl_reg69_enum;
            reset = 0x0;
        } muxctrl_reg69[0:0];
    } muxctrl_reg69 @ 0x114;

    reg {
        name = "Multiplexing control register for the SPI1_SDI pin";
        desc = "muxctrl_reg70 is a multiplexing control register for the SPI1_SDI pin.

Data sheet 2.3.2 muxctrl_reg70 (offset 0x118, printed page 2-77, `hi3516cv100--Hi3516C-Datasheet.txt` line 5292).";

        enum muxctrl_reg70_muxctrl_reg70_enum {
            GPIO5_6 = 0 { name = "Gpio5 6"; desc = "GPIO5_6"; };
            SPI1_SDI = 1 { name = "Spi1 Sdi"; desc = "SPI1_SDI"; };
        };

        field {
            name = "muxctrl_reg70";
            desc = "Multiplexing for the SPI1_SDI pin.";
            sw = rw;
            hw = r;
            encode = muxctrl_reg70_muxctrl_reg70_enum;
            reset = 0x0;
        } muxctrl_reg70[0:0];
    } muxctrl_reg70 @ 0x118;

    reg {
        name = "Multiplexing control register for the SPI1_CSN pin";
        desc = "muxctrl_reg71 is a multiplexing control register for the SPI1_CSN pin. Hi3516C HD IP Camera SoC

Data sheet 2.3.2 muxctrl_reg71 (offset 0x11C, printed page 2-78, `hi3516cv100--Hi3516C-Datasheet.txt` line 5330).";

        enum muxctrl_reg71_muxctrl_reg71_enum {
            GPIO5_7 = 0 { name = "Gpio5 7"; desc = "GPIO5_7"; };
            SPI1_CSN = 1 { name = "Spi1 Csn"; desc = "SPI1_CSN"; };
        };

        field {
            name = "muxctrl_reg71";
            desc = "Multiplexing for the SPI1_CSN pin.";
            sw = rw;
            hw = r;
            encode = muxctrl_reg71_muxctrl_reg71_enum;
            reset = 0x0;
        } muxctrl_reg71[0:0];
    } muxctrl_reg71 @ 0x11C;

    reg {
        name = "Multiplexing control register for the JTAG_TRSTN pin";
        desc = "muxctrl_reg72 is a multiplexing control register for the JTAG_TRSTN pin.

Data sheet 2.3.2 muxctrl_reg72 (offset 0x120, printed page 2-78, `hi3516cv100--Hi3516C-Datasheet.txt` line 5358).";

        enum muxctrl_reg72_muxctrl_reg72_enum {
            GPIO0_0 = 0 { name = "Gpio0 0"; desc = "GPIO0_0"; };
            JTAG_TRSTN = 1 { name = "Jtag Trstn"; desc = "JTAG_TRSTN"; };
            TEMPER_DQ = 2 { name = "Temper Dq"; desc = "TEMPER_DQ"; };
        };

        field {
            name = "muxctrl_reg72";
            desc = "Multiplexing for the JTAG_TRSTN pin. Other values: reserved.";
            sw = rw;
            hw = r;
            encode = muxctrl_reg72_muxctrl_reg72_enum;
            reset = 0x0;
        } muxctrl_reg72[1:0];
    } muxctrl_reg72 @ 0x120;

    reg {
        name = "Multiplexing control register for the JTAG_TCK pin";
        desc = "muxctrl_reg73 is a multiplexing control register for the JTAG_TCK pin. Hi3516C HD IP Camera SoC

Data sheet 2.3.2 muxctrl_reg73 (offset 0x124, printed page 2-79, `hi3516cv100--Hi3516C-Datasheet.txt` line 5397).";

        enum muxctrl_reg73_muxctrl_reg73_enum {
            GPIO0_1 = 0 { name = "Gpio0 1"; desc = "GPIO0_1"; };
            JTAG_TCK = 1 { name = "Jtag Tck"; desc = "JTAG_TCK"; };
            TEMPER_DQ = 2 { name = "Temper Dq"; desc = "TEMPER_DQ"; };
        };

        field {
            name = "muxctrl_reg73";
            desc = "Multiplexing for the JTAG_TCK pin. Other values: reserved.";
            sw = rw;
            hw = r;
            encode = muxctrl_reg73_muxctrl_reg73_enum;
            reset = 0x0;
        } muxctrl_reg73[1:0];
    } muxctrl_reg73 @ 0x124;

    reg {
        name = "Multiplexing control register for the JTAG_TMS pin";
        desc = "muxctrl_reg74 is a multiplexing control register for the JTAG_TMS pin.

Data sheet 2.3.2 muxctrl_reg74 (offset 0x128, printed page 2-79, `hi3516cv100--Hi3516C-Datasheet.txt` line 5426).";

        enum muxctrl_reg74_muxctrl_reg74_enum {
            GPIO0_2 = 0 { name = "Gpio0 2"; desc = "GPIO0_2"; };
            JTAG_TMS = 1 { name = "Jtag Tms"; desc = "JTAG_TMS"; };
            TEMPER_DQ = 2 { name = "Temper Dq"; desc = "TEMPER_DQ"; };
        };

        field {
            name = "muxctrl_reg74";
            desc = "Multiplexing for the JTAG_TMS pin. Other values: reserved.";
            sw = rw;
            hw = r;
            encode = muxctrl_reg74_muxctrl_reg74_enum;
            reset = 0x0;
        } muxctrl_reg74[1:0];
    } muxctrl_reg74 @ 0x128;

    reg {
        name = "Multiplexing control register for the JTAG_TDO pin";
        desc = "muxctrl_reg75 is a multiplexing control register for the JTAG_TDO pin. Hi3516C HD IP Camera SoC

Data sheet 2.3.2 muxctrl_reg75 (offset 0x12C, printed page 2-80, `hi3516cv100--Hi3516C-Datasheet.txt` line 5466).";

        enum muxctrl_reg75_muxctrl_reg75_enum {
            GPIO0_3 = 0 { name = "Gpio0 3"; desc = "GPIO0_3"; };
            JTAG_TDO = 1 { name = "Jtag Tdo"; desc = "JTAG_TDO"; };
            TEMPER_DQ = 2 { name = "Temper Dq"; desc = "TEMPER_DQ"; };
        };

        field {
            name = "muxctrl_reg75";
            desc = "Multiplexing for the JTAG_TDO pin. Other values: reserved.";
            sw = rw;
            hw = r;
            encode = muxctrl_reg75_muxctrl_reg75_enum;
            reset = 0x0;
        } muxctrl_reg75[1:0];
    } muxctrl_reg75 @ 0x12C;

    reg {
        name = "Multiplexing control register for the JTAG_TDI pin";
        desc = "muxctrl_reg76 is a multiplexing control register for the JTAG_TDI pin.

Data sheet 2.3.2 muxctrl_reg76 (offset 0x130, printed page 2-80, `hi3516cv100--Hi3516C-Datasheet.txt` line 5493).";

        enum muxctrl_reg76_muxctrl_reg76_enum {
            GPIO0_4 = 0 { name = "Gpio0 4"; desc = "GPIO0_4"; };
            JTAG_TDI = 1 { name = "Jtag Tdi"; desc = "JTAG_TDI"; };
            TEMPER_DQ = 2 { name = "Temper Dq"; desc = "TEMPER_DQ"; };
        };

        field {
            name = "muxctrl_reg76";
            desc = "Multiplexing for the JTAG_TDI pin. Other values: reserved.";
            sw = rw;
            hw = r;
            encode = muxctrl_reg76_muxctrl_reg76_enum;
            reset = 0x0;
        } muxctrl_reg76[1:0];
    } muxctrl_reg76 @ 0x130;

    reg {
        name = "Multiplexing control register for the GPIO0_5 pin";
        desc = "muxctrl_reg77 is a multiplexing control register for the GPIO0_5 pin. Hi3516C HD IP Camera SoC

Data sheet 2.3.2 muxctrl_reg77 (offset 0x134, printed page 2-81, `hi3516cv100--Hi3516C-Datasheet.txt` line 5533).";

        enum muxctrl_reg77_muxctrl_reg77_enum {
            SVB_PWM = 0 { name = "Svb Pwm"; desc = "SVB_PWM"; };
            GPIO0_5 = 1 { name = "Gpio0 5"; desc = "GPIO0_5"; };
            TEMPER_DQ = 2 { name = "Temper Dq"; desc = "TEMPER_DQ"; };
        };

        field {
            name = "muxctrl_reg77";
            desc = "Multiplexing for the GPIO0_5 pin. Other values: reserved.";
            sw = rw;
            hw = r;
            encode = muxctrl_reg77_muxctrl_reg77_enum;
            reset = 0x0;
        } muxctrl_reg77[1:0];
    } muxctrl_reg77 @ 0x134;

    reg {
        name = "Multiplexing control register for the GPIO0_6 pin";
        desc = "muxctrl_reg78 is a multiplexing control register for the GPIO0_6 pin.

Data sheet 2.3.2 muxctrl_reg78 (offset 0x138, printed page 2-81, `hi3516cv100--Hi3516C-Datasheet.txt` line 5563).";

        enum muxctrl_reg78_muxctrl_reg78_enum {
            GPIO0_6 = 0 { name = "Gpio0 6"; desc = "GPIO0_6"; };
            SVB_PWM = 1 { name = "Svb Pwm"; desc = "SVB_PWM"; };
            TEMPER_DQ = 2 { name = "Temper Dq"; desc = "TEMPER_DQ"; };
        };

        field {
            name = "muxctrl_reg78";
            desc = "Multiplexing for the GPIO0_6 pin. Other values: reserved.";
            sw = rw;
            hw = r;
            encode = muxctrl_reg78_muxctrl_reg78_enum;
            reset = 0x0;
        } muxctrl_reg78[1:0];
    } muxctrl_reg78 @ 0x138;

    reg {
        name = "Multiplexing control register for the GPIO0_7 pin";
        desc = "muxctrl_reg79 is a multiplexing control register for the GPIO0_7 pin. Hi3516C HD IP Camera SoC

Data sheet 2.3.2 muxctrl_reg79 (offset 0x13C, printed page 2-82, `hi3516cv100--Hi3516C-Datasheet.txt` line 5597).";

        enum muxctrl_reg79_muxctrl_reg79_enum {
            SYS_RSTN_OUT = 0 { name = "Sys Rstn Out"; desc = "SYS_RSTN_OUT"; };
            GPIO0_7 = 1 { name = "Gpio0 7"; desc = "GPIO0_7"; };
            TEMPER_DQ = 2 { name = "Temper Dq"; desc = "TEMPER_DQ"; };
        };

        field {
            name = "muxctrl_reg79";
            desc = "Multiplexing for the GPIO0_7 pin. Other values: reserved.";
            sw = rw;
            hw = r;
            encode = muxctrl_reg79_muxctrl_reg79_enum;
            reset = 0x0;
        } muxctrl_reg79[1:0];
    } muxctrl_reg79 @ 0x13C;

    reg {
        name = "Multiplexing control register for the VIU_CLK pin";
        desc = "muxctrl_reg80 is a multiplexing control register for the VIU_CLK pin.

Data sheet 2.3.2 muxctrl_reg80 (offset 0x140, printed page 2-82, `hi3516cv100--Hi3516C-Datasheet.txt` line 5627).";

        enum muxctrl_reg80_muxctrl_reg80_enum {
            VIU_CLK = 0 { name = "Viu Clk"; desc = "VIU_CLK"; };
            GPIO11_6 = 1 { name = "Gpio11 6"; desc = "GPIO11_6"; };
        };

        field {
            name = "muxctrl_reg80";
            desc = "Multiplexing for the VIU_CLK pin.";
            sw = rw;
            hw = r;
            encode = muxctrl_reg80_muxctrl_reg80_enum;
            reset = 0x0;
        } muxctrl_reg80[0:0];
    } muxctrl_reg80 @ 0x140;

    reg {
        name = "Multiplexing control register for the VIU_VS pin";
        desc = "muxctrl_reg81 is a multiplexing control register for the VIU_VS pin. Hi3516C HD IP Camera SoC

Data sheet 2.3.2 muxctrl_reg81 (offset 0x144, printed page 2-83, `hi3516cv100--Hi3516C-Datasheet.txt` line 5665).";

        enum muxctrl_reg81_muxctrl_reg81_enum {
            VIU_VS = 0 { name = "Viu Vs"; desc = "VIU_VS"; };
            GPIO11_5 = 1 { name = "Gpio11 5"; desc = "GPIO11_5"; };
        };

        field {
            name = "muxctrl_reg81";
            desc = "Multiplexing for the VIU_VS pin.";
            sw = rw;
            hw = r;
            encode = muxctrl_reg81_muxctrl_reg81_enum;
            reset = 0x0;
        } muxctrl_reg81[0:0];
    } muxctrl_reg81 @ 0x144;

    reg {
        name = "Multiplexing control register for the VIU_HS pin";
        desc = "muxctrl_reg82 is a multiplexing control register for the VIU_HS pin.

Data sheet 2.3.2 muxctrl_reg82 (offset 0x148, printed page 2-83, `hi3516cv100--Hi3516C-Datasheet.txt` line 5690).";

        enum muxctrl_reg82_muxctrl_reg82_enum {
            VIU_HS = 0 { name = "Viu Hs"; desc = "VIU_HS"; };
            GPIO11_4 = 1 { name = "Gpio11 4"; desc = "GPIO11_4"; };
        };

        field {
            name = "muxctrl_reg82";
            desc = "Multiplexing for the VIU_HS pin.";
            sw = rw;
            hw = r;
            encode = muxctrl_reg82_muxctrl_reg82_enum;
            reset = 0x0;
        } muxctrl_reg82[0:0];
    } muxctrl_reg82 @ 0x148;

    reg {
        name = "Multiplexing control register for the VIU_DAT11 pin";
        desc = "muxctrl_reg83 is a multiplexing control register for the VIU_DAT11 pin. Hi3516C HD IP Camera SoC

Data sheet 2.3.2 muxctrl_reg83 (offset 0x14C, printed page 2-84, `hi3516cv100--Hi3516C-Datasheet.txt` line 5727).";

        enum muxctrl_reg83_muxctrl_reg83_enum {
            VIU_DAT11 = 0 { name = "Viu Dat11"; desc = "VIU_DAT11"; };
            GPIO11_3 = 1 { name = "Gpio11 3"; desc = "GPIO11_3"; };
        };

        field {
            name = "muxctrl_reg83";
            desc = "Multiplexing for the VIU_DAT11 pin.";
            sw = rw;
            hw = r;
            encode = muxctrl_reg83_muxctrl_reg83_enum;
            reset = 0x0;
        } muxctrl_reg83[0:0];
    } muxctrl_reg83 @ 0x14C;

    reg {
        name = "Multiplexing control register for the VIU_DAT10 pin";
        desc = "muxctrl_reg84 is a multiplexing control register for the VIU_DAT10 pin.

Data sheet 2.3.2 muxctrl_reg84 (offset 0x150, printed page 2-84, `hi3516cv100--Hi3516C-Datasheet.txt` line 5755).";

        enum muxctrl_reg84_muxctrl_reg84_enum {
            VIU_DAT10 = 0 { name = "Viu Dat10"; desc = "VIU_DAT10"; };
            GPIO11_2 = 1 { name = "Gpio11 2"; desc = "GPIO11_2"; };
        };

        field {
            name = "muxctrl_reg84";
            desc = "Multiplexing for the VIU_DAT10 pin.";
            sw = rw;
            hw = r;
            encode = muxctrl_reg84_muxctrl_reg84_enum;
            reset = 0x0;
        } muxctrl_reg84[0:0];
    } muxctrl_reg84 @ 0x150;

    reg {
        name = "Multiplexing control register for the VIU_DAT9 pin";
        desc = "muxctrl_reg85 is a multiplexing control register for the VIU_DAT9 pin. Hi3516C HD IP Camera SoC

Data sheet 2.3.2 muxctrl_reg85 (offset 0x154, printed page 2-85, `hi3516cv100--Hi3516C-Datasheet.txt` line 5791).";

        enum muxctrl_reg85_muxctrl_reg85_enum {
            VIU_DAT9 = 0 { name = "Viu Dat9"; desc = "VIU_DAT9"; };
            GPIO11_1 = 1 { name = "Gpio11 1"; desc = "GPIO11_1"; };
        };

        field {
            name = "muxctrl_reg85";
            desc = "Multiplexing for the VIU_DAT9 pin.";
            sw = rw;
            hw = r;
            encode = muxctrl_reg85_muxctrl_reg85_enum;
            reset = 0x0;
        } muxctrl_reg85[0:0];
    } muxctrl_reg85 @ 0x154;

    reg {
        name = "Multiplexing control register for the VIU_DAT8 pin";
        desc = "muxctrl_reg86 is a multiplexing control register for the VIU_DAT8 pin.

Data sheet 2.3.2 muxctrl_reg86 (offset 0x158, printed page 2-85, `hi3516cv100--Hi3516C-Datasheet.txt` line 5816).";

        enum muxctrl_reg86_muxctrl_reg86_enum {
            VIU_DAT8 = 0 { name = "Viu Dat8"; desc = "VIU_DAT8"; };
            GPIO11_0 = 1 { name = "Gpio11 0"; desc = "GPIO11_0"; };
        };

        field {
            name = "muxctrl_reg86";
            desc = "Multiplexing for the VIU_DAT8 pin.";
            sw = rw;
            hw = r;
            encode = muxctrl_reg86_muxctrl_reg86_enum;
            reset = 0x0;
        } muxctrl_reg86[0:0];
    } muxctrl_reg86 @ 0x158;

    reg {
        name = "Multiplexing control register for the VIU_DAT7 pin";
        desc = "muxctrl_reg87 is a multiplexing control register for the VIU_DAT7 pin. Hi3516C HD IP Camera SoC

Data sheet 2.3.2 muxctrl_reg87 (offset 0x15C, printed page 2-86, `hi3516cv100--Hi3516C-Datasheet.txt` line 5854).";

        enum muxctrl_reg87_muxctrl_reg87_enum {
            VIU_DAT7 = 0 { name = "Viu Dat7"; desc = "VIU_DAT7"; };
            GPIO10_7 = 1 { name = "Gpio10 7"; desc = "GPIO10_7"; };
        };

        field {
            name = "muxctrl_reg87";
            desc = "Multiplexing for the VIU_DAT7 pin.";
            sw = rw;
            hw = r;
            encode = muxctrl_reg87_muxctrl_reg87_enum;
            reset = 0x0;
        } muxctrl_reg87[0:0];
    } muxctrl_reg87 @ 0x15C;

    reg {
        name = "Multiplexing control register for the VIU_DAT6 pin";
        desc = "muxctrl_reg88 is a multiplexing control register for the VIU_DAT6 pin.

Data sheet 2.3.2 muxctrl_reg88 (offset 0x160, printed page 2-86, `hi3516cv100--Hi3516C-Datasheet.txt` line 5881).";

        enum muxctrl_reg88_muxctrl_reg88_enum {
            VIU_DAT6 = 0 { name = "Viu Dat6"; desc = "VIU_DAT6"; };
            GPIO10_6 = 1 { name = "Gpio10 6"; desc = "GPIO10_6"; };
        };

        field {
            name = "muxctrl_reg88";
            desc = "Multiplexing for the VIU_DAT6 pin.";
            sw = rw;
            hw = r;
            encode = muxctrl_reg88_muxctrl_reg88_enum;
            reset = 0x0;
        } muxctrl_reg88[0:0];
    } muxctrl_reg88 @ 0x160;

    reg {
        name = "Multiplexing control register for the VIU_DAT5 pin";
        desc = "muxctrl_reg89 is a multiplexing control register for the VIU_DAT5 pin. Hi3516C HD IP Camera SoC

Data sheet 2.3.2 muxctrl_reg89 (offset 0x164, printed page 2-87, `hi3516cv100--Hi3516C-Datasheet.txt` line 5919).";

        enum muxctrl_reg89_muxctrl_reg89_enum {
            VIU_DAT5 = 0 { name = "Viu Dat5"; desc = "VIU_DAT5"; };
            GPIO10_5 = 1 { name = "Gpio10 5"; desc = "GPIO10_5"; };
        };

        field {
            name = "muxctrl_reg89";
            desc = "Multiplexing for the VIU_DAT5 pin.";
            sw = rw;
            hw = r;
            encode = muxctrl_reg89_muxctrl_reg89_enum;
            reset = 0x0;
        } muxctrl_reg89[0:0];
    } muxctrl_reg89 @ 0x164;

    reg {
        name = "Multiplexing control register for the VIU_DAT4 pin";
        desc = "muxctrl_reg90 is a multiplexing control register for the VIU_DAT4 pin.

Data sheet 2.3.2 muxctrl_reg90 (offset 0x168, printed page 2-87, `hi3516cv100--Hi3516C-Datasheet.txt` line 5944).";

        enum muxctrl_reg90_muxctrl_reg90_enum {
            VIU_DAT4 = 0 { name = "Viu Dat4"; desc = "VIU_DAT4"; };
            GPIO10_4 = 1 { name = "Gpio10 4"; desc = "GPIO10_4"; };
        };

        field {
            name = "muxctrl_reg90";
            desc = "Multiplexing for the VIU_DAT4 pin.";
            sw = rw;
            hw = r;
            encode = muxctrl_reg90_muxctrl_reg90_enum;
            reset = 0x0;
        } muxctrl_reg90[0:0];
    } muxctrl_reg90 @ 0x168;

    reg {
        name = "Multiplexing control register for the VIU_DAT3 pin";
        desc = "muxctrl_reg91 is a multiplexing control register for the VIU_DAT3 pin. Hi3516C HD IP Camera SoC

Data sheet 2.3.2 muxctrl_reg91 (offset 0x16C, printed page 2-88, `hi3516cv100--Hi3516C-Datasheet.txt` line 5982).";

        enum muxctrl_reg91_muxctrl_reg91_enum {
            VIU_DAT3 = 0 { name = "Viu Dat3"; desc = "VIU_DAT3"; };
            GPIO10_3 = 1 { name = "Gpio10 3"; desc = "GPIO10_3"; };
        };

        field {
            name = "muxctrl_reg91";
            desc = "Multiplexing for the VIU_DAT3 pin.";
            sw = rw;
            hw = r;
            encode = muxctrl_reg91_muxctrl_reg91_enum;
            reset = 0x0;
        } muxctrl_reg91[0:0];
    } muxctrl_reg91 @ 0x16C;

    reg {
        name = "Multiplexing control register for the VIU_DAT2 pin";
        desc = "muxctrl_reg92 is a multiplexing control register for the VIU_DAT2 pin.

Data sheet 2.3.2 muxctrl_reg92 (offset 0x170, printed page 2-88, `hi3516cv100--Hi3516C-Datasheet.txt` line 6009).";

        enum muxctrl_reg92_muxctrl_reg92_enum {
            VIU_DAT2 = 0 { name = "Viu Dat2"; desc = "VIU_DAT2"; };
            GPIO10_2 = 1 { name = "Gpio10 2"; desc = "GPIO10_2"; };
        };

        field {
            name = "muxctrl_reg92";
            desc = "Multiplexing for the VIU_DAT2 pin.";
            sw = rw;
            hw = r;
            encode = muxctrl_reg92_muxctrl_reg92_enum;
            reset = 0x0;
        } muxctrl_reg92[0:0];
    } muxctrl_reg92 @ 0x170;

    reg {
        name = "Multiplexing control register for the VIU_DAT1 pin";
        desc = "muxctrl_reg93 is a multiplexing control register for the VIU_DAT1 pin. Hi3516C HD IP Camera SoC

Data sheet 2.3.2 muxctrl_reg93 (offset 0x174, printed page 2-89, `hi3516cv100--Hi3516C-Datasheet.txt` line 6046).";

        enum muxctrl_reg93_muxctrl_reg93_enum {
            VIU_DAT1 = 0 { name = "Viu Dat1"; desc = "VIU_DAT1"; };
            GPIO10_1 = 1 { name = "Gpio10 1"; desc = "GPIO10_1"; };
        };

        field {
            name = "muxctrl_reg93";
            desc = "Multiplexing for the VIU_DAT1 pin.";
            sw = rw;
            hw = r;
            encode = muxctrl_reg93_muxctrl_reg93_enum;
            reset = 0x0;
        } muxctrl_reg93[0:0];
    } muxctrl_reg93 @ 0x174;

    reg {
        name = "Multiplexing control register for the VIU_DAT0 pin";
        desc = "muxctrl_reg94 is a multiplexing control register for the VIU_DAT0 pin.

Data sheet 2.3.2 muxctrl_reg94 (offset 0x178, printed page 2-89, `hi3516cv100--Hi3516C-Datasheet.txt` line 6073).";

        enum muxctrl_reg94_muxctrl_reg94_enum {
            VIU_DAT0 = 0 { name = "Viu Dat0"; desc = "VIU_DAT0"; };
            GPIO10_0 = 1 { name = "Gpio10 0"; desc = "GPIO10_0"; };
        };

        field {
            name = "muxctrl_reg94";
            desc = "Multiplexing for the VIU_DAT0 pin.";
            sw = rw;
            hw = r;
            encode = muxctrl_reg94_muxctrl_reg94_enum;
            reset = 0x0;
        } muxctrl_reg94[0:0];
    } muxctrl_reg94 @ 0x178;
};

`endif
