`ifndef EHI3518EV100_CRG_RDL
`define EHI3518EV100_CRG_RDL
regfile eHI3518EV100_CRG {
    name = "Clock and reset generator (CRG)";
    desc = "Clock and reset generator (CRG). 33 registers extracted programmatically from the Hi3518E 720p IP Camera SoC data sheet (Issue 03, 2015-11-26); chapter 3.2.5, table 3-19. Field names, bit ranges, access types and reset values are taken from the register tables; reset values are the data sheet total reset values split onto the fields (per-field values where the table has them). Label: PROVEN. Hardware not verified here (no board).";
    reg {
        name = "PERI_CRG0";
        desc = "PERI_CRG0 is APLL configuration register 0. PERI_CRG0 (offset 0x0000, total reset 0x1100_0000; PROVEN: Hi3518E V100 data sheet, PDF page 156, section 3.2.5).";
        field {
            name = "reserved";
            desc = "Reserved.";
            sw = r; hw = w;
            reset = 0x0;
        } reserved_31_31[31:31];
        field {
            name = "apll_bypass";
            desc = "APLL clock frequency-division bypass control.
- 0: no bypass
- 1: bypass";
            sw = rw; hw = r;
            reset = 0x0;
        } apll_bypass[30:30];
        field {
            name = "apll_postdiv2";
            desc = "Level-2 output divider of the APLL.";
            sw = rw; hw = r;
            reset = 0x2;
        } apll_postdiv2[29:27];
        field {
            name = "apll_postdiv1";
            desc = "Level-1 output divider of the APLL.";
            sw = rw; hw = r;
            reset = 0x1;
        } apll_postdiv1[26:24];
        field {
            name = "apll_frac";
            desc = "Decimal divider of the APLL.";
            sw = rw; hw = r;
            reset = 0x0;
        } apll_frac[23:0];
    } PERI_CRG0 @ 0x0;
    reg {
        name = "PERI_CRG1";
        desc = "PERI_CRG1 is APLL configuration register 1. PERI_CRG1 (offset 0x0004, total reset 0x006C_306E; PROVEN: Hi3518E V100 data sheet, PDF page 157, section 3.2.5).";
        field {
            name = "reserved";
            desc = "Reserved.";
            sw = r; hw = w;
            reset = 0x0;
        } reserved_31_24[31:24];
        field {
            name = "apll_dacpd";
            desc = "APLL test signal control.
- 0: power down
- 1: normal";
            sw = rw; hw = r;
            reset = 0x0;
        } apll_dacpd[23:23];
        field {
            name = "apll_dsmpd";
            desc = "APLL decimal frequency-division control.
- 0: decimal frequency-division mode
- 1: integer frequency-division mode";
            sw = rw; hw = r;
            reset = 0x1;
        } apll_dsmpd[22:22];
        field {
            name = "apll_pd";
            desc = "APLL power down control.
- 0: power down
- 1: normal";
            sw = rw; hw = r;
            reset = 0x1;
        } apll_pd[21:21];
        field {
            name = "apll_foutvcopd";
            desc = "Power down control for the APLL VCO output.
- 0: no output clock
- 1: normal output clock";
            sw = rw; hw = r;
            reset = 0x0;
        } apll_foutvcopd[20:20];
        field {
            name = "apll_postdivpd";
            desc = "Power down control for the APLL POSTDIV output.
- 0: no output clock
- 1: normal output clock";
            sw = rw; hw = r;
            reset = 0x1;
        } apll_postdivpd[19:19];
        field {
            name = "apll_fout4phasepd";
            desc = "Power down control for the APLL FOUT output.
- 0: no output clock
- 1: normal output clock";
            sw = rw; hw = r;
            reset = 0x1;
        } apll_fout4phasepd[18:18];
        field {
            name = "apll_refdiv";
            desc = "Divider of the APLL reference clock.";
            sw = rw; hw = r;
            reset = 0x3;
        } apll_refdiv[17:12];
        field {
            name = "apll_fbdiv";
            desc = "Integral multiplier of the APLL.";
            sw = rw; hw = r;
            reset = 0x6e;
        } apll_fbdiv[11:0];
    } PERI_CRG1 @ 0x4;
    reg {
        name = "PERI_CRG2";
        desc = "PERI_CRG2 is VPLL0 configuration register 0. PERI_CRG2 (offset 0x0008, total reset 0x1200_0000; PROVEN: Hi3518E V100 data sheet, PDF page 158, section 3.2.5).";
        field {
            name = "reserved";
            desc = "Reserved.";
            sw = r; hw = w;
            reset = 0x0;
        } reserved_31_31[31:31];
        field {
            name = "vpll0_bypass";
            desc = "VPLL0 clock frequency-division bypass control.
- 0: no bypass
- 1: bypass";
            sw = rw; hw = r;
            reset = 0x0;
        } vpll0_bypass[30:30];
        field {
            name = "vpll0_postdiv2";
            desc = "Level-2 output divider of VPLL0.";
            sw = rw; hw = r;
            reset = 0x2;
        } vpll0_postdiv2[29:27];
        field {
            name = "vpll0_postdiv1";
            desc = "Level-1 output divider of VPLL0.";
            sw = rw; hw = r;
            reset = 0x2;
        } vpll0_postdiv1[26:24];
        field {
            name = "vpll0_frac";
            desc = "Decimal divider of VPLL0.";
            sw = rw; hw = r;
            reset = 0x0;
        } vpll0_frac[23:0];
    } PERI_CRG2 @ 0x8;
    reg {
        name = "PERI_CRG3";
        desc = "PERI_CRG3 is VPLL0 configuration register 1. PERI_CRG3 (offset 0x000C, total reset 0x007C_2063; PROVEN: Hi3518E V100 data sheet, PDF page 158, section 3.2.5).";
        field {
            name = "reserved";
            desc = "Reserved.";
            sw = r; hw = w;
            reset = 0x0;
        } reserved_31_24[31:24];
        field {
            name = "vpll0_dacpd";
            desc = "VPLL0 test signal control.
- 0: power down
- 1: normal";
            sw = rw; hw = r;
            reset = 0x0;
        } vpll0_dacpd[23:23];
        field {
            name = "vpll0_dsmpd";
            desc = "VPLL0 decimal frequency-division control.
- 0: decimal frequency-division mode
- 1: integer frequency-division mode";
            sw = rw; hw = r;
            reset = 0x1;
        } vpll0_dsmpd[22:22];
        field {
            name = "vpll0_pd";
            desc = "VPLL0 power down control.
- 0: power down
- 1: normal";
            sw = rw; hw = r;
            reset = 0x1;
        } vpll0_pd[21:21];
        field {
            name = "vpll0_foutvcopd";
            desc = "Power down control for the VPLL0 VCO output.
- 0: no output clock
- 1: normal output clock";
            sw = rw; hw = r;
            reset = 0x1;
        } vpll0_foutvcopd[20:20];
        field {
            name = "vpll0_postdivpd";
            desc = "Power down control for the VPLL0 POSTDIV output.
- 0: no output clock
- 1: normal output clock";
            sw = rw; hw = r;
            reset = 0x1;
        } vpll0_postdivpd[19:19];
        field {
            name = "vpll0_fout4phasepd";
            desc = "Power down control for the VPLL0 FOUT output.
- 0: no output clock
- 1: normal output clock";
            sw = rw; hw = r;
            reset = 0x1;
        } vpll0_fout4phasepd[18:18];
        field {
            name = "vpll0_refdiv";
            desc = "Divider of the VPLL0 reference clock.";
            sw = rw; hw = r;
            reset = 0x2;
        } vpll0_refdiv[17:12];
        field {
            name = "vpll0_fbdiv";
            desc = "Integral multiplier of VPLL0.";
            sw = rw; hw = r;
            reset = 0x63;
        } vpll0_fbdiv[11:0];
    } PERI_CRG3 @ 0xc;
    reg {
        name = "PERI_CRG4";
        desc = "PERI_CRG4 is BPLL configuration register 0. PERI_CRG4 (offset 0x0010, total reset 0x1100_0000; PROVEN: Hi3518E V100 data sheet, PDF page 159, section 3.2.5).";
        field {
            name = "reserved";
            desc = "Reserved.";
            sw = r; hw = w;
            reset = 0x0;
        } reserved_31_31[31:31];
        field {
            name = "bpll_bypass";
            desc = "BPLL clock frequency-division bypass control.
- 0: no bypass
- 1: bypass";
            sw = rw; hw = r;
            reset = 0x0;
        } bpll_bypass[30:30];
        field {
            name = "bpll_postdiv2";
            desc = "Level-2 output divider of BPLL.";
            sw = rw; hw = r;
            reset = 0x2;
        } bpll_postdiv2[29:27];
        field {
            name = "bpll_postdiv1";
            desc = "Level-1 output divider of BPLL.";
            sw = rw; hw = r;
            reset = 0x1;
        } bpll_postdiv1[26:24];
        field {
            name = "bpll_frac";
            desc = "Decimal divider of BPLL.";
            sw = rw; hw = r;
            reset = 0x0;
        } bpll_frac[23:0];
    } PERI_CRG4 @ 0x10;
    reg {
        name = "PERI_CRG5";
        desc = "PERI_CRG5 is BPLL configuration register 1. PERI_CRG5 (offset 0x0014, total reset 0x006C_306E; PROVEN: Hi3518E V100 data sheet, PDF page 160, section 3.2.5).";
        field {
            name = "reserved";
            desc = "Reserved.";
            sw = r; hw = w;
            reset = 0x0;
        } reserved_31_24[31:24];
        field {
            name = "bpll_dacpd";
            desc = "BPLL test signal control.
- 0: power down
- 1: normal";
            sw = rw; hw = r;
            reset = 0x0;
        } bpll_dacpd[23:23];
        field {
            name = "bpll_dsmpd";
            desc = "BPLL decimal frequency-division control.
- 0: decimal frequency-division mode
- 1: integer frequency-division mode";
            sw = rw; hw = r;
            reset = 0x1;
        } bpll_dsmpd[22:22];
        field {
            name = "bpll_pd";
            desc = "BPLL power down control.
- 0: power down
- 1: normal";
            sw = rw; hw = r;
            reset = 0x1;
        } bpll_pd[21:21];
        field {
            name = "bpll_foutvcopd";
            desc = "Power down control for the BPLL VCO output.
- 0: no output clock
- 1: normal output clock";
            sw = rw; hw = r;
            reset = 0x0;
        } bpll_foutvcopd[20:20];
        field {
            name = "bpll_postdivpd";
            desc = "Power down control for the BPLL POSTDIV output.
- 0: no output clock
- 1: normal output clock";
            sw = rw; hw = r;
            reset = 0x1;
        } bpll_postdivpd[19:19];
        field {
            name = "bpll_fout4phasepd";
            desc = "Power down control for the BPLL FOUT output.
- 0: no output clock
- 1: normal output clock";
            sw = rw; hw = r;
            reset = 0x1;
        } bpll_fout4phasepd[18:18];
        field {
            name = "bpll_refdiv";
            desc = "Divider of the BPLL reference clock.";
            sw = rw; hw = r;
            reset = 0x3;
        } bpll_refdiv[17:12];
        field {
            name = "bpll_fbdiv";
            desc = "Integral multiplier of BPLL.";
            sw = rw; hw = r;
            reset = 0x6e;
        } bpll_fbdiv[11:0];
    } PERI_CRG5 @ 0x14;
    reg {
        name = "PERI_CRG8";
        desc = "PERI_CRG8 is EPLL configuration register 0. PERI_CRG8 (offset 0x0020, total reset 0x1B00_0000; PROVEN: Hi3518E V100 data sheet, PDF page 162, section 3.2.5).";
        field {
            name = "reserved";
            desc = "Reserved.";
            sw = r; hw = w;
            reset = 0x0;
        } reserved_31_31[31:31];
        field {
            name = "epll_bypass";
            desc = "EPLL clock frequency-division bypass control.
- 0: no bypass
- 1: bypass";
            sw = rw; hw = r;
            reset = 0x0;
        } epll_bypass[30:30];
        field {
            name = "epll_postdiv2";
            desc = "Level-2 output divider of the EPLL.";
            sw = rw; hw = r;
            reset = 0x3;
        } epll_postdiv2[29:27];
        field {
            name = "epll_postdiv1";
            desc = "Level-1 output divider of the EPLL.";
            sw = rw; hw = r;
            reset = 0x3;
        } epll_postdiv1[26:24];
        field {
            name = "epll_frac";
            desc = "Decimal divider of the EPLL.";
            sw = rw; hw = r;
            reset = 0x0;
        } epll_frac[23:0];
    } PERI_CRG8 @ 0x20;
    reg {
        name = "PERI_CRG9";
        desc = "PERI_CRG9 is EPLL configuration register 1. PERI_CRG9 (offset 0x0024, total reset 0x007C_40E1; PROVEN: Hi3518E V100 data sheet, PDF page 162, section 3.2.5).";
        field {
            name = "reserved";
            desc = "Reserved.";
            sw = r; hw = w;
            reset = 0x0;
        } reserved_31_24[31:24];
        field {
            name = "epll_dacpd";
            desc = "EPLL test signal control.
- 0: power down
- 1: normal";
            sw = rw; hw = r;
            reset = 0x0;
        } epll_dacpd[23:23];
        field {
            name = "epll_dsmpd";
            desc = "EPLL decimal frequency-division control.
- 0: decimal frequency-division mode
- 1: integer frequency-division mode";
            sw = rw; hw = r;
            reset = 0x1;
        } epll_dsmpd[22:22];
        field {
            name = "epll_pd";
            desc = "EPLL power down control.
- 0: power down
- 1: normal";
            sw = rw; hw = r;
            reset = 0x1;
        } epll_pd[21:21];
        field {
            name = "epll_foutvcopd";
            desc = "Power down control for the EPLLVCO output.
- 0: no output clock
- 1: normal output clock";
            sw = rw; hw = r;
            reset = 0x1;
        } epll_foutvcopd[20:20];
        field {
            name = "epll_postdivpd";
            desc = "Power down control for the EPLL POSTDIV output.
- 0: no output clock
- 1: normal output clock";
            sw = rw; hw = r;
            reset = 0x1;
        } epll_postdivpd[19:19];
        field {
            name = "epll_fout4phasepd";
            desc = "Power down control for the EPLL FOUT output.
- 0: no output clock
- 1: normal output clock";
            sw = rw; hw = r;
            reset = 0x1;
        } epll_fout4phasepd[18:18];
        field {
            name = "epll_refdiv";
            desc = "Divider of the EPLL reference clock.";
            sw = rw; hw = r;
            reset = 0x4;
        } epll_refdiv[17:12];
        field {
            name = "epll_fbdiv";
            desc = "Integral multiplier of the EPLL.";
            sw = rw; hw = r;
            reset = 0xe1;
        } epll_fbdiv[11:0];
    } PERI_CRG9 @ 0x24;
    reg {
        name = "PERI_CRG10";
        desc = "PERI_CRG10 is an ARM9/DDR frequency mode and reset configuration register. PERI_CRG10 (offset 0x0028, total reset 0x0000_0010; PROVEN: Hi3518E V100 data sheet, PDF page 163, section 3.2.5).";
        field {
            name = "reserved";
            desc = "Reserved.";
            sw = r; hw = w;
            reset = 0x0;
        } reserved_31_11[31:11];
        field {
            name = "cpuclk_loaden";
            desc = "CPU clock DFS frequency division configuration enable. To change the frequency division configuration, perform the following steps: 1 Write a new frequency division configuration value. 2 Write 0 to veduclk_loaden. 3 Write 1 to veduclk_loaden.";
            sw = rw; hw = r;
            reset = 0x0;
        } cpuclk_loaden[10:10];
        field {
            name = "cpuclk_skipcfg";
            desc = "CPU clock DFS frequency division configuration. N: N-beat clocks are disabled every 32-beat CPU clocks.";
            sw = rw; hw = r;
            reset = 0x0;
        } cpuclk_skipcfg[9:5];
        field {
            name = "cpu_srst_req";
            desc = "CPU soft reset request. This bit is valid only in slave loading mode.
- 0: deassert reset
- 1: reset";
            sw = rw; hw = r;
            reset = 0x1;
        } cpu_srst_req[4:4];
        field {
            name = "reserved";
            desc = "Reserved";
            sw = r; hw = w;
            reset = 0x0;
        } reserved_3_0[3:0];
    } PERI_CRG10 @ 0x28;
    reg {
        name = "PERI_CRG11";
        desc = "PERI_CRG11 is a VICAP clock and reset configuration register. PERI_CRG11 (offset 0x002C, total reset 0x0000_0000; PROVEN: Hi3518E V100 data sheet, PDF page 164, section 3.2.5).";
        field {
            name = "reserved";
            desc = "Reserved";
            sw = rw; hw = r;
            reset = 0x0;
        } reserved_31_8[31:8];
        field {
            name = "vi_selftest";
            desc = "VICAP self-test mode.
- 0: normal mode. The I/O input clock is selected.
- 1: 1: self-test mode. The on-chip 24 MHz test clock is selected.";
            sw = rw; hw = r;
            reset = 0x0;
        } vi_selftest[7:7];
        field {
            name = "vi_pctrl";
            desc = "VI input associated clock phase control.
- 0: normal phase clock
- 1: reverse phase clock";
            sw = rw; hw = r;
            reset = 0x0;
        } vi_pctrl[6:6];
        field {
            name = "isp_cken";
            desc = "VI ISP clock gating.
- 0: disabled
- 1: enabled";
            sw = rw; hw = r;
            reset = 0x0;
        } isp_cken[5:5];
        field {
            name = "isp_rst_req";
            desc = "VI ISP soft reset request.
- 0: deassert reset
- 1: reset";
            sw = rw; hw = r;
            reset = 0x0;
        } isp_rst_req[4:4];
        field {
            name = "vi_cken";
            desc = "VI clock gating.
- 0: disabled
- 1: enabled";
            sw = rw; hw = r;
            reset = 0x0;
        } vi_cken[3:3];
        field {
            name = "vi_rst_req";
            desc = "VI soft reset request.
- 0: deassert reset
- 1: reset";
            sw = rw; hw = r;
            reset = 0x0;
        } vi_rst_req[2:2];
        field {
            name = "vi1_hcken";
            desc = "VI bus clock gating.
- 0: disabled
- 1: enabled";
            sw = rw; hw = r;
            reset = 0x0;
        } vi1_hcken[1:1];
        field {
            name = "vi_hrst_req";
            desc = "VI bus soft reset request.
- 0: deassert reset
- 1: reset";
            sw = rw; hw = r;
            reset = 0x0;
        } vi_hrst_req[0:0];
    } PERI_CRG11 @ 0x2c;
    reg {
        name = "PERI_CRG12";
        desc = "PERI_CRG12 is a sensor output clock configuration register. PERI_CRG12 (offset 0x0030, total reset 0x0000_0000; PROVEN: Hi3518E V100 data sheet, PDF page 165, section 3.2.5).";
        field {
            name = "reserved";
            desc = "Reserved";
            sw = rw; hw = r;
            reset = 0x0;
        } reserved_31_3[31:3];
        field {
            name = "sense_cksel";
            desc = "Sensor output clock.
- 000: 12 MHz
- 001: 24 MHz
- 010: 27 MHz
- 011: 54 MHz
- 100: 13.5 MHz
- 101: 27 MHz
- 110: 37.125 MHz
- 111: 74.25 MHz";
            sw = rw; hw = r;
            reset = 0x0;
        } sense_cksel[2:0];
    } PERI_CRG12 @ 0x30;
    reg {
        name = "PERI_CRG13";
        desc = "PERI_CRG13 is a VOU clock and reset control register. PERI_CRG13 (offset 0x0034, total reset 0x0000_0017; PROVEN: Hi3518E V100 data sheet, PDF page 166, section 3.2.5).";
        field {
            name = "reserved";
            desc = "Reserved.";
            sw = r; hw = w;
            reset = 0x0;
        } reserved_31_12[31:12];
        field {
            name = "hd_sd_sel";
            desc = "VOU mode.
- 0: SD
- 1: HD";
            sw = rw; hw = r;
            reset = 0x0;
        } hd_sd_sel[11:11];
        field {
            name = "vou_sd_cken";
            desc = "VOU SD DATE clock gating.
- 0: disabled
- 1: enabled";
            sw = rw; hw = r;
            reset = 0x0;
        } vou_sd_cken[10:10];
        field {
            name = "vou_hd_cken";
            desc = "VOU HD clock gating.
- 0: disabled
- 1: enabled";
            sw = rw; hw = r;
            reset = 0x0;
        } vou_hd_cken[9:9];
        field {
            name = "vou_hcken";
            desc = "VOU bus clock gating.
- 0: disabled
- 1: enabled";
            sw = rw; hw = r;
            reset = 0x0;
        } vou_hcken[8:8];
        field {
            name = "reserved";
            desc = "Reserved.";
            sw = rw; hw = r;
            reset = 0x0;
        } reserved_7_7[7:7];
        field {
            name = "ddac_pd_req";
            desc = "VOU SD DAC power-down configuration.
- 0: normal mode
- 1: power down";
            sw = rw; hw = r;
            reset = 0x0;
        } ddac_pd_req[6:6];
        field {
            name = "reserved";
            desc = "Reserved.";
            sw = rw; hw = r;
            reset = 0x0;
        } reserved_5_5[5:5];
        field {
            name = "vohd_out_pctrl";
            desc = "VOU HD output associated clock phase control.
- 0: normal phase clock
- 1: reverse phase clock";
            sw = rw; hw = r;
            reset = 0x1;
        } vohd_out_pctrl[4:4];
        field {
            name = "reserved";
            desc = "Reserved.";
            sw = r; hw = w;
            reset = 0x0;
        } reserved_3_3[3:3];
        field {
            name = "vo_sd_srst_req";
            desc = "VO SD soft reset request.
- 0: deassert reset
- 1: reset";
            sw = rw; hw = r;
            reset = 0x1;
        } vo_sd_srst_req[2:2];
        field {
            name = "vo_hd_srst_req";
            desc = "VO HD soft reset request.
- 0: deassert reset
- 1: reset";
            sw = rw; hw = r;
            reset = 0x1;
        } vo_hd_srst_req[1:1];
        field {
            name = "vo_hrst_req";
            desc = "VOU bus soft reset request.
- 0: deassert reset
- 1: reset";
            sw = rw; hw = r;
            reset = 0x1;
        } vo_hrst_req[0:0];
    } PERI_CRG13 @ 0x34;
    reg {
        name = "PERI_CRG14";
        desc = "PERI_CRG14 is a PWM clock and reset control register. PERI_CRG14 (offset 0x0038, total reset 0x0000_0000; PROVEN: Hi3518E V100 data sheet, PDF page 167, section 3.2.5).";
        field {
            name = "reserved";
            desc = "Reserved.";
            sw = r; hw = w;
            reset = 0x0;
        } reserved_31_2[31:2];
        field {
            name = "pwm_cken";
            desc = "PWM clock gating.
- 0: disabled
- 1: enabled";
            sw = rw; hw = r;
            reset = 0x0;
        } pwm_cken[1:1];
        field {
            name = "pwm_srst_req";
            desc = "PWM soft reset request.
- 0: deassert reset
- 1: reset";
            sw = rw; hw = r;
            reset = 0x0;
        } pwm_srst_req[0:0];
    } PERI_CRG14 @ 0x38;
    reg {
        name = "PERI_CRG16";
        desc = "PERI_CRG16 is a VEDU clock and soft reset control register. PERI_CRG16 (offset 0x0040, total reset 0x0000_0003; PROVEN: Hi3518E V100 data sheet, PDF page 168, section 3.2.5).";
        field {
            name = "reserved";
            desc = "Reserved.";
            sw = r; hw = w;
            reset = 0x0;
        } reserved_31_10[31:10];
        field {
            name = "veduclk_loaden";
            desc = "VEDU clock frequency division configuration enable.
- 0: disabled
- 1: enabled

To change the frequency division configuration, perform the following steps: 1 Write a new frequency division configuration value. 2 Write 0 to veduclk_loaden. 3 Write 1 to veduclk_loaden.";
            sw = rw; hw = r;
            reset = 0x0;
        } veduclk_loaden[9:9];
        field {
            name = "veduclk_skipcfg";
            desc = "VEDU clock frequency division configuration. N: N-beat clocks are disabled every 32-beat VEDU clocks.";
            sw = rw; hw = r;
            reset = 0x0;
        } veduclk_skipcfg[8:4];
        field {
            name = "reserved";
            desc = "Reserved.";
            sw = r; hw = w;
            reset = 0x0;
        } reserved_3_2[3:2];
        field {
            name = "vedu0_cken";
            desc = "VEDU clock gating.
- 0: disabled
- 1: enabled";
            sw = rw; hw = r;
            reset = 0x1;
        } vedu0_cken[1:1];
        field {
            name = "vedu_srst_req";
            desc = "VEDU soft reset request.
- 0: deassert reset
- 1: reset";
            sw = rw; hw = r;
            reset = 0x1;
        } vedu_srst_req[0:0];
    } PERI_CRG16 @ 0x40;
    reg {
        name = "PERI_CRG18";
        desc = "PERI_CRG18 is a VPSS clock and reset control register. PERI_CRG18 (offset 0x0048, total reset 0x0000_0003; PROVEN: Hi3518E V100 data sheet, PDF page 169, section 3.2.5).";
        field {
            name = "reserved";
            desc = "Reserved.";
            sw = r; hw = w;
            reset = 0x0;
        } reserved_31_10[31:10];
        field {
            name = "vpsclk_loaden";
            desc = "VPSS clock frequency division configuration enable.
- 0: disabled
- 1: enabled

To change the frequency division configuration, perform the following steps: 1 Write a new frequency division configuration value. 2 Write 0 to vpsclk_loaden. 3 Write 1 to vpsclk_loaden.";
            sw = rw; hw = r;
            reset = 0x0;
        } vpsclk_loaden[9:9];
        field {
            name = "vpsclk_skipcfg";
            desc = "VPSS clock frequency division configuration. N: N-beat clocks are disabled every 32-beat VPSS clocks.";
            sw = rw; hw = r;
            reset = 0x0;
        } vpsclk_skipcfg[8:4];
        field {
            name = "reserved";
            desc = "Reserved.";
            sw = r; hw = w;
            reset = 0x0;
        } reserved_3_2[3:2];
        field {
            name = "vps_cken";
            desc = "VPSS clock gating.
- 0: disabled
- 1: enabled";
            sw = rw; hw = r;
            reset = 0x1;
        } vps_cken[1:1];
        field {
            name = "vps_srst_req";
            desc = "VPSS soft reset request.
- 0: deassert reset
- 1: reset";
            sw = rw; hw = r;
            reset = 0x1;
        } vps_srst_req[0:0];
    } PERI_CRG18 @ 0x48;
    reg {
        name = "PERI_CRG22";
        desc = "PERI_CRG22 is a TDE clock and soft reset control register. PERI_CRG22 (offset 0x0058, total reset 0x0000_0003; PROVEN: Hi3518E V100 data sheet, PDF page 170, section 3.2.5).";
        field {
            name = "reserved";
            desc = "Reserved.";
            sw = r; hw = w;
            reset = 0x0;
        } reserved_31_10[31:10];
        field {
            name = "tdeclk_loaden";
            desc = "TDE clock frequency division configuration enable.
- 0: disabled
- 1: enabled

To change the frequency division configuration, perform the following steps: 1 Write a new frequency division configuration value. 2 Write 0 to tdeclk_loaden. 3 Write 1 to tdeclk_loaden.";
            sw = rw; hw = r;
            reset = 0x0;
        } tdeclk_loaden[9:9];
        field {
            name = "tdeclk_skipcfg";
            desc = "TDE clock frequency division configuration. N: N-beat clocks are disabled every 32-beat TDE clocks.";
            sw = rw; hw = r;
            reset = 0x0;
        } tdeclk_skipcfg[8:4];
        field {
            name = "reserved";
            desc = "Reserved.";
            sw = r; hw = w;
            reset = 0x0;
        } reserved_3_2[3:2];
        field {
            name = "tde_cken";
            desc = "TDE clock gating.
- 0: disabled
- 1: enabled";
            sw = rw; hw = r;
            reset = 0x1;
        } tde_cken[1:1];
        field {
            name = "tde_srst_req";
            desc = "TDE soft reset request.
- 0: deassert reset
- 1: reset";
            sw = rw; hw = r;
            reset = 0x1;
        } tde_srst_req[0:0];
    } PERI_CRG22 @ 0x58;
    reg {
        name = "PERI_CRG24";
        desc = "PERI_CRG24 is a JPGE clock and soft reset control register. PERI_CRG24 (offset 0x0060, total reset 0x0000_0003; PROVEN: Hi3518E V100 data sheet, PDF page 171, section 3.2.5).";
        field {
            name = "reserved";
            desc = "Reserved.";
            sw = r; hw = w;
            reset = 0x0;
        } reserved_31_10[31:10];
        field {
            name = "jpgeclk_loaden";
            desc = "JPGE clock frequency division configuration enable.
- 0: disabled
- 1: enabled

To change the frequency division configuration, perform the following steps: 1 Write a new frequency division configuration value. 2 Write 0 to jpgeclk_loaden. 3 Write 1 to jpgeclk_loaden.";
            sw = rw; hw = r;
            reset = 0x0;
        } jpgeclk_loaden[9:9];
        field {
            name = "jpgeclk_skipcfg";
            desc = "JPGE clock frequency division configuration. N: N-beat clocks are disabled every 32-beat TDE clocks.";
            sw = rw; hw = r;
            reset = 0x0;
        } jpgeclk_skipcfg[8:4];
        field {
            name = "reserved";
            desc = "Reserved.";
            sw = r; hw = w;
            reset = 0x0;
        } reserved_3_2[3:2];
        field {
            name = "jpge_cken";
            desc = "JPGE clock gating.
- 0: disabled
- 1: enabled";
            sw = rw; hw = r;
            reset = 0x1;
        } jpge_cken[1:1];
        field {
            name = "jpge_srst_req";
            desc = "JPGE soft reset request.
- 0: deassert reset
- 1: reset";
            sw = rw; hw = r;
            reset = 0x1;
        } jpge_srst_req[0:0];
    } PERI_CRG24 @ 0x60;
    reg {
        name = "PERI_CRG26";
        desc = "PERI_CRG26 is an MDU clock and soft reset control register. PERI_CRG26 (offset 0x0068, total reset 0x0000_0003; PROVEN: Hi3518E V100 data sheet, PDF page 172, section 3.2.5).";
        field {
            name = "reserved";
            desc = "Reserved.";
            sw = r; hw = w;
            reset = 0x0;
        } reserved_31_10[31:10];
        field {
            name = "mduclk_loaden";
            desc = "MDU clock frequency division configuration enable.
- 0: disabled
- 1: enabled

To change the frequency division configuration, perform the following steps: 1 Write a new frequency division configuration value. 2 Write 0 to mduclk_loaden. 3 Write 1 to mduclk_loaden.";
            sw = rw; hw = r;
            reset = 0x0;
        } mduclk_loaden[9:9];
        field {
            name = "mduclk_skipcfg";
            desc = "MDU clock frequency division configuration. N: N-beat clocks are disabled every 32-beat MDU clocks.";
            sw = rw; hw = r;
            reset = 0x0;
        } mduclk_skipcfg[8:4];
        field {
            name = "reserved";
            desc = "Reserved.";
            sw = r; hw = w;
            reset = 0x0;
        } reserved_3_2[3:2];
        field {
            name = "mdu_cken";
            desc = "MDU clock gating.
- 0: disabled
- 1: enabled";
            sw = rw; hw = r;
            reset = 0x1;
        } mdu_cken[1:1];
        field {
            name = "mdu_srst_req";
            desc = "MDU soft reset request.
- 0: deassert reset
- 1: reset";
            sw = rw; hw = r;
            reset = 0x1;
        } mdu_srst_req[0:0];
    } PERI_CRG26 @ 0x68;
    reg {
        name = "PERI_CRG27";
        desc = "PERI_CRG27 is a VAPU clock and soft reset control register. PERI_CRG27 (offset 0x006C, total reset 0x0000_0003; PROVEN: Hi3518E V100 data sheet, PDF page 173, section 3.2.5).";
        field {
            name = "reserved";
            desc = "Reserved.";
            sw = r; hw = w;
            reset = 0x0;
        } reserved_31_10[31:10];
        field {
            name = "vapuclk_loaden";
            desc = "VAPU clock frequency division configuration enable.
- 0: disabled
- 1: enabled

To change the frequency division configuration, perform the following steps: 1 Write a new frequency division configuration value. 2 Write 0 to vapuclk_loaden. 3 Write 1 to vapuclk_loaden.";
            sw = rw; hw = r;
            reset = 0x0;
        } vapuclk_loaden[9:9];
        field {
            name = "vapuclk_skipcfg";
            desc = "VAPU clock frequency division configuration. N: N-beat clocks are disabled every 32-beat VAPU clocks.";
            sw = rw; hw = r;
            reset = 0x0;
        } vapuclk_skipcfg[8:4];
        field {
            name = "reserved";
            desc = "Reserved.";
            sw = r; hw = w;
            reset = 0x0;
        } reserved_3_2[3:2];
        field {
            name = "vapu_cken";
            desc = "VAPU clock gating.
- 0: disabled
- 1: enabled";
            sw = rw; hw = r;
            reset = 0x1;
        } vapu_cken[1:1];
        field {
            name = "vapu_srst_req";
            desc = "VAPU soft reset request.
- 0: deassert reset
- 1: reset";
            sw = rw; hw = r;
            reset = 0x1;
        } vapu_srst_req[0:0];
    } PERI_CRG27 @ 0x6c;
    reg {
        name = "PERI_CRG31";
        desc = "PERI_CRG31 is a CIPHER clock and soft reset control register. PERI_CRG31 (offset 0x007C, total reset 0x0000_0000; PROVEN: Hi3518E V100 data sheet, PDF page 174, section 3.2.5).";
        field {
            name = "reserved";
            desc = "Reserved.";
            sw = r; hw = w;
            reset = 0x0;
        } reserved_31_2[31:2];
        field {
            name = "cipher_cken";
            desc = "CIPHER clock gating.
- 0: disabled
- 1: enabled";
            sw = rw; hw = r;
            reset = 0x0;
        } cipher_cken[1:1];
        field {
            name = "cipher_srst_req";
            desc = "CIPHER soft reset request.
- 0: deassert reset
- 1: reset";
            sw = rw; hw = r;
            reset = 0x0;
        } cipher_srst_req[0:0];
    } PERI_CRG31 @ 0x7c;
    reg {
        name = "PERI_CRG32";
        desc = "PERI_CRG32 is SAR ADC control register. PERI_CRG32 (offset 0x0080, total reset 0x0000_0000; PROVEN: Hi3518E V100 data sheet, PDF page 174, section 3.2.5).";
        field {
            name = "reserved";
            desc = "Reserved.";
            sw = r; hw = w;
            reset = 0x0;
        } reserved_31_2[31:2];
        field {
            name = "sar_adc_cken";
            desc = "SAR ADC clock gating.
- 0: disabled
- 1: enabled";
            sw = rw; hw = r;
            reset = 0x0;
        } sar_adc_cken[1:1];
        field {
            name = "sar_adc_srst_req";
            desc = "SAR ADC soft reset request.
- 0: deassert reset
- 1: reset";
            sw = rw; hw = r;
            reset = 0x0;
        } sar_adc_srst_req[0:0];
    } PERI_CRG32 @ 0x80;
    reg {
        name = "PERI_CRG34";
        desc = "PERI_CRG34 is SIO MCLK control register. PERI_CRG34 (offset 0x0088, total reset 0x0000_0000; PROVEN: Hi3518E V100 data sheet, PDF page 175, section 3.2.5).";
        field {
            name = "reserved";
            desc = "Reserved.";
            sw = r; hw = w;
            reset = 0x0;
        } reserved_31_24[31:24];
        field {
            name = "sio_ckcfg";
            desc = "Division clock of SIO MCLK. The configured value is calculated as follows: (MCLK/Frequency of the SIO clock source) x 2^27. The clock source frequency is 675 MHz, and the maximum value of the MCLK is 62.5 MHz.";
            sw = rw; hw = r;
            reset = 0x0;
        } sio_ckcfg[23:0];
    } PERI_CRG34 @ 0x88;
    reg {
        name = "PERI_CRG35";
        desc = "PERI_CRG35 is SIO clock and soft reset control register. PERI_CRG35 (offset 0x008C, total reset 0x0000_0004; PROVEN: Hi3518E V100 data sheet, PDF page 175, section 3.2.5).";
        field {
            name = "reserved";
            desc = "Reserved.";
            sw = r; hw = w;
            reset = 0x0;
        } reserved_31_16[31:16];
        field {
            name = "adac_srst_req";
            desc = "Audio Codec soft reset request.
- 0: deassert reset
- 1: reset";
            sw = rw; hw = r;
            reset = 0x0;
        } adac_srst_req[15:15];
        field {
            name = "sio_fsclk_div";
            desc = "Division relationship between the bit clock BCLK and sampling clock FS.
- 000: The FS is generated by dividing the BCLK by 16.
- 001: The FS is generated by dividing the BCLK by 32.
- 010: The FS is generated by dividing the BCLK by 48.
- 011: The FS is generated by dividing the BCLK by 64.
- 100: The FS is generated by dividing the BCLK by 128.
- 101: The FS is generated by dividing the BCLK by 256.

Other values: The FS is generated by dividing the BCLK by 8.";
            sw = rw; hw = r;
            reset = 0x0;
        } sio_fsclk_div[14:12];
        field {
            name = "sio_bclk_div";
            desc = "Division relationship between the main clock MCLK and bit clock BCLK.
- 0000: The BCLK is generated by dividing the MCLK by 1.
- 0001: The BCLK is generated by dividing the MCLK by 3.
- 0010: The BCLK is generated by dividing the MCLK by 2.
- 0011: The BCLK is generated by dividing the MCLK by 4.
- 0100: The BCLK is generated by dividing the MCLK by 6.
- 0101: The BCLK is generated by dividing the MCLK by 8.
- 0110: The BCLK is generated by dividing the MCLK by 12.
- 0111: The BCLK is generated by dividing the MCLK by 16.
- 1000: The BCLK is generated by dividing the MCLK by 24.
- 1001: The BCLK is generated by dividing the MCLK by 32.
- 1010: The BCLK is generated by dividing the MCLK by 48.
- 1011: The BCLK is generated by dividing the MCLK by 64.

Other values: The BCLK is generated by dividing the MCLK by 8.";
            sw = rw; hw = r;
            reset = 0x0;
        } sio_bclk_div[11:8];
        field {
            name = "sio_fs_rxtx_sel";
            desc = "Multiplexing relationship between the SIO TX FS and RX FS.
- 0: The RX FS is independent of the TX FS.
- 1: The TX FS multiplexes with the RX FS.";
            sw = rw; hw = r;
            reset = 0x0;
        } sio_fs_rxtx_sel[7:7];
        field {
            name = "sio_bclk_rxtx_sel";
            desc = "Multiplexing relationship between the SIO TX BCLK and RX BCLK.
- 0: The RX BCLK is independent of the TX BCLK.
- 1: The TX BCLK multiplexes with the RX BCLK.";
            sw = rw; hw = r;
            reset = 0x0;
        } sio_bclk_rxtx_sel[6:6];
        field {
            name = "reserved";
            desc = "Reserved.";
            sw = r; hw = w;
            reset = 0x0;
        } reserved_5_5[5:5];
        field {
            name = "sio_bclk_sel";
            desc = "SIO BCLK select.
- 0: external BCLK of the Hi3518E
- 1: internal BCLK of the Hi3518E";
            sw = rw; hw = r;
            reset = 0x0;
        } sio_bclk_sel[4:4];
        field {
            name = "sio_bclkout_pctrl";
            desc = "Polarity of SIO BCLK output.
- 0: normal phase
- 1: reverse phase";
            sw = rw; hw = r;
            reset = 0x0;
        } sio_bclkout_pctrl[3:3];
        field {
            name = "sio_bclk_pctrl";
            desc = "SIO BCLK polarity.
- 0: normal phase
- 1: reverse phase";
            sw = rw; hw = r;
            reset = 0x1;
        } sio_bclk_pctrl[2:2];
        field {
            name = "sio_cken";
            desc = "SIO clock gating.
- 0: disabled
- 1: enabled";
            sw = rw; hw = r;
            reset = 0x0;
        } sio_cken[1:1];
        field {
            name = "sio_srst_req";
            desc = "SIO soft reset request.
- 0: deassert reset
- 1: reset";
            sw = rw; hw = r;
            reset = 0x0;
        } sio_srst_req[0:0];
    } PERI_CRG35 @ 0x8c;
    reg {
        name = "PERI_CRG46";
        desc = "PERI_CRG46 is a USB clock and soft reset control register. PERI_CRG46 (offset 0x00B8, total reset 0x0000_00B7; PROVEN: Hi3518E V100 data sheet, PDF page 177, section 3.2.5).";
        field {
            name = "reserved";
            desc = "Reserved.";
            sw = r; hw = w;
            reset = 0x0;
        } reserved_31_8[31:8];
        field {
            name = "usb_cken";
            desc = "USB PHY reference clock gating.
- 0: disabled
- 1: enabled";
            sw = rw; hw = r;
            reset = 0x1;
        } usb_cken[7:7];
        field {
            name = "reserved";
            desc = "Reserved.";
            sw = rw; hw = r;
            reset = 0x0;
        } reserved_6_6[6:6];
        field {
            name = "usb_ctrl_utmi0_req";
            desc = "Soft reset request of USB controller port0.
- 0: deassert reset
- 1: reset";
            sw = rw; hw = r;
            reset = 0x1;
        } usb_ctrl_utmi0_req[5:5];
        field {
            name = "usb_ctrl_hub_req";
            desc = "Soft reset request of the USB controller hub.
- 0: deassert reset
- 1: reset";
            sw = rw; hw = r;
            reset = 0x1;
        } usb_ctrl_hub_req[4:4];
        field {
            name = "reserved";
            desc = "Reserved.";
            sw = rw; hw = r;
            reset = 0x0;
        } reserved_3_3[3:3];
        field {
            name = "usbphy_port0_treq";
            desc = "Soft reset request of USB PHY port0.
- 0: deassert reset
- 1: reset";
            sw = rw; hw = r;
            reset = 0x1;
        } usbphy_port0_treq[2:2];
        field {
            name = "usbphy_req";
            desc = "Soft reset request of the USB PHY.
- 0: deassert reset
- 1: reset";
            sw = rw; hw = r;
            reset = 0x1;
        } usbphy_req[1:1];
        field {
            name = "usb_ahb_srst_req";
            desc = "Soft reset request of the USB controller bus.
- 0: deassert reset
- 1: reset";
            sw = rw; hw = r;
            reset = 0x1;
        } usb_ahb_srst_req[0:0];
    } PERI_CRG46 @ 0xb8;
    reg {
        name = "PERI_CRG48";
        desc = "PERI_CRG48 is an SFC clock and soft reset control register. PERI_CRG48 (offset 0x00C0, total reset 0x0000_0002; PROVEN: Hi3518E V100 data sheet, PDF page 178, section 3.2.5).";
        field {
            name = "reserved";
            desc = "Reserved.";
            sw = r; hw = w;
            reset = 0x0;
        } reserved_31_3[31:3];
        field {
            name = "sfc_cksel";
            desc = "SFC2X clock source select. The 24 MHz clock is selected by default.
- 0: 24 MHz clock
- 1: 112.5 MHz clock";
            sw = rw; hw = r;
            reset = 0x0;
        } sfc_cksel[2:2];
        field {
            name = "sfc_cken";
            desc = "SFC clock gating.
- 0: disabled
- 1: enabled";
            sw = rw; hw = r;
            reset = 0x1;
        } sfc_cken[1:1];
        field {
            name = "sfc_srst_req";
            desc = "SFC soft reset request.
- 0: deassert reset
- 1: reset";
            sw = rw; hw = r;
            reset = 0x0;
        } sfc_srst_req[0:0];
    } PERI_CRG48 @ 0xc0;
    reg {
        name = "PERI_CRG49";
        desc = "PERI_CRG49 is an SDIO clock and soft reset control register. PERI_CRG49 (offset 0x00C4, total reset 0x0000_0002; PROVEN: Hi3518E V100 data sheet, PDF page 179, section 3.2.5).";
        field {
            name = "reserved";
            desc = "Reserved.";
            sw = rw; hw = r;
            reset = 0x0;
        } reserved_31_5[31:5];
        field {
            name = "sdioclk_pctrl";
            desc = "Polarity of the SDIO SAP clock.
- 0: normal phase
- 1: reverse phase";
            sw = rw; hw = r;
            reset = 0x0;
        } sdioclk_pctrl[4:4];
        field {
            name = "sdioclk_sel";
            desc = "SDIO working clock select.
- 00: 24 MHz
- 01: 50 MHz 1X: reserved";
            sw = rw; hw = r;
            reset = 0x0;
        } sdioclk_sel[3:2];
        field {
            name = "sdio_cken";
            desc = "SDIO clock gating.
- 0: disabled
- 1: enabled";
            sw = rw; hw = r;
            reset = 0x1;
        } sdio_cken[1:1];
        field {
            name = "sdio_srst_req";
            desc = "SDIO soft reset request.
- 0: deassert reset
- 1: reset";
            sw = rw; hw = r;
            reset = 0x0;
        } sdio_srst_req[0:0];
    } PERI_CRG49 @ 0xc4;
    reg {
        name = "PERI_CRG51";
        desc = "PERI_CRG51 is an ETH interface clock and soft reset control register. PERI_CRG51 (offset 0x00CC, total reset 0x0000_0002; PROVEN: Hi3518E V100 data sheet, PDF page 180, section 3.2.5).";
        field {
            name = "reserved";
            desc = "Reserved.";
            sw = r; hw = w;
            reset = 0x0;
        } reserved_31_8[31:8];
        field {
            name = "ethcore_cksel";
            desc = "ETH working clock select.
- 00: 54 MHz clock
- 01: 27 MHz clock

Others: 99 MHz clock";
            sw = rw; hw = r;
            reset = 0x0;
        } ethcore_cksel[7:6];
        field {
            name = "ethphy_cksel";
            desc = "EHTPHY output clock select.
- 00: 25 MHz clock
- 01: 24 MHz clock

Others: 27 MHz clock";
            sw = rw; hw = r;
            reset = 0x0;
        } ethphy_cksel[5:4];
        field {
            name = "mii_rmii_mode";
            desc = "ETH mode.
- 0: MII mode
- 1: RMII mode";
            sw = rw; hw = r;
            reset = 0x0;
        } mii_rmii_mode[3:3];
        field {
            name = "eth_rmiick_sel";
            desc = "ETH RMII clock source select.
- 0: internal CRG clock
- 1: PAD input clock";
            sw = rw; hw = r;
            reset = 0x0;
        } eth_rmiick_sel[2:2];
        field {
            name = "eth_cken";
            desc = "ETH clock gating.
- 0: disabled
- 1: enabled";
            sw = rw; hw = r;
            reset = 0x1;
        } eth_cken[1:1];
        field {
            name = "hrst_eth_s";
            desc = "ETH soft reset request.
- 0: deassert reset
- 1: reset";
            sw = rw; hw = r;
            reset = 0x0;
        } hrst_eth_s[0:0];
    } PERI_CRG51 @ 0xcc;
    reg {
        name = "PERI_CRG54";
        desc = "PERI_CRG54 is a DDRTEST clock and soft reset control register. PERI_CRG54 (offset 0x00D8, total reset 0x0000_0002; PROVEN: Hi3518E V100 data sheet, PDF page 181, section 3.2.5).";
        field {
            name = "reserved";
            desc = "Reserved.";
            sw = r; hw = w;
            reset = 0x0;
        } reserved_31_4[31:4];
        field {
            name = "ddrtest_cken";
            desc = "DDRTEST clock gating.
- 0: disabled
- 1: enabled";
            sw = rw; hw = r;
            reset = 0x0;
        } ddrtest_cken[3:3];
        field {
            name = "ddrtest_srst_req";
            desc = "DDRTEST soft reset request.
- 0: deassert reset
- 1: reset";
            sw = rw; hw = r;
            reset = 0x0;
        } ddrtest_srst_req[2:2];
        field {
            name = "reserved";
            desc = "Reserved.";
            sw = rw; hw = r;
            reset = 0x2;
        } reserved_1_0[1:0];
    } PERI_CRG54 @ 0xd8;
    reg {
        name = "PERI_CRG56";
        desc = "PERI_CRG56 is a DMA clock and soft reset control register. PERI_CRG56 (offset 0x00E0, total reset 0x0000_0008; PROVEN: Hi3518E V100 data sheet, PDF page 181, section 3.2.5).";
        field {
            name = "reserved";
            desc = "Reserved.";
            sw = r; hw = w;
            reset = 0x2;
        } reserved_31_2[31:2];
        field {
            name = "dma_cken";
            desc = "DMA clock gating.
- 0: disabled
- 1: enabled";
            sw = rw; hw = r;
            reset = 0x0;
        } dma_cken[1:1];
        field {
            name = "dma_srst_req";
            desc = "DMA soft reset request.
- 0: deassert reset
- 1: reset";
            sw = rw; hw = r;
            reset = 0x0;
        } dma_srst_req[0:0];
    } PERI_CRG56 @ 0xe0;
    reg {
        name = "PERI_CRG57";
        desc = "PERI_CRG57 is a soft reset control register for other CRG interface modules. PERI_CRG57 (offset 0x00E4, total reset 0x0003_F000; PROVEN: Hi3518E V100 data sheet, PDF page 182, section 3.2.5).";
        field {
            name = "reserved";
            desc = "Reserved.";
            sw = r; hw = w;
            reset = 0x0;
        } reserved_31_18[31:18];
        field {
            name = "urat2_cken";
            desc = "UART2 clock gating.
- 0: disabled
- 1: enabled";
            sw = rw; hw = r;
            reset = 0x1;
        } urat2_cken[17:17];
        field {
            name = "uart1_cken";
            desc = "UART1 clock gating.
- 0: disabled
- 1: enabled";
            sw = rw; hw = r;
            reset = 0x1;
        } uart1_cken[16:16];
        field {
            name = "uart0_cken";
            desc = "UART0 clock gating.
- 0: disabled
- 1: enabled";
            sw = rw; hw = r;
            reset = 0x1;
        } uart0_cken[15:15];
        field {
            name = "ssp1_cken";
            desc = "SSP1 clock gating.
- 0: disabled
- 1: enabled";
            sw = rw; hw = r;
            reset = 0x1;
        } ssp1_cken[14:14];
        field {
            name = "ssp0_cken";
            desc = "SSP0 clock gating.
- 0: disabled
- 1: enabled";
            sw = rw; hw = r;
            reset = 0x1;
        } ssp0_cken[13:13];
        field {
            name = "ir_cken";
            desc = "IR clock gating.
- 0: disabled
- 1: enabled";
            sw = rw; hw = r;
            reset = 0x1;
        } ir_cken[12:12];
        field {
            name = "reserved";
            desc = "Reserved.";
            sw = rw; hw = r;
            reset = 0x0;
        } reserved_11_10[11:10];
        field {
            name = "uart2_srst_req";
            desc = "UART2 soft reset request.
- 0: deassert reset
- 1: reset";
            sw = rw; hw = r;
            reset = 0x0;
        } uart2_srst_req[9:9];
        field {
            name = "uart1_srst_req";
            desc = "UART1 soft reset request.
- 0: deassert reset
- 1: reset";
            sw = rw; hw = r;
            reset = 0x0;
        } uart1_srst_req[8:8];
        field {
            name = "uart0_srst_req";
            desc = "UART0 soft reset request.
- 0: deassert reset
- 1: reset";
            sw = rw; hw = r;
            reset = 0x0;
        } uart0_srst_req[7:7];
        field {
            name = "ssp1_srst_req";
            desc = "SSP1 soft reset request.
- 0: deassert reset
- 1: reset";
            sw = rw; hw = r;
            reset = 0x0;
        } ssp1_srst_req[6:6];
        field {
            name = "ssp0_srst_req";
            desc = "SSP0 soft reset request.
- 0: deassert reset
- 1: reset";
            sw = rw; hw = r;
            reset = 0x0;
        } ssp0_srst_req[5:5];
        field {
            name = "ir_srst_req";
            desc = "IR soft reset request.
- 0: deassert reset
- 1: reset";
            sw = rw; hw = r;
            reset = 0x0;
        } ir_srst_req[4:4];
        field {
            name = "reserved";
            desc = "Reserved.";
            sw = rw; hw = r;
            reset = 0x0;
        } reserved_3_3[3:3];
        field {
            name = "t_cap_srst_req";
            desc = "t_cap soft reset request.
- 0: deassert reset
- 1: reset";
            sw = rw; hw = r;
            reset = 0x0;
        } t_cap_srst_req[2:2];
        field {
            name = "i2c_srst_req";
            desc = "I2C soft reset request.
- 0: deassert reset
- 1: reset";
            sw = rw; hw = r;
            reset = 0x0;
        } i2c_srst_req[1:1];
        field {
            name = "test_clk_en";
            desc = "Test clock enable.
- 0: All test clocks are disabled.
- 1: All test clocks are enabled.";
            sw = rw; hw = r;
            reset = 0x0;
        } test_clk_en[0:0];
    } PERI_CRG57 @ 0xe4;
    reg {
        name = "PERI_CRG58";
        desc = "PERI_CRG58 is a CRG status register. PERI_CRG58 (offset 0x00E8, total reset 0x0000_0000; PROVEN: Hi3518E V100 data sheet, PDF page 184, section 3.2.5).";
        field {
            name = "reserved";
            desc = "Reserved.";
            sw = r; hw = w;
            reset = 0x0;
        } reserved_31_4[31:4];
        field {
            name = "epll_lock";
            desc = "EPLL lock status.
- 0: unlocked
- 1: locked";
            sw = r; hw = w;
            reset = 0x0;
        } epll_lock[3:3];
        field {
            name = "bpll_lock";
            desc = "BPLL lock status.
- 0: unlocked
- 1: locked";
            sw = r; hw = w;
            reset = 0x0;
        } bpll_lock[2:2];
        field {
            name = "vpll0_lock";
            desc = "VPLL0 lock status.
- 0: unlocked
- 1: locked";
            sw = r; hw = w;
            reset = 0x0;
        } vpll0_lock[1:1];
        field {
            name = "apll_lock";
            desc = "APLL lock status.
- 0: unlocked
- 1: locked";
            sw = r; hw = w;
            reset = 0x0;
        } apll_lock[0:0];
    } PERI_CRG58 @ 0xe8;
    reg {
        name = "PERI_CRG61";
        desc = "PERI_CRG61 is a speed monitor control register. PERI_CRG61 (offset 0x00F4, total reset 0x0000_0000; PROVEN: Hi3518E V100 data sheet, PDF page 185, section 3.2.5).";
        field {
            name = "reserved";
            desc = "Reserved.";
            sw = r; hw = w;
            reset = 0x0;
        } reserved_31_3[31:3];
        field {
            name = "osc_en";
            desc = "Speed monitor enable.
- 0: disabled
- 1: enabled";
            sw = rw; hw = r;
            reset = 0x0;
        } osc_en[2:2];
        field {
            name = "osc_mode";
            desc = "Speed monitor mode.
- 0: 150-step level
- 1: 200-step level";
            sw = rw; hw = r;
            reset = 0x0;
        } osc_mode[1:1];
        field {
            name = "osc_clk_en";
            desc = "Speed monitor clock enable.
- 0: disabled
- 1: enabled";
            sw = rw; hw = r;
            reset = 0x0;
        } osc_clk_en[0:0];
    } PERI_CRG61 @ 0xf4;
    reg {
        name = "PERI_CRG62";
        desc = "PERI_CRG62 is speed monitor status register 1. PERI_CRG62 (offset 0x00F8, total reset 0x0000_0000; PROVEN: Hi3518E V100 data sheet, PDF page 185, section 3.2.5).";
        field {
            name = "reserved";
            desc = "Reserved.";
            sw = r; hw = w;
            reset = 0x0;
        } reserved_31_10[31:10];
        field {
            name = "osc_valid";
            desc = "Status of the SpeedMonitor.
- 0: invalid;
- 1: valid.";
            sw = r; hw = w;
            reset = 0x0;
        } osc_valid[9:9];
        field {
            name = "osc_value";
            desc = "Value of the SpeedMonitor.";
            sw = r; hw = w;
            reset = 0x0;
        } osc_value[8:0];
    } PERI_CRG62 @ 0xf8;
};

`endif
