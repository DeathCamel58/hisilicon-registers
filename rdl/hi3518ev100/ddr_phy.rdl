`ifndef EHI3518EV100_DDR_PHY_RDL
`define EHI3518EV100_DDR_PHY_RDL
regfile eHI3518EV100_DDR_PHY {
    name = "DDR PUB PHY";
    desc = "DDR PUB PHY. 33 registers extracted programmatically from the Hi3518E 720p IP Camera SoC data sheet (Issue 03, 2015-11-26); chapter 4.1.6, table 4-6. Field names, bit ranges, access types and reset values are taken from the register tables; reset values are the data sheet total reset values split onto the fields (per-field values where the table has them). Label: PROVEN. Hardware not verified here (no board).";
    reg {
        name = "DDRC_PUB_PIR";
        desc = "DDRC_PUB_PIR is a PHY initialization register. DDRC_PUB_PIR (offset 0x404, total reset 0x0000_0000; PROVEN: Hi3518E V100 data sheet, PDF page 396, section 4.1.6).";
        field {
            name = "initbyp";
            desc = "Initialization bypass. If this bit is set, all running initialization routines including PHY initialization, DRAM initialization, and PHY training are bypassed or stopped. Initialization may be manually triggered by using INIT and the other relevant bits of the PIR register. This bit is self-cleared.";
            sw = rw; hw = r;
            reset = 0x0;
        } initbyp[31:31];
        field {
            name = "zcalbyp";
            desc = "Impedance calibration bypass. If this bit is set, impedance calibration of all ZQ control blocks that are automatically triggered after reset are bypassed or stopped. Impedance calibration may be manually triggered by using INIT and ZCAL bits of the PIR register. This bit is self-cleared.";
            sw = rw; hw = r;
            reset = 0x0;
        } zcalbyp[30:30];
        field {
            name = "lockbyp";
            desc = "DLL lock bypass. If this bit is set, the waiting of DLLs to lock is bypassed or stopped. DLL lock wait is automatically triggered after reset. DLL lock wait may be manually triggered by using INIT and DLLLOCK bits of the PIR register. This bit is self-cleared.";
            sw = rw; hw = r;
            reset = 0x0;
        } lockbyp[29:29];
        field {
            name = "clrsr";
            desc = "Status clear. A write of '1' to this bit will clear (reset to '0') all status registers, including PGSR and DXnGSR. The clear status register bit is self-cleared. This bit is primarily for debugging and is typically not needed during normal functional operation. When PGSR.IDONE is 1, it can be used to manually clear the PGSR status bits, although starting a new initialization process will automatically clear the PGSR status bits. It can also be used to manually clear the DXnGSR status bits, although starting a new data training process will automatically clear the DXnGSR status bits.";
            sw = rw; hw = r;
            reset = 0x0;
        } clrsr[28:28];
        field {
            name = "reserved";
            desc = "reserved";
            sw = rw; hw = r;
            reset = 0x0;
        } reserved_27_19[27:19];
        field {
            name = "ctldinit";
            desc = "Controller DRAM initialization. If this bit is set, this DRAM initialization will be performed by the controller. If this bit is not set, this DRAM initialization will be performed by using the built-in initialization sequence or by using software over the configuration port.";
            sw = rw; hw = r;
            reset = 0x0;
        } ctldinit[18:18];
        field {
            name = "dllbyp";
            desc = "DLL bypass. If this bit is set to 1, all PHY DLLs enter the bypass mode. A bypassed DLL is also powered down (disabled).";
            sw = rw; hw = r;
            reset = 0x0;
        } dllbyp[17:17];
        field {
            name = "icpc";
            desc = "Initialization complete pin configuration.
- 0: This bit is asserted after PHY initialization (DLL locking and impedance calibration) is complete.
- 1: This bit is asserted after PHY initialization and the triggered

PUB initialization (DRAM initialization, data training, or initialization trigger with no selected initialization) are complete.";
            sw = rw; hw = r;
            reset = 0x0;
        } icpc[16:16];
        field {
            name = "reserved";
            desc = "Reserved.";
            sw = rw; hw = r;
            reset = 0x0;
        } reserved_15_9[15:9];
        field {
            name = "eyetrn";
            desc = "Execute read data eye training by PUB.
- 0: disabled
- 1: enabled

This function is not support by this version.";
            sw = rw; hw = r;
            reset = 0x0;
        } eyetrn[8:8];
        field {
            name = "qstrn";
            desc = "Execute read DQS training by PUB.
- 0: disabled
- 1: enabled";
            sw = rw; hw = r;
            reset = 0x0;
        } qstrn[7:7];
        field {
            name = "draminit";
            desc = "DRAM initialization for executing the DRAM initialization sequence.
- 0: disabled
- 1: enabled";
            sw = rw; hw = r;
            reset = 0x0;
        } draminit[6:6];
        field {
            name = "reserved";
            desc = "Reserved";
            sw = rw; hw = r;
            reset = 0x0;
        } reserved_5_5[5:5];
        field {
            name = "itmsrst";
            desc = "ITM soft reset.
- 0: disabled
- 1: enabled";
            sw = rw; hw = r;
            reset = 0x0;
        } itmsrst[4:4];
        field {
            name = "zcal";
            desc = "PHY impedance calibration.
- 0: disabled
- 1: enabled";
            sw = rw; hw = r;
            reset = 0x0;
        } zcal[3:3];
        field {
            name = "dlllock";
            desc = "DLL lock for waiting for the PHY DLLs to lock.
- 0: disabled
- 1: enabled";
            sw = rw; hw = r;
            reset = 0x0;
        } dlllock[2:2];
        field {
            name = "dllsrst";
            desc = "DLL soft reset. All PHY DLLs are soft-reset by driving the DLL soft reset pin.
- 0: disabled
- 1: enabled";
            sw = rw; hw = r;
            reset = 0x0;
        } dllsrst[1:1];
        field {
            name = "init";
            desc = "Initialization trigger (self-cleared).
- 0: No operation is performed.
- 1: The DDR system initialization is triggered.";
            sw = rw; hw = r;
            reset = 0x0;
        } init[0:0];
    } DDRC_PUB_PIR @ 0x404;
    reg {
        name = "DDRC_PUB_PGCR";
        desc = "DDRC_PUB_PGCR is a PHY general configuration register. DDRC_PUB_PGCR (offset 0x408, total reset 0x0184_2E04; PROVEN: Hi3518E V100 data sheet, PDF page 399, section 4.1.6).";
        field {
            name = "lbmode";
            desc = "Loopback mode. If this bit is set, the PHY/PUB is in loopback mode.";
            sw = rw; hw = r;
            reset = 0x0;
        } lbmode[31:31];
        field {
            name = "lbgdqs";
            desc = "Loopback DQS gating. This bit is used to select the DQS gating mode (including BIST loopback mode) that should be used when the PHY is in loopback mode.
- 0: DQS gate training will be triggered on the PUB.
- 1: DQS gate is manually set by using software.";
            sw = rw; hw = r;
            reset = 0x0;
        } lbgdqs[30:30];
        field {
            name = "lbdqss";
            desc = "Loopback DQS shift. This bit is used to select how the read DQS is shifted during loopback to ensure that the read DQS is centered into the read data eye.
- 0: PUB sets the read DQS delay to 0, and the DQS is already shifted 90º by a write path.
- 1: The read DQS shift is manually set by using software.";
            sw = rw; hw = r;
            reset = 0x0;
        } lbdqss[29:29];
        field {
            name = "rfshdt";
            desc = "Refresh during training. A non-zero value specifies that a burst of refreshes equal to the number specified in this field should be sent to the SDRAM after training of each rank except the last rank.";
            sw = rw; hw = r;
            reset = 0x0;
        } rfshdt[28:25];
        field {
            name = "pddisdx";
            desc = "Power down disabled byte. If this bit is set, the DLL and I/Os of a disabled byte should be powered down.";
            sw = rw; hw = r;
            reset = 0x1;
        } pddisdx[24:24];
        field {
            name = "zcksel";
            desc = "Impedance clock divider select. This bit is used to select the divide ratio for the clock used by the impedance control logic relative to the clock used by the memory controller and SDRAM.
- 00: divide by 2
- 01: divide by 8
- 10: divide by 32
- 11: divide by 64";
            sw = rw; hw = r;
            reset = 0x2;
        } zcksel[23:22];
        field {
            name = "ranken";
            desc = "Rank enable. This field specifies the ranks that are enabled for data training. Bit 0 controls rank 0, bit 1 controls rank 1, bit 2 controls rank 2, and bit 3 controls rank 3. Setting a bit to 1 enables the corresponding rank, and setting a bit to 0 disables the corresponding rank. Note: The actual reset value is calculated based on the configured number of ranks. The Hi3518E supports only one rank.";
            sw = rw; hw = r;
            reset = 0x1;
        } ranken[21:18];
        field {
            name = "ioddrm";
            desc = "I/O DDR mode (D3F I/O only). This field is used to select the DDR mode for the I/Os.";
            sw = rw; hw = r;
            reset = 0x0;
        } ioddrm[17:16];
        field {
            name = "iolb";
            desc = "I/O loopback select. This bit is used to select where the signal loopback occurs inside the I/O.
- 0: Loopback is after output buffer, and output enable must be asserted
- 1: Loopback is before output buffer, and output enable is ignored.";
            sw = rw; hw = r;
            reset = 0x0;
        } iolb[15:15];
        field {
            name = "ckinv";
            desc = "CK invert. If this bit is set, CK/CK# must be inverted. Otherwise, CK/CK# toggles with normal polarity.";
            sw = rw; hw = r;
            reset = 0x0;
        } ckinv[14:14];
        field {
            name = "ckdv";
            desc = "CK disable value. The static value that must be driven on CK/CK# pair(s) when the pair(s) is disabled. CKDV[0] specifies the value for CK and CKDV[1] specifies the value for CK#.";
            sw = rw; hw = r;
            reset = 0x2;
        } ckdv[13:12];
        field {
            name = "cken";
            desc = "CK enable. This field controls whether the CK going to the SDRAM is enabled (toggling) or disabled (static value defined by CKDV). One bit corresponds to each of the three CK pairs.";
            sw = rw; hw = r;
            reset = 0x7;
        } cken[11:9];
        field {
            name = "dtosel";
            desc = "DLL test signal output select.
- 0000: test signal of DX DLL0
- 0001: test signal of DX DLL1
- 0010: test signal of DX DLL2
- 0011: test signal of DX DLL3
- 1001: test signal of the AC DLL
- 1111: test signal of DDR PHYB

Other values: reserved";
            sw = rw; hw = r;
            reset = 0x0;
        } dtosel[8:5];
        field {
            name = "dftlmt";
            desc = "DQS drift limit. This field specifies the expected limit of drift on read data strobes. A drift of this value or greater is reported as a drift error through the host port error flag.
- 00: no limit (no error is reported)
- 01: 90° drift
- 10: 180° drift
- 11: 270° or more drift

Note: Although a value is reported through the error flag, this is not an error and no action is required. It only indicates that the drift is greater than expected value.";
            sw = rw; hw = r;
            reset = 0x0;
        } dftlmt[4:3];
        field {
            name = "dftcmp";
            desc = "DQS drift compensation enable.
- 0: disabled
- 1: enabled

Drift compensation is enabled by default. Note: Drift compensation must be disabled for LPDDR2.";
            sw = rw; hw = r;
            reset = 0x1;
        } dftcmp[2:2];
        field {
            name = "dqscfg";
            desc = "DQS gating configuration. This bit is used to select one of the two DQS gating schemes.
- 0: DQS gating is shut off by using the rising edge of DQS_b (active window mode)
- 1: DQS gating blankets the whole burst (passive window mode).

Note: Passive window must be used for LPDDR2.";
            sw = rw; hw = r;
            reset = 0x0;
        } dqscfg[1:1];
        field {
            name = "itmdmd";
            desc = "ITM DDR mode. This bit is used to select whether ITMS uses DQS and DQS# or it only uses DQS.
- 0: ITMS uses DQS and DQS#.
- 1: ITMS uses only DQS.

Note: The valid value for DDR is 1.";
            sw = rw; hw = r;
            reset = 0x0;
        } itmdmd[0:0];
    } DDRC_PUB_PGCR @ 0x408;
    reg {
        name = "DDRC_PUB_PGSR";
        desc = "DDRC_PUB_PGSR is a PHY general status register. DDRC_PUB_PGSR (offset 0x40C, total reset 0x0000_0000; PROVEN: Hi3518E V100 data sheet, PDF page 401, section 4.1.6).";
        field {
            name = "tq";
            desc = "Temperature output (only for LPDDR). This bit is connected to the DRAM TQ pin that is defined to high when the LPDDR device temperature is greater than or equal to 85ºC. Otherwise, this bit is low.";
            sw = r; hw = w;
            reset = 0x0;
        } tq[31:31];
        field {
            name = "reserved";
            desc = "Reserved.";
            sw = r; hw = w;
            reset = 0x0;
        } reserved_30_8[30:8];
        field {
            name = "dfterr";
            desc = "DQS drift error. If this bit is set, at least one of the read data strobes has drifted by more than or equal to the drift limit configured in the PHY general configuration register (PGCR).";
            sw = r; hw = w;
            reset = 0x0;
        } dfterr[7:7];
        field {
            name = "dtierr";
            desc = "Data training intermittent error. If this bit is set, there is an intermittent error during data training. For example, a pass is followed by a failure and then another pass.";
            sw = r; hw = w;
            reset = 0x0;
        } dtierr[6:6];
        field {
            name = "dterr";
            desc = "Data training error. If this bit is set, a valid DQS gating window cannot be found during data training.";
            sw = r; hw = w;
            reset = 0x0;
        } dterr[5:5];
        field {
            name = "dtdone";
            desc = "Data training done. If this bit is set, the PHY has finished data training.";
            sw = r; hw = w;
            reset = 0x0;
        } dtdone[4:4];
        field {
            name = "didone";
            desc = "DRAM initialization done. If this bit is set, DRAM initialization is complete.";
            sw = r; hw = w;
            reset = 0x0;
        } didone[3:3];
        field {
            name = "zcdone";
            desc = "Impedance calibration done. If this bit is set, impedance calibration is complete.";
            sw = r; hw = w;
            reset = 0x0;
        } zcdone[2:2];
        field {
            name = "dldone";
            desc = "DLL lock done. If this bit is set, DLL locking is complete.";
            sw = r; hw = w;
            reset = 0x0;
        } dldone[1:1];
        field {
            name = "idone";
            desc = "Initialization done. If this bit is set, DDR system initialization is complete. This bit is set after all the selected initialization routines in PIR register are complete.";
            sw = r; hw = w;
            reset = 0x0;
        } idone[0:0];
    } DDRC_PUB_PGSR @ 0x40c;
    reg {
        name = "DDRC_PUB_DLLGCR";
        desc = "DDRC_PUB_DLLGCR is a DLL general control register. DDRC_PUB_DLLGCR (offset 0x410, total reset 0x0373_7000; PROVEN: Hi3518E V100 data sheet, PDF page 403, section 4.1.6).";
        field {
            name = "dllrsvd2";
            desc = "DLL reserved control. This bit is connected to the DLL control bus and is reserved for future use.";
            sw = rw; hw = r;
            reset = 0x0;
        } dllrsvd2[31:30];
        field {
            name = "lockdet";
            desc = "Master lock detector enable. Note: This field is only valid for a few processes and is reserved for other processes.";
            sw = rw; hw = r;
            reset = 0x0;
        } lockdet[29:29];
        field {
            name = "dllrsvd1";
            desc = "DLL reserved control. This bit is connected to the DLL control bus and is reserved for future use.";
            sw = rw; hw = r;
            reset = 0x0;
        } dllrsvd1[28:28];
        field {
            name = "sbias";
            desc = "Slave bias trim. This field is used to trim the bias for the slave DLL. Note: If DWC_DDR3PHY_DLL_TYPEA Verilog macro is defined, the default value for this field is 0x00.";
            sw = rw; hw = r;
            reset = 0x37;
        } sbias[27:20];
        field {
            name = "mbias";
            desc = "Master bias trim. This field is used to trim the bias for the master DLL. Note: If DWC_DDR3PHY_DLL_TYPEA Verilog macro is defined, the default value for this field is 0x00.";
            sw = rw; hw = r;
            reset = 0x37;
        } mbias[19:12];
        field {
            name = "testsw";
            desc = "Test switch. This bit is used to select the test signals of either the master DLL ('0') or the slave DLL ('1').";
            sw = rw; hw = r;
            reset = 0x0;
        } testsw[11:11];
        field {
            name = "atc";
            desc = "Analog test control. This field is used to select the analog signal to be output on the DLL analog test output (test_out_a) when TESTEN is high (output is Vss when TESTEN is low). The test output either comes from the master DLL or the slave DLL, depending on the setting of the test switch (TESTSW). Both master DLL and slave DLL outputs are similar to analog test signals.
- 00: filter output (Vc)
- 01: replica bias output for NMOS (Vbn)
- 10: replica bias output for PMOS (Vbp)
- 11: Vdd 00";
            sw = rw; hw = r;
            reset = 0x0;
        } atc[10:9];
        field {
            name = "dtc";
            desc = "Digital test control. This field is used to select the digital signal to be output on the DLL digital test output (test_out_d[1]) when TESTEN is high (output is '0' when TESTEN is low). The following are valid settings for the master DLL (such as when TESTSW is '0'):
- 000: 0º output clock (clk_0)
- 001: 90º output clock (clk_90)
- 010: 180º output clock (clk_180)
- 011: 270º output clock (clk_270)
- 100: 360º internal clock (clk_360_int)
- 101: speed-up pulse (spdup)
- 110: slow-down pulse (slwdn)
- 111: 0º MCTL logic clock (cclk_0)

The following are valid settings for the slave DLL (such as when TESTSW is '1'):
- 000: input DQS strobe (dqs)
- 001: input clock reference (clk_90_in)
- 010: internal feedback clock (clk_0_out)
- 011: 90º output DQS_b strobe (dqsb_90)
- 100: 90º output DQS strobe (dqs_90)
- 101: speed-up pulse (spdup)
- 110: slow-down pulse (slwdn)
- 111: auto-lock enable signal";
            sw = rw; hw = r;
            reset = 0x0;
        } dtc[8:6];
        field {
            name = "testen";
            desc = "Test enable. This bit is used to enable digital and analog test outputs selected by the DTC and ATC respectively.";
            sw = rw; hw = r;
            reset = 0x0;
        } testen[5:5];
        field {
            name = "ipump";
            desc = "Charge pump current trim This field is used to trim charge pump current.
- 000: maximum current
- 111: minimum current";
            sw = rw; hw = r;
            reset = 0x0;
        } ipump[4:2];
        field {
            name = "dres";
            desc = "Delta resistor trim. This field is used to trim reference current versus resistor value variation:
- 00: Rnom
- 01: Rnom − 20% 1x: Rnom + 20%

Note: This field is reserved for a few processes and is not used by the DLL.";
            sw = rw; hw = r;
            reset = 0x0;
        } dres[1:0];
    } DDRC_PUB_DLLGCR @ 0x410;
    reg {
        name = "DDRC_PUB_ACDLLCR";
        desc = "DDRC_PUB_ACDLLCR is an AC DLL control register. DDRC_PUB_ACDLLCR (offset 0x414, total reset 0x4000_0000; PROVEN: Hi3518E V100 data sheet, PDF page 405, section 4.1.6).";
        field {
            name = "dlldis";
            desc = "DLL disable. A disabled DLL is bypassed. The default value 0 indicates that the DLL is enabled.";
            sw = rw; hw = r;
            reset = 0x0;
        } dlldis[31:31];
        field {
            name = "dllsrst";
            desc = "DLL soft reset. The AC DLL is soft-reset by driving the DLL soft reset pin.";
            sw = rw; hw = r;
            reset = 0x1;
        } dllsrst[30:30];
        field {
            name = "reserved";
            desc = "Reserved.";
            sw = rw; hw = r;
            reset = 0x0;
        } reserved_29_20[29:20];
        field {
            name = "sdlbmode";
            desc = "Slave DLL loopback mode. If this bit is set, the slave DLL is put in loopback mode in which there is no 90º phase shift on read DQS/DQS#. This bit must be set when the byte PHYs are operated in loopback mode such as during BIST loopback.";
            sw = rw; hw = r;
            reset = 0x0;
        } sdlbmode[19:19];
        field {
            name = "atesten";
            desc = "Analog test enable. This bit is used to enable the analog test signal to be output on the DLL analog test output (test_out_a). The DLL analog test output is tristated when this bit is 0.";
            sw = rw; hw = r;
            reset = 0x0;
        } atesten[18:18];
        field {
            name = "sdphase";
            desc = "Slave DLL phase trim. This field is used to select the phase difference between the input clock and the corresponding output clock of the slave DLL.
- 0000: 90
- 0001: 72
- 0010: 54
- 0011: 36
- 0100: 108
- 0101: 90
- 0110: 72
- 0111: 54
- 1000: 126
- 1001: 108
- 1010: 90
- 1011: 72
- 1100: 144
- 1101: 126
- 1110: 108
- 1111: 90";
            sw = rw; hw = r;
            reset = 0x0;
        } sdphase[17:14];
        field {
            name = "sstart";
            desc = "Slave auto startup. This field is used to control how the slave DLL starts up relative to the master DLL locking. 0X: Slave DLL automatically starts up once the master DLL is locked.
- 10: The automatic startup of the slave DLL is disabled, and the phase detector is disabled.
- 11: The automatic startup of the slave DLL is disabled, and the phase detector is enabled.";
            sw = rw; hw = r;
            reset = 0x0;
        } sstart[13:12];
        field {
            name = "mfwdly";
            desc = "Master feed-forward delay trim. This field is used to trim the delay in the master DLL feed-forward path.
- 000: minimum delay
- 111: maximum delay";
            sw = rw; hw = r;
            reset = 0x0;
        } mfwdly[11:9];
        field {
            name = "mfbdly";
            desc = "Master feedback delay trim. This field is used to trim the delay in the master DLL feedback path.
- 000: minimum delay
- 111: maximum delay";
            sw = rw; hw = r;
            reset = 0x0;
        } mfbdly[8:6];
        field {
            name = "sfwdly";
            desc = "Slave feed-forward delay trim. This field is used to trim the delay in the slave DLL feed-forward path.
- 000: minimum delay
- 111: maximum delay";
            sw = rw; hw = r;
            reset = 0x0;
        } sfwdly[5:3];
        field {
            name = "sfbdly";
            desc = "Slave feedback delay trim. This field is used to trim the delay in the slave DLL feedback path.
- 000: minimum delay
- 111: maximum delay";
            sw = rw; hw = r;
            reset = 0x0;
        } sfbdly[2:0];
    } DDRC_PUB_ACDLLCR @ 0x414;
    reg {
        name = "DDRC_PUB_PTR0";
        desc = "DDRC_PUB_PTR0 is PHY timing register 0. DDRC_PUB_PTR0 (offset 0x418, total reset 0x0022_AF9B; PROVEN: Hi3518E V100 data sheet, PDF page 407, section 4.1.6).";
        field {
            name = "reserved";
            desc = "Reserved";
            sw = rw; hw = r;
            reset = 0x0;
        } reserved_31_22[31:22];
        field {
            name = "titmsrst";
            desc = "ITM soft reset time. This field defines the number of controller clock cycles during which the ITM soft reset pin must remain asserted when soft reset is performed on ITMs. The number must correspond to a value that is greater than or equal to eight controller clock cycles. The default value corresponds to eight controller clock cycles.";
            sw = rw; hw = r;
            reset = 0x8;
        } titmsrst[21:18];
        field {
            name = "tdlllock";
            desc = "DLL lock time. The field defines the number of clock cycles for the DLL to stabilize and lock the number of clock cycles from when the DLL reset pin is deasserted to when the DLL has locked and is ready for use. For details, see the PHY data book for the DLL lock time. The default value corresponds to 5.12 μs at 533 MHz.";
            sw = rw; hw = r;
            reset = 0xabe;
        } tdlllock[17:6];
        field {
            name = "tdllsrst";
            desc = "DLL soft reset time. The field defines the number of controller clock cycles during which the DLL soft reset pin must remain asserted when the soft reset is triggered through the PHY initialization register (PIR). The number must correspond to a value that is greater than or equal to 50 ns or eight controller clock cycles, whichever is greater. The default value corresponds to 50 ns at 533 MHz.";
            sw = rw; hw = r;
            reset = 0x1b;
        } tdllsrst[5:0];
    } DDRC_PUB_PTR0 @ 0x418;
    reg {
        name = "DDRC_PUB_PTR1";
        desc = "DDRC_PUB_PTR1 is PHY timing register 1. DDRC_PUB_PTR1 (offset 0x41C, total reset 0x0604_111D; PROVEN: Hi3518E V100 data sheet, PDF page 408, section 4.1.6).";
        field {
            name = "reserved";
            desc = "Reserved";
            sw = rw; hw = r;
            reset = 0x0;
        } reserved_31_27[31:27];
        field {
            name = "tdinit1";
            desc = "DRAM initialization time 1. The DRAM initialization time corresponds to the following: DDR2: CKE high time to first command (400 ns) DDR: CKE high time to first command (400 ns or 1 tCK) LPDDR2: CKE low time with power and clock stable (100 ns) The default value corresponds to DDR3 360 ns at 533MHz.";
            sw = rw; hw = r;
            reset = 0xc0;
        } tdinit1[26:19];
        field {
            name = "tdinit0";
            desc = "DRAM initialization time 0. The DRAM initialization time corresponds to the following: DDR3: CKE low time with power and clock stable (500 μs) DDR2: CKE low time with power and clock stable (200 μs) DDR: CKE low time with power and clock stable (200 μs) LPDDR: CKE high time to first command (200 μs) LPDDR2: CKE high time to first command (200 μs) The default value corresponds to DDR3 500 μs at 533MHz.";
            sw = rw; hw = r;
            reset = 0x4111d;
        } tdinit0[18:0];
    } DDRC_PUB_PTR1 @ 0x41c;
    reg {
        name = "DDRC_PUB_PTR2";
        desc = "DDRC_PUB_PTR2 is PHY timing register 2. DDRC_PUB_PTR2 (offset 0x420, total reset 0x042D_A072; PROVEN: Hi3518E V100 data sheet, PDF page 408, section 4.1.6).";
        field {
            name = "reserved";
            desc = "Reserved";
            sw = rw; hw = r;
            reset = 0x0;
        } reserved_31_27[31:27];
        field {
            name = "tdinit3";
            desc = "DRAM initialization time 3. The DRAM initialization time corresponds to the following:";
            sw = rw; hw = r;
            reset = 0x216;
        } tdinit3[26:17];
        field {
            name = "tdinit2";
            desc = "DRAM initialization time 2. The DRAM initialization time corresponds to the following: LPDDR2: time from reset command to end of auto initialization (1 μs + 10 μs = 11 μs) The default value is 200 μs.";
            sw = rw; hw = r;
            reset = 0x1a072;
        } tdinit2[16:0];
    } DDRC_PUB_PTR2 @ 0x420;
    reg {
        name = "DDRC_PUB_ACIOCR";
        desc = "DDRC_PUB_ACIOCR is an AC I/O configuration register. DDRC_PUB_ACIOCR (offset 0x424, total reset 0x3040_0812; PROVEN: Hi3518E V100 data sheet, PDF page 409, section 4.1.6).";
        field {
            name = "acsr";
            desc = "Address/Command slew rate. Note: The Hi3518E does not support the configuration.";
            sw = r; hw = w;
            reset = 0x0;
        } acsr[31:30];
        field {
            name = "rstiom";
            desc = "SDRAM reset I/O mode. This bit is used to select SSTL mode (when set to 0) or CMOS mode (when set to 1) of the I/O for SDRAM reset.";
            sw = rw; hw = r;
            reset = 0x1;
        } rstiom[29:29];
        field {
            name = "rstpdr";
            desc = "SDRAM reset power down receiver. If this bit is set, the input receiver on the I/O is powered down for the SDRAM RST# pin.";
            sw = rw; hw = r;
            reset = 0x1;
        } rstpdr[28:28];
        field {
            name = "rstpdd";
            desc = "SDRAM reset power down driver. If this bit is set, the output driver on the I/O is powered down for the SDRAM RST# pin.";
            sw = rw; hw = r;
            reset = 0x0;
        } rstpdd[27:27];
        field {
            name = "rstodt";
            desc = "SDRAM reset on-die termination. If this bit is set, the on-die termination on the I/O is enabled for the SDRAM RST# pin.";
            sw = rw; hw = r;
            reset = 0x0;
        } rstodt[26:26];
        field {
            name = "rankpdr";
            desc = "Rank power down receiver. If this field is set, the input receiver on the I/O is powered down for CKE[3:0], ODT[3:0], and CS#[3:0] pins. RANKPDR[0] controls the power down for CKE[0], ODT[0], and CS#[0]; RANKPDR[1] controls the power down for CKE[1], ODT[1], and CS#[1], and so on. Note: The actual reset value is calculated based on the configured number of ranks. For the Hi3518E, each PUB supports one rank.";
            sw = rw; hw = r;
            reset = 0x1;
        } rankpdr[25:22];
        field {
            name = "cspdd";
            desc = "CS# power down driver. If this field is set, the output driver on the I/O is powered down for CS#[3:0] pins. PDD[0] controls the power down for CS#[0], PDD[1] controls the power down for CS#[1], and so on. The power down for the CKE and ODT drivers is controlled by the DSGCR register. Note: The actual reset value is calculated based on the configured number of ranks. For the Hi3518E, each PUB supports one rank.";
            sw = rw; hw = r;
            reset = 0x0;
        } cspdd[21:18];
        field {
            name = "rankodt";
            desc = "Rank on-die termination. If this field is set, the on-die termination on the I/O is enabled for CKE[3:0], ODT[3:0], and CS#[3:0] pins. RANKODT[0] controls the on-die termination for CKE[0], ODT[0], and CS#[0]; RANKODT[1] controls the on-die termination for CKE[1], ODT[1], and CS#[1], and so on. Note: The actual reset value is calculated based on the configured number of ranks. For the Hi3518E, each PUB supports one rank.";
            sw = rw; hw = r;
            reset = 0x0;
        } rankodt[17:14];
        field {
            name = "ckpdr";
            desc = "CK power down receiver. If this field is set, the input receiver on the I/O is powered down for CK[0], CK[1], and CK[2] pins respectively. Note: The actual reset value is calculated based on the configured number of DDRCKs. For the Hi3518E, each PUB supports one DDRCK.";
            sw = rw; hw = r;
            reset = 0x1;
        } ckpdr[13:11];
        field {
            name = "ckpdd";
            desc = "CK power down driver. If this field is set, the output driver on the I/O is powered down for CK[0], CK[1], and CK[2] pins respectively. Note: The actual reset value is calculated based on the configured number of DDRCKs. For the Hi3518E, each PUB supports one DDRCK.";
            sw = rw; hw = r;
            reset = 0x0;
        } ckpdd[10:8];
        field {
            name = "ckodt";
            desc = "CK on-die termination. If this field is set, the on-die termination on the I/O is enabled for CK[0], CK[1], and CK[2] pins respectively. Note: The actual reset value is calculated based on the configured number of DDRCKs. For the Hi3518E, each PUB supports one DDRCK.";
            sw = rw; hw = r;
            reset = 0x0;
        } ckodt[7:5];
        field {
            name = "acpdr";
            desc = "AC power down receiver. If this bit is set, the input receiver on the I/O is powered down for RAS#, CAS#, WE#, BA[2:0], and A[15:0] pins, as well as the optional DIMM PAR_IN pin and LPDDR TPD pin.";
            sw = rw; hw = r;
            reset = 0x1;
        } acpdr[4:4];
        field {
            name = "acpdd";
            desc = "AC power down driver. If this bit is set, the output driver on the I/O is powered down for RAS#, CAS#, WE#, BA[2:0], and A[15:0] pins, as well as the optional DIMM PAR_IN pin and LPDDR TPD pin.";
            sw = rw; hw = r;
            reset = 0x0;
        } acpdd[3:3];
        field {
            name = "acodt";
            desc = "Address/Command on-die termination. If this bit is set, the on-die termination on the I/O is enabled for RAS#, CAS#, WE#, BA[2:0], and A[15:0] pins, as well as the optional DIMM PAR_IN pin and LPDDR TPD pin.";
            sw = rw; hw = r;
            reset = 0x0;
        } acodt[2:2];
        field {
            name = "acoe";
            desc = "Address/Command output enable. If this bit is set, the output driver on the I/O is enabled for all address and command pins, as well as the optional DIMM PAR_IN pin and LPDDR TPD pin.";
            sw = rw; hw = r;
            reset = 0x1;
        } acoe[1:1];
        field {
            name = "aciom";
            desc = "Address/Command I/O mode. This bit is used to select the SSTL mode (when set to 0) or CMOS mode (when set to 1) of the I/O for all address and command pins, as well as the optional DIMM PAR_IN pin and LPDDR TPD pin.";
            sw = rw; hw = r;
            reset = 0x0;
        } aciom[0:0];
    } DDRC_PUB_ACIOCR @ 0x424;
    reg {
        name = "DDRC_PUB_DXCCR";
        desc = "DDRC_PUB_DXCCR is a DATX8 common configuration register. DDRC_PUB_DXCCR (offset 0x428, total reset 0x0000_0800; PROVEN: Hi3518E V100 data sheet, PDF page 411, section 4.1.6).";
        field {
            name = "reserved";
            desc = "reserved";
            sw = rw; hw = r;
            reset = 0x0;
        } reserved_31_14[31:14];
        field {
            name = "dxsr";
            desc = "Data slew rate (only for D3F I/O). This field is used to select the slew rate of the I/O for DQ, DM, and DQS/DQS# pins of all DATX8 macros. Note: The Hi3518E does not support the configuration.";
            sw = rw; hw = r;
            reset = 0x0;
        } dxsr[13:12];
        field {
            name = "dqsnres";
            desc = "DQS# resistor. This field is used to select the on-die pull-up/pull-down resistor for DQS# pins. This field has the same encoding as DQSRES. Note: A DQS# resistor must be connected for LPDDR2.";
            sw = rw; hw = r;
            reset = 0x8;
        } dqsnres[11:8];
        field {
            name = "dqsres";
            desc = "DQS resistor. This field is used to select the on-die pull-down/pull-up resistor for DQS pins. DQSRES[3] selects pull-down (when set to 0) or pull-up (when set to 1). DQSRES[2:0] selects the resistor value as follows:
- 000: open. The on-die resistor is disconnected.
- 001: 688 ohms
- 010: 611 ohms
- 011: 550 ohms
- 100: 500 ohms
- 101: 458 ohms
- 110: 393 ohms
- 111: 344 ohms

Note: A DQS resistor must be connected for LPDDR2.";
            sw = rw; hw = r;
            reset = 0x0;
        } dqsres[7:4];
        field {
            name = "dxpdr";
            desc = "Data power down receiver. If this bit is set, the input receiver on I/O is powered down for DQ, DM, and DQS/DQS# pins of all DATX8 macros. This bit is ORed with the PDR configuration bit of the individual DATX8(DXnGCR).";
            sw = rw; hw = r;
            reset = 0x0;
        } dxpdr[3:3];
        field {
            name = "dxpdd";
            desc = "Data power down driver. If this bit is set, the output driver on I/O is powered down for DQ, DM, and DQS/DQS# pins of all DATX8 macros. This bit is ORed with the PDD configuration bit of the individual DATX8(DXnGCR).";
            sw = rw; hw = r;
            reset = 0x0;
        } dxpdd[2:2];
        field {
            name = "dxiom";
            desc = "Data on-die termination. If this bit is set, the on-die termination on the I/O is enabled for DQ, DM, and DQS/DQS# pins of all DATX8 macros. This bit is ORed with the ODT configuration bit of the individual DATX8 (DXnGCR)";
            sw = rw; hw = r;
            reset = 0x0;
        } dxiom[1:1];
        field {
            name = "dxodt";
            desc = "Data on-die termination. If this bit is set, the on-die termination on the I/O is enabled for DQ, DM, and DQS/DQS# pins of all DATX8 macros. This bit is ORed with the ODT configuration bit of the individual DATX8 (DXnGCR)";
            sw = rw; hw = r;
            reset = 0x0;
        } dxodt[0:0];
    } DDRC_PUB_DXCCR @ 0x428;
    reg {
        name = "DDRC_PUB_DSGCR";
        desc = "DDRC_PUB_DSGCR is a DDR system general configuration register. DDRC_PUB_DSGCR (offset 0x42C, total reset 0xFA00_001F; PROVEN: Hi3518E V100 data sheet, PDF page 413, section 4.1.6).";
        field {
            name = "ckeoe";
            desc = "SDRAM CKE output enable. If this bit is set, the output driver on the I/O is enabled for the SDRAM CKE pin.";
            sw = rw; hw = r;
            reset = 0x1;
        } ckeoe[31:31];
        field {
            name = "rstoe";
            desc = "SDRAM reset output enable. If this bit is set, the output driver on the I/O is enabled for the SDRAM RST# pin.";
            sw = rw; hw = r;
            reset = 0x1;
        } rstoe[30:30];
        field {
            name = "odtoe";
            desc = "SDRAM ODT output enable. If this bit is set, the output driver on the I/O is enabled for the SDRAM ODT pin.";
            sw = rw; hw = r;
            reset = 0x1;
        } odtoe[29:29];
        field {
            name = "ckoe";
            desc = "SDRAM CK output enable. If this bit is set, the output driver on the I/O is enabled for SDRAM CK/CK# pins.";
            sw = rw; hw = r;
            reset = 0x1;
        } ckoe[28:28];
        field {
            name = "tpdoe";
            desc = "SDRAM TPD output enable (only for LPDDR). If this bit is set, the output driver on the I/O is enabled for the SDRAM TPD pin.";
            sw = rw; hw = r;
            reset = 0x1;
        } tpdoe[27:27];
        field {
            name = "tpdpd";
            desc = "SDRAM TPD power down driver (only for LPDDR). If this bit is set, the output driver on the I/O is powered down for SDRAM TPD pin. Note that the power down of the receiver on the I/O for SDRAM TPD pin is controlled by ACIOCR[ACPDR] register bit.";
            sw = rw; hw = r;
            reset = 0x0;
        } tpdpd[26:26];
        field {
            name = "nl2oe";
            desc = "Non-LPDDR2 output enable. If this bit is set, the output driver on the I/O is enabled for non-LPDDR2 (ODT, RAS#, CAS#, WE#, and BA) pins. This may be used when a chip designed for both LPDDR2 and other DDR modes is being used in LPDDR2 mode. For these pins, the I/O output enable signal (OE) is an AND of this bit and the respective output enable bit in the ACIOCR or DSGCR register.";
            sw = rw; hw = r;
            reset = 0x1;
        } nl2oe[25:25];
        field {
            name = "nl2pd";
            desc = "Non-LPDDR2 power down. If this bit is set, the output driver and the input receiver on the I/O are powered down for non-LPDDR2 (ODT, RAS#, CAS#, WE#, and BA) pins. This may be used when a chip designed for both LPDDR2 and other DDR modes is being used in LPDDR2 mode. For these pins, the I/O power down signal (PDD or PDR) is an OR of this bit and the respective power-down bit in the ACIOCR register.";
            sw = rw; hw = r;
            reset = 0x0;
        } nl2pd[24:24];
        field {
            name = "odtpdd";
            desc = "ODT power down driver. If this field is set, the output driver on the I/O is powered down for ODT[3:0] pins. ODTPDD[0] controls the power down for ODT[0], ODTPDD[1] controls the power down for ODT[1], and so on. Note: The actual reset value is calculated based on the configured number of ranks. For the Hi3518E, each PUB supports one rank.";
            sw = rw; hw = r;
            reset = 0x0;
        } odtpdd[23:20];
        field {
            name = "ckepdd";
            desc = "CKE power down driver. If this field is set, the output driver on the I/O is powered down for CKE[3:0] pins. CKEPDD[0] controls the power down for CKE[0], CKEPDD[1] controls the power down for CKE[1], and so on. Note: The actual reset value is calculated based on the configured number of ranks. For the Hi3518E, each PUB supports one rank.";
            sw = rw; hw = r;
            reset = 0x0;
        } ckepdd[19:16];
        field {
            name = "reserved";
            desc = "Reserved";
            sw = rw; hw = r;
            reset = 0x0;
        } reserved_15_11[15:11];
        field {
            name = "dqsge";
            desc = "DQS gate early. This field specifies the number of clock cycles during which the DQS gating must be enabled earlier than its normal position. This field is applicable only when the PDQSR I/O cell and passive DQS gating are used and there is no drift compensation. This field is recommended to be set to zero for all DDR types other than LPDDR2. For LPDDR2, this field is set to (tDQSCKmax − tDQSCK) divided by clock cycle and rounded up.";
            sw = rw; hw = r;
            reset = 0x0;
        } dqsge[10:8];
        field {
            name = "dqsgx";
            desc = "DQS gate extension. This field specifies the number of clock cycles during which the DQS gating must be extended beyond the normal burst length width. This field is applicable only when the PDQSR I/O cell and passive DQS gating are used and there is no drift compensation. This field is recommended to be set to zero for all DDR types other than LPDDR2. For LPDDR2, this field is set to (tDQSCKmax − tDQSCK) divided by clock cycle and rounded up.";
            sw = rw; hw = r;
            reset = 0x0;
        } dqsgx[7:5];
        field {
            name = "lpdllpd";
            desc = "Low-power DLL power down. If this bit is set, the PHY must respond to the DFI low-power opportunity request and power down the DLL of the byte when the wakeup time request satisfies the DLL lock time.";
            sw = rw; hw = r;
            reset = 0x1;
        } lpdllpd[4:4];
        field {
            name = "lpiopd";
            desc = "Low-power I/O power down. If this bit is set, it specifies that the PHY should respond to the DFI low-power opportunity request and power down the I/Os of the byte.";
            sw = rw; hw = r;
            reset = 0x1;
        } lpiopd[3:3];
        field {
            name = "zuen";
            desc = "Impedance update enable. If this bit is set, the PHY must perform impedance calibration (update) whenever there is a controller initiated DFI update request. Otherwise the PHY will ignore an update request from the controller.";
            sw = rw; hw = r;
            reset = 0x1;
        } zuen[2:2];
        field {
            name = "bdisen";
            desc = "Byte disable enable. If this bit is set, the PHY must respond to the DFI byte disable request. Otherwise the byte disable from the DFI is ignored, and therefore bytes can be disabled only by using the DXnGCR register.";
            sw = rw; hw = r;
            reset = 0x1;
        } bdisen[1:1];
        field {
            name = "puren";
            desc = "PHY update request enable. If this bit is set, the PHY must issue a PHY-initiated DFI update request when there is DQS drift of more than 3/4 of a clock cycle within one continuous (back-to-back) read burst. The PHY issues PHY-initiated update requests and the controller must respond by default. Otherwise, the PHY may return erroneous values. The option to disable it is provided only for silicon evaluation and testing.";
            sw = rw; hw = r;
            reset = 0x1;
        } puren[0:0];
    } DDRC_PUB_DSGCR @ 0x42c;
    reg {
        name = "DDRC_PUB_DCR";
        desc = "DDRC_PUB_DCR is a DRAM configuration register. DDRC_PUB_DCR (offset 0x430, total reset 0x0000_000B; PROVEN: Hi3518E V100 data sheet, PDF page 415, section 4.1.6).";
        field {
            name = "tpd";
            desc = "Test power down (only for LPDDR). Note: The Hi3518E does not support this function.";
            sw = rw; hw = r;
            reset = 0x0;
        } tpd[31:31];
        field {
            name = "rdimm";
            desc = "Registered DIMM. Note: The Hi3518E does not support this function.";
            sw = rw; hw = r;
            reset = 0x0;
        } rdimm[30:30];
        field {
            name = "udimm";
            desc = "Unbuffered DIMM address mirroring. Note: The Hi3518E does not support this function.";
            sw = rw; hw = r;
            reset = 0x0;
        } udimm[29:29];
        field {
            name = "ddr2t";
            desc = "DDR 2T timing. Note: The Hi3518E does not support this function.";
            sw = rw; hw = r;
            reset = 0x0;
        } ddr2t[28:28];
        field {
            name = "nosra";
            desc = "No simultaneous rank access. Note: The Hi3518E does not support this function.";
            sw = rw; hw = r;
            reset = 0x0;
        } nosra[27:27];
        field {
            name = "reserved";
            desc = "Reserved.";
            sw = rw; hw = r;
            reset = 0x0;
        } reserved_26_10[26:10];
        field {
            name = "ddrtype";
            desc = "DDR type. This field is used to select the DDR type for the specified DDR mode. The following are valid values for LPDDR2:
- 00: LPDDR2-S4
- 01: LPDDR2-S2
- 10: LPDDR2-NVM
- 11: reserved

Note: You do not need to configure this field.";
            sw = rw; hw = r;
            reset = 0x0;
        } ddrtype[9:8];
        field {
            name = "reserved";
            desc = "Reserved.";
            sw = rw; hw = r;
            reset = 0x0;
        } reserved_7_7[7:7];
        field {
            name = "reserved";
            desc = "Reserved.";
            sw = rw; hw = r;
            reset = 0x0;
        } reserved_6_4[6:4];
        field {
            name = "ddr8bnk";
            desc = "DDR 8-bank. If this bit is set, the SDRAM used has eight banks. For tRPA, tRP+1 and tFAW are used for 8-bank DRAMs; for other tRPA, tRP but no tFAW is used. Note that a setting of 1 for DRAMs that have less than 8 banks still results in correct functionality but less tighter DRAM command spacing for the parameters described here.";
            sw = rw; hw = r;
            reset = 0x1;
        } ddr8bnk[3:3];
        field {
            name = "ddrmd";
            desc = "SDRAM DDR mode.
- 000: LPDDR (mobile DDR)
- 001: DDR
- 010: DDR2
- 100: LPDDR2 (mobile DDR2) 101–111: reserved";
            sw = rw; hw = r;
            reset = 0x3;
        } ddrmd[2:0];
    } DDRC_PUB_DCR @ 0x430;
    reg {
        name = "DDRC_PUB_DTPR0";
        desc = "DDRC_PUB_DTPR0 is DRAM timing parameters register 0. DDRC_PUB_DTPR0 (offset 0x434, total reset 0x3092_666E; PROVEN: Hi3518E V100 data sheet, PDF page 416, section 4.1.6).";
        field {
            name = "tccd";
            desc = "Read to read and write to write command delay.
- 0: BL/2 for DDR2
- 1: BL/2 + 1 for DDR2";
            sw = rw; hw = r;
            reset = 0x0;
        } tccd[31:31];
        field {
            name = "trc";
            desc = "Activate to activate command delay (same bank). The valid value ranges from 2 to 42.";
            sw = rw; hw = r;
            reset = 0x18;
        } trc[30:25];
        field {
            name = "trrd";
            desc = "Activate to activate command delay (different banks). The valid value ranges from 1 to 8.";
            sw = rw; hw = r;
            reset = 0x4;
        } trrd[24:21];
        field {
            name = "tras";
            desc = "Activate to precharge command delay. The valid value ranges from 2 to 31.";
            sw = rw; hw = r;
            reset = 0x12;
        } tras[20:16];
        field {
            name = "trcd";
            desc = "Activate to read or write delay. The minimum time from when an activate command is issued to when a read or write to the activated row can be issued. The valid value range from 2 to 11.";
            sw = rw; hw = r;
            reset = 0x6;
        } trcd[15:12];
        field {
            name = "trp";
            desc = "Precharge command period. This field indicates the minimum time between a precharge command and any other command. Note that the controller automatically derives tRPA for 8-bank DDR2 devices by adding 1 to tRP. The valid value ranges from 2 to 11.";
            sw = rw; hw = r;
            reset = 0x6;
        } trp[11:8];
        field {
            name = "twtr";
            desc = "Internal write to read command delay. The valid value ranges from 1 to 6.";
            sw = rw; hw = r;
            reset = 0x3;
        } twtr[7:5];
        field {
            name = "trtp";
            desc = "Internal read to precharge command delay. The valid value ranges from 2 to 6. Note that even though RTP does not apply to JEDEC DDR devices, this parameter must still be set to a minimum value of 2 for DDR because the controller always uses the following DDR2 equation to calculate the read to precharge timing (which is BL/2 for JEDEC DDR): AL + BL/2 + max(RTP, 2) – 2";
            sw = rw; hw = r;
            reset = 0x3;
        } trtp[4:2];
        field {
            name = "tmrd";
            desc = "Load mode cycle time. This field indicates the minimum interval between a load mode register command and any other command.
- 00: 4
- 01: 5
- 10: 6
- 11: 7";
            sw = rw; hw = r;
            reset = 0x2;
        } tmrd[1:0];
    } DDRC_PUB_DTPR0 @ 0x434;
    reg {
        name = "DDRC_PUB_DTPR1";
        desc = "DDRC_PUB_DTPR1 is DRAM timing parameters register 1. DDRC_PUB_DTPR1 (offset 0x438, total reset 0x0983_0090; PROVEN: Hi3518E V100 data sheet, PDF page 417, section 4.1.6).";
        field {
            name = "reserved";
            desc = "Reserved";
            sw = rw; hw = r;
            reset = 0x0;
        } reserved_31_30[31:30];
        field {
            name = "tdqsckmax";
            desc = "Maximum DQS output access time from CK/CK# (LPDDR2 only). This value is used for implementing read-to-write spacing. The valid value ranges from 1 to 7.";
            sw = rw; hw = r;
            reset = 0x1;
        } tdqsckmax[29:27];
        field {
            name = "tdqsck";
            desc = "DQS output access time from CK/CK# (only for LPDDR2). This value is used for calculating the read latency. The valid value ranges from 1 to 7. This value is derived from the corresponding parameter in the SDRAM data sheet divided by the clock cycle time without rounding up. The fractional remainder is automatically adjusted for by data training in quarter clock cycle units. If data training is not performed, this fractional remainder must be converted into quarter clock cycle units and the gating registers (DXnDQSTR) are adjusted accordingly.";
            sw = rw; hw = r;
            reset = 0x1;
        } tdqsck[26:24];
        field {
            name = "trfc";
            desc = "Refresh-to-refresh. This field indicates the minimum time between two refresh commands or between a refresh and an active command. The value unit is clock cycle. The value is derived from the minimum refresh interval from the data sheet, tRFC(min), divided by the clock cycle time. The default number of clock cycles is the greatest value in tRFC(min) defined in the JEDEC protocol.";
            sw = rw; hw = r;
            reset = 0x83;
        } trfc[23:16];
        field {
            name = "reserved";
            desc = "Reserved";
            sw = rw; hw = r;
            reset = 0x0;
        } reserved_15_9[15:9];
        field {
            name = "tfaw";
            desc = "4-bank activate period. No more than 4-bank activate commands may be issued in a specified tFAW period. This field applies only to 8-bank devices. The valid value ranges from 2 to 31.";
            sw = rw; hw = r;
            reset = 0x12;
        } tfaw[8:3];
        field {
            name = "trtw";
            desc = "Read to write command delay.
- 0: standard bus turn around delay
- 1: add 1 clock to standard bus turn around delay

This parameter allows the user to increase the delay between issuing write commands to the SDRAM when preceded by read commands. This provides an option to increase bus turn-around margin for high-frequency systems.";
            sw = rw; hw = r;
            reset = 0x0;
        } trtw[2:2];
        field {
            name = "taondtaofd";
            desc = "ODT turn-on/turn-off delays (only for DDR2). The delay unit is clock cycle.
- 00: 2/2.5
- 01: 3/3.5
- 10: 4/4.5
- 11: 5/5.5

Most DDR2 devices use the fixed value 2/2.5. For non-standard SDRAMs, the user must ensure that the operational write latency is always greater than or equal to the ODT turn-on delay. For example, if the CAS latency, CAS additive latency, and write latency for a DDR2 SDRAM is 3, 0, and 2 respectively, the 2/2.5 but not 3/3.5 or larger can be used.";
            sw = rw; hw = r;
            reset = 0x0;
        } taondtaofd[1:0];
    } DDRC_PUB_DTPR1 @ 0x438;
    reg {
        name = "DDRC_PUB_DTPR2";
        desc = "DDRC_PUB_DTPR2 is DRAM timing parameters register 2. DDRC_PUB_DTPR2 (offset 0x43C, total reset 0x1001_A0C8; PROVEN: Hi3518E V100 data sheet, PDF page 419, section 4.1.6).";
        field {
            name = "reserved";
            desc = "Reserved.";
            sw = rw; hw = r;
            reset = 0x0;
        } reserved_31_29[31:29];
        field {
            name = "tdllk";
            desc = "DLL locking time. The valid value ranges from 2 to 1023.";
            sw = rw; hw = r;
            reset = 0x200;
        } tdllk[28:19];
        field {
            name = "tcke";
            desc = "CKE minimum pulse width. The valid value ranges from 2 to 15.";
            sw = rw; hw = r;
            reset = 0x3;
        } tcke[18:15];
        field {
            name = "txp";
            desc = "Minimum interval between the power down exit command to other commands. When the DDR2 is used, the maximum value among tXP, tXARD, and tXARDS is txp. The valid value ranges from 2 to 31.";
            sw = rw; hw = r;
            reset = 0x8;
        } txp[14:10];
        field {
            name = "txs";
            desc = "Self refresh exit delay. This field indicates the minimum time between a self refresh exit command and any other command. This parameter must be set to the maximum value among the various minimum self refresh exit delay parameters specified in the SDRAM data sheet, for example, max(tXSNR, tXSRD) for DDR2. The valid value ranges from 2 to 1023.";
            sw = rw; hw = r;
            reset = 0xc8;
        } txs[9:0];
    } DDRC_PUB_DTPR2 @ 0x43c;
    reg {
        name = "DDRC_PUB_MR0";
        desc = "DDRC_PUB_MR0 is mode register 0. DDRC_PUB_MR0 (offset 0x440, total reset 0x0000_0A52; PROVEN: Hi3518E V100 data sheet, PDF page 420, section 4.1.6).";
        field {
            name = "reserved";
            desc = "Reserved";
            sw = rw; hw = r;
            reset = 0x0;
        } reserved_31_16[31:16];
        field {
            name = "mr0";
            desc = "SDRAM mode register 0 (MR0). This field corresponds to valid bits 13−0 of mode register 0 (MR0) in the DDRn SDRAM user manual. DDRC_PUB_MR0 bit[15:14] must be set to 0b00. Note: For details about MR0, see the DDRn SDRAM user manual.";
            sw = rw; hw = r;
            reset = 0xa52;
        } mr0[15:0];
    } DDRC_PUB_MR0 @ 0x440;
    reg {
        name = "DDRC_PUB_MR1";
        desc = "DDRC_PUB_MR1 is mode register 1. DDRC_PUB_MR1 (offset 0x444, total reset 0x0000_0000; PROVEN: Hi3518E V100 data sheet, PDF page 420, section 4.1.6).";
        field {
            name = "reserved";
            desc = "Reserved";
            sw = rw; hw = r;
            reset = 0x0;
        } reserved_31_16[31:16];
        field {
            name = "mr1";
            desc = "SDRAM extended mode register 1 (EMR1). This field corresponds to valid bits 13−0 of mode register 1 (MR1) in the DDRn SDRAM user manual. DDRC_PUB_MR1 bit[15:14] must be set to 0b00. Note: For details about MR1, see the DDRn SDRAM user manual.";
            sw = rw; hw = r;
            reset = 0x0;
        } mr1[15:0];
    } DDRC_PUB_MR1 @ 0x444;
    reg {
        name = "DDRC_PUB_MR2";
        desc = "DDRC_PUB_MR2 is mode register 2. DDRC_PUB_MR2 (offset 0x448, total reset 0x0000_0000; PROVEN: Hi3518E V100 data sheet, PDF page 421, section 4.1.6).";
        field {
            name = "reserved";
            desc = "Reserved";
            sw = rw; hw = r;
            reset = 0x0;
        } reserved_31_16[31:16];
        field {
            name = "mr2";
            desc = "This field corresponds to valid bits 13−0 of mode register 2 (MR2) in the DDRn SDRAM user manual. DDRC_PUB_MR2 bit[15:14] must be set to 0b00. Note: For details about MR2, see the DDRn SDRAM user manual.";
            sw = rw; hw = r;
            reset = 0x0;
        } mr2[15:0];
    } DDRC_PUB_MR2 @ 0x448;
    reg {
        name = "DDRC_PUB_MR3";
        desc = "DDRC_PUB_MR3 is mode register 3. DDRC_PUB_MR3 (offset 0x44C, total reset 0x0000_0000; PROVEN: Hi3518E V100 data sheet, PDF page 421, section 4.1.6).";
        field {
            name = "reserved";
            desc = "Reserved";
            sw = rw; hw = r;
            reset = 0x0;
        } reserved_31_16[31:16];
        field {
            name = "mr3";
            desc = "SDRAM extended mode register 3 (EMR3) This field corresponds to valid bits 13−0 of mode register 1 (MR1) in the DDRn SDRAM user manual. DDRC_PUB_MR3 bit[15:14] must be set to 0b00. Note: For details about MR3, see the DDRn SDRAM user manual.";
            sw = rw; hw = r;
            reset = 0x0;
        } mr3[15:0];
    } DDRC_PUB_MR3 @ 0x44c;
    reg {
        name = "DDRC_PUB_ODTCR";
        desc = "DDRC_PUB_ODTCR is an ODT configuration register. DDRC_PUB_ODTCR (offset 0x450, total reset 0x0001_0000; PROVEN: Hi3518E V100 data sheet, PDF page 422, section 4.1.6).";
        field {
            name = "wrodt3";
            desc = "Write ODT: rank select. The description is the same as wodt0. Note: The actual reset value is calculated based on the configured number of ranks. The Hi3518E does not support the configuration.";
            sw = rw; hw = r;
            reset = 0x0;
        } wrodt3[31:28];
        field {
            name = "wrodt2";
            desc = "Write ODT: rank select. The description is the same as wodt0. Note: The actual reset value is calculated based on the configured number of ranks. The Hi3518E does not support the configuration.";
            sw = rw; hw = r;
            reset = 0x0;
        } wrodt2[27:24];
        field {
            name = "wrodt1";
            desc = "Write ODT: rank select. The description is the same as wodt0.";
            sw = rw; hw = r;
            reset = 0x0;
        } wrodt1[23:20];
        field {
            name = "wrodt0";
            desc = "Write ODT: specifies whether ODT should be enabled ('1') or disabled ('0') on each of at most four ranks when a write command is sent to rank n. WRODT0, WRODT1, WRODT2, and WRODT3 specify ODT settings when a write is to rank 0, rank 1, rank 2, and rank 3 respectively. The four bits of each field each represent a rank, the LSB being rank 0 and the MSB being rank 3. The ODT is enabled only on the rank that is being written to by default.";
            sw = rw; hw = r;
            reset = 0x1;
        } wrodt0[19:16];
        field {
            name = "rdodt3";
            desc = "Read ODT: rank select. The description is the same as rodt0. Note: The actual reset value is calculated based on the configured number of ranks. The Hi3518E does not support the configuration.";
            sw = rw; hw = r;
            reset = 0x0;
        } rdodt3[15:12];
        field {
            name = "rdodt2";
            desc = "Read ODT: rank select. The description is the same as rodt0. Note: The actual reset value is calculated based on the configured number of ranks. The Hi3518E does not support the configuration.";
            sw = rw; hw = r;
            reset = 0x0;
        } rdodt2[11:8];
        field {
            name = "rdodt1";
            desc = "Read ODT: rank select. The description is the same as rodt0.";
            sw = rw; hw = r;
            reset = 0x0;
        } rdodt1[7:4];
        field {
            name = "rdodt0";
            desc = "Read ODT: specifies whether ODT should be enabled ('1') or disabled ('0') on each of at most four ranks when a read command is sent to rank n. RDODT0, RDODT1, RDODT2, and RDODT3 specify ODT settings when a read is to rank 0, rank 1, rank 2, and rank 3 respectively. The four bits of each field each represent a rank, the LSB being rank 0 and the MSB being rank 3. The ODT is disabled during reads by default.";
            sw = rw; hw = r;
            reset = 0x0;
        } rdodt0[3:0];
    } DDRC_PUB_ODTCR @ 0x450;
    reg {
        name = "DDRC_PUB_DTAR";
        desc = "DDRC_PUB_DTAR is a data training address register. DDRC_PUB_DTAR (offset 0x454, total reset 0x0000_0000; PROVEN: Hi3518E V100 data sheet, PDF page 423, section 4.1.6).";
        field {
            name = "reserved";
            desc = "Reserved";
            sw = rw; hw = r;
            reset = 0x0;
        } reserved_31_31[31:31];
        field {
            name = "dtbank";
            desc = "Data training bank address. This field is used to select the SDRAM bank address to be used during data training.";
            sw = rw; hw = r;
            reset = 0x0;
        } dtbank[30:28];
        field {
            name = "dtrow";
            desc = "Data training row address. This field is used to select the SDRAM row address to be used during data training.";
            sw = rw; hw = r;
            reset = 0x0;
        } dtrow[27:12];
        field {
            name = "dtcol";
            desc = "Data training column address. This field is used to select the SDRAM column address to be used during data training. The lower four bits of this address must always be \"0000\".";
            sw = rw; hw = r;
            reset = 0x0;
        } dtcol[11:0];
    } DDRC_PUB_DTAR @ 0x454;
    reg {
        name = "DDRC_PUB_DTDR0";
        desc = "DDRC_PUB_DTDR0 is data training data register 0. DDRC_PUB_DTDR0 (offset 0x458, total reset 0xDD22_EE11; PROVEN: Hi3518E V100 data sheet, PDF page 423, section 4.1.6).";
        field {
            name = "dtbyte3";
            desc = "Data training data. This field indicates the fourth byte of data used during data training. The same data byte is used for each byte lane. The default sequence is a walking 1 while data toggling every data cycle.";
            sw = rw; hw = r;
            reset = 0xdd;
        } dtbyte3[31:24];
        field {
            name = "dtbyte2";
            desc = "Data training data. This field indicates the third byte of data used during data training. This same data byte is used for each byte lane. The default sequence is a walking 1 while data toggling every data cycle.";
            sw = rw; hw = r;
            reset = 0x22;
        } dtbyte2[23:16];
        field {
            name = "dtbyte1";
            desc = "Data training data.";
            sw = rw; hw = r;
            reset = 0xee;
        } dtbyte1[15:8];
        field {
            name = "dtbyte0";
            desc = "Data training data. This field indicates the first byte of data used during data training. This same data byte is used for each byte lane. The default sequence is a walking 1 while data toggling every data cycle.";
            sw = rw; hw = r;
            reset = 0x11;
        } dtbyte0[7:0];
    } DDRC_PUB_DTDR0 @ 0x458;
    reg {
        name = "DDRC_PUB_DTDR1";
        desc = "DDRC_PUB_DTDR1 is data training data register 1. DDRC_PUB_DTDR1 (offset 0x45C, total reset 0x7788_BB44; PROVEN: Hi3518E V100 data sheet, PDF page 424, section 4.1.6).";
        field {
            name = "dtbyte7";
            desc = "Data training data. This field indicates the eighth byte of data used during data training. This same data byte is used for each byte lane. The default sequence is a walking 1 while data toggling every data cycle.";
            sw = rw; hw = r;
            reset = 0x77;
        } dtbyte7[31:24];
        field {
            name = "dtbyte6";
            desc = "Data training data. This field indicates the seventh byte of data used during data training. This same data byte is used for each byte lane. The default sequence is a walking 1 while data toggling every data cycle.";
            sw = rw; hw = r;
            reset = 0x88;
        } dtbyte6[23:16];
        field {
            name = "dtbyte5";
            desc = "Data training data. This field indicates the sixth byte of data used during data training. This same data byte is used for each byte lane. The default sequence is a walking 1 while data toggling every data cycle.";
            sw = rw; hw = r;
            reset = 0xbb;
        } dtbyte5[15:8];
        field {
            name = "dtbyte4";
            desc = "Data training data. This field indicates the fifth byte of data used during data training. This same data byte is used for each byte lane. The default sequence is a walking 1 while data toggling every data cycle.";
            sw = rw; hw = r;
            reset = 0x44;
        } dtbyte4[7:0];
    } DDRC_PUB_DTDR1 @ 0x45c;
    reg {
        name = "DDRC_PUB_ZQ_CTRL0";
        desc = "DDRC_PUB_ZQ_CTRL0 is PUB DDR PHY I/O compensation configuration register 0. DDRC_PUB_ZQ_CTRL0 (offset 0x580, total reset 0x0000_014A; PROVEN: Hi3518E V100 data sheet, PDF page 425, section 4.1.6).";
        field {
            name = "zqpd";
            desc = "ZQ power down.
- 0: normal mode
- 1: The ZQ PAD power supply is shut down to implement low-power control.";
            sw = rw; hw = r;
            reset = 0x0;
        } zqpd[31:31];
        field {
            name = "zcal";
            desc = "Impedance calibration enable. Writing 1 enables the impedance auto-calibration logic. This field is automatically cleared after calibration.";
            sw = rw; hw = r;
            reset = 0x0;
        } zcal[30:30];
        field {
            name = "zcalbyp";
            desc = "Impedance compensation bypass mode.
- 0: automatic
- 1: ZQ auto-calibration is disabled. Calibration can be manually enabled.";
            sw = rw; hw = r;
            reset = 0x0;
        } zcalbyp[29:29];
        field {
            name = "zden";
            desc = "Impedance compensation mode.
- 0: auto-compensation mode
- 1: customer-specific mode";
            sw = rw; hw = r;
            reset = 0x0;
        } zden[28:28];
        field {
            name = "zdata";
            desc = "Impedance calibration configuration. zdata[27:20]: reserved zdata[19:15]: ODT pull-up impedance zdata[14:10]: ODT pull-down impedance zdata[9:5]: output pull-up impedance zdata[4:0]: output pull-down impedance";
            sw = rw; hw = r;
            reset = 0x14a;
        } zdata[27:0];
    } DDRC_PUB_ZQ_CTRL0 @ 0x580;
    reg {
        name = "DDRC_PUB_ZQ_CTRL1";
        desc = "DDRC_PUB_ZQ_CTRL1 is PUB DDR PHY I/O compensation configuration register 1. DDRC_PUB_ZQ_CTRL1 (offset 0x584, total reset 0x0000_007B; PROVEN: Hi3518E V100 data sheet, PDF page 425, section 4.1.6).";
        field {
            name = "reserved";
            desc = "Reserved.";
            sw = rw; hw = r;
            reset = 0x0;
        } reserved_31_8[31:8];
        field {
            name = "zprog_odt";
            desc = "I/O matched impedance divide ratio select.";
            sw = rw; hw = r;
            reset = 0x7;
        } zprog_odt[7:4];
        field {
            name = "zprog_drv";
            desc = "I/O drive impedance divide ratio select.";
            sw = rw; hw = r;
            reset = 0xb;
        } zprog_drv[3:0];
    } DDRC_PUB_ZQ_CTRL1 @ 0x584;
    reg {
        name = "DDRC_PUB_ZQ_STATUS0";
        desc = "DDRC_PUB_ZQ_STATUS0 is DDR PHY I/O compensation status register 0. DDRC_PUB_ZQ_STATUS0 (offset 0x588, total reset 0x0000_0000; PROVEN: Hi3518E V100 data sheet, PDF page 426, section 4.1.6).";
        field {
            name = "zdone";
            desc = "Impedance calibration completion indicator.
- 0: Impedance calibration does not start or impedance is being calibrated.
- 1: Impedance calibration is complete.";
            sw = r; hw = w;
            reset = 0x0;
        } zdone[31:31];
        field {
            name = "zerr";
            desc = "Impedance calibration error indicator.
- 0: normal
- 1: error";
            sw = r; hw = w;
            reset = 0x0;
        } zerr[30:30];
        field {
            name = "reserved";
            desc = "Reserved.";
            sw = r; hw = w;
            reset = 0x0;
        } reserved_29_28[29:28];
        field {
            name = "zctrl";
            desc = "Impedance calibration configuration. zctrl[27:20]: reserved zctrl[19:15]: ODT pull-up impedance zctrl[14:10]: ODT pull-down impedance zctrl[9:5]: output pull-up impedance zctrl[4:0]: output pull-down impedance";
            sw = r; hw = w;
            reset = 0x0;
        } zctrl[27:0];
    } DDRC_PUB_ZQ_STATUS0 @ 0x588;
    reg {
        name = "DDRC_PUB_ZQ_STATUS1";
        desc = "DDRC_PUB_ZQ_STATUS1 is DDR PHY I/O compensation status register 1. DDRC_PUB_ZQ_STATUS1 (offset 0x58C, total reset 0x0000_0000; PROVEN: Hi3518E V100 data sheet, PDF page 427, section 4.1.6).";
        field {
            name = "reserved";
            desc = "Reserved.";
            sw = r; hw = w;
            reset = 0x0;
        } reserved_31_8[31:8];
        field {
            name = "opu";
            desc = "ODT impedance pull-up calibration status.
- 00: Impedance calibration is complete and no error occurs.
- 01: An overflow error occurs.
- 10: An underflow error occurs.
- 11: Calibration is in progress.";
            sw = r; hw = w;
            reset = 0x0;
        } opu[7:6];
        field {
            name = "opd";
            desc = "ODT impedance pull-down calibration status.
- 00: Impedance calibration is complete and no error occurs.
- 01: An overflow error occurs.
- 10: An underflow error occurs.
- 11: Calibration is in progress.";
            sw = r; hw = w;
            reset = 0x0;
        } opd[5:4];
        field {
            name = "zpu";
            desc = "Output impedance pull-up calibration status.
- 00: Impedance calibration is complete and no error occurs.
- 01: An overflow error occurs.
- 10: An underflow error occurs.
- 11: Calibration is in progress.";
            sw = r; hw = w;
            reset = 0x0;
        } zpu[3:2];
        field {
            name = "zpd";
            desc = "Output impedance pull-down calibration status.
- 00: Impedance calibration is complete and no error occurs.
- 01: An overflow error occurs.
- 10: An underflow error occurs.
- 11: Calibration is in progress.";
            sw = r; hw = w;
            reset = 0x0;
        } zpd[1:0];
    } DDRC_PUB_ZQ_STATUS1 @ 0x58c;
    regfile {
        name = "DATX8 byte lane registers";
        desc = "The 6 per-byte-lane DATX8 registers of the DDR PHY; the group is repeated for byte lanes 0..1 at offset 0x5C0 + 0x40 x blanes.";
        reg {
            name = "DDRC_PUB_DXNGCR";
            desc = "DDRC_PUB_DXNGCR is a DATX8 general configuration register. DDRC_PUB_DXNGCR (offset 0x5C0 + 0x40 x blanes blanes(0-1), total reset 0x0000_0E81; PROVEN: Hi3518E V100 data sheet, PDF page 428, section 4.1.6).";
            field {
                name = "reserved";
                desc = "Reserved";
                sw = rw; hw = r;
                reset = 0x0;
            } reserved_31_14[31:14];
            field {
                name = "rttoal";
                desc = "RTT on additive latency. This bit indicates the time when the ODT control of DQ/DQS SSTL I/Os is set to the value in DQODT/DQSODT during read cycles.
    - 0: ODT control is set to DQSODT/DQODT almost two cycles before read data preamble
    - 1: ODT control is set to DQSODT/DQODT almost one cycle before read data preamble";
                sw = rw; hw = r;
                reset = 0x0;
            } rttoal[13:13];
            field {
                name = "rttoh";
                desc = "RTT output hold. This field indicates the number of clock cycles (from 0 to 3) after the read data postamble during which ODT control should retain DQSODT for DQS or DQODT for DQ/DM before it is disabled (setting it to '0') when dynamic ODT control is used. ODT is disabled almost RTTOH clock cycles after the read postamble.";
                sw = rw; hw = r;
                reset = 0x1;
            } rttoh[12:11];
            field {
                name = "dqrtt";
                desc = "DQ dynamic RTT control. If this bit is set, the ODT control of DQ/DM SSTL I/Os is dynamically controlled by setting it to the value in DQODT during reads and disabling it (setting it to '0') during any other cycle. If this bit is not set, the ODT control of DQ SSTL I/Os is always set to the value in DQODT.";
                sw = rw; hw = r;
                reset = 0x1;
            } dqrtt[10:10];
            field {
                name = "dqsrtt";
                desc = "DQS dynamic RTT control. If this bit is set, the ODT control of DQS SSTL I/Os is dynamically controlled by setting it to the value in DQSODT during reads and disabling it (setting it to '0') during any other cycle. If this bit is not set, the ODT control of DQS SSTL I/Os is always set to the value in DQSODT field.";
                sw = rw; hw = r;
                reset = 0x1;
            } dqsrtt[9:9];
            field {
                name = "dsen";
                desc = "Write DQS enable. This field is used to control whether the write DQS going to the SDRAM is enabled (toggling) or disabled (static value) and whether the DQS is inverted. DQS# is always the inversion of DQS. These values are valid only when DQS/DQS# output enable is on; otherwise, the DQS/DQS# is tristated.
    - 00: DQS disabled (driven to constant 0)
    - 01: DQS toggling with inverted polarity
    - 10: DQS toggling with normal polarity (This should be the default setting)
    - 11: DQS disabled (driven to constant 1)";
                sw = rw; hw = r;
                reset = 0x1;
            } dsen[8:7];
            field {
                name = "dqsrpd";
                desc = "DQSR power down. If this bit is set, the PDQSR cell is powered down.";
                sw = rw; hw = r;
                reset = 0x0;
            } dqsrpd[6:6];
            field {
                name = "dxpdr";
                desc = "Data power down receiver. If this bit is set, the input receiver on I/O is powered down for DQ, DM, and DQS/DQS# pins of the byte.";
                sw = rw; hw = r;
                reset = 0x0;
            } dxpdr[5:5];
            field {
                name = "dxpdd";
                desc = "Data power down driver. If this bit is set, the output driver on I/O is powered down for DQ, DM, and DQS/DQS# pins of the byte.";
                sw = rw; hw = r;
                reset = 0x0;
            } dxpdd[4:4];
            field {
                name = "dxiom";
                desc = "Data I/O mode. This bit is used to select the SSTL mode (when set to 0) or CMOS mode (when set to 1) of the I/O for DQ, DM, and DQS/DQS# pins of the byte.";
                sw = rw; hw = r;
                reset = 0x0;
            } dxiom[3:3];
            field {
                name = "dqodt";
                desc = "Data on-die termination. If this bit is set, the on-die termination on the I/O is enabled for DQ and DM pins of the byte.";
                sw = rw; hw = r;
                reset = 0x0;
            } dqodt[2:2];
            field {
                name = "dqsodt";
                desc = "DQS on-die termination. If this bit is set, the on-die termination on the I/O is enabled for DQS/DQS# pin of the byte.";
                sw = rw; hw = r;
                reset = 0x0;
            } dqsodt[1:1];
            field {
                name = "dxen";
                desc = "Data byte enable. If this bit is set, the DATX8 and SSTL I/Os used on the data byte are enabled. Setting this bit to '0' disables the byte. For example, the byte SSTL I/Os enter the power-down mode and the DLL in the DATX8 enters the bypass mode.";
                sw = rw; hw = r;
                reset = 0x1;
            } dxen[0:0];
        } DDRC_PUB_DXNGCR @ 0x0;
        reg {
            name = "DDRC_PUB_DXNGSR0";
            desc = "DDRC_PUB_DXNGSR0 is DATX8 general status register 0. DDRC_PUB_DXNGSR0 (offset 0x5C4 + 0x40 x blanes blanes(0-1), total reset 0x0000_0000; PROVEN: Hi3518E V100 data sheet, PDF page 430, section 4.1.6).";
            field {
                name = "reserved";
                desc = "Reserved";
                sw = r; hw = w;
                reset = 0x0;
            } reserved_31_25[31:25];
            field {
                name = "dtpass";
                desc = "Data training pass count. This field indicates the number of passing configurations during DQS gate training. Bits [2:0] are for rank 0, bits [5:3] for rank 1, and so on.";
                sw = r; hw = w;
                reset = 0x0;
            } dtpass[24:13];
            field {
                name = "reserved";
                desc = "Reserved";
                sw = r; hw = w;
                reset = 0x0;
            } reserved_12_12[12:12];
            field {
                name = "dtierr";
                desc = "Data training intermittent error. If this field is set, there is an intermittent error during data training of the byte. For example, a pass is followed by a failure and then another pass. Bit [0] is for rank 0, bit 1 for rank 1, and so on.";
                sw = r; hw = w;
                reset = 0x0;
            } dtierr[11:8];
            field {
                name = "dterr";
                desc = "Data training error. If this field is set, a valid DQS gating window cannot be found during data training of the byte. Bit [0] is for rank 0, bit 1 for rank 1, and so on.";
                sw = r; hw = w;
                reset = 0x0;
            } dterr[7:4];
            field {
                name = "dtdone";
                desc = "Data training done. If this field is set, the byte has finished data training. Bit [0] is for rank 0, bit 1 for rank 1, and so on.";
                sw = r; hw = w;
                reset = 0x0;
            } dtdone[3:0];
        } DDRC_PUB_DXNGSR0 @ 0x4;
        reg {
            name = "DDRC_PUB_DXNGSR1";
            desc = "DDRC_PUB_DXNGSR1 is DATX8 general status register 1. DDRC_PUB_DXNGSR1 (offset 0x5C8 + 0x40 x blanes blanes(0-1), total reset 0x0000_0000; PROVEN: Hi3518E V100 data sheet, PDF page 430, section 4.1.6).";
            field {
                name = "reserved";
                desc = "Reserved";
                sw = r; hw = w;
                reset = 0x0;
            } reserved_31_12[31:12];
            field {
                name = "dqsdft";
                desc = "DQS drift. This field is used to report the drift on the read data strobe of the data byte.
    - 00: no drift
    - 01: 90° drift
    - 10: 180° drift
    - 11: 270° drift or more

    Bits [1:0] are for rank 0, bits [3:2] for rank 1, and so on.";
                sw = r; hw = w;
                reset = 0x0;
            } dqsdft[11:4];
            field {
                name = "dfterr";
                desc = "DQS drift error. If this field is set, the byte read data strobe has drifted by more than or equal to the drift limit configured in the PHY general configuration register (PGCR). Bit [0] is for rank 0, bit 1 for rank 1, and so on.";
                sw = r; hw = w;
                reset = 0x0;
            } dfterr[3:0];
        } DDRC_PUB_DXNGSR1 @ 0x8;
        reg {
            name = "DDRC_PUB_DXNDLLCR";
            desc = "DDRC_PUB_DXNDLLCR is a DATX8 DLL control register. DDRC_PUB_DXNDLLCR (offset 0x5CC + 0x40 x blanes blanes(0-1), total reset 0x4000_0000; PROVEN: Hi3518E V100 data sheet, PDF page 431, section 4.1.6).";
            field {
                name = "dlldis";
                desc = "DLL disable. A disabled DLL is bypassed. The default value 0 indicates that the DLL is enabled.";
                sw = rw; hw = r;
                reset = 0x0;
            } dlldis[31:31];
            field {
                name = "dllsrst";
                desc = "DLL soft reset. This bit is used to soft-reset the byte DLL by driving the DLL soft reset pin.";
                sw = rw; hw = r;
                reset = 0x1;
            } dllsrst[30:30];
            field {
                name = "reserved";
                desc = "Reserved.";
                sw = rw; hw = r;
                reset = 0x0;
            } reserved_29_20[29:20];
            field {
                name = "sdlbmode";
                desc = "Slave DLL loopback mode. If this bit is set, the slave DLL enters the loopback mode in which there is no 90º phase shift on read DQS/DQS#. This bit must be set when the byte PHYs are operated in loopback mode such as during BIST loopback. This bit applies only to the PHYs that have this feature. For details, see the PHY data book.";
                sw = rw; hw = r;
                reset = 0x0;
            } sdlbmode[19:19];
            field {
                name = "atesten";
                desc = "Analog test enable. This bit is used to enable the analog test signal to be output on the DLL analog test output (test_out_a). The DLL analog test output is tristated when this bit is 0.";
                sw = rw; hw = r;
                reset = 0x0;
            } atesten[18:18];
            field {
                name = "sdphase";
                desc = "Slave DLL phase trim. This field is used to select the phase difference between the input clock and the corresponding output clock of the slave DLL.
    - 0000: 90
    - 0001: 72
    - 0010: 54
    - 0011: 36
    - 0100: 108
    - 0101: 90
    - 0110: 72
    - 0111: 54
    - 1000: 126
    - 1001: 108
    - 1010: 90
    - 1011: 72
    - 1100: 144
    - 1101: 126
    - 1110: 108
    - 1111: 90";
                sw = rw; hw = r;
                reset = 0x0;
            } sdphase[17:14];
            field {
                name = "sstart";
                desc = "Slave auto startup. This field is used to control how the slave DLL starts up relative to the master DLL locking: 0X: Slave DLL automatically starts up once the master DLL is locked.
    - 10: The automatic startup of the slave DLL is disabled, and the phase detector is disabled.
    - 11: The automatic startup of the slave DLL is disabled, and the phase detector is enabled.";
                sw = rw; hw = r;
                reset = 0x0;
            } sstart[13:12];
            field {
                name = "mfwdly";
                desc = "Master feed-forward delay trim. This field is used to trim the delay in the master DLL feed-forward path.
    - 000: minimum delay
    - 111: maximum delay";
                sw = rw; hw = r;
                reset = 0x0;
            } mfwdly[11:9];
            field {
                name = "mfbdly";
                desc = "Master feedback delay trim. This field is used to trim the delay in the master DLL feedback path.
    - 000: minimum delay
    - 111: maximum delay";
                sw = rw; hw = r;
                reset = 0x0;
            } mfbdly[8:6];
            field {
                name = "sfwdly";
                desc = "Slave feed-forward delay trim. This field is used to trim the delay in the slave DLL feed-forward path.
    - 000: minimum delay
    - 111: maximum delay";
                sw = rw; hw = r;
                reset = 0x0;
            } sfwdly[5:3];
            field {
                name = "sfbdly";
                desc = "Slave feed-back delay trim. This field is used to trim the delay in the slave DLL feedback path.
    - 000: minimum delay
    - 111: maximum delay";
                sw = rw; hw = r;
                reset = 0x0;
            } sfbdly[2:0];
        } DDRC_PUB_DXNDLLCR @ 0xc;
        reg {
            name = "DDRC_PUB_DXNDQTR";
            desc = "DDRC_PUB_DXNDQTR is a DATX8 DQ timing register. DDRC_PUB_DXNDQTR (offset 0x5D0 + 0x40 x blanes blanes(0-1), total reset 0xFFFF_FFFF; PROVEN: Hi3518E V100 data sheet, PDF page 433, section 4.1.6).";
            field {
                name = "dqdly7";
                desc = "DQ7 delay. The description is the same as DQ0 delay.";
                sw = rw; hw = r;
                reset = 0xf;
            } dqdly7[31:28];
            field {
                name = "dqdly6";
                desc = "DQ6 delay. The description is the same as DQ0 delay.";
                sw = rw; hw = r;
                reset = 0xf;
            } dqdly6[27:24];
            field {
                name = "dqdly5";
                desc = "DQ5 delay. The description is the same as DQ0 delay.";
                sw = rw; hw = r;
                reset = 0xf;
            } dqdly5[23:20];
            field {
                name = "dqdly4";
                desc = "DQ4 delay. The description is the same as DQ0 delay.";
                sw = rw; hw = r;
                reset = 0xf;
            } dqdly4[19:16];
            field {
                name = "dqdly3";
                desc = "DQ3 delay. The description is the same as DQ0 delay.";
                sw = rw; hw = r;
                reset = 0xf;
            } dqdly3[15:12];
            field {
                name = "dqdly2";
                desc = "DQ2 delay. The description is the same as DQ0 delay.";
                sw = rw; hw = r;
                reset = 0xf;
            } dqdly2[11:8];
            field {
                name = "dqdly1";
                desc = "DQ1 delay. The description is the same as DQ0 delay.";
                sw = rw; hw = r;
                reset = 0xf;
            } dqdly1[7:4];
            field {
                name = "dqdly0";
                desc = "DQ0 delay. This field is used to adjust the delay of the data relative to the nominal delay that matches the delay of the data strobes through the slave DLL and clock tree. Every four bits of this register control the delay of a different data bit in the byte. DQDLY0 controls the delay of data bit [0], DQDLY1 controls data bit [1], and so on. The lower two bits of the DQDLY for each DQ bit controls the delay for the data clocked by DQS, while the upper two bits control the delay for the data clocked by DQS_b. The following are valid settings for each 2-bit control field:
    - 00: nominal delay
    - 01: nominal delay + 1 step
    - 10: nominal delay + 2 steps
    - 11: nominal delay + 3 steps

    Note: The step size can be queried in the data books of compatible DWC DDR PHYs.";
                sw = rw; hw = r;
                reset = 0xf;
            } dqdly0[3:0];
        } DDRC_PUB_DXNDQTR @ 0x10;
        reg {
            name = "DDRC_PUB_DXNDQSTR";
            desc = "DDRC_PUB_DXNDQSTR is a DATX8 DQS timing register. DDRC_PUB_DXNDQSTR (offset 0x5D4 + 0x40 x blanes blanes(0-1), total reset 0x3DB0_1000; PROVEN: Hi3518E V100 data sheet, PDF page 434, section 4.1.6).";
            field {
                name = "reserved";
                desc = "Reserved";
                sw = rw; hw = r;
                reset = 0x0;
            } reserved_31_30[31:30];
            field {
                name = "dmdly";
                desc = "DM delay. This field is used to adjust the delay of the data mask relative to the nominal delay that matches the delay of the data strobes through the slave DLL and clock tree. The lower two bits of the DQMDLY controls the delay for the data clocked by DQS, while the upper two bits control the delay for the data clocked by DQS_b. The following are valid settings for each 2-bit control field:
    - 00: nominal delay
    - 01: nominal delay + 1 step
    - 10: nominal delay + 2 steps
    - 11: nominal delay + 3 steps

    Note: The step size can be queried in the data books of compatible DWC DDR PHYs.";
                sw = rw; hw = r;
                reset = 0xf;
            } dmdly[29:26];
            field {
                name = "dqsndly";
                desc = "DQS# delay. This field is used to adjust the delay of the data strobes relative to the nominal delay that matches the delay of the data bit through the slave DLL and clock tree. DQSDLY controls the delay on DQS strobe and DQSNDLY controls the delay on DQS#.
    - 000: nominal delay − 3 steps
    - 001: nominal delay − 2 steps
    - 010: nominal delay − 1 step
    - 011: nominal delay
    - 100: nominal delay + 1 step
    - 101: nominal delay + 2 steps
    - 110: nominal delay + 3 steps
    - 111: nominal delay + 4 steps

    Note: The step size can be queried in the data books of compatible DWC DDR PHYs.";
                sw = rw; hw = r;
                reset = 0x3;
            } dqsndly[25:23];
            field {
                name = "dqsdly";
                desc = "DQS. This field is used to adjust the delay of the data strobes relative to the nominal delay that matches the delay of the data bit through the slave DLL and clock tree. DQSDLY controls the delay on DQS strobe and DQSNDLY controls the delay on DQS#.
    - 000: nominal delay − 3 steps
    - 001: nominal delay − 2 steps
    - 010: nominal delay − 1 step
    - 011: nominal delay
    - 100: nominal delay + 1 step
    - 101: nominal delay + 2 steps
    - 110: nominal delay + 3 steps
    - 111: nominal delay + 4 steps

    Note: The step size can be queried in the data books of compatible DWC DDR PHYs.";
                sw = rw; hw = r;
                reset = 0x3;
            } dqsdly[22:20];
            field {
                name = "r3dgps";
                desc = "Rank 3 DQS gating phase select. The description is the same as r0dgps. Note: The actual reset value is calculated based on the configured number of ranks. The Hi3518E does not support the configuration.";
                sw = rw; hw = r;
                reset = 0x0;
            } r3dgps[19:18];
            field {
                name = "r2dgps";
                desc = "Rank 2 DQS gating phase select. The description is the same as r0dgps. Note: The actual reset value is calculated based on the configured number of ranks. The Hi3518E does not support the configuration.";
                sw = rw; hw = r;
                reset = 0x0;
            } r2dgps[17:16];
            field {
                name = "r1dgps";
                desc = "Rank 1 DQS gating phase select. The description is the same as r0dgps. The Hi3518E does not support the configuration.";
                sw = rw; hw = r;
                reset = 0x0;
            } r1dgps[15:14];
            field {
                name = "r0dgps";
                desc = "Rank 0 DQS gating phase select. This field is used to select the clock used to enable the data strobes during read, so that the value of the data strobes before and after the preamble/postamble are filtered out. The RnDGPS fields are initially set by the PUBL during automatic DQS data training and subsequently updated during data strobe drift compensation. However, these values can be overwritten by a direct write to this register, and the automatic update during DQS drift compensation can be disabled using the PHY general configuration register (PGCR). Every two bits of this register control the DQS gating for each of at most four ranks. R0DGPS controls the DQS gating for rank 0, R1DGPS controls rank 1, and so on. The following are valid values for each 2-bit RnDGPS field:
    - 00: 90° clock (clk90)
    - 01: 180° clock (clk180)
    - 10: 270° clock (clk270)
    - 11: 360° clock (clk0)";
                sw = rw; hw = r;
                reset = 0x1;
            } r0dgps[13:12];
            field {
                name = "r3dgsl";
                desc = "Rank 3 DQS gating system latency. The description is the same as r0dgsl. Note: The actual reset value is calculated based on the configured number of ranks. The Hi3518E does not support the configuration.";
                sw = rw; hw = r;
                reset = 0x0;
            } r3dgsl[11:9];
            field {
                name = "r2dgsl";
                desc = "Rank 2 DQS gating system latency. The description is the same as r0dgsl. Note: The actual reset value is calculated based on the configured number of ranks. The Hi3518E does not support the configuration.";
                sw = rw; hw = r;
                reset = 0x0;
            } r2dgsl[8:6];
            field {
                name = "r1dgsl";
                desc = "Rank 1 DQS gating system latency. The description is the same as r0dgsl.";
                sw = rw; hw = r;
                reset = 0x0;
            } r1dgsl[5:3];
            field {
                name = "r0dgsl";
                desc = "Rank 0 DQS gating system latency. This field is used to increase the number of clock cycles required for obtaining valid DDR read data. At most five extra clock cycles are supported. This is used to compensate for board delays and other system delays. The value 000 indicates power-on by default (for example, no extra clock cycles are required). The SL fields are initially set by the PUBL during automatic DQS data training but these values can be overwritten by a direct write to this register. Every three bits of this register control the latency of each of at most four ranks. R0DGSL controls the latency of rank 0, R1DGSL controls rank 1, and so on.
    - 000: no extra clock cycles
    - 001: 1 extra clock cycle
    - 010: 2 extra clock cycles
    - 011: 3 extra clock cycles
    - 100: 4 extra clock cycles
    - 101: 5 extra clock cycles
    - 110: reserved
    - 111: reserved";
                sw = rw; hw = r;
                reset = 0x0;
            } r0dgsl[2:0];
        } DDRC_PUB_DXNDQSTR @ 0x14;
    } DDRC_PUB_DXN[2] @ 0x5c0 += 0x40;
};

`endif
