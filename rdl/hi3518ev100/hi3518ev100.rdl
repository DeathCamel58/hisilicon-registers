

`include "../common/HISI_USB_HOST.rdl"
`include "io_config.rdl"
`include "crg.rdl"
`include "../common/ARM_PL190.rdl"
`include "sys_ctrl.rdl"
`include "../common/HISI_DMAC.rdl"
`include "../common/HISI_CIPHER_MC.rdl"
`include "../common/HISI_TIMER_SP804.rdl"
`include "../common/HISI_WDG_SP805.rdl"
`include "../common/HISI_RTC_SPI.rdl"
`include "rtc_int.rdl"
`include "ddrc.rdl"
`include "ddr_phy.rdl"
`include "../common/HISI_SFC_350.rdl"
`include "../common/HISI_FEMAC.rdl"
`include "../common/HISI_MOTION_DETECT.rdl"
`include "../common/HISI_IVE.rdl"
`include "vicap.rdl"
`include "vdp.rdl"
`include "isp.rdl"
`include "../common/HISI_SIO.rdl"
`include "../common/HISI_I2C.rdl"
`include "../common/HISI_SPI.rdl"
`include "../common/ARM_PL011.rdl"
`include "../common/HISI_IR.rdl"
`include "../common/ARM_PL061.rdl"
`include "../common/HISI_DWMMC.rdl"
`include "../common/HISI_SAR_ADC.rdl"
`include "../common/HISI_PWM.rdl"

addrmap hi3518ev100 {
    name = "hi3518ev100 registers";
    desc = "
## Status

Register map of the Hi3518E V100 (720p IP camera SoC, ARM926, vector interrupt controller PL190, the Hi3518C V100 generation). Everything below is taken from the HiSilicon Hi3518E 720p IP Camera SoC data sheet (Issue 03, 2015-11-26): the address map (table 1-1), the interrupt table (table 3-20) and the register tables of chapters 2 to 13.
The register blocks were extracted programmatically from the data sheet text (names, offsets, bit ranges, access, reset values, short descriptions) and are labelled PROVEN (data sheet table). Blocks with the same layout as on the Hi3518A/C V100 reuse the shared blocks in rdl/common and the chip-local blocks of rdl/hi3518v100 (compared register by register; see docs/rdl-campaign/hi3518ev100-datasheet.md of the workspace); chip-local blocks were generated where the data sheet differs or no shared block exists.
Not modelled because the data sheet has no register tables: VPSS, TDE, VENC, JPGE, DDRT registers (the Hi3518C V100 chip file models them from vendor code), DMA/VIC details beyond the tables.
Nothing was verified on hardware.

## Addresses

| Start Address | End Address | Description | Documented Here |
|---------------|-------------|-------------|-----------------|
| 0x80000000 | 0x8FFFFFFF | DDR memory space (connects external DDR, 256 MB) | &#10060; |
| 0x58000000 | 0x5BFFFFFF | Storage space of the SPI flash; 64 MB | &#10060; |
| 0x206D0000 | 0x206DFFFF | DDR test module; 64 KB | &#10060; |
| 0x206C0000 | 0x206CFFFF | Motion detection (MD) register; 64 KB | &#9989; MDU (reused common block) |
| 0x20660000 | 0x2066FFFF | JPEG encoder (JPGE) register; 64 KB | &#10060; |
| 0x20620000 | 0x2062FFFF | Video encoding (VENC) register; 64 KB | &#10060; |
| 0x20610000 | 0x2061FFFF | Two-dimensional engine (TDE); 64 KB | &#10060; |
| 0x20600000 | 0x2060FFFF | Video process subsystem (VPSS); 64 KB | &#10060; |
| 0x205E0000 | 0x205EFFFF | IVE register; 64 KB | &#9989; IVE (reused common block) |
| 0x205C0000 | 0x205CFFFF | Video display (VDP) register; 64 KB | &#9989; VDP (generated from the data sheet) |
| 0x20580000 | 0x205BFFFF | Video capture (VICAP) register; 256 KB | &#9989; VICAP, ISP (generated from the data sheet) |
| 0x201F0000 | 0x201FFFFF | GPIO11 register; 64 KB | &#9989; GPIO11 (reused common block) |
| 0x201E0000 | 0x201EFFFF | GPIO10 register; 64 KB | &#9989; GPIO10 (reused common block) |
| 0x201D0000 | 0x201DFFFF | GPIO9 register; 64 KB | &#9989; GPIO9 (reused common block) |
| 0x201B0000 | 0x201BFFFF | GPIO7 register; 64 KB | &#9989; GPIO7 (reused common block) |
| 0x201A0000 | 0x201AFFFF | GPIO6 register; 64 KB | &#9989; GPIO6 (reused common block) |
| 0x20190000 | 0x2019FFFF | GPIO5 register; 64 KB | &#9989; GPIO5 (reused common block) |
| 0x20180000 | 0x2018FFFF | GPIO4 register; 64 KB | &#9989; GPIO4 (reused common block) |
| 0x20170000 | 0x2017FFFF | GPIO3 register; 64 KB | &#9989; GPIO3 (reused common block) |
| 0x20160000 | 0x2016FFFF | GPIO2 register; 64 KB | &#9989; GPIO2 (reused common block) |
| 0x20150000 | 0x2015FFFF | GPIO1 register; 64 KB | &#9989; GPIO1 (reused common block) |
| 0x20140000 | 0x2014FFFF | GPIO0 register; 64 KB | &#9989; GPIO0 (reused common block) |
| 0x20130000 | 0x2013FFFF | PWM0/1/2 register; 64 KB | &#9989; PWM (reused common block) |
| 0x20120000 | 0x2012FFFF | DDR_PHY register; 64 KB | &#9989; DDR_PHY (generated from the data sheet) |
| 0x20110000 | 0x2011FFFF | DDRC register; 64 KB | &#9989; DDRC (generated from the data sheet) |
| 0x200F0000 | 0x200FFFFF | IO configuration register; 64 KB | &#9989; IO_CONFIG (generated from the data sheet) |
| 0x200E0000 | 0x200EFFFF | SPI1 register; 64 KB | &#9989; SPI1 (reused common block) |
| 0x200D0000 | 0x200DFFFF | I2C register; 64 KB | &#9989; I2C (reused common block) |
| 0x200C0000 | 0x200CFFFF | SPI0 register; 64 KB | &#9989; SPI0 (reused common block) |
| 0x200B0000 | 0x200BFFFF | Successive approximation (SAR); 64 KB | &#9989; SAR_ADC (reused common block) |
| 0x200A0000 | 0x200AFFFF | UART2 register; 64 KB | &#9989; UART2 (reused common block) |
| 0x20090000 | 0x2009FFFF | UART1 register; 64 KB | &#9989; UART1 (reused common block) |
| 0x20080000 | 0x2008FFFF | UART0 register; 64 KB | &#9989; UART0 (reused common block) |
| 0x20070000 | 0x2007FFFF | IR register; 64 KB | &#9989; IR (reused common block) |
| 0x20060000 | 0x2006FFFF | RTC register; 64 KB | &#9989; RTC (reused common block) |
| 0x20050000 | 0x2005FFFF | SYS_CTRL register; 64 KB | &#9989; SYS_CTRL (generated from the data sheet) |
| 0x20040000 | 0x2004FFFF | WDG register; 64 KB | &#9989; WDG (reused common block) |
| 0x20030000 | 0x2003FFFF | CRG register; 64 KB | &#9989; CRG (generated from the data sheet) |
| 0x20010000 | 0x2001FFFF | Timer2/3 register; 64 KB | &#9989; TIMER2, TIMER3 (reused common block) |
| 0x20000000 | 0x2000FFFF | Timer0/1 register; 64 KB | &#9989; TIMER0, TIMER1 (reused common block) |
| 0x10140000 | 0x1014FFFF | Vector interrupt controller (VIC); 64 KB | &#9989; INT (reused common block) |
| 0x100D0000 | 0x100DFFFF | Direct memory access control; 64 KB | &#9989; DMAC (reused common block) |
| 0x100C0000 | 0x100CFFFF | CIPHER register; 64 KB | &#9989; CIPHER (reused common block) |
| 0x100B0000 | 0x100BFFFF | USB enhanced host controller; 64 KB | &#9989; EHCI (reused common block) |
| 0x100A0000 | 0x100AFFFF | USB open host controller interface; 64 KB | &#9989; OHCI (generated from the data sheet) |
| 0x10090000 | 0x1009FFFF | Ethernet (ETH) register; 64 KB | &#9989; ETH (reused common block) |
| 0x10040000 | 0x1004FFFF | Sonic input/output (SIO) register; 64 KB | &#9989; SIO (reused common block) |
| 0x10020000 | 0x1002FFFF | SDIO register; 64 KB | &#9989; MMC (reused common block) |
| 0x10010000 | 0x1001FFFF | SPI NOR flash register; 64 KB | &#9989; SFC (reused common block) |
| 0x00000000 | 0x03FFFFFF | During address remapping this window points to the boot ROM; after remapping is cleared it points to the on-chip RAM (64 MB) | &#10060; |

## Interrupts

Interrupt numbers of the interrupt controller (data sheet interrupt table); `Reserved` entries omitted.

| Interrupt | Source |
|-----------|--------|
| 0 | Global software interrupt |
| 1 | WDT (periphctrl0 bit 31 = 0) or COMMRX/WDT (bit 31 = 1) |
| 2 | RTC (periphctrl0 bit 31 = 0) or COMMRX/RTC (bit 31 = 1) |
| 3 | Timer0/Timer1 |
| 4 | Timer2/Timer3 |
| 5 | UART0/UART1 |
| 6 | SSP0 |
| 7 | SSP1 |
| 9 | SIO |
| 10 | Temper_Cap |
| 11 | SFC |
| 12 | ETH |
| 13 | CIPHER |
| 14 | DMAC |
| 15 | USB_EHCI |
| 16 | USB_OHCI |
| 17 | VPSS |
| 18 | SDIO |
| 19 | IR/SAR_ADC |
| 20 | I2C |
| 21 | IVE |
| 22 | VICAP |
| 23 | VOU |
| 24 | VEDU |
| 25 | UART2 |
| 26 | JPGE |
| 27 | TDE |
| 28 | MDU/DDRT |
| 29 | GPIO0/GPIO1/GPIO2/GPIO11 |
| 30 | GPIO3/GPIO4/GPIO5/GPIO10 |
| 31 | GPIO6/GPIO7/GPIO8/GPIO9 |

        <!-- overview:begin -->

        ### Diagrams

        ![Register blocks by function](assets/diagrams/hi3518ev100-blocks.svg)

        ### Interrupts (ARM926 VIC source numbers, data sheet Table 3-20)

        | # | Source | # | Source | # | Source |
        |---|---|---|---|---|---|
        | 0 | Global software interrupt | 11 | SFC | 22 | VICAP |
        | 1 | WDT interrupt when periphctrl0 bit[31] is 0 | 12 | ETH | 23 | VOU |
        | 2 | RTC interrupt when periphctrl0 bit[31] is 0 | 13 | CIPHER | 24 | VEDU |
        | 3 | Timer0/Timer1 | 14 | DMAC | 25 | UART2 |
        | 4 | Timer2/Timer3 | 15 | USB_EHCI | 26 | JPGE |
        | 5 | UART0/UART1 | 16 | USB_OHCI | 27 | TDE |
        | 6 | SSP0 | 17 | VPSS | 28 | MDU/DDRT |
        | 7 | SSP1 | 18 | SDIO | 29 | GPIO0/GPIO1/GPIO2/GPIO11 |
        | 8 | Reserved | 19 | IR/SAR_ADC | 30 | GPIO3/GPIO4/GPIO5/GPIO10 |
        | 9 | SIO | 20 | I2C | 31 | GPIO6/GPIO7/GPIO8/GPIO9 |
        | 10 | Temper_Cap | 21 | IVE |  |  |

        ### Clock-gate and reset map (generated from the CRG registers)

        | Offset | Register | Description | Gate / reset fields |
        |---|---|---|---|
        | 0x028 | PERI_CRG10 | PERI_CRG10 | cpu_srst_req |
        | 0x02C | PERI_CRG11 | PERI_CRG11 | vi_hrst_req, vi1_hcken, vi_rst_req, vi_cken, isp_rst_req, isp_cken |
        | 0x034 | PERI_CRG13 | PERI_CRG13 | vo_hrst_req, vo_hd_srst_req, vo_sd_srst_req, vou_hcken, vou_hd_cken, vou_sd_cken |
        | 0x038 | PERI_CRG14 | PERI_CRG14 | pwm_srst_req, pwm_cken |
        | 0x040 | PERI_CRG16 | PERI_CRG16 | vedu_srst_req, vedu0_cken |
        | 0x048 | PERI_CRG18 | PERI_CRG18 | vps_srst_req, vps_cken |
        | 0x058 | PERI_CRG22 | PERI_CRG22 | tde_srst_req, tde_cken |
        | 0x060 | PERI_CRG24 | PERI_CRG24 | jpge_srst_req, jpge_cken |
        | 0x068 | PERI_CRG26 | PERI_CRG26 | mdu_srst_req, mdu_cken |
        | 0x06C | PERI_CRG27 | PERI_CRG27 | vapu_srst_req, vapu_cken |
        | 0x07C | PERI_CRG31 | PERI_CRG31 | cipher_srst_req, cipher_cken |
        | 0x080 | PERI_CRG32 | PERI_CRG32 | sar_adc_srst_req, sar_adc_cken |
        | 0x08C | PERI_CRG35 | PERI_CRG35 | sio_srst_req, sio_cken, adac_srst_req |
        | 0x0B8 | PERI_CRG46 | PERI_CRG46 | usb_ahb_srst_req, usb_cken |
        | 0x0C0 | PERI_CRG48 | PERI_CRG48 | sfc_srst_req, sfc_cken |
        | 0x0C4 | PERI_CRG49 | PERI_CRG49 | sdio_srst_req, sdio_cken |
        | 0x0CC | PERI_CRG51 | PERI_CRG51 | hrst_eth_s, eth_cken |
        | 0x0D8 | PERI_CRG54 | PERI_CRG54 | ddrtest_srst_req, ddrtest_cken |
        | 0x0E0 | PERI_CRG56 | PERI_CRG56 | dma_srst_req, dma_cken |
        | 0x0E4 | PERI_CRG57 | PERI_CRG57 | test_clk_en, i2c_srst_req, t_cap_srst_req, ir_srst_req, ssp0_srst_req, ssp1_srst_req, uart0_srst_req, uart1_srst_req, uart2_srst_req, ir_cken, ... |
        | 0x0F4 | PERI_CRG61 | PERI_CRG61 | osc_clk_en, osc_en |

        Only fields whose names contain a clock-enable or reset keyword are listed; the field descriptions in the register pages give the polarity and the clocks they gate.

        ### Register blocks (generated from this description)

        | Base | Instance | Block | Register space |
        |---|---|---|---|
        | 0x10010000 | SFC | System Flash Controller Registers | 1088 B |
        | 0x10020000 | MMC | HiSilicon MMC/SD/SDIO controller (DesignWare-MMC based, himciv200) | 516 B |
        | 0x10040000 | SIO | HiSilicon SIO (I2S/PCM audio interface) | 196 B |
        | 0x10090000 | ETH | HiSilicon femac v2 Fast Ethernet MAC with MDIO | 5184 B |
        | 0x100A0000 | OHCI | HiSilicon USB 2.0 host controller - OHCI | 92 B |
        | 0x100B0000 | EHCI | HiSilicon USB 2.0 host controller - EHCI | 176 B |
        | 0x100C0000 | CIPHER | CIPHER (8 channels) | 5184 B |
        | 0x100D0000 | DMAC | HiSilicon DMA controller (PL080-compatible, 4 or 8 channels) | 384 B |
        | 0x10140000 | INT | Vectored interrupt controller (ARM PrimeCell PL190) | 4 KB |
        | 0x20000000 | TIMER0 | Timer Registers | 28 B |
        | 0x20000020 | TIMER1 | Timer Registers | 28 B |
        | 0x20010000 | TIMER2 | Timer Registers | 28 B |
        | 0x20010020 | TIMER3 | Timer Registers | 28 B |
        | 0x20030000 | CRG | Clock and reset generator (CRG) | 252 B |
        | 0x20040000 | WDG | Watchdog Registers | 3076 B |
        | 0x20050000 | SYS_CTRL | System controller (SC) | 3824 B |
        | 0x20060000 | RTC | HiSilicon SPI-bridged RTC (APB registers) | 164 B |
        | 0x20060100 | RTC_INT | Internal RTC register file (device addresses reached through the RTC SPI interface, NOT memory mapped; the instance base 0x20060100 in the SoC map is a placeholder) | 81 B |
        | 0x20070000 | IR | HiSilicon IR receiver | 56 B |
        | 0x20080000 | UART0 | UART (ARM PrimeCell PL011) | 4 KB |
        | 0x20090000 | UART1 | UART (ARM PrimeCell PL011) | 4 KB |
        | 0x200A0000 | UART2 | UART (ARM PrimeCell PL011) | 4 KB |
        | 0x200B0000 | SAR_ADC | HiSilicon SAR ADC (10-bit, 2 channels, first generation) | 32 B |
        | 0x200C0000 | SPI0 | SPI Registers | 48 B |
        | 0x200D0000 | I2C | HiSilicon I2C Master Controller | 32 B |
        | 0x200E0000 | SPI1 | SPI Registers | 48 B |
        | 0x200F0000 | IO_CONFIG | Pin multiplexing registers (muxctrl_reg) | 380 B |
        | 0x20110000 | DDRC | DDR controller (DDRC) | 656 B |
        | 0x20120000 | DDR_PHY | DDR PUB PHY | 1600 B |
        | 0x20130000 | PWM | HiSilicon PWM group | 128 B |
        | 0x20140000 | GPIO0 | ARM PL061 | 1053 B |
        | 0x20150000 | GPIO1 | ARM PL061 | 1053 B |
        | 0x20160000 | GPIO2 | ARM PL061 | 1053 B |
        | 0x20170000 | GPIO3 | ARM PL061 | 1053 B |
        | 0x20180000 | GPIO4 | ARM PL061 | 1053 B |
        | 0x20190000 | GPIO5 | ARM PL061 | 1053 B |
        | 0x201A0000 | GPIO6 | ARM PL061 | 1053 B |
        | 0x201B0000 | GPIO7 | ARM PL061 | 1053 B |
        | 0x201D0000 | GPIO9 | ARM PL061 | 1053 B |
        | 0x201E0000 | GPIO10 | ARM PL061 | 1053 B |
        | 0x201F0000 | GPIO11 | ARM PL061 | 1053 B |
        | 0x20580000 | VICAP | Video capture (VICAP) | 65788 B |
        | 0x205A0000 | ISP | Image signal processor (ISP) | 3200 B |
        | 0x205C0000 | VDP | Video display processor (VDP, VOU) | 52768 B |
        | 0x205E0000 | IVE | HiSilicon intelligent video engine | 28 B |
        | 0x206C0000 | MDU | Motion Detect Unit Registers | 188 B |

        The table is generated from the elaborated root (instances at their absolute addresses; register space is the span of the block's registers, not the data sheet window).

        <!-- overview:end -->
    ";
    eHI3518EV100_IO_CONFIG     IO_CONFIG      @ 0x200F0000;
    eHI3518EV100_CRG           CRG            @ 0x20030000;
    eARM_PL190                 INT            @ 0x10140000;
    eHI3518EV100_SYS_CTRL      SYS_CTRL       @ 0x20050000;
    eHISI_DMAC                 DMAC           @ 0x100D0000;
    eHISI_CIPHER_MC            CIPHER         @ 0x100C0000;
    eHISI_TIMER_SP804          TIMER0         @ 0x20000000;
    eHISI_TIMER_SP804          TIMER1         @ 0x20000020;
    eHISI_TIMER_SP804          TIMER2         @ 0x20010000;
    eHISI_TIMER_SP804          TIMER3         @ 0x20010020;
    eHISI_WDG_SP805            WDG            @ 0x20040000;
    eHISI_RTC_SPI              RTC            @ 0x20060000;
    eHI3518EV100_RTC_INT       RTC_INT        @ 0x20060100;
    eHI3518EV100_DDRC          DDRC           @ 0x20110000;
    eHI3518EV100_DDR_PHY       DDR_PHY        @ 0x20120000;
    eHISI_SFC_350              SFC            @ 0x10010000;
    eHISI_FEMAC                ETH            @ 0x10090000;
    eMOTION_DETECT             MDU            @ 0x206C0000;
    eHISI_IVE                  IVE            @ 0x205E0000;
    eHI3518EV100_VICAP         VICAP          @ 0x20580000;
    eHI3518EV100_VDP           VDP            @ 0x205C0000;
    eHI3518EV100_ISP           ISP            @ 0x205A0000;
    eHISI_SIO                  SIO            @ 0x10040000;
    eHISI_I2C                  I2C            @ 0x200D0000;
    eHISI_SPI                  SPI0           @ 0x200C0000;
    eHISI_SPI                  SPI1           @ 0x200E0000;
    eARM_PL011                 UART0          @ 0x20080000;
    eARM_PL011                 UART1          @ 0x20090000;
    eARM_PL011                 UART2          @ 0x200A0000;
    eHISI_IR                   IR             @ 0x20070000;
    eARM_PL061                 GPIO0          @ 0x20140000;
    eARM_PL061                 GPIO1          @ 0x20150000;
    eARM_PL061                 GPIO2          @ 0x20160000;
    eARM_PL061                 GPIO3          @ 0x20170000;
    eARM_PL061                 GPIO4          @ 0x20180000;
    eARM_PL061                 GPIO5          @ 0x20190000;
    eARM_PL061                 GPIO6          @ 0x201A0000;
    eARM_PL061                 GPIO7          @ 0x201B0000;
    eARM_PL061                 GPIO9          @ 0x201D0000;
    eARM_PL061                 GPIO10         @ 0x201E0000;
    eARM_PL061                 GPIO11         @ 0x201F0000;
    eHISI_USB_EHCI             EHCI           @ 0x100B0000;
    eHISI_DWMMC                MMC            @ 0x10020000;
    eHISI_SAR_ADC              SAR_ADC        @ 0x200B0000;
    eHISI_PWM_GRP              PWM            @ 0x20130000;
    eHISI_USB_OHCI             OHCI           @ 0x100A0000;
};
