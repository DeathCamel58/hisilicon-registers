

`include "../common/HISI_USB_HOST.rdl"
`include "io_config.rdl"
`include "crg.rdl"
`include "../common/ARM_PL190.rdl"
`include "sys_ctrl.rdl"
`include "../common/HISI_DMAC.rdl"
`include "../common/HISI_CIPHER_MC.rdl"
`include "../common/HISI_TIMER_SP804.rdl"
`include "../common/HISI_WDG_SP805.rdl"
`include "../common/HISI_RTC_SPI.rdl"
`include "rtc_int.rdl"
`include "ddrc.rdl"
`include "ddr_phy.rdl"
`include "../common/HISI_SFC_350.rdl"
`include "../common/HISI_FEMAC.rdl"
`include "../common/HISI_MOTION_DETECT.rdl"
`include "../common/HISI_IVE.rdl"
`include "vicap.rdl"
`include "vdp.rdl"
`include "isp.rdl"
`include "../common/HISI_SIO.rdl"
`include "../common/HISI_I2C.rdl"
`include "../common/HISI_SPI.rdl"
`include "../common/ARM_PL011.rdl"
`include "../common/HISI_IR.rdl"
`include "../common/ARM_PL061.rdl"
`include "../common/HISI_DWMMC.rdl"
`include "../common/HISI_SAR_ADC.rdl"
`include "../common/HISI_PWM.rdl"

addrmap hi3518ev100 {
    name = "hi3518ev100 registers";
    desc = "
## Status

Register map of the Hi3518E V100 (720p IP camera SoC, ARM926, vector interrupt controller PL190, the Hi3518C V100 generation). Everything below is taken from the HiSilicon Hi3518E 720p IP Camera SoC data sheet (Issue 03, 2015-11-26): the address map (table 1-1), the interrupt table (table 3-20) and the register tables of chapters 2 to 13.
The register blocks were extracted programmatically from the data sheet text (names, offsets, bit ranges, access, reset values, short descriptions) and are labelled PROVEN (data sheet table). Blocks with the same layout as on the Hi3518A/C V100 reuse the shared blocks in rdl/common and the chip-local blocks of rdl/hi3518v100 (compared register by register; see docs/rdl-campaign/hi3518ev100-datasheet.md of the workspace); chip-local blocks were generated where the data sheet differs or no shared block exists.
Not modelled because the data sheet has no register tables: VPSS, TDE, VENC, JPGE, DDRT registers (the Hi3518C V100 chip file models them from vendor code), DMA/VIC details beyond the tables.
Nothing was verified on hardware.

## Addresses

| Start Address | End Address | Description | Documented Here |
|---------------|-------------|-------------|-----------------|
| 0x80000000 | 0x8FFFFFFF | DDR memory space (connects external DDR, 256 MB) | &#10060; |
| 0x58000000 | 0x5BFFFFFF | Storage space of the SPI flash; 64 MB | &#10060; |
| 0x206D0000 | 0x206DFFFF | DDR test module; 64 KB | &#10060; |
| 0x206C0000 | 0x206CFFFF | Motion detection (MD) register; 64 KB | &#9989; MDU (reused common block) |
| 0x20660000 | 0x2066FFFF | JPEG encoder (JPGE) register; 64 KB | &#10060; |
| 0x20620000 | 0x2062FFFF | Video encoding (VENC) register; 64 KB | &#10060; |
| 0x20610000 | 0x2061FFFF | Two-dimensional engine (TDE); 64 KB | &#10060; |
| 0x20600000 | 0x2060FFFF | Video process subsystem (VPSS); 64 KB | &#10060; |
| 0x205E0000 | 0x205EFFFF | IVE register; 64 KB | &#9989; IVE (reused common block) |
| 0x205C0000 | 0x205CFFFF | Video display (VDP) register; 64 KB | &#9989; VDP (generated from the data sheet) |
| 0x20580000 | 0x205BFFFF | Video capture (VICAP) register; 256 KB | &#9989; VICAP, ISP (generated from the data sheet) |
| 0x201F0000 | 0x201FFFFF | GPIO11 register; 64 KB | &#9989; GPIO11 (reused common block) |
| 0x201E0000 | 0x201EFFFF | GPIO10 register; 64 KB | &#9989; GPIO10 (reused common block) |
| 0x201D0000 | 0x201DFFFF | GPIO9 register; 64 KB | &#9989; GPIO9 (reused common block) |
| 0x201B0000 | 0x201BFFFF | GPIO7 register; 64 KB | &#9989; GPIO7 (reused common block) |
| 0x201A0000 | 0x201AFFFF | GPIO6 register; 64 KB | &#9989; GPIO6 (reused common block) |
| 0x20190000 | 0x2019FFFF | GPIO5 register; 64 KB | &#9989; GPIO5 (reused common block) |
| 0x20180000 | 0x2018FFFF | GPIO4 register; 64 KB | &#9989; GPIO4 (reused common block) |
| 0x20170000 | 0x2017FFFF | GPIO3 register; 64 KB | &#9989; GPIO3 (reused common block) |
| 0x20160000 | 0x2016FFFF | GPIO2 register; 64 KB | &#9989; GPIO2 (reused common block) |
| 0x20150000 | 0x2015FFFF | GPIO1 register; 64 KB | &#9989; GPIO1 (reused common block) |
| 0x20140000 | 0x2014FFFF | GPIO0 register; 64 KB | &#9989; GPIO0 (reused common block) |
| 0x20130000 | 0x2013FFFF | PWM0/1/2 register; 64 KB | &#9989; PWM (reused common block) |
| 0x20120000 | 0x2012FFFF | DDR_PHY register; 64 KB | &#9989; DDR_PHY (generated from the data sheet) |
| 0x20110000 | 0x2011FFFF | DDRC register; 64 KB | &#9989; DDRC (generated from the data sheet) |
| 0x200F0000 | 0x200FFFFF | IO configuration register; 64 KB | &#9989; IO_CONFIG (generated from the data sheet) |
| 0x200E0000 | 0x200EFFFF | SPI1 register; 64 KB | &#9989; SPI1 (reused common block) |
| 0x200D0000 | 0x200DFFFF | I2C register; 64 KB | &#9989; I2C (reused common block) |
| 0x200C0000 | 0x200CFFFF | SPI0 register; 64 KB | &#9989; SPI0 (reused common block) |
| 0x200B0000 | 0x200BFFFF | Successive approximation (SAR); 64 KB | &#9989; SAR_ADC (reused common block) |
| 0x200A0000 | 0x200AFFFF | UART2 register; 64 KB | &#9989; UART2 (reused common block) |
| 0x20090000 | 0x2009FFFF | UART1 register; 64 KB | &#9989; UART1 (reused common block) |
| 0x20080000 | 0x2008FFFF | UART0 register; 64 KB | &#9989; UART0 (reused common block) |
| 0x20070000 | 0x2007FFFF | IR register; 64 KB | &#9989; IR (reused common block) |
| 0x20060000 | 0x2006FFFF | RTC register; 64 KB | &#9989; RTC (reused common block) |
| 0x20050000 | 0x2005FFFF | SYS_CTRL register; 64 KB | &#9989; SYS_CTRL (generated from the data sheet) |
| 0x20040000 | 0x2004FFFF | WDG register; 64 KB | &#9989; WDG (reused common block) |
| 0x20030000 | 0x2003FFFF | CRG register; 64 KB | &#9989; CRG (generated from the data sheet) |
| 0x20010000 | 0x2001FFFF | Timer2/3 register; 64 KB | &#9989; TIMER2, TIMER3 (reused common block) |
| 0x20000000 | 0x2000FFFF | Timer0/1 register; 64 KB | &#9989; TIMER0, TIMER1 (reused common block) |
| 0x10140000 | 0x1014FFFF | Vector interrupt controller (VIC); 64 KB | &#9989; INT (reused common block) |
| 0x100D0000 | 0x100DFFFF | Direct memory access control; 64 KB | &#9989; DMAC (reused common block) |
| 0x100C0000 | 0x100CFFFF | CIPHER register; 64 KB | &#9989; CIPHER (reused common block) |
| 0x100B0000 | 0x100BFFFF | USB enhanced host controller; 64 KB | &#9989; EHCI (reused common block) |
| 0x100A0000 | 0x100AFFFF | USB open host controller interface; 64 KB | &#9989; OHCI (generated from the data sheet) |
| 0x10090000 | 0x1009FFFF | Ethernet (ETH) register; 64 KB | &#9989; ETH (reused common block) |
| 0x10040000 | 0x1004FFFF | Sonic input/output (SIO) register; 64 KB | &#9989; SIO (reused common block) |
| 0x10020000 | 0x1002FFFF | SDIO register; 64 KB | &#9989; MMC (reused common block) |
| 0x10010000 | 0x1001FFFF | SPI NOR flash register; 64 KB | &#9989; SFC (reused common block) |
| 0x00000000 | 0x03FFFFFF | During address remapping this window points to the boot ROM; after remapping is cleared it points to the on-chip RAM (64 MB) | &#10060; |

## Interrupts

Interrupt numbers of the interrupt controller (data sheet interrupt table); `Reserved` entries omitted.

| Interrupt | Source |
|-----------|--------|
| 0 | Global software interrupt |
| 1 | WDT (periphctrl0 bit 31 = 0) or COMMRX/WDT (bit 31 = 1) |
| 2 | RTC (periphctrl0 bit 31 = 0) or COMMRX/RTC (bit 31 = 1) |
| 3 | Timer0/Timer1 |
| 4 | Timer2/Timer3 |
| 5 | UART0/UART1 |
| 6 | SSP0 |
| 7 | SSP1 |
| 9 | SIO |
| 10 | Temper_Cap |
| 11 | SFC |
| 12 | ETH |
| 13 | CIPHER |
| 14 | DMAC |
| 15 | USB_EHCI |
| 16 | USB_OHCI |
| 17 | VPSS |
| 18 | SDIO |
| 19 | IR/SAR_ADC |
| 20 | I2C |
| 21 | IVE |
| 22 | VICAP |
| 23 | VOU |
| 24 | VEDU |
| 25 | UART2 |
| 26 | JPGE |
| 27 | TDE |
| 28 | MDU/DDRT |
| 29 | GPIO0/GPIO1/GPIO2/GPIO11 |
| 30 | GPIO3/GPIO4/GPIO5/GPIO10 |
| 31 | GPIO6/GPIO7/GPIO8/GPIO9 |

        <!-- overview:begin -->

        ### Diagrams

        ![Logic block diagram](assets/diagrams/hi3518ev100-logic.svg)

        ![Register blocks by function](assets/diagrams/hi3518ev100-blocks.svg)

        ![Clock tree](assets/diagrams/hi3518ev100-clocks.svg)

        ![Boot flow](assets/diagrams/hi3518ev100-boot.svg)

        ![Video pipeline](assets/diagrams/hi3518ev100-video.svg)

        ![Interrupt topology](assets/diagrams/hi3518ev100-irq.svg)

        ![Reset tree](assets/diagrams/hi3518ev100-resets.svg)

        ![Storage, USB and Ethernet paths](assets/diagrams/hi3518ev100-io.svg)

        ![DMA request lines](assets/diagrams/hi3518ev100-dma.svg)

        ![Bus masters and DDR QoS groups](assets/diagrams/hi3518ev100-busqos.svg)

        ![Power domains](assets/diagrams/hi3518ev100-power.svg)

        ![CRG register map](assets/diagrams/hi3518ev100-crgmap.svg)

        ![IP editions across the camera family](assets/diagrams/hi3518ev100-editions.svg)

        ### Camera family comparison (data sheet chapter 1)

        One column per chip, taken from the data sheets named in the header row below; `-` = the sheet gives no value. The Hi3518 sheet covers the A and C variants; the Hi3518E V200 sheet covers V200, V201 and Hi3516C V200.

        | Item | Hi3516 V100 | Hi3516C V100 | Hi3518A V100 | Hi3518C V100 | Hi3518E V100 | Hi3516C V300 | Hi3516E V100 | Hi3518E V200 | Hi3518E V201 | Hi3516C V200 |
        |---|---|---|---|---|---|---|---|---|---|---|
        | Data sheet (issue, date, language) | 00B60 2011-08-12, Chinese | 00B02 2013-02-05 | Hi3518 sheet (A and C in one document) | same document as A | 03 2015-11-26 | 05 2018-05-10 (C V300 and E V100 in one document) | same document as C V300 | 02 2017-06-12 (one document for V200, V201, Hi3516C V200) | same document | same document |
        | CPU | Cortex-A9 up to 800 MHz, VFP, 32 KB I + 32 KB D L1, 256 KB L2, about 2000 DMIPS | ARM926 up to 440 MHz, 16 KB I + 16 KB D, 2 KB ITCM | ARM926 up to 440 MHz, 16 KB I + 16 KB D, 2 KB ITCM | ARM926 up to 440 MHz, 16 KB I + 16 KB D, 2 KB ITCM | ARM926 up to 440 MHz, 16 KB I + 16 KB D | ARM926 up to 800 MHz, 32 KB I + 32 KB D | ARM926 up to 800 MHz, 32 KB I + 32 KB D | ARM926 540 MHz, 32 KB I + 32 KB D | ARM926 540 MHz, 32 KB I + 32 KB D | ARM926 600 MHz, 32 KB I + 32 KB D |
        | Interrupt controller | ARM GIC (A9 MPCore), IDs 0-31 internal | PL190 VIC | PL190 VIC | PL190 VIC | PL190 VIC | PL190 VIC | PL190 VIC | PL190 VIC | PL190 VIC | PL190 VIC |
        | DDR | DDR2/DDR3, 32 or 16 bit, up to 500 MHz, 1 GB (32 bit) / 512 MB (16 bit) | DDR2/DDR3, 16 bit, up to 440 MHz, up to 256 MB | DDR2/DDR3, 16 bit, up to 400 MHz, up to 256 MB | DDR2/DDR3, 16 bit, up to 400 MHz, up to 128 MB | embedded 16-bit DDR2, up to 512 Mbit | external 16-bit DDR3/DDR3L, up to 4 Gbit | embedded 512 Mbit DDR (1.8 V) | embedded 16-bit DDR2 512 Mbit, 360 MHz | embedded 16-bit DDR2 256 Mbit, 360 MHz | external 16-bit DDR2/DDR3/DDR3L, up to 4 Gbit, 400 MHz |
        | Boot media | NAND, SPI flash, or PCIe load into DDR | SPI NOR, NAND | SPI NOR, NAND | SPI NOR only | SPI NOR only | SPI NOR/NAND, eMMC (4-bit), serial (fastboot), SD/USB update | same as C V300 (SPI NOR/NAND, eMMC, fastboot, update) | serial (BOOTROM), SPI NOR/NAND, eMMC | same as V200 | same as V200 |
        | Flash controllers | NANDC (2 CS), SFC (2 CS) | SFC (1 CS), NANDC | SFC (1 CS), NANDC | SFC (1 CS) | SFC (1 CS) | FMC (SPI NOR/NAND), eMMC via MMC | FMC, eMMC via MMC | FMC, eMMC | FMC, eMMC | FMC, eMMC |
        | Video encoder | H.264 BP/MP/HP, MPEG4 SP, JPEG; up to 16 Mpixel | H.264 BP/MP, MJPEG/JPEG; 1080p@30 + VGA@30 + JPEG 1080p@1 | H.264 BP/MP, MJPEG/JPEG; 720p@30 + VGA@30 + QVGA@30 + JPEG 720p@1 | H.264 BP/MP, MJPEG/JPEG; 720p@30 + QVGA@30 + JPEG 720p@1 | H.264 BP/MP, MJPEG/JPEG; 720p@25 + JPEG 720p@3 | H.264 BP/MP/HP, H.265 Main, MJPEG/JPEG; 2048x2048@15 + 640x640@15, or 1080p@30 + 480p@30 + 240p@30 | same codecs; 1536x1536 (width up to 2048); 1080p@20 + 576p@20 | H.264 BP/MP/HP, MJPEG/JPEG; 1080p@20 | H.264 BP/MP/HP, MJPEG/JPEG; 960p@25 (no LDC, no 90/270 rotation) | H.264 BP/MP/HP, MJPEG/JPEG; 1080p@30 |
        | Video in | 8-16 bit RGB Bayer up to 150 MHz, BT.601/656/1120, dual sensor | 8/10/12-bit Bayer up to 74.25 MHz, BT.656/BT.1120 | 8/10/12-bit Bayer up to 74.25 MHz, BT.656/BT.1120 | 8/10/12-bit Bayer up to 74.25 MHz, BT.656/BT.1120 | 8/10/12-bit Bayer up to 74.25 MHz, BT.656/BT.1120, 1080p@30 / 720p@30 | 8-14 bit Bayer DC, BT.601/656/1120, MIPI, LVDS/sub-LVDS, HiSPi, up to 2048x2048 and 250 Mpixel/s | same as C V300 | MIPI / LVDS / HiSPi / BT.656 (VICAP) | same as V200 | same as V200, plus differential and single-ended pin modes |
        | Video out | CVBS, BT.656, BT.1120 (1080p@30) | CVBS, BT.1120 (1080p@30) | CVBS, BT.1120 | BT.1120 (no CVBS) | BT.1120 (no CVBS) | PAL/NTSC CVBS, BT.656, 6-bit RGB565 LCD | BT.656, RGB565 LCD (no CVBS) | - | - | - |
        | Ethernet | GMAC 10/100/1000, RGMII/MII | MAC 10/100, RGMII/MII | MAC 10/100, RGMII/MII | MAC 10/100, RGMII/MII | MAC 10/100, RMII/MII | MAC 10/100 RMII, TSO | MAC 10/100 RMII, TSO | MAC + internal FE PHY | MAC + internal FE PHY | MAC + internal FE PHY |
        | USB | 2 x USB 2.0 host | 1 x USB 2.0 host | 1 x USB 2.0 host | 1 x USB 2.0 host | 1 x USB 2.0 host | 1 x USB 2.0 host/device | 1 x USB 2.0 host/device | USB 2.0 host/device | USB 2.0 host/device | USB 2.0 host/device |
        | SDIO/MMC | 2 x MMC (SD/SDIO/eMMC) | 1 x SDIO 2.0 | 1 x SDIO 2.0 | 1 x SDIO 2.0 | 1 x SDIO 2.0 | 3 x SDIO 2.0 (two with 3.3/1.8 V) + eMMC 4.5 | 3 x SDIO 2.0 + eMMC 4.5 | 2 x SDIO + eMMC | 2 x SDIO + eMMC | 2 x SDIO + eMMC |
        | Package | FC-CSP 416, 15x15 mm, 0.65 mm | FCBGA 293, 13x13x1.37 mm, 0.65 mm | FCBGA 293, 13x13x1.37 mm, 0.65 mm | ePad QFP, 20x20x1.0 mm, 0.4 mm | BGA 220, 11x11 mm, 0.65 mm | TFBGA 273, 12x12 mm, 0.65 mm | TFBGA 231, 10x14 mm, 0.65 mm | TFBGA 192, 10x10 mm | TFBGA 192, 10x10 mm | TFBGA 273, 12x12 mm |
        | Typical power | 1200 mW | 850 mW | 700 mW | 700 mW (one value for the Hi3518 sheet) | 900 mW | 550 mW (1080p30) | 600 mW (1080p20) | - | - | - |
        | Core / DDR voltage | 1.0 V core; 1.8/1.5 V DDR; 2.5 V, 3.3 V | 1.2 V; 1.5/1.8 V DDR; 3.3 V I/O | 1.2 V; 1.5/1.8 V DDR; 3.3 V I/O | 1.2 V; 1.5/1.8 V DDR; 3.3 V I/O | 1.2 V; 1.8 V embedded DDR; 3.3 V I/O | 0.9 V; 1.5/1.35 V DDR; 3.3 V I/O | 0.9 V; 1.8 V DDR; 3.3 V I/O | - | - | - |
        | Chip ID (SC_SYSID) | 0x3516_0100 | 0x3518_0100 (as printed in the sheet) | 0x3518_0100 | 0x3518_0100 | 0x3518_0100 (as printed) | 0x3516_C300 | 0x3516_C300 (one value printed for both) | 0x3518E200, SCSYSID0[31:24] = 0x02 | 0x3518E200, [31:24] = 0x03 | 0x3518E200, [31:24] = 0x01 |
        | SDK kernel | - | Linux 3.0.y | Linux 3.0.y | Linux 3.0.y | Linux 3.0.y | Linux 3.18 | Linux 3.18 | - | - | - |

        Differences the data sheets state: the Hi3518C has no NAND controller, no CVBS output, no 90/270 degree rotation, no autofocus, two UARTs, no SSP/IR and 128 MB maximum DDR; the Hi3516C V100 is the Hi3518A with 1080p encoding; the Hi3518E V100 is a 720p part with embedded DDR2 and no NAND controller; the Hi3516E V100 differs from the Hi3516C V300 by embedded 512 Mbit DDR, a 231-pin package, no CVBS output, no two-frame WDR and the lower encoder limit; the Hi3518E V200/V201/Hi3516C V200 differ in CPU speed, DDR, package and encoder performance (table in the root description above).

        Chip: Hi3518E V100 (Hi3518E 720p IP Camera SoC data sheet, issue 03 (2015-11-26), chapter 1).

        ### Boot selection (data sheet 1.3 / 1.4)

        | Strap | Boot medium |
        |---|---|
        | BOOT_SEL (MDCK) pulled down | SPI NOR flash (SFC); the only boot medium named in the sheet |

        ### Memory map notes

        * The Hi3518E V100 sheet carries the same Table 1-1 layout as the Hi3518A/C (remap window at 0, SPI flash space 0x58000000, DDR window 0x80000000); the NAND space is not used (the chip has no NAND controller).

        ### DMA request lines (data sheet Table 3-24 (3-23 on the Hi3518E V100), DMAC at 0x100D0000)

        | Req | Peripheral | Req | Peripheral | Req | Peripheral | Req | Peripheral |
        |---|---|---|---|---|---|---|---|
        | 0 | SIO receive (RX) | 4 | Reserved | 8 | UART1 RX | 12 | SSP1 RX |
        | 1 | SIO transmit (TX) | 5 | Reserved | 9 | UART1 TX | 13 | SSP1 TX |
        | 2 | Reserved | 6 | UART0 RX | 10 | UART2 RX | 14 | SSP0 RX |
        | 3 | Reserved | 7 | UART0 TX | 11 | UART2 TX | 15 | SSP0 TX |

        On the Hi3518C the SSP request lines 12-15 are reserved (the sheet marks them). Channel 0 has the highest priority and channel 3 the lowest; memory-to-memory transfers should use channel 2 or 3 (the DMAC inserts an idle cycle after each bus operation on those channels).

        ### Pin multiplexing summary (generated from the IO_CONFIG registers)

        87 one-per-pin `muxctrl_regN` registers. Alternate functions per interface, as named in the register enumerations (GPIO is always one of the choices); 12 pins have no alternate function other than GPIO. Per-pin choices are in the IO_CONFIG register pages.

        | Interface | Functions |
        |---|---|
        | Serial flash (SFC / FMC) | SFC_ADDR_MODE, SFC_CLK, SFC_DIO, SFC_DOI, SFC_HOLD_IO3, SFC_WP_IO2 |
        | SD / SDIO / eMMC | SDIO_CARD_POWER_EN, SDIO_CCLK_OUT, SDIO_CCMD, SDIO_CDATA0-3, SDIO_CWPR |
        | Ethernet (MAC, MII/RMII/RGMII, MDIO, PHY clock) | EPHY_CLK, MDCK, MII_COL, MII_CRS, MII_RXCK, MII_RXD0-3, MII_RXER, MII_TXCK, MII_TXD0-3, MII_TXEN, RMII_CLK |
        | Video input (VI / VIU) | VIU_CLK, VIU_DAT0-11, VIU_HS, VIU_VS |
        | Video output (VO / LCD) | VOU1120_CLK, VOU1120_DATA0-15 |
        | Sensor control | FLASH_TRIG, SENSOR_CLK, SHUTTER_TRIG |
        | UART | UART1_CTSN, UART1_RTSN, UART1_RXD, UART1_TXD, UART2_RXD, UART2_TXD |
        | SPI / SSP | SPI0_SCLK, SPI0_SDI, SPI0_SDO, SPI1_CSN, SPI1_SCLK, SPI1_SDI, SPI1_SDO |
        | I2C | I2C_SCL, I2C_SDA |
        | PWM | PWM_OUT0, PWM_OUT1 |
        | IR, ADC, USB, JTAG | IR_IN, JTAG_TCK, JTAG_TDI, JTAG_TDO, JTAG_TMS, JTAG_TRSTN, USB_OVRCUR, USB_PWREN |
        | Boot straps and test | BOOT_SEL, CLK_TEST_OUT0-3 |
        | Other | PLL_TEST_OUT0-3, RTC_TEST_CLK, SVB_PWM, SYS_RSTN_OUT, TEMPER_DQ |

        ### Clocks (data sheet 3.2, Tables 3-2 and 3-3)

        Inputs: XIN (24 MHz crystal, PLL input only), RTC_XIN (32 kHz), VIU_CLK (video input clock), MII_RXCK / MII_TXCK (ETH). Four PLLs, two configuration registers each: APLL PERI_CRG0/1, VPLL0 PERI_CRG2/3, BPLL PERI_CRG4/5, EPLL PERI_CRG8/9 (the Hi3518E V100 sheet names the DDR clock row BPLL in its Table 3-3).

        | PLL output | Default | Feeds |
        |---|---|---|
        | APLL FOUTPOSTDIV | 440 MHz | ARM9 clock |
        | second POSTDIV row (printed as APLL; BPLL in the Hi3518E V100 sheet and Table 3-2: INFERRED) | 440 MHz | DDR clock; AXI = DDR / 2, APB = DDR / 4 |
        | VPLL0 FOUTVCO | 1188 MHz | /6 = 198 MHz VPSS and TDE; /12 = 99 MHz MDU, NFC, CIPHER (MDU and CIPHER on the Hi3518E V100) |
        | VPLL0 FOUT2 | 74.25 MHz | VDP HD |
        | EPLL FOUTVCO | 1350 MHz | /2 = 675 MHz SIO MCLK source; /6 = 225 MHz VEDU, JPGE, VAPU; /12 = 112.5 MHz SFC; 54 MHz VDP SD; 27 MHz sensor clock |

        Timer count clocks: SC_CTRL timeren0ov/1ov/2ov/3ov (bits 16, 18, 20, 22) select the reference clock (0) or the bus clock (1) for each timer pair counter. Per-IP dividers/selects and clock gates are in the CRG register pages (the gate map above).

        ### Reset and power

        * Reset sources (data sheet 3.1): the RSTN pin or the internal POR module, selected by the POR_SEL pin (RSTN low for longer than 12 XIN cycles with XIN running); the global soft reset from the system controller (sys_rst_req, deasserts after at least 360 system clocks, does not reset the CRG and test circuits); per-module soft resets xx_srst_req from the CRG (set 1 to reset, written back to 0 to release, never self-clearing).
        * Low-power: two system modes, normal and standby (slow/doze); clock gating per module, module low-power control, DDR self-refresh (DDRC_SREFCTRL); no power-domain switching is described. Typical power is 700-900 mW.

        ### Bus ports (system controller registers)

        | Bus | Masters | Slaves |
        |---|---|---|
        | SYS AXI | AHB bridge (port0), ARMD (CPU data) (port1), IVE (port2), ARMI (CPU instruction) (port3) | s1 AHB (peripheral bridge), s2 APB_SYS, s3 APB_MEDIA, s4 MDDRC (DDR controller) |
        | media AXI | VENC (port0), VPSS (port1), TDE (port2), JPGE (port3), MDU (port4) | (towards DDR) |

        Source: PERIPHCTRL5-13 (timeout, priority registers of the system bus and the media bus); priority 7 = highest on the media bus, 4 = highest on the system bus; timeout count = value x 2. The data sheets name only the bus master ports of the registers; which peripheral sits behind each AHB master port is not stated (the SYS AXI masters are arbitrated at the MDDRC slave port s4).

        ### Interrupts (ARM926 VIC source numbers, data sheet Table 3-20)

        | # | Source | # | Source | # | Source |
        |---|---|---|---|---|---|
        | 0 | Global software interrupt | 11 | SFC | 22 | VICAP |
        | 1 | WDT interrupt when periphctrl0 bit[31] is 0 | 12 | ETH | 23 | VOU |
        | 2 | RTC interrupt when periphctrl0 bit[31] is 0 | 13 | CIPHER | 24 | VEDU |
        | 3 | Timer0/Timer1 | 14 | DMAC | 25 | UART2 |
        | 4 | Timer2/Timer3 | 15 | USB_EHCI | 26 | JPGE |
        | 5 | UART0/UART1 | 16 | USB_OHCI | 27 | TDE |
        | 6 | SSP0 | 17 | VPSS | 28 | MDU/DDRT |
        | 7 | SSP1 | 18 | SDIO | 29 | GPIO0/GPIO1/GPIO2/GPIO11 |
        | 8 | Reserved | 19 | IR/SAR_ADC | 30 | GPIO3/GPIO4/GPIO5/GPIO10 |
        | 9 | SIO | 20 | I2C | 31 | GPIO6/GPIO7/GPIO8/GPIO9 |
        | 10 | Temper_Cap | 21 | IVE |  |  |

        ### Clock-gate and reset map (generated from the CRG registers)

        | Offset | Register | Description | Gate / reset fields |
        |---|---|---|---|
        | 0x028 | PERI_CRG10 | PERI_CRG10 | cpu_srst_req |
        | 0x02C | PERI_CRG11 | PERI_CRG11 | vi_hrst_req, vi1_hcken, vi_rst_req, vi_cken, isp_rst_req, isp_cken |
        | 0x034 | PERI_CRG13 | PERI_CRG13 | vo_hrst_req, vo_hd_srst_req, vo_sd_srst_req, vou_hcken, vou_hd_cken, vou_sd_cken |
        | 0x038 | PERI_CRG14 | PERI_CRG14 | pwm_srst_req, pwm_cken |
        | 0x040 | PERI_CRG16 | PERI_CRG16 | vedu_srst_req, vedu0_cken |
        | 0x048 | PERI_CRG18 | PERI_CRG18 | vps_srst_req, vps_cken |
        | 0x058 | PERI_CRG22 | PERI_CRG22 | tde_srst_req, tde_cken |
        | 0x060 | PERI_CRG24 | PERI_CRG24 | jpge_srst_req, jpge_cken |
        | 0x068 | PERI_CRG26 | PERI_CRG26 | mdu_srst_req, mdu_cken |
        | 0x06C | PERI_CRG27 | PERI_CRG27 | vapu_srst_req, vapu_cken |
        | 0x07C | PERI_CRG31 | PERI_CRG31 | cipher_srst_req, cipher_cken |
        | 0x080 | PERI_CRG32 | PERI_CRG32 | sar_adc_srst_req, sar_adc_cken |
        | 0x08C | PERI_CRG35 | PERI_CRG35 | sio_srst_req, sio_cken, adac_srst_req |
        | 0x0B8 | PERI_CRG46 | PERI_CRG46 | usb_ahb_srst_req, usb_cken |
        | 0x0C0 | PERI_CRG48 | PERI_CRG48 | sfc_srst_req, sfc_cken |
        | 0x0C4 | PERI_CRG49 | PERI_CRG49 | sdio_srst_req, sdio_cken |
        | 0x0CC | PERI_CRG51 | PERI_CRG51 | hrst_eth_s, eth_cken |
        | 0x0D8 | PERI_CRG54 | PERI_CRG54 | ddrtest_srst_req, ddrtest_cken |
        | 0x0E0 | PERI_CRG56 | PERI_CRG56 | dma_srst_req, dma_cken |
        | 0x0E4 | PERI_CRG57 | PERI_CRG57 | test_clk_en, i2c_srst_req, t_cap_srst_req, ir_srst_req, ssp0_srst_req, ssp1_srst_req, uart0_srst_req, uart1_srst_req, uart2_srst_req, ir_cken, ... |
        | 0x0F4 | PERI_CRG61 | PERI_CRG61 | osc_clk_en, osc_en |

        Only fields whose names contain a clock-enable or reset keyword are listed; the field descriptions in the register pages give the polarity and the clocks they gate.

        ### Register blocks (generated from this description)

        | Base | Instance | Block | Register space |
        |---|---|---|---|
        | 0x10010000 | SFC | System Flash Controller Registers | 1088 B |
        | 0x10020000 | MMC | HiSilicon MMC/SD/SDIO controller (DesignWare-MMC based, himciv200) | 516 B |
        | 0x10040000 | SIO | HiSilicon SIO (I2S/PCM audio interface) | 196 B |
        | 0x10090000 | ETH | HiSilicon femac v2 Fast Ethernet MAC with MDIO | 5184 B |
        | 0x100A0000 | OHCI | HiSilicon USB 2.0 host controller - OHCI | 92 B |
        | 0x100B0000 | EHCI | HiSilicon USB 2.0 host controller - EHCI | 176 B |
        | 0x100C0000 | CIPHER | CIPHER (8 channels) | 5184 B |
        | 0x100D0000 | DMAC | HiSilicon DMA controller (PL080-compatible, 4 or 8 channels) | 384 B |
        | 0x10140000 | INT | Vectored interrupt controller (ARM PrimeCell PL190) | 4 KB |
        | 0x20000000 | TIMER0 | Timer Registers | 28 B |
        | 0x20000020 | TIMER1 | Timer Registers | 28 B |
        | 0x20010000 | TIMER2 | Timer Registers | 28 B |
        | 0x20010020 | TIMER3 | Timer Registers | 28 B |
        | 0x20030000 | CRG | Clock and reset generator (CRG) | 252 B |
        | 0x20040000 | WDG | Watchdog Registers | 3076 B |
        | 0x20050000 | SYS_CTRL | System controller (SC) | 3824 B |
        | 0x20060000 | RTC | HiSilicon SPI-bridged RTC (APB registers) | 164 B |
        | 0x20060100 | RTC_INT | Internal RTC register file (device addresses reached through the RTC SPI interface, NOT memory mapped; the instance base 0x20060100 in the SoC map is a placeholder) | 81 B |
        | 0x20070000 | IR | HiSilicon IR receiver | 56 B |
        | 0x20080000 | UART0 | UART (ARM PrimeCell PL011) | 4 KB |
        | 0x20090000 | UART1 | UART (ARM PrimeCell PL011) | 4 KB |
        | 0x200A0000 | UART2 | UART (ARM PrimeCell PL011) | 4 KB |
        | 0x200B0000 | SAR_ADC | HiSilicon SAR ADC (10-bit, 2 channels, first generation) | 32 B |
        | 0x200C0000 | SPI0 | SPI Registers | 48 B |
        | 0x200D0000 | I2C | HiSilicon I2C Master Controller | 32 B |
        | 0x200E0000 | SPI1 | SPI Registers | 48 B |
        | 0x200F0000 | IO_CONFIG | Pin multiplexing registers (muxctrl_reg) | 380 B |
        | 0x20110000 | DDRC | DDR controller (DDRC) | 656 B |
        | 0x20120000 | DDR_PHY | DDR PUB PHY | 1600 B |
        | 0x20130000 | PWM | HiSilicon PWM group | 128 B |
        | 0x20140000 | GPIO0 | ARM PL061 | 1053 B |
        | 0x20150000 | GPIO1 | ARM PL061 | 1053 B |
        | 0x20160000 | GPIO2 | ARM PL061 | 1053 B |
        | 0x20170000 | GPIO3 | ARM PL061 | 1053 B |
        | 0x20180000 | GPIO4 | ARM PL061 | 1053 B |
        | 0x20190000 | GPIO5 | ARM PL061 | 1053 B |
        | 0x201A0000 | GPIO6 | ARM PL061 | 1053 B |
        | 0x201B0000 | GPIO7 | ARM PL061 | 1053 B |
        | 0x201D0000 | GPIO9 | ARM PL061 | 1053 B |
        | 0x201E0000 | GPIO10 | ARM PL061 | 1053 B |
        | 0x201F0000 | GPIO11 | ARM PL061 | 1053 B |
        | 0x20580000 | VICAP | Video capture (VICAP) | 65788 B |
        | 0x205A0000 | ISP | Image signal processor (ISP) | 3200 B |
        | 0x205C0000 | VDP | Video display processor (VDP, VOU) | 52768 B |
        | 0x205E0000 | IVE | HiSilicon intelligent video engine | 28 B |
        | 0x206C0000 | MDU | Motion Detect Unit Registers | 188 B |

        The table is generated from the elaborated root (instances at their absolute addresses; register space is the span of the block's registers, not the data sheet window).

        <!-- overview:end -->
    ";
    eHI3518EV100_IO_CONFIG     IO_CONFIG      @ 0x200F0000;
    eHI3518EV100_CRG           CRG            @ 0x20030000;
    eARM_PL190                 INT            @ 0x10140000;
    eHI3518EV100_SYS_CTRL      SYS_CTRL       @ 0x20050000;
    eHISI_DMAC                 DMAC           @ 0x100D0000;
    eHISI_CIPHER_MC            CIPHER         @ 0x100C0000;
    eHISI_TIMER_SP804          TIMER0         @ 0x20000000;
    eHISI_TIMER_SP804          TIMER1         @ 0x20000020;
    eHISI_TIMER_SP804          TIMER2         @ 0x20010000;
    eHISI_TIMER_SP804          TIMER3         @ 0x20010020;
    eHISI_WDG_SP805            WDG            @ 0x20040000;
    eHISI_RTC_SPI              RTC            @ 0x20060000;
    eHI3518EV100_RTC_INT       RTC_INT        @ 0x20060100;
    eHI3518EV100_DDRC          DDRC           @ 0x20110000;
    eHI3518EV100_DDR_PHY       DDR_PHY        @ 0x20120000;
    eHISI_SFC_350              SFC            @ 0x10010000;
    eHISI_FEMAC                ETH            @ 0x10090000;
    eMOTION_DETECT             MDU            @ 0x206C0000;
    eHISI_IVE                  IVE            @ 0x205E0000;
    eHI3518EV100_VICAP         VICAP          @ 0x20580000;
    eHI3518EV100_VDP           VDP            @ 0x205C0000;
    eHI3518EV100_ISP           ISP            @ 0x205A0000;
    eHISI_SIO                  SIO            @ 0x10040000;
    eHISI_I2C                  I2C            @ 0x200D0000;
    eHISI_SPI                  SPI0           @ 0x200C0000;
    eHISI_SPI                  SPI1           @ 0x200E0000;
    eARM_PL011                 UART0          @ 0x20080000;
    eARM_PL011                 UART1          @ 0x20090000;
    eARM_PL011                 UART2          @ 0x200A0000;
    eHISI_IR                   IR             @ 0x20070000;
    eARM_PL061                 GPIO0          @ 0x20140000;
    eARM_PL061                 GPIO1          @ 0x20150000;
    eARM_PL061                 GPIO2          @ 0x20160000;
    eARM_PL061                 GPIO3          @ 0x20170000;
    eARM_PL061                 GPIO4          @ 0x20180000;
    eARM_PL061                 GPIO5          @ 0x20190000;
    eARM_PL061                 GPIO6          @ 0x201A0000;
    eARM_PL061                 GPIO7          @ 0x201B0000;
    eARM_PL061                 GPIO9          @ 0x201D0000;
    eARM_PL061                 GPIO10         @ 0x201E0000;
    eARM_PL061                 GPIO11         @ 0x201F0000;
    eHISI_USB_EHCI             EHCI           @ 0x100B0000;
    eHISI_DWMMC                MMC            @ 0x10020000;
    eHISI_SAR_ADC              SAR_ADC        @ 0x200B0000;
    eHISI_PWM_GRP              PWM            @ 0x20130000;
    eHISI_USB_OHCI             OHCI           @ 0x100A0000;
};
