`ifndef EHI3518EV100_VICAP_RDL
`define EHI3518EV100_VICAP_RDL
regfile eHI3518EV100_VICAP {
    name = "Video capture (VICAP)";
    desc = "Video capture (VICAP). 116 registers extracted programmatically from the Hi3518E 720p IP Camera SoC data sheet (Issue 03, 2015-11-26); chapter 10.1.6, table 10-5. Field names, bit ranges, access types and reset values are taken from the register tables; reset values are the data sheet total reset values split onto the fields (per-field values where the table has them). Label: PROVEN. Hardware not verified here (no board).";
    reg {
        name = "WK_MODE";
        desc = "WK_MODE is a global working configuration register. WK_MODE (offset 0x0000, total reset 0x0000_0000; PROVEN: Hi3518E V100 data sheet, PDF page 620, section 10.1.6).";
        field {
            name = "reserved";
            desc = "Reserved.";
            sw = r; hw = na;
            reset = 0x0;
        } reserved_31_1[31:1];
        field {
            name = "power_mode";
            desc = "Clock mode.
- 0: The low-power mode is disabled.
- 1: The low-power mode is enabled.";
            sw = rw; hw = r;
            reset = 0x0;
        } power_mode[0:0];
    } WK_MODE @ 0x0;
    reg {
        name = "AXI_CFG";
        desc = "AXI_CFG is a bus configuration register. AXI_CFG (offset 0x0010, total reset 0x0000_0000; PROVEN: Hi3518E V100 data sheet, PDF page 620, section 10.1.6).";
        field {
            name = "reserved";
            desc = "Reserved.";
            sw = r; hw = na;
            reset = 0x0;
        } reserved_31_4[31:4];
        field {
            name = "m0_otd";
            desc = "Number of outstandings. The value range is 1−4.";
            sw = rw; hw = r;
            reset = 0x0;
        } m0_otd[3:0];
    } AXI_CFG @ 0x10;
    reg {
        name = "PT_SEL";
        desc = "PT_SEL is a port input select register. PT_SEL (offset 0x0020, total reset 0x0000_0000; PROVEN: Hi3518E V100 data sheet, PDF page 621, section 10.1.6).";
        field {
            name = "reserved";
            desc = "Reserved.";
            sw = r; hw = na;
            reset = 0x0;
        } reserved_31_1[31:1];
        field {
            name = "pt0_sel";
            desc = "Port input select.
- 0: external input
- 1: colorbar";
            sw = rw; hw = r;
            reset = 0x0;
        } pt0_sel[0:0];
    } PT_SEL @ 0x20;
    reg {
        name = "CH_SEL";
        desc = "CH_SEL is a channel input select register. CH_SEL (offset 0x0030, total reset 0x0000_0000; PROVEN: Hi3518E V100 data sheet, PDF page 621, section 10.1.6).";
        field {
            name = "reserved";
            desc = "Reserved.";
            sw = r; hw = na;
            reset = 0x0;
        } reserved_31_1[31:1];
        field {
            name = "ch0_sel";
            desc = "Channel input select.
- 0: ISP bypass
- 1: input from the ISP";
            sw = rw; hw = r;
            reset = 0x0;
        } ch0_sel[0:0];
    } CH_SEL @ 0x30;
    reg {
        name = "APB_TIMEOUT";
        desc = "APB_TIMEOUT is an APB timeout register. APB_TIMEOUT (offset 0x00E0, total reset 0x8000_0100; PROVEN: Hi3518E V100 data sheet, PDF page 622, section 10.1.6).";
        field {
            name = "enable";
            desc = "Timeout enable.
- 0: disabled
- 1: enabled";
            sw = rw; hw = r;
            reset = 0x1;
        } enable_[31:31];
        field {
            name = "reserved";
            desc = "Reserved.";
            sw = r; hw = na;
            reset = 0x0;
        } reserved_30_16[30:16];
        field {
            name = "timeout";
            desc = "Timeout threshold. The unit is APB clock.";
            sw = rw; hw = r;
            reset = 0x100;
        } timeout[15:0];
    } APB_TIMEOUT @ 0xe0;
    reg {
        name = "VICAP_INT";
        desc = "VICAP_INT is an interrupt indicator register. VICAP_INT (offset 0x00F0, total reset 0x0000_0000; PROVEN: Hi3518E V100 data sheet, PDF page 622, section 10.1.6).";
        field {
            name = "reserved";
            desc = "Reserved.";
            sw = r; hw = na;
            reset = 0x0;
        } reserved_31_25[31:25];
        field {
            name = "int_isp";
            desc = "ISP interrupt indicator.
- 0: No interrupt is generated.
- 1: An interrupt is generated.";
            sw = r; hw = w;
            reset = 0x0;
        } int_isp[24:24];
        field {
            name = "reserved";
            desc = "Reserved.";
            sw = r; hw = na;
            reset = 0x0;
        } reserved_23_17[23:17];
        field {
            name = "int_pt0";
            desc = "Port 0 interrupt indicator.
- 0: No interrupt is generated.
- 1: An interrupt is generated.";
            sw = r; hw = w;
            reset = 0x0;
        } int_pt0[16:16];
        field {
            name = "reserved";
            desc = "Reserved.";
            sw = r; hw = na;
            reset = 0x0;
        } reserved_15_1[15:1];
        field {
            name = "int_ch0";
            desc = "Channel 0 interrupt indicator.
- 0: No interrupt is generated.
- 1: An interrupt is generated.";
            sw = r; hw = w;
            reset = 0x0;
        } int_ch0[0:0];
    } VICAP_INT @ 0xf0;
    reg {
        name = "VICAP_INT_MASK";
        desc = "VICAP_INT_MASK is an interrupt indicator register. VICAP_INT_MASK (offset 0x00F8, total reset 0x0101_0001; PROVEN: Hi3518E V100 data sheet, PDF page 623, section 10.1.6).";
        field {
            name = "reserved";
            desc = "Reserved.";
            sw = r; hw = na;
            reset = 0x0;
        } reserved_31_25[31:25];
        field {
            name = "int_isp_en";
            desc = "ISP interrupt enable.
- 0: masked
- 1: enabled";
            sw = rw; hw = r;
            reset = 0x1;
        } int_isp_en[24:24];
        field {
            name = "reserved";
            desc = "Reserved.";
            sw = r; hw = na;
            reset = 0x0;
        } reserved_23_17[23:17];
        field {
            name = "int_pt0_en";
            desc = "Port 0 interrupt enable.
- 0: masked
- 1: enabled";
            sw = rw; hw = r;
            reset = 0x1;
        } int_pt0_en[16:16];
        field {
            name = "reserved";
            desc = "Reserved.";
            sw = r; hw = na;
            reset = 0x0;
        } reserved_15_1[15:1];
        field {
            name = "int_ch0_en";
            desc = "Channel 0 interrupt enable.
- 0: masked
- 1: enabled";
            sw = rw; hw = r;
            reset = 0x1;
        } int_ch0_en[0:0];
    } VICAP_INT_MASK @ 0xf8;
    reg {
        name = "PT_INTF_MOD";
        desc = "PT_INTF_MOD is a port mode register. PT_INTF_MOD (offset 0x0100, total reset 0x0000_0000; PROVEN: Hi3518E V100 data sheet, PDF page 624, section 10.1.6).";
        field {
            name = "enable";
            desc = "Port enable.
- 0: disabled
- 1: enabled";
            sw = rw; hw = r;
            reset = 0x0;
        } enable_[31:31];
        field {
            name = "reserved";
            desc = "Reserved.";
            sw = r; hw = na;
            reset = 0x0;
        } reserved_30_1[30:1];
        field {
            name = "mode";
            desc = "Timing mode.
- 0: external synchronization
- 1: BT.656";
            sw = rw; hw = r;
            reset = 0x0;
        } mode[0:0];
    } PT_INTF_MOD @ 0x100;
    reg {
        name = "PT_OFFSET0";
        desc = "PT_OFFSET0 is component 0 offset register. PT_OFFSET0 (offset 0x0110, total reset 0xFFF0_0000; PROVEN: Hi3518E V100 data sheet, PDF page 625, section 10.1.6).";
        field {
            name = "mask";
            desc = "Component 0 mask.";
            sw = rw; hw = r;
            reset = 0xfff0;
        } mask_[31:16];
        field {
            name = "rev";
            desc = "Whether the data line is reversed.
- 0: no
- 1: yes";
            sw = rw; hw = r;
            reset = 0x0;
        } rev[15:15];
        field {
            name = "reserved";
            desc = "Reserved.";
            sw = r; hw = na;
            reset = 0x0;
        } reserved_14_6[14:6];
        field {
            name = "offset";
            desc = "Component 0 offset.";
            sw = rw; hw = r;
            reset = 0x0;
        } offset[5:0];
    } PT_OFFSET0 @ 0x110;
    reg {
        name = "PT_OFFSET1";
        desc = "PT_OFFSET1 is component 1 offset register. PT_OFFSET1 (offset 0x0114, total reset 0xFFF0_0010; PROVEN: Hi3518E V100 data sheet, PDF page 625, section 10.1.6).";
        field {
            name = "mask";
            desc = "Component 1 mask.";
            sw = rw; hw = r;
            reset = 0xfff0;
        } mask_[31:16];
        field {
            name = "rev";
            desc = "Whether the data line is reversed.
- 0: no
- 1: yes";
            sw = rw; hw = r;
            reset = 0x0;
        } rev[15:15];
        field {
            name = "reserved";
            desc = "Reserved.";
            sw = r; hw = na;
            reset = 0x0;
        } reserved_14_6[14:6];
        field {
            name = "offset";
            desc = "Component 1 offset.";
            sw = rw; hw = r;
            reset = 0x10;
        } offset[5:0];
    } PT_OFFSET1 @ 0x114;
    reg {
        name = "PT_OFFSET2";
        desc = "PT_OFFSET2 is component 2 offset register. PT_OFFSET2 (offset 0x0118, total reset 0xFFF0_0020; PROVEN: Hi3518E V100 data sheet, PDF page 626, section 10.1.6).";
        field {
            name = "mask";
            desc = "Component 2 mask.";
            sw = rw; hw = r;
            reset = 0xfff0;
        } mask_[31:16];
        field {
            name = "rev";
            desc = "Whether the data line is reversed.
- 0: no
- 1: yes";
            sw = rw; hw = r;
            reset = 0x0;
        } rev[15:15];
        field {
            name = "reserved";
            desc = "Reserved.";
            sw = r; hw = na;
            reset = 0x0;
        } reserved_14_6[14:6];
        field {
            name = "offset";
            desc = "Component 2 offset.";
            sw = rw; hw = r;
            reset = 0x20;
        } offset[5:0];
    } PT_OFFSET2 @ 0x118;
    reg {
        name = "PT_BT656_CFG";
        desc = "PT_BT656_CFG is a BT.656 configuration register. PT_BT656_CFG (offset 0x0120, total reset 0x0000_0303; PROVEN: Hi3518E V100 data sheet, PDF page 626, section 10.1.6).";
        field {
            name = "enable";
            desc = "BT.656 enable.
- 0: disabled
- 1: enabled";
            sw = rw; hw = r;
            reset = 0x0;
        } enable_[31:31];
        field {
            name = "reserved";
            desc = "Reserved.";
            sw = r; hw = na;
            reset = 0x0;
        } reserved_30_11[30:11];
        field {
            name = "field_inv";
            desc = "Field reverse control.
- 0: not reversed
- 1: reversed";
            sw = rw; hw = r;
            reset = 0x0;
        } field_inv[10:10];
        field {
            name = "vsync_inv";
            desc = "vsync reverse control.
- 0: not reversed
- 1: reversed";
            sw = rw; hw = r;
            reset = 0x1;
        } vsync_inv[9:9];
        field {
            name = "hsync_inv";
            desc = "hsync reverse control.
- 0: not reversed
- 1: reversed";
            sw = rw; hw = r;
            reset = 0x1;
        } hsync_inv[8:8];
        field {
            name = "reserved";
            desc = "Reserved.";
            sw = r; hw = na;
            reset = 0x0;
        } reserved_7_4[7:4];
        field {
            name = "mode";
            desc = "Mode select. mode[0]
- 0: hsync is not an active signal.
- 1: hsync is an active signal. mode[1]
- 0: The hsync output is active low.
- 1: The hsync output is active high. mode[3:2]
- 00: Component 0 is parsed.
- 01: Component 1 is parsed.
- 10: Component 2 is parsed.
- 11: reserved";
            sw = rw; hw = r;
            reset = 0x3;
        } mode[3:0];
    } PT_BT656_CFG @ 0x120;
    reg {
        name = "PT_UNIFY_TIMING_CFG";
        desc = "PT_UNIFY_TIMING_CFG is a timing configuration register. PT_UNIFY_TIMING_CFG (offset 0x0130, total reset 0x0008_2801; PROVEN: Hi3518E V100 data sheet, PDF page 628, section 10.1.6).";
        field {
            name = "reserved";
            desc = "Reserved.";
            sw = r; hw = na;
            reset = 0x0;
        } reserved_31_27[31:27];
        field {
            name = "field_inv";
            desc = "Field reverse (level-1 processing for field).
- 0: not reversed
- 1: reversed";
            sw = rw; hw = r;
            reset = 0x0;
        } field_inv[26:26];
        field {
            name = "field_sel";
            desc = "Field source select (level-0 processing for field).
- 00: input field
- 01: input vsync
- 10: detected based on the relationship between vsync and hsync
- 11: 0";
            sw = rw; hw = r;
            reset = 0x0;
        } field_sel[25:24];
        field {
            name = "reserved";
            desc = "Reserved.";
            sw = r; hw = na;
            reset = 0x0;
        } reserved_23_21[23:21];
        field {
            name = "vsync_mode";
            desc = "vsync processing mode (level-2 processing for vsync).
- 00: No operation is performed.
- 01: Pulses are generated based on the rising edge.
- 10: Pulses are generated based on the rising and falling edge.
- 11: reserved";
            sw = rw; hw = r;
            reset = 0x1;
        } vsync_mode[20:19];
        field {
            name = "vsync_inv";
            desc = "vsync reverse (level-1 processing for vsync).
- 0: not reversed
- 1: reversed";
            sw = rw; hw = r;
            reset = 0x0;
        } vsync_inv[18:18];
        field {
            name = "vsync_sel";
            desc = "vsync source select (level-0 processing for vsync).
- 00: input vsync
- 01: input field
- 10: 0
- 11: reserved";
            sw = rw; hw = r;
            reset = 0x0;
        } vsync_sel[17:16];
        field {
            name = "reserved";
            desc = "Reserved.";
            sw = r; hw = na;
            reset = 0x0;
        } reserved_15_15[15:15];
        field {
            name = "hsync_mode";
            desc = "hsync processing mode (level-3 processing for hsync).
- 0: No operation is performed.
- 1: Pulses are generated based on the rising edge.";
            sw = rw; hw = r;
            reset = 0x1;
        } hsync_mode[14:13];
        field {
            name = "hsync_and";
            desc = "Whether hsync is calculated with the level-1 processing result of vsync (level-2 processing for hsync).
- 00: no operation
- 01: AND
- 10: exclusive OR
- 11: reserved";
            sw = rw; hw = r;
            reset = 0x1;
        } hsync_and[12:11];
        field {
            name = "hsync_inv";
            desc = "hsync reverse (level-1 processing for hsync).
- 0: not reversed
- 1: reversed";
            sw = rw; hw = r;
            reset = 0x0;
        } hsync_inv[10:10];
        field {
            name = "hsync_sel";
            desc = "hsync source select (level-0 processing for hsync).
- 00: input vsync
- 01: input de
- 10: 0
- 11: reserved";
            sw = rw; hw = r;
            reset = 0x0;
        } hsync_sel[9:8];
        field {
            name = "reserved";
            desc = "Reserved.";
            sw = r; hw = na;
            reset = 0x0;
        } reserved_7_3[7:3];
        field {
            name = "de_inv";
            desc = "de reverse (level-1 processing for de).
- 0: not reversed
- 1: reversed";
            sw = rw; hw = r;
            reset = 0x0;
        } de_inv[2:2];
        field {
            name = "de_sel";
            desc = "de source select (level-0 processing for de).
- 00: input de
- 01: level-2 processing result of hsync
- 10: 1
- 11: 0";
            sw = rw; hw = r;
            reset = 0x1;
        } de_sel[1:0];
    } PT_UNIFY_TIMING_CFG @ 0x130;
    reg {
        name = "PT_GEN_TIMING_CFG";
        desc = "PT_GEN_TIMING_CFG is a timing restoration module configuration register. PT_GEN_TIMING_CFG (offset 0x0134, total reset 0x0000_0000; PROVEN: Hi3518E V100 data sheet, PDF page 630, section 10.1.6).";
        field {
            name = "enable";
            desc = "Timing restoration enable. Timings are resorted based on timing parameters.
- 0: disabled
- 1: enabled";
            sw = rw; hw = r;
            reset = 0x0;
        } enable_[31:31];
        field {
            name = "reserved";
            desc = "Reserved.";
            sw = r; hw = na;
            reset = 0x0;
        } reserved_30_3[30:3];
        field {
            name = "vsync_mode";
            desc = "vsync restore.
- 0: not restored
- 1: restored";
            sw = rw; hw = r;
            reset = 0x0;
        } vsync_mode[2:2];
        field {
            name = "hsync_mode";
            desc = "hsync restore.
- 0: not restored
- 1: restored";
            sw = rw; hw = r;
            reset = 0x0;
        } hsync_mode[1:1];
        field {
            name = "reserved";
            desc = "Reserved.";
            sw = r; hw = na;
            reset = 0x0;
        } reserved_0_0[0:0];
    } PT_GEN_TIMING_CFG @ 0x134;
    reg {
        name = "PT_UNIFY_DATA_CFG";
        desc = "PT_UNIFY_DATA_CFG is a data configuration register. PT_UNIFY_DATA_CFG (offset 0x0140, total reset 0x0000_0000; PROVEN: Hi3518E V100 data sheet, PDF page 631, section 10.1.6).";
        field {
            name = "enable";
            desc = "Data separation enable.
- 0: disabled
- 1: enabled";
            sw = rw; hw = r;
            reset = 0x0;
        } enable_[31:31];
        field {
            name = "reserved";
            desc = "Reserved.";
            sw = r; hw = na;
            reset = 0x0;
        } reserved_30_4[30:4];
        field {
            name = "uv_seq";
            desc = "CbCr sequence.
- 0: CbCr
- 1: CrCb";
            sw = rw; hw = r;
            reset = 0x0;
        } uv_seq[3:3];
        field {
            name = "yc_seq";
            desc = "YC sequence.
- 0: CY
- 1: YC";
            sw = rw; hw = r;
            reset = 0x0;
        } yc_seq[2:2];
        field {
            name = "comp_num";
            desc = "Data component select.
- 00: component 1
- 01: component 2
- 10: component 3
- 11: reserved";
            sw = rw; hw = r;
            reset = 0x0;
        } comp_num[1:0];
    } PT_UNIFY_DATA_CFG @ 0x140;
    reg {
        name = "PT_GEN_DATA_CFG";
        desc = "PT_GEN_DATA_CFG is a data generation module configuration register. PT_GEN_DATA_CFG (offset 0x0144, total reset 0x0000_00E9; PROVEN: Hi3518E V100 data sheet, PDF page 632, section 10.1.6).";
        field {
            name = "enable";
            desc = "Timing restoration enable. Timings are resorted based on timing parameters.
- 0: disabled
- 1: enabled";
            sw = rw; hw = r;
            reset = 0x0;
        } enable_[31:31];
        field {
            name = "reserved";
            desc = "Reserved.";
            sw = r; hw = na;
            reset = 0x0;
        } reserved_30_8[30:8];
        field {
            name = "data2_move";
            desc = "Data 2 increment.
- 0: no increment
- 1: increment";
            sw = rw; hw = r;
            reset = 0x1;
        } data2_move[7:7];
        field {
            name = "data1_move";
            desc = "Data 1 increment.
- 0: no increment
- 1: increment";
            sw = rw; hw = r;
            reset = 0x1;
        } data1_move[6:6];
        field {
            name = "data0_move";
            desc = "Data 0 increment.
- 0: no increment
- 1: increment";
            sw = rw; hw = r;
            reset = 0x1;
        } data0_move[5:5];
        field {
            name = "vsync_reset";
            desc = "Data reset for the vsync signal.
- 0: not reset
- 1: reset";
            sw = rw; hw = r;
            reset = 0x0;
        } vsync_reset[4:4];
        field {
            name = "hsync_reset";
            desc = "Data reset for the hsync signal.
- 0: not reset
- 1: reset";
            sw = rw; hw = r;
            reset = 0x1;
        } hsync_reset[3:3];
        field {
            name = "vsync_move";
            desc = "Data increment for the vsync signal.
- 0: no increment
- 1: increment";
            sw = rw; hw = r;
            reset = 0x0;
        } vsync_move[2:2];
        field {
            name = "hsync_move";
            desc = "Data increment for the hsync signal.
- 0: no increment
- 1: increment";
            sw = rw; hw = r;
            reset = 0x0;
        } hsync_move[1:1];
        field {
            name = "de_move";
            desc = "Data increment for the de signal.
- 0: no increment
- 1: increment";
            sw = rw; hw = r;
            reset = 0x1;
        } de_move[0:0];
    } PT_GEN_DATA_CFG @ 0x144;
    reg {
        name = "PT_GEN_DATA_COEF";
        desc = "PT_GEN_DATA_COEF is a data generation module coefficient register. PT_GEN_DATA_COEF (offset 0x0148, total reset 0x0100_0100; PROVEN: Hi3518E V100 data sheet, PDF page 633, section 10.1.6).";
        field {
            name = "inc_frame";
            desc = "Pixel incremental value between frames. The incremental value is accumulated in the upper eight bits of data.";
            sw = rw; hw = r;
            reset = 0x1;
        } inc_frame[31:24];
        field {
            name = "step_frame";
            desc = "Pixel value increment interval between frames. The configured value is the actual value minus 1. The value 0 indicates that the pixel value is incremented in each frame.";
            sw = rw; hw = r;
            reset = 0x0;
        } step_frame[23:16];
        field {
            name = "inc_space";
            desc = "Data pixel incremental value. The incremental value is accumulated in the upper 10 bits of data.";
            sw = rw; hw = r;
            reset = 0x1;
        } inc_space[15:8];
        field {
            name = "step_space";
            desc = "Pixel increment interval between pixels. The value 0 indicates that the pixel value is incremented for each pixel.";
            sw = rw; hw = r;
            reset = 0x0;
        } step_space[7:0];
    } PT_GEN_DATA_COEF @ 0x148;
    reg {
        name = "PT_GEN_DATA_INIT";
        desc = "PT_GEN_DATA_INIT is a data generation module initial value register. PT_GEN_DATA_INIT (offset 0x014C, total reset 0x0000_0000; PROVEN: Hi3518E V100 data sheet, PDF page 634, section 10.1.6).";
        field {
            name = "reserved";
            desc = "Reserved.";
            sw = r; hw = na;
            reset = 0x0;
        } reserved_31_24[31:24];
        field {
            name = "data2";
            desc = "Initial V/B value.";
            sw = rw; hw = r;
            reset = 0x0;
        } data2[23:16];
        field {
            name = "data1";
            desc = "Initial U/G value.";
            sw = rw; hw = r;
            reset = 0x0;
        } data1[15:8];
        field {
            name = "data0";
            desc = "Initial Y/R value.";
            sw = rw; hw = r;
            reset = 0x0;
        } data0[7:0];
    } PT_GEN_DATA_INIT @ 0x14c;
    reg {
        name = "PT_YUV444_CFG";
        desc = "PT_YUV444_CFG is a YUV444 configuration register. PT_YUV444_CFG (offset 0x0150, total reset 0x0000_0000; PROVEN: Hi3518E V100 data sheet, PDF page 634, section 10.1.6).";
        field {
            name = "enable";
            desc = "YUV enable. YUV422 signals are converted into YUV444 signals.
- 0: disabled
- 1: enabled";
            sw = rw; hw = r;
            reset = 0x0;
        } enable_[31:31];
        field {
            name = "reserved";
            desc = "Reserved.";
            sw = r; hw = na;
            reset = 0x0;
        } reserved_30_0[30:0];
    } PT_YUV444_CFG @ 0x150;
    reg {
        name = "PT_FSTART_DLY";
        desc = "PT_FSTART_DLY is a port fstart interrupt delay register. PT_FSTART_DLY (offset 0x0160, total reset 0x0000_0000; PROVEN: Hi3518E V100 data sheet, PDF page 635, section 10.1.6).";
        field {
            name = "fstart_dly";
            desc = "Delay time. Its unit is port clock.";
            sw = rw; hw = r;
            reset = 0x0;
        } fstart_dly[31:0];
    } PT_FSTART_DLY @ 0x160;
    reg {
        name = "PT_INTF_HFB";
        desc = "PT_INTF_HFB is a horizontal front blanking width register. PT_INTF_HFB (offset 0x0180, total reset 0x0000_0010; PROVEN: Hi3518E V100 data sheet, PDF page 635, section 10.1.6).";
        field {
            name = "reserved";
            desc = "Reserved.";
            sw = r; hw = na;
            reset = 0x0;
        } reserved_31_16[31:16];
        field {
            name = "hfb";
            desc = "Horizontal front blanking width.";
            sw = rw; hw = r;
            reset = 0x10;
        } hfb[15:0];
    } PT_INTF_HFB @ 0x180;
    reg {
        name = "PT_INTF_HACT";
        desc = "PT_INTF_HACT is a horizontal active width register. PT_INTF_HACT (offset 0x0184, total reset 0x0000_0010; PROVEN: Hi3518E V100 data sheet, PDF page 635, section 10.1.6).";
        field {
            name = "reserved";
            desc = "Reserved.";
            sw = r; hw = na;
            reset = 0x0;
        } reserved_31_16[31:16];
        field {
            name = "hact";
            desc = "Horizontal active width. Its unit is clock cycle.";
            sw = rw; hw = r;
            reset = 0x10;
        } hact[15:0];
    } PT_INTF_HACT @ 0x184;
    reg {
        name = "PT_INTF_HBB";
        desc = "PT_INTF_HBB is a horizontal back blanking width register. PT_INTF_HBB (offset 0x0188, total reset 0x0000_0010; PROVEN: Hi3518E V100 data sheet, PDF page 636, section 10.1.6).";
        field {
            name = "reserved";
            desc = "Reserved.";
            sw = r; hw = na;
            reset = 0x0;
        } reserved_31_16[31:16];
        field {
            name = "hbb";
            desc = "Horizontal back blanking width.";
            sw = rw; hw = r;
            reset = 0x10;
        } hbb[15:0];
    } PT_INTF_HBB @ 0x188;
    reg {
        name = "PT_INTF_VFB";
        desc = "PT_INTF_VFB is a vertical front blanking width register. PT_INTF_VFB (offset 0x018C, total reset 0x0000_0010; PROVEN: Hi3518E V100 data sheet, PDF page 636, section 10.1.6).";
        field {
            name = "reserved";
            desc = "Reserved.";
            sw = r; hw = na;
            reset = 0x0;
        } reserved_31_16[31:16];
        field {
            name = "vfb";
            desc = "Vertical front blanking width.";
            sw = rw; hw = r;
            reset = 0x10;
        } vfb[15:0];
    } PT_INTF_VFB @ 0x18c;
    reg {
        name = "PT_INTF_VACT";
        desc = "PT_INTF_VACT is a vertical active width register. PT_INTF_VACT (offset 0x0190, total reset 0x0000_0010; PROVEN: Hi3518E V100 data sheet, PDF page 636, section 10.1.6).";
        field {
            name = "reserved";
            desc = "Reserved.";
            sw = r; hw = na;
            reset = 0x0;
        } reserved_31_16[31:16];
        field {
            name = "vact";
            desc = "Vertical active width.";
            sw = rw; hw = r;
            reset = 0x10;
        } vact[15:0];
    } PT_INTF_VACT @ 0x190;
    reg {
        name = "PT_INTF_VBB";
        desc = "PT_INTF_VBB is a vertical back blanking width register. PT_INTF_VBB (offset 0x0194, total reset 0x0000_0010; PROVEN: Hi3518E V100 data sheet, PDF page 637, section 10.1.6).";
        field {
            name = "reserved";
            desc = "Reserved.";
            sw = r; hw = na;
            reset = 0x0;
        } reserved_31_16[31:16];
        field {
            name = "vbb";
            desc = "Vertical back blanking width.";
            sw = rw; hw = r;
            reset = 0x10;
        } vbb[15:0];
    } PT_INTF_VBB @ 0x194;
    reg {
        name = "PT_INTF_VBFB";
        desc = "PT_INTF_VBFB is a vertical bottom front blanking width register. PT_INTF_VBFB (offset 0x0198, total reset 0x0000_0010; PROVEN: Hi3518E V100 data sheet, PDF page 637, section 10.1.6).";
        field {
            name = "reserved";
            desc = "Reserved.";
            sw = r; hw = na;
            reset = 0x0;
        } reserved_31_16[31:16];
        field {
            name = "vbfb";
            desc = "Vertical bottom front blanking width.";
            sw = rw; hw = r;
            reset = 0x10;
        } vbfb[15:0];
    } PT_INTF_VBFB @ 0x198;
    reg {
        name = "PT_INTF_VBACT";
        desc = "PT_INTF_VBACT is a vertical bottom active width register. PT_INTF_VBACT (offset 0x019C, total reset 0x0000_0010; PROVEN: Hi3518E V100 data sheet, PDF page 638, section 10.1.6).";
        field {
            name = "reserved";
            desc = "Reserved.";
            sw = r; hw = na;
            reset = 0x0;
        } reserved_31_16[31:16];
        field {
            name = "vact";
            desc = "Vertical bottom active width.";
            sw = rw; hw = r;
            reset = 0x10;
        } vact[15:0];
    } PT_INTF_VBACT @ 0x19c;
    reg {
        name = "PT_INTF_VBBB";
        desc = "PT_INTF_VBBB is a vertical bottom back blanking width register. PT_INTF_VBBB (offset 0x01A0, total reset 0x0000_0010; PROVEN: Hi3518E V100 data sheet, PDF page 638, section 10.1.6).";
        field {
            name = "reserved";
            desc = "Reserved.";
            sw = r; hw = na;
            reset = 0x0;
        } reserved_31_16[31:16];
        field {
            name = "vbbb";
            desc = "Vertical bottom back blanking width.";
            sw = rw; hw = r;
            reset = 0x10;
        } vbbb[15:0];
    } PT_INTF_VBBB @ 0x1a0;
    reg {
        name = "PT_FLASH_CFG";
        desc = "PT_FLASH_CFG is a camera flash configuration register. PT_FLASH_CFG (offset 0x01B0, total reset 0x0000_0000; PROVEN: Hi3518E V100 data sheet, PDF page 639, section 10.1.6).";
        field {
            name = "reserved";
            desc = "Reserved.";
            sw = r; hw = na;
            reset = 0x0;
        } reserved_31_19[31:19];
        field {
            name = "shutter_times";
            desc = "Shutter pulse times.
- 0: twice
- 1: once";
            sw = rw; hw = r;
            reset = 0x0;
        } shutter_times[18:18];
        field {
            name = "shutter_phase";
            desc = "Shutter signal reverse.
- 0: not reversed
- 1: reversed";
            sw = rw; hw = r;
            reset = 0x0;
        } shutter_phase[17:17];
        field {
            name = "shutter_en";
            desc = "Shutter enable. This field is automatically cleared.";
            sw = w; hw = r;
            reset = 0x0;
        } shutter_en[16:16];
        field {
            name = "reserved";
            desc = "Reserved.";
            sw = r; hw = na;
            reset = 0x0;
        } reserved_15_2[15:2];
        field {
            name = "flash_phase";
            desc = "Camera flash signal reverse.
- 0: not reversed
- 1: reversed";
            sw = rw; hw = r;
            reset = 0x0;
        } flash_phase[1:1];
        field {
            name = "flash_en";
            desc = "Camera flash enable. This field is automatically cleared.";
            sw = w; hw = r;
            reset = 0x0;
        } flash_en[0:0];
    } PT_FLASH_CFG @ 0x1b0;
    reg {
        name = "PT_FLASH_CYC0";
        desc = "PT_FLASH_CYC0 is flash timing 0 width register. PT_FLASH_CYC0 (offset 0x01C0, total reset 0x0000_0000; PROVEN: Hi3518E V100 data sheet, PDF page 639, section 10.1.6).";
        field {
            name = "cyc";
            desc = "Duration of flash timing 0. Its unit is port clock. The configured value is the actual value minus 1.";
            sw = rw; hw = r;
            reset = 0x0;
        } cyc[31:0];
    } PT_FLASH_CYC0 @ 0x1c0;
    reg {
        name = "PT_FLASH_CYC1";
        desc = "PT_FLASH_CYC1 is flash timing 1 width register. PT_FLASH_CYC1 (offset 0x01C4, total reset 0x0000_0000; PROVEN: Hi3518E V100 data sheet, PDF page 640, section 10.1.6).";
        field {
            name = "cyc";
            desc = "Duration of flash timing 1. Its unit is port clock. The configured value is the actual value minus 1.";
            sw = rw; hw = r;
            reset = 0x0;
        } cyc[31:0];
    } PT_FLASH_CYC1 @ 0x1c4;
    reg {
        name = "PT_SHUTTER_CYC0";
        desc = "PT_SHUTTER_CYC0 is shutter timing 0 width register. PT_SHUTTER_CYC0 (offset 0x01D0, total reset 0x0000_0000; PROVEN: Hi3518E V100 data sheet, PDF page 640, section 10.1.6).";
        field {
            name = "cyc";
            desc = "Duration of shutter timing 0. Its unit is port clock. The configured value is the actual value minus 1.";
            sw = rw; hw = r;
            reset = 0x0;
        } cyc[31:0];
    } PT_SHUTTER_CYC0 @ 0x1d0;
    reg {
        name = "PT_SHUTTER_CYC1";
        desc = "PT_SHUTTER_CYC1 is shutter timing 1 width register. PT_SHUTTER_CYC1 (offset 0x01D4, total reset 0x0000_0000; PROVEN: Hi3518E V100 data sheet, PDF page 641, section 10.1.6).";
        field {
            name = "cyc";
            desc = "Duration of shutter timing 1. Its unit is port clock. The configured value is the actual value minus 1.";
            sw = rw; hw = r;
            reset = 0x0;
        } cyc[31:0];
    } PT_SHUTTER_CYC1 @ 0x1d4;
    reg {
        name = "PT_SHUTTER_CYC2";
        desc = "PT_SHUTTER_CYC2 is shutter timing 2 width register. PT_SHUTTER_CYC2 (offset 0x01D8, total reset 0x0000_0000; PROVEN: Hi3518E V100 data sheet, PDF page 641, section 10.1.6).";
        field {
            name = "cyc";
            desc = "Duration of shutter timing 2. Its unit is port clock. The configured value is the actual value minus 1.";
            sw = rw; hw = r;
            reset = 0x0;
        } cyc[31:0];
    } PT_SHUTTER_CYC2 @ 0x1d8;
    reg {
        name = "PT_SHUTTER_CYC3";
        desc = "PT_SHUTTER_CYC3 is shutter timing 3 width register. PT_SHUTTER_CYC3 (offset 0x01DC, total reset 0x0000_0000; PROVEN: Hi3518E V100 data sheet, PDF page 641, section 10.1.6).";
        field {
            name = "cyc";
            desc = "Duration of shutter timing 3. Its unit is port clock. The configured value is the actual value minus 1.";
            sw = rw; hw = r;
            reset = 0x0;
        } cyc[31:0];
    } PT_SHUTTER_CYC3 @ 0x1dc;
    reg {
        name = "PT_STATUS";
        desc = "PT_STATUS is a port status register. PT_STATUS (offset 0x01E0, total reset 0x0000_0000; PROVEN: Hi3518E V100 data sheet, PDF page 642, section 10.1.6).";
        field {
            name = "reserved";
            desc = "Reserved.";
            sw = r; hw = na;
            reset = 0x0;
        } reserved_31_4[31:4];
        field {
            name = "field";
            desc = "Field signal output over the port.";
            sw = r; hw = w;
            reset = 0x0;
        } field_[3:3];
        field {
            name = "vysnc";
            desc = "vysnc signal output over the port.";
            sw = r; hw = w;
            reset = 0x0;
        } vysnc[2:2];
        field {
            name = "hsync";
            desc = "hsync signal output over the port.";
            sw = r; hw = w;
            reset = 0x0;
        } hsync[1:1];
        field {
            name = "de";
            desc = "de signal output over the port.";
            sw = r; hw = w;
            reset = 0x0;
        } de[0:0];
    } PT_STATUS @ 0x1e0;
    reg {
        name = "PT_BT656_STATUS";
        desc = "PT_BT656_STATUS is a BT.656 status register. PT_BT656_STATUS (offset 0x01E4, total reset 0x0000_0000; PROVEN: Hi3518E V100 data sheet, PDF page 642, section 10.1.6).";
        field {
            name = "reserved";
            desc = "Reserved.";
            sw = r; hw = na;
            reset = 0x0;
        } reserved_31_16[31:16];
        field {
            name = "seav";
            desc = "Synchronization code.";
            sw = r; hw = w;
            reset = 0x0;
        } seav[15:8];
        field {
            name = "reserved";
            desc = "Reserved.";
            sw = r; hw = na;
            reset = 0x0;
        } reserved_7_0[7:0];
    } PT_BT656_STATUS @ 0x1e4;
    reg {
        name = "PT_SIZE";
        desc = "PT_SIZE is an input size indicator register. PT_SIZE (offset 0x01EC, total reset 0x0000_0000; PROVEN: Hi3518E V100 data sheet, PDF page 643, section 10.1.6).";
        field {
            name = "height";
            desc = "Picture height. Its unit is pixel.";
            sw = r; hw = w;
            reset = 0x0;
        } height[31:16];
        field {
            name = "width";
            desc = "Picture width. Its unit is pixel.";
            sw = r; hw = w;
            reset = 0x0;
        } width[15:0];
    } PT_SIZE @ 0x1ec;
    reg {
        name = "PT_INT";
        desc = "PT_INT is a channel interrupt indicator register. PT_INT (offset 0x01F0, total reset 0x0000_0000; PROVEN: Hi3518E V100 data sheet, PDF page 643, section 10.1.6).";
        field {
            name = "reserved";
            desc = "Reserved.";
            sw = r; hw = na;
            reset = 0x0;
        } reserved_31_3[31:3];
        field {
            name = "height_err";
            desc = "Status of the picture height change interrupt. Writing 1 clears the status.
- 0: No interrupt is generated.
- 1: An interrupt is generated. (data sheet access type WC)";
            sw = rw; hw = r; onwrite = woclr;
            reset = 0x0;
        } height_err[2:2];
        field {
            name = "width_err";
            desc = "Status of the picture width change interrupt. Writing 1 clears the status.
- 0: No interrupt is generated.
- 1: An interrupt is generated. (data sheet access type WC)";
            sw = rw; hw = r; onwrite = woclr;
            reset = 0x0;
        } width_err[1:1];
        field {
            name = "fstart";
            desc = "Status of the field/frame start interrupt. Writing 1 clears the status.
- 0: No interrupt is generated.
- 1: An interrupt is generated. (data sheet access type WC)";
            sw = rw; hw = r; onwrite = woclr;
            reset = 0x0;
        } fstart[0:0];
    } PT_INT @ 0x1f0;
    reg {
        name = "PT_INT_MASK";
        desc = "PT_INT_MASK is a channel interrupt mask register. PT_INT_MASK (offset 0x01F8, total reset 0x0000_0000; PROVEN: Hi3518E V100 data sheet, PDF page 644, section 10.1.6).";
        field {
            name = "reserved";
            desc = "Reserved.";
            sw = r; hw = na;
            reset = 0x0;
        } reserved_31_3[31:3];
        field {
            name = "height_err_en";
            desc = "Picture height change interrupt enable.
- 0: masked
- 1: enabled";
            sw = rw; hw = r;
            reset = 0x0;
        } height_err_en[2:2];
        field {
            name = "width_err_en";
            desc = "Picture width change interrupt enable.
- 0: masked
- 1: enabled";
            sw = rw; hw = r;
            reset = 0x0;
        } width_err_en[1:1];
        field {
            name = "fstart_en";
            desc = "Frame/Field start interrupt enable.
- 0: masked
- 1: enabled";
            sw = rw; hw = r;
            reset = 0x0;
        } fstart_en[0:0];
    } PT_INT_MASK @ 0x1f8;
    reg {
        name = "CH_CTRL";
        desc = "CH_CTRL is a channel control register. CH_CTRL (offset 0x1000, total reset 0x0000_0000; PROVEN: Hi3518E V100 data sheet, PDF page 645, section 10.1.6).";
        field {
            name = "enable";
            desc = "Channel enable.
- 0: disabled
- 1: enabled 0x1000–0x1FFF indicates the channel address range.";
            sw = rw; hw = r;
            reset = 0x0;
        } enable_[31:31];
        field {
            name = "reserved";
            desc = "Reserved.";
            sw = r; hw = na;
            reset = 0x0;
        } reserved_30_0[30:0];
    } CH_CTRL @ 0x1000;
    reg {
        name = "CH_REG_NEWER";
        desc = "CH_REG_NEWER is a capture control register. CH_REG_NEWER (offset 0x1004, total reset 0x0000_0000; PROVEN: Hi3518E V100 data sheet, PDF page 645, section 10.1.6).";
        field {
            name = "reserved";
            desc = "Reserved.";
            sw = r; hw = na;
            reset = 0x0;
        } reserved_31_1[31:1];
        field {
            name = "reg_newer";
            desc = "Channel updated. This bit is automatically cleared when a frame is received.";
            sw = rw; hw = r;
            reset = 0x0;
        } reg_newer[0:0];
    } CH_REG_NEWER @ 0x1004;
    reg {
        name = "CH_ADAPTER_CFG";
        desc = "CH_ADAPTER_CFG is a timing adaptation register. CH_ADAPTER_CFG (offset 0x1010, total reset 0x0000_0003; PROVEN: Hi3518E V100 data sheet, PDF page 646, section 10.1.6).";
        field {
            name = "reserved";
            desc = "Reserved.";
            sw = r; hw = na;
            reset = 0x0;
        } reserved_31_2[31:2];
        field {
            name = "vsync_mode";
            desc = "Delay processing for the vsync signal.
- 0: no delay
- 1: delay";
            sw = rw; hw = r;
            reset = 0x1;
        } vsync_mode[1:1];
        field {
            name = "hsync_mode";
            desc = "Delay processing for the hsync signal.
- 0: no delay
- 1: delay";
            sw = rw; hw = r;
            reset = 0x1;
        } hsync_mode[0:0];
    } CH_ADAPTER_CFG @ 0x1010;
    reg {
        name = "CH_PACK_Y_CFG";
        desc = "CH_PACK_Y_CFG is a Y component control register for the PACK module. CH_PACK_Y_CFG (offset 0x1080, total reset 0x0000_0008; PROVEN: Hi3518E V100 data sheet, PDF page 646, section 10.1.6).";
        field {
            name = "mode";
            desc = "PACK mode.
- 00: normal mode
- 11: mirror mode

Other values: reserved";
            sw = rw; hw = r;
            reset = 0x0;
        } mode[31:30];
        field {
            name = "reserved";
            desc = "Reserved.";
            sw = r; hw = na;
            reset = 0x0;
        } reserved_29_8[29:8];
        field {
            name = "bitw";
            desc = "Data bit width.
- 0x8: 8 bits
- 0xC: 12 bits
- 0x10: 16 bits

Other values: reserved";
            sw = rw; hw = r;
            reset = 0x8;
        } bitw[7:0];
    } CH_PACK_Y_CFG @ 0x1080;
    reg {
        name = "CH_PACK_Y_WIDTH";
        desc = "CH_PACK_Y_WIDTH is a Y component input width register for the PACK module. CH_PACK_Y_WIDTH (offset 0x1084, total reset 0x0000_27FF; PROVEN: Hi3518E V100 data sheet, PDF page 647, section 10.1.6).";
        field {
            name = "reserved";
            desc = "Reserved.";
            sw = r; hw = na;
            reset = 0x0;
        } reserved_31_20[31:20];
        field {
            name = "width";
            desc = "Number of input bits of the PACK module. The configured value is the actual value minus 1.";
            sw = rw; hw = r;
            reset = 0x27ff;
        } width[19:0];
    } CH_PACK_Y_WIDTH @ 0x1084;
    reg {
        name = "CH_PACK_C_CFG";
        desc = "CH_PACK_C_CFG is a C component control register for the PACK module. CH_PACK_C_CFG (offset 0x1090, total reset 0x0000_0010; PROVEN: Hi3518E V100 data sheet, PDF page 648, section 10.1.6).";
        field {
            name = "mode";
            desc = "PACK mode.
- 00: normal mode
- 11: mirror mode

Other values: reserved";
            sw = rw; hw = r;
            reset = 0x0;
        } mode[31:30];
        field {
            name = "reserved";
            desc = "Reserved.";
            sw = r; hw = na;
            reset = 0x0;
        } reserved_29_8[29:8];
        field {
            name = "bitw";
            desc = "Data bit width.
- 0x10: 8 bits

Other values: reserved";
            sw = rw; hw = r;
            reset = 0x10;
        } bitw[7:0];
    } CH_PACK_C_CFG @ 0x1090;
    reg {
        name = "CH_PACK_C_WIDTH";
        desc = "CH_PACK_C_WIDTH is a C component input width register for the PACK module. CH_PACK_C_WIDTH (offset 0x1094, total reset 0x0000_27FF; PROVEN: Hi3518E V100 data sheet, PDF page 648, section 10.1.6).";
        field {
            name = "reserved";
            desc = "Reserved.";
            sw = r; hw = na;
            reset = 0x0;
        } reserved_31_20[31:20];
        field {
            name = "width";
            desc = "Number of input bits of the PACK module. The configured value is the actual value minus 1.";
            sw = rw; hw = r;
            reset = 0x27ff;
        } width[19:0];
    } CH_PACK_C_WIDTH @ 0x1094;
    reg {
        name = "CH_DES_Y_CFG";
        desc = "CH_DES_Y_CFG is a Y component configuration register for the DES module. CH_DES_Y_CFG (offset 0x10B0, total reset 0x003F_0800; PROVEN: Hi3518E V100 data sheet, PDF page 649, section 10.1.6).";
        field {
            name = "buf_len";
            desc = "Buffer size of the DES module. Its unit is 128 bits and it must be an integral multiple of 16. The configured value is the actual value minus 1.";
            sw = rw; hw = r;
            reset = 0x3f;
        } buf_len[31:16];
        field {
            name = "dis";
            desc = "Minimum interval between two consecutive bus requests. Its unit is channel clock.";
            sw = rw; hw = r;
            reset = 0x8;
        } dis[15:8];
        field {
            name = "reserved";
            desc = "Reserved.";
            sw = r; hw = na;
            reset = 0x0;
        } reserved_7_2[7:2];
        field {
            name = "flip";
            desc = "Flip enable.
- 0: disabled
- 1: enabled";
            sw = rw; hw = r;
            reset = 0x0;
        } flip[1:1];
        field {
            name = "mirror";
            desc = "Mirror enable.
- 0: disabled
- 1: enabled";
            sw = rw; hw = r;
            reset = 0x0;
        } mirror[0:0];
    } CH_DES_Y_CFG @ 0x10b0;
    reg {
        name = "CH_DES_Y_FADDR";
        desc = "CH_DES_Y_FADDR is a Y component storage base address register. CH_DES_Y_FADDR (offset 0x10B4, total reset 0x0000_0000; PROVEN: Hi3518E V100 data sheet, PDF page 649, section 10.1.6).";
        field {
            name = "faddr";
            desc = "Base address for storing the Y component in raw streams.";
            sw = rw; hw = r;
            reset = 0x0;
        } faddr[31:0];
    } CH_DES_Y_FADDR @ 0x10b4;
    reg {
        name = "CH_DES_Y_SIZE";
        desc = "CH_DES_Y_SIZE is a Y component storage size register. CH_DES_Y_SIZE (offset 0x10B8, total reset 0x02CF_004F; PROVEN: Hi3518E V100 data sheet, PDF page 650, section 10.1.6).";
        field {
            name = "height";
            desc = "Y component output height. Its unit is line. The configured value is the actual value minus 1.";
            sw = rw; hw = r;
            reset = 0x2cf;
        } height[31:16];
        field {
            name = "reserved";
            desc = "Reserved.";
            sw = r; hw = na;
            reset = 0x0;
        } reserved_15_12[15:12];
        field {
            name = "width";
            desc = "Y component output width. Its unit is 128 bits. The configured value is the actual value minus 1.";
            sw = rw; hw = r;
            reset = 0x4f;
        } width[11:0];
    } CH_DES_Y_SIZE @ 0x10b8;
    reg {
        name = "CH_DES_Y_STRIDE";
        desc = "CH_DES_Y_STRIDE is a Y component stride register. CH_DES_Y_STRIDE (offset 0x10BC, total reset 0x0000_0500; PROVEN: Hi3518E V100 data sheet, PDF page 650, section 10.1.6).";
        field {
            name = "reserved";
            desc = "Reserved.";
            sw = r; hw = na;
            reset = 0x0;
        } reserved_31_16[31:16];
        field {
            name = "stride";
            desc = "Stride for storing the Y component. Its unit is byte.";
            sw = rw; hw = r;
            reset = 0x500;
        } stride[15:0];
    } CH_DES_Y_STRIDE @ 0x10bc;
    reg {
        name = "CH_DES_C_CFG";
        desc = "CH_DES_C_CFG is a C component configuration register for the DES module. CH_DES_C_CFG (offset 0x10C0, total reset 0x003F_0800; PROVEN: Hi3518E V100 data sheet, PDF page 651, section 10.1.6).";
        field {
            name = "buf_len";
            desc = "Buffer size of the DES module. Its unit is 128 bits and it must be an integral multiple of 16. The configured value is the actual value minus 1.";
            sw = rw; hw = r;
            reset = 0x3f;
        } buf_len[31:16];
        field {
            name = "dis";
            desc = "Minimum interval between two consecutive bus requests. Its unit is channel clock.";
            sw = rw; hw = r;
            reset = 0x8;
        } dis[15:8];
        field {
            name = "reserved";
            desc = "Reserved.";
            sw = r; hw = na;
            reset = 0x0;
        } reserved_7_2[7:2];
        field {
            name = "flip";
            desc = "Flip enable.
- 0: disabled
- 1: enabled";
            sw = rw; hw = r;
            reset = 0x0;
        } flip[1:1];
        field {
            name = "mirror";
            desc = "Mirror enable.
- 0: disabled
- 1: enabled";
            sw = rw; hw = r;
            reset = 0x0;
        } mirror[0:0];
    } CH_DES_C_CFG @ 0x10c0;
    reg {
        name = "CH_DES_C_FADDR";
        desc = "CH_DES_C_FADDR is a C component storage base address register. CH_DES_C_FADDR (offset 0x10C4, total reset 0x0000_0000; PROVEN: Hi3518E V100 data sheet, PDF page 651, section 10.1.6).";
        field {
            name = "faddr";
            desc = "Base address for storing the C component in raw streams.";
            sw = rw; hw = r;
            reset = 0x0;
        } faddr[31:0];
    } CH_DES_C_FADDR @ 0x10c4;
    reg {
        name = "CH_DES_C_SIZE";
        desc = "CH_DES_C_SIZE is a C component storage size register. CH_DES_C_SIZE (offset 0x10C8, total reset 0x02CF_004F; PROVEN: Hi3518E V100 data sheet, PDF page 652, section 10.1.6).";
        field {
            name = "height";
            desc = "C component output height. Its unit is line. The configured value is the actual value minus 1.";
            sw = rw; hw = r;
            reset = 0x2cf;
        } height[31:16];
        field {
            name = "reserved";
            desc = "Reserved.";
            sw = r; hw = na;
            reset = 0x0;
        } reserved_15_12[15:12];
        field {
            name = "width";
            desc = "C component output width. Its unit is 128 bits. The configured value is the actual value minus 1.";
            sw = rw; hw = r;
            reset = 0x4f;
        } width[11:0];
    } CH_DES_C_SIZE @ 0x10c8;
    reg {
        name = "CH_DES_C_STRIDE";
        desc = "CH_DES_C_STRIDE is a C component stride register. CH_DES_C_STRIDE (offset 0x10CC, total reset 0x0000_0500; PROVEN: Hi3518E V100 data sheet, PDF page 652, section 10.1.6).";
        field {
            name = "reserved";
            desc = "Reserved.";
            sw = r; hw = na;
            reset = 0x0;
        } reserved_31_16[31:16];
        field {
            name = "stride";
            desc = "Stride for storing the C component. Its unit is byte.";
            sw = rw; hw = r;
            reset = 0x500;
        } stride[15:0];
    } CH_DES_C_STRIDE @ 0x10cc;
    reg {
        name = "CH_INT";
        desc = "CH_INT is a channel raw interrupt register. CH_INT (offset 0x10F0, total reset 0x0000_0000; PROVEN: Hi3518E V100 data sheet, PDF page 653, section 10.1.6).";
        field {
            name = "reserved";
            desc = "Reserved.";
            sw = r; hw = na;
            reset = 0x0;
        } reserved_31_7[31:7];
        field {
            name = "bus_err_y";
            desc = "Status of the Y data channel bus error interrupt. Writing 1 clears the status.
- 0: No interrupt is generated.
- 1: An interrupt is generated. (data sheet access type WC)";
            sw = rw; hw = r; onwrite = woclr;
            reset = 0x0;
        } bus_err_y[6:6];
        field {
            name = "bus_err_c";
            desc = "Status of the C data channel bus error interrupt. Writing 1 clears the status.
- 0: No interrupt is generated.
- 1: An interrupt is generated. (data sheet access type WC)";
            sw = rw; hw = r; onwrite = woclr;
            reset = 0x0;
        } bus_err_c[5:5];
        field {
            name = "update_cfg";
            desc = "Status of the register update interrupt. Writing 1 clears the status.
- 0: No interrupt is generated.
- 1: An interrupt is generated. (data sheet access type WC)";
            sw = rw; hw = r; onwrite = woclr;
            reset = 0x0;
        } update_cfg[4:4];
        field {
            name = "field_throw";
            desc = "Status of the field/frame loss interrupt. Writing 1 clears the status.
- 0: No interrupt is generated.
- 1: An interrupt is generated. (data sheet access type WC)";
            sw = rw; hw = r; onwrite = woclr;
            reset = 0x0;
        } field_throw[3:3];
        field {
            name = "buf_ovf";
            desc = "Status of the internal FIFO overflow error interrupt. Writing 1 clears the status.
- 0: No interrupt is generated.
- 1: An interrupt is generated. (data sheet access type WC)";
            sw = rw; hw = r; onwrite = woclr;
            reset = 0x0;
        } buf_ovf[2:2];
        field {
            name = "cc_int";
            desc = "Status of the capture completion interrupt. Writing 1 clears the status.
- 0: No interrupt is generated.
- 1: An interrupt is generated. (data sheet access type WC)";
            sw = rw; hw = r; onwrite = woclr;
            reset = 0x0;
        } cc_int[1:1];
        field {
            name = "fstart";
            desc = "Status of the field/frame start interrupt. Writing 1 clears the status.
- 0: No interrupt is generated.
- 1: An interrupt is generated. (data sheet access type WC)";
            sw = rw; hw = r; onwrite = woclr;
            reset = 0x0;
        } fstart[0:0];
    } CH_INT @ 0x10f0;
    reg {
        name = "CH_INT_MASK";
        desc = "CH_INT_MASK is a channel interrupt mask register. CH_INT_MASK (offset 0x10F8, total reset 0x0000_0000; PROVEN: Hi3518E V100 data sheet, PDF page 654, section 10.1.6).";
        field {
            name = "reserved";
            desc = "Reserved.";
            sw = r; hw = na;
            reset = 0x0;
        } reserved_31_7[31:7];
        field {
            name = "bus_err_y_en";
            desc = "Y data channel bus error interrupt enable.
- 0: masked
- 1: enabled";
            sw = rw; hw = r;
            reset = 0x0;
        } bus_err_y_en[6:6];
        field {
            name = "bus_err_c_en";
            desc = "C data channel bus error interrupt enable.
- 0: masked
- 1: enabled";
            sw = rw; hw = r;
            reset = 0x0;
        } bus_err_c_en[5:5];
        field {
            name = "update_cfg";
            desc = "Register update interrupt enable.
- 0: masked
- 1: enabled";
            sw = rw; hw = r;
            reset = 0x0;
        } update_cfg[4:4];
        field {
            name = "field_throw_en";
            desc = "Field/Frame loss interrupt enable.
- 0: masked
- 1: enabled";
            sw = rw; hw = r;
            reset = 0x0;
        } field_throw_en[3:3];
        field {
            name = "buf_ovf_en";
            desc = "Internal FIFO overflow error interrupt enable.
- 0: masked
- 1: enabled";
            sw = rw; hw = r;
            reset = 0x0;
        } buf_ovf_en[2:2];
        field {
            name = "cc_int_en";
            desc = "Capture completion interrupt enable.
- 0: masked
- 1: enabled";
            sw = rw; hw = r;
            reset = 0x0;
        } cc_int_en[1:1];
        field {
            name = "fstart_en";
            desc = "Field/Frame start interrupt enable.
- 0: masked
- 1: enabled";
            sw = rw; hw = r;
            reset = 0x0;
        } fstart_en[0:0];
    } CH_INT_MASK @ 0x10f8;
    reg {
        name = "CH_CROP_CFG";
        desc = "CH_CROP_CFG is a crop enable register. CH_CROP_CFG (offset 0x1100, total reset 0x0000_0000; PROVEN: Hi3518E V100 data sheet, PDF page 655, section 10.1.6).";
        field {
            name = "reserved";
            desc = "Reserved.";
            sw = r; hw = na;
            reset = 0x0;
        } reserved_31_1[31:1];
        field {
            name = "n0_en";
            desc = "Region 0 enable.";
            sw = rw; hw = r;
            reset = 0x0;
        } n0_en[0:0];
    } CH_CROP_CFG @ 0x1100;
    reg {
        name = "CH_CROP_WIN";
        desc = "CH_CROP_WIN is a crop window register. CH_CROP_WIN (offset 0x1104, total reset 0xFFFF_FFFF; PROVEN: Hi3518E V100 data sheet, PDF page 655, section 10.1.6).";
        field {
            name = "height";
            desc = "Window height. Its unit is pixel. The configured value is the actual value minus 1.";
            sw = rw; hw = r;
            reset = 0xffff;
        } height[31:16];
        field {
            name = "width";
            desc = "Window width. Its unit is pixel. The configured value is the actual value minus 1.";
            sw = rw; hw = r;
            reset = 0xffff;
        } width[15:0];
    } CH_CROP_WIN @ 0x1104;
    reg {
        name = "CH_CROP0_START";
        desc = "CH_CROP0_START is a crop start position register for region 0. CH_CROP0_START (offset 0x1110, total reset 0x0000_0000; PROVEN: Hi3518E V100 data sheet, PDF page 656, section 10.1.6).";
        field {
            name = "y_start";
            desc = "Number of the line from which pictures start to be captured.";
            sw = rw; hw = r;
            reset = 0x0;
        } y_start[31:16];
        field {
            name = "x_start";
            desc = "Number of the pixel from which pictures start to be captured.";
            sw = rw; hw = r;
            reset = 0x0;
        } x_start[15:0];
    } CH_CROP0_START @ 0x1110;
    reg {
        name = "CH_CROP0_SIZE";
        desc = "CH_CROP0_SIZE is a crop size configuration register for region 0. CH_CROP0_SIZE (offset 0x1114, total reset 0xFFFF_FFFF; PROVEN: Hi3518E V100 data sheet, PDF page 656, section 10.1.6).";
        field {
            name = "height";
            desc = "Height of the captured picture. Its unit is line. The configured value is the actual value minus 1.";
            sw = rw; hw = r;
            reset = 0xffff;
        } height[31:16];
        field {
            name = "width";
            desc = "Width of a line in the captured picture. Its unit is pixel. The configured value is the actual value minus 1.";
            sw = rw; hw = r;
            reset = 0xffff;
        } width[15:0];
    } CH_CROP0_SIZE @ 0x1114;
    reg {
        name = "CH_CSC_CFG";
        desc = "CH_CSC_CFG is a CSC configuration register. CH_CSC_CFG (offset 0x1200, total reset 0x0000_0000; PROVEN: Hi3518E V100 data sheet, PDF page 657, section 10.1.6).";
        field {
            name = "enable";
            desc = "CSC enable.
- 0: disabled
- 1: enabled";
            sw = rw; hw = r;
            reset = 0x0;
        } enable_[31:31];
        field {
            name = "reserved";
            desc = "Reserved.";
            sw = r; hw = na;
            reset = 0x0;
        } reserved_30_0[30:0];
    } CH_CSC_CFG @ 0x1200;
    reg {
        name = "CH_CSC_COEF0";
        desc = "CH_CSC_COEF0 is CSC coefficient register 0. CH_CSC_COEF0 (offset 0x1210, total reset 0x0000_0000; PROVEN: Hi3518E V100 data sheet, PDF page 657, section 10.1.6).";
        field {
            name = "coef01";
            desc = "CSC coefficient. Its format is (s, 4, 8). The value consists of a 1-bit signed part, a 4- bit integral part, and an 8-bit fractional part.";
            sw = rw; hw = r;
            reset = 0x0;
        } coef01[31:19];
        field {
            name = "reserved";
            desc = "Reserved.";
            sw = r; hw = na;
            reset = 0x0;
        } reserved_18_16[18:16];
        field {
            name = "coef00";
            desc = "CSC coefficient. Its format is (s, 4, 8). The value consists of a 1-bit signed part, a 4- bit integral part, and an 8-bit fractional part.";
            sw = rw; hw = r;
            reset = 0x0;
        } coef00[15:3];
        field {
            name = "reserved";
            desc = "Reserved.";
            sw = r; hw = na;
            reset = 0x0;
        } reserved_2_0[2:0];
    } CH_CSC_COEF0 @ 0x1210;
    reg {
        name = "CH_CSC_COEF1";
        desc = "CH_CSC_COEF1 is CSC coefficient register 1. CH_CSC_COEF1 (offset 0x1214, total reset 0x0000_0000; PROVEN: Hi3518E V100 data sheet, PDF page 658, section 10.1.6).";
        field {
            name = "coef10";
            desc = "CSC coefficient. Its format is (s, 4, 8). The value consists of a 1-bit signed part, a 4- bit integral part, and an 8-bit fractional part.";
            sw = rw; hw = r;
            reset = 0x0;
        } coef10[31:19];
        field {
            name = "reserved";
            desc = "Reserved.";
            sw = r; hw = na;
            reset = 0x0;
        } reserved_18_16[18:16];
        field {
            name = "coef02";
            desc = "CSC coefficient. Its format is (s, 4, 8). The value consists of a 1-bit signed part, a 4- bit integral part, and an 8-bit fractional part.";
            sw = rw; hw = r;
            reset = 0x0;
        } coef02[15:3];
        field {
            name = "reserved";
            desc = "Reserved.";
            sw = r; hw = na;
            reset = 0x0;
        } reserved_2_0[2:0];
    } CH_CSC_COEF1 @ 0x1214;
    reg {
        name = "CH_CSC_COEF2";
        desc = "CH_CSC_COEF2 is CSC coefficient register 2. CH_CSC_COEF2 (offset 0x1218, total reset 0x0000_0000; PROVEN: Hi3518E V100 data sheet, PDF page 658, section 10.1.6).";
        field {
            name = "coef12";
            desc = "CSC coefficient. Its format is (s, 4, 8). The value consists of a 1-bit signed part, a 4- bit integral part, and an 8-bit fractional part.";
            sw = rw; hw = r;
            reset = 0x0;
        } coef12[31:19];
        field {
            name = "reserved";
            desc = "Reserved.";
            sw = r; hw = na;
            reset = 0x0;
        } reserved_18_16[18:16];
        field {
            name = "coef11";
            desc = "CSC coefficient. Its format is (s, 4, 8). The value consists of a 1-bit signed part, a 4- bit integral part, and an 8-bit fractional part.";
            sw = rw; hw = r;
            reset = 0x0;
        } coef11[15:3];
        field {
            name = "reserved";
            desc = "Reserved.";
            sw = r; hw = na;
            reset = 0x0;
        } reserved_2_0[2:0];
    } CH_CSC_COEF2 @ 0x1218;
    reg {
        name = "CH_CSC_COEF3";
        desc = "CH_CSC_COEF3 is CSC coefficient register 3. CH_CSC_COEF3 (offset 0x121C, total reset 0x0000_0000; PROVEN: Hi3518E V100 data sheet, PDF page 659, section 10.1.6).";
        field {
            name = "coef21";
            desc = "CSC coefficient. Its format is (s, 4, 8). The value consists of a 1-bit signed part, a 4- bit integral part, and an 8-bit fractional part.";
            sw = rw; hw = r;
            reset = 0x0;
        } coef21[31:19];
        field {
            name = "reserved";
            desc = "Reserved.";
            sw = r; hw = na;
            reset = 0x0;
        } reserved_18_16[18:16];
        field {
            name = "coef20";
            desc = "CSC coefficient. Its format is (s, 4, 8). The value consists of a 1-bit signed part, a 4- bit integral part, and an 8-bit fractional part.";
            sw = rw; hw = r;
            reset = 0x0;
        } coef20[15:3];
        field {
            name = "reserved";
            desc = "Reserved.";
            sw = r; hw = na;
            reset = 0x0;
        } reserved_2_0[2:0];
    } CH_CSC_COEF3 @ 0x121c;
    reg {
        name = "CH_CSC_COEF4";
        desc = "CH_CSC_COEF4 is CSC coefficient register 4. CH_CSC_COEF4 (offset 0x1220, total reset 0x0000_0000; PROVEN: Hi3518E V100 data sheet, PDF page 660, section 10.1.6).";
        field {
            name = "reserved";
            desc = "CSC coefficient. Its format is (s, 4, 8). The value consists of a 1-bit signed part, a 4- bit integral part, and an 8-bit fractional part.";
            sw = rw; hw = r;
            reset = 0x0;
        } reserved_31_19[31:19];
        field {
            name = "reserved";
            desc = "Reserved.";
            sw = r; hw = na;
            reset = 0x0;
        } reserved_18_16[18:16];
        field {
            name = "coef22";
            desc = "CSC coefficient. Its format is (s, 4, 8). The value consists of a 1-bit signed part, a 4- bit integral part, and an 8-bit fractional part.";
            sw = rw; hw = r;
            reset = 0x0;
        } coef22[15:3];
        field {
            name = "reserved";
            desc = "Reserved.";
            sw = r; hw = na;
            reset = 0x0;
        } reserved_2_0[2:0];
    } CH_CSC_COEF4 @ 0x1220;
    reg {
        name = "CH_CSC_IN_DC0";
        desc = "CH_CSC_IN_DC0 is CSC input DC component register 0. CH_CSC_IN_DC0 (offset 0x1230, total reset 0x0000_0000; PROVEN: Hi3518E V100 data sheet, PDF page 660, section 10.1.6).";
        field {
            name = "in_dc1";
            desc = "DC offset of the input G component. It is a signed integer.";
            sw = rw; hw = r;
            reset = 0x0;
        } in_dc1[31:21];
        field {
            name = "reserved";
            desc = "Reserved.";
            sw = r; hw = na;
            reset = 0x0;
        } reserved_20_16[20:16];
        field {
            name = "in_dc0";
            desc = "DC offset of the input R component. It is a signed integer.";
            sw = rw; hw = r;
            reset = 0x0;
        } in_dc0[15:5];
        field {
            name = "reserved";
            desc = "Reserved.";
            sw = r; hw = na;
            reset = 0x0;
        } reserved_4_0[4:0];
    } CH_CSC_IN_DC0 @ 0x1230;
    reg {
        name = "CH_CSC_IN_DC1";
        desc = "CH_CSC_IN_DC1 is CSC input DC component register 1. CH_CSC_IN_DC1 (offset 0x1234, total reset 0x0000_0000; PROVEN: Hi3518E V100 data sheet, PDF page 661, section 10.1.6).";
        field {
            name = "reserved";
            desc = "Reserved.";
            sw = rw; hw = r;
            reset = 0x0;
        } reserved_31_21[31:21];
        field {
            name = "reserved";
            desc = "Reserved.";
            sw = r; hw = na;
            reset = 0x0;
        } reserved_20_16[20:16];
        field {
            name = "in_dc2";
            desc = "DC offset of the input B component. It is a signed integer.";
            sw = rw; hw = r;
            reset = 0x0;
        } in_dc2[15:5];
        field {
            name = "reserved";
            desc = "Reserved.";
            sw = r; hw = na;
            reset = 0x0;
        } reserved_4_0[4:0];
    } CH_CSC_IN_DC1 @ 0x1234;
    reg {
        name = "CH_CSC_OUT_DC0";
        desc = "CH_CSC_OUT_DC0 is CSC output DC component register 0. CH_CSC_OUT_DC0 (offset 0x1238, total reset 0x0000_0000; PROVEN: Hi3518E V100 data sheet, PDF page 661, section 10.1.6).";
        field {
            name = "out_dc1";
            desc = "DC offset of the input U component. It is a signed integer.";
            sw = rw; hw = r;
            reset = 0x0;
        } out_dc1[31:21];
        field {
            name = "reserved";
            desc = "Reserved.";
            sw = r; hw = na;
            reset = 0x0;
        } reserved_20_16[20:16];
        field {
            name = "out_dc0";
            desc = "DC offset of the output Y component. It is a signed integer.";
            sw = rw; hw = r;
            reset = 0x0;
        } out_dc0[15:5];
        field {
            name = "reserved";
            desc = "Reserved.";
            sw = r; hw = na;
            reset = 0x0;
        } reserved_4_0[4:0];
    } CH_CSC_OUT_DC0 @ 0x1238;
    reg {
        name = "CH_CSC_OUT_DC1";
        desc = "CH_CSC_OUT_DC1 is CSC output DC component register 1. CH_CSC_OUT_DC1 (offset 0x123C, total reset 0x0000_0000; PROVEN: Hi3518E V100 data sheet, PDF page 662, section 10.1.6).";
        field {
            name = "reserved";
            desc = "Reserved.";
            sw = rw; hw = r;
            reset = 0x0;
        } reserved_31_21[31:21];
        field {
            name = "reserved";
            desc = "Reserved.";
            sw = r; hw = na;
            reset = 0x0;
        } reserved_20_16[20:16];
        field {
            name = "out_dc2";
            desc = "DC offset of the output V component. It is a signed integer.";
            sw = rw; hw = r;
            reset = 0x0;
        } out_dc2[15:5];
        field {
            name = "reserved";
            desc = "Reserved.";
            sw = r; hw = na;
            reset = 0x0;
        } reserved_4_0[4:0];
    } CH_CSC_OUT_DC1 @ 0x123c;
    reg {
        name = "CH_MSC_CFG";
        desc = "CH_MSC_CFG is a block mask configuration register. CH_MSC_CFG (offset 0x1300, total reset 0x0000_0000; PROVEN: Hi3518E V100 data sheet, PDF page 662, section 10.1.6).";
        field {
            name = "reserved";
            desc = "Reserved.";
            sw = r; hw = na;
            reset = 0x0;
        } reserved_31_4[31:4];
        field {
            name = "msc3_en";
            desc = "Block 3 mask enable.
- 0: disabled
- 1: enabled";
            sw = rw; hw = r;
            reset = 0x0;
        } msc3_en[3:3];
        field {
            name = "msc2_en";
            desc = "Block 2 mask enable.
- 0: disabled
- 1: enabled";
            sw = rw; hw = r;
            reset = 0x0;
        } msc2_en[2:2];
        field {
            name = "msc1_en";
            desc = "Block 1 mask enable.
- 0: disabled
- 1: enabled";
            sw = rw; hw = r;
            reset = 0x0;
        } msc1_en[1:1];
        field {
            name = "msc0_en";
            desc = "Block 0 mask enable.
- 0: disabled
- 1: enabled";
            sw = rw; hw = r;
            reset = 0x0;
        } msc0_en[0:0];
    } CH_MSC_CFG @ 0x1300;
    reg {
        name = "CH_MSC_WIN";
        desc = "CH_MSC_WIN is an occlusion window register. CH_MSC_WIN (offset 0x1304, total reset 0xFFFF_FFFF; PROVEN: Hi3518E V100 data sheet, PDF page 663, section 10.1.6).";
        field {
            name = "height";
            desc = "Window height. Its unit is pixel. The configured value is the actual value minus 1.";
            sw = rw; hw = r;
            reset = 0xffff;
        } height[31:16];
        field {
            name = "width";
            desc = "Window width. Its unit is pixel. The configured value is the actual value minus 1.";
            sw = rw; hw = r;
            reset = 0xffff;
        } width[15:0];
    } CH_MSC_WIN @ 0x1304;
    reg {
        name = "CH_BLOCK0_START";
        desc = "CH_BLOCK0_START is a mask start position register for block 0. CH_BLOCK0_START (offset 0x1310, total reset 0x0000_0000; PROVEN: Hi3518E V100 data sheet, PDF page 663, section 10.1.6).";
        field {
            name = "reserved";
            desc = "Reserved.";
            sw = r; hw = na;
            reset = 0x0;
        } reserved_31_28[31:28];
        field {
            name = "y_start";
            desc = "Vertical start point for masking block 0.";
            sw = rw; hw = r;
            reset = 0x0;
        } y_start[27:16];
        field {
            name = "reserved";
            desc = "Reserved.";
            sw = r; hw = na;
            reset = 0x0;
        } reserved_15_12[15:12];
        field {
            name = "x_start";
            desc = "Horizontal start point for masking block 0.";
            sw = rw; hw = r;
            reset = 0x0;
        } x_start[11:0];
    } CH_BLOCK0_START @ 0x1310;
    reg {
        name = "CH_BLOCK1_START";
        desc = "CH_BLOCK1_START is a mask start position register for block 1. CH_BLOCK1_START (offset 0x1314, total reset 0x0000_0000; PROVEN: Hi3518E V100 data sheet, PDF page 664, section 10.1.6).";
        field {
            name = "reserved";
            desc = "Reserved.";
            sw = r; hw = na;
            reset = 0x0;
        } reserved_31_28[31:28];
        field {
            name = "y_start";
            desc = "Vertical start point for masking block 1.";
            sw = rw; hw = r;
            reset = 0x0;
        } y_start[27:16];
        field {
            name = "reserved";
            desc = "Reserved.";
            sw = r; hw = na;
            reset = 0x0;
        } reserved_15_12[15:12];
        field {
            name = "x_start";
            desc = "Horizontal start point for masking block 1.";
            sw = rw; hw = r;
            reset = 0x0;
        } x_start[11:0];
    } CH_BLOCK1_START @ 0x1314;
    reg {
        name = "CH_BLOCK2_START";
        desc = "CH_BLOCK2_START is a mask start position register for block 2. CH_BLOCK2_START (offset 0x1318, total reset 0x0000_0000; PROVEN: Hi3518E V100 data sheet, PDF page 664, section 10.1.6).";
        field {
            name = "reserved";
            desc = "Reserved.";
            sw = r; hw = na;
            reset = 0x0;
        } reserved_31_28[31:28];
        field {
            name = "y_start";
            desc = "Vertical start point for masking block 2.";
            sw = rw; hw = r;
            reset = 0x0;
        } y_start[27:16];
        field {
            name = "reserved";
            desc = "Reserved.";
            sw = r; hw = na;
            reset = 0x0;
        } reserved_15_12[15:12];
        field {
            name = "x_start";
            desc = "Horizontal start point for masking block 2.";
            sw = rw; hw = r;
            reset = 0x0;
        } x_start[11:0];
    } CH_BLOCK2_START @ 0x1318;
    reg {
        name = "CH_BLOCK3_START";
        desc = "CH_BLOCK3_START is a mask start position register for block 3. CH_BLOCK3_START (offset 0x131C, total reset 0x0000_0000; PROVEN: Hi3518E V100 data sheet, PDF page 665, section 10.1.6).";
        field {
            name = "reserved";
            desc = "Reserved.";
            sw = r; hw = na;
            reset = 0x0;
        } reserved_31_28[31:28];
        field {
            name = "y_start";
            desc = "Vertical start point for masking block 3.";
            sw = rw; hw = r;
            reset = 0x0;
        } y_start[27:16];
        field {
            name = "reserved";
            desc = "Reserved.";
            sw = r; hw = na;
            reset = 0x0;
        } reserved_15_12[15:12];
        field {
            name = "x_start";
            desc = "Horizontal start point for masking block 3.";
            sw = rw; hw = r;
            reset = 0x0;
        } x_start[11:0];
    } CH_BLOCK3_START @ 0x131c;
    reg {
        name = "CH_BLOCK0_SIZE";
        desc = "CH_BLOCK0_SIZE is a mask size register for block 0. CH_BLOCK0_SIZE (offset 0x1320, total reset 0x0000_0000; PROVEN: Hi3518E V100 data sheet, PDF page 665, section 10.1.6).";
        field {
            name = "reserved";
            desc = "Reserved.";
            sw = r; hw = na;
            reset = 0x0;
        } reserved_31_28[31:28];
        field {
            name = "blk_height";
            desc = "Vertical height for masking block 0. The configured value is the actual value minus 1.";
            sw = rw; hw = r;
            reset = 0x0;
        } blk_height[27:16];
        field {
            name = "reserved";
            desc = "Reserved.";
            sw = r; hw = na;
            reset = 0x0;
        } reserved_15_12[15:12];
        field {
            name = "blk_width";
            desc = "Horizontal width for making block 0. The configured value is the actual value minus 1.";
            sw = rw; hw = r;
            reset = 0x0;
        } blk_width[11:0];
    } CH_BLOCK0_SIZE @ 0x1320;
    reg {
        name = "CH_BLOCK1_SIZE";
        desc = "CH_BLOCK1_SIZE is a mask size register for block 1. CH_BLOCK1_SIZE (offset 0x1324, total reset 0x0000_0000; PROVEN: Hi3518E V100 data sheet, PDF page 666, section 10.1.6).";
        field {
            name = "reserved";
            desc = "Reserved.";
            sw = r; hw = na;
            reset = 0x0;
        } reserved_31_28[31:28];
        field {
            name = "blk_height";
            desc = "Vertical height for masking block 1. The configured value is the actual value minus 1.";
            sw = rw; hw = r;
            reset = 0x0;
        } blk_height[27:16];
        field {
            name = "reserved";
            desc = "Reserved.";
            sw = r; hw = na;
            reset = 0x0;
        } reserved_15_12[15:12];
        field {
            name = "blk_width";
            desc = "Horizontal width for making block 1. The configured value is the actual value minus 1.";
            sw = rw; hw = r;
            reset = 0x0;
        } blk_width[11:0];
    } CH_BLOCK1_SIZE @ 0x1324;
    reg {
        name = "CH_BLOCK2_SIZE";
        desc = "CH_BLOCK2_SIZE is a mask size register for block 2. CH_BLOCK2_SIZE (offset 0x1328, total reset 0x0000_0000; PROVEN: Hi3518E V100 data sheet, PDF page 666, section 10.1.6).";
        field {
            name = "reserved";
            desc = "Reserved.";
            sw = r; hw = na;
            reset = 0x0;
        } reserved_31_28[31:28];
        field {
            name = "blk_height";
            desc = "Vertical height for masking block 2. The configured value is the actual value minus 1.";
            sw = rw; hw = r;
            reset = 0x0;
        } blk_height[27:16];
        field {
            name = "reserved";
            desc = "Reserved.";
            sw = r; hw = na;
            reset = 0x0;
        } reserved_15_12[15:12];
        field {
            name = "blk_width";
            desc = "Horizontal width for making block 2. The configured value is the actual value minus 1.";
            sw = rw; hw = r;
            reset = 0x0;
        } blk_width[11:0];
    } CH_BLOCK2_SIZE @ 0x1328;
    reg {
        name = "CH_BLOCK3_SIZE";
        desc = "CH_BLOCK3_SIZE is a mask size register for block 3. CH_BLOCK3_SIZE (offset 0x132C, total reset 0x0000_0000; PROVEN: Hi3518E V100 data sheet, PDF page 667, section 10.1.6).";
        field {
            name = "reserved";
            desc = "Reserved.";
            sw = r; hw = na;
            reset = 0x0;
        } reserved_31_28[31:28];
        field {
            name = "blk_height";
            desc = "Vertical height for masking block 3. The configured value is the actual value minus 1.";
            sw = rw; hw = r;
            reset = 0x0;
        } blk_height[27:16];
        field {
            name = "reserved";
            desc = "Reserved.";
            sw = r; hw = na;
            reset = 0x0;
        } reserved_15_12[15:12];
        field {
            name = "blk_width";
            desc = "Horizontal width for making block 3. The configured value is the actual value minus 1.";
            sw = rw; hw = r;
            reset = 0x0;
        } blk_width[11:0];
    } CH_BLOCK3_SIZE @ 0x132c;
    reg {
        name = "CH_BLOCK0_COLOR";
        desc = "CH_BLOCK0_COLOR is a filling color register for block 0. CH_BLOCK0_COLOR (offset 0x1330, total reset 0x0000_0000; PROVEN: Hi3518E V100 data sheet, PDF page 667, section 10.1.6).";
        field {
            name = "reserved";
            desc = "Reserved.";
            sw = r; hw = na;
            reset = 0x0;
        } reserved_31_24[31:24];
        field {
            name = "blk_cr";
            desc = "Cr component of the filling color of block 0.";
            sw = rw; hw = r;
            reset = 0x0;
        } blk_cr[23:16];
        field {
            name = "blk_cb";
            desc = "Cb component of the filling color of block 0.";
            sw = rw; hw = r;
            reset = 0x0;
        } blk_cb[15:8];
        field {
            name = "blc_y";
            desc = "Y component of the filling color of block 0.";
            sw = rw; hw = r;
            reset = 0x0;
        } blc_y[7:0];
    } CH_BLOCK0_COLOR @ 0x1330;
    reg {
        name = "CH_BLOCK1_COLOR";
        desc = "CH_BLOCK1_COLOR is a filling color register for block 1. CH_BLOCK1_COLOR (offset 0x1334, total reset 0x0000_0000; PROVEN: Hi3518E V100 data sheet, PDF page 668, section 10.1.6).";
        field {
            name = "reserved";
            desc = "Reserved.";
            sw = r; hw = na;
            reset = 0x0;
        } reserved_31_24[31:24];
        field {
            name = "blk_cr";
            desc = "Cr component of the filling color of block 1.";
            sw = rw; hw = r;
            reset = 0x0;
        } blk_cr[23:16];
        field {
            name = "blk_cb";
            desc = "Cb component of the filling color of block 1.";
            sw = rw; hw = r;
            reset = 0x0;
        } blk_cb[15:8];
        field {
            name = "blc_y";
            desc = "Y component of the filling color of block 1.";
            sw = rw; hw = r;
            reset = 0x0;
        } blc_y[7:0];
    } CH_BLOCK1_COLOR @ 0x1334;
    reg {
        name = "CH_BLOCK2_COLOR";
        desc = "CH_BLOCK2_COLOR is a filling color register for block 2. CH_BLOCK2_COLOR (offset 0x1338, total reset 0x0000_0000; PROVEN: Hi3518E V100 data sheet, PDF page 668, section 10.1.6).";
        field {
            name = "reserved";
            desc = "Reserved.";
            sw = r; hw = na;
            reset = 0x0;
        } reserved_31_24[31:24];
        field {
            name = "blk_cr";
            desc = "Cr component of the filling color of block 2.";
            sw = rw; hw = r;
            reset = 0x0;
        } blk_cr[23:16];
        field {
            name = "blk_cb";
            desc = "Cb component of the filling color of block 2.";
            sw = rw; hw = r;
            reset = 0x0;
        } blk_cb[15:8];
        field {
            name = "blc_y";
            desc = "Y component of the filling color of block 2.";
            sw = rw; hw = r;
            reset = 0x0;
        } blc_y[7:0];
    } CH_BLOCK2_COLOR @ 0x1338;
    reg {
        name = "CH_BLOCK3_COLOR";
        desc = "CH_BLOCK3_COLOR is a filling color register for block 3. CH_BLOCK3_COLOR (offset 0x133C, total reset 0x0000_0000; PROVEN: Hi3518E V100 data sheet, PDF page 669, section 10.1.6).";
        field {
            name = "reserved";
            desc = "Reserved.";
            sw = r; hw = na;
            reset = 0x0;
        } reserved_31_24[31:24];
        field {
            name = "blk_cr";
            desc = "Cr component of the filling color of block 3.";
            sw = rw; hw = r;
            reset = 0x0;
        } blk_cr[23:16];
        field {
            name = "blk_cb";
            desc = "Cb component of the filling color of block 3.";
            sw = rw; hw = r;
            reset = 0x0;
        } blk_cb[15:8];
        field {
            name = "blc_y";
            desc = "Y component of the filling color of block 3.";
            sw = rw; hw = r;
            reset = 0x0;
        } blc_y[7:0];
    } CH_BLOCK3_COLOR @ 0x133c;
    reg {
        name = "CH_SKIP_Y_CFG";
        desc = "CH_SKIP_Y_CFG is a Y component skip configuration register. CH_SKIP_Y_CFG (offset 0x1400, total reset 0xFFFF_FFFF; PROVEN: Hi3518E V100 data sheet, PDF page 669, section 10.1.6).";
        field {
            name = "skip_cfg";
            desc = "Skip configuration.";
            sw = rw; hw = r;
            reset = 0xffffffff;
        } skip_cfg[31:0];
    } CH_SKIP_Y_CFG @ 0x1400;
    reg {
        name = "CH_SKIP_Y_WIN";
        desc = "CH_SKIP_Y_WIN is a Y component skip window register. CH_SKIP_Y_WIN (offset 0x1404, total reset 0x0003_0007; PROVEN: Hi3518E V100 data sheet, PDF page 670, section 10.1.6).";
        field {
            name = "reserved";
            desc = "Reserved.";
            sw = r; hw = na;
            reset = 0x0;
        } reserved_31_18[31:18];
        field {
            name = "height";
            desc = "Window height. Its unit is pixel. The configured value is the actual value minus 1.";
            sw = rw; hw = r;
            reset = 0x3;
        } height[17:16];
        field {
            name = "reserved";
            desc = "Reserved.";
            sw = r; hw = na;
            reset = 0x0;
        } reserved_15_3[15:3];
        field {
            name = "width";
            desc = "Window width. Its unit is pixel. The configured value is the actual value minus 1.";
            sw = rw; hw = r;
            reset = 0x7;
        } width[2:0];
    } CH_SKIP_Y_WIN @ 0x1404;
    reg {
        name = "CH_SKIP_C_CFG";
        desc = "CH_SKIP_C_CFG is a C component skip configuration register. CH_SKIP_C_CFG (offset 0x1410, total reset 0xFFFF_FFFF; PROVEN: Hi3518E V100 data sheet, PDF page 670, section 10.1.6).";
        field {
            name = "skip_cfg";
            desc = "Skip configuration.";
            sw = rw; hw = r;
            reset = 0xffffffff;
        } skip_cfg[31:0];
    } CH_SKIP_C_CFG @ 0x1410;
    reg {
        name = "CH_SKIP_C_WIN";
        desc = "CH_SKIP_C_WIN is a C component skip window register. CH_SKIP_C_WIN (offset 0x1414, total reset 0x0003_0007; PROVEN: Hi3518E V100 data sheet, PDF page 671, section 10.1.6).";
        field {
            name = "reserved";
            desc = "Reserved.";
            sw = r; hw = na;
            reset = 0x0;
        } reserved_31_18[31:18];
        field {
            name = "height";
            desc = "Window height. Its unit is pixel. The configured value is the actual value minus 1.";
            sw = rw; hw = r;
            reset = 0x3;
        } height[17:16];
        field {
            name = "reserved";
            desc = "Reserved.";
            sw = r; hw = na;
            reset = 0x0;
        } reserved_15_3[15:3];
        field {
            name = "width";
            desc = "Window width. Its unit is pixel. The configured value is the actual value minus 1.";
            sw = rw; hw = r;
            reset = 0x7;
        } width[2:0];
    } CH_SKIP_C_WIN @ 0x1414;
    reg {
        name = "CH_ZME_C_SSIZE";
        desc = "CH_ZME_C_SSIZE is a C component input size register for the zoom module. CH_ZME_C_SSIZE (offset 0x1500, total reset 0x0000_04FF; PROVEN: Hi3518E V100 data sheet, PDF page 671, section 10.1.6).";
        field {
            name = "reserved";
            desc = "Reserved.";
            sw = r; hw = na;
            reset = 0x0;
        } reserved_31_16[31:16];
        field {
            name = "width";
            desc = "Picture width. Its unit is pixel. The configured value is the actual value minus 1.";
            sw = rw; hw = r;
            reset = 0x4ff;
        } width[15:0];
    } CH_ZME_C_SSIZE @ 0x1500;
    reg {
        name = "CH_ZME_C_DSIZE";
        desc = "CH_ZME_C_DSIZE is a C component output size register for the zoom module. CH_ZME_C_DSIZE (offset 0x1504, total reset 0x0000_04FF; PROVEN: Hi3518E V100 data sheet, PDF page 672, section 10.1.6).";
        field {
            name = "reserved";
            desc = "Reserved.";
            sw = r; hw = na;
            reset = 0x0;
        } reserved_31_16[31:16];
        field {
            name = "width";
            desc = "Picture width. Its unit is pixel. The configured value is the actual value minus 1.";
            sw = rw; hw = r;
            reset = 0x4ff;
        } width[15:0];
    } CH_ZME_C_DSIZE @ 0x1504;
    reg {
        name = "CH_HFIR_C_SPH";
        desc = "CH_HFIR_C_SPH is a chrominance horizontal scaling parameter configuration register. CH_HFIR_C_SPH (offset 0x1510, total reset 0x0000_1000; PROVEN: Hi3518E V100 data sheet, PDF page 672, section 10.1.6).";
        field {
            name = "enable";
            desc = "Chrominance horizontal scaling enable.
- 0: disabled
- 1: enabled";
            sw = rw; hw = r;
            reset = 0x0;
        } enable_[31:31];
        field {
            name = "reserved";
            desc = "Reserved.";
            sw = r; hw = na;
            reset = 0x0;
        } reserved_30_16[30:16];
        field {
            name = "ratio";
            desc = "Chrominance horizontal scaling ratio. It is calculated by dividing the input width by the output width. If horizontal pre-processing is enabled, the input width after pre-processing is used. The ratio is in the format of (u, 4). That is, the ratio consists of a 1-bit unsigned bit and a 4-bit integral part.";
            sw = rw; hw = r;
            reset = 0x1;
        } ratio[15:12];
        field {
            name = "reserved";
            desc = "Reserved.";
            sw = r; hw = na;
            reset = 0x0;
        } reserved_11_0[11:0];
    } CH_HFIR_C_SPH @ 0x1510;
    reg {
        name = "CH_HFIR_C_OFFSET";
        desc = "CH_HFIR_C_OFFSET is a chrominance scaling horizontal offset register. CH_HFIR_C_OFFSET (offset 0x1514, total reset 0x0000_0000; PROVEN: Hi3518E V100 data sheet, PDF page 673, section 10.1.6).";
        field {
            name = "reserved";
            desc = "Reserved.";
            sw = r; hw = na;
            reset = 0x0;
        } reserved_31_17[31:17];
        field {
            name = "offset";
            desc = "Chrominance horizontal start position offset. It is in the format of (s, 5). That is, the offset consists of a 1-bit signed part and a 4-bit integral part. The offset is expressed as the complementary code and ranges from –4 to +15.";
            sw = rw; hw = r;
            reset = 0x0;
        } offset[16:12];
        field {
            name = "reserved";
            desc = "Reserved.";
            sw = r; hw = na;
            reset = 0x0;
        } reserved_11_0[11:0];
    } CH_HFIR_C_OFFSET @ 0x1514;
    reg {
        name = "CH_HFIR_C_COEF0";
        desc = "CH_HFIR_C_COEF0 is chrominance horizontal scaling coefficient register 0. CH_HFIR_C_COEF0 (offset 0x1520, total reset 0x0000_0000; PROVEN: Hi3518E V100 data sheet, PDF page 673, section 10.1.6).";
        field {
            name = "reserved";
            desc = "Reserved.";
            sw = r; hw = na;
            reset = 0x0;
        } reserved_31_30[31:30];
        field {
            name = "coef2";
            desc = "Chrominance horizontal scaling and filtering coefficient 2.";
            sw = rw; hw = r;
            reset = 0x0;
        } coef2[29:20];
        field {
            name = "coef1";
            desc = "Chrominance horizontal scaling and filtering coefficient 1.";
            sw = rw; hw = r;
            reset = 0x0;
        } coef1[19:10];
        field {
            name = "coef0";
            desc = "Chrominance horizontal scaling and filtering coefficient 0. Only 8-tap horizontal scaling at an integral ratio is supported.";
            sw = rw; hw = r;
            reset = 0x0;
        } coef0[9:0];
    } CH_HFIR_C_COEF0 @ 0x1520;
    reg {
        name = "CH_HFIR_C_COEF1";
        desc = "CH_HFIR_C_COEF1 is chrominance horizontal scaling coefficient register 1. CH_HFIR_C_COEF1 (offset 0x1524, total reset 0x0000_01FF; PROVEN: Hi3518E V100 data sheet, PDF page 674, section 10.1.6).";
        field {
            name = "reserved";
            desc = "Reserved.";
            sw = r; hw = na;
            reset = 0x0;
        } reserved_31_30[31:30];
        field {
            name = "coef5";
            desc = "Chrominance horizontal scaling and filtering coefficient 5.";
            sw = rw; hw = r;
            reset = 0x0;
        } coef5[29:20];
        field {
            name = "coef4";
            desc = "Chrominance horizontal scaling and filtering coefficient 4.";
            sw = rw; hw = r;
            reset = 0x0;
        } coef4[19:10];
        field {
            name = "coef3";
            desc = "Chrominance horizontal scaling and filtering coefficient 3.";
            sw = rw; hw = r;
            reset = 0x1ff;
        } coef3[9:0];
    } CH_HFIR_C_COEF1 @ 0x1524;
    reg {
        name = "CH_HFIR_C_COEF2";
        desc = "CH_HFIR_C_COEF2 is chrominance horizontal scaling coefficient register 2. CH_HFIR_C_COEF2 (offset 0x1528, total reset 0x0000_0000; PROVEN: Hi3518E V100 data sheet, PDF page 674, section 10.1.6).";
        field {
            name = "reserved";
            desc = "Reserved.";
            sw = r; hw = na;
            reset = 0x0;
        } reserved_31_20[31:20];
        field {
            name = "coef7";
            desc = "Chrominance horizontal scaling and filtering coefficient 7.";
            sw = rw; hw = r;
            reset = 0x0;
        } coef7[19:10];
        field {
            name = "coef6";
            desc = "Chrominance horizontal scaling and filtering coefficient 6.";
            sw = rw; hw = r;
            reset = 0x0;
        } coef6[9:0];
    } CH_HFIR_C_COEF2 @ 0x1528;
    reg {
        name = "CH_DITHER_CFG";
        desc = "CH_DITHER_CFG is a dither configuration register. CH_DITHER_CFG (offset 0x1600, total reset 0xE000_0000; PROVEN: Hi3518E V100 data sheet, PDF page 675, section 10.1.6).";
        field {
            name = "dither_md";
            desc = "Dither mode select.
- 000: 12-bit inputs, 10-bit outputs, no dithering, and direct bit truncation
- 001: 12-bit inputs, 10-bit outputs, and time-domain dithering
- 010: 12-bit inputs, 10-bit outputs, and spatial-domain dithering
- 011: 12-bit inputs, 8-bit outputs, and time-domain and spatial- domain dithering
- 100: 12-bit inputs, 10-bit outputs, and round off
- 101: 12-bit inputs, 8-bit outputs, and round off
- 111: no operation";
            sw = rw; hw = r;
            reset = 0x7;
        } dither_md[31:29];
        field {
            name = "reserved";
            desc = "Reserved.";
            sw = r; hw = na;
            reset = 0x0;
        } reserved_28_0[28:0];
    } CH_DITHER_CFG @ 0x1600;
    reg {
        name = "CH_DITHER_COEF0";
        desc = "CH_DITHER_COEF0 is dither coefficient register 0. CH_DITHER_COEF0 (offset 0x1604, total reset 0x3860_8000; PROVEN: Hi3518E V100 data sheet, PDF page 675, section 10.1.6).";
        field {
            name = "dither_coef3";
            desc = "Dither coefficient in time-domain mode.";
            sw = rw; hw = r;
            reset = 0x38;
        } dither_coef3[31:24];
        field {
            name = "dither_coef2";
            desc = "Dither coefficient in time-domain mode.";
            sw = rw; hw = r;
            reset = 0x60;
        } dither_coef2[23:16];
        field {
            name = "dither_coef1";
            desc = "Dither coefficient in time-domain mode.";
            sw = rw; hw = r;
            reset = 0x80;
        } dither_coef1[15:8];
        field {
            name = "dither_coef0";
            desc = "Dither coefficient in time-domain mode.";
            sw = rw; hw = r;
            reset = 0x0;
        } dither_coef0[7:0];
    } CH_DITHER_COEF0 @ 0x1604;
    reg {
        name = "CH_DITHER_COEF1";
        desc = "CH_DITHER_COEF1 is dither coefficient register 1. CH_DITHER_COEF1 (offset 0x1608, total reset 0xFBE7_0F1E; PROVEN: Hi3518E V100 data sheet, PDF page 676, section 10.1.6).";
        field {
            name = "dither_coef7";
            desc = "Dither coefficient in time-domain mode.";
            sw = rw; hw = r;
            reset = 0xfb;
        } dither_coef7[31:24];
        field {
            name = "dither_coef6";
            desc = "Dither coefficient in time-domain mode.";
            sw = rw; hw = r;
            reset = 0xe7;
        } dither_coef6[23:16];
        field {
            name = "dither_coef5";
            desc = "Dither coefficient in time-domain mode.";
            sw = rw; hw = r;
            reset = 0xf;
        } dither_coef5[15:8];
        field {
            name = "dither_coef4";
            desc = "Dither coefficient in time-domain mode.";
            sw = rw; hw = r;
            reset = 0x1e;
        } dither_coef4[7:0];
    } CH_DITHER_COEF1 @ 0x1608;
    reg {
        name = "CH_DITHER_Y_SIZE";
        desc = "CH_DITHER_Y_SIZE is a Y component input size register for the dither module. CH_DITHER_Y_SIZE (offset 0x1610, total reset 0x0000_04FF; PROVEN: Hi3518E V100 data sheet, PDF page 676, section 10.1.6).";
        field {
            name = "reserved";
            desc = "Reserved.";
            sw = r; hw = na;
            reset = 0x0;
        } reserved_31_13[31:13];
        field {
            name = "width";
            desc = "Width of a picture line. Its unit is pixel. The configured value is the actual value minus 1.";
            sw = rw; hw = r;
            reset = 0x4ff;
        } width[12:0];
    } CH_DITHER_Y_SIZE @ 0x1610;
    reg {
        name = "CH_DITHER_C_SIZE";
        desc = "CH_DITHER_C_SIZE is a C component input size register for the dither module. CH_DITHER_C_SIZE (offset 0x1614, total reset 0x0000_04FF; PROVEN: Hi3518E V100 data sheet, PDF page 677, section 10.1.6).";
        field {
            name = "reserved";
            desc = "Reserved.";
            sw = r; hw = na;
            reset = 0x0;
        } reserved_31_13[31:13];
        field {
            name = "width";
            desc = "Width of a picture line. Its unit is pixel. The configured value is the actual value minus 1.";
            sw = rw; hw = r;
            reset = 0x4ff;
        } width[12:0];
    } CH_DITHER_C_SIZE @ 0x1614;
    reg {
        name = "CH_VCDS_CFG";
        desc = "CH_VCDS_CFG is a chrominance vertical down sampling configuration register. CH_VCDS_CFG (offset 0x1700, total reset 0x0000_0000; PROVEN: Hi3518E V100 data sheet, PDF page 677, section 10.1.6).";
        field {
            name = "enable";
            desc = "Down sampling enable.
- 0: disabled
- 1: enabled";
            sw = rw; hw = r;
            reset = 0x0;
        } enable_[31:31];
        field {
            name = "reserved";
            desc = "Reserved.";
            sw = r; hw = na;
            reset = 0x0;
        } reserved_30_0[30:0];
    } CH_VCDS_CFG @ 0x1700;
    reg {
        name = "CH_VCDS_COEF";
        desc = "CH_VCDS_COEF is a chrominance vertical down sampling coefficient register. CH_VCDS_COEF (offset 0x1704, total reset 0x0000_001F; PROVEN: Hi3518E V100 data sheet, PDF page 678, section 10.1.6).";
        field {
            name = "reserved";
            desc = "Reserved.";
            sw = r; hw = na;
            reset = 0x0;
        } reserved_31_21[31:21];
        field {
            name = "coef1";
            desc = "Down sampling coefficient 1.";
            sw = rw; hw = r;
            reset = 0x0;
        } coef1[20:16];
        field {
            name = "reserved";
            desc = "Reserved.";
            sw = r; hw = na;
            reset = 0x0;
        } reserved_15_5[15:5];
        field {
            name = "coef0";
            desc = "Down sampling coefficient 0.";
            sw = rw; hw = r;
            reset = 0x1f;
        } coef0[4:0];
    } CH_VCDS_COEF @ 0x1704;
    reg {
        name = "CH_HLDC_CFG";
        desc = "CH_HLDC_CFG is a horizontal lens distortion correction (HLDC) configuration register. CH_HLDC_CFG (offset 0x1800, total reset 0x0000_0000; PROVEN: Hi3518E V100 data sheet, PDF page 678, section 10.1.6).";
        field {
            name = "enable";
            desc = "Lens distortion correction enable.
- 1: disabled
- 1: enabled";
            sw = rw; hw = r;
            reset = 0x0;
        } enable_[31:31];
        field {
            name = "reserved";
            desc = "Reserved.";
            sw = r; hw = na;
            reset = 0x0;
        } reserved_30_1[30:1];
        field {
            name = "round_en";
            desc = "Round off enable.
- 1: disabled
- 1: enabled";
            sw = rw; hw = r;
            reset = 0x0;
        } round_en[0:0];
    } CH_HLDC_CFG @ 0x1800;
    reg {
        name = "CH_HLDC_SIZE";
        desc = "CH_HLDC_SIZE is an HLDC input picture size register. CH_HLDC_SIZE (offset 0x1804, total reset 0x0000_0000; PROVEN: Hi3518E V100 data sheet, PDF page 679, section 10.1.6).";
        field {
            name = "reserved";
            desc = "Reserved.";
            sw = r; hw = na;
            reset = 0x0;
        } reserved_31_28[31:28];
        field {
            name = "height";
            desc = "Input picture height for HLDC. Its unit is pixel. The configured value is the actual value minus 1.";
            sw = rw; hw = r;
            reset = 0x0;
        } height[27:16];
        field {
            name = "reserved";
            desc = "Reserved.";
            sw = r; hw = na;
            reset = 0x0;
        } reserved_15_12[15:12];
        field {
            name = "width";
            desc = "Input picture width for HLDC. Its unit is pixel. The configured value is the actual value minus 1.";
            sw = rw; hw = r;
            reset = 0x0;
        } width[11:0];
    } CH_HLDC_SIZE @ 0x1804;
    reg {
        name = "CH_HLDC_DEL";
        desc = "CH_HLDC_DEL is an HLDC output delay register. CH_HLDC_DEL (offset 0x1808, total reset 0x0000_00F0; PROVEN: Hi3518E V100 data sheet, PDF page 679, section 10.1.6).";
        field {
            name = "reserved";
            desc = "Reserved.";
            sw = r; hw = na;
            reset = 0x0;
        } reserved_31_16[31:16];
        field {
            name = "delay";
            desc = "Output delay.";
            sw = rw; hw = r;
            reset = 0xf0;
        } delay[15:0];
    } CH_HLDC_DEL @ 0x1808;
    reg {
        name = "CH_HLDC_COEF0";
        desc = "CH_HLDC_COEF0 is HLDC coefficient register 0. CH_HLDC_COEF0 (offset 0x1810, total reset 0x0000_0000; PROVEN: Hi3518E V100 data sheet, PDF page 680, section 10.1.6).";
        field {
            name = "reserved";
            desc = "Reserved.";
            sw = r; hw = na;
            reset = 0x0;
        } reserved_31_26[31:26];
        field {
            name = "c2";
            desc = "Vertical coordinate of the distortion center.";
            sw = rw; hw = r;
            reset = 0x0;
        } c2[25:16];
        field {
            name = "reserved";
            desc = "Reserved.";
            sw = r; hw = na;
            reset = 0x0;
        } reserved_15_11[15:11];
        field {
            name = "c1";
            desc = "Horizontal coordinate of the distortion center.";
            sw = rw; hw = r;
            reset = 0x0;
        } c1[10:0];
    } CH_HLDC_COEF0 @ 0x1810;
    reg {
        name = "CH_HLDC_COEF1";
        desc = "CH_HLDC_COEF1 is HLDC coefficient register 1. CH_HLDC_COEF1 (offset 0x1814, total reset 0x0000_0000; PROVEN: Hi3518E V100 data sheet, PDF page 680, section 10.1.6).";
        field {
            name = "reserved";
            desc = "Reserved.";
            sw = r; hw = na;
            reset = 0x0;
        } reserved_31_25[31:25];
        field {
            name = "k2";
            desc = "Ellipse mapping coefficient k2.";
            sw = rw; hw = r;
            reset = 0x0;
        } k2[24:16];
        field {
            name = "reserved";
            desc = "Reserved.";
            sw = r; hw = na;
            reset = 0x0;
        } reserved_15_11[15:11];
        field {
            name = "k1";
            desc = "Ellipse mapping coefficient k1.";
            sw = rw; hw = r;
            reset = 0x0;
        } k1[10:0];
    } CH_HLDC_COEF1 @ 0x1814;
    reg {
        name = "CH_HLDC_COEF2";
        desc = "CH_HLDC_COEF2 is HLDC coefficient register 2. CH_HLDC_COEF2 (offset 0x1818, total reset 0x0000_0000; PROVEN: Hi3518E V100 data sheet, PDF page 681, section 10.1.6).";
        field {
            name = "reserved";
            desc = "Reserved.";
            sw = r; hw = na;
            reset = 0x0;
        } reserved_31_24[31:24];
        field {
            name = "hc2";
            desc = "Trapezoid mapping coefficient hc2.";
            sw = rw; hw = r;
            reset = 0x0;
        } hc2[23:16];
        field {
            name = "reserved";
            desc = "Reserved.";
            sw = r; hw = na;
            reset = 0x0;
        } reserved_15_8[15:8];
        field {
            name = "hc1";
            desc = "Trapezoid mapping coefficient hc1.";
            sw = rw; hw = r;
            reset = 0x0;
        } hc1[7:0];
    } CH_HLDC_COEF2 @ 0x1818;
    reg {
        name = "CH_HLDC_COEF3";
        desc = "CH_HLDC_COEF3 is HLDC coefficient register 3. CH_HLDC_COEF3 (offset 0x181C, total reset 0x0000_0000; PROVEN: Hi3518E V100 data sheet, PDF page 681, section 10.1.6).";
        field {
            name = "reserved";
            desc = "Reserved.";
            sw = r; hw = na;
            reset = 0x0;
        } reserved_31_11[31:11];
        field {
            name = "f_h";
            desc = "Coefficient f_h.";
            sw = rw; hw = r;
            reset = 0x0;
        } f_h[10:0];
    } CH_HLDC_COEF3 @ 0x181c;
    reg {
        name = "CH_CLIP_Y_CFG";
        desc = "CH_CLIP_Y_CFG is a Y component configuration register for the clip module. CH_CLIP_Y_CFG (offset 0x1900, total reset 0xFFFF_0000; PROVEN: Hi3518E V100 data sheet, PDF page 682, section 10.1.6).";
        field {
            name = "max";
            desc = "Maximum output value. The value format is (u, 8, 4). That is, the value consists of a 1-bit unsigned part, an 8-bit integral part, and a 4-bit fractional part.";
            sw = rw; hw = r;
            reset = 0xfff;
        } max[31:20];
        field {
            name = "reserved";
            desc = "Reserved.";
            sw = r; hw = na;
            reset = 0xf;
        } reserved_19_16[19:16];
        field {
            name = "min";
            desc = "Minimum output value. The value format is (u, 8, 4). That is, the value consists of a 1-bit unsigned part, an 8-bit integral part, and a 4-bit fractional part.";
            sw = rw; hw = r;
            reset = 0x0;
        } min[15:4];
        field {
            name = "reserved";
            desc = "Reserved.";
            sw = r; hw = na;
            reset = 0x0;
        } reserved_3_0[3:0];
    } CH_CLIP_Y_CFG @ 0x1900;
    reg {
        name = "CH_CLIP_C_CFG";
        desc = "CH_CLIP_C_CFG is a C component configuration register for the clip module. CH_CLIP_C_CFG (offset 0x1904, total reset 0xFFFF_0000; PROVEN: Hi3518E V100 data sheet, PDF page 682, section 10.1.6).";
        field {
            name = "max";
            desc = "Maximum output value. The value format is (u, 8, 4). That is, the value consists of a 1-bit unsigned part, an 8-bit integral part, and a 4-bit fractional part.";
            sw = rw; hw = r;
            reset = 0xfff;
        } max[31:20];
        field {
            name = "reserved";
            desc = "Reserved.";
            sw = r; hw = na;
            reset = 0xf;
        } reserved_19_16[19:16];
        field {
            name = "min";
            desc = "Minimum output value. The value format is (u, 8, 4). That is, the value consists of a 1-bit unsigned part, an 8-bit integral part, and a 4-bit fractional part.";
            sw = rw; hw = r;
            reset = 0x0;
        } min[15:4];
        field {
            name = "reserved";
            desc = "Reserved.";
            sw = r; hw = na;
            reset = 0x0;
        } reserved_3_0[3:0];
    } CH_CLIP_C_CFG @ 0x1904;
    reg {
        name = "CH_SUM_Y";
        desc = "CH_SUM_Y is an input picture luminance statistics register. CH_SUM_Y (offset 0x1A00, total reset 0x0000_0000; PROVEN: Hi3518E V100 data sheet, PDF page 683, section 10.1.6).";
        field {
            name = "sum_y";
            desc = "Luminance statistics.";
            sw = r; hw = w;
            reset = 0x0;
        } sum_y[31:0];
    } CH_SUM_Y @ 0x1a00;
    reg {
        name = "ISP_INT";
        desc = "ISP_INT is an ISP interrupt indicator register. ISP_INT (offset 0x100F0, total reset 0x0000_0000; PROVEN: Hi3518E V100 data sheet, PDF page 683, section 10.1.6).";
        field {
            name = "reserved";
            desc = "Reserved.";
            sw = r; hw = na;
            reset = 0x0;
        } reserved_31_8[31:8];
        field {
            name = "int7";
            desc = "ISP interrupt 7 indicator. Writing 1 clears the indicator.
- 0: No interrupt is generated.
- 1: An interrupt is generated. (data sheet access type WC)";
            sw = rw; hw = r; onwrite = woclr;
            reset = 0x0;
        } int7[7:7];
        field {
            name = "int6";
            desc = "ISP interrupt 6 indicator. Writing 1 clears the indicator.
- 0: No interrupt is generated.
- 1: An interrupt is generated. (data sheet access type WC)";
            sw = rw; hw = r; onwrite = woclr;
            reset = 0x0;
        } int6[6:6];
        field {
            name = "int5";
            desc = "ISP interrupt 5 indicator. Writing 1 clears the indicator.
- 0: No interrupt is generated.
- 1: An interrupt is generated. (data sheet access type WC)";
            sw = rw; hw = r; onwrite = woclr;
            reset = 0x0;
        } int5[5:5];
        field {
            name = "int4";
            desc = "ISP interrupt 4 indicator. Writing 1 clears the indicator.
- 0: No interrupt is generated.
- 1: An interrupt is generated. (data sheet access type WC)";
            sw = rw; hw = r; onwrite = woclr;
            reset = 0x0;
        } int4[4:4];
        field {
            name = "int3";
            desc = "ISP interrupt 3 indicator. Writing 1 clears the indicator.
- 0: No interrupt is generated.
- 1: An interrupt is generated. (data sheet access type WC)";
            sw = rw; hw = r; onwrite = woclr;
            reset = 0x0;
        } int3[3:3];
        field {
            name = "int2";
            desc = "ISP interrupt 2 indicator. Writing 1 clears the indicator.
- 0: No interrupt is generated.
- 1: An interrupt is generated. (data sheet access type WC)";
            sw = rw; hw = r; onwrite = woclr;
            reset = 0x0;
        } int2[2:2];
        field {
            name = "int1";
            desc = "ISP interrupt 1 indicator. Writing 1 clears the indicator.
- 0: No interrupt is generated.
- 1: An interrupt is generated. (data sheet access type WC)";
            sw = rw; hw = r; onwrite = woclr;
            reset = 0x0;
        } int1[1:1];
        field {
            name = "int0";
            desc = "ISP interrupt 0 indicator. Writing 1 clears the indicator.
- 0: No interrupt is generated.
- 1: An interrupt is generated. (data sheet access type WC)";
            sw = rw; hw = r; onwrite = woclr;
            reset = 0x0;
        } int0[0:0];
    } ISP_INT @ 0x100f0;
    reg {
        name = "ISP_INT_MASK";
        desc = "ISP_INT_MASK is an ISP interrupt mask register. ISP_INT_MASK (offset 0x100F8, total reset 0x0000_0000; PROVEN: Hi3518E V100 data sheet, PDF page 684, section 10.1.6).";
        field {
            name = "reserved";
            desc = "Reserved.";
            sw = r; hw = na;
            reset = 0x0;
        } reserved_31_8[31:8];
        field {
            name = "int7_en";
            desc = "ISP interrupt 7 mask.
- 0: No interrupt is generated.
- 1: An interrupt is generated.";
            sw = rw; hw = r;
            reset = 0x0;
        } int7_en[7:7];
        field {
            name = "int6_en";
            desc = "ISP interrupt 6 mask.
- 0: No interrupt is generated.
- 1: An interrupt is generated.";
            sw = rw; hw = r;
            reset = 0x0;
        } int6_en[6:6];
        field {
            name = "int5_en";
            desc = "ISP interrupt 5 mask.
- 0: No interrupt is generated.
- 1: An interrupt is generated.";
            sw = rw; hw = r;
            reset = 0x0;
        } int5_en[5:5];
        field {
            name = "int4_en";
            desc = "ISP interrupt 4 mask.
- 0: No interrupt is generated.
- 1: An interrupt is generated.";
            sw = rw; hw = r;
            reset = 0x0;
        } int4_en[4:4];
        field {
            name = "int3_en";
            desc = "ISP interrupt 3 mask.
- 0: No interrupt is generated.
- 1: An interrupt is generated.";
            sw = rw; hw = r;
            reset = 0x0;
        } int3_en[3:3];
        field {
            name = "int2_en";
            desc = "ISP interrupt 2 mask.
- 0: No interrupt is generated.
- 1: An interrupt is generated.";
            sw = rw; hw = r;
            reset = 0x0;
        } int2_en[2:2];
        field {
            name = "int1_en";
            desc = "ISP interrupt 1 mask.
- 0: No interrupt is generated.
- 1: An interrupt is generated.";
            sw = rw; hw = r;
            reset = 0x0;
        } int1_en[1:1];
        field {
            name = "int0_en";
            desc = "ISP interrupt 0 mask.
- 0: No interrupt is generated.
- 1: An interrupt is generated.";
            sw = rw; hw = r;
            reset = 0x0;
        } int0_en[0:0];
    } ISP_INT_MASK @ 0x100f8;
};

`endif
