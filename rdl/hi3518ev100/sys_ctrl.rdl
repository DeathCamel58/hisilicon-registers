`ifndef EHI3518EV100_SYS_CTRL_RDL
`define EHI3518EV100_SYS_CTRL_RDL
regfile eHI3518EV100_SYS_CTRL {
    name = "System controller (SC)";
    desc = "System controller (SC). 32 registers extracted programmatically from the Hi3518E 720p IP Camera SoC data sheet (Issue 03, 2015-11-26); chapter 3.4.6, table 3-22. Field names, bit ranges, access types and reset values are taken from the register tables; reset values are the data sheet total reset values split onto the fields (per-field values where the table has them). Label: PROVEN. Hardware not verified here (no board).";
    reg {
        name = "SC_CTRL";
        desc = "SC_CTRL is a system control register. It is used to specify the operations that are performed by the system. Write protection for this register can be enabled by configuring SC_LOCKEN. This register can be written only when write protection is disabled. SC_CTRL (offset 0x000, total reset 0x0000_0212; PROVEN: Hi3518E V100 data sheet, PDF page 198, section 3.4.6).";
        field {
            name = "reserved";
            desc = "Reserved.";
            sw = rw; hw = r;
            reset = 0x0;
        } reserved_31_24[31:24];
        field {
            name = "wdogenov";
            desc = "Watchdog count clock select.
- 0: 3 MHz clock
- 1: bus clock";
            sw = rw; hw = r;
            reset = 0x0;
        } wdogenov[23:23];
        field {
            name = "timeren3ov";
            desc = "Count clock select of timer3.
- 0: 3 MHz clock.
- 1: bus clock";
            sw = rw; hw = r;
            reset = 0x0;
        } timeren3ov[22:22];
        field {
            name = "reserved";
            desc = "Reserved.";
            sw = rw; hw = r;
            reset = 0x0;
        } reserved_21_21[21:21];
        field {
            name = "timeren2ov";
            desc = "Count clock select of timer2.
- 0: 3 MHz clock
- 1: bus clock";
            sw = rw; hw = r;
            reset = 0x0;
        } timeren2ov[20:20];
        field {
            name = "reserved";
            desc = "Reserved.";
            sw = rw; hw = r;
            reset = 0x0;
        } reserved_19_19[19:19];
        field {
            name = "timeren1ov";
            desc = "Count clock select of timer1.
- 0: 3 MHz clock
- 1: bus clock";
            sw = rw; hw = r;
            reset = 0x0;
        } timeren1ov[18:18];
        field {
            name = "reserved";
            desc = "Reserved.";
            sw = rw; hw = r;
            reset = 0x0;
        } reserved_17_17[17:17];
        field {
            name = "timeren0ov";
            desc = "Count clock select of timer0.
- 0: 3 MHz clock
- 1: bus clock";
            sw = rw; hw = r;
            reset = 0x0;
        } timeren0ov[16:16];
        field {
            name = "reserved";
            desc = "Reserved.";
            sw = rw; hw = r;
            reset = 0x0;
        } reserved_15_15[15:15];
        field {
            name = "reserved";
            desc = "Reserved. Reading this field returns 0 and writing to this field has no effect.";
            sw = r; hw = na;
            reset = 0x0;
        } reserved_14_10[14:10];
        field {
            name = "remapstat";
            desc = "Status of address remap.
- 0: The address is not remapped.
- 1: The address is remapped. The details are as follows:

SFC is remapped to address 0.";
            sw = r; hw = w;
            reset = 0x1;
        } remapstat[9:9];
        field {
            name = "remapclear";
            desc = "Address remap clear.
- 0: keep the remap status
- 1: clear the remap status

For details about the address mappings before and after remapping is cleared, see Table 1-1.";
            sw = rw; hw = r;
            reset = 0x0;
        } remapclear[8:8];
        field {
            name = "reserved";
            desc = "Reserved. Reading this bit returns 0 and writing to this bit has no effect.";
            sw = r; hw = na;
            reset = 0x0;
        } reserved_7_7[7:7];
        field {
            name = "modestatus";
            desc = "Mode status. The current operating mode of the system is returned.
- 0x0: reserved
- 0x1: doze
- 0x2: slow
- 0x3: XTAL CTL
- 0x4: normal
- 0x6: PLL CTL
- 0x9: SW from XTAL
- 0xA: SW from PLL
- 0xB: SW to XTAL
- 0xE: SW to PLL

Other values: reserved";
            sw = rw; hw = r;
            reset = 0x2;
        } modestatus[6:3];
        field {
            name = "modectrl";
            desc = "Mode control. This field defines the operating mode to which the system controller is switched.
- 000: reserved
- 001: doze
- 010: slow
- 100: normal";
            sw = rw; hw = r;
            reset = 0x2;
        } modectrl[2:0];
    } SC_CTRL @ 0x0;
    reg {
        name = "SC_SYSRES";
        desc = "SC_SYSRES is a system soft reset register. When any value is written to this register, the system controller transmits a system soft reset request to the reset module. Then the reset module resets the system. Write protection for this register can be enabled by configuring SC_LOCKEN. This register can be written only when write protection is disabled. SC_SYSRES (offset 0x004, total reset 0x0000_0002; PROVEN: Hi3518E V100 data sheet, PDF page 200, section 3.4.6).";
        field {
            name = "softresreq";
            desc = "The system is reset when any value is written to this register.";
            sw = w; hw = r;
            reset = 0x2;
        } softresreq[31:0];
    } SC_SYSRES @ 0x4;
    reg {
        name = "SC_IMCTRL";
        desc = "SC_IMCTRL is an interrupt mode control register. It is used to control the system mode when an interrupt is generated. SC_IMCTRL (offset 0x008, total reset 0x0000_0000; PROVEN: Hi3518E V100 data sheet, PDF page 200, section 3.4.6).";
        field {
            name = "reserved";
            desc = "Reserved. Reading this field returns 0x000000 and writing to this field has no effect.";
            sw = r; hw = na;
            reset = 0x0;
        } reserved_31_8[31:8];
        field {
            name = "inmdtype";
            desc = "Type of the interrupt for triggering the interrupt mode of the system.
- 0: fast interrupt request (FIQ) interrupt
- 1: FIQ interrupt or interrupt request (IRQ) interrupt";
            sw = rw; hw = r;
            reset = 0x0;
        } inmdtype[7:7];
        field {
            name = "reserved";
            desc = "Reserved.";
            sw = r; hw = na;
            reset = 0x0;
        } reserved_6_4[6:4];
        field {
            name = "itmdctrl";
            desc = "Operating mode of the system with the lowest speed in interrupt mode. The value obtained after the values of this register and SC_CTRL[modectrl] are ORed indicates the operating mode of the system after an interrupt is generated. The definitions of these bits are as follows:
- 000: sleep
- 001: doze 01X: slow 1XX: normal";
            sw = rw; hw = r;
            reset = 0x0;
        } itmdctrl[3:1];
        field {
            name = "itmden";
            desc = "Interrupt mode enable.
- 0: disabled
- 1: enabled. When an interrupt is generated, the system enters the interrupt mode.";
            sw = rw; hw = r;
            reset = 0x0;
        } itmden[0:0];
    } SC_IMCTRL @ 0x8;
    reg {
        name = "SC_IMSTAT";
        desc = "SC_IMSTAT is an interrupt mode status register. It is used to check whether the system is in interrupt mode. The system can be set to the interrupt mode forcibly by configuring this register. When the interrupt service routine (ISR) ends, the interrupt mode must be cleared manually. SC_IMSTAT (offset 0x00C, total reset 0x0000_0000; PROVEN: Hi3518E V100 data sheet, PDF page 201, section 3.4.6).";
        field {
            name = "reserved";
            desc = "Reserved. Reading this field returns 0x00000000 and writing to this field has no effect.";
            sw = r; hw = na;
            reset = 0x0;
        } reserved_31_1[31:1];
        field {
            name = "itmdstat";
            desc = "Interrupt mode status. The bit is used by software for controlling whether the system enters the interrupt mode. When the register is read:
- 0: The system is not in interrupt mode.
- 1: The system is in interrupt mode.

When the register is written:
- 0: Software controls whether the system enters the interrupt mode.
- 1: Software does not control whether the system enters the interrupt mode.";
            sw = rw; hw = r;
            reset = 0x0;
        } itmdstat[0:0];
    } SC_IMSTAT @ 0xc;
    reg {
        name = "SC_XTALCTRL";
        desc = "SC_XTALCTRL is a crystal oscillator control register. It is used to specify the stable wait time after the clock module is initialized. The stable wait time is the period when the system is switched from the XTAL CTL mode to the SW-to-XTAL mode. SC_XTALCTRL (offset 0x010, total reset 0x0000_0000; PROVEN: Hi3518E V100 data sheet, PDF page 202, section 3.4.6).";
        field {
            name = "reserved";
            desc = "Reserved. Reading this field returns 0x0000 and writing to this field has no effect.";
            sw = r; hw = na;
            reset = 0x0;
        } reserved_31_19[31:19];
        field {
            name = "xtaltime";
            desc = "Wait time of crystal oscillator switching. The value of this field is used to specify the time spent on switching the system mode from XTAL CTL to SW-to-XTAL. The wait cycle can be calculated as follows: (65536 – xtaltime) x T46.8 K. T46.8 K indicates the clock cycle of the 46.8 kHz clock.";
            sw = rw; hw = r;
            reset = 0x0;
        } xtaltime[18:3];
        field {
            name = "reserved";
            desc = "Reserved. Reading this bit returns 0x0 and writing to this bit has no effect.";
            sw = r; hw = na;
            reset = 0x0;
        } reserved_2_2[2:2];
        field {
            name = "reserved";
            desc = "Reserved. Reading this field returns the written value and writing to this field has no effect.";
            sw = r; hw = na;
            reset = 0x0;
        } reserved_1_0[1:0];
    } SC_XTALCTRL @ 0x10;
    reg {
        name = "SC_PLLCTRL";
        desc = "SC_PLLCTRL is a PLL control register. It is used to control whether to enable the on-chip ARMPLL through software or system mode switching. It also sets the stable time of the ARMPLL. Write protection for this register can be enabled by configuring SC_LOCKEN. This register can be written only when write protection is disabled. When the ARMPLL is enabled by switching the system mode (namely, by configuring SC_PLLCTRL[pllover]), the ARMPLL is disabled automatically if the system is not in normal mode. The clock frequency of the APLL is controlled by PERI_CRG0 and PERI_CRG1. When the PLL frequency is changed, a stable clock can be output only after 0.5 ms. Therefore, the plltime of this register must meet this requirement. SC_PLLCTRL (offset 0x014, total reset 0x0000_0000; PROVEN: Hi3518E V100 data sheet, PDF page 203, section 3.4.6).";
        field {
            name = "reserved";
            desc = "Reserved. Reading this bit returns 0x0 and writing to this bit has no effect.";
            sw = r; hw = na;
            reset = 0x0;
        } reserved_31_28[31:28];
        field {
            name = "plltime";
            desc = "Stable time of the ARMPLL. This time refers to the period from the start of the PLL to the output of a stable PLL clock. That is, the wait time of switching the system mode from PLL CTL to SW-to-PLL. The timeout is calculated as follows: 4 x (33554432 – plltime) x TXIN. TXIN indicates the clock cycle of the external crystal oscillator of the Hi3518E.";
            sw = rw; hw = r;
            reset = 0x0;
        } plltime[27:3];
        field {
            name = "reserved";
            desc = "Reserved. Reading this bit returns 0x0 and writing to this bit has no effect.";
            sw = r; hw = na;
            reset = 0x0;
        } reserved_2_2[2:2];
        field {
            name = "reserved";
            desc = "Reserved.";
            sw = r; hw = na;
            reset = 0x0;
        } reserved_1_1[1:1];
        field {
            name = "pllover";
            desc = "Whether the ARMPLL is enabled is controlled by the software rather than system mode switching. This bit must be set to 0.
- 0: The ARMPLL is enabled by switching the system mode.
- 1: reserved";
            sw = rw; hw = r;
            reset = 0x0;
        } pllover[0:0];
    } SC_PLLCTRL @ 0x14;
    reg {
        name = "PERIPHCTRL0";
        desc = "PERIPHCTRL0 is peripheral control register 0. Write protection for this register can be enabled by configuring SC_LOCKEN. This register can be written only when write protection is disabled. PERIPHCTRL0 (offset 0x01C, total reset 0x0022_1000; PROVEN: Hi3518E V100 data sheet, PDF page 204, section 3.4.6).";
        field {
            name = "reserved";
            desc = "Reserved.";
            sw = r; hw = na;
            reset = 0x0;
        } reserved_31_23[31:23];
        field {
            name = "arm_tcm_gate_en";
            desc = "ARM TCM dynamic clock gating enable.
- 0: disabled
- 1: enabled";
            sw = rw; hw = r;
            reset = 0x0;
        } arm_tcm_gate_en[22:22];
        field {
            name = "arm_mem_adjust";
            desc = "ARM9 memory adjustment.";
            sw = rw; hw = r;
            reset = 0x22;
        } arm_mem_adjust[21:16];
        field {
            name = "reserved";
            desc = "Reserved.";
            sw = r; hw = na;
            reset = 0x0;
        } reserved_15_15[15:15];
        field {
            name = "global_software_int";
            desc = "Global software interrupt.
- 0: No interrupt is generated.
- 1: An interrupt is generated.";
            sw = rw; hw = r;
            reset = 0x0;
        } global_software_int[14:14];
        field {
            name = "reserved";
            desc = "Reserved.";
            sw = r; hw = na;
            reset = 0x0;
        } reserved_13_13[13:13];
        field {
            name = "ddrc_apb_gt_en";
            desc = "DDRC APB clock gating.
- 0: disabled
- 1: enabled";
            sw = rw; hw = r;
            reset = 0x1;
        } ddrc_apb_gt_en[12:12];
        field {
            name = "reserved";
            desc = "Reserved.";
            sw = r; hw = na;
            reset = 0x0;
        } reserved_11_0[11:0];
    } PERIPHCTRL0 @ 0x1c;
    reg {
        name = "PERIPHCTRL1";
        desc = "PERIPHCTRL1 is a software interrupt configuration register. PERIPHCTRL1 (offset 0x0020, total reset 0x0000_0000; PROVEN: Hi3518E V100 data sheet, PDF page 205, section 3.4.6).";
        field {
            name = "reserved";
            desc = "Reserved.";
            sw = r; hw = na;
            reset = 0x0;
        } reserved_31_1[31:1];
        field {
            name = "software_int";
            desc = "Software interrupts.
- 0: No interrupt is generated.
- 1: An interrupt is generated.";
            sw = rw; hw = r;
            reset = 0x0;
        } software_int[0:0];
    } PERIPHCTRL1 @ 0x20;
    reg {
        name = "PERIPHCTRL3";
        desc = "PERIPHCTRL3 is peripheral control register 3 (MDDRC out-of-order configuration register outtodr_ctrl). PERIPHCTRL3 (offset 0x0038, total reset 0x0000_0000; PROVEN: Hi3518E V100 data sheet, PDF page 206, section 3.4.6).";
        field {
            name = "reserved";
            desc = "Reserved.";
            sw = r; hw = w;
            reset = 0x0;
        } reserved_31_20[31:20];
        field {
            name = "reserved";
            desc = "Reserved.";
            sw = r; hw = w;
            reset = 0x0;
        } reserved_19_18[19:18];
        field {
            name = "ive_ctrl";
            desc = "Indicates whether out-of-order is allowed when the IVE subsystem accesses DDR.
- 0: Out-of-order is not allowed.
- 1: Out-of-order is allowed.";
            sw = rw; hw = r;
            reset = 0x0;
        } ive_ctrl[17:17];
        field {
            name = "reserved";
            desc = "Reserved.";
            sw = r; hw = w;
            reset = 0x0;
        } reserved_16_8[16:8];
        field {
            name = "mdu_ddrt_ctrl";
            desc = "Indicates whether out-of-order is allowed when MDU or DDRT accesses DDR.
- 0: Out-of-order is not allowed.
- 1: Out-of-order is allowed.";
            sw = rw; hw = r;
            reset = 0x0;
        } mdu_ddrt_ctrl[7:7];
        field {
            name = "jpge_ctrl";
            desc = "Indicates whether out-of-order is allowed when JPGE accesses DDR.
- 0: Out-of-order is not allowed.
- 1: Out-of-order is allowed.";
            sw = rw; hw = r;
            reset = 0x0;
        } jpge_ctrl[6:6];
        field {
            name = "tde_ctrl";
            desc = "Indicates whether out-of-order is allowed when TDE accesses DDR.
- 0: Out-of-order is not allowed.
- 1: Out-of-order is allowed.";
            sw = rw; hw = r;
            reset = 0x0;
        } tde_ctrl[5:5];
        field {
            name = "vpss_ctrl";
            desc = "Indicates whether out-of-order is allowed when VPSS accesses DDR.
- 0: Out-of-order is not allowed.
- 1: Out-of-order is allowed.";
            sw = rw; hw = r;
            reset = 0x0;
        } vpss_ctrl[4:4];
        field {
            name = "venc_ctrl";
            desc = "Indicates whether out-of-order is allowed when VENC accesses DDR.
- 0: Out-of-order is not allowed.
- 1: Out-of-order is allowed.";
            sw = rw; hw = r;
            reset = 0x0;
        } venc_ctrl[3:3];
        field {
            name = "reserved";
            desc = "Reserved.";
            sw = r; hw = w;
            reset = 0x0;
        } reserved_2_2[2:2];
        field {
            name = "vicap_ctrl";
            desc = "Indicates whether out-of-order is allowed when the VICAP accesses DDR.
- 0: Out-of-order is not allowed.
- 1: Out-of-order is allowed.";
            sw = rw; hw = r;
            reset = 0x0;
        } vicap_ctrl[1:1];
        field {
            name = "vou_ctrl";
            desc = "Indicates whether out-of-order is allowed when the VOU accesses DDR.
- 0: Out-of-order is not allowed.
- 1: Out-of-order is allowed.";
            sw = rw; hw = r;
            reset = 0x0;
        } vou_ctrl[0:0];
    } PERIPHCTRL3 @ 0x38;
    reg {
        name = "PERIPHCTRL4";
        desc = "PERIPHCTRL4 is peripheral control register 4. PERIPHCTRL4 (offset 0x003C, total reset 0x0000_01E0; PROVEN: Hi3518E V100 data sheet, PDF page 207, section 3.4.6).";
        field {
            name = "reserved";
            desc = "Reserved.";
            sw = r; hw = w;
            reset = 0x0;
        } reserved_31_17[31:17];
        field {
            name = "cbar_en";
            desc = "cbar_en output enable.
- 0: disabled
- 1: enabled";
            sw = rw; hw = r;
            reset = 0x0;
        } cbar_en[16:16];
        field {
            name = "mdu_ddrt_sel";
            desc = "Motion detection unit (MDU) and DDR test (DDRT) function select.
- 0: Only the MDU is enabled.
- 1: Only the DDRT is enabled.";
            sw = rw; hw = r;
            reset = 0x0;
        } mdu_ddrt_sel[15:15];
        field {
            name = "reserved";
            desc = "Reserved.";
            sw = r; hw = w;
            reset = 0x3c;
        } reserved_14_3[14:3];
        field {
            name = "sdio_det_mode";
            desc = "Signal detection mode of the SDIO card.
- 0: active low
- 1: active high";
            sw = rw; hw = r;
            reset = 0x0;
        } sdio_det_mode[2:2];
        field {
            name = "uart1_rts_ctrl";
            desc = "UART1 RTS output control.
- 0: normal output
- 1: reverse output";
            sw = rw; hw = r;
            reset = 0x0;
        } uart1_rts_ctrl[1:1];
        field {
            name = "reserved";
            desc = "Reserved.";
            sw = r; hw = w;
            reset = 0x0;
        } reserved_0_0[0:0];
    } PERIPHCTRL4 @ 0x3c;
    reg {
        name = "PERIPHCTRL5";
        desc = "PERIPHCTRL5 is peripheral control register 5 (media bus timeout control register 1 for master port l). PERIPHCTRL5 (offset 0x0040, total reset 0x0000_0000; PROVEN: Hi3518E V100 data sheet, PDF page 208, section 3.4.6).";
        field {
            name = "count_en_media0_port1";
            desc = "Timeout count enable of the VPSS port.
- 0: Disabled;
- 1: Enabled.";
            sw = rw; hw = r;
            reset = 0x0;
        } count_en_media0_port1[31:31];
        field {
            name = "over_value_media0_port1";
            desc = "Timeout count value of the VPSS port.
Count value = over_value_media0_port1 x 2.";
            sw = rw; hw = r;
            reset = 0x0;
        } over_value_media0_port1[30:16];
        field {
            name = "count_en_media0_port0";
            desc = "Timeout count enable of the VENC port.
- 0: Disabled;
- 1: Enabled.";
            sw = rw; hw = r;
            reset = 0x0;
        } count_en_media0_port0[15:15];
        field {
            name = "over_value_media0_port0";
            desc = "Timeout count value of the VENC port.
Count value = over_value_media0_port0 x 2.";
            sw = rw; hw = r;
            reset = 0x0;
        } over_value_media0_port0[14:0];
    } PERIPHCTRL5 @ 0x40;
    reg {
        name = "SC_LOCKEN";
        desc = "SC_LOCKEN is a register for locking key system control registers. SC_LOCKEN (offset 0x0044, total reset 0x0000_0000; PROVEN: Hi3518E V100 data sheet, PDF page 209, section 3.4.6).";
        field {
            name = "scper_lockl";
            desc = "Register for locking key system control registers. The key registers include SC_CTRL, SYSSTAT, and SC_PLLCTRL. When 0x1ACC_E551 is written to SC_LOCKEN, the write permission for all registers is enabled; when any other value is written to SC_LOCKEN, the write permission is disabled. Reading this register returns the lock status rather than its written value. 0x0000_0000: The write permission is enabled (unlocked). 0x0000_0001: The write permission is disabled (locked).";
            sw = rw; hw = r;
            reset = 0x0;
        } scper_lockl[31:0];
    } SC_LOCKEN @ 0x44;
    reg {
        name = "PERIPHCTRL6";
        desc = "PERIPHCTRL6 is peripheral control register 6 (media bus timeout control register 2 for master port l). PERIPHCTRL6 (offset 0x0048, total reset 0x0000_0000; PROVEN: Hi3518E V100 data sheet, PDF page 209, section 3.4.6).";
        field {
            name = "count_en_media0_port3";
            desc = "Timeout count enable of the JPGE port.
- 0: Disabled;
- 1: Enabled.";
            sw = rw; hw = r;
            reset = 0x0;
        } count_en_media0_port3[31:31];
        field {
            name = "over_value_media0_port3";
            desc = "Timeout count value of the JPGE port.
Count value = over_value_media0_port3 x 2.";
            sw = rw; hw = r;
            reset = 0x0;
        } over_value_media0_port3[30:16];
        field {
            name = "count_en_media0_port2";
            desc = "Timeout count enable of the TDE port.
- 0: Disabled;
- 1: Enabled.";
            sw = rw; hw = r;
            reset = 0x0;
        } count_en_media0_port2[15:15];
        field {
            name = "over_value_media0_port2";
            desc = "Timeout count value of the TDE port.
Count value = over_value_media0_port2 x 2.";
            sw = rw; hw = r;
            reset = 0x0;
        } over_value_media0_port2[14:0];
    } PERIPHCTRL6 @ 0x48;
    reg {
        name = "PERIPHCTRL7";
        desc = "PERIPHCTRL7 is peripheral control register 7 (media bus timeout control register 3 for master port l). PERIPHCTRL7 (offset 0x004C, total reset 0x0000_0000; PROVEN: Hi3518E V100 data sheet, PDF page 210, section 3.4.6).";
        field {
            name = "reserved";
            desc = "Reserved.";
            sw = r; hw = w;
            reset = 0x0;
        } reserved_31_16[31:16];
        field {
            name = "count_en_media0_port4";
            desc = "Timeout count enable for the MDU port.
- 0: disabled
- 1: enabled";
            sw = rw; hw = r;
            reset = 0x0;
        } count_en_media0_port4[15:15];
        field {
            name = "over_value_media0_port4";
            desc = "Timeout count value of the MDU port. Count value = over_value_media0_port4 x 2";
            sw = rw; hw = r;
            reset = 0x0;
        } over_value_media0_port4[14:0];
    } PERIPHCTRL7 @ 0x4c;
    reg {
        name = "PERIPHCTRL9";
        desc = "PERIPHCTRL9 is peripheral control register 9 (media bus priority configuration register for master port l). PERIPHCTRL9 (offset 0x0054, total reset 0x0001_2345; PROVEN: Hi3518E V100 data sheet, PDF page 211, section 3.4.6).";
        field {
            name = "reserved";
            desc = "Reserved.";
            sw = r; hw = w;
            reset = 0x0;
        } reserved_31_19[31:19];
        field {
            name = "media0_port4_pri";
            desc = "MDU priority. The value 7 indicates the highest priority.";
            sw = rw; hw = r;
            reset = 0x1;
        } media0_port4_pri[18:16];
        field {
            name = "reserved";
            desc = "Reserved.";
            sw = r; hw = w;
            reset = 0x0;
        } reserved_15_15[15:15];
        field {
            name = "media0_port3_pri";
            desc = "JPGE priority. The value 7 indicates the highest priority.";
            sw = rw; hw = r;
            reset = 0x2;
        } media0_port3_pri[14:12];
        field {
            name = "reserved";
            desc = "Reserved.";
            sw = r; hw = w;
            reset = 0x0;
        } reserved_11_11[11:11];
        field {
            name = "media0_port2_pri";
            desc = "TDE priority. The value 7 indicates the highest priority.";
            sw = rw; hw = r;
            reset = 0x3;
        } media0_port2_pri[10:8];
        field {
            name = "reserved";
            desc = "Reserved.";
            sw = r; hw = w;
            reset = 0x0;
        } reserved_7_7[7:7];
        field {
            name = "media0_port1_pri";
            desc = "VPSS priority. The value 7 indicates the highest priority.";
            sw = rw; hw = r;
            reset = 0x4;
        } media0_port1_pri[6:4];
        field {
            name = "reserved";
            desc = "Reserved.";
            sw = r; hw = w;
            reset = 0x0;
        } reserved_3_3[3:3];
        field {
            name = "media0_port0_pri";
            desc = "VENC priority. The value 7 indicates the highest priority.";
            sw = rw; hw = r;
            reset = 0x5;
        } media0_port0_pri[2:0];
    } PERIPHCTRL9 @ 0x54;
    reg {
        name = "PERIPHCTRL10";
        desc = "PERIPHCTRL10 is peripheral control register 10 (system bus timeout control register 1 for master port l). PERIPHCTRL10 (offset 0x0058, total reset 0x0000_0000; PROVEN: Hi3518E V100 data sheet, PDF page 212, section 3.4.6).";
        field {
            name = "count_en_port1";
            desc = "Timeout count enable for ARMD port.
- 0: disabled
- 1: enabled";
            sw = rw; hw = r;
            reset = 0x0;
        } count_en_port1[31:31];
        field {
            name = "over_value_port1";
            desc = "Timeout count value of ARMD port. Count value = over_value_port1 x 2";
            sw = rw; hw = r;
            reset = 0x0;
        } over_value_port1[30:16];
        field {
            name = "count_en_port0";
            desc = "Timeout count enable for the AHB bridge port
- 0: disabled
- 1: enabled";
            sw = rw; hw = r;
            reset = 0x0;
        } count_en_port0[15:15];
        field {
            name = "over_value_port0";
            desc = "Timeout count value of the AHB bridge port. Count value = over_value_port0 x 2";
            sw = rw; hw = r;
            reset = 0x0;
        } over_value_port0[14:0];
    } PERIPHCTRL10 @ 0x58;
    reg {
        name = "PERIPHCTRL11";
        desc = "PERIPHCTRL11 is peripheral control register 11 (system bus timeout control register 2 for master port l). PERIPHCTRL11 (offset 0x005C, total reset 0x0000_0000; PROVEN: Hi3518E V100 data sheet, PDF page 212, section 3.4.6).";
        field {
            name = "count_en_port3";
            desc = "Timeout count enable for the ARMI port.
- 0: disabled
- 1: enabled";
            sw = rw; hw = r;
            reset = 0x0;
        } count_en_port3[31:31];
        field {
            name = "over_value_port3";
            desc = "Timeout count value of the ARMI port. Count value = over_value_port3 x 2";
            sw = rw; hw = r;
            reset = 0x0;
        } over_value_port3[30:16];
        field {
            name = "count_en_port2";
            desc = "Timeout count enable for the IVE port.
- 0: disabled
- 1: enabled";
            sw = rw; hw = r;
            reset = 0x0;
        } count_en_port2[15:15];
        field {
            name = "over_value_port2";
            desc = "Timeout count value of the IVE port. Count value = over_value_port2 x 2";
            sw = rw; hw = r;
            reset = 0x0;
        } over_value_port2[14:0];
    } PERIPHCTRL11 @ 0x5c;
    reg {
        name = "PERIPHCTRL12";
        desc = "PERIPHCTRL12 is peripheral control register 12 (system bus priority configuration register for master port l). PERIPHCTRL12 (offset 0x0060, total reset 0x0000_1234; PROVEN: Hi3518E V100 data sheet, PDF page 213, section 3.4.6).";
        field {
            name = "reserved";
            desc = "Reserved.";
            sw = r; hw = w;
            reset = 0x0;
        } reserved_31_15[31:15];
        field {
            name = "mst_pri3";
            desc = "ARMI priority. The value 4 indicates the highest priority.";
            sw = rw; hw = r;
            reset = 0x1;
        } mst_pri3[14:12];
        field {
            name = "reserved";
            desc = "Reserved.";
            sw = r; hw = w;
            reset = 0x0;
        } reserved_11_11[11:11];
        field {
            name = "mst_pri2";
            desc = "IVE priority. The value 4 indicates the highest priority.";
            sw = rw; hw = r;
            reset = 0x2;
        } mst_pri2[10:8];
        field {
            name = "reserved";
            desc = "Reserved.";
            sw = r; hw = w;
            reset = 0x0;
        } reserved_7_7[7:7];
        field {
            name = "mst_pri1";
            desc = "Priority of ARMD. The value 4 indicates the highest priority.";
            sw = rw; hw = r;
            reset = 0x3;
        } mst_pri1[6:4];
        field {
            name = "reserved";
            desc = "Reserved.";
            sw = r; hw = w;
            reset = 0x0;
        } reserved_3_3[3:3];
        field {
            name = "mst_pri0";
            desc = "Priority of AHB bridge. The value 4 indicates the highest priority.";
            sw = rw; hw = r;
            reset = 0x4;
        } mst_pri0[2:0];
    } PERIPHCTRL12 @ 0x60;
    reg {
        name = "PERIPHCTRL13";
        desc = "PERIPHCTRL13 is peripheral control register 13 (system bus priority configuration register for slave port l). PERIPHCTRL13 (offset 0x0064, total reset 0x0000_1234; PROVEN: Hi3518E V100 data sheet, PDF page 214, section 3.4.6).";
        field {
            name = "reserved";
            desc = "Reserved.";
            sw = r; hw = w;
            reset = 0x0;
        } reserved_31_19[31:19];
        field {
            name = "reserved";
            desc = "Reserved.";
            sw = r; hw = w;
            reset = 0x0;
        } reserved_18_15[18:15];
        field {
            name = "slave_priority_s4";
            desc = "Priority for accessing the MDDRC bus over the SYS AXI s4 port. The value 4 indicates the highest priority.";
            sw = rw; hw = r;
            reset = 0x1;
        } slave_priority_s4[14:12];
        field {
            name = "reserved";
            desc = "Reserved.";
            sw = r; hw = na;
            reset = 0x0;
        } reserved_11_11[11:11];
        field {
            name = "slave_priority_s3";
            desc = "Priority for accessing the APB_MEDIA bus over the SYS AXI s3 port. The value 4 indicates the highest priority.";
            sw = rw; hw = r;
            reset = 0x2;
        } slave_priority_s3[10:8];
        field {
            name = "reserved";
            desc = "Reserved.";
            sw = r; hw = na;
            reset = 0x0;
        } reserved_7_7[7:7];
        field {
            name = "slave_priority_s2";
            desc = "Priority for accessing the APB_SYS bus over the SYS AXI s2 port. The value 4 indicates the highest priority.";
            sw = rw; hw = r;
            reset = 0x3;
        } slave_priority_s2[6:4];
        field {
            name = "reserved";
            desc = "Reserved.";
            sw = r; hw = na;
            reset = 0x0;
        } reserved_3_3[3:3];
        field {
            name = "slave_priority_s1";
            desc = "Priority for accessing the AHB of the SYS AXI s1 port. The value 4 indicates the highest priority.";
            sw = rw; hw = r;
            reset = 0x4;
        } slave_priority_s1[2:0];
    } PERIPHCTRL13 @ 0x64;
    reg {
        name = "PERIPHCTRL14";
        desc = "PERIPHCTRL14 is peripheral control register 14 (audio CODEC control register 0). PERIPHCTRL14 (offset 0x0068, total reset 0x0000_0000; PROVEN: Hi3518E V100 data sheet, PDF page 215, section 3.4.6).";
        field {
            name = "pd_adcl";
            desc = "Power-down control for the analog-to-digital converter left (ADCL).
- 0: The digital and analog parts of the ADCL work normally.
- 1: The digital and analog parts of the ADCL are powered down.";
            sw = rw; hw = r;
            reset = 0x0;
        } pd_adcl[31:31];
        field {
            name = "pd_adcr";
            desc = "Power-down control for the analog-to-digital converter right (ADCR).
- 0: The digital and analog parts of the ADCR work normally.
- 1: The digital and analog parts of the ADCR are powered down.";
            sw = rw; hw = r;
            reset = 0x0;
        } pd_adcr[30:30];
        field {
            name = "pd_dacl";
            desc = "Power-down control for the digital-to-analog converter left (DACL).
- 0: The digital and analog parts of the DACL work normally.
- 1: The digital and analog parts of the DACL are powered down.";
            sw = rw; hw = r;
            reset = 0x0;
        } pd_dacl[29:29];
        field {
            name = "pd_dacr";
            desc = "Power-down control for the digital-to-analog converter right (DACR).
- 0: The digital and analog parts of the DACR work normally.
- 1: The digital and analog parts of the DACR are powered down.";
            sw = rw; hw = r;
            reset = 0x0;
        } pd_dacr[28:28];
        field {
            name = "pd_micbias";
            desc = "MICBIAS power-down control signal.
- 0: The MICBIAS works properly.
- 1: The MICBIAS is powered down.";
            sw = rw; hw = r;
            reset = 0x0;
        } pd_micbias[27:27];
        field {
            name = "pd_vref";
            desc = "Reference voltage power-down control signal.
- 0: The reference voltage is normal.
- 1: The reference voltage is powered down.";
            sw = rw; hw = r;
            reset = 0x0;
        } pd_vref[26:26];
        field {
            name = "reserved";
            desc = "Reserved";
            sw = r; hw = w;
            reset = 0x0;
        } reserved_25_25[25:25];
        field {
            name = "ana_loop";
            desc = "Analog loop control signal.
- 0: normal mode
- 1: analog loop mode";
            sw = rw; hw = r;
            reset = 0x0;
        } ana_loop[24:24];
        field {
            name = "mute_dacl";
            desc = "Mute control for the DACL.
- 0: The DACL works normally.
- 1: The DACR is muted.";
            sw = rw; hw = r;
            reset = 0x0;
        } mute_dacl[23:23];
        field {
            name = "mute_dacr";
            desc = "Mute control for the DACR.
- 0: The DACR works normally.
- 1: The DACR is muted.";
            sw = rw; hw = r;
            reset = 0x0;
        } mute_dacr[22:22];
        field {
            name = "popfreel";
            desc = "Pop free control for the DACL.
- 0: The pop free function is disabled.
- 1: The pop free function is enabled. The pop free function is required only in ultra-low-power mode. In this case, the capacitor at the LINEOUT end of the DACL is charged until the voltage is

AVDD/2.";
            sw = rw; hw = r;
            reset = 0x0;
        } popfreel[21:21];
        field {
            name = "popfreer";
            desc = "Pop free control for the DACR.
- 0: The pop free function is disabled.
- 1: The pop free function is enabled. The pop free function is required only in ultra-low-power mode. In this case, the capacitor at the LINEOUT end of the DACR is charged until the voltage is

AVDD/2.";
            sw = rw; hw = r;
            reset = 0x0;
        } popfreer[20:20];
        field {
            name = "mute_micl";
            desc = "LINEIN mute control for the left channel.
- 0: The left channel of the LINEIN works normally.
- 1: The left channel of the LINEIN is muted.";
            sw = rw; hw = r;
            reset = 0x0;
        } mute_micl[19:19];
        field {
            name = "mute_micr";
            desc = "LINEIN mute control for the right channel.
- 0: The right channel of the LINEIN works normally.
- 1: The right channel of the LINEIN is muted.";
            sw = rw; hw = r;
            reset = 0x0;
        } mute_micr[18:18];
        field {
            name = "reserved";
            desc = "Reserved. This bit is fixed at 1.";
            sw = r; hw = w;
            reset = 0x0;
        } reserved_17_17[17:17];
        field {
            name = "reserved";
            desc = "Reserved. This bit is fixed at 0.";
            sw = r; hw = w;
            reset = 0x0;
        } reserved_16_15[16:15];
        field {
            name = "gain_micl";
            desc = "Gain control for the LINEINL input end.
- 0x00: –16.5 dB
- 0x01: –15 dB
- 0x02: –13.5 dB ...
- 0x0B: 0 dB
- 0x0C: 1.5 dB ...
- 0x1F: 30 dB";
            sw = rw; hw = r;
            reset = 0x0;
        } gain_micl[14:10];
        field {
            name = "gainboostl";
            desc = "LINEINL gain boost control.
- 0: 0 dB
- 1: 26 dB";
            sw = rw; hw = r;
            reset = 0x0;
        } gainboostl[9:9];
        field {
            name = "reserved";
            desc = "Reserved. This bit is fixed at 0.";
            sw = r; hw = w;
            reset = 0x0;
        } reserved_8_7[8:7];
        field {
            name = "gain_micr";
            desc = "Gain control for the LINEINL input end.
- 0x00: –16.5 dB
- 0x01: –15 dB
- 0x02: –13.5 dB ...
- 0x0B: 0 dB
- 0x0C: 1.5 dB ...
- 0x1F: 30 dB";
            sw = rw; hw = r;
            reset = 0x0;
        } gain_micr[6:2];
        field {
            name = "gainboostr";
            desc = "LINEINR gain boost control.
- 0: 0 dB
- 1: 26 dB";
            sw = rw; hw = r;
            reset = 0x0;
        } gainboostr[1:1];
        field {
            name = "reserved";
            desc = "Reserved. This bit is fixed at 0.";
            sw = r; hw = w;
            reset = 0x0;
        } reserved_0_0[0:0];
    } PERIPHCTRL14 @ 0x68;
    reg {
        name = "PERIPHCTRL15";
        desc = "PERIPHCTRL15 is peripheral control register 15 (audio CODEC control register 1). PERIPHCTRL15 (offset 0x006C, total reset 0x0000_0000; PROVEN: Hi3518E V100 data sheet, PDF page 217, section 3.4.6). Data sheet inconsistency: the total reset value reads 0x0000_0000 (used here) but the bit diagram shows 0x00F3_DE75; the audio codec registers of the Hi3535 (MISC_CTRL51-55) and Hi3520D with the same field layout have non-zero defaults equal to the bit diagram, so the bit diagram is probably right (UNVERIFIED).";
        field {
            name = "dacl_rst_n";
            desc = "DACL reset signal.
- 0: valid
- 1: invalid";
            sw = rw; hw = r;
            reset = 0x0;
        } dacl_rst_n[31:31];
        field {
            name = "dacr_rst_n";
            desc = "DACR reset signal.
- 0: valid
- 1: invalid";
            sw = rw; hw = r;
            reset = 0x0;
        } dacr_rst_n[30:30];
        field {
            name = "adcl_rst_n";
            desc = "ADCL reset signal.
- 0: valid
- 1: invalid";
            sw = rw; hw = r;
            reset = 0x0;
        } adcl_rst_n[29:29];
        field {
            name = "adcr_rst_n";
            desc = "ADCR reset signal.
- 0: valid
- 1: invalid";
            sw = rw; hw = r;
            reset = 0x0;
        } adcr_rst_n[28:28];
        field {
            name = "dacl_en";
            desc = "DACL enable signal.
- 0: disabled
- 1: enabled";
            sw = rw; hw = r;
            reset = 0x0;
        } dacl_en[27:27];
        field {
            name = "dacr_en";
            desc = "DACR enable signal.
- 0: disabled
- 1: enabled";
            sw = rw; hw = r;
            reset = 0x0;
        } dacr_en[26:26];
        field {
            name = "adcl_en";
            desc = "ADCL enable signal.
- 0: disabled
- 1: enabled";
            sw = rw; hw = r;
            reset = 0x0;
        } adcl_en[25:25];
        field {
            name = "adcr_en";
            desc = "ADCR enable signal.
- 0: disabled
- 1: enabled";
            sw = rw; hw = r;
            reset = 0x0;
        } adcr_en[24:24];
        field {
            name = "reserved";
            desc = "Reserved.";
            sw = r; hw = w;
            reset = 0x0;
        } reserved_23_18[23:18];
        field {
            name = "i2s1_fs_sel";
            desc = "I2S1 sample rate select.
- 00000: 8 kHz, 16.896 MHz mclk
- 00001: 16 kHz, 16.896 MHz mclk
- 00010: 32 kHz, 16.896 MHz mclk
- 00011: 64 kHz, 16.896 MHz mclk 001xx: 128 kHz, 16.896 MHz mclk
- 01000: 11 kHz, 16.896 MHz mclk
- 01001: 22 kHz, 16.896 MHz mclk
- 01010: 44 kHz, 16.896 MHz mclk
- 01011: 88 kHz, 16.896 MHz mclk 011xx: 176 kHz, 16.896 MHz mclk
- 10000: 12 kHz, 16.896 MHz mclk
- 10001: 24 kHz, 16.896 MHz mclk
- 10010: 48 kHz, 16.896 MHz mclk
- 10011: 96 kHz, 16.896 MHz mclk 101xx: 192 kHz, 16.896 MHz mclk
- 11000: mclk/1024
- 11001: mclk/512
- 11010: mclk/256
- 11011: mclk/128 111xx: mclk/64";
            sw = rw; hw = r;
            reset = 0x0;
        } i2s1_fs_sel[17:13];
        field {
            name = "reserved";
            desc = "Reserved.";
            sw = r; hw = w;
            reset = 0x0;
        } reserved_12_1[12:1];
        field {
            name = "rst";
            desc = "Analog circuit reset.
- 0: normal mode
- 1: reset";
            sw = rw; hw = r;
            reset = 0x0;
        } rst[0:0];
    } PERIPHCTRL15 @ 0x6c;
    reg {
        name = "PERIPHCTRL16";
        desc = "PERIPHCTRL16 is peripheral control register 16 (audio CODEC control register 2). PERIPHCTRL16 (offset 0x0070, total reset 0x0000_0000; PROVEN: Hi3518E V100 data sheet, PDF page 219, section 3.4.6). Data sheet inconsistency: the total reset value reads 0x0000_0000 (used here) but the bit diagram shows 0x0000_0001; the audio codec registers of the Hi3535 (MISC_CTRL51-55) and Hi3520D with the same field layout have non-zero defaults equal to the bit diagram, so the bit diagram is probably right (UNVERIFIED).";
        field {
            name = "smutel";
            desc = "Soft mute control bit of the DACL.
- 0: Soft mute is disabled.
- 1: Soft mute is enabled.";
            sw = rw; hw = r;
            reset = 0x0;
        } smutel[31:31];
        field {
            name = "smuter";
            desc = "Soft mute control bit of the DACR.
- 0: Soft mute is disabled.
- 1: Soft mute is enabled.";
            sw = rw; hw = r;
            reset = 0x0;
        } smuter[30:30];
        field {
            name = "sunmutel";
            desc = "Soft unmute control bit of DACL.
- 0: Soft unmute is disabled.
- 1: Soft unmute is enabled.";
            sw = rw; hw = r;
            reset = 0x0;
        } sunmutel[29:29];
        field {
            name = "sunmuter";
            desc = "Soft unmute control bit of the DACR.
- 0: Soft unmute is disabled.
- 1: Soft unmute is enabled.";
            sw = rw; hw = r;
            reset = 0x0;
        } sunmuter[28:28];
        field {
            name = "dacvu";
            desc = "Volume update control bit of the DAC.
- 0: The volume is not updated.
- 1: The volume is updated.";
            sw = rw; hw = r;
            reset = 0x0;
        } dacvu[27:27];
        field {
            name = "mutel_rate";
            desc = "Soft mute rate control bit of the DACL.
- 00: fs/2
- 01: fs/8
- 10: fs/32
- 11: fs/64";
            sw = rw; hw = r;
            reset = 0x0;
        } mutel_rate[26:25];
        field {
            name = "muter_rate";
            desc = "Soft mute rate control bit of the DACR.
- 00: fs/2
- 01: fs/8
- 10: fs/32
- 11: fs/64";
            sw = rw; hw = r;
            reset = 0x0;
        } muter_rate[24:23];
        field {
            name = "reserved";
            desc = "Reserved.";
            sw = r; hw = w;
            reset = 0x0;
        } reserved_22_0[22:0];
    } PERIPHCTRL16 @ 0x70;
    reg {
        name = "PERIPHCTRL17";
        desc = "PERIPHCTRL17 is peripheral control register 17 (audio CODEC control register 3). PERIPHCTRL17 (offset 0x0074, total reset 0x0000_0000; PROVEN: Hi3518E V100 data sheet, PDF page 220, section 3.4.6). Data sheet inconsistency: the total reset value reads 0x0000_0000 (used here) but the bit diagram shows 0x0606_2424; the audio codec registers of the Hi3535 (MISC_CTRL51-55) and Hi3520D with the same field layout have non-zero defaults equal to the bit diagram, so the bit diagram is probably right (UNVERIFIED).";
        field {
            name = "dacl_mute";
            desc = "Mute control for the DACL.
- 0: normal mode
- 1: mute";
            sw = rw; hw = r;
            reset = 0x0;
        } dacl_mute[31:31];
        field {
            name = "dacl_vol";
            desc = "Volume control for the DACL.
- 0x00: 6 dB
- 0x01: 5 dB
- 0x02: 4 dB ...
- 0x7E: –120 dB
- 0x7F: mute";
            sw = rw; hw = r;
            reset = 0x0;
        } dacl_vol[30:24];
        field {
            name = "dacr_mute";
            desc = "Mute control for the DACR.
- 0: normal mode
- 1: mute";
            sw = rw; hw = r;
            reset = 0x0;
        } dacr_mute[23:23];
        field {
            name = "dacr_vol";
            desc = "Volume control for the DACR.
- 0x00: 6 dB
- 0x01: 5 dB
- 0x02: 4 dB ...
- 0x7E: –120 dB
- 0x7F: mute";
            sw = rw; hw = r;
            reset = 0x0;
        } dacr_vol[22:16];
        field {
            name = "reserved";
            desc = "Reserved.";
            sw = r; hw = w;
            reset = 0x0;
        } reserved_15_0[15:0];
    } PERIPHCTRL17 @ 0x74;
    reg {
        name = "PERIPHCTRL18";
        desc = "PERIPHCTRL18 is peripheral control register 18 (audio CODEC control register 4). PERIPHCTRL18 (offset 0x0078, total reset 0x0000_0000; PROVEN: Hi3518E V100 data sheet, PDF page 221, section 3.4.6). Data sheet inconsistency: the total reset value reads 0x0000_0000 (used here) but the bit diagram shows 0x1E1E_0001; the audio codec registers of the Hi3535 (MISC_CTRL51-55) and Hi3520D with the same field layout have non-zero defaults equal to the bit diagram, so the bit diagram is probably right (UNVERIFIED).";
        field {
            name = "adcl_mute";
            desc = "Mute control bit of the ADCL.
- 0: The ADCL is unmuted.
- 1: The ADCL is muted.";
            sw = rw; hw = r;
            reset = 0x0;
        } adcl_mute[31:31];
        field {
            name = "adcl_vol";
            desc = "Volume control for the ADCL.
- 00: 30 dB
- 01: 29 dB
- 02: 28 dB ... 7E: –96 dB 7F: –97 dB";
            sw = rw; hw = r;
            reset = 0x0;
        } adcl_vol[30:24];
        field {
            name = "adcr_mute";
            desc = "Mute control bit of the ADCR.
- 0: The ADCR is unmuted.
- 1: The ADCR is muted.";
            sw = rw; hw = r;
            reset = 0x0;
        } adcr_mute[23:23];
        field {
            name = "adcr_vol";
            desc = "Volume control for the ADCR.
- 00: 30 dB
- 01: 29 dB
- 02: 28 dB ... 7E: –96 dB 7F: –97 dB";
            sw = rw; hw = r;
            reset = 0x0;
        } adcr_vol[22:16];
        field {
            name = "adcl_hpf_en";
            desc = "High-pass filter enable control for the ADCL.
- 0: disabled
- 1: enabled";
            sw = rw; hw = r;
            reset = 0x0;
        } adcl_hpf_en[15:15];
        field {
            name = "adcr_hpf_en";
            desc = "High-pass filter enable control for the ADCR.
- 0: disabled
- 1: enabled";
            sw = rw; hw = r;
            reset = 0x0;
        } adcr_hpf_en[14:14];
        field {
            name = "reserved";
            desc = "Reserved.";
            sw = rw; hw = r;
            reset = 0x0;
        } reserved_13_0[13:0];
    } PERIPHCTRL18 @ 0x78;
    reg {
        name = "PERIPHCTRL19";
        desc = "PERIPHCTRL19 is peripheral control register 19 (audio CODEC control register 5). PERIPHCTRL19 (offset 0x007C, total reset 0x0000_0000; PROVEN: Hi3518E V100 data sheet, PDF page 222, section 3.4.6). Data sheet inconsistency: the total reset value reads 0x0000_0000 (used here) but the bit diagram shows 0x2424_2424; the audio codec registers of the Hi3535 (MISC_CTRL51-55) and Hi3520D with the same field layout have non-zero defaults equal to the bit diagram, so the bit diagram is probably right (UNVERIFIED).";
        field {
            name = "adcl2dacl_en";
            desc = "Mixer control signal of adcl2dacl.
- 0: disabled
- 1: enabled";
            sw = rw; hw = r;
            reset = 0x0;
        } adcl2dacl_en[31:31];
        field {
            name = "adcl2dacl_vol";
            desc = "Volume control bit of dacl to dacl.
- 00: 36 dB
- 01: 35 dB
- 02: 34 dB ... 7E: –90 dB 7F: –91 dB";
            sw = rw; hw = r;
            reset = 0x0;
        } adcl2dacl_vol[30:24];
        field {
            name = "adcr2dacl_en";
            desc = "Mixer control signal of adcr2dacl.
- 0: disabled
- 1: enabled";
            sw = rw; hw = r;
            reset = 0x0;
        } adcr2dacl_en[23:23];
        field {
            name = "adcr2dacl_vol";
            desc = "Volume control bit of dacr to dacl.
- 00: 36 dB
- 01: 35 dB
- 02: 34 dB ... 7E: –90 dB 7F: –91 dB";
            sw = rw; hw = r;
            reset = 0x0;
        } adcr2dacl_vol[22:16];
        field {
            name = "adcl2dacr_en";
            desc = "Mixer control signal of adcl2dacr.
- 0: disabled
- 1: enabled";
            sw = rw; hw = r;
            reset = 0x0;
        } adcl2dacr_en[15:15];
        field {
            name = "adcl2dacr_vol";
            desc = "Volume control bit of dacl to dacr.
- 00: 36 dB
- 01: 35 dB
- 02: 34 dB ... 7E: –90 dB 7F: –91 dB";
            sw = rw; hw = r;
            reset = 0x0;
        } adcl2dacr_vol[14:8];
        field {
            name = "adcr2dacr_en";
            desc = "Mixer control signal of adcr2dacr.
- 0: disabled
- 1: enabled";
            sw = rw; hw = r;
            reset = 0x0;
        } adcr2dacr_en[7:7];
        field {
            name = "adcr2dacr_vol";
            desc = "Volume control bit of dacr to dacr.
- 00: 36 dB
- 01: 35 dB
- 02: 34 dB ... 7E: –90 dB 7F: –91 dB";
            sw = rw; hw = r;
            reset = 0x0;
        } adcr2dacr_vol[6:0];
    } PERIPHCTRL19 @ 0x7c;
    reg {
        name = "PERIPHCTRL20";
        desc = "PERIPHCTRL20 is a USB control register 1 (peripheral control register 20). PERIPHCTRL20 (offset 0x0080, total reset 0x0003_33A8; PROVEN: Hi3518E V100 data sheet, PDF page 224, section 3.4.6).";
        field {
            name = "reserved";
            desc = "Reserved.";
            sw = r; hw = w;
            reset = 0x0;
        } reserved_31_18[31:18];
        field {
            name = "usbovr_p_ctrl";
            desc = "Polarity for over-current protection.
- 0: active low
- 1: active high";
            sw = rw; hw = r;
            reset = 0x1;
        } usbovr_p_ctrl[17:17];
        field {
            name = "usbpwr_p_ctrl";
            desc = "Polarity for power enable.
- 0: active low
- 1: active high";
            sw = rw; hw = r;
            reset = 0x1;
        } usbpwr_p_ctrl[16:16];
        field {
            name = "reserved";
            desc = "Reserved.";
            sw = r; hw = w;
            reset = 0x0;
        } reserved_15_15[15:15];
        field {
            name = "phy0_ovrcur_en";
            desc = "Over-current protection enable for PHY0.
- 0: disabled
- 1: enabled";
            sw = rw; hw = r;
            reset = 0x0;
        } phy0_ovrcur_en[14:14];
        field {
            name = "reserved";
            desc = "Reserved.";
            sw = r; hw = w;
            reset = 0x1;
        } reserved_13_13[13:13];
        field {
            name = "phy0_pwr_en";
            desc = "Power-off control for the PHY0 power supply.
- 0: powered off
- 1: enable the power output of the controller";
            sw = rw; hw = r;
            reset = 0x1;
        } phy0_pwr_en[12:12];
        field {
            name = "reserved";
            desc = "Reserved.";
            sw = r; hw = w;
            reset = 0x0;
        } reserved_11_10[11:10];
        field {
            name = "ss_ena_incr16_i";
            desc = "AHB burst16 enable.
- 0: disabled
- 1: enabled";
            sw = rw; hw = r;
            reset = 0x1;
        } ss_ena_incr16_i[9:9];
        field {
            name = "ss_ena_incr8_i";
            desc = "AHB burst8 enable.
- 0: disabled
- 1: enabled";
            sw = rw; hw = r;
            reset = 0x1;
        } ss_ena_incr8_i[8:8];
        field {
            name = "ss_ena_incr4_i";
            desc = "AHB burst4 enable.
- 0: disabled
- 1: enabled";
            sw = rw; hw = r;
            reset = 0x1;
        } ss_ena_incr4_i[7:7];
        field {
            name = "ss_ena_incrx_align_i";
            desc = "Burst alignment enable.
- 0: disabled
- 1: enabled";
            sw = rw; hw = r;
            reset = 0x0;
        } ss_ena_incrx_align_i[6:6];
        field {
            name = "ss_autoppd_on_overcur_en_i";
            desc = "Port automatic power-off enable during overcurrent.
- 0: disabled
- 1: enabled";
            sw = rw; hw = r;
            reset = 0x1;
        } ss_autoppd_on_overcur_en_i[5:5];
        field {
            name = "reserved";
            desc = "Reserved (ULPI mode16_en).";
            sw = r; hw = w;
            reset = 0x0;
        } reserved_4_4[4:4];
        field {
            name = "ulpi_bypass_en";
            desc = "ULPI bypass control. This bit must be set to 1.
- 0: ULPI mode
- 1: UTMI mode";
            sw = rw; hw = r;
            reset = 0x1;
        } ulpi_bypass_en[3:3];
        field {
            name = "app_start_clk_i";
            desc = "Open host controller interface (OHCI) clock control.
- 0: The OHCI works properly.
- 1: The OHCI clock is enabled in suspend mode.";
            sw = rw; hw = r;
            reset = 0x0;
        } app_start_clk_i[2:2];
        field {
            name = "ohci_susp_lgcy_i";
            desc = "Strap input signal when the OHCI is suspended.";
            sw = rw; hw = r;
            reset = 0x0;
        } ohci_susp_lgcy_i[1:1];
        field {
            name = "wordinterface";
            desc = "Data bit width select of the UTMI interface.
- 0: 8 bits
- 1: 16 bits";
            sw = rw; hw = r;
            reset = 0x0;
        } wordinterface[0:0];
    } PERIPHCTRL20 @ 0x80;
    reg {
        name = "PERIPHCTRL21";
        desc = "PERIPHCTRL21 is USB control register 2 (peripheral control register 21). PERIPHCTRL21 (offset 0x0084, total reset 0x001D_2188; PROVEN: Hi3518E V100 data sheet, PDF page 225, section 3.4.6).";
        field {
            name = "reserved";
            desc = "Reserved.";
            sw = r; hw = na;
            reset = 0x0;
        } reserved_31_23[31:23];
        field {
            name = "siddq";
            desc = "Analog power-off test enable of the PHY.
- 0: do not power off the analog power
- 1: power off the analog power

The default value is 0. The bit must be set to 0 before the built-in self test (BIST).";
            sw = rw; hw = r;
            reset = 0x0;
        } siddq[22:22];
        field {
            name = "commononn";
            desc = "Indicates whether XO BIAS BANDGAP PLL works when the PHY is suspended.
- 0: clk48m_ohci output is always valid even when the PHY is suspended.
- 1: clk48m_ohci output is valid except when the PHY is suspended.";
            sw = rw; hw = r;
            reset = 0x0;
        } commononn[21:21];
        field {
            name = "phy0_txhsxvtune";
            desc = "Crossover voltage tune signal of DP/DM.
- 00: reserved
- 01: –15 mV
- 10: +15 mV
- 11: default";
            sw = rw; hw = r;
            reset = 0x3;
        } phy0_txhsxvtune[20:19];
        field {
            name = "phy0_sleepm";
            desc = "Sleep mode of port 0.
- 0: sleep mode
- 1: normal mode";
            sw = rw; hw = r;
            reset = 0x1;
        } phy0_sleepm[18:18];
        field {
            name = "phy0_loopbackenb";
            desc = "Loopback (from D+ to D-) test enable signal of PHY0. This bit must be set to 0.";
            sw = rw; hw = r;
            reset = 0x0;
        } phy0_loopbackenb[17:17];
        field {
            name = "phy0_compdistune";
            desc = "HOSDISCONNECT threshold level tune signal of PHY0.
- 000: –6%
- 001: –4.5%
- 010: –3%
- 100: default value
- 101: +1.5%
- 110: +3%
- 111: +4.5%

Other values: reserved";
            sw = rw; hw = r;
            reset = 0x4;
        } phy0_compdistune[16:14];
        field {
            name = "phy0_sqrxtune";
            desc = "Squelch circuit tune signal of PHY0.
- 000: +20%
- 001: +15%
- 010: +10%
- 011: +5%
- 100: default value
- 101: –5%
- 110: –10%
- 111: –15%";
            sw = rw; hw = r;
            reset = 0x4;
        } phy0_sqrxtune[13:11];
        field {
            name = "phy0_txfslstune";
            desc = "FS LS impedance tune signal of PHY0.
- 0x0: +5%
- 0x1: +2.5%
- 0x3: default value
- 0x7: –2.5%
- 0xF: –5%

Other values: reserved";
            sw = rw; hw = r;
            reset = 0x3;
        } phy0_txfslstune[10:7];
        field {
            name = "phy0_txpreemphasistune";
            desc = "Pre-emphasis transmit enable signal of PHY0 in HS mode. The default value is 0.
- 0: disabled
- 1: enabled";
            sw = rw; hw = r;
            reset = 0x0;
        } phy0_txpreemphasistune[6:6];
        field {
            name = "reserved";
            desc = "Reserved.";
            sw = rw; hw = r;
            reset = 0x0;
        } reserved_5_5[5:5];
        field {
            name = "phy0_txrisetune";
            desc = "High-speed signal up/down time tune of PHY0.
- 0: default value
- 1: –8%";
            sw = rw; hw = r;
            reset = 0x0;
        } phy0_txrisetune[4:4];
        field {
            name = "phy0_txverftune";
            desc = "DC level tune signal in HS mode of PHY0.
- 0x0: –10%
- 0x1: –8.75%
- 0x2: –7.5%
- 0x3: –6.25%
- 0x4: –5%
- 0x5: –3.75%
- 0x6: –2.5%
- 0x7: –1.25%
- 0x8: default value
- 0x9: +1.25%
- 0xA: +2.5%
- 0xB: +3.7%
- 0xC: +5%
- 0xD: +6.25%
- 0xE: +7.5%
- 0xF: +8.75%";
            sw = rw; hw = r;
            reset = 0x8;
        } phy0_txverftune[3:0];
    } PERIPHCTRL21 @ 0x84;
    reg {
        name = "SYSSTAT";
        desc = "SYSSTAT is a system status register (PLL_LOCK). SYSSTAT (offset 0x008C, total reset 0x0000_0000; PROVEN: Hi3518E V100 data sheet, PDF page 228, section 3.4.6).";
        field {
            name = "reserved";
            desc = "Reserved.";
            sw = r; hw = w;
            reset = 0x0;
        } reserved_31_19[31:19];
        field {
            name = "arm_standbywfi";
            desc = "Whether the ARM processor is in wait for interrupt (WFI) status.
- 0: non-WFI status
- 1: WFI status";
            sw = r; hw = w;
            reset = 0x0;
        } arm_standbywfi[18:18];
        field {
            name = "reserved";
            desc = "Reserved.";
            sw = r; hw = w;
            reset = 0x0;
        } reserved_17_17[17:17];
        field {
            name = "sfc_addr_mode";
            desc = "Default address mode of the SFC.
- 0: 3-byte address mode
- 1: 4-byte address mode";
            sw = r; hw = w;
            reset = 0x0;
        } sfc_addr_mode[16:16];
        field {
            name = "reserved";
            desc = "Reserved.";
            sw = r; hw = w;
            reset = 0x0;
        } reserved_15_8[15:8];
        field {
            name = "jtag_sel";
            desc = "Selected debugging mode of the chip.
- 00: debug ARM
- 01: reserved
- 10: debug SATA PHY
- 11: reserved";
            sw = r; hw = w;
            reset = 0x0;
        } jtag_sel[7:6];
        field {
            name = "boot_mode";
            desc = "Selected boot mode of the chip.
- 0: boot from the SPI flash
- 1: reserved";
            sw = r; hw = w;
            reset = 0x0;
        } boot_mode[5:5];
        field {
            name = "reserved";
            desc = "Reserved.";
            sw = r; hw = w;
            reset = 0x0;
        } reserved_4_0[4:0];
    } SYSSTAT @ 0x8c;
    reg {
        name = "SCSYSID0";
        desc = "SCSYSID0 is chip ID register 0. SCSYSID0 (offset 0xEE0, total reset 0x00; PROVEN: Hi3518E V100 data sheet, PDF page 229, section 3.4.6).";
        field {
            name = "sysid0";
            desc = "Reading this register returns 0x00.";
            sw = r; hw = w;
            reset = 0x0;
        } sysid0[7:0];
    } SCSYSID0 @ 0xee0;
    reg {
        name = "SCSYSID1";
        desc = "SCSYSID1 is chip ID register 1. SCSYSID1 (offset 0xEE4, total reset 0x01; PROVEN: Hi3518E V100 data sheet, PDF page 229, section 3.4.6).";
        field {
            name = "sysid1";
            desc = "Reading this register returns 0x01.";
            sw = r; hw = w;
            reset = 0x1;
        } sysid1[7:0];
    } SCSYSID1 @ 0xee4;
    reg {
        name = "SCSYSID2";
        desc = "SCSYSID2 is chip ID register 2. SCSYSID2 (offset 0xEE8, total reset 0x18; PROVEN: Hi3518E V100 data sheet, PDF page 230, section 3.4.6).";
        field {
            name = "sysid2";
            desc = "Reading this register returns 0x18.";
            sw = r; hw = w;
            reset = 0x18;
        } sysid2[7:0];
    } SCSYSID2 @ 0xee8;
    reg {
        name = "SCSYSID3";
        desc = "SCSYSID3 is chip ID register 3. SCSYSID3 (offset 0xEEC, total reset 0x35; PROVEN: Hi3518E V100 data sheet, PDF page 230, section 3.4.6).";
        field {
            name = "sysid3";
            desc = "Reading this register returns 0x35.";
            sw = r; hw = w;
            reset = 0x35;
        } sysid3[7:0];
    } SCSYSID3 @ 0xeec;
};

`endif
