`ifndef EHI3518EV100_RTC_INT_RDL
`define EHI3518EV100_RTC_INT_RDL
regfile eHI3518EV100_RTC_INT {
    name = "Internal RTC register file (device addresses reached through the RTC SPI interface, NOT memory mapped; the instance base 0x20060100 in the SoC map is a placeholder)";
    desc = "Internal RTC register file (device addresses reached through the RTC SPI interface, NOT memory mapped; the instance base 0x20060100 in the SoC map is a placeholder) of the Hi3518E V100 at base 0x20060000. 79 registers extracted programmatically from the Hi3518E 720p IP Camera SoC data sheet (Issue 03, 2015-11-26); chapter 3.9.7, table 3-34. Field names, bit ranges, access types and reset values are taken from the register tables; reset values are the data sheet total reset values split onto the fields (per-field values where the table has them). Label: PROVEN. Hardware not verified here (no board).";
    default regwidth = 8;
    default accesswidth = 8;
    reg {
        name = "RTC_10MS_COUNT";
        desc = "RTC_10MS_COUNT is the count value register for the RTC 10 ms counter. RTC_10MS_COUNT (offset 0x00, total reset 0x00; PROVEN: Hi3518E V100 data sheet, PDF page 317, section 3.9.7).";
        field {
            name = "reserved";
            desc = "Reserved.";
            sw = r; hw = na;
            reset = 0x0;
        } reserved_7_7[7:7];
        field {
            name = "rtc_10ms_count";
            desc = "RTC 10 ms counter value. It indicates the currently counted time. Its unit is 10 ms. The value range is 0–99.";
            sw = r; hw = w;
            reset = 0x0;
        } rtc_10ms_count[6:0];
    } RTC_10MS_COUNT @ 0x0;
    reg {
        name = "RTC_S_COUNT";
        desc = "RTC_S_COUNT is the count value register for the RTC second counter. RTC_S_COUNT (offset 0x01, total reset 0x00; PROVEN: Hi3518E V100 data sheet, PDF page 317, section 3.9.7).";
        field {
            name = "reserved";
            desc = "Reserved.";
            sw = r; hw = na;
            reset = 0x0;
        } reserved_7_6[7:6];
        field {
            name = "rtc_s_count";
            desc = "RTC second counter value. It indicates the currently counted seconds. The value range is 0–59.";
            sw = r; hw = w;
            reset = 0x0;
        } rtc_s_count[5:0];
    } RTC_S_COUNT @ 0x1;
    reg {
        name = "RTC_M_COUNT";
        desc = "RTC_M_COUNT is the count value register for the RTC minute counter. RTC_M_COUNT (offset 0x02, total reset 0x00; PROVEN: Hi3518E V100 data sheet, PDF page 318, section 3.9.7).";
        field {
            name = "reserved";
            desc = "Reserved.";
            sw = r; hw = na;
            reset = 0x0;
        } reserved_7_6[7:6];
        field {
            name = "rtc_m_count";
            desc = "RTC minute counter value. It indicates the currently counted minutes. The value range is 0–59.";
            sw = r; hw = w;
            reset = 0x0;
        } rtc_m_count[5:0];
    } RTC_M_COUNT @ 0x2;
    reg {
        name = "RTC_H_COUNT";
        desc = "RTC_H_COUNT is the count value register for the RTC hour counter. RTC_H_COUNT (offset 0x03, total reset 0x00; PROVEN: Hi3518E V100 data sheet, PDF page 318, section 3.9.7).";
        field {
            name = "reserved";
            desc = "Reserved.";
            sw = r; hw = na;
            reset = 0x0;
        } reserved_7_5[7:5];
        field {
            name = "rtc_h_count";
            desc = "RTC hour counter value. It indicates the currently counted hours. The value range is 0–23.";
            sw = r; hw = w;
            reset = 0x0;
        } rtc_h_count[4:0];
    } RTC_H_COUNT @ 0x3;
    reg {
        name = "RTC_D_COUNT_L";
        desc = "RTC_D_COUNT_L is the lower-8-bit count value register for the RTC day counter. RTC_D_COUNT_L (offset 0x04, total reset 0x00; PROVEN: Hi3518E V100 data sheet, PDF page 319, section 3.9.7).";
        field {
            name = "rtc_d_count_l";
            desc = "Lower eight bits of the RTC day counter value. This field works with RTC_D_COUNT_H to indicate the currently counted days. The day range is 0–65535.";
            sw = r; hw = w;
            reset = 0x0;
        } rtc_d_count_l[7:0];
    } RTC_D_COUNT_L @ 0x4;
    reg {
        name = "RTC_D_COUNT_H";
        desc = "RTC_D_COUNT_H is the upper-8-bit count value register for the RTC day counter. RTC_D_COUNT_H (offset 0x05, total reset 0x00; PROVEN: Hi3518E V100 data sheet, PDF page 319, section 3.9.7).";
        field {
            name = "rtc_d_count_h";
            desc = "Upper eight bits of the RTC day counter value. This field works with RTC_D_COUNT_L to indicate the currently counted day. The day range is 0–65535.";
            sw = r; hw = w;
            reset = 0x0;
        } rtc_d_count_h[7:0];
    } RTC_D_COUNT_H @ 0x5;
    reg {
        name = "RTC_MR_10MS";
        desc = "RTC_MR_10MS is the match value register for the RTC 10 ms counter. RTC_MR_10MS (offset 0x06, total reset 0x7F; PROVEN: Hi3518E V100 data sheet, PDF page 320, section 3.9.7).";
        field {
            name = "reserved";
            desc = "Reserved.";
            sw = rw; hw = r;
            reset = 0x0;
        } reserved_7_7[7:7];
        field {
            name = "rtc_mr_10ms";
            desc = "Match value of the RTC 10 ms counter. The value range is 0–99.";
            sw = rw; hw = r;
            reset = 0x7f;
        } rtc_mr_10ms[6:0];
    } RTC_MR_10MS @ 0x6;
    reg {
        name = "RTC_MR_S";
        desc = "RTC_MR_S is the match value register for the RTC second counter. RTC_MR_S (offset 0x07, total reset 0x3F; PROVEN: Hi3518E V100 data sheet, PDF page 320, section 3.9.7).";
        field {
            name = "reserved";
            desc = "Reserved.";
            sw = rw; hw = r;
            reset = 0x0;
        } reserved_7_6[7:6];
        field {
            name = "rtc_mr_s";
            desc = "Match value of the RTC second counter. The value range is 0–59.";
            sw = rw; hw = r;
            reset = 0x3f;
        } rtc_mr_s[5:0];
    } RTC_MR_S @ 0x7;
    reg {
        name = "RTC_MR_M";
        desc = "RTC_MR_M is the match value register for the RTC minute counter. RTC_MR_M (offset 0x08, total reset 0x3F; PROVEN: Hi3518E V100 data sheet, PDF page 321, section 3.9.7).";
        field {
            name = "reserved";
            desc = "Reserved.";
            sw = rw; hw = r;
            reset = 0x0;
        } reserved_7_6[7:6];
        field {
            name = "rtc_mr_m";
            desc = "Match value of the RTC minute counter. The value range is 0–59.";
            sw = rw; hw = r;
            reset = 0x3f;
        } rtc_mr_m[5:0];
    } RTC_MR_M @ 0x8;
    reg {
        name = "RTC_MR_H";
        desc = "RTC_MR_H is the match value register for the RTC hour counter. RTC_MR_H (offset 0x09, total reset 0x1F; PROVEN: Hi3518E V100 data sheet, PDF page 321, section 3.9.7).";
        field {
            name = "reserved";
            desc = "Reserved.";
            sw = rw; hw = r;
            reset = 0x0;
        } reserved_7_5[7:5];
        field {
            name = "rtc_mr_h";
            desc = "Match value of the RTC hour counter. The value range is 0–23.";
            sw = rw; hw = r;
            reset = 0x1f;
        } rtc_mr_h[4:0];
    } RTC_MR_H @ 0x9;
    reg {
        name = "RTC_MR_D_L";
        desc = "RTC_MR_D_L is the lower-8-bit match value register for the RTC day counter. RTC_MR_D_L (offset 0x0A, total reset 0xFF; PROVEN: Hi3518E V100 data sheet, PDF page 322, section 3.9.7).";
        field {
            name = "rtc_mr_d_l";
            desc = "Lower eight bits of the match value of the RTC day counter. This field works with RTC_MR_D_H to indicate the matched day. The day range is 0–65535.";
            sw = rw; hw = r;
            reset = 0xff;
        } rtc_mr_d_l[7:0];
    } RTC_MR_D_L @ 0xa;
    reg {
        name = "RTC_MR_D_H";
        desc = "RTC_MR_D_H is the upper-8-bit match value register for the RTC day counter. RTC_MR_D_H (offset 0x0B, total reset 0xFF; PROVEN: Hi3518E V100 data sheet, PDF page 322, section 3.9.7).";
        field {
            name = "rtc_mr_d_h";
            desc = "Upper eight bits of the match value of the RTC day counter. This field works with RTC_MR_D_L to indicate the matched day. The day range is 0–65535.";
            sw = rw; hw = r;
            reset = 0xff;
        } rtc_mr_d_h[7:0];
    } RTC_MR_D_H @ 0xb;
    reg {
        name = "RTC_LR_10MS";
        desc = "RTC_LR_10MS is the configured value register for the RTC 10 ms counter. RTC_LR_10MS (offset 0x0C, total reset 0x00; PROVEN: Hi3518E V100 data sheet, PDF page 323, section 3.9.7).";
        field {
            name = "reserved";
            desc = "Reserved.";
            sw = rw; hw = r;
            reset = 0x0;
        } reserved_7_7[7:7];
        field {
            name = "rtc_lr_10ms";
            desc = "Configured value of the RTC 10 ms counter. The value range is 0–99.";
            sw = rw; hw = r;
            reset = 0x0;
        } rtc_lr_10ms[6:0];
    } RTC_LR_10MS @ 0xc;
    reg {
        name = "RTC_LR_S";
        desc = "RTC_LR_S is the configured value register for the RTC second counter. RTC_LR_S (offset 0x0D, total reset 0x00; PROVEN: Hi3518E V100 data sheet, PDF page 323, section 3.9.7).";
        field {
            name = "reserved";
            desc = "Reserved.";
            sw = rw; hw = r;
            reset = 0x0;
        } reserved_7_6[7:6];
        field {
            name = "rtc_lr_s";
            desc = "Configured value of the RTC second counter. The value range is 0–59.";
            sw = rw; hw = r;
            reset = 0x0;
        } rtc_lr_s[5:0];
    } RTC_LR_S @ 0xd;
    reg {
        name = "RTC_LR_M";
        desc = "RTC_LR_M is the configured value register for the RTC minute counter. RTC_LR_M (offset 0x0E, total reset 0x00; PROVEN: Hi3518E V100 data sheet, PDF page 324, section 3.9.7).";
        field {
            name = "reserved";
            desc = "Reserved.";
            sw = rw; hw = r;
            reset = 0x0;
        } reserved_7_6[7:6];
        field {
            name = "rtc_lr_m";
            desc = "Configured value of the RTC minute counter. The value range is 0–59.";
            sw = rw; hw = r;
            reset = 0x0;
        } rtc_lr_m[5:0];
    } RTC_LR_M @ 0xe;
    reg {
        name = "RTC_LR_H";
        desc = "RTC_LR_H is the configured value register for the RTC hour counter. RTC_LR_H (offset 0x0F, total reset 0x00; PROVEN: Hi3518E V100 data sheet, PDF page 324, section 3.9.7).";
        field {
            name = "reserved";
            desc = "Reserved.";
            sw = rw; hw = r;
            reset = 0x0;
        } reserved_7_5[7:5];
        field {
            name = "rtc_lr_h";
            desc = "Configured value of the RTC hour counter. The value range is 0–23.";
            sw = rw; hw = r;
            reset = 0x0;
        } rtc_lr_h[4:0];
    } RTC_LR_H @ 0xf;
    reg {
        name = "RTC_LR_D_L";
        desc = "RTC_LR_D_L is the lower-8-bit configured value register for the RTC day counter. RTC_LR_D_L (offset 0x10, total reset 0x00; PROVEN: Hi3518E V100 data sheet, PDF page 325, section 3.9.7).";
        field {
            name = "rtc_lr_d_l";
            desc = "Lower eight bits of the configured value of the RTC day counter. This field works with RTC_LR_D_H to indicate the configured day. The day range is 0–255.";
            sw = rw; hw = r;
            reset = 0x0;
        } rtc_lr_d_l[7:0];
    } RTC_LR_D_L @ 0x10;
    reg {
        name = "RTC_LR_D_H";
        desc = "RTC_LR_D_H is the upper-8-bit configured value register for the RTC day counter. RTC_LR_D_H (offset 0x11, total reset 0x00; PROVEN: Hi3518E V100 data sheet, PDF page 325, section 3.9.7).";
        field {
            name = "rtc_lr_d_h";
            desc = "Upper eight bits of the configured value of the RTC day counter. This field works with RTC_LR_D_L to indicate the configured day. The day range is 0–255.";
            sw = rw; hw = r;
            reset = 0x0;
        } rtc_lr_d_h[7:0];
    } RTC_LR_D_H @ 0x11;
    reg {
        name = "RTC_LORD";
        desc = "RTC_LORD is the RTC configured value loading enable register. RTC_LORD (offset 0x12, total reset 0x00; PROVEN: Hi3518E V100 data sheet, PDF page 326, section 3.9.7).";
        field {
            name = "reserved";
            desc = "Reserved.";
            sw = r; hw = na;
            reset = 0x0;
        } reserved_7_1[7:1];
        field {
            name = "rtc_load";
            desc = "RTC configured value loading enable. When the field is enabled, the RTC configured value will be loaded to the RTC accumulator. If software writes 1 to load the configured value, hardware will automatically set this field to 0 after successful loading.";
            sw = rw; hw = r;
            reset = 0x0;
        } rtc_load[0:0];
    } RTC_LORD @ 0x12;
    reg {
        name = "RTC_IMSC";
        desc = "RTC_IMSC is the RTC interrupt enable register. RTC_IMSC (offset 0x13, total reset 0x00; PROVEN: Hi3518E V100 data sheet, PDF page 326, section 3.9.7).";
        field {
            name = "reserved";
            desc = "Reserved.";
            sw = r; hw = na;
            reset = 0x0;
        } reserved_7_1[7:1];
        field {
            name = "rtc_imsc";
            desc = "RTC timing interrupt enable.
- 0: disabled
- 1: enabled";
            sw = rw; hw = r;
            reset = 0x0;
        } rtc_imsc[0:0];
    } RTC_IMSC @ 0x13;
    reg {
        name = "RTC_INT_CLR";
        desc = "RTC_INT_CLR is the RTC interrupt clear register. RTC_INT_CLR (offset 0x14, total reset 0x00; PROVEN: Hi3518E V100 data sheet, PDF page 327, section 3.9.7).";
        field {
            name = "reserved";
            desc = "Reserved.";
            sw = r; hw = na;
            reset = 0x0;
        } reserved_7_1[7:1];
        field {
            name = "rtc_int_clr";
            desc = "RTC timing interrupt clear. If software writes 1 to clear the interrupt, hardware will automatically set this field to 0 after the interrupt is successfully cleared.";
            sw = rw; hw = r;
            reset = 0x0;
        } rtc_int_clr[0:0];
    } RTC_INT_CLR @ 0x14;
    reg {
        name = "RTC_MSC_INT";
        desc = "RTC_MSC_INT is the RTC mask interrupt status register. RTC_MSC_INT (offset 0x15, total reset 0x00; PROVEN: Hi3518E V100 data sheet, PDF page 327, section 3.9.7).";
        field {
            name = "reserved";
            desc = "Reserved.";
            sw = r; hw = na;
            reset = 0x0;
        } reserved_7_1[7:1];
        field {
            name = "mask_int";
            desc = "Mask interrupt status.";
            sw = r; hw = w;
            reset = 0x0;
        } mask_int[0:0];
    } RTC_MSC_INT @ 0x15;
    reg {
        name = "RTC_RAW_INT";
        desc = "RTC_RAW_INT is the RTC raw interrupt status register. RTC_RAW_INT (offset 0x16, total reset 0x00; PROVEN: Hi3518E V100 data sheet, PDF page 328, section 3.9.7).";
        field {
            name = "reserved";
            desc = "Reserved.";
            sw = r; hw = na;
            reset = 0x0;
        } reserved_7_1[7:1];
        field {
            name = "raw_int";
            desc = "Raw interrupt status.";
            sw = r; hw = w;
            reset = 0x0;
        } raw_int[0:0];
    } RTC_RAW_INT @ 0x16;
    reg {
        name = "RTC_CLK";
        desc = "RTC_CLK is the RTC output clock select register. RTC_CLK (offset 0x17, total reset 0x00; PROVEN: Hi3518E V100 data sheet, PDF page 328, section 3.9.7).";
        field {
            name = "reserved";
            desc = "Reserved.";
            sw = r; hw = na;
            reset = 0x0;
        } reserved_7_2[7:2];
        field {
            name = "clk_out_sel";
            desc = "Output test clock of the RTC.
- 00: output crystal oscillator clock
- 01: output corrected 100 Hz clock 1X: output 1 Hz clock";
            sw = rw; hw = r;
            reset = 0x0;
        } clk_out_sel[1:0];
    } RTC_CLK @ 0x17;
    reg {
        name = "RTC_POR_N";
        desc = "RTC_POR_N is the RTC reset control register. RTC_POR_N (offset 0x18, total reset 0x01; PROVEN: Hi3518E V100 data sheet, PDF page 329, section 3.9.7).";
        field {
            name = "reserved";
            desc = "Reserved.";
            sw = r; hw = na;
            reset = 0x0;
        } reserved_7_1[7:1];
        field {
            name = "rtc_por_n";
            desc = "RTC reset. This field is automatically set to 1 after the RTC is successfully reset.
- 0: reset";
            sw = rw; hw = r;
            reset = 0x1;
        } rtc_por_n[0:0];
    } RTC_POR_N @ 0x18;
    reg {
        name = "RTC_SAR_CTRL";
        desc = "RTC_SAR_CTRL is the RTC internal t_sensor control register. RTC_SAR_CTRL (offset 0x1A, total reset 0x00; PROVEN: Hi3518E V100 data sheet, PDF page 329, section 3.9.7).";
        field {
            name = "reserved";
            desc = "Reserved.";
            sw = rw; hw = r;
            reset = 0x0;
        } reserved_7_2[7:2];
        field {
            name = "sample_time";
            desc = "Temperature update period
- 00: 1 minute
- 01: 4 minutes
- 10: 8 minutes
- 11: 16 minutes";
            sw = rw; hw = r;
            reset = 0x0;
        } sample_time[1:0];
    } RTC_SAR_CTRL @ 0x1a;
    reg {
        name = "TOT_OFFSET_L";
        desc = "TOT_OFFSET_L is the lower-8-bit corrected tot_offset register when the correction algorithm is used. TOT_OFFSET_L (offset 0x1C, total reset 0x00; PROVEN: Hi3518E V100 data sheet, PDF page 330, section 3.9.7).";
        field {
            name = "tot_offset_l";
            desc = "Corrected tot_offset by using the correction algorithm. The value is expressed by complement codes –256 to +255. That is, tot_offset is 1990 + (–256 to +255) in the correction algorithm. This field value is the lower seven bits of tot_offset.";
            sw = rw; hw = r;
            reset = 0x0;
        } tot_offset_l[7:0];
    } TOT_OFFSET_L @ 0x1c;
    reg {
        name = "TOT_OFFSET_H";
        desc = "TOT_OFFSET_H is the upper-1-bit corrected tot_offset register when the correction algorithm is used. TOT_OFFSET_H (offset 0x1D, total reset 0x00; PROVEN: Hi3518E V100 data sheet, PDF page 330, section 3.9.7).";
        field {
            name = "reserved";
            desc = "Reserved.";
            sw = r; hw = na;
            reset = 0x0;
        } reserved_7_1[7:1];
        field {
            name = "tot_offset_h";
            desc = "Corrected tot_offset by using the correction algorithm. The value is expressed by complement codes –256 to +255. That is, tot_offset is 1990 + (–256 to +255) in the correction algorithm. This field value is the upper one bit of tot_offset.";
            sw = rw; hw = r;
            reset = 0x0;
        } tot_offset_h[0:0];
    } TOT_OFFSET_H @ 0x1d;
    reg {
        name = "TEMP_OFFSET";
        desc = "TEMP_OFFSET is the temperature code word offset register corresponding to the correction input LUT. TEMP_OFFSET (offset 0x1E, total reset 0x00; PROVEN: Hi3518E V100 data sheet, PDF page 331, section 3.9.7).";
        field {
            name = "reserved";
            desc = "Reserved.";
            sw = r; hw = na;
            reset = 0x0;
        } reserved_7_6[7:6];
        field {
            name = "temp_offset";
            desc = "Offset of the temperature code words that are input to the correction LUT. The value is expressed by the complement code and the value ranges from –32 to +31.";
            sw = rw; hw = r;
            reset = 0x0;
        } temp_offset[5:0];
    } TEMP_OFFSET @ 0x1e;
    reg {
        name = "OUTSIDE_TEMP";
        desc = "OUTSIDE_TEMP is the external ambient temperature register. OUTSIDE_TEMP (offset 0x1F, total reset 0x00; PROVEN: Hi3518E V100 data sheet, PDF page 331, section 3.9.7).";
        field {
            name = "outside_temp";
            desc = "Ambient temperature. The code word indicates –40°C to +140°C.";
            sw = rw; hw = r;
            reset = 0x0;
        } outside_temp[7:0];
    } OUTSIDE_TEMP @ 0x1f;
    reg {
        name = "DIE_TEMP";
        desc = "DIE_TEMP is the RTC internal t_sensor temperature register. DIE_TEMP (offset 0x20, total reset 0x00; PROVEN: Hi3518E V100 data sheet, PDF page 332, section 3.9.7).";
        field {
            name = "die_temp";
            desc = "Internal chip temperature provided by the t_sensor in the RTC. The code word indicates –40°C to +140°C.";
            sw = r; hw = w;
            reset = 0x0;
        } die_temp[7:0];
    } DIE_TEMP @ 0x20;
    reg {
        name = "TEMP_SEL";
        desc = "TEMP_SEL is the correction algorithm input temperature source select register. TEMP_SEL (offset 0x21, total reset 0x00; PROVEN: Hi3518E V100 data sheet, PDF page 332, section 3.9.7).";
        field {
            name = "reserved";
            desc = "Reserved.";
            sw = rw; hw = r;
            reset = 0x0;
        } reserved_7_2[7:2];
        field {
            name = "fix_mode";
            desc = "Correction algorithm input temperature source select. This field works with temp_sel. For details, see descriptions of the temp_sel field.";
            sw = rw; hw = r;
            reset = 0x0;
        } fix_mode[1:1];
        field {
            name = "temp_sel";
            desc = "Correction algorithm input temperature source select. This field parameter works with fix_mode. When the chip is powered on, the value meanings for {fix_mode, temp_sel} are as follows:
- 00: The correction circuit temperature is read from the

DIE_TEMP register.
- 01: The correction circuit temperature is read from the

OUTSIDE_TEMP register. 1X: The correction circuit temperature is read from the OUTSIDE_TEMP register. When the chip is powered off, the value meanings for {fix_mode, temp_sel} are as follows: 0X: The correction circuit temperature is read from the DIE_TEMP register. 1X: The correction circuit temperature is read from the OUTSIDE_TEMP register.";
            sw = rw; hw = r;
            reset = 0x0;
        } temp_sel[0:0];
    } TEMP_SEL @ 0x21;
    reg {
        name = "LUT1";
        desc = "LUT1 is the temperature correction algorithm LUT1 register. LUT1 (offset 0x22, total reset 0xAC; PROVEN: Hi3518E V100 data sheet, PDF page 333, section 3.9.7).";
        field {
            name = "lut1";
            desc = "Temperature correction algorithm LUT1.";
            sw = rw; hw = r;
            reset = 0xac;
        } lut1[7:0];
    } LUT1 @ 0x22;
    reg {
        name = "LUT2";
        desc = "LUT2 is the temperature correction algorithm LUT2 register. LUT2 (offset 0x23, total reset 0xB4; PROVEN: Hi3518E V100 data sheet, PDF page 333, section 3.9.7).";
        field {
            name = "lut2";
            desc = "Temperature correction algorithm LUT2.";
            sw = rw; hw = r;
            reset = 0xb4;
        } lut2[7:0];
    } LUT2 @ 0x23;
    reg {
        name = "LUT3";
        desc = "LUT3 is the temperature correction algorithm LUT3 register. LUT3 (offset 0x24, total reset 0xBB; PROVEN: Hi3518E V100 data sheet, PDF page 334, section 3.9.7).";
        field {
            name = "lut3";
            desc = "Temperature correction algorithm LUT3.";
            sw = rw; hw = r;
            reset = 0xbb;
        } lut3[7:0];
    } LUT3 @ 0x24;
    reg {
        name = "LUT4";
        desc = "LUT4 is the temperature correction algorithm LUT4 register. LUT4 (offset 0x25, total reset 0xC2; PROVEN: Hi3518E V100 data sheet, PDF page 334, section 3.9.7).";
        field {
            name = "lut4";
            desc = "Temperature correction algorithm LUT4.";
            sw = rw; hw = r;
            reset = 0xc2;
        } lut4[7:0];
    } LUT4 @ 0x25;
    reg {
        name = "LUT5";
        desc = "LUT5 is the temperature correction algorithm LUT5 register. LUT5 (offset 0x26, total reset 0xC8; PROVEN: Hi3518E V100 data sheet, PDF page 334, section 3.9.7).";
        field {
            name = "lut5";
            desc = "Temperature correction algorithm LUT5.";
            sw = rw; hw = r;
            reset = 0xc8;
        } lut5[7:0];
    } LUT5 @ 0x26;
    reg {
        name = "LUT6";
        desc = "LUT6 is the temperature correction algorithm LUT6 register. LUT6 (offset 0x27, total reset 0xCF; PROVEN: Hi3518E V100 data sheet, PDF page 335, section 3.9.7).";
        field {
            name = "lut6";
            desc = "Temperature correction algorithm LUT6.";
            sw = rw; hw = r;
            reset = 0xcf;
        } lut6[7:0];
    } LUT6 @ 0x27;
    reg {
        name = "LUT7";
        desc = "LUT7 is the temperature correction algorithm LUT7 register. LUT7 (offset 0x28, total reset 0xD5; PROVEN: Hi3518E V100 data sheet, PDF page 335, section 3.9.7).";
        field {
            name = "lut7";
            desc = "Temperature correction algorithm LUT7.";
            sw = rw; hw = r;
            reset = 0xd5;
        } lut7[7:0];
    } LUT7 @ 0x28;
    reg {
        name = "LUT8";
        desc = "LUT8 is the temperature correction algorithm LUT8 register. LUT8 (offset 0x29, total reset 0xDC; PROVEN: Hi3518E V100 data sheet, PDF page 335, section 3.9.7).";
        field {
            name = "lut8";
            desc = "Temperature correction algorithm LUT8.";
            sw = rw; hw = r;
            reset = 0xdc;
        } lut8[7:0];
    } LUT8 @ 0x29;
    reg {
        name = "LUT9";
        desc = "LUT9 is the temperature correction algorithm LUT9 register. LUT9 (offset 0x2A, total reset 0xE2; PROVEN: Hi3518E V100 data sheet, PDF page 336, section 3.9.7).";
        field {
            name = "lut9";
            desc = "Temperature correction algorithm LUT9.";
            sw = rw; hw = r;
            reset = 0xe2;
        } lut9[7:0];
    } LUT9 @ 0x2a;
    reg {
        name = "LUT10";
        desc = "LUT10 is the temperature correction algorithm LUT10 register. LUT10 (offset 0x2B, total reset 0xE8; PROVEN: Hi3518E V100 data sheet, PDF page 336, section 3.9.7).";
        field {
            name = "lut10";
            desc = "Temperature correction algorithm LUT10.";
            sw = rw; hw = r;
            reset = 0xe8;
        } lut10[7:0];
    } LUT10 @ 0x2b;
    reg {
        name = "LUT11";
        desc = "LUT11 is the temperature correction algorithm LUT11 register. LUT11 (offset 0x2C, total reset 0xEE; PROVEN: Hi3518E V100 data sheet, PDF page 336, section 3.9.7).";
        field {
            name = "lut11";
            desc = "Temperature correction algorithm LUT11.";
            sw = rw; hw = r;
            reset = 0xee;
        } lut11[7:0];
    } LUT11 @ 0x2c;
    reg {
        name = "LUT12";
        desc = "LUT12 is the temperature correction algorithm LUT12 register. LUT12 (offset 0x2D, total reset 0xF3; PROVEN: Hi3518E V100 data sheet, PDF page 337, section 3.9.7).";
        field {
            name = "lut12";
            desc = "Temperature correction algorithm LUT12.";
            sw = rw; hw = r;
            reset = 0xf3;
        } lut12[7:0];
    } LUT12 @ 0x2d;
    reg {
        name = "LUT13";
        desc = "LUT13 is the temperature correction algorithm LUT13 register. LUT13 (offset 0x2E, total reset 0xF9; PROVEN: Hi3518E V100 data sheet, PDF page 337, section 3.9.7).";
        field {
            name = "lut13";
            desc = "Temperature correction algorithm LUT13.";
            sw = rw; hw = r;
            reset = 0xf9;
        } lut13[7:0];
    } LUT13 @ 0x2e;
    reg {
        name = "LUT14";
        desc = "LUT14 is the temperature correction algorithm LUT14 register. LUT14 (offset 0x2F, total reset 0xFE; PROVEN: Hi3518E V100 data sheet, PDF page 337, section 3.9.7).";
        field {
            name = "lut14";
            desc = "Temperature correction algorithm LUT14.";
            sw = rw; hw = r;
            reset = 0xfe;
        } lut14[7:0];
    } LUT14 @ 0x2f;
    reg {
        name = "LUT15";
        desc = "LUT15 is the temperature correction algorithm LUT15 register. LUT15 (offset 0x30, total reset 0x03; PROVEN: Hi3518E V100 data sheet, PDF page 338, section 3.9.7).";
        field {
            name = "lut15";
            desc = "Temperature correction algorithm LUT15.";
            sw = rw; hw = r;
            reset = 0x3;
        } lut15[7:0];
    } LUT15 @ 0x30;
    reg {
        name = "LUT16";
        desc = "LUT16 is the temperature correction algorithm LUT16 register. LUT16 (offset 0x31, total reset 0x08; PROVEN: Hi3518E V100 data sheet, PDF page 338, section 3.9.7).";
        field {
            name = "lut16";
            desc = "Temperature correction algorithm LUT16.";
            sw = rw; hw = r;
            reset = 0x8;
        } lut16[7:0];
    } LUT16 @ 0x31;
    reg {
        name = "LUT17";
        desc = "LUT17 is the temperature correction algorithm LUT17 register. LUT17 (offset 0x32, total reset 0x0D; PROVEN: Hi3518E V100 data sheet, PDF page 338, section 3.9.7).";
        field {
            name = "lut17";
            desc = "Temperature correction algorithm LUT17.";
            sw = rw; hw = r;
            reset = 0xd;
        } lut17[7:0];
    } LUT17 @ 0x32;
    reg {
        name = "LUT18";
        desc = "LUT18 is the temperature correction algorithm LUT18 register. LUT18 (offset 0x33, total reset 0x12; PROVEN: Hi3518E V100 data sheet, PDF page 339, section 3.9.7).";
        field {
            name = "lut18";
            desc = "Temperature correction algorithm LUT18.";
            sw = rw; hw = r;
            reset = 0x12;
        } lut18[7:0];
    } LUT18 @ 0x33;
    reg {
        name = "LUT19";
        desc = "LUT19 is the temperature correction algorithm LUT19 register. LUT19 (offset 0x34, total reset 0x17; PROVEN: Hi3518E V100 data sheet, PDF page 339, section 3.9.7).";
        field {
            name = "lut19";
            desc = "Temperature correction algorithm LUT19.";
            sw = rw; hw = r;
            reset = 0x17;
        } lut19[7:0];
    } LUT19 @ 0x34;
    reg {
        name = "LUT20";
        desc = "LUT20 is the temperature correction algorithm LUT20 register. LUT20 (offset 0x35, total reset 0x1B; PROVEN: Hi3518E V100 data sheet, PDF page 339, section 3.9.7).";
        field {
            name = "lut20";
            desc = "Temperature correction algorithm LUT20.";
            sw = rw; hw = r;
            reset = 0x1b;
        } lut20[7:0];
    } LUT20 @ 0x35;
    reg {
        name = "LUT21";
        desc = "LUT21 is the temperature correction algorithm LUT21 register. LUT21 (offset 0x36, total reset 0x1F; PROVEN: Hi3518E V100 data sheet, PDF page 340, section 3.9.7).";
        field {
            name = "lut21";
            desc = "Temperature correction algorithm LUT21.";
            sw = rw; hw = r;
            reset = 0x1f;
        } lut21[7:0];
    } LUT21 @ 0x36;
    reg {
        name = "LUT22";
        desc = "LUT22 is the temperature correction algorithm LUT22 register. LUT22 (offset 0x37, total reset 0x23; PROVEN: Hi3518E V100 data sheet, PDF page 340, section 3.9.7).";
        field {
            name = "lut22";
            desc = "Temperature correction algorithm LUT22.";
            sw = rw; hw = r;
            reset = 0x23;
        } lut22[7:0];
    } LUT22 @ 0x37;
    reg {
        name = "LUT23";
        desc = "LUT23 is the temperature correction algorithm LUT23 register. LUT23 (offset 0x38, total reset 0x27; PROVEN: Hi3518E V100 data sheet, PDF page 340, section 3.9.7).";
        field {
            name = "lut23";
            desc = "Temperature correction algorithm LUT23.";
            sw = rw; hw = r;
            reset = 0x27;
        } lut23[7:0];
    } LUT23 @ 0x38;
    reg {
        name = "LUT24";
        desc = "LUT24 is the temperature correction algorithm LUT24 register. LUT24 (offset 0x39, total reset 0x2B; PROVEN: Hi3518E V100 data sheet, PDF page 341, section 3.9.7).";
        field {
            name = "lut24";
            desc = "Temperature correction algorithm LUT24.";
            sw = rw; hw = r;
            reset = 0x2b;
        } lut24[7:0];
    } LUT24 @ 0x39;
    reg {
        name = "LUT25";
        desc = "LUT25 is the temperature correction algorithm LUT25 register. LUT25 (offset 0x3A, total reset 0x2E; PROVEN: Hi3518E V100 data sheet, PDF page 341, section 3.9.7).";
        field {
            name = "lut25";
            desc = "Temperature correction algorithm LUT25.";
            sw = rw; hw = r;
            reset = 0x2e;
        } lut25[7:0];
    } LUT25 @ 0x3a;
    reg {
        name = "LUT26";
        desc = "LUT26 is the temperature correction algorithm LUT26 register. LUT26 (offset 0x3B, total reset 0x32; PROVEN: Hi3518E V100 data sheet, PDF page 341, section 3.9.7).";
        field {
            name = "lut26";
            desc = "Temperature correction algorithm LUT26.";
            sw = rw; hw = r;
            reset = 0x32;
        } lut26[7:0];
    } LUT26 @ 0x3b;
    reg {
        name = "LUT27";
        desc = "LUT27 is the temperature correction algorithm LUT27 register. LUT27 (offset 0x3C, total reset 0x35; PROVEN: Hi3518E V100 data sheet, PDF page 342, section 3.9.7).";
        field {
            name = "lut27";
            desc = "Temperature correction algorithm LUT27.";
            sw = rw; hw = r;
            reset = 0x35;
        } lut27[7:0];
    } LUT27 @ 0x3c;
    reg {
        name = "LUT28";
        desc = "LUT28 is the temperature correction algorithm LUT28 register. LUT28 (offset 0x3D, total reset 0x38; PROVEN: Hi3518E V100 data sheet, PDF page 342, section 3.9.7).";
        field {
            name = "lut28";
            desc = "Temperature correction algorithm LUT28.";
            sw = rw; hw = r;
            reset = 0x38;
        } lut28[7:0];
    } LUT28 @ 0x3d;
    reg {
        name = "LUT29";
        desc = "LUT29 is the temperature correction algorithm LUT29 register. LUT29 (offset 0x3E, total reset 0x3B; PROVEN: Hi3518E V100 data sheet, PDF page 342, section 3.9.7).";
        field {
            name = "lut29";
            desc = "Temperature correction algorithm LUT29.";
            sw = rw; hw = r;
            reset = 0x3b;
        } lut29[7:0];
    } LUT29 @ 0x3e;
    reg {
        name = "LUT30";
        desc = "LUT30 is the temperature correction algorithm LUT30 register. LUT30 (offset 0x3F, total reset 0x3E; PROVEN: Hi3518E V100 data sheet, PDF page 343, section 3.9.7).";
        field {
            name = "lut30";
            desc = "Temperature correction algorithm LUT30.";
            sw = rw; hw = r;
            reset = 0x3e;
        } lut30[7:0];
    } LUT30 @ 0x3f;
    reg {
        name = "LUT31";
        desc = "LUT31 is the temperature correction algorithm LUT31 register. LUT31 (offset 0x40, total reset 0x41; PROVEN: Hi3518E V100 data sheet, PDF page 343, section 3.9.7).";
        field {
            name = "lut31";
            desc = "Temperature correction algorithm LUT31.";
            sw = rw; hw = r;
            reset = 0x41;
        } lut31[7:0];
    } LUT31 @ 0x40;
    reg {
        name = "LUT32";
        desc = "LUT32 is the temperature correction algorithm LUT32 register. LUT32 (offset 0x41, total reset 0x43; PROVEN: Hi3518E V100 data sheet, PDF page 343, section 3.9.7).";
        field {
            name = "lut32";
            desc = "Temperature correction algorithm LUT32.";
            sw = rw; hw = r;
            reset = 0x43;
        } lut32[7:0];
    } LUT32 @ 0x41;
    reg {
        name = "LUT33";
        desc = "LUT33 is the temperature correction algorithm LUT33 register. LUT33 (offset 0x42, total reset 0x45; PROVEN: Hi3518E V100 data sheet, PDF page 344, section 3.9.7).";
        field {
            name = "lut33";
            desc = "Temperature correction algorithm LUT33.";
            sw = rw; hw = r;
            reset = 0x45;
        } lut33[7:0];
    } LUT33 @ 0x42;
    reg {
        name = "LUT34";
        desc = "LUT34 is the temperature correction algorithm LUT34 register. LUT34 (offset 0x43, total reset 0x48; PROVEN: Hi3518E V100 data sheet, PDF page 344, section 3.9.7).";
        field {
            name = "lut34";
            desc = "Temperature correction algorithm LUT34.";
            sw = rw; hw = r;
            reset = 0x48;
        } lut34[7:0];
    } LUT34 @ 0x43;
    reg {
        name = "LUT35";
        desc = "LUT35 is the temperature correction algorithm LUT35 register. LUT35 (offset 0x44, total reset 0x4A; PROVEN: Hi3518E V100 data sheet, PDF page 344, section 3.9.7).";
        field {
            name = "lut35";
            desc = "Temperature correction algorithm LUT35.";
            sw = rw; hw = r;
            reset = 0x4a;
        } lut35[7:0];
    } LUT35 @ 0x44;
    reg {
        name = "LUT36";
        desc = "LUT36 is the temperature correction algorithm LUT36 register. LUT36 (offset 0x45, total reset 0x4B; PROVEN: Hi3518E V100 data sheet, PDF page 345, section 3.9.7).";
        field {
            name = "lut36";
            desc = "Temperature correction algorithm LUT36.";
            sw = rw; hw = r;
            reset = 0x4b;
        } lut36[7:0];
    } LUT36 @ 0x45;
    reg {
        name = "LUT37";
        desc = "LUT37 is the temperature correction algorithm LUT37 register. LUT37 (offset 0x46, total reset 0x4D; PROVEN: Hi3518E V100 data sheet, PDF page 345, section 3.9.7).";
        field {
            name = "lut37";
            desc = "Temperature correction algorithm LUT37.";
            sw = rw; hw = r;
            reset = 0x4d;
        } lut37[7:0];
    } LUT37 @ 0x46;
    reg {
        name = "LUT38";
        desc = "LUT38 is the temperature correction algorithm LUT38 register. LUT38 (offset 0x47, total reset 0x4F; PROVEN: Hi3518E V100 data sheet, PDF page 345, section 3.9.7).";
        field {
            name = "lut38";
            desc = "Temperature correction algorithm LUT38.";
            sw = rw; hw = r;
            reset = 0x4f;
        } lut38[7:0];
    } LUT38 @ 0x47;
    reg {
        name = "LUT39";
        desc = "LUT39 is the temperature correction algorithm LUT39 register. LUT39 (offset 0x48, total reset 0x50; PROVEN: Hi3518E V100 data sheet, PDF page 346, section 3.9.7).";
        field {
            name = "lut39";
            desc = "Temperature correction algorithm LUT39.";
            sw = rw; hw = r;
            reset = 0x50;
        } lut39[7:0];
    } LUT39 @ 0x48;
    reg {
        name = "LUT40";
        desc = "LUT40 is the temperature correction algorithm LUT40 register. LUT40 (offset 0x49, total reset 0x51; PROVEN: Hi3518E V100 data sheet, PDF page 346, section 3.9.7).";
        field {
            name = "lut40";
            desc = "Temperature correction algorithm LUT40.";
            sw = rw; hw = r;
            reset = 0x51;
        } lut40[7:0];
    } LUT40 @ 0x49;
    reg {
        name = "LUT41";
        desc = "LUT41 is the temperature correction algorithm LUT41 register. LUT41 (offset 0x4A, total reset 0x52; PROVEN: Hi3518E V100 data sheet, PDF page 346, section 3.9.7).";
        field {
            name = "lut41";
            desc = "Temperature correction algorithm LUT41.";
            sw = rw; hw = r;
            reset = 0x52;
        } lut41[7:0];
    } LUT41 @ 0x4a;
    reg {
        name = "LUT42";
        desc = "LUT42 is the temperature correction algorithm LUT42 register. LUT42 (offset 0x4B, total reset 0x53; PROVEN: Hi3518E V100 data sheet, PDF page 347, section 3.9.7).";
        field {
            name = "lut42";
            desc = "Temperature correction algorithm LUT42.";
            sw = rw; hw = r;
            reset = 0x53;
        } lut42[7:0];
    } LUT42 @ 0x4b;
    reg {
        name = "LUT43";
        desc = "LUT43 is the temperature correction algorithm LUT43 register. LUT43 (offset 0x4C, total reset 0x54; PROVEN: Hi3518E V100 data sheet, PDF page 347, section 3.9.7).";
        field {
            name = "lut43";
            desc = "Temperature correction algorithm LUT43.";
            sw = rw; hw = r;
            reset = 0x54;
        } lut43[7:0];
    } LUT43 @ 0x4c;
    reg {
        name = "LUT44";
        desc = "LUT44 is the temperature correction algorithm LUT44 register. LUT44 (offset 0x4D, total reset 0x54; PROVEN: Hi3518E V100 data sheet, PDF page 347, section 3.9.7).";
        field {
            name = "lut44";
            desc = "Temperature correction algorithm LUT44.";
            sw = rw; hw = r;
            reset = 0x54;
        } lut44[7:0];
    } LUT44 @ 0x4d;
    reg {
        name = "LUT45";
        desc = "LUT45 is the temperature correction algorithm LUT45 register. LUT45 (offset 0x4E, total reset 0x55; PROVEN: Hi3518E V100 data sheet, PDF page 348, section 3.9.7).";
        field {
            name = "lut45";
            desc = "Temperature correction algorithm LUT45.";
            sw = rw; hw = r;
            reset = 0x55;
        } lut45[7:0];
    } LUT45 @ 0x4e;
    reg {
        name = "LUT46";
        desc = "LUT46 is the temperature correction algorithm LUT46 register. LUT46 (offset 0x4F, total reset 0x55; PROVEN: Hi3518E V100 data sheet, PDF page 348, section 3.9.7).";
        field {
            name = "lut46";
            desc = "Temperature correction algorithm LUT46.";
            sw = rw; hw = r;
            reset = 0x55;
        } lut46[7:0];
    } LUT46 @ 0x4f;
    reg {
        name = "LUT47";
        desc = "LUT47 is the temperature correction algorithm LUT47 register. LUT47 (offset 0x50, total reset 0x55; PROVEN: Hi3518E V100 data sheet, PDF page 348, section 3.9.7).";
        field {
            name = "lut47";
            desc = "Temperature correction algorithm LUT47.";
            sw = rw; hw = r;
            reset = 0x55;
        } lut47[7:0];
    } LUT47 @ 0x50;
};

`endif
