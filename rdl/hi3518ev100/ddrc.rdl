`ifndef EHI3518EV100_DDRC_RDL
`define EHI3518EV100_DDRC_RDL
regfile eHI3518EV100_DDRC {
    name = "DDR controller (DDRC)";
    desc = "DDR controller (DDRC). 41 registers extracted programmatically from the Hi3518E 720p IP Camera SoC data sheet (Issue 03, 2015-11-26); chapter 4.1.6, table 4-5. Field names, bit ranges, access types and reset values are taken from the register tables; reset values are the data sheet total reset values split onto the fields (per-field values where the table has them). Label: PROVEN. Hardware not verified here (no board).";
    reg {
        name = "DDRC_STATUS";
        desc = "DDRC_STATUS is a DDRC status register. DDRC_STATUS (offset 0x000, total reset 0x0000_0005; PROVEN: Hi3518E V100 data sheet, PDF page 367, section 4.1.6).";
        field {
            name = "reserved";
            desc = "Reserved.";
            sw = r; hw = w;
            reset = 0x0;
        } reserved_31_4[31:4];
        field {
            name = "in_init";
            desc = "Initialization status of a controller.
- 0: normal
- 1: initializing";
            sw = r; hw = w;
            reset = 0x0;
        } in_init[3:3];
        field {
            name = "in_sr";
            desc = "Self-refresh status of a controller.
- 0: normal
- 1: self refreshing";
            sw = r; hw = w;
            reset = 0x1;
        } in_sr[2:2];
        field {
            name = "reserved";
            desc = "Reserved.";
            sw = r; hw = w;
            reset = 0x0;
        } reserved_1_1[1:1];
        field {
            name = "busy";
            desc = "Busy status of a controller.
- 0: idle
- 1: A command is being processed.";
            sw = r; hw = w;
            reset = 0x1;
        } busy[0:0];
    } DDRC_STATUS @ 0x0;
    reg {
        name = "DDRC_SREFCTRL";
        desc = "DDRC_SREFCTRL is a DDRC self-refresh control register. DDRC_SREFCTRL (offset 0x004, total reset 0x0000_0001; PROVEN: Hi3518E V100 data sheet, PDF page 368, section 4.1.6).";
        field {
            name = "reserved";
            desc = "Reserved.";
            sw = r; hw = w;
            reset = 0x0;
        } reserved_31_1[31:1];
        field {
            name = "sr_req";
            desc = "SDRAM self-refresh request.
- 0: exit the self-refresh status
- 1: enter the self-refresh status";
            sw = rw; hw = r;
            reset = 0x1;
        } sr_req[0:0];
    } DDRC_SREFCTRL @ 0x4;
    reg {
        name = "DDRC_INITCTRL";
        desc = "DDRC_INITCTRL is a DDRC initialization control register. DDRC_INITCTRL (offset 0x008, total reset 0x0000_0000; PROVEN: Hi3518E V100 data sheet, PDF page 368, section 4.1.6).";
        field {
            name = "reserved";
            desc = "Reserved.";
            sw = r; hw = w;
            reset = 0x0;
        } reserved_31_1[31:1];
        field {
            name = "init_req";
            desc = "Initialization enable.
- 0: Initialization is complete or initialization is performed properly.
- 1: The SDRAM starts to be initialized.";
            sw = rw; hw = r;
            reset = 0x0;
        } init_req[0:0];
    } DDRC_INITCTRL @ 0x8;
    reg {
        name = "DDRC_EMRS01";
        desc = "DDRC_EMRS01 is a DDR mode configuration register. DDRC_EMRS01 (offset 0x014, total reset 0x0000_0000; PROVEN: Hi3518E V100 data sheet, PDF page 369, section 4.1.6).";
        field {
            name = "emrs1";
            desc = "DDRn SDRAM extended mode register 1. This field corresponds to bits 15−0 of mode register 1 (MR1) in the DDRn SDRAM user manual. Because MR1 bit[15:14] are not used for most DDRs. DDRC_EMRS01 bit[31:30] are set to 0b00. For details about MR1, see the DDRn SDRAM user manual.";
            sw = rw; hw = r;
            reset = 0x0;
        } emrs1[31:16];
        field {
            name = "mrs";
            desc = "DDRn SDRAM mode register. This field corresponds to bits 15−0 of mode register 0 (MR0) in the DDRn SDRAM user manual. Because MR0 bit[15:14] are not used for most DDRs. DDRC_EMRS01 bit[15:14] are set to 0b00. For details about MR0, see the DDRn SDRAM user manual.";
            sw = rw; hw = r;
            reset = 0x0;
        } mrs[15:0];
    } DDRC_EMRS01 @ 0x14;
    reg {
        name = "DDRC_EMRS23";
        desc = "DDRC_EMRS23 is a DDR extended mode configuration register. DDRC_EMRS23 (offset 0x018, total reset 0x0000_0000; PROVEN: Hi3518E V100 data sheet, PDF page 369, section 4.1.6).";
        field {
            name = "emrs3";
            desc = "DDRn SDRAM extended mode register 3. This field corresponds to bits 15−0 of mode register 3 (MR3) in the DDRn SDRAM user manual. Because MR3 bit[15:14] are not used for most DDRs. DDRC_EMRS23 bit[31:30] are set to 0b00.";
            sw = rw; hw = r;
            reset = 0x0;
        } emrs3[31:16];
        field {
            name = "emrs2";
            desc = "DDRn SDRAM extended mode register 2. This field corresponds to bits 15−0 of mode register 2 (MR2) in the DDRn SDRAM user manual. Because MR2 bit[15:14] are not used for most DDRs. DDRC_EMRS23 bit[15:14] are set to 0b00. For details about MR2, see the DDRn SDRAM user manual.";
            sw = rw; hw = r;
            reset = 0x0;
        } emrs2[15:0];
    } DDRC_EMRS23 @ 0x18;
    reg {
        name = "DDRC_CONFIG0";
        desc = "DDRC_CONFIG0 is DDRC function configuration register 0. DDRC_CONFIG0 (offset 0x01C, total reset 0x2000_0510; PROVEN: Hi3518E V100 data sheet, PDF page 370, section 4.1.6).";
        field {
            name = "init_arefnum";
            desc = "Number of auto-refresh operations when the DDRn SDRAM is being initialized. 0x0–0x2: two 0x3–0xF: n.";
            sw = rw; hw = r;
            reset = 0x2;
        } init_arefnum[31:28];
        field {
            name = "pd_prd";
            desc = "Power down cycle of the SDRAM. When the DDRC does not receive any command in pd_prd consecutive cycles, it forces the DDRn SDRAM to enter the low-power mode; when a command is received, the DDRC forces the DDRn SDRAM to exit the low-power mode.
- 0x00: 1 clock cycle 0x01–0xFF: n clock cycles

Note: This parameter is valid only when pd_en is 1.";
            sw = rw; hw = r;
            reset = 0x0;
        } pd_prd[27:20];
        field {
            name = "rcv_pdr";
            desc = "DDR receive I/O dynamic power-down control enable. The DDRC disables the receive buffer of the DDR data I/O in the non-read status when it is enabled.
- 0: disabled
- 1: enabled";
            sw = rw; hw = r;
            reset = 0x0;
        } rcv_pdr[19:19];
        field {
            name = "sr_cc";
            desc = "DDRn SDRAM clock control in self-refresh mode.
- 0: The DDRn SDRAM clock is enabled.
- 1: The DDRn SDRAM clock is disabled.";
            sw = rw; hw = r;
            reset = 0x0;
        } sr_cc[18:18];
        field {
            name = "pd_cc";
            desc = "DDRn SDRAM clock control in power-down mode.
- 0: The DDRn SDRAM clock is enabled.
- 1: The DDRn SDRAM clock is disabled.

Note: This parameter is valid only when the LPDDR SDRAM or LPDDR2 SDRAM is connected.";
            sw = rw; hw = r;
            reset = 0x0;
        } pd_cc[17:17];
        field {
            name = "pd_en";
            desc = "Automatic low-power enable of the DDRn SDRAM.
- 0: disabled
- 1: enabled";
            sw = rw; hw = r;
            reset = 0x0;
        } pd_en[16:16];
        field {
            name = "reserved";
            desc = "Reserved.";
            sw = rw; hw = r;
            reset = 0x0;
        } reserved_15_14[15:14];
        field {
            name = "rank";
            desc = "Rank configuration of the DDRC.
- 00: 1 rank

Other values: reserved";
            sw = rw; hw = r;
            reset = 0x0;
        } rank[13:12];
        field {
            name = "reserved";
            desc = "Reserved.";
            sw = rw; hw = r;
            reset = 0x0;
        } reserved_11_11[11:11];
        field {
            name = "dram_type";
            desc = "External memory type.
- 101: DDR2
- 110: DDR3

Note: The Hi3518E supports only the DDR2.";
            sw = rw; hw = r;
            reset = 0x5;
        } dram_type[10:8];
        field {
            name = "reserved";
            desc = "Reserved.";
            sw = rw; hw = r;
            reset = 0x0;
        } reserved_7_6[7:6];
        field {
            name = "mem_width";
            desc = "Bit width of the storage data bus.
- 00: 16 bits
- 01: 32 bits

Note: The Hi3518E supports only the 16-bit width.";
            sw = rw; hw = r;
            reset = 0x1;
        } mem_width[5:4];
        field {
            name = "reserved";
            desc = "Reserved.";
            sw = rw; hw = r;
            reset = 0x0;
        } reserved_3_2[3:2];
        field {
            name = "reserved";
            desc = "Reserved";
            sw = rw; hw = r;
            reset = 0x0;
        } reserved_1_1[1:1];
        field {
            name = "brstlen";
            desc = "Burst length of the DDRC.
- 0: burst4
- 1: burst8

When the ratio of the frequency of the DDRC to the frequency of the PHY is 1:1, the burst length of the DDR2 SDRAM can be set to burst 4 or burst 8. When the ratio of the frequency of the DDRC to the frequency of the PHY is 1:2, the burst length of the DDR2 SDRAM can only be set to burst 4.";
            sw = rw; hw = r;
            reset = 0x0;
        } brstlen[0:0];
    } DDRC_CONFIG0 @ 0x1c;
    reg {
        name = "DDRC_CONFIG1";
        desc = "DDRC_CONFIG1 is DDRC function configuration register 1. DDRC_CONFIG1 (offset 0x020, total reset 0x0000_A380; PROVEN: Hi3518E V100 data sheet, PDF page 372, section 4.1.6).";
        field {
            name = "sref_arefnum";
            desc = "Number of times of auto refresh operations after DDRn SDRAM exits auto refresh in DFS process. 0x0–0x1: once 0x2–0xF: n times Note: This field is valid only when train_en is 1. When train_en is 0, DDRn SDRAM exits self refresh and DDRC does not perform auto refresh operation.";
            sw = rw; hw = r;
            reset = 0x0;
        } sref_arefnum[31:28];
        field {
            name = "reserved";
            desc = "Reserved.";
            sw = rw; hw = r;
            reset = 0x0;
        } reserved_27_23[27:23];
        field {
            name = "sref_zqc_en";
            desc = "ZQ calibration long enable when the DDR exits the self-refresh state.
- 0: disabled
- 1: enabled

Note: This bit is valid for the LPDDR2 mode. If the DDR is in the self-refresh state for a long time, set this bit to 1.";
            sw = rw; hw = r;
            reset = 0x0;
        } sref_zqc_en[22:22];
        field {
            name = "reserved";
            desc = "Reserved.";
            sw = rw; hw = r;
            reset = 0x0;
        } reserved_21_21[21:21];
        field {
            name = "clk_switch";
            desc = "DDRC low-power clock switch control. This field determines whether to perform back pressure on AXI port command when DDRC enters the low-power status (DDR self refresh).
- 0: not perform back pressure on the command and return the error response.
- 1: perform back pressure on the command and run the original command when the clock is switched.";
            sw = rw; hw = r;
            reset = 0x0;
        } clk_switch[20:20];
        field {
            name = "reserved";
            desc = "Reserved.";
            sw = rw; hw = r;
            reset = 0x0;
        } reserved_19_18[19:18];
        field {
            name = "odis_ddrio";
            desc = "Output disable configuration of the DDR command and data I/O.
- 0: enable the pin output
- 1: disable the pin output

Note: This is a static configuration. When DDR enters the self–refresh mode, set DDR to 1 to disable the DDR command and data I/O output. Before DDR exits the self–refresh mode, set DDR to 0 to enable the DDR command and data I/O output.";
            sw = rw; hw = r;
            reset = 0x0;
        } odis_ddrio[17:17];
        field {
            name = "pd_ac";
            desc = "SDRAM address command status enable control in power-down mode.
- 0: enable the pin output
- 1: disable the pin output

Note: When pd_en is enabled, pd_ac is valid. The control pins exclude CKE, ODT, CSN, and RESET_N.";
            sw = rw; hw = r;
            reset = 0x0;
        } pd_ac[16:16];
        field {
            name = "pd_pst_opn";
            desc = "SDRAM address/command pin delay before the power-down mode is exited.
- 00: 0 cycles
- 01: 1 cycle
- 10: 2 cycles
- 11: 3cycles

Note: When pd_en is enabled, pd_pst_opn is valid. The control pins exclude CKE and RESET_N.";
            sw = rw; hw = r;
            reset = 0x2;
        } pd_pst_opn[15:14];
        field {
            name = "pd_pre_cls";
            desc = "SDRAM address/command disable delay after the power-down mode is entered.
- 00: 0 cycles
- 01: 1 cycle
- 10: 2 cycles
- 11: 3 cycles

Note: When pd_en is enabled, pd_pre_cls is valid. The control pins exclude CKE and RESET_N.";
            sw = rw; hw = r;
            reset = 0x2;
        } pd_pre_cls[13:12];
        field {
            name = "reserved";
            desc = "Reserved.";
            sw = rw; hw = r;
            reset = 0x0;
        } reserved_11_11[11:11];
        field {
            name = "auto_pre_en";
            desc = "Auto precharge enable.
- 0: disabled
- 1: enabled";
            sw = rw; hw = r;
            reset = 0x0;
        } auto_pre_en[10:10];
        field {
            name = "wr_rcv_mode";
            desc = "Mode of receiving the write command over the DDRC AXI port.
- 0: The write command is received directly.
- 1: The write command is received only after the expected data to be written arrives.";
            sw = rw; hw = r;
            reset = 0x1;
        } wr_rcv_mode[9:9];
        field {
            name = "exclu_en";
            desc = "Exclusive command enable.
- 0: disabled
- 1: enabled";
            sw = rw; hw = r;
            reset = 0x1;
        } exclu_en[8:8];
        field {
            name = "lock_en";
            desc = "WRAP command lock enable.
- 0: disabled
- 1: enabled";
            sw = rw; hw = r;
            reset = 0x1;
        } lock_en[7:7];
        field {
            name = "aref_mode";
            desc = "Auto-refresh mode select.
- 0: An auto-refresh operation is performed every one tREFI period.
- 1: Eight auto-refresh operations are performed every nine tREFI periods.";
            sw = rw; hw = r;
            reset = 0x0;
        } aref_mode[6:6];
        field {
            name = "reserved";
            desc = "Reserved.";
            sw = rw; hw = r;
            reset = 0x0;
        } reserved_5_5[5:5];
        field {
            name = "reserved";
            desc = "Reserved. This field must be set to 0.";
            sw = rw; hw = r;
            reset = 0x0;
        } reserved_4_4[4:4];
        field {
            name = "read_mode";
            desc = "Read mode select of the DDRC.
- 0: associated read mode
- 1: delay read mode

The associated read mode is a mode in which the DDRC samples data based on the data valid signal from the PHY. The delay read mode is a mode in which the DDRC samples the data from the PHY after the internal delay of the DDRC. Note: z This bit must be set to 0 when DDRC_DTRCTRL[train_mode] is set to 0. z The Hi3518E supports only the associated read mode.";
            sw = rw; hw = r;
            reset = 0x0;
        } read_mode[3:3];
        field {
            name = "clkratio";
            desc = "Operating mode of the DDRC. When the frequency ratio of DDRC to PHY is 1:1, this bit is set to 0. When the frequency ratio of DDRC to PHY is 1:2, this bit is set to 1.";
            sw = rw; hw = r;
            reset = 0x0;
        } clkratio[2:2];
        field {
            name = "reserved";
            desc = "Reserved.";
            sw = rw; hw = r;
            reset = 0x0;
        } reserved_1_1[1:1];
        field {
            name = "reserved";
            desc = "Reserved.";
            sw = rw; hw = r;
            reset = 0x0;
        } reserved_0_0[0:0];
    } DDRC_CONFIG1 @ 0x20;
    reg {
        name = "DDRC_CMDCFG";
        desc = "DDRC_CMDCFG is a DDRC command configuration register. DDRC_CMDCFG (offset 0x024, total reset 0x0000_0000; PROVEN: Hi3518E V100 data sheet, PDF page 374, section 4.1.6).";
        field {
            name = "cmd_mrs";
            desc = "Value of the DDR mode register when the load mode register (LMR) command is configured.";
            sw = rw; hw = r;
            reset = 0x0;
        } cmd_mrs[31:16];
        field {
            name = "cmd_ba";
            desc = "Value of the DDR BA when the LMR command is configured.";
            sw = rw; hw = r;
            reset = 0x0;
        } cmd_ba[15:8];
        field {
            name = "cmd_rank";
            desc = "Rank for running commands.
- 0: The configuration command is executed.
- 1: The configuration command is not executed.

Each bit controls a rank. Note: As the Hi3518E only has rank0, cmd_rank must be set to 0x0 or 0x1.";
            sw = rw; hw = r;
            reset = 0x0;
        } cmd_rank[7:4];
        field {
            name = "reserved";
            desc = "Reserved.";
            sw = rw; hw = r;
            reset = 0x0;
        } reserved_3_2[3:2];
        field {
            name = "cmd_type";
            desc = "DDR command configuration.
- 00: enter the deep power-down mode
- 01: exit the deep power-down mode
- 10: LMR command
- 11: ZQCL";
            sw = rw; hw = r;
            reset = 0x0;
        } cmd_type[1:0];
    } DDRC_CMDCFG @ 0x24;
    reg {
        name = "DDRC_CMDEXE";
        desc = "DDRC_CMDEXE is a DDRC software configuration command start register. DDRC_CMDEXE (offset 0x028, total reset 0x0000_0000; PROVEN: Hi3518E V100 data sheet, PDF page 375, section 4.1.6).";
        field {
            name = "reserved";
            desc = "Reserved.";
            sw = r; hw = w;
            reset = 0x0;
        } reserved_31_1[31:1];
        field {
            name = "cmd_req";
            desc = "Request of executing the configuration command of the DDRC.
- 0: The command is not executed or the parameter is cleared automatically after the command is executed.
- 1: The command is requested to be executed.";
            sw = rw; hw = r;
            reset = 0x0;
        } cmd_req[0:0];
    } DDRC_CMDEXE @ 0x28;
    reg {
        name = "DDRC_RNKCFG";
        desc = "DDRC_RNKCFG is a DDR feature configuration register. DDRC_RNKCFG (offset 0x02C, total reset 0x0000_0000; PROVEN: Hi3518E V100 data sheet, PDF page 376, section 4.1.6).";
        field {
            name = "reserved";
            desc = "Reserved.";
            sw = r; hw = w;
            reset = 0x0;
        } reserved_31_14[31:14];
        field {
            name = "mem_map";
            desc = "Address translation mode of the SDRAM.
- 00: {Rank, Row, Ba, Col, DW} = AXI_Address
- 01: {Rank, Ba, Row, Col, DW} = AXI_Address

Other values: reserved";
            sw = rw; hw = r;
            reset = 0x0;
        } mem_map[13:12];
        field {
            name = "reserved";
            desc = "Reserved.";
            sw = rw; hw = r;
            reset = 0x0;
        } reserved_11_9[11:9];
        field {
            name = "mem_bank";
            desc = "Number of banks of a single SDRAM.
- 0: 4 banks
- 1: 8 banks

If there are multiple ranks, the ranks in the same channel can have different configurations. In dual-channel mode, the dual channels must have the same configuration.";
            sw = rw; hw = r;
            reset = 0x0;
        } mem_bank[8:8];
        field {
            name = "reserved";
            desc = "Reserved.";
            sw = rw; hw = r;
            reset = 0x0;
        } reserved_7_7[7:7];
        field {
            name = "mem_row";
            desc = "Bit width of the row address of a single SDRAM.
- 000: 11 bits
- 001: 12 bits
- 010: 13 bits
- 011: 14 bits
- 100: 15 bits
- 101: 16 bits

Other values: reserved";
            sw = rw; hw = r;
            reset = 0x0;
        } mem_row[6:4];
        field {
            name = "reserved";
            desc = "Reserved.";
            sw = rw; hw = r;
            reset = 0x0;
        } reserved_3_3[3:3];
        field {
            name = "mem_col";
            desc = "Bit width of the column address of a single SDRAM.
- 000: 8 bits
- 001: 9 bits
- 010: 10 bits
- 011: 11 bits
- 100: 12 bits

Other values: reserved";
            sw = rw; hw = r;
            reset = 0x0;
        } mem_col[2:0];
    } DDRC_RNKCFG @ 0x2c;
    reg {
        name = "DDRC_BASEADDR";
        desc = "DDRC_BASEADDR is a DDR space base address configuration register. DDRC_BASEADDR (offset 0x040, total reset 0x0000_0000; PROVEN: Hi3518E V100 data sheet, PDF page 377, section 4.1.6).";
        field {
            name = "mem_base_addr";
            desc = "Configuration of the start base address of the DDR in the system.";
            sw = rw; hw = r;
            reset = 0x0;
        } mem_base_addr[31:0];
    } DDRC_BASEADDR @ 0x40;
    reg {
        name = "DDRC_TIMING0";
        desc = "DDRC_TIMING0 is DDR timing parameter register 0. DDRC_TIMING0 (offset 0x050, total reset 0xFFFF_3F1F; PROVEN: Hi3518E V100 data sheet, PDF page 377, section 4.1.6).";
        field {
            name = "tmrd";
            desc = "Count of wait cycles of LMR command. 0x0–0x1: 1 clock cycle 0x2–0xF: n clock cycles";
            sw = rw; hw = r;
            reset = 0xf;
        } tmrd[31:28];
        field {
            name = "trrd";
            desc = "Number of wait cycles of the ACT bank A to ACT bank B command. 0x0–0x1: 1 clock cycle 0x2–0xF: n clock cycles";
            sw = rw; hw = r;
            reset = 0xf;
        } trrd[27:24];
        field {
            name = "trp";
            desc = "Count of wait cycles for disabling commands (PRE period). 0x0–0x1: 1 clock cycle 0x2–0xF: n clock cycles";
            sw = rw; hw = r;
            reset = 0xf;
        } trp[23:20];
        field {
            name = "trcd";
            desc = "Number of wait cycles from the ACT bank command to the read or write bank command. 0x0–0x3: 3 clock cycles 0x4–0xF: n clock cycles";
            sw = rw; hw = r;
            reset = 0xf;
        } trcd[19:16];
        field {
            name = "reserved";
            desc = "Reserved.";
            sw = rw; hw = r;
            reset = 0x0;
        } reserved_15_14[15:14];
        field {
            name = "trc";
            desc = "Number of wait cycles from an ACT bank command to the next ACT bank command. 0x00–0x01: 1 clock cycle 0x02–0x3F: n clock cycles";
            sw = rw; hw = r;
            reset = 0x3f;
        } trc[13:8];
        field {
            name = "reserved";
            desc = "Reserved.";
            sw = rw; hw = r;
            reset = 0x0;
        } reserved_7_5[7:5];
        field {
            name = "tras";
            desc = "Number of wait cycles from ACT to PRE. 0x00–0x01: 1 clock cycle 0x02–0x0F: n clock cycles";
            sw = rw; hw = r;
            reset = 0x1f;
        } tras[4:0];
    } DDRC_TIMING0 @ 0x50;
    reg {
        name = "DDRC_TIMING1";
        desc = "DDRC_TIMING1 is DDR timing parameter register 1. DDRC_TIMING1 (offset 0x054, total reset 0xFF01_45FF; PROVEN: Hi3518E V100 data sheet, PDF page 378, section 4.1.6).";
        field {
            name = "tsre";
            desc = "Number of wait cycles from the self-refresh exit command to the read command.
- 0x0: 1 clock cycle 0x01–0xFF: n x 2 clock cycles";
            sw = rw; hw = r;
            reset = 0xff;
        } tsre[31:24];
        field {
            name = "trdlat";
            desc = "Inherent delay of the DDR PHY. 0x0–0xF: n + 1 clock cycles When the Dophin PHY is used, the value is set to 0x5. This field is valid when read_mode is 1 (delay read mode).";
            sw = rw; hw = r;
            reset = 0x0;
        } trdlat[23:20];
        field {
            name = "trtw";
            desc = "Delay from the last read data segment to the first written data segment. 0x0–0x1: 1 clock cycle 0x2-0xF: n + 1 clock cycles";
            sw = rw; hw = r;
            reset = 0x1;
        } trtw[19:16];
        field {
            name = "twl";
            desc = "Number of wait cycles from the write command to the write data. 0x0–0x1: 1 clock cycle 0x2–0xF: n clock cycles For example, 0x3 indicates 3 clock cycles. Note: In DDR2 mode, tw1 is set to (tcl – 1) and the equation of twl – taond ≥ 1 must be true. Note: The time parameter value is calculated based on the DDR SRAM clock cycle.";
            sw = rw; hw = r;
            reset = 0x4;
        } twl[15:12];
        field {
            name = "tcl";
            desc = "DDR CL from the read command to the read data. 0x0–0x1: 1 clock cycle 0x2–0xF: n clock cycles Note: The time parameter value is calculated based on the DDR SRAM clock cycle.";
            sw = rw; hw = r;
            reset = 0x5;
        } tcl[11:8];
        field {
            name = "trfc";
            desc = "Number of wait cycles of the AREF period or AREF to the ACT command. The register can be set to the maximum value max{trfc, tzqcs}. 0x00–0x01: 1 clock cycle 0x02–0xFF: n clock cycles";
            sw = rw; hw = r;
            reset = 0xff;
        } trfc[7:0];
    } DDRC_TIMING1 @ 0x54;
    reg {
        name = "DDRC_TIMING2";
        desc = "DDRC_TIMING2 is DDR timing parameter register 2. DDRC_TIMING2 (offset 0x058, total reset 0xF3F3_F000; PROVEN: Hi3518E V100 data sheet, PDF page 379, section 4.1.6).";
        field {
            name = "tcke";
            desc = "Minimum cycle of maintaining the low-power mode. 0x0–0x1: 1 clock cycle 0x2–0xF: n clock cycles The value needs to be set to the maximum value among tCKESR, tCKSRE, tCKSRX, and tCKE. When the Dophin DDR PHY is used, the value of this register needs to be set to max{tCKSRx, tCKE} + 3.";
            sw = rw; hw = r;
            reset = 0xf;
        } tcke[31:28];
        field {
            name = "twtr";
            desc = "Number of wait cycles of the last write-to-read command. 0x0–0x1: 1 clock cycle 0x2–0xF: n clock cycles For example, 0x3 indicates 3 clock cycles.";
            sw = rw; hw = r;
            reset = 0x3;
        } twtr[27:24];
        field {
            name = "twr";
            desc = "Number of wait cycles of write recovery. 0x0–0x1: 1 clock cycle 0x2–0xF: n clock cycles Note: When DFS is required, tWR must be set to the maximum frequency in the DFS and cannot be changed with the frequency of the DDR.";
            sw = rw; hw = r;
            reset = 0xf;
        } twr[23:20];
        field {
            name = "reserved";
            desc = "Reserved.";
            sw = rw; hw = r;
            reset = 0x0;
        } reserved_19_18[19:18];
        field {
            name = "tfaw";
            desc = "Number of clock cycles of four consecutive activation commands. 0x00-0x3F: n clock cycles For example, 0x14 indicates 20 clock cycles.";
            sw = rw; hw = r;
            reset = 0x3f;
        } tfaw[17:12];
        field {
            name = "reserved";
            desc = "Reserved.";
            sw = rw; hw = r;
            reset = 0x0;
        } reserved_11_11[11:11];
        field {
            name = "taref";
            desc = "Number of auto-refresh cycles.
- 0x000: forbidden 0x001–0x7FF: The auto-refresh cycle of the SDRAM is 16 x n clock cycles.

For example, 0x008 indicates 128 clock cycles. The configuration interval is calculated as follows: Configuration interval = tREFI/16/Tclk. tREFI is 7800 ns, and Tclk is two times of the running cycle when the SDRAM is used. When DDRC_CONFIG1[aref_mode] is 1, the interval of DDRC_TIMING2 must be set to 8 x tREFI.";
            sw = rw; hw = r;
            reset = 0x0;
        } taref[10:0];
    } DDRC_TIMING2 @ 0x58;
    reg {
        name = "DDRC_TIMING3";
        desc = "DDRC_TIMING3 is DDR timing parameter register 3. DDRC_TIMING3 (offset 0x05C, total reset 0xFFDF_F0F2; PROVEN: Hi3518E V100 data sheet, PDF page 380, section 4.1.6).";
        field {
            name = "tzq_prd";
            desc = "Number of ZQCS command cycles.
- 0x000: The ZQCS command is forbidden. 0x001–0x3FF: n x 128 AREF cycles.

The number of ZQCS command cycles is n x 128 taref clock cycles.";
            sw = rw; hw = r;
            reset = 0x3ff;
        } tzq_prd[31:22];
        field {
            name = "tzqinit";
            desc = "Number of delay cycles during ZQ initialization. 0x0–0x1FF: n + 1 clock cycles The value needs to be set to the maximum value between tZQINIT and tDLLK.";
            sw = rw; hw = r;
            reset = 0x1ff;
        } tzqinit[21:12];
        field {
            name = "taond";
            desc = "Count of ODT enable/disable cycles. In DDR2 mode (taond/taofd):
- 0x0: 2/2.5
- 0x1: 3/3.5";
            sw = rw; hw = r;
            reset = 0x0;
        } taond[11:8];
        field {
            name = "txard";
            desc = "Number of wait cycles of exiting the DDR low-power mode. 0x0–0xF: n clock cycles. The letter n indicates the corresponding decimal value. For example, 0x7 indicates 7 clock cycles. The value is set to the maximum value among tXP, tXARD, tXARDS, and tXS.";
            sw = rw; hw = r;
            reset = 0xf;
        } txard[7:4];
        field {
            name = "trtp";
            desc = "Wait delay from the read command to the disable command. 000–010: 2 clock cycles 011–111: n clock cycles Trtp is calculated as follows: AL + BL/2 + Max(trtp, 2) – 2";
            sw = rw; hw = r;
            reset = 0x2;
        } trtp[3:0];
    } DDRC_TIMING3 @ 0x5c;
    reg {
        name = "DDRC_DTRADDR";
        desc = "DDRC_DTRADDR is a DDRC gating training address configuration register. DDRC_DTRADDR (offset 0x0A0, total reset 0x0000_0000; PROVEN: Hi3518E V100 data sheet, PDF page 381, section 4.1.6).";
        field {
            name = "train_row";
            desc = "Row address of the DDRn SDRAM used in the gating position training. When the row address is less than 16 bits, the upper bits are stuffed with 0s.";
            sw = rw; hw = r;
            reset = 0x0;
        } train_row[31:16];
        field {
            name = "train_bank";
            desc = "Bank address of the DDRn SDRAM used in the gating position training. When the bank address is less than three bits, the upper bits are stuffed with 0s.";
            sw = rw; hw = r;
            reset = 0x0;
        } train_bank[15:13];
        field {
            name = "train_col";
            desc = "Column address of the DDRn SDRAM used in the gating position training. When the column address is less than 13 bits, the upper bits are stuffed with 0s.";
            sw = rw; hw = r;
            reset = 0x0;
        } train_col[12:0];
    } DDRC_DTRADDR @ 0xa0;
    reg {
        name = "DDRC_DTRDATA0";
        desc = "DDRC_DTRDATA0 is DDRC gating training data configuration register 0. DDRC_DTRDATA0 (offset 0x0A4, total reset 0xE11E_D22D; PROVEN: Hi3518E V100 data sheet, PDF page 382, section 4.1.6).";
        field {
            name = "dtr_byte3";
            desc = "Gating training data configuration 0 of the DDRC. When the DDRC performs training, data must be transferred in DDR BL8 mode in each read or write operation. Note: The data configured for each byte (data for the upper four bits and lower four bits) must be different.";
            sw = rw; hw = r;
            reset = 0xe1;
        } dtr_byte3[31:24];
        field {
            name = "dtr_byte2";
            desc = "Gating training data configuration of the DDRC.";
            sw = rw; hw = r;
            reset = 0x1e;
        } dtr_byte2[23:16];
        field {
            name = "dtr_byte1";
            desc = "Gating training data configuration of the DDRC.";
            sw = rw; hw = r;
            reset = 0xd2;
        } dtr_byte1[15:8];
        field {
            name = "dtr_byte0";
            desc = "Gating training data configuration of the DDRC.";
            sw = rw; hw = r;
            reset = 0x2d;
        } dtr_byte0[7:0];
    } DDRC_DTRDATA0 @ 0xa4;
    reg {
        name = "DDRC_DTRDATA1";
        desc = "DDRC_DTRDATA1 is DDRC gating training data configuration register 1. DDRC_DTRDATA1 (offset 0x0A8, total reset 0xC33C_B44B; PROVEN: Hi3518E V100 data sheet, PDF page 382, section 4.1.6).";
        field {
            name = "dtr_byte7";
            desc = "Gating training data configuration 1 of the DDRC. When the DDRC performs training, data must be transferred in DDR BL8 mode in each read or write operation. Note: The data configured for each byte (data for the upper four bits and lower four bits) must be different.";
            sw = rw; hw = r;
            reset = 0xc3;
        } dtr_byte7[31:24];
        field {
            name = "dtr_byte6";
            desc = "Gating training data configuration of the DDRC.";
            sw = rw; hw = r;
            reset = 0x3c;
        } dtr_byte6[23:16];
        field {
            name = "dtr_byte5";
            desc = "Gating training data configuration of the DDRC.";
            sw = rw; hw = r;
            reset = 0xb4;
        } dtr_byte5[15:8];
        field {
            name = "dtr_byte4";
            desc = "Gating training data configuration of the DDRC.";
            sw = rw; hw = r;
            reset = 0x4b;
        } dtr_byte4[7:0];
    } DDRC_DTRDATA1 @ 0xa8;
    reg {
        name = "DDRC_DTRCTRL";
        desc = "DDRC_DTRCTRL is a DDRC gating training control register. DDRC_DTRCTRL (offset 0x0AC, total reset 0x0000_0401; PROVEN: Hi3518E V100 data sheet, PDF page 383, section 4.1.6).";
        field {
            name = "dt_byte";
            desc = "Byte training enable.
- 0: disabled
- 1: enabled [24]: DDRC byte0 training enable … [31]: DDRC byte7 training enable";
            sw = rw; hw = r;
            reset = 0x0;
        } dt_byte[31:24];
        field {
            name = "reserved";
            desc = "Reserved.";
            sw = rw; hw = r;
            reset = 0x0;
        } reserved_23_20[23:20];
        field {
            name = "train_start_pos";
            desc = "Start position of the gating training. 0x0-0x5: n clock cycles Other values: reserved";
            sw = rw; hw = r;
            reset = 0x0;
        } train_start_pos[19:16];
        field {
            name = "reserved";
            desc = "Reserved.";
            sw = rw; hw = r;
            reset = 0x0;
        } reserved_15_14[15:14];
        field {
            name = "train_rank";
            desc = "Number of ranks in the gating training. 0x0–0x3: n + 1 ranks Note: As the Hi3518E has only one rank, train_rank can be set only to 0.";
            sw = rw; hw = r;
            reset = 0x0;
        } train_rank[13:12];
        field {
            name = "rensel";
            desc = "Read enable delay cycle. 000–011: n + 1 clock cycles Other values: reserved";
            sw = rw; hw = r;
            reset = 0x2;
        } rensel[11:9];
        field {
            name = "train_mode";
            desc = "Gating training mode.
- 0: Dophin training mode
- 1: common training mode";
            sw = rw; hw = r;
            reset = 0x0;
        } train_mode[8:8];
        field {
            name = "reserved";
            desc = "Reserved.";
            sw = rw; hw = r;
            reset = 0x0;
        } reserved_7_6[7:6];
        field {
            name = "dt_limit";
            desc = "DQS gating shift control.
- 00: shift 0°
- 01: shift 90°
- 10: shift 180°
- 11: shift 270°";
            sw = rw; hw = r;
            reset = 0x0;
        } dt_limit[5:4];
        field {
            name = "reserved";
            desc = "Reserved.";
            sw = rw; hw = r;
            reset = 0x0;
        } reserved_3_3[3:3];
        field {
            name = "track_en";
            desc = "Auto-refresh enable for the gating position.
- 0: disabled
- 1: enabled

Note: A read operation is required between two training operations and the continuous length of the accessed data must be greater than DDR burst 8.";
            sw = rw; hw = r;
            reset = 0x0;
        } track_en[2:2];
        field {
            name = "train_en";
            desc = "Gating position training enable.
- 0: disabled
- 1: enabled";
            sw = rw; hw = r;
            reset = 0x0;
        } train_en[1:1];
        field {
            name = "reserved";
            desc = "Reserved.";
            sw = rw; hw = r;
            reset = 0x1;
        } reserved_0_0[0:0];
    } DDRC_DTRCTRL @ 0xac;
    reg {
        name = "DDRC_DTRPRD";
        desc = "DDRC_DTRPRD is a DDRC gating track period configuration register. DDRC_DTRPRD (offset 0x0B0, total reset 0x0000_0000; PROVEN: Hi3518E V100 data sheet, PDF page 384, section 4.1.6).";
        field {
            name = "reserved";
            desc = "Reserved.";
            sw = r; hw = w;
            reset = 0x0;
        } reserved_31_20[31:20];
        field {
            name = "track_prd";
            desc = "Auto-update period configuration of the DQS gating. The DDRC tracks the gating position in the configured period.
- 0x0: 1 AREF period 0x1–0x7FF: n + 1 AREF periods";
            sw = rw; hw = r;
            reset = 0x0;
        } track_prd[19:0];
    } DDRC_DTRPRD @ 0xb0;
    reg {
        name = "DDRC_DTRGATE";
        desc = "DDRC_DTRGATE is a DDRC gating phase position register. DDRC_DTRGATE (offset 0x0B4, total reset 0x0000_0000; PROVEN: Hi3518E V100 data sheet, PDF page 384, section 4.1.6).";
        field {
            name = "reserved";
            desc = "Reserved. Note: This register cannot be read continuously.";
            sw = r; hw = w;
            reset = 0x0;
        } reserved_31_16[31:16];
        field {
            name = "gate_sel";
            desc = "Gating phase position of the DDRC.
- 00: 0°
- 01: 90°
- 10: 180°
- 11: 270° [2 x (N + 1) – 1:2 x N]: gating phase of DDRC byteN

N = 0–7";
            sw = rw; hw = r;
            reset = 0x0;
        } gate_sel[15:0];
    } DDRC_DTRGATE @ 0xb4;
    reg {
        name = "DDRC_DTRLAT";
        desc = "DDRC_DTRLAT is a DDRC gating period position register. DDRC_DTRLAT (offset 0x0C4, total reset 0x0000_0000; PROVEN: Hi3518E V100 data sheet, PDF page 385, section 4.1.6).";
        field {
            name = "sys_lat";
            desc = "Number of gating delay cycles of the DDRC. 0x0–0x5: n clock cycles Other values: reserved [4 x (N + 1) – 1:4 x N]: gating phase of DDRC ByteN. N = 0–7 Note: This register cannot be read or written continuously.";
            sw = rw; hw = r;
            reset = 0x0;
        } sys_lat[31:0];
    } DDRC_DTRLAT @ 0xc4;
    reg {
        name = "DDRC_DTRSTATUS";
        desc = "DDRC_DTRSTATUS is a DDRC gating status register. DDRC_DTRSTATUS (offset 0x0D4, total reset 0x0000_0000; PROVEN: Hi3518E V100 data sheet, PDF page 385, section 4.1.6).";
        field {
            name = "dtr_st";
            desc = "Phase shift status of the byte gating position.
- 00: shift 0°
- 01: shift 90°
- 10: shift 180°
- 11: shift 270° bit[31:30] to bit[17:16]: Each two bits correspond to DDRC byte7 to DDRC byte0 respectively.";
            sw = r; hw = w;
            reset = 0x0;
        } dtr_st[31:16];
        field {
            name = "dtr_ok";
            desc = "Gating training status.
- 0: training error
- 1: no training error bit[15] to bit[8]: Each bit corresponds to DDRC byte7 to DDRC byte0 respectively.";
            sw = r; hw = w;
            reset = 0x0;
        } dtr_ok[15:8];
        field {
            name = "dtr_err";
            desc = "Auto tracking error status of the gating position.
- 0: no tracking error
- 1: tracking error bit[7] to bit[0]: Each bit corresponds to DDRC byte7 to DDRC byte0 respectively.";
            sw = r; hw = w;
            reset = 0x0;
        } dtr_err[7:0];
    } DDRC_DTRSTATUS @ 0xd4;
    reg {
        name = "DDRC_AXISTATUS";
        desc = "DDRC_AXISTATUS is a DDRC interface status register. DDRC_AXISTATUS (offset 0x0F0, total reset 0x0000_0000; PROVEN: Hi3518E V100 data sheet, PDF page 386, section 4.1.6).";
        field {
            name = "reserved";
            desc = "Reserved.";
            sw = r; hw = w;
            reset = 0x0;
        } reserved_31_8[31:8];
        field {
            name = "axi_st7";
            desc = "Status of DDRC bus interface 7.
- 0: idle
- 1: A command is being executed.";
            sw = r; hw = w;
            reset = 0x0;
        } axi_st7[7:7];
        field {
            name = "axi_st6";
            desc = "Status of DDRC bus interface 6.
- 0: idle
- 1: A command is being executed.";
            sw = r; hw = w;
            reset = 0x0;
        } axi_st6[6:6];
        field {
            name = "axi_st5";
            desc = "Status of DDRC bus interface 5.
- 0: idle
- 1: A command is being executed.";
            sw = r; hw = w;
            reset = 0x0;
        } axi_st5[5:5];
        field {
            name = "axi_st4";
            desc = "Status of DDRC bus interface 4.
- 0: idle
- 1: A command is being executed.";
            sw = r; hw = w;
            reset = 0x0;
        } axi_st4[4:4];
        field {
            name = "axi_st3";
            desc = "Status of DDRC bus interface 3.
- 0: idle
- 1: A command is being executed.";
            sw = r; hw = w;
            reset = 0x0;
        } axi_st3[3:3];
        field {
            name = "axi_st2";
            desc = "Status of DDRC bus interface 2.
- 0: idle
- 1: A command is being executed.";
            sw = r; hw = w;
            reset = 0x0;
        } axi_st2[2:2];
        field {
            name = "axi_st1";
            desc = "Status of DDRC bus interface 1.
- 0: idle
- 1: A command is being executed.";
            sw = r; hw = w;
            reset = 0x0;
        } axi_st1[1:1];
        field {
            name = "axi_st0";
            desc = "Status of DDRC bus interface 0.
- 0: idle
- 1: A command is being executed.";
            sw = r; hw = w;
            reset = 0x0;
        } axi_st0[0:0];
    } DDRC_AXISTATUS @ 0xf0;
    reg {
        name = "DDRC_ODTCFG";
        desc = "DDRC_ODTCFG is a DDR ODT feature configuration register. DDRC_ODTCFG (offset 0x0F4, total reset 0x0000_0000; PROVEN: Hi3518E V100 data sheet, PDF page 387, section 4.1.6).";
        field {
            name = "reserved";
            desc = "Reserved. This field must be fixed at 0.";
            sw = rw; hw = r;
            reset = 0x0;
        } reserved_31_17[31:17];
        field {
            name = "rodt0";
            desc = "Read ODT configuration of rank0.
- 0: disabled
- 1: enabled";
            sw = rw; hw = r;
            reset = 0x0;
        } rodt0[16:16];
        field {
            name = "reserved";
            desc = "Reserved. This field must be fixed at 0.";
            sw = rw; hw = r;
            reset = 0x0;
        } reserved_15_1[15:1];
        field {
            name = "wodt0";
            desc = "Write ODT configuration of rank1.
- 0: disabled
- 1: enabled";
            sw = rw; hw = r;
            reset = 0x0;
        } wodt0[0:0];
    } DDRC_ODTCFG @ 0xf4;
    reg {
        name = "DDRC_QOSCFG0";
        desc = "DDRC_QOSCFG0 is DDRC QoS algorithm configuration register 0. DDRC_QOSCFG0 (offset 0x100, total reset 0x0000_000F; PROVEN: Hi3518E V100 data sheet, PDF page 388, section 4.1.6).";
        field {
            name = "reserved";
            desc = "Reserved.";
            sw = rw; hw = r;
            reset = 0x0;
        } reserved_31_7[31:7];
        field {
            name = "idmap_mode";
            desc = "ID mapping mode.
- 0: The id_map mapping mode configured by the register is used by default.
- 1: The QoS mapping mode is used. The AXI port configures this mode in associated mode by running read/write commands. This mapping mode is valid only when its macro definition is enabled in the RTL code.

This field must be 1.";
            sw = rw; hw = r;
            reset = 0x0;
        } idmap_mode[6:6];
        field {
            name = "id_order_ctl";
            desc = "Out-of –order execution enable of the specified ID.
- 0: disabled
- 1: enabled The DDRC does not ensure the order when conflict occurs between the DDR row addresses of the read/write commands with the specified ID and other IDs. Master ensures the consistency of the data.";
            sw = rw; hw = r;
            reset = 0x0;
        } id_order_ctl[5:5];
        field {
            name = "order_en";
            desc = "Execution order enable for the commands with the same priority.
- 0: disabled
- 1: enabled";
            sw = rw; hw = r;
            reset = 0x0;
        } order_en[4:4];
        field {
            name = "dmc_fifo_lvl";
            desc = "Depth of the command register FIFO in the DMC. 0x0–0xF: n + 1 command depths Note: The maximum depth of the command register FIFO in the Hi3518E is 0xB, but it is recommended to set the depth to 0x7.";
            sw = rw; hw = r;
            reset = 0xf;
        } dmc_fifo_lvl[3:0];
    } DDRC_QOSCFG0 @ 0x100;
    reg {
        name = "DDRC_QOS";
        desc = "DDRC_QOS is a DDRC command priority configuration register. DDRC_QOS (offset 0x150+0x4 x id0 id0(0-15), total reset 0x0000_0004; PROVEN: Hi3518E V100 data sheet, PDF page 389, section 4.1.6). Per-instance register (offset = 0x150+0x4 x id0 id0(0~15)); the first instance is modelled.";
        field {
            name = "reserved";
            desc = "Reserved.";
            sw = rw; hw = r;
            reset = 0x0;
        } reserved_31_28[31:28];
        field {
            name = "pri_apt";
            desc = "Command priority adaptation configuration.
- 0x0: disabled 0x1−0xF: n x 16 clock cycles";
            sw = rw; hw = r;
            reset = 0x0;
        } pri_apt[27:24];
        field {
            name = "age_prd";
            desc = "Command aging cycle configuration.
- 0x0: disabled 0x1−0xF: n x 16 clock cycles";
            sw = rw; hw = r;
            reset = 0x0;
        } age_prd[23:20];
        field {
            name = "reserved";
            desc = "Reserved.";
            sw = rw; hw = r;
            reset = 0x0;
        } reserved_19_17[19:17];
        field {
            name = "qos_en";
            desc = "Command QoS enable (timeout).
- 0: disabled
- 1: enabled";
            sw = rw; hw = r;
            reset = 0x0;
        } qos_en[16:16];
        field {
            name = "reserved";
            desc = "Reserved.";
            sw = rw; hw = r;
            reset = 0x0;
        } reserved_15_14[15:14];
        field {
            name = "qos";
            desc = "Command QoS configuration (timeout). 0x1−0x3FF: n clock cycles Other values: reserved Note: The used timeout is an integral multiple of 16. The lower four bits of rd_qos is ignored.";
            sw = rw; hw = r;
            reset = 0x0;
        } qos[13:4];
        field {
            name = "reserved";
            desc = "Reserved.";
            sw = rw; hw = r;
            reset = 0x0;
        } reserved_3_3[3:3];
        field {
            name = "pri";
            desc = "Command priority configuration.
- 000: highest priority
- 001: higher priority …
- 111: lowest priority";
            sw = rw; hw = r;
            reset = 0x4;
        } pri[2:0];
    } DDRC_QOS @ 0x150;
    reg {
        name = "DDRC_FLUX";
        desc = "DDRC_FLUX is a DDRC AXI port bandwidth traffic control configuration register. DDRC_FLUX (offset 0x200+0x4 x ports ports(0-5), total reset 0x0000_0000; PROVEN: Hi3518E V100 data sheet, PDF page 390, section 4.1.6). Per-instance register (offset = 0x200+0x4 x ports ports(0~5)); the first instance is modelled.";
        field {
            name = "reserved";
            desc = "Reserved.";
            sw = rw; hw = r;
            reset = 0x0;
        } reserved_31_22[31:22];
        field {
            name = "flux_port_en";
            desc = "AXI port DDRC traffic count enable.
- 0: disabled
- 1: enabled";
            sw = rw; hw = r;
            reset = 0x0;
        } flux_port_en[21:21];
        field {
            name = "flux_ovfl";
            desc = "AXI port traffic overflow allow enable.
- 0: disabled
- 1: enabled

When this bit is set to 1, the traffic of the AXI port exceeds the bandwidth limit, and no request is raised over the AXI ports without overflow, the bandwidth of the AXI port can exceed the configured value.";
            sw = rw; hw = r;
            reset = 0x0;
        } flux_ovfl[20:20];
        field {
            name = "reserved";
            desc = "Reserved.";
            sw = rw; hw = r;
            reset = 0x0;
        } reserved_19_17[19:17];
        field {
            name = "flux_lvl";
            desc = "AXI port traffic overflow allow threshold. 0x0–0xC: DMC threshold for allowing traffic overflow Other values: reserved When flux_ovfl is set to 1, this traffic overflow over the AXI port is allowed if the traffic of the AXI port is greater than the configured bandwidth of flux and the number of the commands to be processed in DMC is less than the configured threshold.";
            sw = rw; hw = r;
            reset = 0x0;
        } flux_lvl[16:12];
        field {
            name = "reserved";
            desc = "Reserved.";
            sw = rw; hw = r;
            reset = 0x0;
        } reserved_11_10[11:10];
        field {
            name = "flux";
            desc = "Bandwidth configuration of the AXI port. 0x0–0x3FF: ratio of the maximum DDR bandwidth to the total bandwidth accessed by the AXI port. The total bandwidth is 1024. The configured value is calculated as follows: ratio of the required bandwidth to the total bandwidth x1024. For example, if 20% of bandwidth is required for this AXI port, configure flux to 0xCD.";
            sw = rw; hw = r;
            reset = 0x0;
        } flux[9:0];
    } DDRC_FLUX @ 0x200;
    reg {
        name = "DDRC_TEST0";
        desc = "DDRC_TEST0 is a DDRC test status register. DDRC_TEST0 (offset 0x240, total reset 0x0000_0000; PROVEN: Hi3518E V100 data sheet, PDF page 391, section 4.1.6).";
        field {
            name = "dmc_ct";
            desc = "DDRC command type.";
            sw = r; hw = w;
            reset = 0x0;
        } dmc_ct[31:16];
        field {
            name = "dmc_cv";
            desc = "Commands that are being processed by the DDRC.";
            sw = r; hw = w;
            reset = 0x0;
        } dmc_cv[15:0];
    } DDRC_TEST0 @ 0x240;
    reg {
        name = "DDRC_TEST1";
        desc = "DDRC_TEST1 is a DDRC test status register. DDRC_TEST1 (offset 0x244, total reset 0x0000_0000; PROVEN: Hi3518E V100 data sheet, PDF page 391, section 4.1.6).";
        field {
            name = "reserved";
            desc = "Reserved.";
            sw = r; hw = w;
            reset = 0x0;
        } reserved_31_9[31:9];
        field {
            name = "dt_num";
            desc = "Cycle n select, data read from the training module (n = 0–23).";
            sw = rw; hw = r;
            reset = 0x0;
        } dt_num[8:4];
        field {
            name = "reserved";
            desc = "Reserved.";
            sw = rw; hw = r;
            reset = 0x0;
        } reserved_3_3[3:3];
        field {
            name = "byte_sel";
            desc = "Channel select of the returned data. 0x0–0x7: channel n select";
            sw = rw; hw = r;
            reset = 0x0;
        } byte_sel[2:0];
    } DDRC_TEST1 @ 0x244;
    reg {
        name = "DDRC_TEST2";
        desc = "DDRC_TEST2 is a DDRC test status register. DDRC_TEST2 (offset 0x248, total reset 0x0000_0000; PROVEN: Hi3518E V100 data sheet, PDF page 392, section 4.1.6).";
        field {
            name = "data_h";
            desc = "Upper 32 bits of the training data.";
            sw = r; hw = w;
            reset = 0x0;
        } data_h[31:0];
    } DDRC_TEST2 @ 0x248;
    reg {
        name = "DDRC_TEST3";
        desc = "DDRC_TEST3 is a DDRC test status register. DDRC_TEST3 (offset 0x24C, total reset 0x0000_0000; PROVEN: Hi3518E V100 data sheet, PDF page 392, section 4.1.6).";
        field {
            name = "data_l";
            desc = "Lower 32 bits of the training data.";
            sw = r; hw = w;
            reset = 0x0;
        } data_l[31:0];
    } DDRC_TEST3 @ 0x24c;
    reg {
        name = "DDRC_TEST4";
        desc = "DDRC_TEST4 is a DDRC test status register. DDRC_TEST4 (offset 0x250, total reset 0x0000_0000; PROVEN: Hi3518E V100 data sheet, PDF page 392, section 4.1.6).";
        field {
            name = "dt_ok_cnt";
            desc = "Number of times of correct training data. 0x0–0xF: n + 1 [3 x (N + 1) – 1:3 x N]: number of times of correct byteN";
            sw = r; hw = w;
            reset = 0x0;
        } dt_ok_cnt[31:0];
    } DDRC_TEST4 @ 0x250;
    reg {
        name = "DDRC_TEST7";
        desc = "DDRC_TEST7 is a DDRC performance measurement control register. DDRC_TEST7 (offset 0x260, total reset 0x0000_0000; PROVEN: Hi3518E V100 data sheet, PDF page 393, section 4.1.6).";
        field {
            name = "perf_mode";
            desc = "Performance measurement mode.
- 0: continuous trigger mode. The performance counter counts continuously. No data overflow occurs within 1s = (533 MHz).
- 1: single trigger mode. When the performance counter reaches the maximum value, the count value is retained but counting is stopped.

Note: When an overflow occurs, the count values wrap.";
            sw = rw; hw = r;
            reset = 0x0;
        } perf_mode[31:31];
        field {
            name = "perf_en";
            desc = "Performance measurement enable.
- 0: disabled
- 1: enabled

Note: When perf_mode is 0 and this bit is enabled, performance measurement register starts cyclic counting. When perf_mode is 1, this bit is cleared after counting is complete once.";
            sw = rw; hw = r;
            reset = 0x0;
        } perf_en[30:30];
        field {
            name = "perf_ch";
            desc = "Read and write count channel.
- 00: disabled
- 01: channel 0
- 10: channel 1
- 11: channel 0 and channel 1

Note: This register limits the number of read/write command count channels of DDRC_TEST8 and DDRC_TEST9.";
            sw = rw; hw = r;
            reset = 0x0;
        } perf_ch[29:28];
        field {
            name = "perf_prd";
            desc = "Performance measurement cycle. 0x0–0xFFFFFFF: count cycles The actual count cycle is calculated as follows: perf_prd x 4 xtclk. Where tclk is the bus clock cycle of the DDRC. Note: This configuration is valid only when perf_mode is 1. When perf_mode is set to 0 to select the continuous count mode, the performance counters keep on counting.";
            sw = rw; hw = r;
            reset = 0x0;
        } perf_prd[27:0];
    } DDRC_TEST7 @ 0x260;
    reg {
        name = "DDRC_TEST8";
        desc = "DDRC_TEST8 is a DDRC write command count register. DDRC_TEST8 (offset 0x264, total reset 0x0000_0000; PROVEN: Hi3518E V100 data sheet, PDF page 394, section 4.1.6).";
        field {
            name = "wr_num";
            desc = "Count of write commands in the count period. This register is written to clear. Wrap cycle counting is supported. (data sheet access type RWC)";
            sw = rw; hw = rw; onwrite = woclr;
            reset = 0x0;
        } wr_num[31:0];
    } DDRC_TEST8 @ 0x264;
    reg {
        name = "DDRC_TEST9";
        desc = "DDRC_TEST9 is a DDRC read command count register. DDRC_TEST9 (offset 0x268, total reset 0x0000_0000; PROVEN: Hi3518E V100 data sheet, PDF page 394, section 4.1.6).";
        field {
            name = "rd_num";
            desc = "Count of read commands in the count period. This register is written to clear. Wrap cycle counting is supported. (data sheet access type RWC)";
            sw = rw; hw = rw; onwrite = woclr;
            reset = 0x0;
        } rd_num[31:0];
    } DDRC_TEST9 @ 0x268;
    reg {
        name = "DDRC_TEST10";
        desc = "DDRC_TEST10 is a DDRC DMC wait command count register. DDRC_TEST10 (offset 0x26C, total reset 0x0000_0000; PROVEN: Hi3518E V100 data sheet, PDF page 394, section 4.1.6).";
        field {
            name = "dmc_cmd_num";
            desc = "Count of DMC wait commands of the DDRC in the count period. This register is written to clear. Wrap cycle counting is supported. Note: As the register width is limited and data overflow needs to be avoided within 1s under the 533 MHz clock, the displayed count value of this register is the actual count value divided by 2. (data sheet access type RWC)";
            sw = rw; hw = rw; onwrite = woclr;
            reset = 0x0;
        } dmc_cmd_num[31:0];
    } DDRC_TEST10 @ 0x26c;
    reg {
        name = "DDRC_TEST12";
        desc = "DDRC_TEST12 is a DDRC test status register. DDRC_TEST12 (offset 0x280, total reset 0x0000_0FFF; PROVEN: Hi3518E V100 data sheet, PDF page 395, section 4.1.6).";
        field {
            name = "wfifo_f";
            desc = "Write FIFO full status.";
            sw = r; hw = w;
            reset = 0x0;
        } wfifo_f[31:16];
        field {
            name = "wfifo_e";
            desc = "Write FIFO empty status. Note: Only the 12-bit reset value is 0xFFF for the Hi3518E.";
            sw = r; hw = w;
            reset = 0xfff;
        } wfifo_e[15:0];
    } DDRC_TEST12 @ 0x280;
    reg {
        name = "DDRC_TEST13";
        desc = "DDRC_TEST13 is DDRC reorder test status register 1. DDRC_TEST13 (offset 0x284, total reset 0x0000_0000; PROVEN: Hi3518E V100 data sheet, PDF page 395, section 4.1.6).";
        field {
            name = "reserved";
            desc = "Reserved.";
            sw = r; hw = w;
            reset = 0x0;
        } reserved_31_16[31:16];
        field {
            name = "ddrexec_reorder";
            desc = "DDREXEC reorder status.";
            sw = r; hw = w;
            reset = 0x0;
        } ddrexec_reorder[15:0];
    } DDRC_TEST13 @ 0x284;
    reg {
        name = "DDRC_TEST14";
        desc = "DDRC_TEST14 is DDRC reorder test status register 2. DDRC_TEST14 (offset 0x288, total reset 0x0000_0000; PROVEN: Hi3518E V100 data sheet, PDF page 396, section 4.1.6).";
        field {
            name = "reserved";
            desc = "Reserved.";
            sw = r; hw = w;
            reset = 0x0;
        } reserved_31_16[31:16];
        field {
            name = "ddrexec_reorder_req";
            desc = "DDREXEC reorder request status.";
            sw = r; hw = w;
            reset = 0x0;
        } ddrexec_reorder_req[15:0];
    } DDRC_TEST14 @ 0x288;
    reg {
        name = "DDRC_TEST15";
        desc = "DDRC_TEST15 is DDRC reorder test status register 3. DDRC_TEST15 (offset 0x28C, total reset 0x0000_0000; PROVEN: Hi3518E V100 data sheet, PDF page 396, section 4.1.6).";
        field {
            name = "reserved";
            desc = "Reserved.";
            sw = r; hw = w;
            reset = 0x0;
        } reserved_31_16[31:16];
        field {
            name = "ddrexec_reorder_gnt";
            desc = "DDREXEC reorder arbitration status.";
            sw = r; hw = w;
            reset = 0x0;
        } ddrexec_reorder_gnt[15:0];
    } DDRC_TEST15 @ 0x28c;
};

`endif
