`ifndef EHI3518EV100_VDP_RDL
`define EHI3518EV100_VDP_RDL
regfile eHI3518EV100_VDP {
    name = "Video display processor (VDP, VOU)";
    desc = "Video display processor (VDP, VOU). 68 registers extracted programmatically from the Hi3518E 720p IP Camera SoC data sheet (Issue 03, 2015-11-26); chapters 10.2.5, table 10-8. Field names, bit ranges, access types and reset values are taken from the register tables; reset values are the data sheet total reset values split onto the fields (per-field values where the table has them). Label: PROVEN. Hardware not verified here (no board).";
    reg {
        name = "VSD1VFPOS";
        desc = "VSD1VFPOS is a VSD surface content start position (in the display window) register (non- instant register). The start position is in the unit of pixel. VSD1VFPOS (offset 0x3068, total reset 0x0000_0000; PROVEN: Hi3518E V100 data sheet, PDF page 702, section 10.2.5).";
        field {
            name = "reserved";
            desc = "Reserved.";
            sw = r; hw = w;
            reset = 0x0;
        } reserved_31_24[31:24];
        field {
            name = "video_yfpos";
            desc = "Start coordinate of the video column. The frame height is referenced and the unit is line.";
            sw = rw; hw = r;
            reset = 0x0;
        } video_yfpos[23:12];
        field {
            name = "video_xfpos";
            desc = "Start coordinate of the video row.";
            sw = rw; hw = r;
            reset = 0x0;
        } video_xfpos[11:0];
    } VSD1VFPOS @ 0x3068;
    reg {
        name = "VSD1VLPOS";
        desc = "VSD1VLPOS is a VSD surface content end position (in the display window) register (non- instant register). The end position is in the unit of pixel. VSD1VLPOS (offset 0x306C, total reset 0x0000_0000; PROVEN: Hi3518E V100 data sheet, PDF page 702, section 10.2.5).";
        field {
            name = "reserved";
            desc = "Reserved.";
            sw = r; hw = w;
            reset = 0x0;
        } reserved_31_24[31:24];
        field {
            name = "video_ylpos";
            desc = "End coordinate of the video column. The frame height is referenced and the unit is line.";
            sw = rw; hw = r;
            reset = 0x0;
        } video_ylpos[23:12];
        field {
            name = "video_xlpos";
            desc = "End coordinate of the video row.";
            sw = rw; hw = r;
            reset = 0x0;
        } video_xlpos[11:0];
    } VSD1VLPOS @ 0x306c;
    reg {
        name = "VSD1CTRL";
        desc = "VSD1CTRL is a VSD control register (non-instant register). It is used to configure the layer information VSD1CTRL (offset 0x4000, total reset 0x0000_0000; PROVEN: Hi3518E V100 data sheet, PDF page 697, section 10.2.5).";
        field {
            name = "surface_en";
            desc = "Surface enable (non-instant register).
- 0: disabled
- 1: enabled";
            sw = rw; hw = r;
            reset = 0x0;
        } surface_en[31:31];
        field {
            name = "reserved";
            desc = "Reserved.";
            sw = r; hw = na;
            reset = 0x0;
        } reserved_30_20[30:20];
        field {
            name = "ifir_mode";
            desc = "Horizontal chrominance IFIR mode.
- 00: reserved
- 01: chrominance IFIR copy mode
- 10: bilinear interpolation
- 11: 6-tap FIR";
            sw = rw; hw = r;
            reset = 0x0;
        } ifir_mode[19:18];
        field {
            name = "vup_mode";
            desc = "Register update mode.
- 0: update by field
- 1: update by frame";
            sw = r; hw = na;
            reset = 0x0;
        } vup_mode[17:17];
        field {
            name = "reserved";
            desc = "Reserved.";
            sw = r; hw = na;
            reset = 0x0;
        } reserved_16_4[16:4];
        field {
            name = "ifmt";
            desc = "Input data format.
- 0x3: SPYCbCr420
- 0x4: SPYCbCr422

Other values: reserved";
            sw = rw; hw = r;
            reset = 0x0;
        } ifmt[3:0];
    } VSD1CTRL @ 0x4000;
    reg {
        name = "VSD1UPD";
        desc = "VSD1UPD is a VSD channel update enable register. VSD1UPD (offset 0x4004, total reset 0x0000_0000; PROVEN: Hi3518E V100 data sheet, PDF page 698, section 10.2.5).";
        field {
            name = "reserved";
            desc = "Reserved.";
            sw = r; hw = na;
            reset = 0x0;
        } reserved_31_1[31:1];
        field {
            name = "regup";
            desc = "Surface register update. After the registers at this layer are configured, the registers are updated when the value 1 is written to this bit. After updates, this bit is cleared automatically by the hardware.";
            sw = rw; hw = r;
            reset = 0x0;
        } regup[0:0];
    } VSD1UPD @ 0x4004;
    reg {
        name = "VSD1CADDR";
        desc = "VSD1CADDR is a VSD current frame address register. In package pixel format, the address is the address of the frame buffer; in semi-planar pixel format, the address is the address of the luminance frame buffer. VSD1CADDR (offset 0x4010, total reset 0x0000_0000; PROVEN: Hi3518E V100 data sheet, PDF page 698, section 10.2.5).";
        field {
            name = "surface_caddr";
            desc = "Address of the current frame.";
            sw = rw; hw = r;
            reset = 0x0;
        } surface_caddr[31:0];
    } VSD1CADDR @ 0x4010;
    reg {
        name = "VSD1CCADDR";
        desc = "VSD1CCADDR is a VSD current frame chrominance address register. In package pixel format, the address is invalid; in semi-planar pixel format, the address is the address of the luminance frame buffer. VSD1CCADDR (offset 0x4014, total reset 0x0000_0000; PROVEN: Hi3518E V100 data sheet, PDF page 699, section 10.2.5).";
        field {
            name = "surface_ccaddr";
            desc = "Chrominance address of the current frame.";
            sw = rw; hw = r;
            reset = 0x0;
        } surface_ccaddr[31:0];
    } VSD1CCADDR @ 0x4014;
    reg {
        name = "VSD1STRIDE";
        desc = "VSD1STRIDE is a VSD surface stride register. VSD1STRIDE (offset 0x4024, total reset 0x0000_0000; PROVEN: Hi3518E V100 data sheet, PDF page 699, section 10.2.5).";
        field {
            name = "surface_cstride";
            desc = "Stride of the chrominance frame buffer (valid in semi-planar format), 128-bit alignment.";
            sw = rw; hw = r;
            reset = 0x0;
        } surface_cstride[31:16];
        field {
            name = "surface_stride";
            desc = "Stride of the frame buffer (valid in semi-planar format, luminance stride), 128-bit alignment.";
            sw = rw; hw = r;
            reset = 0x0;
        } surface_stride[15:0];
    } VSD1STRIDE @ 0x4024;
    reg {
        name = "VSD1IRESO";
        desc = "VSD1IRESO is a VSD input resolution register (non-instant register). VSD1IRESO (offset 0x4028, total reset 0x0000_0000; PROVEN: Hi3518E V100 data sheet, PDF page 700, section 10.2.5).";
        field {
            name = "reserved";
            desc = "Reserved.";
            sw = r; hw = na;
            reset = 0x0;
        } reserved_31_24[31:24];
        field {
            name = "ih";
            desc = "Height (in line). The value is the actual height minus 1. The frame height is referenced.";
            sw = rw; hw = r;
            reset = 0x0;
        } ih[23:12];
        field {
            name = "iw";
            desc = "Width (in pixel). The value is the actual width minus 1.";
            sw = rw; hw = r;
            reset = 0x0;
        } iw[11:0];
    } VSD1IRESO @ 0x4028;
    reg {
        name = "VSD1CBMPARA";
        desc = "VSD1CBMPARA is a VSD overlay parameter register (non-instant register). VSD1CBMPARA (offset 0x4034, total reset 0x0000_0000; PROVEN: Hi3518E V100 data sheet, PDF page 700, section 10.2.5).";
        field {
            name = "reserved";
            desc = "Reserved.";
            sw = rw; hw = r;
            reset = 0x0;
        } reserved_31_8[31:8];
        field {
            name = "galpha";
            desc = "Overlay global alpha value. The value ranges from 0 to 128. The value 128 indicates opaque, and the value 0 indicates full transparent.";
            sw = rw; hw = r;
            reset = 0x0;
        } galpha[7:0];
    } VSD1CBMPARA @ 0x4034;
    reg {
        name = "VSD1DFPOS";
        desc = "VSD1DFPOS is a VSD surface start position (in the display window) register (non-instant register). VSD1DFPOS (offset 0x4060, total reset 0x0000_0000; PROVEN: Hi3518E V100 data sheet, PDF page 701, section 10.2.5).";
        field {
            name = "reserved";
            desc = "Reserved.";
            sw = r; hw = na;
            reset = 0x0;
        } reserved_31_24[31:24];
        field {
            name = "disp_yfpos";
            desc = "Start coordinate of the display column. The frame height is referenced and the unit is line.";
            sw = rw; hw = r;
            reset = 0x0;
        } disp_yfpos[23:12];
        field {
            name = "disp_xfpos";
            desc = "Start coordinate of the display row.";
            sw = rw; hw = r;
            reset = 0x0;
        } disp_xfpos[11:0];
    } VSD1DFPOS @ 0x4060;
    reg {
        name = "VSD1DLPOS";
        desc = "VSD1DLPOS is a VSD surface end position (in the display window) register (non-instant register). The end position is in the unit of pixel. VSD1DLPOS (offset 0x4064, total reset 0x0000_0000; PROVEN: Hi3518E V100 data sheet, PDF page 701, section 10.2.5).";
        field {
            name = "reserved";
            desc = "Reserved.";
            sw = r; hw = na;
            reset = 0x0;
        } reserved_31_24[31:24];
        field {
            name = "disp_ylpos";
            desc = "End coordinate of the display column. The frame height is referenced and the unit is line.";
            sw = rw; hw = r;
            reset = 0x0;
        } disp_ylpos[23:12];
        field {
            name = "disp_xlpos";
            desc = "End coordinate of the display row.";
            sw = rw; hw = r;
            reset = 0x0;
        } disp_xlpos[11:0];
    } VSD1DLPOS @ 0x4064;
    reg {
        name = "VSD1BK";
        desc = "VSD1BK is a video layer background color register. VSD1BK (offset 0x4070, total reset 0x0000_0000; PROVEN: Hi3518E V100 data sheet, PDF page 703, section 10.2.5).";
        field {
            name = "vbk_alpha";
            desc = "Levels 0–128 of the background filling color of the video layer.";
            sw = rw; hw = r;
            reset = 0x0;
        } vbk_alpha[31:24];
        field {
            name = "vbk_y";
            desc = "Y component.";
            sw = rw; hw = r;
            reset = 0x0;
        } vbk_y[23:16];
        field {
            name = "vbk_cb";
            desc = "Cb component.";
            sw = rw; hw = r;
            reset = 0x0;
        } vbk_cb[15:8];
        field {
            name = "vbk_cr";
            desc = "Cr component.";
            sw = rw; hw = r;
            reset = 0x0;
        } vbk_cr[7:0];
    } VSD1BK @ 0x4070;
    reg {
        name = "VSD1CSCIDC";
        desc = "VSD1CSCIDC is a VSD input DC component register for CSC (instant register). VSD1CSCIDC (offset 0x4080, total reset 0x0000_0000; PROVEN: Hi3518E V100 data sheet, PDF page 703, section 10.2.5).";
        field {
            name = "reserved";
            desc = "Reserved.";
            sw = r; hw = na;
            reset = 0x0;
        } reserved_31_28[31:28];
        field {
            name = "csc_en";
            desc = "CSC enable.
- 0: disabled
- 1: enabled";
            sw = rw; hw = r;
            reset = 0x0;
        } csc_en[27:27];
        field {
            name = "cscidc2";
            desc = "DC parameter of input component 2. The MSB is the signed bit. The value is expressed as the complementary code.";
            sw = rw; hw = r;
            reset = 0x0;
        } cscidc2[26:18];
        field {
            name = "cscidc1";
            desc = "DC parameter of input component 1. The MSB is the signed bit. The value is expressed as the complementary code.";
            sw = rw; hw = r;
            reset = 0x0;
        } cscidc1[17:9];
        field {
            name = "cscidc0";
            desc = "DC parameter of input component 0. The MSB is the signed bit. The value is expressed as the complementary code.";
            sw = rw; hw = r;
            reset = 0x0;
        } cscidc0[8:0];
    } VSD1CSCIDC @ 0x4080;
    reg {
        name = "VSD1CSCODC";
        desc = "VSD1CSCODC is a VSD output DC component register for CSC (instant register). VSD1CSCODC (offset 0x4084, total reset 0x0000_0000; PROVEN: Hi3518E V100 data sheet, PDF page 704, section 10.2.5).";
        field {
            name = "reserved";
            desc = "Reserved.";
            sw = r; hw = na;
            reset = 0x0;
        } reserved_31_27[31:27];
        field {
            name = "cscodc2";
            desc = "DC parameter of output component 2. The MSB is the signed bit. The value is expressed as the complementary code.";
            sw = rw; hw = r;
            reset = 0x0;
        } cscodc2[26:18];
        field {
            name = "cscodc1";
            desc = "DC parameter of output component 1. The MSB is the signed bit. The value is expressed as the complementary code.";
            sw = rw; hw = r;
            reset = 0x0;
        } cscodc1[17:9];
        field {
            name = "cscodc0";
            desc = "DC parameter of output component 0. The MSB is the signed bit. The value is expressed as the complementary code.";
            sw = rw; hw = r;
            reset = 0x0;
        } cscodc0[8:0];
    } VSD1CSCODC @ 0x4084;
    reg {
        name = "VSD1CSCP0";
        desc = "VSD1CSCP0 is VSD CSC parameter 0 register (instant register). VSD1CSCP0 (offset 0x4088, total reset 0x0000_0000; PROVEN: Hi3518E V100 data sheet, PDF page 704, section 10.2.5).";
        field {
            name = "reserved";
            desc = "Reserved.";
            sw = r; hw = na;
            reset = 0x0;
        } reserved_31_29[31:29];
        field {
            name = "cscp01";
            desc = "5.8 data format. The value consists of a 1-bit signed bit, a 4-bit integral part, and an 8-bit fractional part. The value is expressed as the complementary code.";
            sw = rw; hw = r;
            reset = 0x0;
        } cscp01[28:16];
        field {
            name = "reserved";
            desc = "Reserved.";
            sw = r; hw = na;
            reset = 0x0;
        } reserved_15_13[15:13];
        field {
            name = "cscp00";
            desc = "5.8 data format. The value consists of a 1-bit signed bit, a 4-bit integral part, and an 8-bit fractional part. The value is expressed as the complementary code.";
            sw = rw; hw = r;
            reset = 0x0;
        } cscp00[12:0];
    } VSD1CSCP0 @ 0x4088;
    reg {
        name = "VSD1CSCP1";
        desc = "VSD1CSCP1 is VSD CSC parameter 1 register (instant register). VSD1CSCP1 (offset 0x408C, total reset 0x0000_0000; PROVEN: Hi3518E V100 data sheet, PDF page 705, section 5.8).";
        field {
            name = "reserved";
            desc = "Reserved.";
            sw = r; hw = na;
            reset = 0x0;
        } reserved_31_29[31:29];
        field {
            name = "cscp10";
            desc = "5.8 data format. The value consists of a 1-bit signed bit, a 4-bit integral part, and an 8-bit fractional part. The value is expressed as the complementary code.";
            sw = rw; hw = r;
            reset = 0x0;
        } cscp10[28:16];
        field {
            name = "reserved";
            desc = "Reserved.";
            sw = r; hw = na;
            reset = 0x0;
        } reserved_15_13[15:13];
        field {
            name = "cscp02";
            desc = "5.8 data format. The value consists of a 1-bit signed bit, a 4-bit integral part, and an 8-bit fractional part. The value is expressed as the complementary code.";
            sw = rw; hw = r;
            reset = 0x0;
        } cscp02[12:0];
    } VSD1CSCP1 @ 0x408c;
    reg {
        name = "VSD1CSCP2";
        desc = "VSD1CSCP2 is VSD CSC parameter 2 register (instant register). VSD1CSCP2 (offset 0x4090, total reset 0x0000_0000; PROVEN: Hi3518E V100 data sheet, PDF page 705, section 5.8).";
        field {
            name = "reserved";
            desc = "Reserved.";
            sw = r; hw = na;
            reset = 0x0;
        } reserved_31_29[31:29];
        field {
            name = "cscp12";
            desc = "5.8 data format. The value consists of a 1-bit signed bit, a 4-bit integral part, and an 8-bit fractional part. The value is expressed as the complementary code.";
            sw = rw; hw = r;
            reset = 0x0;
        } cscp12[28:16];
        field {
            name = "reserved";
            desc = "Reserved.";
            sw = r; hw = na;
            reset = 0x0;
        } reserved_15_13[15:13];
        field {
            name = "cscp11";
            desc = "5.8 data format. The value consists of a 1-bit signed bit, a 4-bit integral part, and an 8-bit fractional part. The value is expressed as the complementary code.";
            sw = rw; hw = r;
            reset = 0x0;
        } cscp11[12:0];
    } VSD1CSCP2 @ 0x4090;
    reg {
        name = "VSD1CSCP3";
        desc = "VSD1CSCP3 is VSD CSC parameter 3 register (instant register). VSD1CSCP3 (offset 0x4094, total reset 0x0000_0000; PROVEN: Hi3518E V100 data sheet, PDF page 706, section 5.8).";
        field {
            name = "reserved";
            desc = "Reserved.";
            sw = r; hw = na;
            reset = 0x0;
        } reserved_31_29[31:29];
        field {
            name = "cscp21";
            desc = "5.8 data format. The value consists of a 1-bit signed bit, a 4-bit integral part, and an 8-bit fractional part. The value is expressed as the complementary code.";
            sw = rw; hw = r;
            reset = 0x0;
        } cscp21[28:16];
        field {
            name = "reserved";
            desc = "Reserved.";
            sw = r; hw = na;
            reset = 0x0;
        } reserved_15_13[15:13];
        field {
            name = "cscp20";
            desc = "5.8 data format. The value consists of a 1-bit signed bit, a 4-bit integral part, and an 8-bit fractional part. The value is expressed as the complementary code.";
            sw = rw; hw = r;
            reset = 0x0;
        } cscp20[12:0];
    } VSD1CSCP3 @ 0x4094;
    reg {
        name = "VSD1CSCP4";
        desc = "VSD1CSCP4 is VSD CSC parameter 4 register (instant register). VSD1CSCP4 (offset 0x4098, total reset 0x0000_0000; PROVEN: Hi3518E V100 data sheet, PDF page 706, section 5.8).";
        field {
            name = "reserved";
            desc = "Reserved.";
            sw = r; hw = na;
            reset = 0x0;
        } reserved_31_13[31:13];
        field {
            name = "cscp22";
            desc = "5.8 data format. The value consists of a 1-bit signed bit, a 4-bit integral part, and an 8-bit fractional part. The value is expressed as the complementary code.";
            sw = rw; hw = r;
            reset = 0x0;
        } cscp22[12:0];
    } VSD1CSCP4 @ 0x4098;
    reg {
        name = "VSD1IFIRCOEF01";
        desc = "VSD1IFIRCOEF01 is a VSD IFIR filtering coefficients 0–1 register. VSD1IFIRCOEF01 (offset 0x4180, total reset 0x000D_0000; PROVEN: Hi3518E V100 data sheet, PDF page 707, section 5.8).";
        field {
            name = "reserved";
            desc = "Reserved.";
            sw = r; hw = na;
            reset = 0x0;
        } reserved_31_26[31:26];
        field {
            name = "coef1";
            desc = "IFIR filtering coefficient 1.";
            sw = rw; hw = r;
            reset = 0xd;
        } coef1[25:16];
        field {
            name = "reserved";
            desc = "Reserved.";
            sw = r; hw = na;
            reset = 0x0;
        } reserved_15_10[15:10];
        field {
            name = "coef0";
            desc = "IFIR filtering coefficient 0.";
            sw = rw; hw = r;
            reset = 0x0;
        } coef0[9:0];
    } VSD1IFIRCOEF01 @ 0x4180;
    reg {
        name = "VSD1IFIRCOEF23";
        desc = "VSD1IFIRCOEF23 is a VSD IFIR filtering coefficients 2–3 register. VSD1IFIRCOEF23 (offset 0x4184, total reset 0x0132_03C1; PROVEN: Hi3518E V100 data sheet, PDF page 707, section 5.8).";
        field {
            name = "reserved";
            desc = "Reserved.";
            sw = r; hw = na;
            reset = 0x0;
        } reserved_31_26[31:26];
        field {
            name = "coef3";
            desc = "IFIR filtering coefficient 3.";
            sw = rw; hw = r;
            reset = 0x132;
        } coef3[25:16];
        field {
            name = "reserved";
            desc = "Reserved.";
            sw = r; hw = na;
            reset = 0x0;
        } reserved_15_10[15:10];
        field {
            name = "coef2";
            desc = "IFIR filtering coefficients 2.";
            sw = rw; hw = r;
            reset = 0x3c1;
        } coef2[9:0];
    } VSD1IFIRCOEF23 @ 0x4184;
    reg {
        name = "VSD1IFIRCOEF45";
        desc = "VSD1IFIRCOEF45 is a VSD IFIR filtering coefficients 4–5 register. VSD1IFIRCOEF45 (offset 0x4188, total reset 0x003C_0132; PROVEN: Hi3518E V100 data sheet, PDF page 708, section 5.8).";
        field {
            name = "reserved";
            desc = "Reserved.";
            sw = r; hw = na;
            reset = 0x0;
        } reserved_31_26[31:26];
        field {
            name = "coef5";
            desc = "IFIR filtering coefficient 5.";
            sw = rw; hw = r;
            reset = 0x3c;
        } coef5[25:16];
        field {
            name = "reserved";
            desc = "Reserved.";
            sw = r; hw = na;
            reset = 0x0;
        } reserved_15_10[15:10];
        field {
            name = "coef4";
            desc = "IFIR filtering coefficient 4.";
            sw = rw; hw = r;
            reset = 0x132;
        } coef4[9:0];
    } VSD1IFIRCOEF45 @ 0x4188;
    reg {
        name = "VSD1IFIRCOEF67";
        desc = "VSD1IFIRCOEF67 is a VSD IFIR filtering coefficients 6–7 register. VSD1IFIRCOEF67 (offset 0x418C, total reset 0x0000_000D; PROVEN: Hi3518E V100 data sheet, PDF page 708, section 5.8).";
        field {
            name = "reserved";
            desc = "Reserved.";
            sw = r; hw = na;
            reset = 0x0;
        } reserved_31_26[31:26];
        field {
            name = "coef7";
            desc = "IFIR filtering coefficient 7.";
            sw = rw; hw = r;
            reset = 0x0;
        } coef7[25:16];
        field {
            name = "reserved";
            desc = "Reserved.";
            sw = r; hw = na;
            reset = 0x0;
        } reserved_15_10[15:10];
        field {
            name = "coef6";
            desc = "IFIR filtering coefficient 6.";
            sw = rw; hw = r;
            reset = 0xd;
        } coef6[9:0];
    } VSD1IFIRCOEF67 @ 0x418c;
    reg {
        name = "VSD1P0RESO";
        desc = "VSD1P0RESO is a VSD1 region 0 resolution register (non-instant register). VSD1P0RESO (offset 0x4400 (m = 0-63), total reset 0x0000_0000; PROVEN: Hi3518E V100 data sheet, PDF page 709, section 5.8). Data sheet defect: the offset cell reads 0x4400 (m = 0-63) but no stride is given and the register table lists only region 0 (VSD1P0*); modelled as the single register at 0x4400.";
        field {
            name = "reserved";
            desc = "Reserved.";
            sw = rw; hw = r;
            reset = 0x0;
        } reserved_31_24[31:24];
        field {
            name = "h";
            desc = "Height (in line). The frame height is referenced. The value is the actual height minus 1. Note: The actual height must be an even number.";
            sw = rw; hw = r;
            reset = 0x0;
        } h[23:12];
        field {
            name = "w";
            desc = "Width (in pixel). The value is the actual width minus 1. Note: The actual width must be an even number.";
            sw = rw; hw = r;
            reset = 0x0;
        } w_[11:0];
    } VSD1P0RESO @ 0x4400;
    reg {
        name = "VSD1P0LADDR";
        desc = "VSD1P0LADDR is a VSD1 region 0 address register. VSD1P0LADDR (offset 0x4404, total reset 0x0000_0000; PROVEN: Hi3518E V100 data sheet, PDF page 709, section 5.8).";
        field {
            name = "surface_addr";
            desc = "Start address of VSD1 region 0.";
            sw = rw; hw = r;
            reset = 0x0;
        } surface_addr[31:0];
    } VSD1P0LADDR @ 0x4404;
    reg {
        name = "VSD1P0CADDR";
        desc = "VSD1P0CADDR is a VSD1 region 0 chrominance address register. VSD1P0CADDR (offset 0x4408, total reset 0x0000_0000; PROVEN: Hi3518E V100 data sheet, PDF page 710, section 5.8).";
        field {
            name = "surface_addr";
            desc = "Chrominance start address of VSD1 region 0.";
            sw = rw; hw = r;
            reset = 0x0;
        } surface_addr[31:0];
    } VSD1P0CADDR @ 0x4408;
    reg {
        name = "VSD1P0STRIDE";
        desc = "VSD1P0STRIDE is a VSD1 region 0 stride register. VSD1P0STRIDE (offset 0x440C, total reset 0x0000_0000; PROVEN: Hi3518E V100 data sheet, PDF page 710, section 5.8).";
        field {
            name = "surface_cstride";
            desc = "Stride of the chrominance buffer of VSD1 region 0 (valid in semi- planar format), 128-bit alignment.";
            sw = rw; hw = r;
            reset = 0x0;
        } surface_cstride[31:16];
        field {
            name = "surface_stride";
            desc = "Stride of the buffer of VSD1 region 0 (valid in semi-planar format, luminance stride), 128-bit alignment.";
            sw = rw; hw = r;
            reset = 0x0;
        } surface_stride[15:0];
    } VSD1P0STRIDE @ 0x440c;
    reg {
        name = "VSD1P0VFPOS";
        desc = "VSD1P0VFPOS is a VSD1 region 0 video start position register. The start position is in the unit of pixel. VSD1P0VFPOS (offset 0x4410, total reset 0x0000_0000; PROVEN: Hi3518E V100 data sheet, PDF page 710, section 5.8).";
        field {
            name = "reserved";
            desc = "Reserved.";
            sw = rw; hw = r;
            reset = 0x0;
        } reserved_31_24[31:24];
        field {
            name = "video_yfpos";
            desc = "Start coordinate of the video column. The frame height is referenced and the unit is line.";
            sw = rw; hw = r;
            reset = 0x0;
        } video_yfpos[23:12];
        field {
            name = "video_xfpos";
            desc = "Start coordinate of the video row.";
            sw = rw; hw = r;
            reset = 0x0;
        } video_xfpos[11:0];
    } VSD1P0VFPOS @ 0x4410;
    reg {
        name = "VSD1P0VLPOS";
        desc = "VSD1P0VLPOS is a VSD1 region 0 video end position register (non-instant register). The end position is in the unit of pixel. VSD1P0VLPOS (offset 0x4414, total reset 0x0000_0000; PROVEN: Hi3518E V100 data sheet, PDF page 711, section 5.8).";
        field {
            name = "reserved";
            desc = "Reserved.";
            sw = rw; hw = r;
            reset = 0x0;
        } reserved_31_24[31:24];
        field {
            name = "video_ylpos";
            desc = "Start coordinate of the video column. The frame height is referenced and the unit is line.";
            sw = rw; hw = r;
            reset = 0x0;
        } video_ylpos[23:12];
        field {
            name = "video_xlpos";
            desc = "Start coordinate of the video row.";
            sw = rw; hw = r;
            reset = 0x0;
        } video_xlpos[11:0];
    } VSD1P0VLPOS @ 0x4414;
    reg {
        name = "VSD116REGIONEN";
        desc = "VSD116REGIONEN is a VSD1 region 0 enable register (non-instant register). VSD116REGIONEN (offset 0x4C04, total reset 0x0000_0000; PROVEN: Hi3518E V100 data sheet, PDF page 711, section 5.8).";
        field {
            name = "reserved";
            desc = "Reserved.";
            sw = rw; hw = r;
            reset = 0x0;
        } reserved_31_1[31:1];
        field {
            name = "p0_en";
            desc = "VSD1 region 0 enable.
- 0: disabled
- 1: enabled";
            sw = rw; hw = r;
            reset = 0x0;
        } p0_en[0:0];
    } VSD116REGIONEN @ 0x4c04;
    reg {
        name = "G3CTRL";
        desc = "G3CTRL is the G3 control register (non-instant register). It is used to configure the layer information G3CTRL (offset 0x9600, total reset 0x0000_0000; PROVEN: Hi3518E V100 data sheet, PDF page 712, section 5.8).";
        field {
            name = "surface_en";
            desc = "Surface enable (non-instant register).
- 0: disabled
- 1: enabled";
            sw = rw; hw = r;
            reset = 0x0;
        } surface_en[31:31];
        field {
            name = "reserved";
            desc = "Reserved.";
            sw = r; hw = na;
            reset = 0x0;
        } reserved_30_28[30:28];
        field {
            name = "upd_mode";
            desc = "Update mode.
- 0: update by frame
- 1: update by field";
            sw = rw; hw = r;
            reset = 0x0;
        } upd_mode[27:27];
        field {
            name = "read_mode";
            desc = "Data read mode.
- 0: The read mode is automatically selected based on the interface read mode. That is, the progressive read mode is selected in progressive display mode, and the interlaced read mode is selected in interlaced display mode.
- 1: The progressive read mode is selected forcibly.";
            sw = rw; hw = r;
            reset = 0x0;
        } read_mode[26:26];
        field {
            name = "reserved";
            desc = "Reserved.";
            sw = rw; hw = r;
            reset = 0x0;
        } reserved_25_10[25:10];
        field {
            name = "bitext";
            desc = "Bit extend mode of the input bitmap. 0X: lower bits stuffed with 0s
- 10: lower bits stuffed with the MSB
- 11: lower bits stuffed with upper bits";
            sw = rw; hw = r;
            reset = 0x0;
        } bitext[9:8];
        field {
            name = "ifmt";
            desc = "Input data format.
- 0x49: ARGB1555
- 0x68: ARGB8888

Other values: reserved";
            sw = rw; hw = r;
            reset = 0x0;
        } ifmt[7:0];
    } G3CTRL @ 0x9600;
    reg {
        name = "G3UPD";
        desc = "G3UPD is the G3 channel update enable register. G3UPD (offset 0x9604, total reset 0x0000_0000; PROVEN: Hi3518E V100 data sheet, PDF page 713, section 5.8).";
        field {
            name = "reserved";
            desc = "Reserved.";
            sw = r; hw = na;
            reset = 0x0;
        } reserved_31_1[31:1];
        field {
            name = "regup";
            desc = "Surface register update. After the registers at this layer are configured, the registers are updated when the value 1 is written to this bit. After updates, this bit is cleared automatically by the hardware";
            sw = rw; hw = r;
            reset = 0x0;
        } regup[0:0];
    } G3UPD @ 0x9604;
    reg {
        name = "G3ADDR";
        desc = "G3ADDR is the G3 address register. When the horizontal pixel offsets, the address is calculated according to the description of G3SFPOS. G3ADDR (offset 0x9608, total reset 0x0000_0000; PROVEN: Hi3518E V100 data sheet, PDF page 713, section 5.8).";
        field {
            name = "surface_addr";
            desc = "Address of the surface frame buffer.";
            sw = rw; hw = r;
            reset = 0x0;
        } surface_addr[31:0];
    } G3ADDR @ 0x9608;
    reg {
        name = "G3STRIDE";
        desc = "G3STRIDE is the G3 stride register. G3STRIDE (offset 0x960C, total reset 0x0000_0000; PROVEN: Hi3518E V100 data sheet, PDF page 714, section 5.8).";
        field {
            name = "reserved";
            desc = "Reserved.";
            sw = r; hw = na;
            reset = 0x0;
        } reserved_31_16[31:16];
        field {
            name = "surface_stride";
            desc = "Stride of the frame buffer.";
            sw = rw; hw = r;
            reset = 0x0;
        } surface_stride[15:0];
    } G3STRIDE @ 0x960c;
    reg {
        name = "G3CBMPARA";
        desc = "G3CBMPARA is the G3 overlay parameter register (non-instant register). G3CBMPARA (offset 0x9610, total reset 0x0000_0000; PROVEN: Hi3518E V100 data sheet, PDF page 714, section 5.8).";
        field {
            name = "reserved";
            desc = "Reserved.";
            sw = r; hw = na;
            reset = 0x0;
        } reserved_31_16[31:16];
        field {
            name = "key_mode";
            desc = "Colorkey mode.
- 0: The color is regarded as the colorkey when the following condition is met: Keymin ≤ Pixel ≤ Keymax
- 1: The color is regarded as the colorkey when either of the following conditions is met: Pixel ≤ Keymin or Pixel ≥ Keymax";
            sw = rw; hw = r;
            reset = 0x0;
        } key_mode[15:15];
        field {
            name = "key_en";
            desc = "Colorkey enable.
- 0: disabled
- 1: enabled";
            sw = rw; hw = r;
            reset = 0x0;
        } key_en[14:14];
        field {
            name = "reserved";
            desc = "Reserved.";
            sw = r; hw = na;
            reset = 0x0;
        } reserved_13_13[13:13];
        field {
            name = "palpha_en";
            desc = "Pixel alpha enable.
- 0: disabled
- 1: enabled";
            sw = rw; hw = r;
            reset = 0x0;
        } palpha_en[12:12];
        field {
            name = "reserved";
            desc = "Reserved.";
            sw = rw; hw = r;
            reset = 0x0;
        } reserved_11_9[11:9];
        field {
            name = "palpha_range";
            desc = "Pixel alpha range.
- 0: 0–128
- 1: 0–255";
            sw = rw; hw = r;
            reset = 0x0;
        } palpha_range[8:8];
        field {
            name = "galpha";
            desc = "Overlay global alpha value. This value ranges from 0 to 255. The value 255 indicates opaque, and the value 0 indicates full transparent.";
            sw = rw; hw = r;
            reset = 0x0;
        } galpha[7:0];
    } G3CBMPARA @ 0x9610;
    reg {
        name = "G3CKEYMAX";
        desc = "G3CKEYMAX is the G3 maximum colorkey register (non-instant register). G3CKEYMAX (offset 0x9614, total reset 0x0000_0000; PROVEN: Hi3518E V100 data sheet, PDF page 715, section 5.8).";
        field {
            name = "va0";
            desc = "Alpha0 value. When the data format is alphaRGB1555 and the alpha value is 0, the alpha0 value is used.";
            sw = rw; hw = r;
            reset = 0x0;
        } va0[31:24];
        field {
            name = "keyr_max";
            desc = "Maximum value of colorkey R component.";
            sw = rw; hw = r;
            reset = 0x0;
        } keyr_max[23:16];
        field {
            name = "keyg_max";
            desc = "Maximum value of colorkey G component.";
            sw = rw; hw = r;
            reset = 0x0;
        } keyg_max[15:8];
        field {
            name = "keyb_max";
            desc = "Maximum value of colorkey B component.";
            sw = rw; hw = r;
            reset = 0x0;
        } keyb_max[7:0];
    } G3CKEYMAX @ 0x9614;
    reg {
        name = "G3CKEYMIN";
        desc = "G3CKEYMIN is the G3 minimum colorkey register (non-instant register). G3CKEYMIN (offset 0x9618, total reset 0x0000_0000; PROVEN: Hi3518E V100 data sheet, PDF page 715, section 5.8).";
        field {
            name = "va1";
            desc = "Alpha1 value. When the data format is alphaRGB1555 and the alpha value is 1, the alpha1 value is used.";
            sw = rw; hw = r;
            reset = 0x0;
        } va1[31:24];
        field {
            name = "keyr_min";
            desc = "Minimum value of colorkey R component.";
            sw = rw; hw = r;
            reset = 0x0;
        } keyr_min[23:16];
        field {
            name = "keyg_min";
            desc = "Minimum value of colorkey G component.";
            sw = rw; hw = r;
            reset = 0x0;
        } keyg_min[15:8];
        field {
            name = "keyb_min";
            desc = "Minimum value of colorkey B component.";
            sw = rw; hw = r;
            reset = 0x0;
        } keyb_min[7:0];
    } G3CKEYMIN @ 0x9618;
    reg {
        name = "G3CMASK";
        desc = "G3CMASK is the G3 colorkey mask register (non-instant register). When the corresponding bit is 0, the colorkey is compared. In this case, this bit can be ignored. G3CMASK (offset 0x961C, total reset 0x0000_0000; PROVEN: Hi3518E V100 data sheet, PDF page 716, section 5.8).";
        field {
            name = "reserved";
            desc = "Reserved.";
            sw = r; hw = w;
            reset = 0x0;
        } reserved_31_24[31:24];
        field {
            name = "kmsk_r";
            desc = "R component of colorkey mask.";
            sw = rw; hw = r;
            reset = 0x0;
        } kmsk_r[23:16];
        field {
            name = "kmsk_g";
            desc = "G component of colorkey mask.";
            sw = rw; hw = r;
            reset = 0x0;
        } kmsk_g[15:8];
        field {
            name = "kmsk_b";
            desc = "B component of colorkey mask.";
            sw = rw; hw = r;
            reset = 0x0;
        } kmsk_b[7:0];
    } G3CMASK @ 0x961c;
    reg {
        name = "G3IRESO";
        desc = "G3IRESO is the G3 input resolution register (non-instant register). G3IRESO (offset 0x9620, total reset 0x0000_0000; PROVEN: Hi3518E V100 data sheet, PDF page 716, section 5.8).";
        field {
            name = "reserved";
            desc = "Reserved.";
            sw = r; hw = na;
            reset = 0x0;
        } reserved_31_24[31:24];
        field {
            name = "ih";
            desc = "Height (in line). The value is the actual height minus 1. Note: In interlaced output mode, the actual layer height must be an even number. There is no such limitation in progressive output mode.";
            sw = rw; hw = r;
            reset = 0x0;
        } ih[23:12];
        field {
            name = "iw";
            desc = "Width (in pixel). The value is the actual width minus 1. Note: The actual layer width must be an even number.";
            sw = rw; hw = r;
            reset = 0x0;
        } iw[11:0];
    } G3IRESO @ 0x9620;
    reg {
        name = "G3ORESO";
        desc = "G3ORESO is the G3 output resolution register (non-instant register). G3ORESO (offset 0x9624, total reset 0x0000_0000; PROVEN: Hi3518E V100 data sheet, PDF page 717, section 5.8).";
        field {
            name = "reserved";
            desc = "Reserved.";
            sw = r; hw = na;
            reset = 0x0;
        } reserved_31_24[31:24];
        field {
            name = "oh";
            desc = "Height (in line). The value is the actual height minus 1. Note: In interlaced output mode, the actual layer height must be an even number. There is no such limitation in progressive output mode.";
            sw = rw; hw = r;
            reset = 0x0;
        } oh[23:12];
        field {
            name = "ow";
            desc = "Width (in pixel). The value is the actual width minus 1. Note: The actual layer width must be an even number.";
            sw = rw; hw = r;
            reset = 0x0;
        } ow[11:0];
    } G3ORESO @ 0x9624;
    reg {
        name = "G3DFPOS";
        desc = "G3DFPOS is the G3 surface start position (in the display window) register (non-instant register). The start position is in the unit of pixel. G3DFPOS (offset 0x962C, total reset 0x0000_0000; PROVEN: Hi3518E V100 data sheet, PDF page 717, section 5.8).";
        field {
            name = "reserved";
            desc = "Reserved.";
            sw = r; hw = na;
            reset = 0x0;
        } reserved_31_24[31:24];
        field {
            name = "disp_yfpos";
            desc = "Column start coordinate.";
            sw = rw; hw = r;
            reset = 0x0;
        } disp_yfpos[23:12];
        field {
            name = "disp_xfpos";
            desc = "Row start coordinate.";
            sw = rw; hw = r;
            reset = 0x0;
        } disp_xfpos[11:0];
    } G3DFPOS @ 0x962c;
    reg {
        name = "G3DLPOS";
        desc = "G3DLPOS is the G3 surface end position (in the display window) register (non-instant register). The end position is in the unit of pixel. G3DLPOS (offset 0x9630, total reset 0x0000_0000; PROVEN: Hi3518E V100 data sheet, PDF page 718, section 5.8).";
        field {
            name = "reserved";
            desc = "Reserved.";
            sw = r; hw = na;
            reset = 0x0;
        } reserved_31_24[31:24];
        field {
            name = "disp_ylpos";
            desc = "Column end coordinate.";
            sw = rw; hw = r;
            reset = 0x0;
        } disp_ylpos[23:12];
        field {
            name = "disp_xlpos";
            desc = "Row end coordinate.";
            sw = rw; hw = r;
            reset = 0x0;
        } disp_xlpos[11:0];
    } G3DLPOS @ 0x9630;
    reg {
        name = "G3CSCIDC";
        desc = "G3CSCIDC is the G3 input DC component register for CSC (instant register). G3CSCIDC (offset 0x96A0, total reset 0x0000_0000; PROVEN: Hi3518E V100 data sheet, PDF page 718, section 5.8).";
        field {
            name = "reserved";
            desc = "Reserved.";
            sw = r; hw = na;
            reset = 0x0;
        } reserved_31_29[31:29];
        field {
            name = "csc_mode";
            desc = "CSC mode.
- 0: RGB to YUV 601
- 1: RGB to YUV 709";
            sw = rw; hw = r;
            reset = 0x0;
        } csc_mode[28:28];
        field {
            name = "csc_en";
            desc = "CSC enable.
- 0: disabled
- 1: enabled";
            sw = rw; hw = r;
            reset = 0x0;
        } csc_en[27:27];
        field {
            name = "cscidc2";
            desc = "DC parameter of input component 2. The MSB is the signed bit. The value is expressed as the complementary code.";
            sw = r; hw = w;
            reset = 0x0;
        } cscidc2[26:18];
        field {
            name = "cscidc1";
            desc = "DC parameter of input component 1. The MSB is the signed bit. The value is expressed as the complementary code.";
            sw = r; hw = w;
            reset = 0x0;
        } cscidc1[17:9];
        field {
            name = "cscidc0";
            desc = "DC parameter of input component 0. The MSB is the signed bit. The value is expressed as the complementary code.";
            sw = r; hw = w;
            reset = 0x0;
        } cscidc0[8:0];
    } G3CSCIDC @ 0x96a0;
    reg {
        name = "G3CSCODC";
        desc = "G3CSCODC is the G3 output DC component register for CSC (instant register). G3CSCODC (offset 0x96A4, total reset 0x0000_0000; PROVEN: Hi3518E V100 data sheet, PDF page 719, section 5.8).";
        field {
            name = "reserved";
            desc = "Reserved.";
            sw = r; hw = na;
            reset = 0x0;
        } reserved_31_27[31:27];
        field {
            name = "cscodc2";
            desc = "DC parameter of output component 2. The MSB is the signed bit. The value is expressed as the complementary code.";
            sw = r; hw = w;
            reset = 0x0;
        } cscodc2[26:18];
        field {
            name = "cscodc1";
            desc = "DC parameter of output component 1. The MSB is the signed bit. The value is expressed as the complementary code.";
            sw = r; hw = w;
            reset = 0x0;
        } cscodc1[17:9];
        field {
            name = "cscodc0";
            desc = "DC parameter of output component 0. The MSB is the signed bit. The value is expressed as the complementary code.";
            sw = r; hw = w;
            reset = 0x0;
        } cscodc0[8:0];
    } G3CSCODC @ 0x96a4;
    reg {
        name = "G3CSCP0";
        desc = "G3CSCP0 is the G3 CSC parameter 0 register (instant register). G3CSCP0 (offset 0x96A8, total reset 0x0000_0000; PROVEN: Hi3518E V100 data sheet, PDF page 720, section 5.8).";
        field {
            name = "reserved";
            desc = "Reserved.";
            sw = r; hw = na;
            reset = 0x0;
        } reserved_31_29[31:29];
        field {
            name = "cscp01";
            desc = "5.8 data format. The value consists of a 1-bit signed bit, a 4-bit integral part, and an 8-bit fractional part. The value is expressed as the complementary code.";
            sw = r; hw = w;
            reset = 0x0;
        } cscp01[28:16];
        field {
            name = "reserved";
            desc = "Reserved.";
            sw = r; hw = na;
            reset = 0x0;
        } reserved_15_13[15:13];
        field {
            name = "cscp00";
            desc = "5.8 data format. The value consists of a 1-bit signed bit, a 4-bit integral part, and an 8-bit fractional part. The value is expressed as the complementary code.";
            sw = r; hw = w;
            reset = 0x0;
        } cscp00[12:0];
    } G3CSCP0 @ 0x96a8;
    reg {
        name = "G3CSCP1";
        desc = "G3CSCP1 is the G3 CSC parameter 1 register (instant register). G3CSCP1 (offset 0x96AC, total reset 0x0000_0000; PROVEN: Hi3518E V100 data sheet, PDF page 720, section 5.8).";
        field {
            name = "reserved";
            desc = "Reserved.";
            sw = r; hw = na;
            reset = 0x0;
        } reserved_31_29[31:29];
        field {
            name = "cscp10";
            desc = "5.8 data format. The value consists of a 1-bit signed bit, a 4-bit integral part, and an 8-bit fractional part. The value is expressed as the complementary code.";
            sw = r; hw = w;
            reset = 0x0;
        } cscp10[28:16];
        field {
            name = "reserved";
            desc = "Reserved.";
            sw = r; hw = na;
            reset = 0x0;
        } reserved_15_13[15:13];
        field {
            name = "cscp02";
            desc = "5.8 data format. The value consists of a 1-bit signed bit, a 4-bit integral part, and an 8-bit fractional part. The value is expressed as the complementary code.";
            sw = r; hw = w;
            reset = 0x0;
        } cscp02[12:0];
    } G3CSCP1 @ 0x96ac;
    reg {
        name = "G3CSCP2";
        desc = "G3CSCP2 is the G3 CSC parameter 2 register (instant register). G3CSCP2 (offset 0x96B0, total reset 0x0000_0000; PROVEN: Hi3518E V100 data sheet, PDF page 721, section 5.8).";
        field {
            name = "reserved";
            desc = "Reserved.";
            sw = r; hw = na;
            reset = 0x0;
        } reserved_31_29[31:29];
        field {
            name = "cscp12";
            desc = "5.8 data format. The value consists of a 1-bit signed bit, a 4-bit integral part, and an 8-bit fractional part. The value is expressed as the complementary code.";
            sw = r; hw = w;
            reset = 0x0;
        } cscp12[28:16];
        field {
            name = "reserved";
            desc = "Reserved.";
            sw = r; hw = na;
            reset = 0x0;
        } reserved_15_13[15:13];
        field {
            name = "cscp11";
            desc = "5.8 data format. The value consists of a 1-bit signed bit, a 4-bit integral part, and an 8-bit fractional part. The value is expressed as the complementary code.";
            sw = r; hw = w;
            reset = 0x0;
        } cscp11[12:0];
    } G3CSCP2 @ 0x96b0;
    reg {
        name = "G3CSCP3";
        desc = "G3CSCP3 is the G3 CSC parameter 3 register (instant register). G3CSCP3 (offset 0x96B4, total reset 0x0000_0000; PROVEN: Hi3518E V100 data sheet, PDF page 721, section 5.8).";
        field {
            name = "reserved";
            desc = "Reserved.";
            sw = r; hw = na;
            reset = 0x0;
        } reserved_31_29[31:29];
        field {
            name = "cscp21";
            desc = "5.8 data format. The value consists of a 1-bit signed bit, a 4-bit integral part, and an 8-bit fractional part. The value is expressed as the complementary code.";
            sw = r; hw = w;
            reset = 0x0;
        } cscp21[28:16];
        field {
            name = "reserved";
            desc = "Reserved.";
            sw = r; hw = na;
            reset = 0x0;
        } reserved_15_13[15:13];
        field {
            name = "cscp20";
            desc = "5.8 data format. The value consists of a 1-bit signed bit, a 4-bit integral part, and an 8-bit fractional part. The value is expressed as the complementary code.";
            sw = r; hw = w;
            reset = 0x0;
        } cscp20[12:0];
    } G3CSCP3 @ 0x96b4;
    reg {
        name = "G3CSCP4";
        desc = "G3CSCP4 is the G3 CSC parameter 4 register (instant register). G3CSCP4 (offset 0x96B8, total reset 0x0000_0000; PROVEN: Hi3518E V100 data sheet, PDF page 722, section 5.8).";
        field {
            name = "reserved";
            desc = "Reserved.";
            sw = r; hw = na;
            reset = 0x0;
        } reserved_31_13[31:13];
        field {
            name = "cscp22";
            desc = "5.8 data format. The value consists of a 1-bit signed bit, a 4-bit integral part, and an 8-bit fractional part. The value is expressed as the complementary code.";
            sw = r; hw = w;
            reset = 0x0;
        } cscp22[12:0];
    } G3CSCP4 @ 0x96b8;
    reg {
        name = "CBMBKG4";
        desc = "CBMBKG4 is the SD1 overlay background color register. CBMBKG4 (offset 0x9E0C, total reset 0x0000_0000; PROVEN: Hi3518E V100 data sheet, PDF page 722, section 5.8).";
        field {
            name = "reserved";
            desc = "Reserved.";
            sw = r; hw = na;
            reset = 0x0;
        } reserved_31_24[31:24];
        field {
            name = "cbm_bkgy";
            desc = "Overlay background color of mixer 4, Y component.";
            sw = rw; hw = r;
            reset = 0x0;
        } cbm_bkgy[23:16];
        field {
            name = "cbm_bkgcb";
            desc = "Overlay background color of mixer 4, Cb component.";
            sw = rw; hw = r;
            reset = 0x0;
        } cbm_bkgcb[15:8];
        field {
            name = "cbm_bkgcr";
            desc = "Overlay background color of mixer 4, Cr component.";
            sw = rw; hw = r;
            reset = 0x0;
        } cbm_bkgcr[7:0];
    } CBMBKG4 @ 0x9e0c;
    reg {
        name = "CBMMIX4";
        desc = "CBMMIX4 is the mixer 4 priority configuration register (non-instant register). The register configuration takes effect only when the VSYNC signal is valid. CBMMIX4 (offset 0x9E20, total reset 0x0000_0000; PROVEN: Hi3518E V100 data sheet, PDF page 723, section 5.8).";
        field {
            name = "reserved";
            desc = "Reserved.";
            sw = r; hw = na;
            reset = 0x0;
        } reserved_31_8[31:8];
        field {
            name = "mixer_prio1";
            desc = "Priority 1 of the overlay layer of mixer 4.
- 0x0: no overlay layer
- 0x5: VSD1
- 0xC: G3

Other values: reserved";
            sw = rw; hw = r;
            reset = 0x0;
        } mixer_prio1[7:4];
        field {
            name = "mixer_prio0";
            desc = "Priority 0 of the overlay layer of mixer 4.
- 0x0: no overlay layer
- 0x5: VSD1
- 0xC: G3

Other values: reserved";
            sw = rw; hw = r;
            reset = 0x0;
        } mixer_prio0[3:0];
    } CBMMIX4 @ 0x9e20;
    reg {
        name = "DSD1CTRL";
        desc = "DSD1CTRL is the DSD1 global control register. You must configure this register before configuring DSDCTRL[intf_en]. Otherwise, the configuration does not take effect. DSD1CTRL (offset 0xAC00, total reset 0x0000_0000; PROVEN: Hi3518E V100 data sheet, PDF page 724, section 5.8).";
        field {
            name = "intf_en";
            desc = "Display interface enable (instant register). Data is output over the interface only when this bit is enabled.
- 0: disabled
- 1: enabled";
            sw = rw; hw = r;
            reset = 0x0;
        } intf_en[31:31];
        field {
            name = "reserved";
            desc = "Reserved.";
            sw = r; hw = na;
            reset = 0x0;
        } reserved_30_11[30:11];
        field {
            name = "idv";
            desc = "Output phase reverse enable for the data valid signal (instant field).
- 0: disabled
- 1: enabled";
            sw = rw; hw = r;
            reset = 0x0;
        } idv[10:10];
        field {
            name = "ihs";
            desc = "Output phase reverse enable for the horizontal sync pulse (instant field).
- 0: disabled
- 1: enabled";
            sw = rw; hw = r;
            reset = 0x0;
        } ihs[9:9];
        field {
            name = "ivs";
            desc = "Output phase reverse enable for the vertical sync pulse (instant field).
- 0: disabled
- 1: enabled";
            sw = rw; hw = r;
            reset = 0x0;
        } ivs[8:8];
        field {
            name = "iop";
            desc = "Progressive or interlaced display (instant field).
- 0: interlaced display
- 1: progressive display";
            sw = rw; hw = r;
            reset = 0x0;
        } iop[7:7];
        field {
            name = "synm";
            desc = "Sync mode (instant field).
- 0: timing label mode (such as BT.656)
- 1: sync signal mode (such as LCD display)";
            sw = rw; hw = r;
            reset = 0x0;
        } synm[6:6];
        field {
            name = "intfb";
            desc = "Bit width mode of the output interface (instant field).
- 00: single-component mode (each clock outputs one component)

Other values: reserved";
            sw = rw; hw = r;
            reset = 0x0;
        } intfb[5:4];
        field {
            name = "intfdm";
            desc = "Interface data format (instant field).
- 0x0: YCbCr422

Other values: reserved";
            sw = rw; hw = r;
            reset = 0x0;
        } intfdm[3:0];
    } DSD1CTRL @ 0xac00;
    reg {
        name = "DSD1VSYNC";
        desc = "DSD1VSYNC is the DSD1 vertical timing register. In interlaced output mode, this register indicates the top vertical sync timing; in progressive output mode, this register indicates the frame vertical sync timing. The setting of this register takes effect immediately after configuration. That is, the timing of the VSYNC pin is affected immediately. You must configure this register before configuring DSDCTRL[intf_en]. Otherwise, the configuration does not take effect. DSD1VSYNC (offset 0xAC04, total reset 0x0011_511F; PROVEN: Hi3518E V100 data sheet, PDF page 725, section 5.8).";
        field {
            name = "reserved";
            desc = "Reserved.";
            sw = r; hw = na;
            reset = 0x0;
        } reserved_31_28[31:28];
        field {
            name = "vfb";
            desc = "In interlaced output mode: TVFB In progressive output mode: VFB Unit: line";
            sw = rw; hw = r;
            reset = 0x1;
        } vfb[27:20];
        field {
            name = "vbb";
            desc = "In interlaced output mode: TVBB In progressive output mode: VBB + VPW Unit: line";
            sw = rw; hw = r;
            reset = 0x15;
        } vbb[19:12];
        field {
            name = "vact";
            desc = "In interlaced output mode: height of an active picture in the top field In progressive output format: height of an active picture in a frame. The register value is the actual value minus 1. Unit: line";
            sw = rw; hw = r;
            reset = 0x11f;
        } vact[11:0];
    } DSD1VSYNC @ 0xac04;
    reg {
        name = "DSD1HSYNC1";
        desc = "DSD1HSYNC1 is DSD1 horizontal timing register 1. In interlaced or progressive output mode, this register is the horizontal sync timing configuration register. The setting of this register takes effect immediately after configuration. That is, the timing of the HSYNC pin is affected immediately. You must configure this register before configuring DSDCTRL[intf_en]. Otherwise, the configuration does not take effect. DSD1HSYNC1 (offset 0xAC08, total reset 0x0107_02CF; PROVEN: Hi3518E V100 data sheet, PDF page 726, section 5.8).";
        field {
            name = "hbb";
            desc = "HBB. Unit: pixel";
            sw = rw; hw = r;
            reset = 0x107;
        } hbb[31:16];
        field {
            name = "hact";
            desc = "Number of horizontal pixels in an active region.";
            sw = rw; hw = r;
            reset = 0x2cf;
        } hact[15:0];
    } DSD1HSYNC1 @ 0xac08;
    reg {
        name = "DSD1HSYNC2";
        desc = "DSD1HSYNC2 is DSD1 horizontal timing register 2. In interlaced or progressive output mode, this register is the horizontal sync timing configuration register. The setting of this register takes effect immediately after configuration. That is, the timing of the HSYNC pin is affected immediately. You must configure this register before configuring DSDCTRL[intf_en]. Otherwise, the configuration does not take effect. DSD1HSYNC2 (offset 0xAC0C, total reset 0x0000_0017; PROVEN: Hi3518E V100 data sheet, PDF page 726, section 5.8).";
        field {
            name = "reserved";
            desc = "Reserved.";
            sw = r; hw = na;
            reset = 0x0;
        } reserved_31_16[31:16];
        field {
            name = "hfb";
            desc = "HFB. Unit: pixel";
            sw = rw; hw = r;
            reset = 0x17;
        } hfb[15:0];
    } DSD1HSYNC2 @ 0xac0c;
    reg {
        name = "DSD1VPLUS";
        desc = "DSD1VPLUS is the DSD1 bottom vertical sync timing register in interlaced output mode. You must configure this register before configuring DSDCTRL[intf_en]. Otherwise, the configuration does not take effect. DSD1VPLUS (offset 0xAC10, total reset 0x0011_611F; PROVEN: Hi3518E V100 data sheet, PDF page 727, section 5.8).";
        field {
            name = "reserved";
            desc = "Reserved.";
            sw = r; hw = na;
            reset = 0x0;
        } reserved_31_28[31:28];
        field {
            name = "bvfb";
            desc = "In interlaced output mode: BVFB Unit: line";
            sw = rw; hw = r;
            reset = 0x1;
        } bvfb[27:20];
        field {
            name = "bvbb";
            desc = "In interlaced output mode: BVBB + VPW Unit: line";
            sw = rw; hw = r;
            reset = 0x16;
        } bvbb[19:12];
        field {
            name = "bvact";
            desc = "In interlaced output mode: height of an active picture in the bottom field. The register value is the actual value minus 1. Unit: line";
            sw = rw; hw = r;
            reset = 0x11f;
        } bvact[11:0];
    } DSD1VPLUS @ 0xac10;
    reg {
        name = "DSD1PWR";
        desc = "DSD1PWR is the DSD1 sync signal pulse width register. You must configure this register before configuring DSDCTRL[intf_en]. Otherwise, the configuration does not take effect. DSD1PWR (offset 0xAC14, total reset 0x0000_0000; PROVEN: Hi3518E V100 data sheet, PDF page 728, section 5.8).";
        field {
            name = "reserved";
            desc = "Reserved.";
            sw = r; hw = na;
            reset = 0x0;
        } reserved_31_24[31:24];
        field {
            name = "vpw";
            desc = "VPW minus 1. Unit: pixel";
            sw = rw; hw = r;
            reset = 0x0;
        } vpw[23:16];
        field {
            name = "hpw";
            desc = "HPW minus 1. Unit: pixel";
            sw = rw; hw = r;
            reset = 0x0;
        } hpw[15:0];
    } DSD1PWR @ 0xac14;
    reg {
        name = "DSD1VTTHD";
        desc = "DSD1VTTHD is the DSD1 vertical timing threshold register (instant register). It can be used to set two thresholds for generating two interrupts separately. DSD1VTTHD (offset 0xAC1C, total reset 0x0000_0001; PROVEN: Hi3518E V100 data sheet, PDF page 728, section 5.8).";
        field {
            name = "reserved";
            desc = "Reserved.";
            sw = r; hw = na;
            reset = 0x0;
        } reserved_31_16[31:16];
        field {
            name = "thd1_mode";
            desc = "Threshold 1 interrupt generation mode.
- 0: frame mode. The threshold count is in the unit of frame.
- 1: field mode. The threshold count is in the unit of field in interlaced display mode.";
            sw = rw; hw = r;
            reset = 0x0;
        } thd1_mode[15:15];
        field {
            name = "reserved";
            desc = "Reserved.";
            sw = r; hw = na;
            reset = 0x0;
        } reserved_14_13[14:13];
        field {
            name = "vtmgthd1";
            desc = "Vertical timing threshold 1. When the vertical timing counter reaches this threshold, the VOINTSTA[dsdvtthd_int1] interrupt is triggered.";
            sw = rw; hw = r;
            reset = 0x1;
        } vtmgthd1[12:0];
    } DSD1VTTHD @ 0xac1c;
    reg {
        name = "DSD1CLIPL";
        desc = "DSD1CLIPL is the DSD1 clip lower threshold register (instant register). DSD1CLIPL (offset 0xAC40, total reset 0x4010_1010; PROVEN: Hi3518E V100 data sheet, PDF page 729, section 5.8).";
        field {
            name = "clipen";
            desc = "Output clip enable (instant field).
- 0: disabled
- 1: enabled";
            sw = rw; hw = r;
            reset = 0x0;
        } clipen[31:31];
        field {
            name = "dfir_en";
            desc = "Horizontal chrominance down scaling enable.
- 0: disabled
- 1: enabled";
            sw = rw; hw = r;
            reset = 0x1;
        } dfir_en[30:30];
        field {
            name = "clipcl2";
            desc = "Lower threshold Y/R of component 2, unsigned integer.";
            sw = rw; hw = r;
            reset = 0x1;
        } clipcl2[29:20];
        field {
            name = "clipcl1";
            desc = "Lower threshold Cb/G of component 1, unsigned integer.";
            sw = rw; hw = r;
            reset = 0x4;
        } clipcl1[19:10];
        field {
            name = "clipcl0";
            desc = "Lower threshold Cr/B of component 0, unsigned integer.";
            sw = rw; hw = r;
            reset = 0x10;
        } clipcl0[9:0];
    } DSD1CLIPL @ 0xac40;
    reg {
        name = "DSD1CLIPH";
        desc = "DSD1CLIPH is the DSD1 clip upper threshold register (instant register). For example, the output data needs to be clipped in BT.656 output mode. DSD1CLIPH (offset 0xAC44, total reset 0x00EB_F0F0; PROVEN: Hi3518E V100 data sheet, PDF page 730, section 5.8).";
        field {
            name = "reserved";
            desc = "Reserved.";
            sw = r; hw = na;
            reset = 0x0;
        } reserved_31_30[31:30];
        field {
            name = "clipch2";
            desc = "Upper threshold Y/R of component 2, unsigned integer.";
            sw = rw; hw = r;
            reset = 0xe;
        } clipch2[29:20];
        field {
            name = "clipch1";
            desc = "Upper threshold Cb/G of component 1, unsigned integer.";
            sw = rw; hw = r;
            reset = 0x2fc;
        } clipch1[19:10];
        field {
            name = "clipch0";
            desc = "Upper threshold Cr/B of component 0, unsigned integer.";
            sw = rw; hw = r;
            reset = 0xf0;
        } clipch0[9:0];
    } DSD1CLIPH @ 0xac44;
    reg {
        name = "DSD1STATE";
        desc = "DSD1STATE is the DSD1 status register. DSD1STATE (offset 0xACF0, total reset 0x0000_0110; PROVEN: Hi3518E V100 data sheet, PDF page 730, section 5.8).";
        field {
            name = "reserved";
            desc = "Reserved.";
            sw = r; hw = na;
            reset = 0x22;
        } reserved_31_3[31:3];
        field {
            name = "bottom_field";
            desc = "DSD1 top/bottom field flag.
- 0: top field
- 1: bottom field";
            sw = rw; hw = r;
            reset = 0x0;
        } bottom_field[2:2];
        field {
            name = "vblank";
            desc = "DSD1 blanking region flag.
- 0: active region
- 1: blanking region";
            sw = rw; hw = r;
            reset = 0x0;
        } vblank[1:1];
        field {
            name = "vback_blank";
            desc = "DSD1 back blanking region flag.
- 0: non-back blanking region
- 1: back blanking region";
            sw = rw; hw = r;
            reset = 0x0;
        } vback_blank[0:0];
    } DSD1STATE @ 0xacf0;
    reg {
        name = "VOCTRL";
        desc = "VOCTRL is a VO control register. VOCTRL (offset 0xCE00, total reset 0x0000_0000; PROVEN: Hi3518E V100 data sheet, PDF page 731, section 5.8).";
        field {
            name = "vo_ck_gt_en";
            desc = "Clock gating enable.
- 0: disabled
- 1: enabled";
            sw = r; hw = na;
            reset = 0x0;
        } vo_ck_gt_en[31:31];
        field {
            name = "vo_id_sel";
            desc = "VOU read ID select.
- 0: 0
- 1: 1";
            sw = rw; hw = r;
            reset = 0x0;
        } vo_id_sel[30:30];
        field {
            name = "reserved";
            desc = "Reserved.";
            sw = r; hw = na;
            reset = 0x0;
        } reserved_29_28[29:28];
        field {
            name = "awid_cfg";
            desc = "ID written by the AXI bus.";
            sw = rw; hw = r;
            reset = 0x0;
        } awid_cfg[27:24];
        field {
            name = "reserved";
            desc = "Reserved.";
            sw = r; hw = na;
            reset = 0x0;
        } reserved_23_22[23:22];
        field {
            name = "bus_dbg_en";
            desc = "Bus debugging enable.
- 00: normal mode
- 01: read-write loopback mode for bus test
- 10: write loopback mode for bus test

Other values: reserved";
            sw = rw; hw = r;
            reset = 0x0;
        } bus_dbg_en[21:20];
        field {
            name = "outstd_wid0";
            desc = "Outstanding of the AXI bus write channel.";
            sw = rw; hw = r;
            reset = 0x0;
        } outstd_wid0[19:16];
        field {
            name = "arid_cfg1";
            desc = "ID1 of the AXI bus read channel.";
            sw = rw; hw = r;
            reset = 0x0;
        } arid_cfg1[15:12];
        field {
            name = "outstd_rid0";
            desc = "ID0 of the AXI bus read channel.";
            sw = rw; hw = r;
            reset = 0x0;
        } outstd_rid0[11:8];
        field {
            name = "outstd_rid1";
            desc = "Outstanding of the AXI bus read channel.";
            sw = rw; hw = r;
            reset = 0x0;
        } outstd_rid1[7:4];
        field {
            name = "arb_mode";
            desc = "Arbitration mode of requesting data for each internal surface bus of the VOU.
- 0000: The polling mode is used.
- 0001: The graphics layer takes priority.

Other values: reserved";
            sw = rw; hw = r;
            reset = 0x0;
        } arb_mode[3:0];
    } VOCTRL @ 0xce00;
    reg {
        name = "VOINTSTA";
        desc = "VOINTSTA is a VO interrupt status register. It is a read-only register. VOINTSTA (offset 0xCE04, total reset 0x0000_0000; PROVEN: Hi3518E V100 data sheet, PDF page 732, section 5.8).";
        field {
            name = "be_int";
            desc = "Bus error interrupt (AXI_Master).
- 0: No interrupt is generated.
- 1: An interrupt is generated.";
            sw = r; hw = w;
            reset = 0x0;
        } be_int[31:31];
        field {
            name = "reserved";
            desc = "Reserved.";
            sw = r; hw = w;
            reset = 0x0;
        } reserved_30_30[30:30];
        field {
            name = "reserved";
            desc = "Reserved.";
            sw = r; hw = w;
            reset = 0x0;
        } reserved_29_29[29:29];
        field {
            name = "reserved";
            desc = "Reserved.";
            sw = r; hw = w;
            reset = 0x0;
        } reserved_28_24[28:24];
        field {
            name = "g3rr_int";
            desc = "G3 register update interrupt.";
            sw = r; hw = w;
            reset = 0x0;
        } g3rr_int[23:23];
        field {
            name = "reserved";
            desc = "Reserved.";
            sw = r; hw = w;
            reset = 0x0;
        } reserved_22_21[22:21];
        field {
            name = "vsd1rr_int";
            desc = "VSD1 register update interrupt.";
            sw = r; hw = w;
            reset = 0x0;
        } vsd1rr_int[20:20];
        field {
            name = "reserved";
            desc = "Reserved.";
            sw = r; hw = w;
            reset = 0x0;
        } reserved_19_4[19:4];
        field {
            name = "dsduf_int";
            desc = "DSD low-bandwidth alarm interrupt.";
            sw = r; hw = w;
            reset = 0x0;
        } dsduf_int[3:3];
        field {
            name = "reserved";
            desc = "Reserved.";
            sw = r; hw = w;
            reset = 0x0;
        } reserved_2_2[2:2];
        field {
            name = "dsdvtthd1_int";
            desc = "DSD1 vertical timing interrupt.";
            sw = r; hw = w;
            reset = 0x0;
        } dsdvtthd1_int[1:1];
        field {
            name = "reserved";
            desc = "Reserved.";
            sw = r; hw = w;
            reset = 0x0;
        } reserved_0_0[0:0];
    } VOINTSTA @ 0xce04;
    reg {
        name = "VOMSKINTSTA";
        desc = "VOMSKINTSTA is a VO masked interrupt status register. Writing 1 clears this register. VOMSKINTSTA (offset 0xCE08, total reset 0x0000_0000; PROVEN: Hi3518E V100 data sheet, PDF page 733, section 5.8).";
        field {
            name = "be_int";
            desc = "Bus error interrupt (AXI_Master).
- 0: No interrupt is generated.
- 1: An interrupt is generated.";
            sw = r; hw = w;
            reset = 0x0;
        } be_int[31:31];
        field {
            name = "reserved";
            desc = "Reserved.";
            sw = r; hw = w;
            reset = 0x0;
        } reserved_30_30[30:30];
        field {
            name = "reserved";
            desc = "Reserved.";
            sw = r; hw = w;
            reset = 0x0;
        } reserved_29_29[29:29];
        field {
            name = "reserved";
            desc = "Reserved.";
            sw = r; hw = w;
            reset = 0x0;
        } reserved_28_24[28:24];
        field {
            name = "g3rr_int";
            desc = "G3 register update interrupt.";
            sw = r; hw = w;
            reset = 0x0;
        } g3rr_int[23:23];
        field {
            name = "reserved";
            desc = "Reserved.";
            sw = r; hw = w;
            reset = 0x0;
        } reserved_22_21[22:21];
        field {
            name = "vsd1rr_int";
            desc = "VSD1 register update interrupt.";
            sw = r; hw = w;
            reset = 0x0;
        } vsd1rr_int[20:20];
        field {
            name = "reserved";
            desc = "Reserved.";
            sw = r; hw = w;
            reset = 0x0;
        } reserved_19_4[19:4];
        field {
            name = "dsduf_int";
            desc = "DSD low-bandwidth alarm interrupt.";
            sw = r; hw = w;
            reset = 0x0;
        } dsduf_int[3:3];
        field {
            name = "reserved";
            desc = "Reserved.";
            sw = r; hw = w;
            reset = 0x0;
        } reserved_2_2[2:2];
        field {
            name = "dsdvtthd1_int";
            desc = "DSD1 vertical timing interrupt.";
            sw = r; hw = w;
            reset = 0x0;
        } dsdvtthd1_int[1:1];
        field {
            name = "reserved";
            desc = "Reserved.";
            sw = r; hw = w;
            reset = 0x0;
        } reserved_0_0[0:0];
    } VOMSKINTSTA @ 0xce08;
    reg {
        name = "VOINTMSK";
        desc = "VOINTMSK is a VDP interrupt mask register. It corresponds to VOINTSTA. When the corresponding bit is set to 1, the interrupt is enabled; when the corresponding bit is set to 0, the interrupt is masked. VOINTMSK (offset 0xCE0C, total reset 0x0000_0000; PROVEN: Hi3518E V100 data sheet, PDF page 734, section 5.8).";
        field {
            name = "be_intmask";
            desc = "Bus error interrupt (AXI_Master).
- 0: No interrupt is generated.
- 1: An interrupt is generated.";
            sw = r; hw = w;
            reset = 0x0;
        } be_intmask[31:31];
        field {
            name = "reserved";
            desc = "Reserved.";
            sw = r; hw = w;
            reset = 0x0;
        } reserved_30_30[30:30];
        field {
            name = "reserved";
            desc = "Reserved.";
            sw = r; hw = w;
            reset = 0x0;
        } reserved_29_29[29:29];
        field {
            name = "reserved";
            desc = "Reserved.";
            sw = r; hw = w;
            reset = 0x0;
        } reserved_28_24[28:24];
        field {
            name = "g3rr_intmsk";
            desc = "G3 register update interrupt.";
            sw = r; hw = w;
            reset = 0x0;
        } g3rr_intmsk[23:23];
        field {
            name = "reserved";
            desc = "Reserved.";
            sw = r; hw = w;
            reset = 0x0;
        } reserved_22_21[22:21];
        field {
            name = "vsd1rr_intmask";
            desc = "VSD1 register update interrupt.";
            sw = r; hw = w;
            reset = 0x0;
        } vsd1rr_intmask[20:20];
        field {
            name = "reserved";
            desc = "Reserved.";
            sw = r; hw = w;
            reset = 0x0;
        } reserved_19_4[19:4];
        field {
            name = "dsduf_intmask";
            desc = "DSD low-bandwidth alarm interrupt.";
            sw = r; hw = w;
            reset = 0x0;
        } dsduf_intmask[3:3];
        field {
            name = "reserved";
            desc = "Reserved.";
            sw = r; hw = w;
            reset = 0x0;
        } reserved_2_2[2:2];
        field {
            name = "dsdvtthd1_intmask";
            desc = "DSD1 vertical timing interrupt.";
            sw = r; hw = w;
            reset = 0x0;
        } dsdvtthd1_intmask[1:1];
        field {
            name = "reserved";
            desc = "Reserved.";
            sw = r; hw = w;
            reset = 0x0;
        } reserved_0_0[0:0];
    } VOINTMSK @ 0xce0c;
    reg {
        name = "VOUVERSION1";
        desc = "VOUVERSION1 is VDP version register 1. VOUVERSION1 (offset 0xCE10, total reset 0x7675_6F76; PROVEN: Hi3518E V100 data sheet, PDF page 735, section 5.8).";
        field {
            name = "vouversion0";
            desc = "VDP version.";
            sw = r; hw = w;
            reset = 0x76756f76;
        } vouversion0[31:0];
    } VOUVERSION1 @ 0xce10;
    reg {
        name = "VOUVERSION2";
        desc = "VOUVERSION2 is VDP version register 2. VOUVERSION2 (offset 0xCE14, total reset 0x3030_3134; PROVEN: Hi3518E V100 data sheet, PDF page 735, section 5.8).";
        field {
            name = "vouversion1";
            desc = "VDP version.";
            sw = r; hw = w;
            reset = 0x30303134;
        } vouversion1[31:0];
    } VOUVERSION2 @ 0xce14;
    reg {
        name = "VOMUX";
        desc = "VOMUX is a VO interface multiplexing register. VOMUX (offset 0xCE1C, total reset 0x0004_001B; PROVEN: Hi3518E V100 data sheet, PDF page 735, section 5.8).";
        field {
            name = "reserved";
            desc = "Reserved.";
            sw = rw; hw = r;
            reset = 0x0;
        } reserved_31_24[31:24];
        field {
            name = "bt1120_sel_yc";
            desc = "BT.1120 Y/C position select.
- 0: The upper eight bits are used to transmit the Y component, and the lower eight bits are used to transmit the C component.
- 1: The upper eight bits are used to transmit the C component, and the lower eight bits are used to transmit the Y component.";
            sw = rw; hw = r;
            reset = 0x0;
        } bt1120_sel_yc[23:23];
        field {
            name = "reserved";
            desc = "Reserved. Contents";
            sw = r; hw = na;
            reset = 0x4001b;
        } reserved_22_0[22:0];
    } VOMUX @ 0xce1c;
};

`endif
