`ifndef EHI3518EV100_IO_CONFIG_RDL
`define EHI3518EV100_IO_CONFIG_RDL
regfile eHI3518EV100_IO_CONFIG {
    name = "Pin multiplexing registers (muxctrl_reg)";
    desc = "Pin multiplexing registers (muxctrl_reg). 87 registers extracted programmatically from the Hi3518E 720p IP Camera SoC data sheet (Issue 03, 2015-11-26); chapter 2.3.2, table 2-30. Field names, bit ranges, access types and reset values are taken from the register tables; reset values are the data sheet total reset values split onto the fields (per-field values where the table has them). Label: PROVEN. Hardware not verified here (no board).";
    reg {
        name = "muxctrl_reg0";
        desc = "muxctrl_reg0 is a multiplexing control register for the SHUTTER_TRIG pin. muxctrl_reg0 (offset 0x000, total reset 0x00000000; PROVEN: Hi3518E V100 data sheet, PDF page 60, section 2.3.2).";
        field {
            name = "reserved";
            desc = "Reserved";
            sw = r; hw = w;
            reset = 0x0;
        } reserved_31_1[31:1];
        field {
            name = "muxctrl_reg0";
            desc = "Multiplexing for the SHUTTER_TRIG pin.
- 0: GPIO1_0
- 1: SHUTTER_TRIG";
            sw = rw; hw = r;
            reset = 0x0;
        } muxctrl_reg0[0:0];
    } muxctrl_reg0 @ 0x0;
    reg {
        name = "muxctrl_reg1";
        desc = "muxctrl_reg1 is a multiplexing control register for the SDIO_CCLK_OUT pin. muxctrl_reg1 (offset 0x004, total reset 0x00000000; PROVEN: Hi3518E V100 data sheet, PDF page 60, section 2.3.2).";
        field {
            name = "reserved";
            desc = "Reserved";
            sw = r; hw = w;
            reset = 0x0;
        } reserved_31_1[31:1];
        field {
            name = "muxctrl_reg1";
            desc = "Multiplexing for the SDIO_CCLK_OUT pin.
- 0: GPIO1_1
- 1: SDIO_CCLK_OUT";
            sw = rw; hw = r;
            reset = 0x0;
        } muxctrl_reg1[0:0];
    } muxctrl_reg1 @ 0x4;
    reg {
        name = "muxctrl_reg2";
        desc = "muxctrl_reg2 is a multiplexing control register for the SENSOR_CLK pin. muxctrl_reg2 (offset 0x008, total reset 0x00000000; PROVEN: Hi3518E V100 data sheet, PDF page 61, section 2.3.2).";
        field {
            name = "reserved";
            desc = "Reserved";
            sw = r; hw = w;
            reset = 0x0;
        } reserved_31_1[31:1];
        field {
            name = "muxctrl_reg2";
            desc = "Multiplexing for the SENSOR_CLK pin.
- 0: GPIO1_2
- 1: SENSOR_CLK";
            sw = rw; hw = r;
            reset = 0x0;
        } muxctrl_reg2[0:0];
    } muxctrl_reg2 @ 0x8;
    reg {
        name = "muxctrl_reg3";
        desc = "muxctrl_reg3 is a multiplexing control register for the SPI0_SCLK pin. muxctrl_reg3 (offset 0x00C, total reset 0x00000000; PROVEN: Hi3518E V100 data sheet, PDF page 61, section 2.3.2).";
        field {
            name = "reserved";
            desc = "Reserved";
            sw = r; hw = w;
            reset = 0x0;
        } reserved_31_1[31:1];
        field {
            name = "muxctrl_reg3";
            desc = "Multiplexing for the SPI0_SCLK pin.
- 0: GPIO1_4
- 1: SPI0_SCLK";
            sw = rw; hw = r;
            reset = 0x0;
        } muxctrl_reg3[0:0];
    } muxctrl_reg3 @ 0xc;
    reg {
        name = "muxctrl_reg4";
        desc = "muxctrl_reg4 is a multiplexing control register for the SPI0_SDO pin. muxctrl_reg4 (offset 0x010, total reset 0x00000000; PROVEN: Hi3518E V100 data sheet, PDF page 62, section 2.3.2).";
        field {
            name = "reserved";
            desc = "Reserved";
            sw = r; hw = w;
            reset = 0x0;
        } reserved_31_1[31:1];
        field {
            name = "muxctrl_reg4";
            desc = "Multiplexing for the SPI0_SDO pin.
- 0: GPIO1_5
- 1: SPI0_SDO";
            sw = rw; hw = r;
            reset = 0x0;
        } muxctrl_reg4[0:0];
    } muxctrl_reg4 @ 0x10;
    reg {
        name = "muxctrl_reg5";
        desc = "muxctrl_reg5 is a multiplexing control register for the SPI0_SDI pin. muxctrl_reg5 (offset 0x014, total reset 0x00000000; PROVEN: Hi3518E V100 data sheet, PDF page 62, section 2.3.2).";
        field {
            name = "reserved";
            desc = "Reserved";
            sw = r; hw = w;
            reset = 0x0;
        } reserved_31_1[31:1];
        field {
            name = "muxctrl_reg5";
            desc = "Multiplexing for the SPI0_SDI pin.
- 0: GPIO1_6
- 1: SPI0_SDI";
            sw = rw; hw = r;
            reset = 0x0;
        } muxctrl_reg5[0:0];
    } muxctrl_reg5 @ 0x14;
    reg {
        name = "muxctrl_reg6";
        desc = "muxctrl_reg6 is a multiplexing control register for the I2C_SDA pin. muxctrl_reg6 (offset 0x018, total reset 0x00000000; PROVEN: Hi3518E V100 data sheet, PDF page 63, section 2.3.2).";
        field {
            name = "reserved";
            desc = "Reserved";
            sw = r; hw = w;
            reset = 0x0;
        } reserved_31_1[31:1];
        field {
            name = "muxctrl_reg6";
            desc = "Multiplexing for the I2C_SDA pin.
- 0: GPIO2_0
- 1: I2C_SDA";
            sw = rw; hw = r;
            reset = 0x0;
        } muxctrl_reg6[0:0];
    } muxctrl_reg6 @ 0x18;
    reg {
        name = "muxctrl_reg7";
        desc = "muxctrl_reg7 is a multiplexing control register for the I2C_SCL pin. muxctrl_reg7 (offset 0x01C, total reset 0x00000000; PROVEN: Hi3518E V100 data sheet, PDF page 63, section 2.3.2).";
        field {
            name = "reserved";
            desc = "Reserved";
            sw = r; hw = w;
            reset = 0x0;
        } reserved_31_1[31:1];
        field {
            name = "muxctrl_reg7";
            desc = "Multiplexing for the I2C_SCL pin.
- 0: GPIO2_1
- 1: I2C_SCL";
            sw = rw; hw = r;
            reset = 0x0;
        } muxctrl_reg7[0:0];
    } muxctrl_reg7 @ 0x1c;
    reg {
        name = "muxctrl_reg8";
        desc = "muxctrl_reg8 is a multiplexing control register for the UART1_RTSN pin. muxctrl_reg8 (offset 0x020, total reset 0x00000000; PROVEN: Hi3518E V100 data sheet, PDF page 64, section 2.3.2).";
        field {
            name = "reserved";
            desc = "Reserved";
            sw = r; hw = w;
            reset = 0x0;
        } reserved_31_1[31:1];
        field {
            name = "muxctrl_reg8";
            desc = "Multiplexing for the UART1_RTSN pin.
- 0: GPIO2_2
- 1: UART1_RTSN";
            sw = rw; hw = r;
            reset = 0x0;
        } muxctrl_reg8[0:0];
    } muxctrl_reg8 @ 0x20;
    reg {
        name = "muxctrl_reg9";
        desc = "muxctrl_reg9 is a multiplexing control register for the UART1_RXD pin. muxctrl_reg9 (offset 0x024, total reset 0x00000000; PROVEN: Hi3518E V100 data sheet, PDF page 64, section 2.3.2).";
        field {
            name = "reserved";
            desc = "Reserved";
            sw = r; hw = w;
            reset = 0x0;
        } reserved_31_1[31:1];
        field {
            name = "muxctrl_reg9";
            desc = "Multiplexing for the UART1_RXD pin.
- 0: GPIO2_3
- 1: UART1_RXD";
            sw = rw; hw = r;
            reset = 0x0;
        } muxctrl_reg9[0:0];
    } muxctrl_reg9 @ 0x24;
    reg {
        name = "muxctrl_reg10";
        desc = "muxctrl_reg10 is a multiplexing control register for the UART1_CTSN pin. muxctrl_reg10 (offset 0x028, total reset 0x00000000; PROVEN: Hi3518E V100 data sheet, PDF page 65, section 2.3.2).";
        field {
            name = "reserved";
            desc = "Reserved";
            sw = r; hw = w;
            reset = 0x0;
        } reserved_31_1[31:1];
        field {
            name = "muxctrl_reg10";
            desc = "Multiplexing for the UART1_CTSN pin.
- 0: GPIO2_4
- 1: UART1_CTSN";
            sw = rw; hw = r;
            reset = 0x0;
        } muxctrl_reg10[0:0];
    } muxctrl_reg10 @ 0x28;
    reg {
        name = "muxctrl_reg11";
        desc = "muxctrl_reg11 is a multiplexing control register for the UART1_TXD pin. muxctrl_reg11 (offset 0x02C, total reset 0x00000000; PROVEN: Hi3518E V100 data sheet, PDF page 65, section 2.3.2).";
        field {
            name = "reserved";
            desc = "Reserved";
            sw = r; hw = w;
            reset = 0x0;
        } reserved_31_1[31:1];
        field {
            name = "muxctrl_reg11";
            desc = "Multiplexing for the UART1_TXD pin.
- 0: GPIO2_5
- 1: UART1_TXD";
            sw = rw; hw = r;
            reset = 0x0;
        } muxctrl_reg11[0:0];
    } muxctrl_reg11 @ 0x2c;
    reg {
        name = "muxctrl_reg12";
        desc = "muxctrl_reg12 is a multiplexing control register for the MII_CRS pin. muxctrl_reg12 (offset 0x030, total reset 0x00000000; PROVEN: Hi3518E V100 data sheet, PDF page 66, section 2.3.2).";
        field {
            name = "reserved";
            desc = "Reserved";
            sw = r; hw = w;
            reset = 0x0;
        } reserved_31_2[31:2];
        field {
            name = "muxctrl_reg12";
            desc = "Multiplexing for the MII_CRS pin.
- 00: GPIO3_0
- 01: MII_CRS
- 10: VOU1120_DATA10

Other values: reserved";
            sw = rw; hw = r;
            reset = 0x0;
        } muxctrl_reg12[1:0];
    } muxctrl_reg12 @ 0x30;
    reg {
        name = "muxctrl_reg13";
        desc = "muxctrl_reg13 is a multiplexing control register for the MII_COL pin. muxctrl_reg13 (offset 0x034, total reset 0x00000000; PROVEN: Hi3518E V100 data sheet, PDF page 66, section 2.3.2).";
        field {
            name = "reserved";
            desc = "Reserved";
            sw = r; hw = w;
            reset = 0x0;
        } reserved_31_2[31:2];
        field {
            name = "muxctrl_reg13";
            desc = "Multiplexing for the MII_COL pin.
- 00: GPIO3_1
- 01: MII_COL
- 10: VOU1120_DATA9

Other values: reserved";
            sw = rw; hw = r;
            reset = 0x0;
        } muxctrl_reg13[1:0];
    } muxctrl_reg13 @ 0x34;
    reg {
        name = "muxctrl_reg14";
        desc = "muxctrl_reg14 is a multiplexing control register for the MII_RXD3 pin. muxctrl_reg14 (offset 0x038, total reset 0x00000000; PROVEN: Hi3518E V100 data sheet, PDF page 67, section 2.3.2).";
        field {
            name = "reserved";
            desc = "Reserved";
            sw = r; hw = w;
            reset = 0x0;
        } reserved_31_2[31:2];
        field {
            name = "muxctrl_reg14";
            desc = "Multiplexing for the MII_RXD3 pin.
- 00: GPIO4_3
- 01: MII_RXD3
- 10: VOU1120_DATA15

Other values: reserved";
            sw = rw; hw = r;
            reset = 0x0;
        } muxctrl_reg14[1:0];
    } muxctrl_reg14 @ 0x38;
    reg {
        name = "muxctrl_reg15";
        desc = "muxctrl_reg15 is a multiplexing control register for the MII_RXD2 pin. muxctrl_reg15 (offset 0x03C, total reset 0x00000000; PROVEN: Hi3518E V100 data sheet, PDF page 68, section 2.3.2).";
        field {
            name = "reserved";
            desc = "Reserved";
            sw = r; hw = w;
            reset = 0x0;
        } reserved_31_2[31:2];
        field {
            name = "muxctrl_reg15";
            desc = "Multiplexing for the MII_RXD2 pin.
- 00: GPIO4_2
- 01: MII_RXD2
- 10: VOU1120_DATA11

Other values: reserved";
            sw = rw; hw = r;
            reset = 0x0;
        } muxctrl_reg15[1:0];
    } muxctrl_reg15 @ 0x3c;
    reg {
        name = "muxctrl_reg16";
        desc = "muxctrl_reg16 is a multiplexing control register for the MII_RXD1 pin. muxctrl_reg16 (offset 0x040, total reset 0x00000000; PROVEN: Hi3518E V100 data sheet, PDF page 68, section 2.3.2).";
        field {
            name = "reserved";
            desc = "Reserved";
            sw = r; hw = w;
            reset = 0x0;
        } reserved_31_2[31:2];
        field {
            name = "muxctrl_reg16";
            desc = "Multiplexing for the MII_RXD1 pin.
- 00: GPIO4_1
- 01: MII_RXD1
- 10: VOU1120_DATA8

Other values: reserved";
            sw = rw; hw = r;
            reset = 0x0;
        } muxctrl_reg16[1:0];
    } muxctrl_reg16 @ 0x40;
    reg {
        name = "muxctrl_reg17";
        desc = "muxctrl_reg17 is a multiplexing control register for the MII_RXD0 pin. muxctrl_reg17 (offset 0x044, total reset 0x00000000; PROVEN: Hi3518E V100 data sheet, PDF page 69, section 2.3.2).";
        field {
            name = "reserved";
            desc = "Reserved";
            sw = r; hw = w;
            reset = 0x0;
        } reserved_31_2[31:2];
        field {
            name = "muxctrl_reg17";
            desc = "Multiplexing for the MII_RXD0 pin.
- 00: GPIO4_0
- 01: MII_RXD0
- 10: VOU1120_DATA12

Other values: reserved";
            sw = rw; hw = r;
            reset = 0x0;
        } muxctrl_reg17[1:0];
    } muxctrl_reg17 @ 0x44;
    reg {
        name = "muxctrl_reg18";
        desc = "muxctrl_reg18 is a multiplexing control register for the MII_TXD3 pin. muxctrl_reg18 (offset 0x048, total reset 0x00000000; PROVEN: Hi3518E V100 data sheet, PDF page 69, section 2.3.2).";
        field {
            name = "reserved";
            desc = "Reserved";
            sw = r; hw = w;
            reset = 0x0;
        } reserved_31_2[31:2];
        field {
            name = "muxctrl_reg18";
            desc = "Multiplexing for the MII_TXD3 pin.
- 00: GPIO4_7
- 01: MII_TXD3
- 10: VOU1120_DATA3

Other values: reserved";
            sw = rw; hw = r;
            reset = 0x0;
        } muxctrl_reg18[1:0];
    } muxctrl_reg18 @ 0x48;
    reg {
        name = "muxctrl_reg19";
        desc = "muxctrl_reg19 is a multiplexing control register for the MII_TXD2 pin. muxctrl_reg19 (offset 0x04C, total reset 0x00000000; PROVEN: Hi3518E V100 data sheet, PDF page 70, section 2.3.2).";
        field {
            name = "reserved";
            desc = "Reserved";
            sw = r; hw = w;
            reset = 0x0;
        } reserved_31_2[31:2];
        field {
            name = "muxctrl_reg19";
            desc = "Multiplexing for the MII_TXD2 pin.
- 00: GPIO4_6
- 01: MII_TXD2
- 10: VOU1120_DATA13

Other values: reserved";
            sw = rw; hw = r;
            reset = 0x0;
        } muxctrl_reg19[1:0];
    } muxctrl_reg19 @ 0x4c;
    reg {
        name = "muxctrl_reg20";
        desc = "muxctrl_reg20 is a multiplexing control register for the MII_TXD1 pin. muxctrl_reg20 (offset 0x050, total reset 0x00000000; PROVEN: Hi3518E V100 data sheet, PDF page 70, section 2.3.2).";
        field {
            name = "reserved";
            desc = "Reserved";
            sw = r; hw = w;
            reset = 0x0;
        } reserved_31_2[31:2];
        field {
            name = "muxctrl_reg20";
            desc = "Multiplexing for the MII_TXD1 pin.
- 00: GPIO4_5
- 01: MII_TXD1
- 10: VOU1120_DATA0";
            sw = rw; hw = r;
            reset = 0x0;
        } muxctrl_reg20[1:0];
    } muxctrl_reg20 @ 0x50;
    reg {
        name = "muxctrl_reg21";
        desc = "muxctrl_reg21 is a multiplexing control register for the MII_TXD0 pin. muxctrl_reg21 (offset 0x054, total reset 0x00000000; PROVEN: Hi3518E V100 data sheet, PDF page 71, section 2.3.2).";
        field {
            name = "reserved";
            desc = "Reserved";
            sw = r; hw = w;
            reset = 0x0;
        } reserved_31_2[31:2];
        field {
            name = "muxctrl_reg21";
            desc = "Multiplexing for the MII_TXD0 pin.
- 00: GPIO4_4
- 01: MII_TXD0
- 10: VOU1120_DATA4

Other values: reserved";
            sw = rw; hw = r;
            reset = 0x0;
        } muxctrl_reg21[1:0];
    } muxctrl_reg21 @ 0x54;
    reg {
        name = "muxctrl_reg22";
        desc = "muxctrl_reg22 is a multiplexing control register for the MII_RXCK pin. muxctrl_reg22 (offset 0x058, total reset 0x00000000; PROVEN: Hi3518E V100 data sheet, PDF page 71, section 2.3.2).";
        field {
            name = "reserved";
            desc = "Reserved";
            sw = r; hw = w;
            reset = 0x0;
        } reserved_31_2[31:2];
        field {
            name = "muxctrl_reg22";
            desc = "Multiplexing for the MII_RXCK pin.
- 00: GPIO3_2
- 01: MII_RXCK
- 10: VOU1120_CLK";
            sw = rw; hw = r;
            reset = 0x0;
        } muxctrl_reg22[1:0];
    } muxctrl_reg22 @ 0x58;
    reg {
        name = "muxctrl_reg23";
        desc = "muxctrl_reg23 is a multiplexing control register for the MII_TXCK pin. muxctrl_reg23 (offset 0x05C, total reset 0x00000000; PROVEN: Hi3518E V100 data sheet, PDF page 72, section 2.3.2).";
        field {
            name = "reserved";
            desc = "Reserved";
            sw = r; hw = w;
            reset = 0x0;
        } reserved_31_2[31:2];
        field {
            name = "muxctrl_reg23";
            desc = "Multiplexing for the MII_TXCK pin.
- 00: GPIO3_3
- 01: MII_TXCK
- 10: VOU1120_DATA7
- 11: RMII_CLK";
            sw = rw; hw = r;
            reset = 0x0;
        } muxctrl_reg23[1:0];
    } muxctrl_reg23 @ 0x5c;
    reg {
        name = "muxctrl_reg24";
        desc = "muxctrl_reg24 is a multiplexing control register for the MII_RXDV pin. muxctrl_reg24 (offset 0x060, total reset 0x00000000; PROVEN: Hi3518E V100 data sheet, PDF page 72, section 2.3.2).";
        field {
            name = "reserved";
            desc = "Reserved";
            sw = r; hw = w;
            reset = 0x0;
        } reserved_31_2[31:2];
        field {
            name = "muxctrl_reg24";
            desc = "Multiplexing for the MII_RXDV pin.
- 00: GPIO3_4";
            sw = rw; hw = r;
            reset = 0x0;
        } muxctrl_reg24[1:0];
    } muxctrl_reg24 @ 0x60;
    reg {
        name = "muxctrl_reg25";
        desc = "muxctrl_reg25 is a multiplexing control register for the MII_TXEN pin. muxctrl_reg25 (offset 0x064, total reset 0x00000000; PROVEN: Hi3518E V100 data sheet, PDF page 73, section 2.3.2).";
        field {
            name = "reserved";
            desc = "Reserved";
            sw = r; hw = w;
            reset = 0x0;
        } reserved_31_2[31:2];
        field {
            name = "muxctrl_reg25";
            desc = "Multiplexing for the MII_TXEN pin.
- 00: GPIO3_5
- 01: MII_TXEN
- 10: VOU1120_DATA5

Other values: reserved";
            sw = rw; hw = r;
            reset = 0x0;
        } muxctrl_reg25[1:0];
    } muxctrl_reg25 @ 0x64;
    reg {
        name = "muxctrl_reg26";
        desc = "muxctrl_reg26 is a multiplexing control register for the MII_TXER pin. muxctrl_reg26 (offset 0x068, total reset 0x00000000; PROVEN: Hi3518E V100 data sheet, PDF page 73, section 2.3.2).";
        field {
            name = "reserved";
            desc = "Reserved";
            sw = r; hw = w;
            reset = 0x0;
        } reserved_31_1[31:1];
        field {
            name = "muxctrl_reg26";
            desc = "Multiplexing for the MII_TXER pin.";
            sw = rw; hw = r;
            reset = 0x0;
        } muxctrl_reg26[0:0];
    } muxctrl_reg26 @ 0x68;
    reg {
        name = "muxctrl_reg27";
        desc = "muxctrl_reg27 is a multiplexing control register for the MII_RXER pin. muxctrl_reg27 (offset 0x06C, total reset 0x00000000; PROVEN: Hi3518E V100 data sheet, PDF page 74, section 2.3.2).";
        field {
            name = "reserved";
            desc = "Reserved";
            sw = r; hw = w;
            reset = 0x0;
        } reserved_31_1[31:1];
        field {
            name = "muxctrl_reg27";
            desc = "Multiplexing for the MII_RXER pin.
- 0: GPIO2_7
- 1: MII_RXER";
            sw = rw; hw = r;
            reset = 0x0;
        } muxctrl_reg27[0:0];
    } muxctrl_reg27 @ 0x6c;
    reg {
        name = "muxctrl_reg28";
        desc = "muxctrl_reg28 is a multiplexing control register for the EPHY_CLK pin. muxctrl_reg28 (offset 0x070, total reset 0x00000000; PROVEN: Hi3518E V100 data sheet, PDF page 74, section 2.3.2).";
        field {
            name = "reserved";
            desc = "Reserved";
            sw = r; hw = w;
            reset = 0x0;
        } reserved_31_2[31:2];
        field {
            name = "muxctrl_reg28";
            desc = "Multiplexing for the EPHY_CLK pin.
- 00: GPIO1_3
- 01: EPHY_CLK";
            sw = rw; hw = r;
            reset = 0x0;
        } muxctrl_reg28[1:0];
    } muxctrl_reg28 @ 0x70;
    reg {
        name = "muxctrl_reg29";
        desc = "muxctrl_reg29 is a multiplexing control register for the MDCK pin. muxctrl_reg29 (offset 0x074, total reset 0x00000000; PROVEN: Hi3518E V100 data sheet, PDF page 75, section 2.3.2).";
        field {
            name = "reserved";
            desc = "Reserved";
            sw = r; hw = w;
            reset = 0x0;
        } reserved_31_2[31:2];
        field {
            name = "muxctrl_reg29";
            desc = "Multiplexing for the MDCK pin.
- 00: GPIO3_6
- 01: MDCK
- 10: VOU1120_DATA6
- 11: BOOT_SEL";
            sw = rw; hw = r;
            reset = 0x0;
        } muxctrl_reg29[1:0];
    } muxctrl_reg29 @ 0x74;
    reg {
        name = "muxctrl_reg30";
        desc = "muxctrl_reg30 is a multiplexing control register for the MDIO pin. muxctrl_reg30 (offset 0x078, total reset 0x00000000; PROVEN: Hi3518E V100 data sheet, PDF page 75, section 2.3.2).";
        field {
            name = "reserved";
            desc = "Reserved";
            sw = r; hw = w;
            reset = 0x0;
        } reserved_31_2[31:2];
        field {
            name = "muxctrl_reg30";
            desc = "Multiplexing for the MDIO pin.";
            sw = rw; hw = r;
            reset = 0x0;
        } muxctrl_reg30[1:0];
    } muxctrl_reg30 @ 0x78;
    reg {
        name = "muxctrl_reg31";
        desc = "muxctrl_reg31 is a multiplexing control register for the FLASH_TRIG pin. muxctrl_reg31 (offset 0x07C, total reset 0x00000000; PROVEN: Hi3518E V100 data sheet, PDF page 76, section 2.3.2).";
        field {
            name = "reserved";
            desc = "Reserved";
            sw = r; hw = w;
            reset = 0x0;
        } reserved_31_1[31:1];
        field {
            name = "muxctrl_reg31";
            desc = "Multiplexing for the FLASH_TRIG pin.
- 0: GPIO1_7
- 1: FLASH_TRIG";
            sw = rw; hw = r;
            reset = 0x0;
        } muxctrl_reg31[0:0];
    } muxctrl_reg31 @ 0x7c;
    reg {
        name = "muxctrl_reg32";
        desc = "muxctrl_reg32 is a multiplexing control register for the SDIO_CARD_DETECT pin. muxctrl_reg32 (offset 0x080, total reset 0x00000000; PROVEN: Hi3518E V100 data sheet, PDF page 76, section 2.3.2).";
        field {
            name = "reserved";
            desc = "Reserved";
            sw = r; hw = w;
            reset = 0x0;
        } reserved_31_1[31:1];
        field {
            name = "muxctrl_reg32";
            desc = "Multiplexing for the SDIO_CARD_DETECT pin.";
            sw = rw; hw = r;
            reset = 0x0;
        } muxctrl_reg32[0:0];
    } muxctrl_reg32 @ 0x80;
    reg {
        name = "muxctrl_reg33";
        desc = "muxctrl_reg33 is a multiplexing control register for the SDIO_CARD_POWER_EN pin. muxctrl_reg33 (offset 0x084, total reset 0x00000000; PROVEN: Hi3518E V100 data sheet, PDF page 77, section 2.3.2).";
        field {
            name = "reserved";
            desc = "Reserved";
            sw = r; hw = w;
            reset = 0x0;
        } reserved_31_1[31:1];
        field {
            name = "muxctrl_reg33";
            desc = "Multiplexing for the SDIO_CARD_POWER_EN pin.
- 0: GPIO6_1
- 1: SDIO_CARD_POWER_EN";
            sw = rw; hw = r;
            reset = 0x0;
        } muxctrl_reg33[0:0];
    } muxctrl_reg33 @ 0x84;
    reg {
        name = "muxctrl_reg34";
        desc = "muxctrl_reg34 is a multiplexing control register for the SDIO_CWPR pin. muxctrl_reg34 (offset 0x088, total reset 0x00000000; PROVEN: Hi3518E V100 data sheet, PDF page 77, section 2.3.2).";
        field {
            name = "reserved";
            desc = "Reserved";
            sw = r; hw = w;
            reset = 0x0;
        } reserved_31_1[31:1];
        field {
            name = "muxctrl_reg34";
            desc = "Multiplexing for the SDIO_CWPR pin.
- 0: GPIO6_2
- 1: SDIO_CWPR";
            sw = rw; hw = r;
            reset = 0x0;
        } muxctrl_reg34[0:0];
    } muxctrl_reg34 @ 0x88;
    reg {
        name = "muxctrl_reg35";
        desc = "muxctrl_reg35 is a multiplexing control register for the SDIO_CCMD pin. muxctrl_reg35 (offset 0x08C, total reset 0x00000000; PROVEN: Hi3518E V100 data sheet, PDF page 78, section 2.3.2).";
        field {
            name = "reserved";
            desc = "Reserved";
            sw = r; hw = w;
            reset = 0x0;
        } reserved_31_1[31:1];
        field {
            name = "muxctrl_reg35";
            desc = "Multiplexing for the SDIO_CCMD pin.
- 0: GPIO6_3
- 1: SDIO_CCMD";
            sw = rw; hw = r;
            reset = 0x0;
        } muxctrl_reg35[0:0];
    } muxctrl_reg35 @ 0x8c;
    reg {
        name = "muxctrl_reg36";
        desc = "muxctrl_reg36 is a multiplexing control register for the SDIO_CDATA0 pin. muxctrl_reg36 (offset 0x090, total reset 0x00000000; PROVEN: Hi3518E V100 data sheet, PDF page 78, section 2.3.2).";
        field {
            name = "reserved";
            desc = "Reserved";
            sw = r; hw = w;
            reset = 0x0;
        } reserved_31_3[31:3];
        field {
            name = "muxctrl_reg36";
            desc = "Multiplexing for the SDIO_CDATA0 pin.
- 000: GPIO6_4
- 001: SDIO_CDATA0
- 010: CLK_TEST_OUT0
- 011: CLK_TEST_OUT1
- 100: CLK_TEST_OUT2
- 101: CLK_TEST_OUT3";
            sw = rw; hw = r;
            reset = 0x0;
        } muxctrl_reg36[2:0];
    } muxctrl_reg36 @ 0x90;
    reg {
        name = "muxctrl_reg37";
        desc = "muxctrl_reg37 is a multiplexing control register for the SDIO_CDATA1 pin. muxctrl_reg37 (offset 0x094, total reset 0x00000000; PROVEN: Hi3518E V100 data sheet, PDF page 79, section 2.3.2).";
        field {
            name = "reserved";
            desc = "Reserved";
            sw = r; hw = w;
            reset = 0x0;
        } reserved_31_3[31:3];
        field {
            name = "muxctrl_reg37";
            desc = "Multiplexing for the SDIO_CDATA1 pin.
- 000: PLL_TEST_OUT0
- 001: SDIO_CDATA1
- 010: GPIO6_5
- 011: PLL_TEST_OUT1
- 100: PLL_TEST_OUT2
- 101: PLL_TEST_OUT3
- 110: RTC_TEST_CLK

Other values: reserved";
            sw = rw; hw = r;
            reset = 0x0;
        } muxctrl_reg37[2:0];
    } muxctrl_reg37 @ 0x94;
    reg {
        name = "muxctrl_reg38";
        desc = "muxctrl_reg38 is a multiplexing control register for the SDIO_CDATA2 pin. muxctrl_reg38 (offset 0x098, total reset 0x00000000; PROVEN: Hi3518E V100 data sheet, PDF page 79, section 2.3.2).";
        field {
            name = "reserved";
            desc = "Reserved";
            sw = r; hw = w;
            reset = 0x0;
        } reserved_31_1[31:1];
        field {
            name = "muxctrl_reg38";
            desc = "Multiplexing for the SDIO_CDATA2 pin.
- 0: GPIO6_6
- 1: SDIO_CDATA2";
            sw = rw; hw = r;
            reset = 0x0;
        } muxctrl_reg38[0:0];
    } muxctrl_reg38 @ 0x98;
    reg {
        name = "muxctrl_reg39";
        desc = "muxctrl_reg39 is a multiplexing control register for the SDIO_CDATA3 pin. muxctrl_reg39 (offset 0x09C, total reset 0x00000000; PROVEN: Hi3518E V100 data sheet, PDF page 80, section 2.3.2).";
        field {
            name = "reserved";
            desc = "Reserved";
            sw = r; hw = w;
            reset = 0x0;
        } reserved_31_1[31:1];
        field {
            name = "muxctrl_reg39";
            desc = "Multiplexing for the SDIO_CDATA3 pin.
- 0: GPIO6_7
- 1: SDIO_CDATA3";
            sw = rw; hw = r;
            reset = 0x0;
        } muxctrl_reg39[0:0];
    } muxctrl_reg39 @ 0x9c;
    reg {
        name = "muxctrl_reg40";
        desc = "muxctrl_reg40 is a multiplexing control register for the SFC_DIO pin. muxctrl_reg40 (offset 0x0A0, total reset 0x00000000; PROVEN: Hi3518E V100 data sheet, PDF page 80, section 2.3.2).";
        field {
            name = "reserved";
            desc = "Reserved";
            sw = r; hw = w;
            reset = 0x0;
        } reserved_31_1[31:1];
        field {
            name = "muxctrl_reg40";
            desc = "Multiplexing for the SFC_DIO pin.
- 0: SFC_DIO
- 1: GPIO7_0";
            sw = rw; hw = r;
            reset = 0x0;
        } muxctrl_reg40[0:0];
    } muxctrl_reg40 @ 0xa0;
    reg {
        name = "muxctrl_reg41";
        desc = "muxctrl_reg41 is a multiplexing control register for the SFC_WP_IO2 pin. muxctrl_reg41 (offset 0x0A4, total reset 0x00000000; PROVEN: Hi3518E V100 data sheet, PDF page 81, section 2.3.2).";
        field {
            name = "reserved";
            desc = "Reserved";
            sw = r; hw = w;
            reset = 0x0;
        } reserved_31_1[31:1];
        field {
            name = "muxctrl_reg41";
            desc = "Multiplexing for the SFC_WP_IO2 pin.
- 0: SFC_WP_IO2
- 1: GPIO7_1";
            sw = rw; hw = r;
            reset = 0x0;
        } muxctrl_reg41[0:0];
    } muxctrl_reg41 @ 0xa4;
    reg {
        name = "muxctrl_reg42";
        desc = "muxctrl_reg42 is a multiplexing control register for the SFC_CLK pin. muxctrl_reg42 (offset 0x0A8, total reset 0x00000000; PROVEN: Hi3518E V100 data sheet, PDF page 81, section 2.3.2).";
        field {
            name = "reserved";
            desc = "Reserved";
            sw = r; hw = w;
            reset = 0x0;
        } reserved_31_2[31:2];
        field {
            name = "muxctrl_reg42";
            desc = "Multiplexing for the SFC_CLK pin.
- 00: SFC_CLK
- 01: GPIO7_2
- 10: SFC_ADDR_MODE

Other values: reserved";
            sw = rw; hw = r;
            reset = 0x0;
        } muxctrl_reg42[1:0];
    } muxctrl_reg42 @ 0xa8;
    reg {
        name = "muxctrl_reg43";
        desc = "muxctrl_reg43 is a multiplexing control register for the SFC_DOI pin. muxctrl_reg43 (offset 0x0AC, total reset 0x00000000; PROVEN: Hi3518E V100 data sheet, PDF page 82, section 2.3.2).";
        field {
            name = "reserved";
            desc = "Reserved";
            sw = r; hw = w;
            reset = 0x0;
        } reserved_31_1[31:1];
        field {
            name = "muxctrl_reg43";
            desc = "Multiplexing for the SFC_DOI pin.
- 0: SFC_DOI
- 1: GPIO7_3";
            sw = rw; hw = r;
            reset = 0x0;
        } muxctrl_reg43[0:0];
    } muxctrl_reg43 @ 0xac;
    reg {
        name = "muxctrl_reg44";
        desc = "muxctrl_reg44 is a multiplexing control register for the SFC_HOLD_IO3 pin. muxctrl_reg44 (offset 0x0B0, total reset 0x00000000; PROVEN: Hi3518E V100 data sheet, PDF page 82, section 2.3.2).";
        field {
            name = "reserved";
            desc = "Reserved";
            sw = r; hw = w;
            reset = 0x0;
        } reserved_31_1[31:1];
        field {
            name = "muxctrl_reg44";
            desc = "Multiplexing for the SFC_HOLD_IO3 pin.
- 0: SFC_HOLD_IO3
- 1: GPIO7_4";
            sw = rw; hw = r;
            reset = 0x0;
        } muxctrl_reg44[0:0];
    } muxctrl_reg44 @ 0xb0;
    reg {
        name = "muxctrl_reg45";
        desc = "muxctrl_reg45 is a multiplexing control register for the USB_OVRCUR pin. muxctrl_reg45 (offset 0x0B4, total reset 0x00000000; PROVEN: Hi3518E V100 data sheet, PDF page 83, section 2.3.2).";
        field {
            name = "reserved";
            desc = "Reserved";
            sw = r; hw = w;
            reset = 0x0;
        } reserved_31_1[31:1];
        field {
            name = "muxctrl_reg45";
            desc = "Multiplexing for the USB_OVRCUR pin.
- 0: GPIO5_0
- 1: USB_OVRCUR";
            sw = rw; hw = r;
            reset = 0x0;
        } muxctrl_reg45[0:0];
    } muxctrl_reg45 @ 0xb4;
    reg {
        name = "muxctrl_reg46";
        desc = "muxctrl_reg46 is a multiplexing control register for the USB_PWREN pin. muxctrl_reg46 (offset 0x0B8, total reset 0x00000000; PROVEN: Hi3518E V100 data sheet, PDF page 83, section 2.3.2).";
        field {
            name = "reserved";
            desc = "Reserved";
            sw = r; hw = w;
            reset = 0x0;
        } reserved_31_1[31:1];
        field {
            name = "muxctrl_reg46";
            desc = "Multiplexing for the USB_PWREN pin.
- 0: GPIO5_1
- 1: USB_PWREN";
            sw = rw; hw = r;
            reset = 0x0;
        } muxctrl_reg46[0:0];
    } muxctrl_reg46 @ 0xb8;
    reg {
        name = "muxctrl_reg47";
        desc = "muxctrl_reg47 is a multiplexing control register for the PWM_OUT0 pin. muxctrl_reg47 (offset 0x0BC, total reset 0x00000000; PROVEN: Hi3518E V100 data sheet, PDF page 84, section 2.3.2).";
        field {
            name = "reserved";
            desc = "Reserved";
            sw = r; hw = w;
            reset = 0x0;
        } reserved_31_1[31:1];
        field {
            name = "muxctrl_reg47";
            desc = "Multiplexing for the PWM_OUT0 pin.
- 0: GPIO5_2
- 1: PWM_OUT0";
            sw = rw; hw = r;
            reset = 0x0;
        } muxctrl_reg47[0:0];
    } muxctrl_reg47 @ 0xbc;
    reg {
        name = "muxctrl_reg48";
        desc = "muxctrl_reg48 is a multiplexing control register for the PWM_OUT1 pin. muxctrl_reg48 (offset 0x0C0, total reset 0x00000000; PROVEN: Hi3518E V100 data sheet, PDF page 84, section 2.3.2).";
        field {
            name = "reserved";
            desc = "Reserved";
            sw = r; hw = w;
            reset = 0x0;
        } reserved_31_1[31:1];
        field {
            name = "muxctrl_reg48";
            desc = "Multiplexing for the PWM_OUT1 pin.
- 0: GPIO5_3
- 1: PWM_OUT1";
            sw = rw; hw = r;
            reset = 0x0;
        } muxctrl_reg48[0:0];
    } muxctrl_reg48 @ 0xc0;
    reg {
        name = "muxctrl_reg49";
        desc = "muxctrl_reg49 is a multiplexing control register for the IR_IN pin. muxctrl_reg49 (offset 0x0C4, total reset 0x00000000; PROVEN: Hi3518E V100 data sheet, PDF page 85, section 2.3.2).";
        field {
            name = "reserved";
            desc = "Reserved";
            sw = r; hw = w;
            reset = 0x0;
        } reserved_31_1[31:1];
        field {
            name = "muxctrl_reg49";
            desc = "Multiplexing for the IR_IN pin.
- 0: IR_IN
- 1: GPIO7_5";
            sw = rw; hw = r;
            reset = 0x0;
        } muxctrl_reg49[0:0];
    } muxctrl_reg49 @ 0xc4;
    reg {
        name = "muxctrl_reg50";
        desc = "muxctrl_reg50 is a multiplexing control register for the GPIO9_0 pin. muxctrl_reg50 (offset 0x0C8, total reset 0x00000000; PROVEN: Hi3518E V100 data sheet, PDF page 85, section 2.3.2).";
        field {
            name = "reserved";
            desc = "Reserved";
            sw = r; hw = w;
            reset = 0x0;
        } reserved_31_1[31:1];
        field {
            name = "muxctrl_reg50";
            desc = "Multiplexing for the GPIO9_0 pin.
- 0: reserved
- 1: GPIO9_0";
            sw = rw; hw = r;
            reset = 0x0;
        } muxctrl_reg50[0:0];
    } muxctrl_reg50 @ 0xc8;
    reg {
        name = "muxctrl_reg51";
        desc = "muxctrl_reg51 is a multiplexing control register for the GPIO9_1 pin. muxctrl_reg51 (offset 0x0CC, total reset 0x00000000; PROVEN: Hi3518E V100 data sheet, PDF page 86, section 2.3.2).";
        field {
            name = "reserved";
            desc = "Reserved";
            sw = r; hw = w;
            reset = 0x0;
        } reserved_31_1[31:1];
        field {
            name = "muxctrl_reg51";
            desc = "Multiplexing for the GPIO9_1 pin.
- 0: reserved
- 1: GPIO9_1";
            sw = rw; hw = r;
            reset = 0x0;
        } muxctrl_reg51[0:0];
    } muxctrl_reg51 @ 0xcc;
    reg {
        name = "muxctrl_reg52";
        desc = "muxctrl_reg52 is a multiplexing control register for the GPIO9_2 pin. muxctrl_reg52 (offset 0x0D0, total reset 0x00000000; PROVEN: Hi3518E V100 data sheet, PDF page 86, section 2.3.2).";
        field {
            name = "reserved";
            desc = "Reserved";
            sw = r; hw = w;
            reset = 0x0;
        } reserved_31_1[31:1];
        field {
            name = "muxctrl_reg52";
            desc = "Multiplexing for the GPIO9_2 pin.
- 0: reserved
- 1: GPIO9_2";
            sw = rw; hw = r;
            reset = 0x0;
        } muxctrl_reg52[0:0];
    } muxctrl_reg52 @ 0xd0;
    reg {
        name = "muxctrl_reg53";
        desc = "muxctrl_reg53 is a multiplexing control register for the GPIO9_3 pin. muxctrl_reg53 (offset 0x0D4, total reset 0x00000000; PROVEN: Hi3518E V100 data sheet, PDF page 87, section 2.3.2).";
        field {
            name = "reserved";
            desc = "Reserved";
            sw = r; hw = w;
            reset = 0x0;
        } reserved_31_1[31:1];
        field {
            name = "muxctrl_reg53";
            desc = "Multiplexing for the GPIO9_3 pin.
- 0: reserved
- 1: GPIO9_3";
            sw = rw; hw = r;
            reset = 0x0;
        } muxctrl_reg53[0:0];
    } muxctrl_reg53 @ 0xd4;
    reg {
        name = "muxctrl_reg54";
        desc = "muxctrl_reg54 is a multiplexing control register for the GPIO9_4 pin. muxctrl_reg54 (offset 0x0D8, total reset 0x00000000; PROVEN: Hi3518E V100 data sheet, PDF page 87, section 2.3.2).";
        field {
            name = "reserved";
            desc = "Reserved";
            sw = r; hw = w;
            reset = 0x0;
        } reserved_31_1[31:1];
        field {
            name = "muxctrl_reg54";
            desc = "Multiplexing for the GPIO9_4 pin.
- 0: reserved
- 1: GPIO9_4";
            sw = rw; hw = r;
            reset = 0x0;
        } muxctrl_reg54[0:0];
    } muxctrl_reg54 @ 0xd8;
    reg {
        name = "muxctrl_reg55";
        desc = "muxctrl_reg55 is a multiplexing control register for the GPIO9_5 pin. muxctrl_reg55 (offset 0x0DC, total reset 0x00000000; PROVEN: Hi3518E V100 data sheet, PDF page 88, section 2.3.2).";
        field {
            name = "reserved";
            desc = "Reserved";
            sw = r; hw = w;
            reset = 0x0;
        } reserved_31_1[31:1];
        field {
            name = "muxctrl_reg55";
            desc = "Multiplexing for the GPIO9_5 pin.
- 0: reserved
- 1: GPIO9_5";
            sw = rw; hw = r;
            reset = 0x0;
        } muxctrl_reg55[0:0];
    } muxctrl_reg55 @ 0xdc;
    reg {
        name = "muxctrl_reg56";
        desc = "muxctrl_reg56 is a multiplexing control register for the GPIO9_6 pin. muxctrl_reg56 (offset 0x0E0, total reset 0x00000000; PROVEN: Hi3518E V100 data sheet, PDF page 88, section 2.3.2).";
        field {
            name = "reserved";
            desc = "Reserved";
            sw = r; hw = w;
            reset = 0x0;
        } reserved_31_1[31:1];
        field {
            name = "muxctrl_reg56";
            desc = "Multiplexing for the GPIO9_6 pin.
- 0: reserved
- 1: GPIO9_6";
            sw = rw; hw = r;
            reset = 0x0;
        } muxctrl_reg56[0:0];
    } muxctrl_reg56 @ 0xe0;
    reg {
        name = "muxctrl_reg57";
        desc = "muxctrl_reg57 is a multiplexing control register for the GPIO9_7 pin. muxctrl_reg57 (offset 0x0E4, total reset 0x00000000; PROVEN: Hi3518E V100 data sheet, PDF page 89, section 2.3.2).";
        field {
            name = "reserved";
            desc = "Reserved";
            sw = r; hw = w;
            reset = 0x0;
        } reserved_31_1[31:1];
        field {
            name = "muxctrl_reg57";
            desc = "Multiplexing for the GPIO9_7 pin.
- 0: reserved
- 1: GPIO9_7";
            sw = rw; hw = r;
            reset = 0x0;
        } muxctrl_reg57[0:0];
    } muxctrl_reg57 @ 0xe4;
    reg {
        name = "muxctrl_reg66";
        desc = "muxctrl_reg66 is a multiplexing control register for the UART2_RXD pin. muxctrl_reg66 (offset 0x108, total reset 0x00000000; PROVEN: Hi3518E V100 data sheet, PDF page 89, section 2.3.2).";
        field {
            name = "reserved";
            desc = "Reserved";
            sw = r; hw = w;
            reset = 0x0;
        } reserved_31_1[31:1];
        field {
            name = "muxctrl_reg66";
            desc = "Multiplexing for the UART2_RXD pin.
- 0: GPIO7_6
- 1: UART2_RXD";
            sw = rw; hw = r;
            reset = 0x0;
        } muxctrl_reg66[0:0];
    } muxctrl_reg66 @ 0x108;
    reg {
        name = "muxctrl_reg67";
        desc = "muxctrl_reg67 is a multiplexing control register for the UART2_TXD pin. muxctrl_reg67 (offset 0x10C, total reset 0x00000000; PROVEN: Hi3518E V100 data sheet, PDF page 90, section 2.3.2).";
        field {
            name = "reserved";
            desc = "Reserved";
            sw = r; hw = w;
            reset = 0x0;
        } reserved_31_1[31:1];
        field {
            name = "muxctrl_reg67";
            desc = "Multiplexing for the UART2_TXD pin.
- 0: GPIO7_7
- 1: UART2_TXD";
            sw = rw; hw = r;
            reset = 0x0;
        } muxctrl_reg67[0:0];
    } muxctrl_reg67 @ 0x10c;
    reg {
        name = "muxctrl_reg68";
        desc = "muxctrl_reg68 is a multiplexing control register for the SPI1_SCLK pin. muxctrl_reg68 (offset 0x110, total reset 0x00000000; PROVEN: Hi3518E V100 data sheet, PDF page 90, section 2.3.2).";
        field {
            name = "reserved";
            desc = "Reserved";
            sw = r; hw = w;
            reset = 0x0;
        } reserved_31_1[31:1];
        field {
            name = "muxctrl_reg68";
            desc = "Multiplexing for the SPI1_SCLK pin.
- 0: GPIO5_4
- 1: SPI1_SCLK";
            sw = rw; hw = r;
            reset = 0x0;
        } muxctrl_reg68[0:0];
    } muxctrl_reg68 @ 0x110;
    reg {
        name = "muxctrl_reg69";
        desc = "muxctrl_reg69 is a multiplexing control register for the SPI1_SDO pin. muxctrl_reg69 (offset 0x114, total reset 0x00000000; PROVEN: Hi3518E V100 data sheet, PDF page 91, section 2.3.2).";
        field {
            name = "reserved";
            desc = "Reserved";
            sw = r; hw = w;
            reset = 0x0;
        } reserved_31_1[31:1];
        field {
            name = "muxctrl_reg69";
            desc = "Multiplexing for the SPI1_SDO pin.
- 0: GPIO5_5
- 1: SPI1_SDO";
            sw = rw; hw = r;
            reset = 0x0;
        } muxctrl_reg69[0:0];
    } muxctrl_reg69 @ 0x114;
    reg {
        name = "muxctrl_reg70";
        desc = "muxctrl_reg70 is a multiplexing control register for the SPI1_SDI pin. muxctrl_reg70 (offset 0x118, total reset 0x00000000; PROVEN: Hi3518E V100 data sheet, PDF page 91, section 2.3.2).";
        field {
            name = "reserved";
            desc = "Reserved";
            sw = r; hw = w;
            reset = 0x0;
        } reserved_31_1[31:1];
        field {
            name = "muxctrl_reg70";
            desc = "Multiplexing for the SPI1_SDI pin.
- 0: GPIO5_6
- 1: SPI1_SDI";
            sw = rw; hw = r;
            reset = 0x0;
        } muxctrl_reg70[0:0];
    } muxctrl_reg70 @ 0x118;
    reg {
        name = "muxctrl_reg71";
        desc = "muxctrl_reg71 is a multiplexing control register for the SPI1_CSN pin. muxctrl_reg71 (offset 0x11C, total reset 0x00000000; PROVEN: Hi3518E V100 data sheet, PDF page 92, section 2.3.2).";
        field {
            name = "reserved";
            desc = "Reserved";
            sw = r; hw = w;
            reset = 0x0;
        } reserved_31_1[31:1];
        field {
            name = "muxctrl_reg71";
            desc = "Multiplexing for the SPI1_CSN pin.
- 0: GPIO5_7
- 1: SPI1_CSN";
            sw = rw; hw = r;
            reset = 0x0;
        } muxctrl_reg71[0:0];
    } muxctrl_reg71 @ 0x11c;
    reg {
        name = "muxctrl_reg72";
        desc = "muxctrl_reg72 is a multiplexing control register for the JTAG_TRSTN pin. muxctrl_reg72 (offset 0x120, total reset 0x00000000; PROVEN: Hi3518E V100 data sheet, PDF page 92, section 2.3.2).";
        field {
            name = "reserved";
            desc = "Reserved";
            sw = r; hw = w;
            reset = 0x0;
        } reserved_31_2[31:2];
        field {
            name = "muxctrl_reg72";
            desc = "Multiplexing for the JTAG_TRSTN pin.
- 00: GPIO0_0
- 01: JTAG_TRSTN
- 10: TEMPER_DQ

Other values: reserved";
            sw = rw; hw = r;
            reset = 0x0;
        } muxctrl_reg72[1:0];
    } muxctrl_reg72 @ 0x120;
    reg {
        name = "muxctrl_reg73";
        desc = "muxctrl_reg73 is a multiplexing control register for the JTAG_TCK pin. muxctrl_reg73 (offset 0x124, total reset 0x00000000; PROVEN: Hi3518E V100 data sheet, PDF page 93, section 2.3.2).";
        field {
            name = "reserved";
            desc = "Reserved";
            sw = r; hw = w;
            reset = 0x0;
        } reserved_31_2[31:2];
        field {
            name = "muxctrl_reg73";
            desc = "Multiplexing for the JTAG_TCK pin.
- 00: GPIO0_1
- 01: JTAG_TCK
- 10: TEMPER_DQ

Other values: reserved";
            sw = rw; hw = r;
            reset = 0x0;
        } muxctrl_reg73[1:0];
    } muxctrl_reg73 @ 0x124;
    reg {
        name = "muxctrl_reg74";
        desc = "muxctrl_reg74 is a multiplexing control register for the JTAG_TMS pin. muxctrl_reg74 (offset 0x128, total reset 0x00000000; PROVEN: Hi3518E V100 data sheet, PDF page 94, section 2.3.2).";
        field {
            name = "reserved";
            desc = "Reserved";
            sw = r; hw = w;
            reset = 0x0;
        } reserved_31_2[31:2];
        field {
            name = "muxctrl_reg74";
            desc = "Multiplexing for the JTAG_TMS pin.
- 00: GPIO0_2
- 01: JTAG_TMS
- 10: TEMPER_DQ

Other values: reserved";
            sw = rw; hw = r;
            reset = 0x0;
        } muxctrl_reg74[1:0];
    } muxctrl_reg74 @ 0x128;
    reg {
        name = "muxctrl_reg75";
        desc = "muxctrl_reg75 is a multiplexing control register for the JTAG_TDO pin. muxctrl_reg75 (offset 0x12C, total reset 0x00000000; PROVEN: Hi3518E V100 data sheet, PDF page 94, section 2.3.2).";
        field {
            name = "reserved";
            desc = "Reserved";
            sw = r; hw = w;
            reset = 0x0;
        } reserved_31_2[31:2];
        field {
            name = "muxctrl_reg75";
            desc = "Multiplexing for the JTAG_TDO pin.
- 00: GPIO0_3
- 01: JTAG_TDO
- 10: TEMPER_DQ

Other values: reserved";
            sw = rw; hw = r;
            reset = 0x0;
        } muxctrl_reg75[1:0];
    } muxctrl_reg75 @ 0x12c;
    reg {
        name = "muxctrl_reg76";
        desc = "muxctrl_reg76 is a multiplexing control register for the JTAG_TDI pin. muxctrl_reg76 (offset 0x130, total reset 0x00000000; PROVEN: Hi3518E V100 data sheet, PDF page 95, section 2.3.2).";
        field {
            name = "reserved";
            desc = "Reserved";
            sw = r; hw = w;
            reset = 0x0;
        } reserved_31_2[31:2];
        field {
            name = "muxctrl_reg76";
            desc = "Multiplexing for the JTAG_TDI pin.
- 00: GPIO0_4
- 01: JTAG_TDI
- 10: TEMPER_DQ

Other values: reserved";
            sw = rw; hw = r;
            reset = 0x0;
        } muxctrl_reg76[1:0];
    } muxctrl_reg76 @ 0x130;
    reg {
        name = "muxctrl_reg77";
        desc = "muxctrl_reg77 is a multiplexing control register for the GPIO0_5 pin. muxctrl_reg77 (offset 0x134, total reset 0x00000000; PROVEN: Hi3518E V100 data sheet, PDF page 95, section 2.3.2).";
        field {
            name = "reserved";
            desc = "Reserved";
            sw = r; hw = w;
            reset = 0x0;
        } reserved_31_2[31:2];
        field {
            name = "muxctrl_reg77";
            desc = "Multiplexing for the GPIO0_5 pin.
- 00: SVB_PWM
- 01: GPIO0_5
- 10: TEMPER_DQ

Other values: reserved";
            sw = rw; hw = r;
            reset = 0x0;
        } muxctrl_reg77[1:0];
    } muxctrl_reg77 @ 0x134;
    reg {
        name = "muxctrl_reg78";
        desc = "muxctrl_reg78 is a multiplexing control register for the GPIO0_6 pin. muxctrl_reg78 (offset 0x138, total reset 0x00000000; PROVEN: Hi3518E V100 data sheet, PDF page 96, section 2.3.2).";
        field {
            name = "reserved";
            desc = "Reserved";
            sw = r; hw = w;
            reset = 0x0;
        } reserved_31_2[31:2];
        field {
            name = "muxctrl_reg78";
            desc = "Multiplexing for the GPIO0_6 pin.
- 00: GPIO0_6
- 01: SVB_PWM
- 10: TEMPER_DQ

Other values: reserved";
            sw = rw; hw = r;
            reset = 0x0;
        } muxctrl_reg78[1:0];
    } muxctrl_reg78 @ 0x138;
    reg {
        name = "muxctrl_reg79";
        desc = "muxctrl_reg79 is a multiplexing control register for the GPIO0_7 pin. muxctrl_reg79 (offset 0x13C, total reset 0x00000000; PROVEN: Hi3518E V100 data sheet, PDF page 96, section 2.3.2).";
        field {
            name = "reserved";
            desc = "Reserved";
            sw = r; hw = w;
            reset = 0x0;
        } reserved_31_2[31:2];
        field {
            name = "muxctrl_reg79";
            desc = "Multiplexing for the GPIO0_7 pin.
- 00: SYS_RSTN_OUT
- 01: GPIO0_7
- 10: TEMPER_DQ

Other values: reserved";
            sw = rw; hw = r;
            reset = 0x0;
        } muxctrl_reg79[1:0];
    } muxctrl_reg79 @ 0x13c;
    reg {
        name = "muxctrl_reg80";
        desc = "muxctrl_reg80 is a multiplexing control register for the VIU_CLK pin. muxctrl_reg80 (offset 0x140, total reset 0x00000000; PROVEN: Hi3518E V100 data sheet, PDF page 97, section 2.3.2).";
        field {
            name = "reserved";
            desc = "Reserved";
            sw = r; hw = w;
            reset = 0x0;
        } reserved_31_1[31:1];
        field {
            name = "muxctrl_reg80";
            desc = "Multiplexing for the VIU_CLK pin.
- 0: VIU_CLK
- 1: GPIO11_6";
            sw = rw; hw = r;
            reset = 0x0;
        } muxctrl_reg80[0:0];
    } muxctrl_reg80 @ 0x140;
    reg {
        name = "muxctrl_reg81";
        desc = "muxctrl_reg81 is a multiplexing control register for the VIU_VS pin. muxctrl_reg81 (offset 0x144, total reset 0x00000000; PROVEN: Hi3518E V100 data sheet, PDF page 97, section 2.3.2).";
        field {
            name = "reserved";
            desc = "Reserved";
            sw = r; hw = w;
            reset = 0x0;
        } reserved_31_1[31:1];
        field {
            name = "muxctrl_reg81";
            desc = "Multiplexing for the VIU_VS pin.
- 0: VIU_VS
- 1: GPIO11_5";
            sw = rw; hw = r;
            reset = 0x0;
        } muxctrl_reg81[0:0];
    } muxctrl_reg81 @ 0x144;
    reg {
        name = "muxctrl_reg82";
        desc = "muxctrl_reg82 is a multiplexing control register for the VIU_HS pin. muxctrl_reg82 (offset 0x148, total reset 0x00000000; PROVEN: Hi3518E V100 data sheet, PDF page 98, section 2.3.2).";
        field {
            name = "reserved";
            desc = "Reserved";
            sw = r; hw = w;
            reset = 0x0;
        } reserved_31_1[31:1];
        field {
            name = "muxctrl_reg82";
            desc = "Multiplexing for the VIU_HS pin.
- 0: VIU_HS
- 1: GPIO11_4";
            sw = rw; hw = r;
            reset = 0x0;
        } muxctrl_reg82[0:0];
    } muxctrl_reg82 @ 0x148;
    reg {
        name = "muxctrl_reg83";
        desc = "muxctrl_reg83 is a multiplexing control register for the VIU_DAT11 pin. muxctrl_reg83 (offset 0x14C, total reset 0x00000000; PROVEN: Hi3518E V100 data sheet, PDF page 98, section 2.3.2).";
        field {
            name = "reserved";
            desc = "Reserved";
            sw = r; hw = w;
            reset = 0x0;
        } reserved_31_1[31:1];
        field {
            name = "muxctrl_reg83";
            desc = "Multiplexing for the VIU_DAT11 pin.
- 0: VIU_DAT11
- 1: GPIO11_3";
            sw = rw; hw = r;
            reset = 0x0;
        } muxctrl_reg83[0:0];
    } muxctrl_reg83 @ 0x14c;
    reg {
        name = "muxctrl_reg84";
        desc = "muxctrl_reg84 is a multiplexing control register for the VIU_DAT10 pin. muxctrl_reg84 (offset 0x150, total reset 0x00000000; PROVEN: Hi3518E V100 data sheet, PDF page 99, section 2.3.2).";
        field {
            name = "reserved";
            desc = "Reserved";
            sw = r; hw = w;
            reset = 0x0;
        } reserved_31_1[31:1];
        field {
            name = "muxctrl_reg84";
            desc = "Multiplexing for the VIU_DAT10 pin.
- 0: VIU_DAT10
- 1: GPIO11_2";
            sw = rw; hw = r;
            reset = 0x0;
        } muxctrl_reg84[0:0];
    } muxctrl_reg84 @ 0x150;
    reg {
        name = "muxctrl_reg85";
        desc = "muxctrl_reg85 is a multiplexing control register for the VIU_DAT9 pin. muxctrl_reg85 (offset 0x154, total reset 0x00000000; PROVEN: Hi3518E V100 data sheet, PDF page 99, section 2.3.2).";
        field {
            name = "reserved";
            desc = "Reserved";
            sw = r; hw = w;
            reset = 0x0;
        } reserved_31_1[31:1];
        field {
            name = "muxctrl_reg85";
            desc = "Multiplexing for the VIU_DAT9 pin.
- 0: VIU_DAT9
- 1: GPIO11_1";
            sw = rw; hw = r;
            reset = 0x0;
        } muxctrl_reg85[0:0];
    } muxctrl_reg85 @ 0x154;
    reg {
        name = "muxctrl_reg86";
        desc = "muxctrl_reg86 is a multiplexing control register for the VIU_DAT8 pin. muxctrl_reg86 (offset 0x158, total reset 0x00000000; PROVEN: Hi3518E V100 data sheet, PDF page 100, section 2.3.2).";
        field {
            name = "reserved";
            desc = "Reserved";
            sw = r; hw = w;
            reset = 0x0;
        } reserved_31_1[31:1];
        field {
            name = "muxctrl_reg86";
            desc = "Multiplexing for the VIU_DAT8 pin.
- 0: VIU_DAT8
- 1: GPIO11_0";
            sw = rw; hw = r;
            reset = 0x0;
        } muxctrl_reg86[0:0];
    } muxctrl_reg86 @ 0x158;
    reg {
        name = "muxctrl_reg87";
        desc = "muxctrl_reg87 is a multiplexing control register for the VIU_DAT7 pin. muxctrl_reg87 (offset 0x15C, total reset 0x00000000; PROVEN: Hi3518E V100 data sheet, PDF page 100, section 2.3.2).";
        field {
            name = "reserved";
            desc = "Reserved";
            sw = r; hw = w;
            reset = 0x0;
        } reserved_31_1[31:1];
        field {
            name = "muxctrl_reg87";
            desc = "Multiplexing for the VIU_DAT7 pin.
- 0: VIU_DAT7
- 1: GPIO10_7";
            sw = rw; hw = r;
            reset = 0x0;
        } muxctrl_reg87[0:0];
    } muxctrl_reg87 @ 0x15c;
    reg {
        name = "muxctrl_reg88";
        desc = "muxctrl_reg88 is a multiplexing control register for the VIU_DAT6 pin. muxctrl_reg88 (offset 0x160, total reset 0x00000000; PROVEN: Hi3518E V100 data sheet, PDF page 101, section 2.3.2).";
        field {
            name = "reserved";
            desc = "Reserved";
            sw = r; hw = w;
            reset = 0x0;
        } reserved_31_1[31:1];
        field {
            name = "muxctrl_reg88";
            desc = "Multiplexing for the VIU_DAT6 pin.
- 0: VIU_DAT6
- 1: GPIO10_6";
            sw = rw; hw = r;
            reset = 0x0;
        } muxctrl_reg88[0:0];
    } muxctrl_reg88 @ 0x160;
    reg {
        name = "muxctrl_reg89";
        desc = "muxctrl_reg89 is a multiplexing control register for the VIU_DAT5 pin. muxctrl_reg89 (offset 0x164, total reset 0x00000000; PROVEN: Hi3518E V100 data sheet, PDF page 101, section 2.3.2).";
        field {
            name = "reserved";
            desc = "Reserved";
            sw = r; hw = w;
            reset = 0x0;
        } reserved_31_1[31:1];
        field {
            name = "muxctrl_reg89";
            desc = "Multiplexing for the VIU_DAT5 pin.
- 0: VIU_DAT5
- 1: GPIO10_5";
            sw = rw; hw = r;
            reset = 0x0;
        } muxctrl_reg89[0:0];
    } muxctrl_reg89 @ 0x164;
    reg {
        name = "muxctrl_reg90";
        desc = "muxctrl_reg90 is a multiplexing control register for the VIU_DAT4 pin. muxctrl_reg90 (offset 0x168, total reset 0x00000000; PROVEN: Hi3518E V100 data sheet, PDF page 102, section 2.3.2).";
        field {
            name = "reserved";
            desc = "Reserved";
            sw = r; hw = w;
            reset = 0x0;
        } reserved_31_1[31:1];
        field {
            name = "muxctrl_reg90";
            desc = "Multiplexing for the VIU_DAT4 pin.
- 0: VIU_DAT4
- 1: GPIO10_4";
            sw = rw; hw = r;
            reset = 0x0;
        } muxctrl_reg90[0:0];
    } muxctrl_reg90 @ 0x168;
    reg {
        name = "muxctrl_reg91";
        desc = "muxctrl_reg91 is a multiplexing control register for the VIU_DAT3 pin. muxctrl_reg91 (offset 0x16C, total reset 0x00000000; PROVEN: Hi3518E V100 data sheet, PDF page 102, section 2.3.2).";
        field {
            name = "reserved";
            desc = "Reserved";
            sw = r; hw = w;
            reset = 0x0;
        } reserved_31_1[31:1];
        field {
            name = "muxctrl_reg91";
            desc = "Multiplexing for the VIU_DAT3 pin.
- 0: VIU_DAT3
- 1: GPIO10_3";
            sw = rw; hw = r;
            reset = 0x0;
        } muxctrl_reg91[0:0];
    } muxctrl_reg91 @ 0x16c;
    reg {
        name = "muxctrl_reg92";
        desc = "muxctrl_reg92 is a multiplexing control register for the VIU_DAT2 pin. muxctrl_reg92 (offset 0x170, total reset 0x00000000; PROVEN: Hi3518E V100 data sheet, PDF page 103, section 2.3.2).";
        field {
            name = "reserved";
            desc = "Reserved";
            sw = r; hw = w;
            reset = 0x0;
        } reserved_31_1[31:1];
        field {
            name = "muxctrl_reg92";
            desc = "Multiplexing for the VIU_DAT2 pin.
- 0: VIU_DAT2
- 1: GPIO10_2";
            sw = rw; hw = r;
            reset = 0x0;
        } muxctrl_reg92[0:0];
    } muxctrl_reg92 @ 0x170;
    reg {
        name = "muxctrl_reg93";
        desc = "muxctrl_reg93 is a multiplexing control register for the VIU_DAT1 pin. muxctrl_reg93 (offset 0x174, total reset 0x00000000; PROVEN: Hi3518E V100 data sheet, PDF page 103, section 2.3.2).";
        field {
            name = "reserved";
            desc = "Reserved";
            sw = r; hw = w;
            reset = 0x0;
        } reserved_31_1[31:1];
        field {
            name = "muxctrl_reg93";
            desc = "Multiplexing for the VIU_DAT1 pin.
- 0: VIU_DAT1
- 1: GPIO10_1";
            sw = rw; hw = r;
            reset = 0x0;
        } muxctrl_reg93[0:0];
    } muxctrl_reg93 @ 0x174;
    reg {
        name = "muxctrl_reg94";
        desc = "muxctrl_reg94 is a multiplexing control register for the VIU_DAT0 pin. muxctrl_reg94 (offset 0x178, total reset 0x00000000; PROVEN: Hi3518E V100 data sheet, PDF page 104, section 2.3.2).";
        field {
            name = "reserved";
            desc = "Reserved";
            sw = r; hw = w;
            reset = 0x0;
        } reserved_31_1[31:1];
        field {
            name = "muxctrl_reg94";
            desc = "Multiplexing for the VIU_DAT0 pin.
- 0: VIU_DAT0
- 1: GPIO10_0";
            sw = rw; hw = r;
            reset = 0x0;
        } muxctrl_reg94[0:0];
    } muxctrl_reg94 @ 0x178;
};

`endif
