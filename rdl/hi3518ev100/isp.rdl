`ifndef EHI3518EV100_ISP_RDL
`define EHI3518EV100_ISP_RDL
regfile eHI3518EV100_ISP {
    name = "Image signal processor (ISP)";
    desc = "Image signal processor (ISP). 164 registers extracted programmatically from the Hi3518E 720p IP Camera SoC data sheet (Issue 03, 2015-11-26); chapter 11.4, table 11-1. Field names, bit ranges, access types and reset values are taken from the register tables; reset values are the data sheet total reset values split onto the fields (per-field values where the table has them). Label: PROVEN. Hardware not verified here (no board).";
    reg {
        name = "ACTIVE_WIDTH";
        desc = "ACTIVE_WIDTH is a picture width register. ACTIVE_WIDTH (offset 0x0010, total reset 0x0000_0000; PROVEN: Hi3518E V100 data sheet, PDF page 754, section 11.4).";
        field {
            name = "reserved";
            desc = "Reserved.";
            sw = rw; hw = r;
            reset = 0x0;
        } reserved_31_16[31:16];
        field {
            name = "ActiveWidth";
            desc = "Active video width (in pixel).";
            sw = rw; hw = r;
            reset = 0x0;
        } ActiveWidth[15:0];
    } ACTIVE_WIDTH @ 0x10;
    reg {
        name = "ACTIVE_HEIGHT";
        desc = "ACTIVE_HEIGHT is a picture height register. ACTIVE_HEIGHT (offset 0x0014, total reset 0x0000_0000; PROVEN: Hi3518E V100 data sheet, PDF page 754, section 11.4).";
        field {
            name = "reserved";
            desc = "Reserved.";
            sw = rw; hw = r;
            reset = 0x0;
        } reserved_31_16[31:16];
        field {
            name = "ActiveHeight";
            desc = "Active video height (in line).";
            sw = rw; hw = r;
            reset = 0x0;
        } ActiveHeight[15:0];
    } ACTIVE_HEIGHT @ 0x14;
    reg {
        name = "RGGB_START";
        desc = "RGGB_START is an RGGB mode register. RGGB_START (offset 0x0018, total reset 0x0000_0000; PROVEN: Hi3518E V100 data sheet, PDF page 754, section 11.4).";
        field {
            name = "reserved";
            desc = "Reserved.";
            sw = rw; hw = r;
            reset = 0x0;
        } reserved_31_2[31:2];
        field {
            name = "RGGBstart";
            desc = "Start color of the RGGB pattern.
- 00: R Gr Gb B
- 01: Gr R B Gb
- 10: Gb B R Gr
- 11: B Gb";
            sw = rw; hw = r;
            reset = 0x0;
        } RGGBstart[1:0];
    } RGGB_START @ 0x18;
    reg {
        name = "CONFIG_BUFFER_MODE";
        desc = "CONFIG_BUFFER_MODE is an update mode configuration register. CONFIG_BUFFER_MODE (offset 0x0030, total reset 0x0000_0000; PROVEN: Hi3518E V100 data sheet, PDF page 755, section 11.4).";
        field {
            name = "reserved";
            desc = "Reserved.";
            sw = rw; hw = r;
            reset = 0x0;
        } reserved_31_2[31:2];
        field {
            name = "ConfigBufferMode";
            desc = "Double-buffer mode select.
- 00: disabled (configuration are updated immediately)
- 01: blocked (configuration are not updated)
- 10: local (module configurations are updated during local vertical blanking)
- 11: global (all module configurations are updated during ISP vertical blanking)";
            sw = rw; hw = r;
            reset = 0x0;
        } ConfigBufferMode[1:0];
    } CONFIG_BUFFER_MODE @ 0x30;
    reg {
        name = "BYPASS";
        desc = "BYPASS is a bypass register. BYPASS (offset 0x0040, total reset 0x0000_0000; PROVEN: Hi3518E V100 data sheet, PDF page 756, section 11.4).";
        field {
            name = "reserved";
            desc = "Reserved.";
            sw = rw; hw = r;
            reset = 0x0;
        } reserved_31_27[31:27];
        field {
            name = "ISPfullbypassenable";
            desc = "Output is connected directly to input.";
            sw = rw; hw = r;
            reset = 0x0;
        } ISPfullbypassenable[26:26];
        field {
            name = "ISPprocessingbypassmode";
            desc = "- 00: full processing
- 01: bypass entire ISP processing (video input and output ports are still connected) and output raw sensor data
- 10: bypass entire ISP processing (video input and output ports are still connected) and output raw sensor data in most significant bits of channels 1 and 2
- 11: connect output to ground";
            sw = rw; hw = r;
            reset = 0x0;
        } ISPprocessingbypassmode[25:24];
        field {
            name = "reserved";
            desc = "Reserved.";
            sw = rw; hw = r;
            reset = 0x0;
        } reserved_23_19[23:19];
        field {
            name = "reserved";
            desc = "Reserved.";
            sw = rw; hw = r;
            reset = 0x0;
        } reserved_18_18[18:18];
        field {
            name = "reserved";
            desc = "Reserved.";
            sw = rw; hw = r;
            reset = 0x0;
        } reserved_17_15[17:15];
        field {
            name = "Bypassgamma";
            desc = "Bypass gamma table.";
            sw = rw; hw = r;
            reset = 0x0;
        } Bypassgamma[14:14];
        field {
            name = "Bypasscolor";
            desc = "Bypass color matrix.";
            sw = rw; hw = r;
            reset = 0x0;
        } Bypasscolor[13:13];
        field {
            name = "Bypassdemosaic";
            desc = "Bypass demosaic module (output raw data).";
            sw = rw; hw = r;
            reset = 0x0;
        } Bypassdemosaic[12:12];
        field {
            name = "BypassDRC";
            desc = "Bypass DRC.";
            sw = rw; hw = r;
            reset = 0x0;
        } BypassDRC[11:11];
        field {
            name = "reserved";
            desc = "Reserved.";
            sw = rw; hw = r;
            reset = 0x0;
        } reserved_10_10[10:10];
        field {
            name = "Bypassradial";
            desc = "Bypass shading.";
            sw = rw; hw = r;
            reset = 0x0;
        } Bypassradial[9:9];
        field {
            name = "reserved";
            desc = "Reserved.";
            sw = rw; hw = r;
            reset = 0x0;
        } reserved_8_7[8:7];
        field {
            name = "Bypassgain";
            desc = "Bypass black level/gain.";
            sw = rw; hw = r;
            reset = 0x0;
        } Bypassgain[6:6];
        field {
            name = "Bypassdenoise";
            desc = "Bypass denoise.";
            sw = rw; hw = r;
            reset = 0x0;
        } Bypassdenoise[5:5];
        field {
            name = "Bypassdefectpixel";
            desc = "Bypass defect pixel.";
            sw = rw; hw = r;
            reset = 0x0;
        } Bypassdefectpixel[4:4];
        field {
            name = "Bypassgreenequalize";
            desc = "Bypass green equalization.";
            sw = rw; hw = r;
            reset = 0x0;
        } Bypassgreenequalize[3:3];
        field {
            name = "Bypassgammafe";
            desc = "Bypass WDR compression front-end lookup.";
            sw = rw; hw = r;
            reset = 0x0;
        } Bypassgammafe[2:2];
        field {
            name = "Bypassbalancefe";
            desc = "Bypass front-end black level adjustment.";
            sw = rw; hw = r;
            reset = 0x0;
        } Bypassbalancefe[1:1];
        field {
            name = "Bypassvideotestgen";
            desc = "Bypass video test generator.";
            sw = rw; hw = r;
            reset = 0x0;
        } Bypassvideotestgen[0:0];
    } BYPASS @ 0x40;
    reg {
        name = "AE_SWITCH";
        desc = "AE_SWITCH is an AE region statistics position control register. AE_SWITCH (offset 0x0044, total reset 0x0000_0000; PROVEN: Hi3518E V100 data sheet, PDF page 757, section 11.4).";
        field {
            name = "reserved";
            desc = "Reserved.";
            sw = rw; hw = r;
            reset = 0x0;
        } reserved_31_2[31:2];
        field {
            name = "AEswitch";
            desc = "AE tap in the pipeline.
- 00: after static WB
- 01: immediately from sensor (for WDR compression modes)
- 10: after shading
- 11: after front-end LUT (for WDR compression modes)";
            sw = rw; hw = r;
            reset = 0x0;
        } AEswitch[1:0];
    } AE_SWITCH @ 0x44;
    reg {
        name = "AWB_SWITCH";
        desc = "AWB_SWITCH is an AWB statistics position control register. AWB_SWITCH (offset 0x0048, total reset 0x0000_0000; PROVEN: Hi3518E V100 data sheet, PDF page 758, section 11.4).";
        field {
            name = "reserved";
            desc = "Reserved.";
            sw = rw; hw = r;
            reset = 0x0;
        } reserved_31_1[31:1];
        field {
            name = "AWBswitch";
            desc = "AWB tap in the pipeline.
- 0: immediately before color matrix
- 1: immediately after color matrix (for sensors with strong color channel crosstalk)";
            sw = rw; hw = r;
            reset = 0x0;
        } AWBswitch[0:0];
    } AWB_SWITCH @ 0x48;
    reg {
        name = "AF_SWITCH";
        desc = "AF_SWITCH is an AF statistics position control register. AF_SWITCH (offset 0x004C, total reset 0x0000_0000; PROVEN: Hi3518E V100 data sheet, PDF page 759, section 11.4).";
        field {
            name = "reserved";
            desc = "Reserved.";
            sw = rw; hw = r;
            reset = 0x0;
        } reserved_31_1[31:1];
        field {
            name = "AFswitch";
            desc = "AF tap in the pipeline.
- 0: enabled
- 1: disabled";
            sw = rw; hw = r;
            reset = 0x0;
        } AFswitch[0:0];
    } AF_SWITCH @ 0x4c;
    reg {
        name = "DIS_SWITCH";
        desc = "DIS_SWITCH is a DIS statistics position control register. DIS_SWITCH (offset 0x0050, total reset 0x0000_0000; PROVEN: Hi3518E V100 data sheet, PDF page 759, section 11.4).";
        field {
            name = "reserved";
            desc = "Reserved.";
            sw = rw; hw = r;
            reset = 0x0;
        } reserved_31_2[31:2];
        field {
            name = "DISswitch";
            desc = "DIS tap in the pipeline.
- 00: end of pipeline
- 01: after DRC
- 10: after defect pixel
- 11: switched off";
            sw = rw; hw = r;
            reset = 0x0;
        } DISswitch[1:0];
    } DIS_SWITCH @ 0x50;
    reg {
        name = "HISTOGRAM_SWITCH";
        desc = "HISTOGRAM_SWITCH is an AE global statistics position control register. HISTOGRAM_SWITCH (offset 0x0054, total reset 0x0000_0000; PROVEN: Hi3518E V100 data sheet, PDF page 760, section 11.4).";
        field {
            name = "reserved";
            desc = "Reserved.";
            sw = rw; hw = r;
            reset = 0x0;
        } reserved_31_2[31:2];
        field {
            name = "Histogramswitch";
            desc = "AE tap in the pipeline.
- 00: same as AE
- 01: immediately from sensor (for WDR compression modes)
- 10: after shading
- 11: after front-end LUT (for WDR compression modes)";
            sw = rw; hw = r;
            reset = 0x0;
        } Histogramswitch[1:0];
    } HISTOGRAM_SWITCH @ 0x54;
    reg {
        name = "INTERRUPT0";
        desc = "INTERRUPT0 is interrupt 0 register. INTERRUPT0 (offset 0x0080, total reset 0x0000_0000; PROVEN: Hi3518E V100 data sheet, PDF page 760, section 11.4).";
        field {
            name = "reserved";
            desc = "Reserved.";
            sw = rw; hw = r;
            reset = 0x0;
        } reserved_31_5[31:5];
        field {
            name = "Interrupt0source";
            desc = "Interrupt source select.";
            sw = rw; hw = r;
            reset = 0x0;
        } Interrupt0source[4:0];
    } INTERRUPT0 @ 0x80;
    reg {
        name = "INTERRUPT1";
        desc = "INTERRUPT1 is interrupt 1 register. INTERRUPT1 (offset 0x0084, total reset 0x0000_0000; PROVEN: Hi3518E V100 data sheet, PDF page 761, section 11.4).";
        field {
            name = "reserved";
            desc = "Reserved.";
            sw = rw; hw = r;
            reset = 0x0;
        } reserved_31_5[31:5];
        field {
            name = "Interrupt1source";
            desc = "Interrupt source select.";
            sw = rw; hw = r;
            reset = 0x0;
        } Interrupt1source[4:0];
    } INTERRUPT1 @ 0x84;
    reg {
        name = "INTERRUPT2";
        desc = "INTERRUPT2 is interrupt 2 register. INTERRUPT2 (offset 0x0088, total reset 0x0000_0000; PROVEN: Hi3518E V100 data sheet, PDF page 761, section 11.4).";
        field {
            name = "reserved";
            desc = "Reserved.";
            sw = rw; hw = r;
            reset = 0x0;
        } reserved_31_5[31:5];
        field {
            name = "Interrupt2source";
            desc = "Interrupt source select.";
            sw = rw; hw = r;
            reset = 0x0;
        } Interrupt2source[4:0];
    } INTERRUPT2 @ 0x88;
    reg {
        name = "INTERRUPT3";
        desc = "INTERRUPT3 is interrupt 3 register. INTERRUPT3 (offset 0x008C, total reset 0x0000_0000; PROVEN: Hi3518E V100 data sheet, PDF page 761, section 11.4).";
        field {
            name = "reserved";
            desc = "Reserved.";
            sw = rw; hw = r;
            reset = 0x0;
        } reserved_31_5[31:5];
        field {
            name = "Interrupt3source";
            desc = "Interrupt source select.";
            sw = rw; hw = r;
            reset = 0x0;
        } Interrupt3source[4:0];
    } INTERRUPT3 @ 0x8c;
    reg {
        name = "INTERRUPT4";
        desc = "INTERRUPT4 is interrupt 4 register. INTERRUPT4 (offset 0x0090, total reset 0x0000_0000; PROVEN: Hi3518E V100 data sheet, PDF page 762, section 11.4).";
        field {
            name = "reserved";
            desc = "Reserved.";
            sw = rw; hw = r;
            reset = 0x0;
        } reserved_31_5[31:5];
        field {
            name = "Interrupt4source";
            desc = "Interrupt source select.";
            sw = rw; hw = r;
            reset = 0x0;
        } Interrupt4source[4:0];
    } INTERRUPT4 @ 0x90;
    reg {
        name = "INTERRUPT5";
        desc = "INTERRUPT5 is interrupt 5 register. INTERRUPT5 (offset 0x0094, total reset 0x0000_0000; PROVEN: Hi3518E V100 data sheet, PDF page 762, section 11.4).";
        field {
            name = "reserved";
            desc = "Reserved.";
            sw = rw; hw = r;
            reset = 0x0;
        } reserved_31_5[31:5];
        field {
            name = "Interrupt5source";
            desc = "Interrupt source select.";
            sw = rw; hw = r;
            reset = 0x0;
        } Interrupt5source[4:0];
    } INTERRUPT5 @ 0x94;
    reg {
        name = "INTERRUPT6";
        desc = "INTERRUPT6 is interrupt 6 register. INTERRUPT6 (offset 0x0098, total reset 0x0000_0000; PROVEN: Hi3518E V100 data sheet, PDF page 762, section 11.4).";
        field {
            name = "reserved";
            desc = "Reserved.";
            sw = rw; hw = r;
            reset = 0x0;
        } reserved_31_5[31:5];
        field {
            name = "Interrupt6source";
            desc = "Interrupt source select.";
            sw = rw; hw = r;
            reset = 0x0;
        } Interrupt6source[4:0];
    } INTERRUPT6 @ 0x98;
    reg {
        name = "INTERRUPT7";
        desc = "INTERRUPT7 is interrupt 7 register. INTERRUPT7 (offset 0x009C, total reset 0x0000_0000; PROVEN: Hi3518E V100 data sheet, PDF page 763, section 11.4).";
        field {
            name = "reserved";
            desc = "Reserved.";
            sw = rw; hw = r;
            reset = 0x0;
        } reserved_31_5[31:5];
        field {
            name = "Interrupt7source";
            desc = "Interrupt source select.";
            sw = rw; hw = r;
            reset = 0x0;
        } Interrupt7source[4:0];
    } INTERRUPT7 @ 0x9c;
    reg {
        name = "INPUTPORT_CTRL";
        desc = "INPUTPORT_CTRL is an input port control register. INPUTPORT_CTRL (offset 0x0130, total reset 0x0000_0000; PROVEN: Hi3518E V100 data sheet, PDF page 763, section 11.4).";
        field {
            name = "reserved";
            desc = "Reserved.";
            sw = rw; hw = r;
            reset = 0x0;
        } reserved_31_8[31:8];
        field {
            name = "freezeconfig";
            desc = "- 0: normal operation
- 1: retain the previous configuration state";
            sw = rw; hw = r;
            reset = 0x0;
        } freezeconfig[7:7];
        field {
            name = "reserved";
            desc = "Reserved.";
            sw = rw; hw = r;
            reset = 0x0;
        } reserved_6_3[6:3];
        field {
            name = "moderequest";
            desc = "- 000: safe stop
- 001: safe start
- 010: urgent stop
- 011: urgent start
- 100: reserved
- 101: safer start
- 110: reserved
- 111: reserved";
            sw = rw; hw = r;
            reset = 0x0;
        } moderequest[2:0];
    } INPUTPORT_CTRL @ 0x130;
    reg {
        name = "INPUTPORT_STATUS";
        desc = "INPUTPORT_STATUS is an input port status register. INPUTPORT_STATUS (offset 0x0134, total reset 0x0000_0000; PROVEN: Hi3518E V100 data sheet, PDF page 764, section 11.4).";
        field {
            name = "reserved";
            desc = "Reserved.";
            sw = rw; hw = r;
            reset = 0x0;
        } reserved_31_3[31:3];
        field {
            name = "modestatus";
            desc = "For bit 0:
- 1: started
- 0: stopped

For bits 1 and 2: reserved";
            sw = rw; hw = r;
            reset = 0x0;
        } modestatus[2:0];
    } INPUTPORT_STATUS @ 0x134;
    reg {
        name = "SENSOR_R_BLACK";
        desc = "SENSOR_R_BLACK is an R component black level register for the sensor offset module. SENSOR_R_BLACK (offset 0x0140, total reset 0x0000_0000; PROVEN: Hi3518E V100 data sheet, PDF page 765, section 11.4).";
        field {
            name = "reserved";
            desc = "Reserved.";
            sw = rw; hw = r;
            reset = 0x0;
        } reserved_31_16[31:16];
        field {
            name = "Black00";
            desc = "Black offset for color channel 00 (R).";
            sw = rw; hw = r;
            reset = 0x0;
        } Black00[15:0];
    } SENSOR_R_BLACK @ 0x140;
    reg {
        name = "SENSOR_GR_BLACK";
        desc = "SENSOR_GR_BLACK is a Gr component black level register for the sensor offset module. SENSOR_GR_BLACK (offset 0x0144, total reset 0x0000_0000; PROVEN: Hi3518E V100 data sheet, PDF page 766, section 11.4).";
        field {
            name = "reserved";
            desc = "Reserved.";
            sw = rw; hw = r;
            reset = 0x0;
        } reserved_31_16[31:16];
        field {
            name = "Black01";
            desc = "Black offset for color channel 01 (Gr).";
            sw = rw; hw = r;
            reset = 0x0;
        } Black01[15:0];
    } SENSOR_GR_BLACK @ 0x144;
    reg {
        name = "SENSOR_GB_BLACK";
        desc = "SENSOR_GB_BLACK is a Gb component black level register for the sensor offset module. SENSOR_GB_BLACK (offset 0x0148, total reset 0x0000_0000; PROVEN: Hi3518E V100 data sheet, PDF page 766, section 11.4).";
        field {
            name = "reserved";
            desc = "Reserved.";
            sw = rw; hw = r;
            reset = 0x0;
        } reserved_31_16[31:16];
        field {
            name = "Black10";
            desc = "Black offset for color channel 10 (Gb).";
            sw = rw; hw = r;
            reset = 0x0;
        } Black10[15:0];
    } SENSOR_GB_BLACK @ 0x148;
    reg {
        name = "SENSOR_B_BLACK";
        desc = "SENSOR_B_BLACK is a B component black level register for the sensor offset module. SENSOR_B_BLACK (offset 0x014C, total reset 0x0000_0000; PROVEN: Hi3518E V100 data sheet, PDF page 766, section 11.4).";
        field {
            name = "reserved";
            desc = "Reserved.";
            sw = rw; hw = r;
            reset = 0x0;
        } reserved_31_16[31:16];
        field {
            name = "Black11";
            desc = "Black offset for color channel 11 (B).";
            sw = rw; hw = r;
            reset = 0x0;
        } Black11[15:0];
    } SENSOR_B_BLACK @ 0x14c;
    reg {
        name = "FRONTEND_LUT_STATUS";
        desc = "FRONTEND_LUT_STATUS is a front-end LUT status register. FRONTEND_LUT_STATUS (offset 0x0188, total reset 0x0000_0000; PROVEN: Hi3518E V100 data sheet, PDF page 767, section 11.4).";
        field {
            name = "reserved";
            desc = "Reserved.";
            sw = r; hw = w;
            reset = 0x0;
        } reserved_31_3[31:3];
        field {
            name = "MCUready";
            desc = "LUT is ready to receive the data from the CPU.";
            sw = r; hw = w;
            reset = 0x0;
        } MCUready[2:2];
        field {
            name = "MCUpriority";
            desc = "Priority of CPU port.
- 0: low
- 1: high";
            sw = rw; hw = r;
            reset = 0x0;
        } MCUpriority[1:1];
        field {
            name = "Enable";
            desc = "front-end look-up enable.
- 0: off
- 1: on";
            sw = r; hw = w;
            reset = 0x0;
        } Enable[0:0];
    } FRONTEND_LUT_STATUS @ 0x188;
    reg {
        name = "GE_CTRL1";
        desc = "GE_CTRL1 is green equalization module control register 1. GE_CTRL1 (offset 0x01C0, total reset 0x0000_0000; PROVEN: Hi3518E V100 data sheet, PDF page 768, section 11.4).";
        field {
            name = "reserved";
            desc = "Reserved.";
            sw = rw; hw = r;
            reset = 0x0;
        } reserved_31_4[31:4];
        field {
            name = "showdynamicdefectpixel";
            desc = "Show defect pixel.
- 0: off
- 1: on";
            sw = rw; hw = r;
            reset = 0x0;
        } showdynamicdefectpixel[3:3];
        field {
            name = "dpenable";
            desc = "Defect pixel enable.
- 0: off
- 1: on";
            sw = rw; hw = r;
            reset = 0x0;
        } dpenable[2:2];
        field {
            name = "reserved";
            desc = "Reserved.";
            sw = rw; hw = r;
            reset = 0x0;
        } reserved_1_1[1:1];
        field {
            name = "geenable";
            desc = "Green equalization enable.
- 0: off
- 1: on";
            sw = rw; hw = r;
            reset = 0x0;
        } geenable[0:0];
    } GE_CTRL1 @ 0x1c0;
    reg {
        name = "GE_CTRL2";
        desc = "GE_CTRL2 is green equalization module control register 2. GE_CTRL2 (offset 0x01C4, total reset 0x0000_0000; PROVEN: Hi3518E V100 data sheet, PDF page 768, section 11.4).";
        field {
            name = "reserved";
            desc = "Reserved.";
            sw = rw; hw = r;
            reset = 0x0;
        } reserved_31_8[31:8];
        field {
            name = "gestrength";
            desc = "Green equalization strength.";
            sw = rw; hw = r;
            reset = 0x0;
        } gestrength[7:0];
    } GE_CTRL2 @ 0x1c4;
    reg {
        name = "GE_CTRL3";
        desc = "GE_CTRL3 is green equalization module control register 3. GE_CTRL3 (offset 0x01C8, total reset 0x0000_0000; PROVEN: Hi3518E V100 data sheet, PDF page 769, section 11.4).";
        field {
            name = "reserved";
            desc = "Reserved.";
            sw = rw; hw = r;
            reset = 0x0;
        } reserved_31_28[31:28];
        field {
            name = "dpthreshold";
            desc = "Green equalization configuration.";
            sw = rw; hw = r;
            reset = 0x0;
        } dpthreshold[27:16];
        field {
            name = "reserved";
            desc = "Reserved.";
            sw = rw; hw = r;
            reset = 0x0;
        } reserved_15_12[15:12];
        field {
            name = "debugsel";
            desc = "Debug port select.";
            sw = rw; hw = r;
            reset = 0x0;
        } debugsel[11:0];
    } GE_CTRL3 @ 0x1c8;
    reg {
        name = "GE_CTRL4";
        desc = "GE_CTRL4 is green equalization module control register 4. GE_CTRL4 (offset 0x01CC, total reset 0x0000_0000; PROVEN: Hi3518E V100 data sheet, PDF page 769, section 11.4).";
        field {
            name = "reserved";
            desc = "Reserved.";
            sw = rw; hw = r;
            reset = 0x0;
        } reserved_31_12[31:12];
        field {
            name = "gethreshold";
            desc = "Green equalization configuration.";
            sw = rw; hw = r;
            reset = 0x0;
        } gethreshold[11:0];
    } GE_CTRL4 @ 0x1cc;
    reg {
        name = "GE_CTRL5";
        desc = "GE_CTRL5 is green equalization module control register 5. GE_CTRL5 (offset 0x01D0, total reset 0x0000_0000; PROVEN: Hi3518E V100 data sheet, PDF page 770, section 11.4).";
        field {
            name = "reserved";
            desc = "Reserved.";
            sw = rw; hw = r;
            reset = 0x0;
        } reserved_31_12[31:12];
        field {
            name = "dpslope";
            desc = "Slope for the HP mask function.";
            sw = rw; hw = r;
            reset = 0x0;
        } dpslope[11:0];
    } GE_CTRL5 @ 0x1d0;
    reg {
        name = "GE_CTRL6";
        desc = "GE_CTRL6 is green equalization module control register 6. GE_CTRL6 (offset 0x01D4, total reset 0x0000_0000; PROVEN: Hi3518E V100 data sheet, PDF page 770, section 11.4).";
        field {
            name = "reserved";
            desc = "Reserved.";
            sw = rw; hw = r;
            reset = 0x0;
        } reserved_31_24[31:24];
        field {
            name = "gesens";
            desc = "STD-DEV sensitivity.";
            sw = rw; hw = r;
            reset = 0x0;
        } gesens[23:16];
        field {
            name = "reserved";
            desc = "Reserved.";
            sw = rw; hw = r;
            reset = 0x0;
        } reserved_15_12[15:12];
        field {
            name = "geslope";
            desc = "Slope for the GE mask function.";
            sw = rw; hw = r;
            reset = 0x0;
        } geslope[11:0];
    } GE_CTRL6 @ 0x1d4;
    reg {
        name = "HP_DEFECT_PIXEL_CTRL";
        desc = "HP_DEFECT_PIXEL_CTRL is a defect pixel module control register. HP_DEFECT_PIXEL_CTRL (offset 0x01E8, total reset 0x0000_0000; PROVEN: Hi3518E V100 data sheet, PDF page 771, section 11.4).";
        field {
            name = "reserved";
            desc = "Reserved.";
            sw = rw; hw = r;
            reset = 0x0;
        } reserved_31_5[31:5];
        field {
            name = "DetectionTrigger";
            desc = "Start detection on 0-1 transition.";
            sw = rw; hw = r;
            reset = 0x0;
        } DetectionTrigger[4:4];
        field {
            name = "ShowStaticDefect_Pixels";
            desc = "Show the pixels that have been detected as defect pixels.";
            sw = rw; hw = r;
            reset = 0x0;
        } ShowStaticDefect_Pixels[3:3];
        field {
            name = "Enable";
            desc = "Correction enable.
- 0: off
- 1: on";
            sw = rw; hw = r;
            reset = 0x0;
        } Enable[2:2];
        field {
            name = "ShowReference";
            desc = "Show reference values that are compared with actual values to detect defect pixels.";
            sw = rw; hw = r;
            reset = 0x0;
        } ShowReference[1:1];
        field {
            name = "PointerReset";
            desc = "Reset defect-pixel table pointer each frame. This field is set when the defect-pixel table has been written from the MCU.";
            sw = rw; hw = r;
            reset = 0x0;
        } PointerReset[0:0];
    } HP_DEFECT_PIXEL_CTRL @ 0x1e8;
    reg {
        name = "HP_COUNT";
        desc = "HP_COUNT is a defect pixel count register for the defect pixel module. HP_COUNT (offset 0x01EC, total reset 0x0000_0000; PROVEN: Hi3518E V100 data sheet, PDF page 771, section 11.4).";
        field {
            name = "reserved";
            desc = "Reserved.";
            sw = r; hw = w;
            reset = 0x0;
        } reserved_31_10[31:10];
        field {
            name = "DefectPixelCount";
            desc = "Number of defect pixels detected.";
            sw = r; hw = w;
            reset = 0x0;
        } DefectPixelCount[9:0];
    } HP_COUNT @ 0x1ec;
    reg {
        name = "HP_TABLE_START";
        desc = "HP_TABLE_START is a defect pixel start address register for the defect pixel module. HP_TABLE_START (offset 0x01F0, total reset 0x0000_0000; PROVEN: Hi3518E V100 data sheet, PDF page 772, section 11.4).";
        field {
            name = "reserved";
            desc = "Reserved.";
            sw = r; hw = w;
            reset = 0x0;
        } reserved_31_10[31:10];
        field {
            name = "TableStart";
            desc = "Address of the first defect pixel in stored defect pixels.";
            sw = r; hw = w;
            reset = 0x0;
        } TableStart[9:0];
    } HP_TABLE_START @ 0x1f0;
    reg {
        name = "HP_COUNT_IN";
        desc = "HP_COUNT_IN is a written defect pixel count register for the defect pixel module. HP_COUNT_IN (offset 0x01F4, total reset 0x0000_0000; PROVEN: Hi3518E V100 data sheet, PDF page 772, section 11.4).";
        field {
            name = "reserved";
            desc = "Reserved.";
            sw = rw; hw = r;
            reset = 0x0;
        } reserved_31_10[31:10];
        field {
            name = "DefectPixelCountInNumber";
            desc = "of defect pixels in the written table.";
            sw = rw; hw = r;
            reset = 0x0;
        } DefectPixelCountInNumber[9:0];
    } HP_COUNT_IN @ 0x1f4;
    reg {
        name = "DNR_CTRL1";
        desc = "DNR_CTRL1 is DNR module control register 1. DNR_CTRL1 (offset 0x0200, total reset 0x0000_0411; PROVEN: Hi3518E V100 data sheet, PDF page 774, section 11.4).";
        field {
            name = "rmcenterx";
            desc = "Horizontal coordinates of the shading map.";
            sw = rw; hw = r;
            reset = 0x0;
        } rmcenterx[31:16];
        field {
            name = "reserved";
            desc = "Reserved.";
            sw = rw; hw = r;
            reset = 0x0;
        } reserved_15_12[15:12];
        field {
            name = "intconfig";
            desc = "Intensity blending with mosaic raw.";
            sw = rw; hw = r;
            reset = 0x4;
        } intconfig[11:8];
        field {
            name = "rmenable";
            desc = "Lens shading correction enable.
- 0: off
- 1: on";
            sw = rw; hw = r;
            reset = 0x0;
        } rmenable[7:7];
        field {
            name = "Intselect";
            desc = "Intensity filter select.";
            sw = rw; hw = r;
            reset = 0x0;
        } Intselect[6:6];
        field {
            name = "Filterselect";
            desc = "Denoise filter fine tuning.";
            sw = rw; hw = r;
            reset = 0x0;
        } Filterselect[5:5];
        field {
            name = "Enable";
            desc = "Denoise enable.
- 0: off
- 1: on";
            sw = rw; hw = r;
            reset = 0x1;
        } Enable[4:4];
        field {
            name = "Rsvd";
            desc = "Reserved.";
            sw = rw; hw = r;
            reset = 0x1;
        } Rsvd[3:0];
    } DNR_CTRL1 @ 0x200;
    reg {
        name = "DNR_CTRL2";
        desc = "DNR_CTRL2 is DNR module control register 2. DNR_CTRL2 (offset 0x0204, total reset 0x0000_0000; PROVEN: Hi3518E V100 data sheet, PDF page 775, section 11.4).";
        field {
            name = "rmoffcentermult";
            desc = "Normalizing factor for sum of squares.";
            sw = rw; hw = r;
            reset = 0x0;
        } rmoffcentermult[31:16];
        field {
            name = "rmcentery";
            desc = "Vertical coordinates of the shading map.";
            sw = rw; hw = r;
            reset = 0x0;
        } rmcentery[15:0];
    } DNR_CTRL2 @ 0x204;
    reg {
        name = "DNR_CTRL3";
        desc = "DNR_CTRL3 is DNR module control register 3. DNR_CTRL3 (offset 0x0208, total reset 0x0000_0000; PROVEN: Hi3518E V100 data sheet, PDF page 775, section 11.4).";
        field {
            name = "reserved";
            desc = "Reserved.";
            sw = rw; hw = r;
            reset = 0x0;
        } reserved_31_16[31:16];
        field {
            name = "Thresh1h";
            desc = "Noise threshold for the horizontal green-only filter.";
            sw = rw; hw = r;
            reset = 0x0;
        } Thresh1h[15:8];
        field {
            name = "Thresh0h";
            desc = "Noise threshold for high horizontal spatial frequencies.";
            sw = rw; hw = r;
            reset = 0x0;
        } Thresh0h[7:0];
    } DNR_CTRL3 @ 0x208;
    reg {
        name = "DNR_THRESH_2H";
        desc = "DNR_THRESH_2H is a horizontal intermediate-frequency noise threshold register for the DNR module. DNR_THRESH_2H (offset 0x020C, total reset 0x0000_0000; PROVEN: Hi3518E V100 data sheet, PDF page 776, section 11.4).";
        field {
            name = "reserved";
            desc = "Reserved.";
            sw = rw; hw = r;
            reset = 0x0;
        } reserved_31_8[31:8];
        field {
            name = "Thresh2h";
            desc = "Noise threshold for medium horizontal spatial frequencies.";
            sw = rw; hw = r;
            reset = 0x0;
        } Thresh2h[7:0];
    } DNR_THRESH_2H @ 0x20c;
    reg {
        name = "DNR_THRESH_4H";
        desc = "DNR_THRESH_4H is a horizontal low-frequency noise threshold register for the DNR module. DNR_THRESH_4H (offset 0x0210, total reset 0x0000_0000; PROVEN: Hi3518E V100 data sheet, PDF page 776, section 11.4).";
        field {
            name = "reserved";
            desc = "Reserved.";
            sw = rw; hw = r;
            reset = 0x0;
        } reserved_31_8[31:8];
        field {
            name = "Thresh4h";
            desc = "Noise threshold for low horizontal spatial frequencies.";
            sw = rw; hw = r;
            reset = 0x0;
        } Thresh4h[7:0];
    } DNR_THRESH_4H @ 0x210;
    reg {
        name = "DNR_THRESH_0V";
        desc = "DNR_THRESH_0V is a vertical high-frequency noise threshold register for the DNR module. DNR_THRESH_0V (offset 0x0214, total reset 0x0000_0000; PROVEN: Hi3518E V100 data sheet, PDF page 776, section 11.4).";
        field {
            name = "reserved";
            desc = "Reserved.";
            sw = rw; hw = r;
            reset = 0x0;
        } reserved_31_8[31:8];
        field {
            name = "Thresh0v";
            desc = "Noise threshold for high vertical spatial frequencies.";
            sw = rw; hw = r;
            reset = 0x0;
        } Thresh0v[7:0];
    } DNR_THRESH_0V @ 0x214;
    reg {
        name = "DNR_THRESH_1V";
        desc = "DNR_THRESH_1V is a vertical green noise threshold register for the DNR module. DNR_THRESH_1V (offset 0x0218, total reset 0x0000_0000; PROVEN: Hi3518E V100 data sheet, PDF page 777, section 11.4).";
        field {
            name = "reserved";
            desc = "Reserved.";
            sw = rw; hw = r;
            reset = 0x0;
        } reserved_31_8[31:8];
        field {
            name = "Thresh1v";
            desc = "Noise threshold for the vertical green-only filter.";
            sw = rw; hw = r;
            reset = 0x0;
        } Thresh1v[7:0];
    } DNR_THRESH_1V @ 0x218;
    reg {
        name = "DNR_THRESH_2V";
        desc = "DNR_THRESH_2V is a vertical intermediate-frequency noise threshold for the DNR module. DNR_THRESH_2V (offset 0x021C, total reset 0x0000_0000; PROVEN: Hi3518E V100 data sheet, PDF page 777, section 11.4).";
        field {
            name = "reserved";
            desc = "Reserved.";
            sw = rw; hw = r;
            reset = 0x0;
        } reserved_31_8[31:8];
        field {
            name = "Thresh2v";
            desc = "Noise threshold for medium vertical spatial frequencies.";
            sw = rw; hw = r;
            reset = 0x0;
        } Thresh2v[7:0];
    } DNR_THRESH_2V @ 0x21c;
    reg {
        name = "DNR_THRESH_4V";
        desc = "DNR_THRESH_4V is a vertical low-frequency noise threshold for the DNR module. DNR_THRESH_4V (offset 0x0220, total reset 0x0000_0000; PROVEN: Hi3518E V100 data sheet, PDF page 777, section 11.4).";
        field {
            name = "reserved";
            desc = "Reserved.";
            sw = rw; hw = r;
            reset = 0x0;
        } reserved_31_8[31:8];
        field {
            name = "Thresh4v";
            desc = "Noise threshold for low vertical spatial frequencies.";
            sw = rw; hw = r;
            reset = 0x0;
        } Thresh4v[7:0];
    } DNR_THRESH_4V @ 0x220;
    reg {
        name = "DNR_THRESH_SHORT";
        desc = "DNR_THRESH_SHORT is a short exposure noise threshold register for the DNR module. DNR_THRESH_SHORT (offset 0x0224, total reset 0x0000_0000; PROVEN: Hi3518E V100 data sheet, PDF page 778, section 11.4).";
        field {
            name = "reserved";
            desc = "Reserved.";
            sw = rw; hw = r;
            reset = 0x0;
        } reserved_31_8[31:8];
        field {
            name = "ThreshShort";
            desc = "Noise threshold adjustment for short exposure data.";
            sw = rw; hw = r;
            reset = 0x0;
        } ThreshShort[7:0];
    } DNR_THRESH_SHORT @ 0x224;
    reg {
        name = "DNR_THRESH_LONG";
        desc = "DNR_THRESH_LONG is a long exposure noise threshold register for the DNR module. DNR_THRESH_LONG (offset 0x0228, total reset 0x0000_0000; PROVEN: Hi3518E V100 data sheet, PDF page 778, section 11.4).";
        field {
            name = "reserved";
            desc = "Reserved.";
            sw = rw; hw = r;
            reset = 0x0;
        } reserved_31_8[31:8];
        field {
            name = "ThreshLong";
            desc = "Noise threshold adjustment for long exposure data.";
            sw = rw; hw = r;
            reset = 0x0;
        } ThreshLong[7:0];
    } DNR_THRESH_LONG @ 0x228;
    reg {
        name = "DNR_STRENGTH0";
        desc = "DNR_STRENGTH0 is a high-frequency component denoise strength register for the DNR module. DNR_STRENGTH0 (offset 0x022C, total reset 0x0000_0000; PROVEN: Hi3518E V100 data sheet, PDF page 779, section 11.4).";
        field {
            name = "reserved";
            desc = "Reserved.";
            sw = rw; hw = r;
            reset = 0x0;
        } reserved_31_8[31:8];
        field {
            name = "Strength0";
            desc = "Noise reduction effect for high spatial frequencies.";
            sw = rw; hw = r;
            reset = 0x0;
        } Strength0[7:0];
    } DNR_STRENGTH0 @ 0x22c;
    reg {
        name = "DNR_STRENGTH1";
        desc = "DNR_STRENGTH1 is a green component denoise strength register for the DNR module. DNR_STRENGTH1 (offset 0x0230, total reset 0x0000_0000; PROVEN: Hi3518E V100 data sheet, PDF page 779, section 11.4).";
        field {
            name = "reserved";
            desc = "Reserved.";
            sw = rw; hw = r;
            reset = 0x0;
        } reserved_31_8[31:8];
        field {
            name = "Strength1";
            desc = "Noise reduction effect for the green-only filter.";
            sw = rw; hw = r;
            reset = 0x0;
        } Strength1[7:0];
    } DNR_STRENGTH1 @ 0x230;
    reg {
        name = "DNR_STRENGTH2";
        desc = "DNR_STRENGTH2 is an intermediate-frequency denoise strength register for the DNR module. DNR_STRENGTH2 (offset 0x0234, total reset 0x0000_0000; PROVEN: Hi3518E V100 data sheet, PDF page 780, section 11.4).";
        field {
            name = "reserved";
            desc = "Reserved.";
            sw = rw; hw = r;
            reset = 0x0;
        } reserved_31_8[31:8];
        field {
            name = "Strength2";
            desc = "Noise reduction effect for medium spatial frequencies.";
            sw = rw; hw = r;
            reset = 0x0;
        } Strength2[7:0];
    } DNR_STRENGTH2 @ 0x234;
    reg {
        name = "DNR_STRENGTH4";
        desc = "DNR_STRENGTH4 is a low-frequency denoise strength register for the DNR module. DNR_STRENGTH4 (offset 0x0238, total reset 0x0000_0000; PROVEN: Hi3518E V100 data sheet, PDF page 780, section 11.4).";
        field {
            name = "reserved";
            desc = "Reserved.";
            sw = rw; hw = r;
            reset = 0x0;
        } reserved_31_8[31:8];
        field {
            name = "Strength4";
            desc = "Noise reduction effect for low spatial frequencies.";
            sw = rw; hw = r;
            reset = 0x0;
        } Strength4[7:0];
    } DNR_STRENGTH4 @ 0x238;
    reg {
        name = "DNR_EXP_THRESH";
        desc = "DNR_EXP_THRESH is a long/short exposure threshold register for the DNR module. DNR_EXP_THRESH (offset 0x0270, total reset 0x0000_0000; PROVEN: Hi3518E V100 data sheet, PDF page 784, section 11.4).";
        field {
            name = "reserved";
            desc = "Reserved.";
            sw = rw; hw = r;
            reset = 0x0;
        } reserved_31_16[31:16];
        field {
            name = "ExpThresh";
            desc = "Threshold for determining long/short exposure data.";
            sw = rw; hw = r;
            reset = 0x0;
        } ExpThresh[15:0];
    } DNR_EXP_THRESH @ 0x270;
    reg {
        name = "DNR_RATIO_SHORT";
        desc = "DNR_RATIO_SHORT is a short exposure noise profile LUT multiplier register for the DNR module. DNR_RATIO_SHORT (offset 0x0274, total reset 0x0000_0000; PROVEN: Hi3518E V100 data sheet, PDF page 784, section 11.4).";
        field {
            name = "reserved";
            desc = "Reserved.";
            sw = rw; hw = r;
            reset = 0x0;
        } reserved_31_8[31:8];
        field {
            name = "ShortRatio";
            desc = "Multiplier that applies to short exposure data for noise profile calculation. Format: unsigned 6.2-bit fixed-point";
            sw = rw; hw = r;
            reset = 0x0;
        } ShortRatio[7:0];
    } DNR_RATIO_SHORT @ 0x274;
    reg {
        name = "DNR_RATIO_LONG";
        desc = "DNR_RATIO_LONG is a long exposure noise profile LUT multiplier register for the DNR module. DNR_RATIO_LONG (offset 0x0278, total reset 0x0000_0000; PROVEN: Hi3518E V100 data sheet, PDF page 785, section 11.4).";
        field {
            name = "reserved";
            desc = "Reserved.";
            sw = rw; hw = r;
            reset = 0x0;
        } reserved_31_8[31:8];
        field {
            name = "LongRatio";
            desc = "Multiplier that applies to long exposure data for noise profile calculation. Format: unsigned 6.2-bit fixed-point";
            sw = rw; hw = r;
            reset = 0x0;
        } LongRatio[7:0];
    } DNR_RATIO_LONG @ 0x278;
    reg {
        name = "WB_GAIN00";
        desc = "WB_GAIN00 is an R component gain register for the white balance module. WB_GAIN00 (offset 0x02C0, total reset 0x0000_0000; PROVEN: Hi3518E V100 data sheet, PDF page 785, section 11.4).";
        field {
            name = "reserved";
            desc = "Reserved.";
            sw = rw; hw = r;
            reset = 0x0;
        } reserved_31_12[31:12];
        field {
            name = "Gain00";
            desc = "Multiplier for color channel 00 (R). Format: unsigned 4.8-bit fixed-point";
            sw = rw; hw = r;
            reset = 0x0;
        } Gain00[11:0];
    } WB_GAIN00 @ 0x2c0;
    reg {
        name = "WB_GAIN01";
        desc = "WB_GAIN01 is a Gr component gain register for the white balance module. WB_GAIN01 (offset 0x02C4, total reset 0x0000_0000; PROVEN: Hi3518E V100 data sheet, PDF page 786, section 11.4).";
        field {
            name = "reserved";
            desc = "Reserved.";
            sw = rw; hw = r;
            reset = 0x0;
        } reserved_31_12[31:12];
        field {
            name = "Gain01";
            desc = "Multiplier for color channel 01 (Gr). Format: unsigned 4.8-bit fixed-point";
            sw = rw; hw = r;
            reset = 0x0;
        } Gain01[11:0];
    } WB_GAIN01 @ 0x2c4;
    reg {
        name = "WB_GAIN10";
        desc = "WB_GAIN10 is a Gb component gain register for the white balance module. WB_GAIN10 (offset 0x02C8, total reset 0x0000_0000; PROVEN: Hi3518E V100 data sheet, PDF page 786, section 11.4).";
        field {
            name = "reserved";
            desc = "Reserved.";
            sw = rw; hw = r;
            reset = 0x0;
        } reserved_31_12[31:12];
        field {
            name = "Gain10";
            desc = "Multiplier for color channel 10 (Gb). Format: unsigned 4.8-bit fixed-point";
            sw = rw; hw = r;
            reset = 0x0;
        } Gain10[11:0];
    } WB_GAIN10 @ 0x2c8;
    reg {
        name = "WB_GAIN11";
        desc = "WB_GAIN11 is a B component gain register for the white balance module. WB_GAIN11 (offset 0x02CC, total reset 0x0000_0000; PROVEN: Hi3518E V100 data sheet, PDF page 787, section 11.4).";
        field {
            name = "reserved";
            desc = "Reserved.";
            sw = rw; hw = r;
            reset = 0x0;
        } reserved_31_12[31:12];
        field {
            name = "Gain11";
            desc = "Multiplier for color channel 11 (B). Format: unsigned 4.8-bit fixed-point";
            sw = rw; hw = r;
            reset = 0x0;
        } Gain11[11:0];
    } WB_GAIN11 @ 0x2cc;
    reg {
        name = "WB_BLACK00";
        desc = "WB_BLACK00 is an R component black level register for the white balance module. WB_BLACK00 (offset 0x02D0, total reset 0x0000_0000; PROVEN: Hi3518E V100 data sheet, PDF page 787, section 11.4).";
        field {
            name = "reserved";
            desc = "Reserved.";
            sw = rw; hw = r;
            reset = 0x0;
        } reserved_31_16[31:16];
        field {
            name = "Black00";
            desc = "Black offset for color channel 00(R).";
            sw = rw; hw = r;
            reset = 0x0;
        } Black00[15:0];
    } WB_BLACK00 @ 0x2d0;
    reg {
        name = "WB_BLACK01";
        desc = "WB_BLACK01 is a Gr component black level register for the white balance module. WB_BLACK01 (offset 0x02D4, total reset 0x0000_0000; PROVEN: Hi3518E V100 data sheet, PDF page 788, section 11.4).";
        field {
            name = "reserved";
            desc = "Reserved.";
            sw = rw; hw = r;
            reset = 0x0;
        } reserved_31_16[31:16];
        field {
            name = "Black01";
            desc = "Black offset for color channel 01 (Gr).";
            sw = rw; hw = r;
            reset = 0x0;
        } Black01[15:0];
    } WB_BLACK01 @ 0x2d4;
    reg {
        name = "WB_BLACK10";
        desc = "WB_BLACK10 is a Gb component black level register for the white balance module. WB_BLACK10 (offset 0x02D8, total reset 0x0000_0000; PROVEN: Hi3518E V100 data sheet, PDF page 788, section 11.4).";
        field {
            name = "reserved";
            desc = "Reserved.";
            sw = rw; hw = r;
            reset = 0x0;
        } reserved_31_16[31:16];
        field {
            name = "Black10";
            desc = "Black offset for color channel 10 (Gb).";
            sw = rw; hw = r;
            reset = 0x0;
        } Black10[15:0];
    } WB_BLACK10 @ 0x2d8;
    reg {
        name = "WB_BLACK11";
        desc = "WB_BLACK11 is a B component black level register for the white balance module. WB_BLACK11 (offset 0x02DC, total reset 0x0000_0000; PROVEN: Hi3518E V100 data sheet, PDF page 788, section 11.4).";
        field {
            name = "reserved";
            desc = "Reserved.";
            sw = rw; hw = r;
            reset = 0x0;
        } reserved_31_16[31:16];
        field {
            name = "Black11";
            desc = "Black offset for color channel 11 (B).";
            sw = rw; hw = r;
            reset = 0x0;
        } Black11[15:0];
    } WB_BLACK11 @ 0x2dc;
    reg {
        name = "SHADING_CTRL";
        desc = "SHADING_CTRL is a lens shading module control module. SHADING_CTRL (offset 0x0300, total reset 0x0000_0000; PROVEN: Hi3518E V100 data sheet, PDF page 789, section 11.4).";
        field {
            name = "reserved";
            desc = "Reserved.";
            sw = rw; hw = r;
            reset = 0x0;
        } reserved_31_1[31:1];
        field {
            name = "Enable";
            desc = "Lens shading correction enable.
- 0: off
- 1: on";
            sw = rw; hw = r;
            reset = 0x0;
        } Enable[0:0];
    } SHADING_CTRL @ 0x300;
    reg {
        name = "SHADING_RX";
        desc = "SHADING_RX is an R component center horizontal coordinate register for the lens shading module. SHADING_RX (offset 0x0304, total reset 0x0000_0000; PROVEN: Hi3518E V100 data sheet, PDF page 789, section 11.4).";
        field {
            name = "reserved";
            desc = "Reserved.";
            sw = rw; hw = r;
            reset = 0x0;
        } reserved_31_16[31:16];
        field {
            name = "centerRx";
            desc = "Rx coordinates of the shading map.";
            sw = rw; hw = r;
            reset = 0x0;
        } centerRx[15:0];
    } SHADING_RX @ 0x304;
    reg {
        name = "SHADING_RY";
        desc = "SHADING_RY is an R component center vertical coordinate register for the lens shading module. SHADING_RY (offset 0x0308, total reset 0x0000_0000; PROVEN: Hi3518E V100 data sheet, PDF page 790, section 11.4).";
        field {
            name = "reserved";
            desc = "Reserved.";
            sw = rw; hw = r;
            reset = 0x0;
        } reserved_31_16[31:16];
        field {
            name = "centerRy";
            desc = "Ry coordinates of the shading map.";
            sw = rw; hw = r;
            reset = 0x0;
        } centerRy[15:0];
    } SHADING_RY @ 0x308;
    reg {
        name = "SHADING_GX";
        desc = "SHADING_GX is a G component center horizontal coordinate register for the lens shading module. SHADING_GX (offset 0x030C, total reset 0x0000_0000; PROVEN: Hi3518E V100 data sheet, PDF page 790, section 11.4).";
        field {
            name = "reserved";
            desc = "Reserved.";
            sw = rw; hw = r;
            reset = 0x0;
        } reserved_31_16[31:16];
        field {
            name = "centerGx";
            desc = "Gx coordinates of the shading map.";
            sw = rw; hw = r;
            reset = 0x0;
        } centerGx[15:0];
    } SHADING_GX @ 0x30c;
    reg {
        name = "SHADING_GY";
        desc = "SHADING_GY is a G component center vertical coordinate register for the lens shading module. SHADING_GY (offset 0x0310, total reset 0x0000_0000; PROVEN: Hi3518E V100 data sheet, PDF page 790, section 11.4).";
        field {
            name = "reserved";
            desc = "Reserved.";
            sw = rw; hw = r;
            reset = 0x0;
        } reserved_31_16[31:16];
        field {
            name = "centerGy";
            desc = "Gy coordinates of the shading map.";
            sw = rw; hw = r;
            reset = 0x0;
        } centerGy[15:0];
    } SHADING_GY @ 0x310;
    reg {
        name = "SHADING_BX";
        desc = "SHADING_BX is a B component center horizontal coordinate register for the lens shading module. SHADING_BX (offset 0x0314, total reset 0x0000_0000; PROVEN: Hi3518E V100 data sheet, PDF page 791, section 11.4).";
        field {
            name = "reserved";
            desc = "Reserved.";
            sw = rw; hw = r;
            reset = 0x0;
        } reserved_31_16[31:16];
        field {
            name = "centerBx";
            desc = "Bx coordinates of the shading map.";
            sw = rw; hw = r;
            reset = 0x0;
        } centerBx[15:0];
    } SHADING_BX @ 0x314;
    reg {
        name = "SHADING_BY";
        desc = "SHADING_BY is a B component center vertical coordinate register for the lens shading module. SHADING_BY (offset 0x0318, total reset 0x0000_0000; PROVEN: Hi3518E V100 data sheet, PDF page 791, section 11.4).";
        field {
            name = "reserved";
            desc = "Reserved.";
            sw = rw; hw = r;
            reset = 0x0;
        } reserved_31_16[31:16];
        field {
            name = "centerBy";
            desc = "By coordinates of the shading map.";
            sw = rw; hw = r;
            reset = 0x0;
        } centerBy[15:0];
    } SHADING_BY @ 0x318;
    reg {
        name = "SHADING_MULTR";
        desc = "SHADING_MULTR is an R component shading factor for the lens shading module. SHADING_MULTR (offset 0x031C, total reset 0x0000_0000; PROVEN: Hi3518E V100 data sheet, PDF page 792, section 11.4).";
        field {
            name = "reserved";
            desc = "Reserved.";
            sw = rw; hw = r;
            reset = 0x0;
        } reserved_31_16[31:16];
        field {
            name = "offcentermultR";
            desc = "Normalizing factor for sum of squares.";
            sw = rw; hw = r;
            reset = 0x0;
        } offcentermultR[15:0];
    } SHADING_MULTR @ 0x31c;
    reg {
        name = "SHADING_MULTG";
        desc = "SHADING_MULTG is a G component shading factor for the lens shading module. SHADING_MULTG (offset 0x0320, total reset 0x0000_0000; PROVEN: Hi3518E V100 data sheet, PDF page 792, section 11.4).";
        field {
            name = "reserved";
            desc = "Reserved.";
            sw = rw; hw = r;
            reset = 0x0;
        } reserved_31_16[31:16];
        field {
            name = "offcentermultG";
            desc = "Normalizing factor for sum of squares.es";
            sw = rw; hw = r;
            reset = 0x0;
        } offcentermultG[15:0];
    } SHADING_MULTG @ 0x320;
    reg {
        name = "SHADING_MULTB";
        desc = "SHADING_MULTB is a B component shading factor for the lens shading module. SHADING_MULTB (offset 0x0324, total reset 0x0000_0000; PROVEN: Hi3518E V100 data sheet, PDF page 792, section 11.4).";
        field {
            name = "reserved";
            desc = "Reserved.";
            sw = rw; hw = r;
            reset = 0x0;
        } reserved_31_16[31:16];
        field {
            name = "offcentermultB";
            desc = "Normalizing factor for sum of squares.";
            sw = rw; hw = r;
            reset = 0x0;
        } offcentermultB[15:0];
    } SHADING_MULTB @ 0x324;
    reg {
        name = "DRC_ENABLE";
        desc = "DRC_ENABLE is a DRC enable register. DRC_ENABLE (offset 0x0380, total reset 0x0000_0000; PROVEN: Hi3518E V100 data sheet, PDF page 793, section 11.4).";
        field {
            name = "reserved";
            desc = "Reserved.";
            sw = rw; hw = r;
            reset = 0x0;
        } reserved_31_1[31:1];
        field {
            name = "Enable";
            desc = "DRC enable.
- 0: off
- 1: on";
            sw = rw; hw = r;
            reset = 0x0;
        } Enable[0:0];
    } DRC_ENABLE @ 0x380;
    reg {
        name = "DRC_STRENGTH";
        desc = "DRC_STRENGTH is a DRC strength register. DRC_STRENGTH (offset 0x0384, total reset 0x0000_0000; PROVEN: Hi3518E V100 data sheet, PDF page 793, section 11.4).";
        field {
            name = "reserved";
            desc = "Reserved.";
            sw = rw; hw = r;
            reset = 0x0;
        } reserved_31_8[31:8];
        field {
            name = "Strength";
            desc = "Strength of dynamic range compression. When other parameters are default values, increase the visibility of shadows.";
            sw = rw; hw = r;
            reset = 0x0;
        } Strength[7:0];
    } DRC_STRENGTH @ 0x384;
    reg {
        name = "DRC_CTRL";
        desc = "DRC_CTRL is a DRC module control register. DRC_CTRL (offset 0x0388, total reset 0x0000_0010; PROVEN: Hi3518E V100 data sheet, PDF page 794, section 11.4).";
        field {
            name = "reserved";
            desc = "Reserved.";
            sw = rw; hw = r;
            reset = 0x0;
        } reserved_31_24[31:24];
        field {
            name = "slopemin";
            desc = "Restrict the minimum slope (gain) that can be generated by the adaptive algorithm.";
            sw = rw; hw = r;
            reset = 0x0;
        } slopemin[23:16];
        field {
            name = "slopemax";
            desc = "Restrict the maximum slope (gain) which can be generated by the adaptive algorithm.";
            sw = rw; hw = r;
            reset = 0x0;
        } slopemax[15:8];
        field {
            name = "varianceintensity";
            desc = "Degree of luminance sensitivity of the algorithm.";
            sw = rw; hw = r;
            reset = 0x1;
        } varianceintensity[7:4];
        field {
            name = "VarianceSpace";
            desc = "Degree of spatial sensitivity of the algorithm.";
            sw = rw; hw = r;
            reset = 0x0;
        } VarianceSpace[3:0];
    } DRC_CTRL @ 0x388;
    reg {
        name = "DRC_LOOKUP1_ENABLE";
        desc = "DRC_LOOKUP1_ENABLE is a DRC LUT1 enable register. DRC_LOOKUP1_ENABLE (offset 0x03C8, total reset 0x0000_0000; PROVEN: Hi3518E V100 data sheet, PDF page 794, section 11.4).";
        field {
            name = "reserved";
            desc = "Reserved.";
            sw = rw; hw = r;
            reset = 0x0;
        } reserved_31_2[31:2];
        field {
            name = "RevPerceptEnable";
            desc = "DRC look-up 1 enable.
- 0: off
- 1: on";
            sw = rw; hw = r;
            reset = 0x0;
        } RevPerceptEnable[1:1];
        field {
            name = "reserved";
            desc = "Reserved.";
            sw = rw; hw = r;
            reset = 0x0;
        } reserved_0_0[0:0];
    } DRC_LOOKUP1_ENABLE @ 0x3c8;
    reg {
        name = "DRC_LOOKUP2_ENABLE";
        desc = "DRC_LOOKUP1_ENABLE is a DRC LUT2 enable register. DRC_LOOKUP2_ENABLE (offset 0x03E8, total reset 0x0000_0000; PROVEN: Hi3518E V100 data sheet, PDF page 796, section 11.4).";
        field {
            name = "reserved";
            desc = "Reserved.";
            sw = rw; hw = r;
            reset = 0x0;
        } reserved_31_2[31:2];
        field {
            name = "FwdPerceptEnable";
            desc = "DRC look-up 2 enable.
- 0: off
- 1: on";
            sw = rw; hw = r;
            reset = 0x0;
        } FwdPerceptEnable[1:1];
        field {
            name = "reserved";
            desc = "Reserved.";
            sw = rw; hw = r;
            reset = 0x0;
        } reserved_0_0[0:0];
    } DRC_LOOKUP2_ENABLE @ 0x3e8;
    reg {
        name = "DEMOSAIC_VH_SLOPE";
        desc = "DEMOSAIC_VH_SLOPE is a maximum vertical/horizontal slope register for the demosaic module. DEMOSAIC_VH_SLOPE (offset 0x0400, total reset 0x0000_0000; PROVEN: Hi3518E V100 data sheet, PDF page 797, section 11.4).";
        field {
            name = "reserved";
            desc = "Reserved.";
            sw = rw; hw = r;
            reset = 0x0;
        } reserved_31_8[31:8];
        field {
            name = "VHSlope";
            desc = "Slope of vertical/horizontal blending threshold in 4.4 logarithmic format.";
            sw = rw; hw = r;
            reset = 0x0;
        } VHSlope[7:0];
    } DEMOSAIC_VH_SLOPE @ 0x400;
    reg {
        name = "DEMOSAIC_AA_SLOPE";
        desc = "DEMOSAIC_AA_SLOPE is an AA slope register. DEMOSAIC_AA_SLOPE (offset 0x0404, total reset 0x0000_0000; PROVEN: Hi3518E V100 data sheet, PDF page 797, section 11.4).";
        field {
            name = "reserved";
            desc = "Reserved.";
            sw = rw; hw = r;
            reset = 0x0;
        } reserved_31_8[31:8];
        field {
            name = "AASlope";
            desc = "Slope of angular blending threshold in 4.4 logarithmic format.";
            sw = rw; hw = r;
            reset = 0x0;
        } AASlope[7:0];
    } DEMOSAIC_AA_SLOPE @ 0x404;
    reg {
        name = "DEMOSAIC_VA_SLOPE";
        desc = "DEMOSAIC_VA_SLOPE is a VA slope register. DEMOSAIC_VA_SLOPE (offset 0x0408, total reset 0x0000_0000; PROVEN: Hi3518E V100 data sheet, PDF page 798, section 11.4).";
        field {
            name = "reserved";
            desc = "Reserved.";
            sw = rw; hw = r;
            reset = 0x0;
        } reserved_31_8[31:8];
        field {
            name = "VASlope";
            desc = "Slope of VH-AA (VA) blending threshold in 4.4 logarithmic format.";
            sw = rw; hw = r;
            reset = 0x0;
        } VASlope[7:0];
    } DEMOSAIC_VA_SLOPE @ 0x408;
    reg {
        name = "DEMOSAIC_UU_SLOPE";
        desc = "DEMOSAIC_UU_SLOPE is a UU slope register. DEMOSAIC_UU_SLOPE (offset 0x040C, total reset 0x0000_0000; PROVEN: Hi3518E V100 data sheet, PDF page 798, section 11.4).";
        field {
            name = "reserved";
            desc = "Reserved.";
            sw = rw; hw = r;
            reset = 0x0;
        } reserved_31_8[31:8];
        field {
            name = "UUSlope";
            desc = "Slope of undefined blending threshold in 4.4 logarithmic format.";
            sw = rw; hw = r;
            reset = 0x0;
        } UUSlope[7:0];
    } DEMOSAIC_UU_SLOPE @ 0x40c;
    reg {
        name = "DEMOSAIC_SAT_SLOPE";
        desc = "DEMOSAIC_SAT_SLOPE is an SAT slope register. DEMOSAIC_SAT_SLOPE (offset 0x0410, total reset 0x0000_0000; PROVEN: Hi3518E V100 data sheet, PDF page 799, section 11.4).";
        field {
            name = "reserved";
            desc = "Reserved.";
            sw = rw; hw = r;
            reset = 0x0;
        } reserved_31_8[31:8];
        field {
            name = "SatSlope";
            desc = "Slope of saturation blending threshold in linear format 2.6.";
            sw = rw; hw = r;
            reset = 0x0;
        } SatSlope[7:0];
    } DEMOSAIC_SAT_SLOPE @ 0x410;
    reg {
        name = "DEMOSAIC_VH_THRESH";
        desc = "DEMOSAIC_VH_THRESH is a VH threshold register. DEMOSAIC_VH_THRESH (offset 0x0414, total reset 0x0000_0000; PROVEN: Hi3518E V100 data sheet, PDF page 799, section 11.4).";
        field {
            name = "reserved";
            desc = "Reserved.";
            sw = rw; hw = r;
            reset = 0x0;
        } reserved_31_12[31:12];
        field {
            name = "VHThresh";
            desc = "Threshold for the range of vertical/horizontal blending in 0.12 format.";
            sw = rw; hw = r;
            reset = 0x0;
        } VHThresh[11:0];
    } DEMOSAIC_VH_THRESH @ 0x414;
    reg {
        name = "DEMOSAIC_AA_THRESH";
        desc = "DEMOSAIC_AA_THRESH is an AA threshold register. DEMOSAIC_AA_THRESH (offset 0x0418, total reset 0x0000_0000; PROVEN: Hi3518E V100 data sheet, PDF page 800, section 11.4).";
        field {
            name = "reserved";
            desc = "Reserved.";
            sw = rw; hw = r;
            reset = 0x0;
        } reserved_31_12[31:12];
        field {
            name = "AAThresh";
            desc = "Threshold for the range of angular blending in 0.12 format.";
            sw = rw; hw = r;
            reset = 0x0;
        } AAThresh[11:0];
    } DEMOSAIC_AA_THRESH @ 0x418;
    reg {
        name = "DEMOSAIC_VA_THRESH";
        desc = "DEMOSAIC_VA_THRESH is a VA threshold register. DEMOSAIC_VA_THRESH (offset 0x041C, total reset 0x0000_0000; PROVEN: Hi3518E V100 data sheet, PDF page 800, section 11.4).";
        field {
            name = "reserved";
            desc = "Reserved.";
            sw = rw; hw = r;
            reset = 0x0;
        } reserved_31_12[31:12];
        field {
            name = "VAThresh";
            desc = "Threshold for the range of VA blending in 0.12 format.";
            sw = rw; hw = r;
            reset = 0x0;
        } VAThresh[11:0];
    } DEMOSAIC_VA_THRESH @ 0x41c;
    reg {
        name = "DEMOSAIC_UU_THRESH";
        desc = "DEMOSAIC_UU_THRESH is a UU threshold register. DEMOSAIC_UU_THRESH (offset 0x0420, total reset 0x0000_0000; PROVEN: Hi3518E V100 data sheet, PDF page 800, section 11.4).";
        field {
            name = "reserved";
            desc = "Reserved.";
            sw = rw; hw = r;
            reset = 0x0;
        } reserved_31_12[31:12];
        field {
            name = "UUThresh";
            desc = "Threshold for the range of undefined blending in 0.12 format.";
            sw = rw; hw = r;
            reset = 0x0;
        } UUThresh[11:0];
    } DEMOSAIC_UU_THRESH @ 0x420;
    reg {
        name = "DEMOSAIC_SAT_THRESH";
        desc = "DEMOSAIC_AA_OFFSET is an AA threshold register. DEMOSAIC_SAT_THRESH (offset 0x0424, total reset 0x0000_0000; PROVEN: Hi3518E V100 data sheet, PDF page 801, section 11.4).";
        field {
            name = "reserved";
            desc = "Reserved.";
            sw = rw; hw = r;
            reset = 0x0;
        } reserved_31_12[31:12];
        field {
            name = "SatThresh";
            desc = "Threshold for the range of saturation blending in signed 2.9 format.";
            sw = rw; hw = r;
            reset = 0x0;
        } SatThresh[11:0];
    } DEMOSAIC_SAT_THRESH @ 0x424;
    reg {
        name = "DEMOSAIC_VH_OFFSET";
        desc = "DEMOSAIC_VH_OFFSET is a vertical/horizontal offset register for the demosaic module. DEMOSAIC_VH_OFFSET (offset 0x0428, total reset 0x0000_0000; PROVEN: Hi3518E V100 data sheet, PDF page 801, section 11.4).";
        field {
            name = "reserved";
            desc = "Reserved.";
            sw = rw; hw = r;
            reset = 0x0;
        } reserved_31_12[31:12];
        field {
            name = "VHOffset";
            desc = "Offset for vertical/horizontal blending threshold in 0.12 format.";
            sw = rw; hw = r;
            reset = 0x0;
        } VHOffset[11:0];
    } DEMOSAIC_VH_OFFSET @ 0x428;
    reg {
        name = "DEMOSAIC_AA_OFFSET";
        desc = "DEMOSAIC_AA_OFFSET is an AA offset register. DEMOSAIC_AA_OFFSET (offset 0x042C, total reset 0x0000_0000; PROVEN: Hi3518E V100 data sheet, PDF page 802, section 11.4).";
        field {
            name = "reserved";
            desc = "Reserved.";
            sw = rw; hw = r;
            reset = 0x0;
        } reserved_31_12[31:12];
        field {
            name = "AAOffset";
            desc = "Offset for angular blending threshold in 0.12 format.";
            sw = rw; hw = r;
            reset = 0x0;
        } AAOffset[11:0];
    } DEMOSAIC_AA_OFFSET @ 0x42c;
    reg {
        name = "DEMOSAIC_VA_OFFSET";
        desc = "DEMOSAIC_VA_OFFSET is a VA offset register. DEMOSAIC_VA_OFFSET (offset 0x0430, total reset 0x0000_0000; PROVEN: Hi3518E V100 data sheet, PDF page 802, section 11.4).";
        field {
            name = "reserved";
            desc = "Reserved.";
            sw = rw; hw = r;
            reset = 0x0;
        } reserved_31_12[31:12];
        field {
            name = "VAOffset";
            desc = "Offset for VA blending threshold in 0.12 format.";
            sw = rw; hw = r;
            reset = 0x0;
        } VAOffset[11:0];
    } DEMOSAIC_VA_OFFSET @ 0x430;
    reg {
        name = "DEMOSAIC_UU_OFFSET";
        desc = "DEMOSAIC_UU_OFFSET is a UU offset register. DEMOSAIC_UU_OFFSET (offset 0x0434, total reset 0x0000_0000; PROVEN: Hi3518E V100 data sheet, PDF page 802, section 11.4).";
        field {
            name = "reserved";
            desc = "Reserved.";
            sw = rw; hw = r;
            reset = 0x0;
        } reserved_31_12[31:12];
        field {
            name = "UUOffset";
            desc = "Offset for undefined blending threshold in 0.12 format.";
            sw = rw; hw = r;
            reset = 0x0;
        } UUOffset[11:0];
    } DEMOSAIC_UU_OFFSET @ 0x434;
    reg {
        name = "DEMOSAIC_SAT_OFFSET";
        desc = "DEMOSAIC_SAT_OFFSET is an SAT offset register. DEMOSAIC_SAT_OFFSET (offset 0x0438, total reset 0x0000_0000; PROVEN: Hi3518E V100 data sheet, PDF page 803, section 11.4).";
        field {
            name = "reserved";
            desc = "Reserved.";
            sw = rw; hw = r;
            reset = 0x0;
        } reserved_31_12[31:12];
        field {
            name = "SatOffset";
            desc = "Offset for saturation blending threshold in signed 2.9 format.";
            sw = rw; hw = r;
            reset = 0x0;
        } SatOffset[11:0];
    } DEMOSAIC_SAT_OFFSET @ 0x438;
    reg {
        name = "DEMOSAIC_SHARP_ALT_D";
        desc = "DEMOSAIC_SHARP_ALT_D is an edge sharpen strength register. DEMOSAIC_SHARP_ALT_D (offset 0x043C, total reset 0x0000_0000; PROVEN: Hi3518E V100 data sheet, PDF page 803, section 11.4).";
        field {
            name = "reserved";
            desc = "Reserved.";
            sw = rw; hw = r;
            reset = 0x0;
        } reserved_31_8[31:8];
        field {
            name = "sharpaltd";
            desc = "Directional sharp mask strength in signed 4.4 format.";
            sw = rw; hw = r;
            reset = 0x0;
        } sharpaltd[7:0];
    } DEMOSAIC_SHARP_ALT_D @ 0x43c;
    reg {
        name = "DEMOSAIC_SHARP_ALT_UD";
        desc = "DEMOSAIC_SHARP_ALT_UD is a flat area sharpen strength register. DEMOSAIC_SHARP_ALT_UD (offset 0x0440, total reset 0x0000_0000; PROVEN: Hi3518E V100 data sheet, PDF page 803, section 11.4).";
        field {
            name = "reserved";
            desc = "Reserved.";
            sw = rw; hw = r;
            reset = 0x0;
        } reserved_31_8[31:8];
        field {
            name = "sharpaltud";
            desc = "Non-directional sharp mask strength in signed 4.4 format.";
            sw = rw; hw = r;
            reset = 0x0;
        } sharpaltud[7:0];
    } DEMOSAIC_SHARP_ALT_UD @ 0x440;
    reg {
        name = "DEMOSAIC_LUM_THRESH";
        desc = "DEMOSAIC_LUM_THRESH is an LUM threshold register. DEMOSAIC_LUM_THRESH (offset 0x0444, total reset 0x0000_0000; PROVEN: Hi3518E V100 data sheet, PDF page 804, section 11.4).";
        field {
            name = "reserved";
            desc = "Reserved.";
            sw = rw; hw = r;
            reset = 0x0;
        } reserved_31_12[31:12];
        field {
            name = "lumthresh";
            desc = "Luminance threshold for directional sharpening.";
            sw = rw; hw = r;
            reset = 0x0;
        } lumthresh[11:0];
    } DEMOSAIC_LUM_THRESH @ 0x444;
    reg {
        name = "DEMOSAIC_NP_OFFSET";
        desc = "DEMOSAIC_NP_OFFSET is an NP offset register. DEMOSAIC_NP_OFFSET (offset 0x0448, total reset 0x0000_0000; PROVEN: Hi3518E V100 data sheet, PDF page 804, section 11.4).";
        field {
            name = "reserved";
            desc = "Reserved.";
            sw = rw; hw = r;
            reset = 0x0;
        } reserved_31_8[31:8];
        field {
            name = "npoffset";
            desc = "Noise profile offset in logarithmic 4.4 format.";
            sw = rw; hw = r;
            reset = 0x0;
        } npoffset[7:0];
    } DEMOSAIC_NP_OFFSET @ 0x448;
    reg {
        name = "DEMOSAIC_AC_THRESH";
        desc = "DEMOSAIC_AC_THRESH is an AC threshold register. DEMOSAIC_AC_THRESH (offset 0x0450, total reset 0x0000_0000; PROVEN: Hi3518E V100 data sheet, PDF page 805, section 11.4).";
        field {
            name = "reserved";
            desc = "Reserved.";
            sw = rw; hw = r;
            reset = 0x0;
        } reserved_31_12[31:12];
        field {
            name = "ACThresh";
            desc = "Threshold for the range of AC blending in signed 2.9 format.";
            sw = rw; hw = r;
            reset = 0x0;
        } ACThresh[11:0];
    } DEMOSAIC_AC_THRESH @ 0x450;
    reg {
        name = "DEMOSAIC_AC_SLOPE";
        desc = "DEMOSAIC_AC_SLOPE is an AC slope register. DEMOSAIC_AC_SLOPE (offset 0x0454, total reset 0x0000_0000; PROVEN: Hi3518E V100 data sheet, PDF page 805, section 11.4).";
        field {
            name = "reserved";
            desc = "Reserved.";
            sw = rw; hw = r;
            reset = 0x0;
        } reserved_31_8[31:8];
        field {
            name = "ACSlope";
            desc = "Slope of AC blending threshold in linear 2.6 format.";
            sw = rw; hw = r;
            reset = 0x0;
        } ACSlope[7:0];
    } DEMOSAIC_AC_SLOPE @ 0x454;
    reg {
        name = "DEMOSAIC_AC_OFFSET";
        desc = "DEMOSAIC_AC_OFFSET is an AC offset register. DEMOSAIC_AC_OFFSET (offset 0x0458, total reset 0x0000_0000; PROVEN: Hi3518E V100 data sheet, PDF page 805, section 11.4).";
        field {
            name = "reserved";
            desc = "Reserved.";
            sw = rw; hw = r;
            reset = 0x0;
        } reserved_31_12[31:12];
        field {
            name = "ACOffset";
            desc = "Offset for AC blending threshold in signed 2.9 format.";
            sw = rw; hw = r;
            reset = 0x0;
        } ACOffset[11:0];
    } DEMOSAIC_AC_OFFSET @ 0x458;
    reg {
        name = "DEMOSAIC_FC_SLPOE";
        desc = "DEMOSAIC_FC_SLPOE is an anti-false color strength register. DEMOSAIC_FC_SLPOE (offset 0x045C, total reset 0x0000_0000; PROVEN: Hi3518E V100 data sheet, PDF page 806, section 11.4).";
        field {
            name = "reserved";
            desc = "Reserved.";
            sw = rw; hw = r;
            reset = 0x0;
        } reserved_31_8[31:8];
        field {
            name = "FCSlope";
            desc = "Slope (strength) of false color correction.";
            sw = rw; hw = r;
            reset = 0x0;
        } FCSlope[7:0];
    } DEMOSAIC_FC_SLPOE @ 0x45c;
    reg {
        name = "CCM_COEFFT_RR";
        desc = "CCM_COEFFT_RR is an RR position coefficient register for the color matrix module. CCM_COEFFT_RR (offset 0x0480, total reset 0x0000_0000; PROVEN: Hi3518E V100 data sheet, PDF page 808, section 11.4).";
        field {
            name = "reserved";
            desc = "Reserved.";
            sw = rw; hw = r;
            reset = 0x0;
        } reserved_31_16[31:16];
        field {
            name = "CoefftR_R";
            desc = "Matrix coefficient for red-red multiplier. Format: sign/magnitude 8.8-bit fixed-point";
            sw = rw; hw = r;
            reset = 0x0;
        } CoefftR_R[15:0];
    } CCM_COEFFT_RR @ 0x480;
    reg {
        name = "CCM_COEFFT_RG";
        desc = "CCM_COEFFT_RG is an RG position coefficient register for the color matrix module. CCM_COEFFT_RG (offset 0x0484, total reset 0x0000_0000; PROVEN: Hi3518E V100 data sheet, PDF page 809, section 11.4).";
        field {
            name = "reserved";
            desc = "Reserved.";
            sw = rw; hw = r;
            reset = 0x0;
        } reserved_31_16[31:16];
        field {
            name = "CoefftR_G";
            desc = "Matrix coefficient for red-green multiplier. Format: sign/magnitude 8.8-bit fixed-point";
            sw = rw; hw = r;
            reset = 0x0;
        } CoefftR_G[15:0];
    } CCM_COEFFT_RG @ 0x484;
    reg {
        name = "CCM_COEFFT_RB";
        desc = "CCM_COEFFT_RB is an RB position coefficient register for the color matrix module. CCM_COEFFT_RB (offset 0x0488, total reset 0x0000_0000; PROVEN: Hi3518E V100 data sheet, PDF page 809, section 11.4).";
        field {
            name = "reserved";
            desc = "Reserved.";
            sw = rw; hw = r;
            reset = 0x0;
        } reserved_31_16[31:16];
        field {
            name = "CoefftR_B";
            desc = "Matrix coefficient for red-blue multiplier. Format: sign/magnitude 8.8-bit fixed-point";
            sw = rw; hw = r;
            reset = 0x0;
        } CoefftR_B[15:0];
    } CCM_COEFFT_RB @ 0x488;
    reg {
        name = "CCM_COEFFT_GR";
        desc = "CCM_COEFFT_GR is a GR position coefficient register for the color matrix module. CCM_COEFFT_GR (offset 0x048C, total reset 0x0000_0000; PROVEN: Hi3518E V100 data sheet, PDF page 809, section 11.4).";
        field {
            name = "reserved";
            desc = "Reserved.";
            sw = rw; hw = r;
            reset = 0x0;
        } reserved_31_16[31:16];
        field {
            name = "CoefftG_R";
            desc = "Matrix coefficient for green-red multiplier. Format: sign/magnitude 8.8-bit fixed-point";
            sw = rw; hw = r;
            reset = 0x0;
        } CoefftG_R[15:0];
    } CCM_COEFFT_GR @ 0x48c;
    reg {
        name = "CCM_COEFFT_GG";
        desc = "CCM_COEFFT_GG is a GG position coefficient register for the color matrix module. CCM_COEFFT_GG (offset 0x0490, total reset 0x0000_0000; PROVEN: Hi3518E V100 data sheet, PDF page 810, section 11.4).";
        field {
            name = "reserved";
            desc = "Reserved.";
            sw = rw; hw = r;
            reset = 0x0;
        } reserved_31_16[31:16];
        field {
            name = "CoefftG_G";
            desc = "Matrix coefficient for green-green multiplier. Format: sign/magnitude 8.8-bit fixed-point";
            sw = rw; hw = r;
            reset = 0x0;
        } CoefftG_G[15:0];
    } CCM_COEFFT_GG @ 0x490;
    reg {
        name = "CCM_COEFFT_GB";
        desc = "CCM_COEFFT_GB is a GB position coefficient register for the color matrix module. CCM_COEFFT_GB (offset 0x0494, total reset 0x0000_0000; PROVEN: Hi3518E V100 data sheet, PDF page 810, section 11.4).";
        field {
            name = "reserved";
            desc = "Reserved.";
            sw = rw; hw = r;
            reset = 0x0;
        } reserved_31_16[31:16];
        field {
            name = "CoefftG_B";
            desc = "Matrix coefficient for green-blue multiplier. Format: sign/magnitude 8.8-bit fixed-point";
            sw = rw; hw = r;
            reset = 0x0;
        } CoefftG_B[15:0];
    } CCM_COEFFT_GB @ 0x494;
    reg {
        name = "CCM_COEFFT_BR";
        desc = "CCM_COEFFT_BR is a BR position coefficient register for the color matrix module. CCM_COEFFT_BR (offset 0x0498, total reset 0x0000_0000; PROVEN: Hi3518E V100 data sheet, PDF page 811, section 11.4).";
        field {
            name = "reserved";
            desc = "Reserved.";
            sw = rw; hw = r;
            reset = 0x0;
        } reserved_31_16[31:16];
        field {
            name = "CoefftB_R";
            desc = "Matrix coefficient for blue-red multiplier. Format: sign/magnitude 8.8-bit fixed-point";
            sw = rw; hw = r;
            reset = 0x0;
        } CoefftB_R[15:0];
    } CCM_COEFFT_BR @ 0x498;
    reg {
        name = "CCM_COEFFT_BG";
        desc = "CCM_COEFFT_BG is a BG position coefficient register for the color matrix module. CCM_COEFFT_BG (offset 0x049C, total reset 0x0000_0000; PROVEN: Hi3518E V100 data sheet, PDF page 811, section 11.4).";
        field {
            name = "reserved";
            desc = "Reserved.";
            sw = rw; hw = r;
            reset = 0x0;
        } reserved_31_16[31:16];
        field {
            name = "CoefftB_G";
            desc = "Matrix coefficient for blue-green multiplier. Format: sign/magnitude 8.8-bit fixed-point";
            sw = rw; hw = r;
            reset = 0x0;
        } CoefftB_G[15:0];
    } CCM_COEFFT_BG @ 0x49c;
    reg {
        name = "CCM_COEFFT_BB";
        desc = "CCM_COEFFT_BB is a BB position coefficient register for the color matrix module. CCM_COEFFT_BB (offset 0x04A0, total reset 0x0000_0000; PROVEN: Hi3518E V100 data sheet, PDF page 812, section 11.4).";
        field {
            name = "reserved";
            desc = "Reserved.";
            sw = rw; hw = r;
            reset = 0x0;
        } reserved_31_16[31:16];
        field {
            name = "CoefftB_B";
            desc = "Matrix coefficient for blue-blue multiplier. Format: sign/magnitude 8.8-bit fixed-point";
            sw = rw; hw = r;
            reset = 0x0;
        } CoefftB_B[15:0];
    } CCM_COEFFT_BB @ 0x4a0;
    reg {
        name = "CCM_CTRL";
        desc = "CCM_CTRL is a color matrix module control register. CCM_CTRL (offset 0x04A4, total reset 0x0000_0000; PROVEN: Hi3518E V100 data sheet, PDF page 808, section 11.4).";
        field {
            name = "reserved";
            desc = "Reserved.";
            sw = rw; hw = r;
            reset = 0x0;
        } reserved_31_1[31:1];
        field {
            name = "Enable";
            desc = "Color matrix enable.
- 0: off
- 1: on";
            sw = rw; hw = r;
            reset = 0x0;
        } Enable[0:0];
    } CCM_CTRL @ 0x4a4;
    reg {
        name = "CCM_COEFFT_WBR";
        desc = "CCM_COEFFT_WBR is an R component white balance gain register for the color matrix module. CCM_COEFFT_WBR (offset 0x04A8, total reset 0x0000_0000; PROVEN: Hi3518E V100 data sheet, PDF page 812, section 11.4).";
        field {
            name = "reserved";
            desc = "Reserved.";
            sw = rw; hw = r;
            reset = 0x0;
        } reserved_31_16[31:16];
        field {
            name = "CoefftWBR";
            desc = "White balance gain for red. Format: sign/magnitude 8.8-bit fixed-point";
            sw = rw; hw = r;
            reset = 0x0;
        } CoefftWBR[15:0];
    } CCM_COEFFT_WBR @ 0x4a8;
    reg {
        name = "CCM_COEFFT_WBG";
        desc = "CCM_COEFFT_WBG is a G component white balance gain register for the color matrix module. CCM_COEFFT_WBG (offset 0x04AC, total reset 0x0000_0000; PROVEN: Hi3518E V100 data sheet, PDF page 813, section 11.4).";
        field {
            name = "reserved";
            desc = "Reserved.";
            sw = rw; hw = r;
            reset = 0x0;
        } reserved_31_16[31:16];
        field {
            name = "CoefftWBG";
            desc = "White balance gain for green. Format: sign/magnitude 8.8-bit fixed-point";
            sw = rw; hw = r;
            reset = 0x0;
        } CoefftWBG[15:0];
    } CCM_COEFFT_WBG @ 0x4ac;
    reg {
        name = "CCM_COEFFT_WBB";
        desc = "CCM_COEFFT_WBB is a B component white balance gain register for the color matrix module. CCM_COEFFT_WBB (offset 0x04B0, total reset 0x0000_0000; PROVEN: Hi3518E V100 data sheet, PDF page 813, section 11.4).";
        field {
            name = "reserved";
            desc = "Reserved.";
            sw = rw; hw = r;
            reset = 0x0;
        } reserved_31_16[31:16];
        field {
            name = "CoefftWBB";
            desc = "White balance gain for blue. Format: sign/magnitude 8.8-bit fixed-point";
            sw = rw; hw = r;
            reset = 0x0;
        } CoefftWBB[15:0];
    } CCM_COEFFT_WBB @ 0x4b0;
    reg {
        name = "GAMMA_STATUS";
        desc = "GAMMA_CTRL is a gamma module status register. GAMMA_STATUS (offset 0x04C0, total reset 0x0000_0000; PROVEN: Hi3518E V100 data sheet, PDF page 828, section 11.4).";
        field {
            name = "reserved";
            desc = "Reserved.";
            sw = r; hw = w;
            reset = 0x0;
        } reserved_31_3[31:3];
        field {
            name = "MCUready";
            desc = "LUT is ready to receive the data from the CPU.";
            sw = r; hw = w;
            reset = 0x0;
        } MCUready[2:2];
        field {
            name = "MCUpriority";
            desc = "Priority of CPU port.
- 0: low
- 1: high";
            sw = rw; hw = r;
            reset = 0x0;
        } MCUpriority[1:1];
        field {
            name = "Enable";
            desc = "Gamma enable.
- 0: off
- 1: on";
            sw = r; hw = w;
            reset = 0x0;
        } Enable[0:0];
    } GAMMA_STATUS @ 0x4c0;
    reg {
        name = "METERING_HIST_THRESH01";
        desc = "METERING_HIST_THRESH01 is segment 0 and segment 1 boundary point register for histogram statistics. METERING_HIST_THRESH01 (offset 0x0600, total reset 0x0000_0000; PROVEN: Hi3518E V100 data sheet, PDF page 814, section 11.4).";
        field {
            name = "reserved";
            desc = "Reserved.";
            sw = rw; hw = r;
            reset = 0x0;
        } reserved_31_8[31:8];
        field {
            name = "HistThresh01";
            desc = "Histogram threshold for bin 0/1 boundary.";
            sw = rw; hw = r;
            reset = 0x0;
        } HistThresh01[7:0];
    } METERING_HIST_THRESH01 @ 0x600;
    reg {
        name = "METERING_HIST_THRESH12";
        desc = "METERING_HIST_THRESH12 is segment 1 and segment 2 boundary point register for histogram statistics. METERING_HIST_THRESH12 (offset 0x0604, total reset 0x0000_0000; PROVEN: Hi3518E V100 data sheet, PDF page 814, section 11.4).";
        field {
            name = "reserved";
            desc = "Reserved.";
            sw = rw; hw = r;
            reset = 0x0;
        } reserved_31_8[31:8];
        field {
            name = "HistThresh12";
            desc = "Histogram threshold for bin 1/2 boundary.";
            sw = rw; hw = r;
            reset = 0x0;
        } HistThresh12[7:0];
    } METERING_HIST_THRESH12 @ 0x604;
    reg {
        name = "METERING_HIST_THRESH34";
        desc = "METERING_HIST_THRESH34 is segment 3 and segment 4 boundary point register for histogram statistics. METERING_HIST_THRESH34 (offset 0x0608, total reset 0x0000_0000; PROVEN: Hi3518E V100 data sheet, PDF page 814, section 11.4).";
        field {
            name = "reserved";
            desc = "Reserved.";
            sw = rw; hw = r;
            reset = 0x0;
        } reserved_31_8[31:8];
        field {
            name = "HistThresh34";
            desc = "Histogram threshold for bin 2/3 boundary.";
            sw = rw; hw = r;
            reset = 0x0;
        } HistThresh34[7:0];
    } METERING_HIST_THRESH34 @ 0x608;
    reg {
        name = "METERING_HIST_THRESH45";
        desc = "METERING_HIST_THRESH45 is segment 4 and segment 5 boundary point register for histogram statistics. METERING_HIST_THRESH45 (offset 0x060C, total reset 0x0000_0000; PROVEN: Hi3518E V100 data sheet, PDF page 815, section 11.4).";
        field {
            name = "reserved";
            desc = "Reserved.";
            sw = rw; hw = r;
            reset = 0x0;
        } reserved_31_8[31:8];
        field {
            name = "HistThresh45";
            desc = "Histogram threshold for bin 3/4 boundary.";
            sw = rw; hw = r;
            reset = 0x0;
        } HistThresh45[7:0];
    } METERING_HIST_THRESH45 @ 0x60c;
    reg {
        name = "METERING_HIST0";
        desc = "METERING_HIST0 is histogram statistics register for segment 0. METERING_HIST0 (offset 0x0620, total reset 0x0000_0000; PROVEN: Hi3518E V100 data sheet, PDF page 815, section 11.4).";
        field {
            name = "reserved";
            desc = "Reserved.";
            sw = r; hw = w;
            reset = 0x0;
        } reserved_31_16[31:16];
        field {
            name = "Hist0";
            desc = "Normalized histogram results for bin 0.";
            sw = r; hw = w;
            reset = 0x0;
        } Hist0[15:0];
    } METERING_HIST0 @ 0x620;
    reg {
        name = "METERING_HIST1";
        desc = "METERING_HIST1 is histogram statistics register for segment 1. METERING_HIST1 (offset 0x0624, total reset 0x0000_0000; PROVEN: Hi3518E V100 data sheet, PDF page 816, section 11.4).";
        field {
            name = "reserved";
            desc = "Reserved.";
            sw = r; hw = w;
            reset = 0x0;
        } reserved_31_16[31:16];
        field {
            name = "Hist1";
            desc = "Normalized histogram results for bin 1.";
            sw = r; hw = w;
            reset = 0x0;
        } Hist1[15:0];
    } METERING_HIST1 @ 0x624;
    reg {
        name = "METERING_HIST3";
        desc = "METERING_HIST3 is histogram statistics register for segment 3. METERING_HIST3 (offset 0x0628, total reset 0x0000_0000; PROVEN: Hi3518E V100 data sheet, PDF page 816, section 11.4).";
        field {
            name = "reserved";
            desc = "Reserved.";
            sw = r; hw = w;
            reset = 0x0;
        } reserved_31_16[31:16];
        field {
            name = "Hist3";
            desc = "Normalized histogram results for bin 3.";
            sw = r; hw = w;
            reset = 0x0;
        } Hist3[15:0];
    } METERING_HIST3 @ 0x628;
    reg {
        name = "METERING_HIST4";
        desc = "METERING_HIST4 is histogram statistics register for segment 4. METERING_HIST4 (offset 0x062C, total reset 0x0000_0000; PROVEN: Hi3518E V100 data sheet, PDF page 816, section 11.4).";
        field {
            name = "reserved";
            desc = "Reserved.";
            sw = r; hw = w;
            reset = 0x0;
        } reserved_31_16[31:16];
        field {
            name = "Hist4";
            desc = "Normalized histogram results for bin 4.";
            sw = r; hw = w;
            reset = 0x0;
        } Hist4[15:0];
    } METERING_HIST4 @ 0x62c;
    reg {
        name = "AE_NODES_USED";
        desc = "AE_NODES_USED is an AE active region register. AE_NODES_USED (offset 0x0630, total reset 0x0000_0000; PROVEN: Hi3518E V100 data sheet, PDF page 817, section 11.4).";
        field {
            name = "reserved";
            desc = "Reserved.";
            sw = rw; hw = r;
            reset = 0x0;
        } reserved_31_16[31:16];
        field {
            name = "AEXPNodesUsedVert";
            desc = "Number of vertical active zones.";
            sw = rw; hw = r;
            reset = 0x0;
        } AEXPNodesUsedVert[15:8];
        field {
            name = "AEXPNodesUsedHoriz";
            desc = "Number of horizontal active zones.";
            sw = rw; hw = r;
            reset = 0x0;
        } AEXPNodesUsedHoriz[7:0];
    } AE_NODES_USED @ 0x630;
    reg {
        name = "METERING_AWB_WHITE_LEVEL";
        desc = "METERING_AWB_WHITE_LEVEL is an AWB brightest point register. METERING_AWB_WHITE_LEVEL (offset 0x0640, total reset 0x0000_0000; PROVEN: Hi3518E V100 data sheet, PDF page 817, section 11.4).";
        field {
            name = "reserved";
            desc = "Reserved.";
            sw = rw; hw = r;
            reset = 0x0;
        } reserved_31_10[31:10];
        field {
            name = "WhiteLevelAWB";
            desc = "Upper limit of valid data for AWB.";
            sw = rw; hw = r;
            reset = 0x0;
        } WhiteLevelAWB[9:0];
    } METERING_AWB_WHITE_LEVEL @ 0x640;
    reg {
        name = "METERING_AWB_BLACK_LEVEL";
        desc = "METERING_AWB_BLACK_LEVEL is an AWB darkest point register. METERING_AWB_BLACK_LEVEL (offset 0x0644, total reset 0x0000_0000; PROVEN: Hi3518E V100 data sheet, PDF page 818, section 11.4).";
        field {
            name = "reserved";
            desc = "Reserved.";
            sw = rw; hw = r;
            reset = 0x0;
        } reserved_31_12[31:12];
        field {
            name = "BlackLevelAWB";
            desc = "Lower limit of valid data for AWB.";
            sw = rw; hw = r;
            reset = 0x0;
        } BlackLevelAWB[11:0];
    } METERING_AWB_BLACK_LEVEL @ 0x644;
    reg {
        name = "METERING_AWB_CR_REF_MAX";
        desc = "METERING_AWB_CR_REF_MAX is the maximum Cr value register for the AWB reference white point. METERING_AWB_CR_REF_MAX (offset 0x0648, total reset 0x0000_0000; PROVEN: Hi3518E V100 data sheet, PDF page 818, section 11.4).";
        field {
            name = "reserved";
            desc = "Reserved.";
            sw = rw; hw = r;
            reset = 0x0;
        } reserved_31_12[31:12];
        field {
            name = "CrRefMaxAWB";
            desc = "Maximum value of R/G for white region. Format: unsigned 4.8-bit fixed-point";
            sw = rw; hw = r;
            reset = 0x0;
        } CrRefMaxAWB[11:0];
    } METERING_AWB_CR_REF_MAX @ 0x648;
    reg {
        name = "METERING_AWB_CR_REF_MIN";
        desc = "METERING_AWB_CR_REF_MIN is the minimum Cr value register for the AWB reference white point. METERING_AWB_CR_REF_MIN (offset 0x064C, total reset 0x0000_0000; PROVEN: Hi3518E V100 data sheet, PDF page 818, section 11.4).";
        field {
            name = "reserved";
            desc = "Reserved.";
            sw = rw; hw = r;
            reset = 0x0;
        } reserved_31_12[31:12];
        field {
            name = "CrRefMinAWB";
            desc = "Minimum value of R/G for white region. Format: unsigned 4.8-bit fixed-point";
            sw = rw; hw = r;
            reset = 0x0;
        } CrRefMinAWB[11:0];
    } METERING_AWB_CR_REF_MIN @ 0x64c;
    reg {
        name = "METERING_AWB_CB_REF_MAX";
        desc = "METERING_AWB_CB_REF_MAX is the maximum Cb value register for the AWB reference white point. METERING_AWB_CB_REF_MAX (offset 0x0650, total reset 0x0000_0000; PROVEN: Hi3518E V100 data sheet, PDF page 819, section 11.4).";
        field {
            name = "reserved";
            desc = "Reserved.";
            sw = rw; hw = r;
            reset = 0x0;
        } reserved_31_12[31:12];
        field {
            name = "CbRefMaxAWB";
            desc = "Maximum value of B/G for white region. Format: unsigned 4.8-bit fixed-point";
            sw = rw; hw = r;
            reset = 0x0;
        } CbRefMaxAWB[11:0];
    } METERING_AWB_CB_REF_MAX @ 0x650;
    reg {
        name = "METERING_AWB_CB_REF_MIN";
        desc = "METERING_AWB_CB_REF_MIN is the minimum Cb value register for the AWB reference white point. METERING_AWB_CB_REF_MIN (offset 0x0654, total reset 0x0000_0000; PROVEN: Hi3518E V100 data sheet, PDF page 819, section 11.4).";
        field {
            name = "reserved";
            desc = "Reserved.";
            sw = rw; hw = r;
            reset = 0x0;
        } reserved_31_12[31:12];
        field {
            name = "CbRefMinAWB";
            desc = "Minimum value of B/G for white region. Format: unsigned 4.8-bit fixed-point";
            sw = rw; hw = r;
            reset = 0x0;
        } CbRefMinAWB[11:0];
    } METERING_AWB_CB_REF_MIN @ 0x654;
    reg {
        name = "METERING_AWB_RG";
        desc = "METERING_AWB_RG is an AWB output G/R register. METERING_AWB_RG (offset 0x0658, total reset 0x0000_0000; PROVEN: Hi3518E V100 data sheet, PDF page 820, section 11.4).";
        field {
            name = "reserved";
            desc = "Reserved.";
            sw = r; hw = w;
            reset = 0x0;
        } reserved_31_12[31:12];
        field {
            name = "AWBRG";
            desc = "AWB output R/G. Format: unsigned 4.8-bit fixed-point";
            sw = r; hw = w;
            reset = 0x0;
        } AWBRG[11:0];
    } METERING_AWB_RG @ 0x658;
    reg {
        name = "METERING_AWB_BG";
        desc = "METERING_AWB_BG is an AWB output G/B register. METERING_AWB_BG (offset 0x065C, total reset 0x0000_0000; PROVEN: Hi3518E V100 data sheet, PDF page 820, section 11.4).";
        field {
            name = "reserved";
            desc = "Reserved.";
            sw = r; hw = w;
            reset = 0x0;
        } reserved_31_12[31:12];
        field {
            name = "AWBBG";
            desc = "AWB output B/G. Format: unsigned 4.8-bit fixed-point";
            sw = r; hw = w;
            reset = 0x0;
        } AWBBG[11:0];
    } METERING_AWB_BG @ 0x65c;
    reg {
        name = "METERING_AWB_SUM";
        desc = "METERING_AWB_SUM is an AWB reference white point count register. METERING_AWB_SUM (offset 0x0660, total reset 0x0000_0000; PROVEN: Hi3518E V100 data sheet, PDF page 821, section 11.4).";
        field {
            name = "AWBSUM";
            desc = "Format: unsigned 4.8-bit fixed-point";
            sw = r; hw = w;
            reset = 0x0;
        } AWBSUM[31:0];
    } METERING_AWB_SUM @ 0x660;
    reg {
        name = "AWB_NODES_USED";
        desc = "AWB_NODES_USED is an AWB active region register. AWB_NODES_USED (offset 0x0670, total reset 0x0000_0000; PROVEN: Hi3518E V100 data sheet, PDF page 821, section 11.4).";
        field {
            name = "reserved";
            desc = "Reserved.";
            sw = rw; hw = r;
            reset = 0x0;
        } reserved_31_16[31:16];
        field {
            name = "AWBNodesUsedVert";
            desc = "Number of vertical active zones.";
            sw = rw; hw = r;
            reset = 0x0;
        } AWBNodesUsedVert[15:8];
        field {
            name = "AWBNodesUsedHoriz";
            desc = "Number of horizontal active zones.";
            sw = rw; hw = r;
            reset = 0x0;
        } AWBNodesUsedHoriz[7:0];
    } AWB_NODES_USED @ 0x670;
    reg {
        name = "METERING_AF_METRICS";
        desc = "METERING_AF_METRICS is an AF metric statistics register. METERING_AF_METRICS (offset 0x0680, total reset 0x0000_0000; PROVEN: Hi3518E V100 data sheet, PDF page 822, section 11.4).";
        field {
            name = "reserved";
            desc = "Reserved.";
            sw = r; hw = w;
            reset = 0x0;
        } reserved_31_16[31:16];
        field {
            name = "AFmetrics";
            desc = "Integrated and normalized measure of contrast. Format: unsigned 16-bit integer";
            sw = r; hw = w;
            reset = 0x0;
        } AFmetrics[15:0];
    } METERING_AF_METRICS @ 0x680;
    reg {
        name = "METERING_AF_THRESHOLD_READ";
        desc = "METERING_AF_THRESHOLD_READ is an updated AF threshold register. METERING_AF_THRESHOLD_READ (offset 0x0688, total reset 0x0000_0000; PROVEN: Hi3518E V100 data sheet, PDF page 823, section 11.4).";
        field {
            name = "AFintensityread";
            desc = "Calculated value of AF intensity. Format: unsigned 16-bit integer";
            sw = r; hw = w;
            reset = 0x0;
        } AFintensityread[31:16];
        field {
            name = "AFthresholdread";
            desc = "Calculated value of AF threshold. Format: unsigned 16-bit integer";
            sw = r; hw = w;
            reset = 0x0;
        } AFthresholdread[15:0];
    } METERING_AF_THRESHOLD_READ @ 0x688;
    reg {
        name = "AF_METRICS_SHIFT";
        desc = "AF_METRICS_SHIFT is an AF metric conversion register. AF_METRICS_SHIFT (offset 0x068C, total reset 0x0000_0000; PROVEN: Hi3518E V100 data sheet, PDF page 822, section 11.4).";
        field {
            name = "reserved";
            desc = "Reserved.";
            sw = rw; hw = r;
            reset = 0x0;
        } reserved_31_4[31:4];
        field {
            name = "AFmetricsshift";
            desc = "Metrics scaling factor. The default value is 0x03. Format: unsigned 4-bit integer";
            sw = rw; hw = r;
            reset = 0x0;
        } AFmetricsshift[3:0];
    } AF_METRICS_SHIFT @ 0x68c;
    reg {
        name = "AF_NODES_USED";
        desc = "AF_NODES_USED is an AF active region register. AF_NODES_USED (offset 0x0690, total reset 0x0000_0000; PROVEN: Hi3518E V100 data sheet, PDF page 823, section 11.4).";
        field {
            name = "reserved";
            desc = "Reserved.";
            sw = rw; hw = r;
            reset = 0x0;
        } reserved_31_16[31:16];
        field {
            name = "AFNodesUsedVert";
            desc = "Number of vertical active zones.";
            sw = rw; hw = r;
            reset = 0x0;
        } AFNodesUsedVert[15:8];
        field {
            name = "AFNodesUsedHoriz";
            desc = "Number of horizontal active zones.";
            sw = rw; hw = r;
            reset = 0x0;
        } AFNodesUsedHoriz[7:0];
    } AF_NODES_USED @ 0x690;
    reg {
        name = "AF_NP_OFFSET";
        desc = "AF_NP_OFFSET is an AF noise profile offset register. AF_NP_OFFSET (offset 0x0694, total reset 0x0000_0000; PROVEN: Hi3518E V100 data sheet, PDF page 824, section 11.4).";
        field {
            name = "reserved";
            desc = "Reserved.";
            sw = rw; hw = r;
            reset = 0x0;
        } reserved_31_8[31:8];
        field {
            name = "AFNPoffset";
            desc = "AF noise profile offset. Format: unsigned 4.4-bit fixed-point";
            sw = rw; hw = r;
            reset = 0x0;
        } AFNPoffset[7:0];
    } AF_NP_OFFSET @ 0x694;
    reg {
        name = "HISTOGRAM_CTRL";
        desc = "HISTOGRAM_CTRL is a histogram control register. HISTOGRAM_CTRL (offset 0x06C0, total reset 0x0000_0000; PROVEN: Hi3518E V100 data sheet, PDF page 825, section 11.4).";
        field {
            name = "reserved";
            desc = "Reserved.";
            sw = rw; hw = r;
            reset = 0x0;
        } reserved_31_6[31:6];
        field {
            name = "offsety";
            desc = "- 0: start from the first row
- 1: start from the second row";
            sw = rw; hw = r;
            reset = 0x0;
        } offsety[5:5];
        field {
            name = "offsetx";
            desc = "- 0: start from the first column
- 1: start from the second column";
            sw = rw; hw = r;
            reset = 0x0;
        } offsetx[4:4];
        field {
            name = "skipy";
            desc = "Histogram decimation in vertical direction.
- 00: every pixel
- 01: every the second pixel
- 10: every the fourth pixel
- 11: every the eighth pixel";
            sw = rw; hw = r;
            reset = 0x0;
        } skipy[3:2];
        field {
            name = "skipx";
            desc = "Histogram decimation in horizontal direction.
- 00: every the second pixel
- 01: every the fourth pixel
- 10: every the eighth pixel
- 11: every the sixteenth pixel";
            sw = rw; hw = r;
            reset = 0x0;
        } skipx[1:0];
    } HISTOGRAM_CTRL @ 0x6c0;
    reg {
        name = "SCALE_CTRL";
        desc = "SCALE_CTRL is a scale control register. SCALE_CTRL (offset 0x06C4, total reset 0x0000_0000; PROVEN: Hi3518E V100 data sheet, PDF page 825, section 11.4).";
        field {
            name = "reserved";
            desc = "Reserved.";
            sw = rw; hw = r;
            reset = 0x0;
        } reserved_31_8[31:8];
        field {
            name = "scaletop";
            desc = "Scale of top half of the range.
- 000: 1x
- 001: 2x
- 010: 4x
- 011: 8x
- 100: 16x

Other values: reserved";
            sw = rw; hw = r;
            reset = 0x0;
        } scaletop[7:4];
        field {
            name = "scalebottom";
            desc = "Scale of bottom half of the range.
- 000: 1x
- 001: 2x
- 010: 4x
- 011: 8x
- 100: 16x

Other values: reserved";
            sw = rw; hw = r;
            reset = 0x0;
        } scalebottom[3:0];
    } SCALE_CTRL @ 0x6c4;
    reg {
        name = "TOTAL_PIXELS";
        desc = "TOTAL_PIXELS is a total pixel number register. TOTAL_PIXELS (offset 0x06C8, total reset 0x0000_0000; PROVEN: Hi3518E V100 data sheet, PDF page 826, section 11.4).";
        field {
            name = "TotalPixels";
            desc = "Total number of pixels processed (skip x and skip y are taken into account).";
            sw = r; hw = w;
            reset = 0x0;
        } TotalPixels[31:0];
    } TOTAL_PIXELS @ 0x6c8;
    reg {
        name = "COUNTED_PIXEL";
        desc = "COUNTED_PIXEL is an involved pixel count register for statistics. COUNTED_PIXEL (offset 0x06CC, total reset 0x0000_0000; PROVEN: Hi3518E V100 data sheet, PDF page 827, section 11.4).";
        field {
            name = "CountedPixels";
            desc = "Number of pixels accumulated (with non-zero weight).";
            sw = r; hw = w;
            reset = 0x0;
        } CountedPixels[31:0];
    } COUNTED_PIXEL @ 0x6cc;
    reg {
        name = "HISTOGRAM_DATA_SHIFT";
        desc = "HISTOGRAM_DATA_SHIFT is a global statistical data offset register. HISTOGRAM_DATA_SHIFT (offset 0x06D0, total reset 0x0000_0000; PROVEN: Hi3518E V100 data sheet, PDF page 827, section 11.4).";
        field {
            name = "reserved";
            desc = "Reserved.";
            sw = r; hw = w;
            reset = 0x0;
        } reserved_31_3[31:3];
        field {
            name = "Histogramdatashift";
            desc = "Data shift for the histogram.";
            sw = r; hw = w;
            reset = 0x0;
        } Histogramdatashift[2:0];
    } HISTOGRAM_DATA_SHIFT @ 0x6d0;
    reg {
        name = "DIS_CTRL";
        desc = "DIS_CTRL is a DIS module control register. DIS_CTRL (offset 0x0700, total reset 0x0000_0000; PROVEN: Hi3518E V100 data sheet, PDF page 829, section 11.4).";
        field {
            name = "reserved";
            desc = "Reserved.";
            sw = rw; hw = r;
            reset = 0x0;
        } reserved_31_24[31:24];
        field {
            name = "ManualOffsetX";
            desc = "Manual X offset control.";
            sw = rw; hw = r;
            reset = 0x0;
        } ManualOffsetX[23:16];
        field {
            name = "reserved";
            desc = "Reserved.";
            sw = rw; hw = r;
            reset = 0x0;
        } reserved_15_10[15:10];
        field {
            name = "Shiftmux";
            desc = "Scaling factor for the internal accumulators.
- 00: There is no shift.
- 01: Internal results are multiplied by 4.
- 10: Internal results are multiplied by 16.
- 11: Internal results are multiplied by 64.";
            sw = rw; hw = r;
            reset = 0x0;
        } Shiftmux[9:8];
        field {
            name = "reserved";
            desc = "Reserved.";
            sw = rw; hw = r;
            reset = 0x0;
        } reserved_7_3[7:3];
        field {
            name = "rsvd";
            desc = "Reserved.";
            sw = rw; hw = r;
            reset = 0x0;
        } rsvd[2:1];
        field {
            name = "manualcontrol";
            desc = "DIS and manual output offset enable.";
            sw = rw; hw = r;
            reset = 0x0;
        } manualcontrol[0:0];
    } DIS_CTRL @ 0x700;
    reg {
        name = "DIS_OFFSET_X";
        desc = "DIS_OFFSET_X is horizontal offset register for the DIS module. DIS_OFFSET_X (offset 0x0704, total reset 0x0000_0000; PROVEN: Hi3518E V100 data sheet, PDF page 830, section 11.4).";
        field {
            name = "reserved";
            desc = "Reserved.";
            sw = r; hw = w;
            reset = 0x0;
        } reserved_31_24[31:24];
        field {
            name = "OffsetX";
            desc = "Calculated X offset.";
            sw = r; hw = w;
            reset = 0x0;
        } OffsetX[23:16];
        field {
            name = "reserved";
            desc = "Reserved.";
            sw = rw; hw = r;
            reset = 0x0;
        } reserved_15_8[15:8];
        field {
            name = "ManualOffsetY";
            desc = "Manual Y offset control.";
            sw = r; hw = w;
            reset = 0x0;
        } ManualOffsetY[7:0];
    } DIS_OFFSET_X @ 0x704;
    reg {
        name = "DIS_OFFSET_Y";
        desc = "DIS_OFFSET_Y is a vertical offset register for the DIS module. DIS_OFFSET_Y (offset 0x0708, total reset 0x0000_0000; PROVEN: Hi3518E V100 data sheet, PDF page 831, section 11.4).";
        field {
            name = "reserved";
            desc = "Reserved.";
            sw = rw; hw = r;
            reset = 0x0;
        } reserved_31_24[31:24];
        field {
            name = "Corrruntimes";
            desc = "Multiplier for correlation block size to obtain correlation range in +-8 increments.";
            sw = rw; hw = r;
            reset = 0x0;
        } Corrruntimes[23:16];
        field {
            name = "reserved";
            desc = "Reserved.";
            sw = rw; hw = r;
            reset = 0x0;
        } reserved_15_8[15:8];
        field {
            name = "OffsetY";
            desc = "Calculated Y offset. Contents";
            sw = rw; hw = r;
            reset = 0x0;
        } OffsetY[7:0];
    } DIS_OFFSET_Y @ 0x708;
    reg {
        name = "DNR_NOISE_PROFILE_LUT1";
        desc = "DNR_NOISE_PROFILE_LUT1 is a noise profile LUT write data register for the DNR module. DNR_NOISE_PROFILE_LUT1 (offset 0x0780, total reset 0x0000_0000; PROVEN: Hi3518E V100 data sheet, PDF page 782, section 11.4).";
        field {
            name = "Weightlut_3_";
            desc = "Noise profile LUT.";
            sw = rw; hw = r;
            reset = 0x0;
        } Weightlut_3[31:24];
        field {
            name = "Weightlut_2_";
            desc = "Noise profile LUT. (The access cell of this row reads 0x0 in the data sheet; RW as in the neighboring rows.)";
            sw = rw; hw = r;
            reset = 0x0;
        } Weightlut_2[23:16];
        field {
            name = "Weightlut_1_";
            desc = "Noise profile LUT.";
            sw = rw; hw = r;
            reset = 0x0;
        } Weightlut_1[15:8];
        field {
            name = "Weightlut_0_";
            desc = "Noise profile LUT.";
            sw = rw; hw = r;
            reset = 0x0;
        } Weightlut_0[7:0];
    } DNR_NOISE_PROFILE_LUT1 @ 0x780;
    reg {
        name = "DNR_NOISE_PROFILE_LUT2";
        desc = "DNR_NOISE_PROFILE_LUT2 is a noise profile LUT write data register for the DNR module. DNR_NOISE_PROFILE_LUT2 (offset 0x0784, total reset 0x0000_0000; PROVEN: Hi3518E V100 data sheet, PDF page 783, section 11.4).";
        field {
            name = "Weightlut_7_";
            desc = "Noise profile LUT.";
            sw = rw; hw = r;
            reset = 0x0;
        } Weightlut_7[31:24];
        field {
            name = "Weightlut_6_";
            desc = "Noise profile LUT. (The access cell of this row reads 0x0 in the data sheet; RW as in the neighboring rows.)";
            sw = rw; hw = r;
            reset = 0x0;
        } Weightlut_6[23:16];
        field {
            name = "Weightlut_5_";
            desc = "Noise profile LUT.";
            sw = rw; hw = r;
            reset = 0x0;
        } Weightlut_5[15:8];
        field {
            name = "Weightlut_4_";
            desc = "Noise profile LUT.";
            sw = rw; hw = r;
            reset = 0x0;
        } Weightlut_4[7:0];
    } DNR_NOISE_PROFILE_LUT2 @ 0x784;
    reg {
        name = "DNR_NOISE_PROFILE_LUTn";
        desc = "DNR_NOISE_PROFILE_LUTn is a noise profile LUT write data register for the DNR module. DNR_NOISE_PROFILE_LUTn (offset 0x07FC, total reset 0x0000_0000; PROVEN: Hi3518E V100 data sheet, PDF page 783, section 11.4).";
        field {
            name = "Weightlut_127_";
            desc = "Noise profile LUT.";
            sw = rw; hw = r;
            reset = 0x0;
        } Weightlut_127[31:24];
        field {
            name = "Weightlut_126_";
            desc = "Noise profile LUT.";
            sw = rw; hw = r;
            reset = 0x0;
        } Weightlut_126[23:16];
        field {
            name = "Weightlut_125_";
            desc = "Noise profile LUT. (The access cell of this row reads 0x0 in the data sheet; RW as in the neighboring rows.)";
            sw = rw; hw = r;
            reset = 0x0;
        } Weightlut_125[15:8];
        field {
            name = "Weightlut_124_";
            desc = "Noise profile LUT.";
            sw = rw; hw = r;
            reset = 0x0;
        } Weightlut_124[7:0];
    } DNR_NOISE_PROFILE_LUTn @ 0x7fc;
    reg {
        name = "DRC_LUT1_ADDR";
        desc = "DRC_LOOKUP1_ENABLE is a DRC LUT1 address register. DRC_LUT1_ADDR (offset 0x0820, total reset 0x0000_0000; PROVEN: Hi3518E V100 data sheet, PDF page 795, section 11.4).";
        field {
            name = "reserved";
            desc = "Reserved.";
            sw = rw; hw = r;
            reset = 0x0;
        } reserved_31_7[31:7];
        field {
            name = "revperceptlutaddr";
            desc = "LUT address register (valid range 0 to 64).";
            sw = rw; hw = r;
            reset = 0x0;
        } revperceptlutaddr[6:0];
    } DRC_LUT1_ADDR @ 0x820;
    reg {
        name = "DRC_LUT1_DATA";
        desc = "DRC_LOOKUP1_ENABLE is a DRC LUT1 data register. DRC_LUT1_DATA (offset 0x0824, total reset 0x0000_0000; PROVEN: Hi3518E V100 data sheet, PDF page 795, section 11.4).";
        field {
            name = "RevPerceptLUTWriteData";
            desc = "LUT write data register.";
            sw = rw; hw = r;
            reset = 0x0;
        } RevPerceptLUTWriteData[31:0];
    } DRC_LUT1_DATA @ 0x824;
    reg {
        name = "DRC_LUT2_ADDR";
        desc = "DRC_LOOKUP1_ENABLE is a DRC LUT2 address register. DRC_LUT2_ADDR (offset 0x0830, total reset 0x0000_0000; PROVEN: Hi3518E V100 data sheet, PDF page 796, section 11.4).";
        field {
            name = "reserved";
            desc = "Reserved.";
            sw = rw; hw = r;
            reset = 0x0;
        } reserved_31_7[31:7];
        field {
            name = "FwdPerceptLUTAddr";
            desc = "LUT address register (valid range 0 to 64).";
            sw = rw; hw = r;
            reset = 0x0;
        } FwdPerceptLUTAddr[6:0];
    } DRC_LUT2_ADDR @ 0x830;
    reg {
        name = "DRC_LUT2_DATA";
        desc = "DRC_LOOKUP1_ENABLE is a DRC LUT2 data register. DRC_LUT2_DATA (offset 0x0834, total reset 0x0000_0000; PROVEN: Hi3518E V100 data sheet, PDF page 797, section 11.4).";
        field {
            name = "reserved";
            desc = "Reserved.";
            sw = rw; hw = r;
            reset = 0x0;
        } reserved_31_12[31:12];
        field {
            name = "FwdPerceptLUTWriteData";
            desc = "LUT write data register.";
            sw = rw; hw = r;
            reset = 0x0;
        } FwdPerceptLUTWriteData[11:0];
    } DRC_LUT2_DATA @ 0x834;
    reg {
        name = "HP_TABLE_LUT_ADDR";
        desc = "HP_TABLE_LUT_ADDR is a lookup table (LUT) address register for the defect pixel module. HP_TABLE_LUT_ADDR (offset 0x0850, total reset 0x0000_0000; PROVEN: Hi3518E V100 data sheet, PDF page 773, section 11.4).";
        field {
            name = "reserved";
            desc = "Reserved.";
            sw = rw; hw = r;
            reset = 0x0;
        } reserved_31_10[31:10];
        field {
            name = "TableLUTAddr";
            desc = "LUT address register (valid range 0 to 1023)";
            sw = rw; hw = r;
            reset = 0x0;
        } TableLUTAddr[9:0];
    } HP_TABLE_LUT_ADDR @ 0x850;
    reg {
        name = "HP_TABLE_LUT_WRITE_DATA";
        desc = "HP_TABLE_LUT_WRITE_DATA is an LUT write data register for the defect pixel module. HP_TABLE_LUT_WRITE_DATA (offset 0x0854, total reset 0x0000_0000; PROVEN: Hi3518E V100 data sheet, PDF page 773, section 11.4).";
        field {
            name = "reserved";
            desc = "Reserved.";
            sw = rw; hw = r;
            reset = 0x0;
        } reserved_31_22[31:22];
        field {
            name = "TableLUTWriteData";
            desc = "LUT write data register.";
            sw = rw; hw = r;
            reset = 0x0;
        } TableLUTWriteData[21:0];
    } HP_TABLE_LUT_WRITE_DATA @ 0x854;
    reg {
        name = "HP_TABLE_LUT_READ_DATA";
        desc = "HP_TABLE_LUT_READ_DATA is an LUT read data register for the defect pixel module. HP_TABLE_LUT_READ_DATA (offset 0x0858, total reset 0x0000_0000; PROVEN: Hi3518E V100 data sheet, PDF page 774, section 11.4).";
        field {
            name = "reserved";
            desc = "Reserved.";
            sw = r; hw = w;
            reset = 0x0;
        } reserved_31_22[31:22];
        field {
            name = "TableLUTReadData";
            desc = "LUT read data register.";
            sw = r; hw = w;
            reset = 0x0;
        } TableLUTReadData[21:0];
    } HP_TABLE_LUT_READ_DATA @ 0x858;
    reg {
        name = "RADIAL_LUT1";
        desc = "RADIAL_LUT1 is radial LUT 1 register for the DNR module. RADIAL_LUT1 (offset 0x0970, total reset 0x0000_0000; PROVEN: Hi3518E V100 data sheet, PDF page 780, section 11.4).";
        field {
            name = "rmshadinglut_3_";
            desc = "Radial LUT.";
            sw = rw; hw = r;
            reset = 0x0;
        } rmshadinglut_3[31:24];
        field {
            name = "rmshadinglut_2_";
            desc = "Radial LUT.";
            sw = rw; hw = r;
            reset = 0x0;
        } rmshadinglut_2[23:16];
        field {
            name = "rmshadinglut_1_";
            desc = "Radial LUT. (The access cell of this row reads 0x0 in the data sheet; RW as in the neighboring rows.)";
            sw = rw; hw = r;
            reset = 0x0;
        } rmshadinglut_1[15:8];
        field {
            name = "rmshadinglut_0_";
            desc = "Radial LUT.";
            sw = rw; hw = r;
            reset = 0x0;
        } rmshadinglut_0[7:0];
    } RADIAL_LUT1 @ 0x970;
    reg {
        name = "RADIAL_LUT2";
        desc = "RADIAL_LUT2 radial LUT 2 register for the DNR module. RADIAL_LUT2 (offset 0x0974, total reset 0x0000_0000; PROVEN: Hi3518E V100 data sheet, PDF page 781, section 11.4).";
        field {
            name = "rmshADinglut_7_";
            desc = "Radial LUT.";
            sw = rw; hw = r;
            reset = 0x0;
        } rmshADinglut_7[31:24];
        field {
            name = "rmshadinglut_6_";
            desc = "Radial LUT.";
            sw = rw; hw = r;
            reset = 0x0;
        } rmshadinglut_6[23:16];
        field {
            name = "rmshadinglut_5_";
            desc = "Radial LUT. (The access cell of this row reads 0x0 in the data sheet; RW as in the neighboring rows.)";
            sw = rw; hw = r;
            reset = 0x0;
        } rmshadinglut_5[15:8];
        field {
            name = "rmshadinglut_4_";
            desc = "Radial LUT. (The access cell of this row reads 0x0 in the data sheet; RW as in the neighboring rows.)";
            sw = rw; hw = r;
            reset = 0x0;
        } rmshadinglut_4[7:0];
    } RADIAL_LUT2 @ 0x974;
    reg {
        name = "RADIAL_LUT3";
        desc = "RADIAL_LUT3 radial LUT 3 register for the DNR module. RADIAL_LUT3 (offset 0x098C, total reset 0x0000_0000; PROVEN: Hi3518E V100 data sheet, PDF page 781, section 11.4).";
        field {
            name = "rmshadinglut_31_";
            desc = "Radial LUT.";
            sw = rw; hw = r;
            reset = 0x0;
        } rmshadinglut_31[31:24];
        field {
            name = "rmshadinglut_30_";
            desc = "Radial LUT.";
            sw = rw; hw = r;
            reset = 0x0;
        } rmshadinglut_30[23:16];
        field {
            name = "rmshadinglut_29_";
            desc = "Radial LUT. (The access cell of this row reads 0x0 in the data sheet; RW as in the neighboring rows.)";
            sw = rw; hw = r;
            reset = 0x0;
        } rmshadinglut_29[15:8];
        field {
            name = "rmshadinglut_28_";
            desc = "Radial LUT.";
            sw = rw; hw = r;
            reset = 0x0;
        } rmshadinglut_28[7:0];
    } RADIAL_LUT3 @ 0x98c;
    reg {
        name = "RADIAL_LUT4";
        desc = "RADIAL_LUT4 radial LUT 4 register for the DNR module. RADIAL_LUT4 (offset 0x0990, total reset 0x0000_0000; PROVEN: Hi3518E V100 data sheet, PDF page 782, section 11.4).";
        field {
            name = "reserved";
            desc = "Reserved.";
            sw = rw; hw = r;
            reset = 0x0;
        } reserved_31_8[31:8];
        field {
            name = "rmshadinglut_32_";
            desc = "Radial LUT.";
            sw = rw; hw = r;
            reset = 0x0;
        } rmshadinglut_32[7:0];
    } RADIAL_LUT4 @ 0x990;
    reg {
        name = "METERING_AWB_WEIGHT";
        desc = "METERING_AWB_WEIGHT is an AWB window weight register. METERING_AWB_WEIGHT (offset 0x0B00, total reset 0x0000_0000; PROVEN: Hi3518E V100 data sheet, PDF page 828, section 11.4).";
        field {
            name = "reserved";
            desc = "Reserved.";
            sw = rw; hw = r;
            reset = 0x0;
        } reserved_31_28[31:28];
        field {
            name = "AWBWeight_0_3_";
            desc = "Sets zone weighting for AWB.";
            sw = rw; hw = r;
            reset = 0x0;
        } AWBWeight_0_3[27:24];
        field {
            name = "reserved";
            desc = "Reserved.";
            sw = rw; hw = r;
            reset = 0x0;
        } reserved_23_20[23:20];
        field {
            name = "AWBWeight_0_2_";
            desc = "Sets zone weighting for AWB. (The access cell of this row reads 0x0 in the data sheet; RW as in the neighboring rows.)";
            sw = rw; hw = r;
            reset = 0x0;
        } AWBWeight_0_2[19:16];
        field {
            name = "reserved";
            desc = "Reserved.";
            sw = rw; hw = r;
            reset = 0x0;
        } reserved_15_12[15:12];
        field {
            name = "AWBWeight_0_1_";
            desc = "Sets zone weighting for AWB. (The access cell of this row reads 0x0 in the data sheet; RW as in the neighboring rows.)";
            sw = rw; hw = r;
            reset = 0x0;
        } AWBWeight_0_1[11:8];
        field {
            name = "reserved";
            desc = "Reserved.";
            sw = rw; hw = r;
            reset = 0x0;
        } reserved_7_4[7:4];
        field {
            name = "AWBWeight_0_0_";
            desc = "Sets zone weighting for AWB.";
            sw = rw; hw = r;
            reset = 0x0;
        } AWBWeight_0_0[3:0];
    } METERING_AWB_WEIGHT @ 0xb00;
    reg {
        name = "NP_LUT_WEIGHT1";
        desc = "NP_LUT_WEIGHT1 is noise profile LUT weight 1 register. NP_LUT_WEIGHT1 (offset 0x0C00, total reset 0x0000_0000; PROVEN: Hi3518E V100 data sheet, PDF page 806, section 11.4).";
        field {
            name = "Weightlut_3_";
            desc = "Noise profile LUT.";
            sw = rw; hw = r;
            reset = 0x0;
        } Weightlut_3[31:24];
        field {
            name = "Weightlut_2_";
            desc = "Noise profile LUT.";
            sw = rw; hw = r;
            reset = 0x0;
        } Weightlut_2[23:16];
        field {
            name = "Weightlut_1_";
            desc = "Noise profile LUT. (The access cell of this row reads 0x0 in the data sheet; RW as in the neighboring rows.)";
            sw = rw; hw = r;
            reset = 0x0;
        } Weightlut_1[15:8];
        field {
            name = "Weightlut_0_";
            desc = "Noise profile LUT.";
            sw = rw; hw = r;
            reset = 0x0;
        } Weightlut_0[7:0];
    } NP_LUT_WEIGHT1 @ 0xc00;
    reg {
        name = "NP_LUT_WEIGHT2";
        desc = "NP_LUT_WEIGHT2 is noise profile LUT weight 2 register. NP_LUT_WEIGHT2 (offset 0x0C04, total reset 0x0000_0000; PROVEN: Hi3518E V100 data sheet, PDF page 807, section 11.4).";
        field {
            name = "Weightlut_7_";
            desc = "Noise profile LUT.";
            sw = rw; hw = r;
            reset = 0x0;
        } Weightlut_7[31:24];
        field {
            name = "Weightlut_6_";
            desc = "Noise profile LUT. (The access cell of this row reads 0x0 in the data sheet; RW as in the neighboring rows.)";
            sw = rw; hw = r;
            reset = 0x0;
        } Weightlut_6[23:16];
        field {
            name = "Weightlut_5_";
            desc = "Noise profile LUT.";
            sw = rw; hw = r;
            reset = 0x0;
        } Weightlut_5[15:8];
        field {
            name = "Weightlut_4_";
            desc = "Noise profile LUT.";
            sw = rw; hw = r;
            reset = 0x0;
        } Weightlut_4[7:0];
    } NP_LUT_WEIGHT2 @ 0xc04;
    reg {
        name = "NP_LUT_WEIGHTn";
        desc = "NP_LUT_WEIGHTn is noise profile LUT weight n register. NP_LUT_WEIGHTn (offset 0x0C7C, total reset 0x0000_0000; PROVEN: Hi3518E V100 data sheet, PDF page 807, section 11.4).";
        field {
            name = "Weightlut_127_";
            desc = "Noise profile LUT.";
            sw = rw; hw = r;
            reset = 0x0;
        } Weightlut_127[31:24];
        field {
            name = "Weightlut_126_";
            desc = "Noise profile LUT.";
            sw = rw; hw = r;
            reset = 0x0;
        } Weightlut_126[23:16];
        field {
            name = "Weightlut_125_";
            desc = "Noise profile LUT.";
            sw = rw; hw = r;
            reset = 0x0;
        } Weightlut_125[15:8];
        field {
            name = "Weightlut_124_";
            desc = "Noise profile LUT.";
            sw = rw; hw = r;
            reset = 0x0;
        } Weightlut_124[7:0];
    } NP_LUT_WEIGHTn @ 0xc7c;
    reg {
        name = "METERING_AF_THRESHOLD_WRITE";
        desc = "METERING_AF_THRESHOLD_WRITE is a preset AF threshold register. METERING_AF_THRESHOLD_WRITE (offset 0x0684, total reset 0x0000_0000; PROVEN: Hi3518E V100 data sheet, PDF page 822, section 11.4). Offset 0x0684 taken from the register summary table (the detail table has no offset text for this register).";
        field {
            name = "reserved";
            desc = "Reserved.";
            sw = rw; hw = r;
            reset = 0x0;
        } reserved_31_16[31:16];
        field {
            name = "AFthresholdwrite";
            desc = "Recommended value of AF threshold (or 0 to use threshold from previous frame). Format: unsigned 16-bit integer";
            sw = rw; hw = r;
            reset = 0x0;
        } AFthresholdwrite[15:0];
    } METERING_AF_THRESHOLD_WRITE @ 0x684;
};

`endif
