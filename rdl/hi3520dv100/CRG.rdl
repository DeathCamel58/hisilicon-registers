`ifndef CRG_RDL
`define CRG_RDL

regfile eCRG {
    name = "CRG Registers";
    desc = "
    The clock management module manages clock input, clock generation, and clock control in a unified manner as follows:

    * Manages and controls clock inputs
    * Divides and controls clock frequencies
    * Generates working clocks for each module

    ![Block Diagram](assets/crg-block-diagram.png)
    ";

    reg {
        name = "APLL configuration register 0";

        enum PERI_CRG0_apll_bypass_enum {
            NO_BYPASS = 0x0 { desc = "No bypass."; };
            BYPASS    = 0x1 { desc = "Bypass."; };
        };

        field {
            name = "APLL clock divider bypass (bypass) control.";
            encode = PERI_CRG0_apll_bypass_enum;
            reset = 0x0;
        } apll_bypass[30:30];

        field {
            name = "Level-2 output frequency divider of the APLL";
            reset = 0x2;
        } apll_postdiv2[29:27];

        field {
            name = "Level-1 output frequency divider of the APLL";
            reset = 0x1;
        } apll_postdiv1[26:24];

        field {
            name = "Decimal part of the APLL frequency multiplication coefficient";
            reset = 0x0;
        } apll_frac[23:0];

    } PERI_CRG0 @ 0x0000;

    reg {
        name = "APLL configuration register 1";
        desc = "Hardware (Hi3520D V100 board, read on hardware 2026-11-08, stock U-Boot prompt after a cold boot): reads 0x007C30A5 (apll_fbdiv = 0xA5), reset here (data sheet) 0x007C309B (apll_fbdiv = 0x9B). Boot value: the BootROM / stock boot table reprograms the APLL before the prompt, so this is not taken as the reset value.";

        field {
            enum apll_dacpd_enum {
                down = 0x0 { desc = "power-down mode"; };
                normal = 0x1 { desc = "normal operating mode"; };
            };
            name = "APLL test signal control";
            encode = apll_dacpd_enum;
            reset = 0x0;
        } apll_dacpd[23:23];

        field {
            enum apll_dsmpd_enum {
                decimal = 0x0 { desc = "decimal frequency-division mode"; };
                integral = 0x1 { desc = "integral frequency-division mode"; };
            };
            name = "APLL decimal division control";
            encode = apll_dsmpd_enum;
            reset = 0x1;
        } apll_dsmpd[22:22];

        field {
            enum apll_pd_enum {
                down = 0x0 { desc = "power-down mode"; };
                normal = 0x1 { desc = "normal operating mode"; };
            };
            name = "APLL power-down control";
            encode = apll_pd_enum;

            reset = 0x1;
        } apll_pd[21:21];

        field {
            enum apll_foutvcopd_enum {
                no = 0x0 { desc = "no output clock"; };
                normal = 0x1 { desc = "normal output clock"; };
            };
            name = "APLL VCO output power-down control";
            encode = apll_foutvcopd_enum;
            reset = 0x1;
        } apll_foutvcopd [20:20];

        field {
            enum apll_postdivpd_enum {
                no = 0x0 { desc = "no output clock"; };
                normal = 0x1 { desc = "normal clock output"; };
            };

            name = "APLL FOUT output power-down control";
            encode = apll_postdivpd_enum;
            reset = 0x1;
        } apll_postdivpd[19:19];

        field {
            enum apll_fout4phasepd_enum {
                no = 0x0 { desc = "no output clock"; };
                normal = 0x1 { desc = "normal output clock"; };
            };
            name = "APLL FOUT output power-down control";
            encode = apll_fout4phasepd_enum;
            reset = 0x1;
        } apll_fout4phasepd[18:18];

        field {
            name = "Frequency divider of the APLL reference clock";
            reset = 0x3;
        } apll_refdiv[17:12];

        field {
            name = "Integral part of the APLL frequency multiplication coefficient";
            reset = 0x9B;
        } apll_fbdiv[11:0];

    } PERI_CRG1 @ 0x0004;

    reg {
        name = "VPLL0 Configuration Register 0";
        desc = "Hardware (Hi3520D V100 board, read on hardware 2026-11-08, stock U-Boot prompt after a cold boot): reads 0x22000000 (vpll0_postdiv2 = 4, postdiv1 = 2), data sheet reset 0x12000000 (postdiv2 = 2). Boot value (VPLL0 is programmed by the boot table), not taken as the reset value.";

        field {
            enum vpll0_bypass_enum {
                no = 0x0 { desc = "not bypassed"; };
                bypass = 0x1 { desc = "bypassed"; };
            };
            name = "VPLL0 clock frequency division bypass";
            encode = vpll0_bypass_enum;
            reset = 0x0;
        } vpll0_bypass[30:30];

        field {
            name = "Level-2 output divider of VPLL0";
            reset = 0x2;
        } vpll0_postdiv2[29:27];

        field {
            name = "Level-1 output divider of VPLL0";
            reset = 0x2;
        } vpll0_postdiv1[26:24];

        field {
                name = "Decimal part of the VPLL0 frequency multiplication coefficient";
            reset = 0x0;
        } vpll0_frac[23:0];

    } PERI_CRG2 @ 0x008;

    reg {
        name = "VPLL0 Configuration Register 1";

        field {
            enum vpll0_dacpd_enum {
                down = 0x0 { desc = "power-down mode"; };
                normal = 0x1 { desc = "normal operating mode"; };
            };
            name = "VPLL0 test signal control";
            encode = vpll0_dacpd_enum;
            reset = 0x0;
        } vpll0_dacpd[23:23];

        field {
            enum vpll0_dsmpd_encode {
                decimal = 0x0 { desc = "decimal frequency-division mode"; };
                integral = 0x1 { desc = "integral frequency-division mode"; };
            };
            name = "VPLL0 decimal division control";
            encode = vpll0_dsmpd_encode;
            reset = 0x1;
        } vpll0_dsmpd[22:22];

        field {
            enum vpll0_pd_enum {
                down = 0x0 { desc = "power-down mode"; };
                normal = 0x1 { desc = "normal operating mode"; };
            };
            name = "VPLL0 power-down control";
            encode = vpll0_pd_enum;
            reset = 0x1;
        } vpll0_pd[21:21];

        field {
            enum vpll0_foutvcopd_enum {
                no = 0x0 { desc = "no output clock"; };
                normal = 0x1 { desc = "normal output clock"; };
            };
            name = "VPLL0 VCO output power-down control";
            encode = vpll0_foutvcopd_enum;
            reset = 0x1;
        } vpll0_foutvcopd[20:20];

        field {
            enum vpll0_postdivpd_enum {
                no = 0x0 { desc = "no output clock"; };
                normal = 0x1 { desc = "normal clock output"; };
            };
            name = "VPLL0 POSTDIV output power-down control";
            encode = vpll0_postdivpd_enum;
            reset = 0x1;
        } vpll0_postdivpd[19:19];

        field {
            enum vpll0_fout4phasepd_enum {
                no = 0x0 { desc = "no output clock"; };
                normal = 0x1 { desc = "normal output clock"; };
            };
            name = "VPLL0 FOUT output power-down control";
            encode = vpll0_fout4phasepd_enum;
            reset = 0x1;
        } vpll0_fout4phasepd[18:18];

        field {
            name = "Frequency divider of the VPLL0 reference clock";
            reset = 0x2;
        } vpll0_refdiv[17:12];

        field {
            name = "Integral part of the VPLL0 frequency multiplication coefficient";
            reset = 0x63;
        } vpll0_fbdiv[11:0];

    } PERI_CRG3 @ 0x000C;

    reg {
        name = "EPLL Configuration Register 0";

        field {
            enum epll_bypass_enum {
                no = 0x0 { desc = "not bypassed"; };
                bypass = 0x1 { desc = "bypassed"; };
            };
            name = "EPLL clock frequency division bypass";
            encode = epll_bypass_enum;
            reset = 0x0;
        } epll_bypass[30:30];

        field {
            name = "Level-2 output divider of EPLL";
            reset = 0x3;
        } epll_postdiv2[29:27];

        field {
            name = "Level-1 output divider of EPLL";
            reset = 0x3;
        } epll_postdiv1[26:24];

        field {
            name = "Decimal part of the EPLL frequency multiplication coefficient";
            reset = 0x0;
        } epll_frac[23:0];

    } PERI_CRG8 @ 0x0020;

    reg {
        name = "EPLL Configuration Register 1";

        field {
            enum epll_dacpd_enum {
                down = 0x0 { desc = "power-down mode"; };
                normal = 0x1 { desc = "normal operating mode"; };
            };
            name = "EPLL test signal control";
            encode = epll_dacpd_enum;
            reset = 0x0;
        } epll_dacpd[23:23];

        field {
            enum epll_dsmpd_encode {
                decimal = 0x0 { desc = "decimal frequency-division mode"; };
                integral = 0x1 { desc = "integral frequency-division mode"; };
            };
            name = "EPLL decimal division control";
            encode = epll_dsmpd_encode;
            reset = 0x1;
        } epll_dsmpd[22:22];

        field {
            enum epll_pd_enum {
                down = 0x0 { desc = "power-down mode"; };
                normal = 0x1 { desc = "normal operating mode"; };
            };
            name = "EPLL power-down control";
            encode = epll_pd_enum;
            reset = 0x1;
        } epll_pd[21:21];

        field {
            enum epll_foutvcopd_enum {
                no = 0x0 { desc = "no output clock"; };
                normal = 0x1 { desc = "normal output clock"; };
            };
            name = "EPLL VCO output power-down control";
            encode = epll_foutvcopd_enum;
            reset = 0x1;
        } epll_foutvcopd[20:20];

        field {
            enum epll_postdivpd_enum {
                no = 0x0 { desc = "no output clock"; };
                normal = 0x1 { desc = "normal clock output"; };
            };
            name = "EPLL POSTDIV output power-down control";
            encode = epll_postdivpd_enum;
            reset = 0x1;
        } epll_postdivpd[19:19];

        field {
            enum epll_fout4phasepd_enum {
                no = 0x0 { desc = "no output clock"; };
                normal = 0x1 { desc = "normal output clock"; };
            };
            name = "EPLL FOUT output power-down control";
            encode = epll_fout4phasepd_enum;
            reset = 0x1;
        } epll_fout4phasepd[18:18];

        field {
            name = "Frequency divider of the EPLL reference clock";
            reset = 0x4;
        } epll_refdiv[17:12];

        field {
            name = "Integral part of the EPLL frequency multiplication coefficient";
            reset = 0xE1;
        } epll_fbdiv[11:0];

    } PERI_CRG9 @ 0x0024;

    reg {
        name = "A9 Frequency mode and reset configuration register";
        desc = "Data sheet: bit 4 reserved, reset value 0x20 (cpu_srst_req = 1). Hardware (Hi3520D V100, after boot): reads 0x10, i.e. reserved bit 4 reads 1 and cpu_srst_req [5] reads 0. Writes should preserve bit 4. Read again on 2026-11-08 after two cold boots: 0x00000010 (stock U-Boot prompt). The A9 is running, so cpu_srst_req = 0 is a boot value; the data sheet reset 0x20 is kept.";

        enum reset_enum {
            CANCEL = 0x0 { desc = "Cancel reset"; };
            RESET  = 0x1 { desc = "Reset"; };
        };

        field {
            name = "CS soft reset request.";
            encode = reset_enum;
            reset = 0x0;
        } cs_srst_req[11:11];

        field {
            name = "SCU soft reset request.";
            encode = reset_enum;
            reset = 0x0;
        } cluster_scu_srst_req[10:10];

        field {
            name = "PERI soft reset request.";
            encode = reset_enum;
            reset = 0x0;
        } cluster_peri_srst_req[9:9];

        field {
            name = "WDG soft reset request.";
            encode = reset_enum;
            reset = 0x0;
        } sc_wd_srst_req[7:7];

        field {
            name = "DBG soft reset request.";
            encode = reset_enum;
            reset = 0x0;
        } cluster_dbg_srst_req[6:6];

        field {
            name = "CPU soft reset request. (Documentation says something about 'only valid in the slave loading mode')";
            encode = reset_enum;
            reset = 0x1;
        } cpu_srst_req[5:5];

        enum freqmode_a9_sys_enum {
            A9_AXI_2_1_0 = 0x0 { desc = "A9:AXI = 2:1"; };
            A9_AXI_2_1_1 = 0x1 { desc = "A9:AXI = 2:1"; };
            A9_AXI_2_1_2 = 0x2 { desc = "A9:AXI = 2:1"; };
            A9_AXI_1_1 = 0x3 { desc = "A9:AXI = 1:1"; };
        };

        field {
            name = "A9 clock down-conversion configuration.";
            desc = "
                A9 frequency reduction can be realized through Mask A9 clock pulse, and the frequency ratio between it and AXI clock can be adjusted.
                11: A9:AXI = 1:1
                Others: A9:AXI = 2:1
            ";
            encode = freqmode_a9_sys_enum;
            reset = 0x0;
        } freqmode_a9_sys[3:2];

    } PERI_CRG10 @ 0x0028;

    reg {
        name = "VICAP Clock and Reset Configuration Register";

        enum PERI_CRG11_vich0_divsel_enum {
            DIV2 = 0x0 { desc = "div2"; };
            DIV4 = 0x1 { desc = "div4"; };
        };

        field {
            name = "vich0_divsel";
            encode = PERI_CRG11_vich0_divsel_enum;
            reset = 0x0;
        } vich0_divsel[31:30];

        enum PERI_CRG11_vich1_divsel_enum {
            DIV2 = 0x0 { desc = "div2"; };
            DIV4 = 0x1 { desc = "div4"; };
        };

        field {
            name = "vich1_divsel";
            encode = PERI_CRG11_vich1_divsel_enum;
            reset = 0x0;
        } vich1_divsel[29:28];

        enum PERI_CRG11_vich4_divsel_enum {
            DIV2 = 0x0 { desc = "div2"; };
            DIV4 = 0x1 { desc = "div4"; };
        };

        field {
            name = "vich4_divsel";
            encode = PERI_CRG11_vich4_divsel_enum;
            reset = 0x0;
        } vich4_divsel[27:26];

        enum PERI_CRG11_vich5_divsel_enum {
            DIV2 = 0x0 { desc = "div2"; };
            DIV4 = 0x1 { desc = "div4"; };
        };

        field {
            name = "vich5_divsel";
            encode = PERI_CRG11_vich5_divsel_enum;
            reset = 0x0;
        } vich5_divsel[25:24];

        enum PERI_CRG11_vi_selftest_enum {
            NORMAL_MODE = 0x0 { desc = "normal mode (I/O input clock)"; };
            SELF_TEST_MODE = 0x1 { desc = "self test mode (on-chip 24 MHz test clock)"; };
        };

        field {
            name = "vi_selftest";
            encode = PERI_CRG11_vi_selftest_enum;
            reset = 0x0;
        } vi_selftest[22:22];

        enum PERI_CRG11_vi1_sc_sel_enum {
            VI0_PAD_INPUT = 0x0 { desc = "VI0 pad input clock"; };
            VI1_PAD_INPUT = 0x1 { desc = "VI1 pad input clock"; };
        };

        field {
            name = "vi1_sc_sel";
            encode = PERI_CRG11_vi1_sc_sel_enum;
            reset = 0x1;
        } vi1_sc_sel[21:21];

        enum PERI_CRG11_vi0_sc_sel_enum {
            VI0_PAD_INPUT = 0x0 { desc = "VI0 pad input clock"; };
            VI1_PAD_INPUT = 0x1 { desc = "VI1 pad input clock"; };
        };

        field {
            name = "vi0_sc_sel";
            encode = PERI_CRG11_vi0_sc_sel_enum;
            reset = 0x0;
        } vi0_sc_sel[20:20];

        enum PERI_CRG11_vi_adc_cksel_enum {
            V_54_MHZ = 0x0 { desc = "54 MHz"; };
            V_27_MHZ = 0x1 { desc = "27 MHz"; };
            V_24_MHZ = 0x2 { desc = "24 MHz"; };
            V_24_MHZ_3 = 0x3 { desc = "24 MHz"; };
        };

        field {
            name = "vi_adc_cksel";
            encode = PERI_CRG11_vi_adc_cksel_enum;
            reset = 0x0;
        } vi_adc_cksel[19:18];

        enum PERI_CRG11_vi_cken_ch_enum {
            DISABLE = 0x0 { desc = "disabled"; };
            ENABLE = 0x1 { desc = "enabled"; };
        };

        field {
            name = "vi_cken_ch";
            desc = "Other values: bits: bit15 = VI channel 7 ... bit8 = VI channel 0";
            encode = PERI_CRG11_vi_cken_ch_enum;
            reset = 0x0;
        } vi_cken_ch[15:8];

        enum PERI_CRG11_vi0_rst_req_enum {
            DEASSERT_RESET = 0x0 { desc = "deassert reset"; };
            RESET = 0x1 { desc = "reset"; };
        };

        field {
            name = "vi0_rst_req";
            encode = PERI_CRG11_vi0_rst_req_enum;
            reset = 0x0;
        } vi0_rst_req[7:7];

        enum PERI_CRG11_vi1_rst_req_enum {
            DEASSERT_RESET = 0x0 { desc = "deassert reset"; };
            RESET = 0x1 { desc = "reset"; };
        };

        field {
            name = "vi1_rst_req";
            encode = PERI_CRG11_vi1_rst_req_enum;
            reset = 0x0;
        } vi1_rst_req[6:6];

        enum PERI_CRG11_vi0_pctrl_enum {
            NORMAL_PHASE_CLOCK = 0x0 { desc = "normal phase clock"; };
            REVERSE_PHASE_CLOCK = 0x1 { desc = "reverse phase clock"; };
        };

        field {
            name = "vi0_pctrl";
            encode = PERI_CRG11_vi0_pctrl_enum;
            reset = 0x0;
        } vi0_pctrl[3:3];

        enum PERI_CRG11_vi1_pctrl_enum {
            NORMAL_PHASE_CLOCK = 0x0 { desc = "normal phase clock"; };
            REVERSE_PHASE_CLOCK = 0x1 { desc = "reverse phase clock"; };
        };

        field {
            name = "vi1_pctrl";
            encode = PERI_CRG11_vi1_pctrl_enum;
            reset = 0x0;
        } vi1_pctrl[2:2];

        enum PERI_CRG11_vi_hcken_enum {
            DISABLE = 0x0 { desc = "disabled"; };
            ENABLE = 0x1 { desc = "enabled"; };
        };

        field {
            name = "vi_hcken";
            encode = PERI_CRG11_vi_hcken_enum;
            reset = 0x0;
        } vi_hcken[1:1];

        enum PERI_CRG11_vi_hrst_req_enum {
            DEASSERT_RESET = 0x0 { desc = "deassert reset"; };
            RESET = 0x1 { desc = "reset"; };
        };

        field {
            name = "vi_hrst_req";
            encode = PERI_CRG11_vi_hrst_req_enum;
            reset = 0x0;
        } vi_hrst_req[0:0];

    } PERI_CRG11 @ 0x002C;

    reg {
        name = "VOU Clock and Reset Control Register";
        desc = "Hardware (Hi3520D V100 board, read on hardware 2026-11-08, stock U-Boot prompt after a cold boot): reads 0x00000037: the data-sheet resets (all clocks off, the three vo_*_srst_req bits asserted) plus reserved bits 5:4 reading 1. Not modelled (reserved).";

        enum PERI_CRG13_vou_sd1_cken_enum {
            DISABLE = 0x0 { desc = "disabled"; };
            ENABLE = 0x1 { desc = "enabled"; };
        };

        field {
            name = "vou_sd1_cken";
            encode = PERI_CRG13_vou_sd1_cken_enum;
            reset = 0x0;
        } vou_sd1_cken[11:11];

        enum PERI_CRG13_vou_sd0_cken_enum {
            DISABLE = 0x0 { desc = "disabled"; };
            ENABLE = 0x1 { desc = "enabled"; };
        };

        field {
            name = "vou_sd0_cken";
            encode = PERI_CRG13_vou_sd0_cken_enum;
            reset = 0x0;
        } vou_sd0_cken[10:10];

        enum PERI_CRG13_vou_hd_cken_enum {
            DISABLE = 0x0 { desc = "disabled"; };
            ENABLE = 0x1 { desc = "enabled"; };
        };

        field {
            name = "vou_hd_cken";
            encode = PERI_CRG13_vou_hd_cken_enum;
            reset = 0x0;
        } vou_hd_cken[9:9];

        enum PERI_CRG13_vou_hcken_enum {
            DISABLE = 0x0 { desc = "disabled"; };
            ENABLE = 0x1 { desc = "enabled"; };
        };

        field {
            name = "vou_hcken";
            encode = PERI_CRG13_vou_hcken_enum;
            reset = 0x0;
        } vou_hcken[8:8];

        enum PERI_CRG13_sddac_cken_enum {
            DISABLE = 0x0 { desc = "disabled"; };
            ENABLE = 0x1 { desc = "enabled"; };
        };

        field {
            name = "sddac_cken";
            encode = PERI_CRG13_sddac_cken_enum;
            reset = 0x0;
        } sddac_cken[7:7];

        enum PERI_CRG13_hddac_cken_enum {
            DISABLE = 0x0 { desc = "disabled"; };
            ENABLE = 0x1 { desc = "enabled"; };
        };

        field {
            name = "hddac_cken";
            encode = PERI_CRG13_hddac_cken_enum;
            reset = 0x0;
        } hddac_cken[6:6];

        enum PERI_CRG13_vo_sd_srst_req_enum {
            DEASSERT_RESET = 0x0 { desc = "deassert reset"; };
            RESET = 0x1 { desc = "reset"; };
        };

        field {
            name = "vo_sd_srst_req";
            encode = PERI_CRG13_vo_sd_srst_req_enum;
            reset = 0x1;
        } vo_sd_srst_req[2:2];

        enum PERI_CRG13_vo_hd_srst_req_enum {
            DEASSERT_RESET = 0x0 { desc = "deassert reset"; };
            RESET = 0x1 { desc = "reset"; };
        };

        field {
            name = "vo_hd_srst_req";
            encode = PERI_CRG13_vo_hd_srst_req_enum;
            reset = 0x1;
        } vo_hd_srst_req[1:1];

        enum PERI_CRG13_vo_hrst_req_enum {
            DEASSERT_RESET = 0x0 { desc = "deassert reset"; };
            RESET = 0x1 { desc = "reset"; };
        };

        field {
            name = "vo_hrst_req";
            encode = PERI_CRG13_vo_hrst_req_enum;
            reset = 0x1;
        } vo_hrst_req[0:0];

    } PERI_CRG13 @ 0x0034;

    reg {
        name = "PWM Clock and Reset Control Register";

        enum PERI_CRG14_pwm_cksel_enum {
            V_3_MHZ = 0x0 { desc = "3 MHz"; };
            V_24_MHZ = 0x1 { desc = "24 MHz"; };
        };

        field {
            name = "pwm_cksel";
            encode = PERI_CRG14_pwm_cksel_enum;
            reset = 0x0;
        } pwm_cksel[2:2];

        enum PERI_CRG14_pwm_cken_enum {
            DISABLE = 0x0 { desc = "disabled"; };
            ENABLE = 0x1 { desc = "enabled"; };
        };

        field {
            name = "pwm_cken";
            encode = PERI_CRG14_pwm_cken_enum;
            reset = 0x0;
        } pwm_cken[1:1];

        enum PERI_CRG14_pwm_srst_req_enum {
            DEASSERT_RESET = 0x0 { desc = "deassert reset"; };
            RESET = 0x1 { desc = "reset"; };
        };

        field {
            name = "pwm_srst_req";
            encode = PERI_CRG14_pwm_srst_req_enum;
            reset = 0x0;
        } pwm_srst_req[0:0];

    } PERI_CRG14 @ 0x0038;

    reg {
        name = "HDMI Clock and Reset Control Register";

        enum PERI_CRG15_hdmi_cec_clk_sel_enum {
            XTAL_DIV12_CLOCK = 0x0 { desc = "XTAL div12 clock"; };
            V_2_04_MHZ = 0x1 { desc = "2.04 MHz clock generated by dividing the PLL clock"; };
        };

        field {
            name = "hdmi_cec_clk_sel";
            encode = PERI_CRG15_hdmi_cec_clk_sel_enum;
            reset = 0x0;
        } hdmi_cec_clk_sel[6:6];

        enum PERI_CRG15_hdmi_asclk_sel_enum {
            HDMI_PHY_CLOCK = 0x0 { desc = "HDMI PHY clock"; };
            PLL_CLOCK = 0x1 { desc = "PLL clock"; };
        };

        field {
            name = "hdmi_asclk_sel";
            encode = PERI_CRG15_hdmi_asclk_sel_enum;
            reset = 0x0;
        } hdmi_asclk_sel[5:5];

        enum PERI_CRG15_hdmi_osclk_sel_enum {
            HDMI_PHY_CLOCK = 0x0 { desc = "HDMI PHY clock"; };
            PLL_CLOCK = 0x1 { desc = "PLL clock"; };
        };

        field {
            name = "hdmi_osclk_sel";
            encode = PERI_CRG15_hdmi_osclk_sel_enum;
            reset = 0x0;
        } hdmi_osclk_sel[4:4];

        enum PERI_CRG15_hdmi_idcken_enum {
            DISABLE = 0x0 { desc = "disabled"; };
            ENABLE = 0x1 { desc = "enabled"; };
        };

        field {
            name = "hdmi_idcken";
            encode = PERI_CRG15_hdmi_idcken_enum;
            reset = 0x0;
        } hdmi_idcken[3:3];

        enum PERI_CRG15_hdmi_hcken_enum {
            DISABLE = 0x0 { desc = "disabled"; };
            ENABLE = 0x1 { desc = "enabled"; };
        };

        field {
            name = "hdmi_hcken";
            encode = PERI_CRG15_hdmi_hcken_enum;
            reset = 0x0;
        } hdmi_hcken[2:2];

        enum PERI_CRG15_hdmi_srst_req_enum {
            DEASSERT_RESET = 0x0 { desc = "deassert reset"; };
            RESET = 0x1 { desc = "reset"; };
        };

        field {
            name = "hdmi_srst_req";
            encode = PERI_CRG15_hdmi_srst_req_enum;
            reset = 0x1;
        } hdmi_srst_req[0:0];

    } PERI_CRG15 @ 0x003C;

    reg {
        name = "VEDU clock and soft reset control register";

        enum PERI_CRG16_sed_cken_enum {
            DISABLE = 0x0 { desc = "disabled"; };
            ENABLE = 0x1 { desc = "enabled"; };
        };

        field {
            name = "sed_cken";
            encode = PERI_CRG16_sed_cken_enum;
            reset = 0x1;
        } sed_cken[11:11];

        enum PERI_CRG16_sed_srst_req_enum {
            DEASSERT_RESET = 0x0 { desc = "deassert reset"; };
            RESET = 0x1 { desc = "reset"; };
        };

        field {
            name = "sed_srst_req";
            encode = PERI_CRG16_sed_srst_req_enum;
            reset = 0x1;
        } sed_srst_req[10:10];

        enum PERI_CRG16_vedu0_cken_enum {
            DISABLE = 0x0 { desc = "disabled"; };
            ENABLE = 0x1 { desc = "enabled"; };
        };

        field {
            name = "vedu0_cken";
            encode = PERI_CRG16_vedu0_cken_enum;
            reset = 0x1;
        } vedu0_cken[1:1];

        enum PERI_CRG16_vedu_srst_req_enum {
            DEASSERT_RESET = 0x0 { desc = "deassert reset"; };
            RESET = 0x1 { desc = "reset"; };
        };

        field {
            name = "vedu_srst_req";
            encode = PERI_CRG16_vedu_srst_req_enum;
            reset = 0x1;
        } vedu_srst_req[0:0];

    } PERI_CRG16 @ 0x0040;

    reg {
        name = "VPSS Clock and Soft Reset Control Register";

        enum PERI_CRG18_vps_cken_enum {
            DISABLE = 0x0 { desc = "disabled"; };
            ENABLE = 0x1 { desc = "enabled"; };
        };

        field {
            name = "vps_cken";
            encode = PERI_CRG18_vps_cken_enum;
            reset = 0x1;
        } vps_cken[1:1];

        enum PERI_CRG18_vps_srst_req_enum {
            DEASSERT_RESET = 0x0 { desc = "deassert reset"; };
            RESET = 0x1 { desc = "reset"; };
        };

        field {
            name = "vps_srst_req";
            encode = PERI_CRG18_vps_srst_req_enum;
            reset = 0x1;
        } vps_srst_req[0:0];

    } PERI_CRG18 @ 0x0048;

    reg {
        name = "TDE Clock and Soft Reset Control Register";

        enum PERI_CRG22_tde_srst_req_enum {
            DEASSERT_RESET = 0x0 { desc = "deassert reset"; };
            RESET = 0x1 { desc = "reset"; };
        };

        enum PERI_CRG22_tde_cken_enum {
            DISABLED = 0x0 { desc = "disabled"; };
            ENABLED = 0x1 { desc = "enabled"; };
        };

        field {
            name = "tde_cken";
            desc = "TDE clock gating.";
            encode = PERI_CRG22_tde_cken_enum;
            reset = 0x1;
        } tde_cken[1:1];

        field {
            name = "tde_srst_req";
            encode = PERI_CRG22_tde_srst_req_enum;
            reset = 0x1;
        } tde_srst_req[0:0];

    } PERI_CRG22 @ 0x0058;

    reg {
        name = "JPGE clock and soft reset control register";

        enum PERI_CRG24_jpge_cken_enum {
            DISABLE = 0x0 { desc = "disabled"; };
            ENABLE = 0x1 { desc = "enabled"; };
        };

        field {
            name = "jpge_cken";
            encode = PERI_CRG24_jpge_cken_enum;
            reset = 0x1;
        } jpge_cken[1:1];

        enum PERI_CRG24_jpge_srst_req_enum {
            DEASSERT_RESET = 0x0 { desc = "deassert reset"; };
            RESET = 0x1 { desc = "reset"; };
        };

        field {
            name = "jpge_srst_req";
            encode = PERI_CRG24_jpge_srst_req_enum;
            reset = 0x1;
        } jpge_srst_req[0:0];

    } PERI_CRG24 @ 0x0060;

    reg {
        name = "JPGD clock and soft reset control register";

        enum PERI_CRG25_jpgd_cken_enum {
            DISABLE = 0x0 { desc = "disabled"; };
            ENABLE = 0x1 { desc = "enabled"; };
        };

        field {
            name = "jpgd_cken";
            encode = PERI_CRG25_jpgd_cken_enum;
            reset = 0x1;
        } jpgd_cken[1:1];

        enum PERI_CRG25_jpgd_srst_req_enum {
            DEASSERT_RESET = 0x0 { desc = "deassert reset"; };
            RESET = 0x1 { desc = "reset"; };
        };

        field {
            name = "jpgd_srst_req";
            encode = PERI_CRG25_jpgd_srst_req_enum;
            reset = 0x1;
        } jpgd_srst_req[0:0];

    } PERI_CRG25 @ 0x0064;

    reg {
        name = "MDU clock and soft reset control register";

        enum PERI_CRG26_mdu_cken_enum {
            DISABLE = 0x0 { desc = "disabled"; };
            ENABLE = 0x1 { desc = "enabled"; };
        };

        field {
            name = "mdu_cken";
            encode = PERI_CRG26_mdu_cken_enum;
            reset = 0x1;
        } mdu_cken[1:1];

        enum PERI_CRG26_mdu_srst_req_enum {
            DEASSERT_RESET = 0x0 { desc = "deassert reset"; };
            RESET = 0x1 { desc = "reset"; };
        };

        field {
            name = "mdu_srst_req";
            encode = PERI_CRG26_mdu_srst_req_enum;
            reset = 0x1;
        } mdu_srst_req[0:0];

    } PERI_CRG26 @ 0x0068;

    reg {
        name = "VAPU clock and soft reset control register";

        enum PERI_CRG27_vapu_cken_enum {
            DISABLE = 0x0 { desc = "disabled"; };
            ENABLE = 0x1 { desc = "enabled"; };
        };

        field {
            name = "vapu_cken";
            encode = PERI_CRG27_vapu_cken_enum;
            reset = 0x1;
        } vapu_cken[1:1];

        enum PERI_CRG27_vapu_srst_req_enum {
            DEASSERT_RESET = 0x0 { desc = "deassert reset"; };
            RESET = 0x1 { desc = "reset"; };
        };

        field {
            name = "vapu_srst_req";
            encode = PERI_CRG27_vapu_srst_req_enum;
            reset = 0x1;
        } vapu_srst_req[0:0];

    } PERI_CRG27 @ 0x006C;

    reg {
        name = "VOIE related clock and soft reset control register";

        enum PERI_CRG28_voie_cken_enum {
            DISABLE = 0x0 { desc = "disabled"; };
            ENABLE = 0x1 { desc = "enabled"; };
        };

        field {
            name = "voie_cken";
            encode = PERI_CRG28_voie_cken_enum;
            reset = 0x0;
        } voie_cken[1:1];

        enum PERI_CRG28_voie_srst_req_enum {
            DEASSERT_RESET = 0x0 { desc = "deassert reset"; };
            RESET = 0x1 { desc = "reset"; };
        };

        field {
            name = "voie_srst_req";
            encode = PERI_CRG28_voie_srst_req_enum;
            reset = 0x0;
        } voie_srst_req[0:0];

    } PERI_CRG28 @ 0x0070;

    reg {
        name = "VCMP related clock and soft reset control register";

        enum PERI_CRG29_vcmp_cken_enum {
            DISABLE = 0x0 { desc = "disabled"; };
            ENABLE = 0x1 { desc = "enabled"; };
        };

        field {
            name = "vcmp_cken";
            encode = PERI_CRG29_vcmp_cken_enum;
            reset = 0x0;
        } vcmp_cken[1:1];

        enum PERI_CRG29_vcmp_srst_req_enum {
            DEASSERT_RESET = 0x0 { desc = "deassert reset"; };
            RESET = 0x1 { desc = "reset"; };
        };

        field {
            name = "vcmp_srst_req";
            encode = PERI_CRG29_vcmp_srst_req_enum;
            reset = 0x0;
        } vcmp_srst_req[0:0];

    } PERI_CRG29 @ 0x0074;

    reg {
        name = "CIPHER related clock and soft reset control register";

        enum PERI_CRG31_cipher_cken_enum {
            DISABLE = 0x0 { desc = "disabled"; };
            ENABLE = 0x1 { desc = "enabled"; };
        };

        field {
            name = "cipher_cken";
            encode = PERI_CRG31_cipher_cken_enum;
            reset = 0x0;
        } cipher_cken[1:1];

        enum PERI_CRG31_cipher_srst_req_enum {
            DEASSERT_RESET = 0x0 { desc = "deassert reset"; };
            RESET = 0x1 { desc = "reset"; };
        };

        field {
            name = "cipher_srst_req";
            encode = PERI_CRG31_cipher_srst_req_enum;
            reset = 0x0;
        } cipher_srst_req[0:0];

    } PERI_CRG31 @ 0x007C;

    reg {
        name = "AIP MCLK Control Register";

        enum PERI_CRG32_aip_clk_sel_enum {
            AOP0_BCLK_FSCLK = 0x0 { desc = "AOP0 BCLK/FSCLK configuration is shared"; };
            AOP0_BCLK_FSCLK_1 = 0x1 { desc = "AOP0 BCLK/FSCLK configuration is not shared"; };
        };

        field {
            name = "aip_clk_sel";
            encode = PERI_CRG32_aip_clk_sel_enum;
            reset = 0x0;
        } aip_clk_sel[24:24];

        field {
            name = "aip_ckcfg";
            reset = 0x0;
        } aip_ckcfg[23:0];

    } PERI_CRG32 @ 0x0080;

    reg {
        name = "AOP0 MCLK Control Register";

        field {
            name = "aop0_ckcfg";
            reset = 0x0;
        } aop0_ckcfg[23:0];

    } PERI_CRG33 @ 0x0084;

    reg {
        name = "AOP1 MCLK Control Register";

        field {
            name = "aop1_ckcfg";
            reset = 0x0;
        } aop1_ckcfg[23:0];

    } PERI_CRG34 @ 0x0088;

    reg {
        name = "AIO Bus Clock Reset Control Register";

        enum PERI_CRG35_aio_hcken_enum {
            DISABLE = 0x0 { desc = "disabled"; };
            ENABLE = 0x1 { desc = "enabled"; };
        };

        field {
            name = "aio_hcken";
            encode = PERI_CRG35_aio_hcken_enum;
            reset = 0x0;
        } aio_hcken[1:1];

        enum PERI_CRG35_aio_hrst_req_enum {
            DEASSERT_RESET = 0x0 { desc = "deassert reset"; };
            RESET = 0x1 { desc = "reset"; };
        };

        field {
            name = "aio_hrst_req";
            encode = PERI_CRG35_aio_hrst_req_enum;
            reset = 0x0;
        } aio_hrst_req[0:0];

    } PERI_CRG35 @ 0x008C;

    reg {
        name = "AIP related clock and soft reset control register";

        enum PERI_CRG36_aip_fsclk_div_enum {
            FS_BCLK_16 = 0x0 { desc = "FS = BCLK/16"; };
            FS_BCLK_32 = 0x1 { desc = "FS = BCLK/32"; };
            FS_BCLK_48 = 0x8 { desc = "FS = BCLK/48"; };
            FS_BCLK_64 = 0x9 { desc = "FS = BCLK/64"; };
        };

        field {
            name = "aip_fsclk_div";
            desc = "Other values: other: FS = BCLK/8";
            encode = PERI_CRG36_aip_fsclk_div_enum;
            reset = 0x0;
        } aip_fsclk_div[15:12];

        enum PERI_CRG36_aip_bclk_div_enum {
            BCLK_MCLK_1 = 0x0 { desc = "BCLK = MCLK/1"; };
            BCLK_MCLK_3 = 0x1 { desc = "BCLK = MCLK/3"; };
            BCLK_MCLK_2 = 0x8 { desc = "BCLK = MCLK/2"; };
            BCLK_MCLK_4 = 0x9 { desc = "BCLK = MCLK/4"; };
        };

        field {
            name = "aip_bclk_div";
            desc = "Other values: other: BCLK = MCLK/8";
            encode = PERI_CRG36_aip_bclk_div_enum;
            reset = 0x0;
        } aip_bclk_div[11:8];

        enum PERI_CRG36_aip_bclk_sel_enum {
            EXTERNAL_BCLK_HI3520D = 0x0 { desc = "external BCLK of the Hi3520D"; };
            INTERNAL_BCLK_HI3520D = 0x1 { desc = "internal BCLK of the Hi3520D"; };
        };

        field {
            name = "aip_bclk_sel";
            encode = PERI_CRG36_aip_bclk_sel_enum;
            reset = 0x0;
        } aip_bclk_sel[4:4];

        enum PERI_CRG36_aip_bclkout_pctrl_enum {
            NORMAL_PHASE = 0x0 { desc = "normal phase"; };
            REVERSE_PHASE = 0x1 { desc = "reverse phase"; };
        };

        field {
            name = "aip_bclkout_pctrl";
            encode = PERI_CRG36_aip_bclkout_pctrl_enum;
            reset = 0x0;
        } aip_bclkout_pctrl[3:3];

        enum PERI_CRG36_aip_bclk_pctrl_enum {
            NORMAL_PHASE = 0x0 { desc = "normal phase"; };
            REVERSE_PHASE = 0x1 { desc = "reverse phase"; };
        };

        field {
            name = "aip_bclk_pctrl";
            encode = PERI_CRG36_aip_bclk_pctrl_enum;
            reset = 0x0;
        } aip_bclk_pctrl[2:2];

        enum PERI_CRG36_aip_cken_enum {
            DISABLE = 0x0 { desc = "disabled"; };
            ENABLE = 0x1 { desc = "enabled"; };
        };

        field {
            name = "aip_cken";
            encode = PERI_CRG36_aip_cken_enum;
            reset = 0x0;
        } aip_cken[1:1];

        enum PERI_CRG36_aip_srst_req_enum {
            DEASSERT_RESET = 0x0 { desc = "deassert reset"; };
            RESET = 0x1 { desc = "reset"; };
        };

        field {
            name = "aip_srst_req";
            encode = PERI_CRG36_aip_srst_req_enum;
            reset = 0x0;
        } aip_srst_req[0:0];

    } PERI_CRG36 @ 0x0090;

    reg {
        name = "AOP0 related clock and soft reset control register";

        enum PERI_CRG37_aop0_fsclk_div_enum {
            FS_BCLK_16 = 0x0 { desc = "FS = BCLK/16"; };
            FS_BCLK_32 = 0x1 { desc = "FS = BCLK/32"; };
        };

        field {
            name = "aop0_fsclk_div";
            desc = "Other values: other: FS = BCLK/8";
            encode = PERI_CRG37_aop0_fsclk_div_enum;
            reset = 0x0;
        } aop0_fsclk_div[14:12];

        enum PERI_CRG37_aop0_bclk_div_enum {
            BCLK_MCLK_1 = 0x0 { desc = "BCLK = MCLK/1"; };
            BCLK_MCLK_3 = 0x1 { desc = "BCLK = MCLK/3"; };
            BCLK_MCLK_2 = 0x8 { desc = "BCLK = MCLK/2"; };
            BCLK_MCLK_4 = 0x9 { desc = "BCLK = MCLK/4"; };
        };

        field {
            name = "aop0_bclk_div";
            desc = "Other values: other: BCLK = MCLK/8";
            encode = PERI_CRG37_aop0_bclk_div_enum;
            reset = 0x0;
        } aop0_bclk_div[11:8];

        enum PERI_CRG37_aop0_bclk_sel_enum {
            EXTERNAL_BCLK_HI3520D = 0x0 { desc = "external BCLK of the Hi3520D"; };
            INTERNAL_BCLK_HI3520D = 0x1 { desc = "internal BCLK of the Hi3520D"; };
        };

        field {
            name = "aop0_bclk_sel";
            encode = PERI_CRG37_aop0_bclk_sel_enum;
            reset = 0x0;
        } aop0_bclk_sel[4:4];

        enum PERI_CRG37_aop0_bclkout_pctrl_enum {
            NORMAL_PHASE = 0x0 { desc = "normal phase"; };
            REVERSE_PHASE = 0x1 { desc = "reverse phase"; };
        };

        field {
            name = "aop0_bclkout_pctrl";
            encode = PERI_CRG37_aop0_bclkout_pctrl_enum;
            reset = 0x0;
        } aop0_bclkout_pctrl[3:3];

        enum PERI_CRG37_aop0_bclk_pctrl_enum {
            NORMAL_PHASE = 0x0 { desc = "normal phase"; };
            REVERSE_PHASE = 0x1 { desc = "reverse phase"; };
        };

        field {
            name = "aop0_bclk_pctrl";
            encode = PERI_CRG37_aop0_bclk_pctrl_enum;
            reset = 0x0;
        } aop0_bclk_pctrl[2:2];

        enum PERI_CRG37_aop0_cken_enum {
            DISABLE = 0x0 { desc = "disabled"; };
            ENABLE = 0x1 { desc = "enabled"; };
        };

        field {
            name = "aop0_cken";
            encode = PERI_CRG37_aop0_cken_enum;
            reset = 0x0;
        } aop0_cken[1:1];

        enum PERI_CRG37_aop0_srst_req_enum {
            DEASSERT_RESET = 0x0 { desc = "deassert reset"; };
            RESET = 0x1 { desc = "reset"; };
        };

        field {
            name = "aop0_srst_req";
            encode = PERI_CRG37_aop0_srst_req_enum;
            reset = 0x0;
        } aop0_srst_req[0:0];

    } PERI_CRG37 @ 0x0094;

    reg {
        name = "AOP1 related clock and soft reset control register";

        enum PERI_CRG38_aop1_fsclk_div_enum {
            FS_BCLK_16 = 0x0 { desc = "FS = BCLK/16"; };
            FS_BCLK_32 = 0x1 { desc = "FS = BCLK/32"; };
        };

        field {
            name = "aop1_fsclk_div";
            desc = "Other values: other: FS = BCLK/8";
            encode = PERI_CRG38_aop1_fsclk_div_enum;
            reset = 0x0;
        } aop1_fsclk_div[14:12];

        enum PERI_CRG38_aop1_bclk_div_enum {
            BCLK_MCLK_1 = 0x0 { desc = "BCLK = MCLK/1"; };
            BCLK_MCLK_3 = 0x1 { desc = "BCLK = MCLK/3"; };
            BCLK_MCLK_2 = 0x8 { desc = "BCLK = MCLK/2"; };
            BCLK_MCLK_4 = 0x9 { desc = "BCLK = MCLK/4"; };
        };

        field {
            name = "aop1_bclk_div";
            desc = "Other values: other: BCLK = MCLK/8";
            encode = PERI_CRG38_aop1_bclk_div_enum;
            reset = 0x0;
        } aop1_bclk_div[11:8];

        enum PERI_CRG38_aop1_bclk_sel_enum {
            EXTERNAL_BCLK_HI3520D = 0x0 { desc = "external BCLK of the Hi3520D"; };
            INTERNAL_BCLK_HI3520D = 0x1 { desc = "internal BCLK of the Hi3520D"; };
        };

        field {
            name = "aop1_bclk_sel";
            encode = PERI_CRG38_aop1_bclk_sel_enum;
            reset = 0x0;
        } aop1_bclk_sel[4:4];

        enum PERI_CRG38_aop1_bclkout_pctrl_enum {
            NORMAL_PHASE = 0x0 { desc = "normal phase"; };
            REVERSE_PHASE = 0x1 { desc = "reverse phase"; };
        };

        field {
            name = "aop1_bclkout_pctrl";
            encode = PERI_CRG38_aop1_bclkout_pctrl_enum;
            reset = 0x0;
        } aop1_bclkout_pctrl[3:3];

        enum PERI_CRG38_aop1_bclk_pctrl_enum {
            NORMAL_PHASE = 0x0 { desc = "normal phase"; };
            REVERSE_PHASE = 0x1 { desc = "reverse phase"; };
        };

        field {
            name = "aop1_bclk_pctrl";
            encode = PERI_CRG38_aop1_bclk_pctrl_enum;
            reset = 0x0;
        } aop1_bclk_pctrl[2:2];

        enum PERI_CRG38_aop1_cken_enum {
            DISABLE = 0x0 { desc = "disabled"; };
            ENABLE = 0x1 { desc = "enabled"; };
        };

        field {
            name = "aop1_cken";
            encode = PERI_CRG38_aop1_cken_enum;
            reset = 0x0;
        } aop1_cken[1:1];

        enum PERI_CRG38_aop1_srst_req_enum {
            DEASSERT_RESET = 0x0 { desc = "deassert reset"; };
            RESET = 0x1 { desc = "reset"; };
        };

        field {
            name = "aop1_srst_req";
            encode = PERI_CRG38_aop1_srst_req_enum;
            reset = 0x0;
        } aop1_srst_req[0:0];

    } PERI_CRG38 @ 0x0098;

    reg {
        name = "SATA related clock and soft reset control register";
        desc = "
        Clock gates, reference clock select and the eight soft resets of the AHCI SATA host at 0x10080000 and its PHY (DS 14.7.5, `datasheet.txt` lines 57113-57260). Reset bits are asserted (1) after power-on
        by the hardware default of 0; the bring-up order is: PERI_CRG45 bit 11 = 0 (150 MHz reference), deassert `hrst_sata_s` (bit 1), deassert `rst_sataphy_s` (bit 0), program the PHY registers, pulse
        `rst_sataphy_s`, then deassert `rst_sata_s` (2), `rst_tx0_s` (3), `rst_rx0_s` (5), `rst_alive_s` (7) (and the port 1 resets 4 and 6 on Hi3520D/Hi3515A; Hi3515C has one port).
        Vendor driver (`ahci_sys_hi3520d_defconfig.c`, `HI_SATA_PERI_CRG` = CRG + 0xB4): `hi_sata_clk_open` sets bits 10, 9, 8 (`sata_cken`, `sata0_cken`, `sata1_cken`), `hi_sata_phy_clk_sel` clears bits 11
        and 12, `hi_sata_unreset` / `hi_sata_reset` clear / set bit 1, `hi_sata_phy_(un)reset` bit 0, `hi_sata_clk_(un)reset` set / clear bits 2-7 together. The SATA PHY analog options are in SYS_CTRL
        PERIPHCTRL3 / PERIPHCTRL25. The data sheet text at 14.7.5.1 says 'disable the clock by setting sata0_cken and sata1_cken to 1' (typo: 0).
         Hardware (Hi3520D V100 board, read on hardware 2026-11-08, stock U-Boot prompt after a cold boot): reads 0x00000000, i.e. all SATA clocks OFF (sata*_cken = 0) and no reset asserted, while the data sheet reset is 0x00000700 (clocks on). Open question: the BootROM / boot table may gate the SATA clocks, or the data sheet reset is wrong (PERI_CRG46, the USB equivalent, reads its data-sheet reset 0xFF). The reset is left at the data sheet value until it is known which. Linux must enable the clocks before touching the SATA block (the SATA host registers were not read for that reason).";

        enum PERI_CRG45_cko_alive_cksel_enum {
            INTERNAL_50_MHZ = 0x0 { desc = "internal 50 MHz CRG clock"; };
            CKO_ALIVE_CLOCK = 0x1 { desc = "cko_alive clock of the SATA PHY"; };
        };

        field {
            name = "cko_alive_cksel";
            encode = PERI_CRG45_cko_alive_cksel_enum;
            reset = 0x0;
        } cko_alive_cksel[12:12];

        enum PERI_CRG45_sata_clk_sel_enum {
            V_150_MHZ_CLOCK = 0x0 { desc = "150 MHz clock"; };
            V_50_MHZ_CLOCK = 0x1 { desc = "50 MHz clock"; };
        };

        field {
            name = "sata_clk_sel";
            encode = PERI_CRG45_sata_clk_sel_enum;
            reset = 0x0;
        } sata_clk_sel[11:11];

        enum PERI_CRG45_sata_cken_enum {
            DISABLE = 0x0 { desc = "disabled"; };
            ENABLE = 0x1 { desc = "enabled"; };
        };

        field {
            name = "sata_cken";
            encode = PERI_CRG45_sata_cken_enum;
            reset = 0x1;
        } sata_cken[10:10];

        enum PERI_CRG45_sata0_cken_enum {
            DISABLE = 0x0 { desc = "disabled"; };
            ENABLE = 0x1 { desc = "enabled"; };
        };

        field {
            name = "sata0_cken";
            encode = PERI_CRG45_sata0_cken_enum;
            reset = 0x1;
        } sata0_cken[9:9];

        enum PERI_CRG45_sata1_cken_enum {
            DISABLE = 0x0 { desc = "disabled"; };
            ENABLE = 0x1 { desc = "enabled"; };
        };

        field {
            name = "sata1_cken";
            encode = PERI_CRG45_sata1_cken_enum;
            reset = 0x1;
        } sata1_cken[8:8];

        enum PERI_CRG45_rst_alive_s_enum {
            DEASSERT_RESET = 0x0 { desc = "deassert reset"; };
            RESET = 0x1 { desc = "reset"; };
        };

        field {
            name = "rst_alive_s";
            encode = PERI_CRG45_rst_alive_s_enum;
            reset = 0x0;
        } rst_alive_s[7:7];

        enum PERI_CRG45_rst_rx1_s_enum {
            DEASSERT_RESET = 0x0 { desc = "deassert reset"; };
            RESET = 0x1 { desc = "reset"; };
        };

        field {
            name = "rst_rx1_s";
            encode = PERI_CRG45_rst_rx1_s_enum;
            reset = 0x0;
        } rst_rx1_s[6:6];

        enum PERI_CRG45_rst_rx0_s_enum {
            DEASSERT_RESET = 0x0 { desc = "deassert reset"; };
            RESET = 0x1 { desc = "reset"; };
        };

        field {
            name = "rst_rx0_s";
            encode = PERI_CRG45_rst_rx0_s_enum;
            reset = 0x0;
        } rst_rx0_s[5:5];

        enum PERI_CRG45_rst_tx1_s_enum {
            DEASSERT_RESET = 0x0 { desc = "deassert reset"; };
            RESET = 0x1 { desc = "reset"; };
        };

        field {
            name = "rst_tx1_s";
            encode = PERI_CRG45_rst_tx1_s_enum;
            reset = 0x0;
        } rst_tx1_s[4:4];

        enum PERI_CRG45_rst_tx0_s_enum {
            DEASSERT_RESET = 0x0 { desc = "deassert reset"; };
            RESET = 0x1 { desc = "reset"; };
        };

        field {
            name = "rst_tx0_s";
            encode = PERI_CRG45_rst_tx0_s_enum;
            reset = 0x0;
        } rst_tx0_s[3:3];

        enum PERI_CRG45_rst_sata_s_enum {
            DEASSERT_RESET = 0x0 { desc = "deassert reset"; };
            RESET = 0x1 { desc = "reset"; };
        };

        field {
            name = "rst_sata_s";
            encode = PERI_CRG45_rst_sata_s_enum;
            reset = 0x0;
        } rst_sata_s[2:2];

        enum PERI_CRG45_hrst_sata_s_enum {
            DEASSERT_RESET = 0x0 { desc = "deassert reset"; };
            RESET = 0x1 { desc = "reset"; };
        };

        field {
            name = "hrst_sata_s";
            encode = PERI_CRG45_hrst_sata_s_enum;
            reset = 0x0;
        } hrst_sata_s[1:1];

        enum PERI_CRG45_rst_sataphy_s_enum {
            DEASSERT_RESET = 0x0 { desc = "deassert reset"; };
            RESET = 0x1 { desc = "reset"; };
        };

        field {
            name = "rst_sataphy_s";
            encode = PERI_CRG45_rst_sataphy_s_enum;
            reset = 0x0;
        } rst_sataphy_s[0:0];

    } PERI_CRG45 @ 0x00B4;

    reg {
        name = "USB related clock and soft reset control register";
        desc = "
        Clock gate and soft resets of the USB 2.0 host controllers (EHCI 0x100B0000, OHCI 0x100A0000) and their two-port PHY (DS 14.6.3, `datasheet.txt` lines 56621-56726). All reset bits are 1 (asserted) and the
        clock is on after power-on. Deassert order (DS): wait 10 us; clear `usbphy_port0_treq` / `usbphy_port1_treq`; clear `usbphy_req`; wait 250 us; clear `usb_ctrl_utmi0_req`, `usb_ctrl_utmi1_req`,
        `usb_ctrl_hub_req`; clear `usb_ahb_srst_req`. To reset a single port: set `usb_ctrl_utmiN_req`, set `usbphy_portN_treq`, wait 200 us, clear `usbphy_portN_treq`, clear `usb_ctrl_utmiN_req`.
        Vendor driver (`hiusb-hi3520d.c`, CRG + 0xB8): start = set `usb_cken` and clear the seven reset bits in one write, 100 us delay; stop = clear `usb_cken` and set the seven reset bits. The PHY
        and controller options are in SYS_CTRL PERIPHCTRL20 (burst, UTMI, port power, over-current polarity) and PERIPHCTRL21 / PERIPHCTRL22 (PHY0 / PHY1 tuning).
        ";

        enum PERI_CRG46_usb_cken_enum {
            DISABLE = 0x0 { desc = "disabled"; };
            ENABLE = 0x1 { desc = "enabled"; };
        };

        field {
            name = "usb_cken";
            encode = PERI_CRG46_usb_cken_enum;
            reset = 0x1;
        } usb_cken[7:7];

        enum PERI_CRG46_usb_ctrl_utmi1_req_enum {
            DEASSERT_RESET = 0x0 { desc = "deassert reset"; };
            RESET = 0x1 { desc = "reset"; };
        };

        field {
            name = "usb_ctrl_utmi1_req";
            encode = PERI_CRG46_usb_ctrl_utmi1_req_enum;
            reset = 0x1;
        } usb_ctrl_utmi1_req[6:6];

        enum PERI_CRG46_usb_ctrl_utmi0_req_enum {
            DEASSERT_RESET = 0x0 { desc = "deassert reset"; };
            RESET = 0x1 { desc = "reset"; };
        };

        field {
            name = "usb_ctrl_utmi0_req";
            encode = PERI_CRG46_usb_ctrl_utmi0_req_enum;
            reset = 0x1;
        } usb_ctrl_utmi0_req[5:5];

        enum PERI_CRG46_usb_ctrl_hub_req_enum {
            DEASSERT_RESET = 0x0 { desc = "deassert reset"; };
            RESET = 0x1 { desc = "reset"; };
        };

        field {
            name = "usb_ctrl_hub_req";
            encode = PERI_CRG46_usb_ctrl_hub_req_enum;
            reset = 0x1;
        } usb_ctrl_hub_req[4:4];

        enum PERI_CRG46_usbphy_port1_treq_enum {
            DEASSERT_RESET = 0x0 { desc = "deassert reset"; };
            RESET = 0x1 { desc = "reset"; };
        };

        field {
            name = "usbphy_port1_treq";
            encode = PERI_CRG46_usbphy_port1_treq_enum;
            reset = 0x1;
        } usbphy_port1_treq[3:3];

        enum PERI_CRG46_usbphy_port0_treq_enum {
            DEASSERT_RESET = 0x0 { desc = "deassert reset"; };
            RESET = 0x1 { desc = "reset"; };
        };

        field {
            name = "usbphy_port0_treq";
            encode = PERI_CRG46_usbphy_port0_treq_enum;
            reset = 0x1;
        } usbphy_port0_treq[2:2];

        enum PERI_CRG46_usbphy_req_enum {
            DEASSERT_RESET = 0x0 { desc = "deassert reset"; };
            RESET = 0x1 { desc = "reset"; };
        };

        field {
            name = "usbphy_req";
            encode = PERI_CRG46_usbphy_req_enum;
            reset = 0x1;
        } usbphy_req[1:1];

        enum PERI_CRG46_usb_ahb_srst_req_enum {
            DEASSERT_RESET = 0x0 { desc = "deassert reset"; };
            RESET = 0x1 { desc = "reset"; };
        };

        field {
            name = "usb_ahb_srst_req";
            encode = PERI_CRG46_usb_ahb_srst_req_enum;
            reset = 0x1;
        } usb_ahb_srst_req[0:0];

    } PERI_CRG46 @ 0x00B8;

    reg {
        name = "SFC related clock and soft reset control register";
        desc = "Hardware (Hi3520D V100 board, read on hardware 2026-11-08, stock U-Boot prompt after a cold boot): reads 0x0000000E (sfc_cksel = 3, reserved encoding, sfc_cken = 1), data sheet reset 0x00000002. Boot value (the boot code selects the SFC clock to boot from SPI flash), not taken as the reset value.";

        enum PERI_CRG48_sfc_cksel_enum {
            V_24_MHZ_CLOCK = 0x0 { desc = "24 MHz clock"; };
            V_24_MHZ_CLOCK_2 = 0x2 { desc = "24 MHz clock"; };
            V_75_MHZ_CLOCK = 0x1 { desc = "75 MHz clock"; };
        };

        field {
            name = "sfc_cksel";
            encode = PERI_CRG48_sfc_cksel_enum;
            reset = 0x0;
        } sfc_cksel[3:2];

        enum PERI_CRG48_sfc_cken_enum {
            DISABLE = 0x0 { desc = "disabled"; };
            ENABLE = 0x1 { desc = "enabled"; };
        };

        field {
            name = "sfc_cken";
            encode = PERI_CRG48_sfc_cken_enum;
            reset = 0x1;
        } sfc_cken[1:1];

        enum PERI_CRG48_sfc_srst_req_enum {
            DEASSERT_RESET = 0x0 { desc = "deassert reset"; };
            RESET = 0x1 { desc = "reset"; };
        };

        field {
            name = "sfc_srst_req";
            encode = PERI_CRG48_sfc_srst_req_enum;
            reset = 0x0;
        } sfc_srst_req[0:0];

    } PERI_CRG48 @ 0x00C0;

    reg {
        name = "Clock and soft reset control registers related to ETH interface";

        enum reset_enum {
            CANCEL = 0x0 { desc = "Cancel reset"; };
            RESET  = 0x1 { desc = "Reset"; };
        };

        field {
            enum eth_rmiick_sel_enum {
                CRG = 0x0 { desc = "Select internal CRG clock"; };
                PAD = 0x1 { desc = "Select PAD input clock"; };
            };

            name = "ETH RMII CLK clock source selection.";
            encode = eth_rmiick_sel_enum;
            reset = 0x0;
        } eth_rmiick_sel[4:4];

        field {
            enum mii_rmii_mode_enum {
                MII  = 0x0 { desc = "MII mode"; };
                RMII = 0x1 { desc = "RMII mode"; };
            };

            name = "ETH MII, RMII mode configuration.";
            encode = mii_rmii_mode_enum;
            reset = 0x0;
        } mii_rmii_mode[3:3];

        field {
            name = "Soft reset request for FE PHY.";
            encode = reset_enum;
            reset = 0x0;
        } fephy_srst_req[2:2];

        field {
            enum eth_cken_enum {
                OFF = 0x0 { desc = "Turn off the clock"; };
                ON  = 0x1 { desc = "Turn on the clock"; };
            };

            name = "ETH clock gating configuration register.";
            encode = eth_cken_enum;
            reset = 0x1;
        } eth_cken[1:1];

        field {
            name = "Soft reset request for ETH.";
            encode = reset_enum;
            reset = 0x0;
        } hrst_eth_s[0:0];

    } PERI_CRG51 @ 0x00CC;

    reg {
        name = "SCD related clock and soft reset control register";

        enum PERI_CRG53_scd_cken_enum {
            DISABLE = 0x0 { desc = "disabled"; };
            ENABLE = 0x1 { desc = "enabled"; };
        };

        field {
            name = "scd_cken";
            encode = PERI_CRG53_scd_cken_enum;
            reset = 0x0;
        } scd_cken[3:3];

        enum PERI_CRG53_scd_srst_req_enum {
            DEASSERT_RESET = 0x0 { desc = "deassert reset"; };
            RESET = 0x1 { desc = "reset"; };
        };

        field {
            name = "scd_srst_req";
            encode = PERI_CRG53_scd_srst_req_enum;
            reset = 0x0;
        } scd_srst_req[1:1];

    } PERI_CRG53 @ 0x00D4;

    reg {
        name = "DDRTEST and EFUSE related clock and soft reset control register";
        desc = "Hardware (Hi3520D V100 board, read on hardware 2026-11-08, stock U-Boot prompt after a cold boot): reads 0x0000000A (ddrtest_cken = 1), data sheet reset 0x00000002. Boot value (the DDR boot table uses the DDR tester for training), not taken as the reset value.";

        enum PERI_CRG54_ddrtest_cken_enum {
            DISABLE = 0x0 { desc = "disabled"; };
            ENABLE = 0x1 { desc = "enabled"; };
        };

        field {
            name = "ddrtest_cken";
            encode = PERI_CRG54_ddrtest_cken_enum;
            reset = 0x0;
        } ddrtest_cken[3:3];

        enum PERI_CRG54_ddrtest_srst_req_enum {
            DEASSERT_RESET = 0x0 { desc = "deassert reset"; };
            RESET = 0x1 { desc = "reset"; };
        };

        field {
            name = "ddrtest_srst_req";
            encode = PERI_CRG54_ddrtest_srst_req_enum;
            reset = 0x0;
        } ddrtest_srst_req[2:2];

        enum PERI_CRG54_efuse_cken_enum {
            DISABLE = 0x0 { desc = "disabled"; };
            ENABLE = 0x1 { desc = "enabled"; };
        };

        field {
            name = "efuse_cken";
            encode = PERI_CRG54_efuse_cken_enum;
            reset = 0x1;
        } efuse_cken[1:1];

        enum PERI_CRG54_efuse_srst_req_enum {
            DEASSERT_RESET = 0x0 { desc = "deassert reset"; };
            RESET = 0x1 { desc = "reset"; };
        };

        field {
            name = "efuse_srst_req";
            encode = PERI_CRG54_efuse_srst_req_enum;
            reset = 0x0;
        } efuse_srst_req[0:0];

    } PERI_CRG54 @ 0x00D8;

    reg {
        name = "Other CRG Interface Module Soft Reset Control Register";
        desc = "Hardware (Hi3520D V100 board, read on hardware 2026-11-08, stock U-Boot prompt after a cold boot): reads 0x0007B000: uart_cksel = 0 (APB clock) while the reset here is 1 (0x0007F000). Boot value (the boot code switches the UART to the APB clock), not taken as the reset value; everything else equals the reset.";

        enum PERI_CRG57_test_clk_sel_enum {
            TEST_CLOCK_GROUP = 0x0 { desc = "test clock group 1 (USB and PCLK)"; };
            TEST_CLOCK_GROUP_1 = 0x1 { desc = "test clock group 2 (HDMI)"; };
        };

        field {
            name = "test_clk_sel";
            encode = PERI_CRG57_test_clk_sel_enum;
            reset = 0x0;
        } test_clk_sel[19:19];

        enum PERI_CRG57_uart3_cken_enum {
            DISABLE = 0x0 { desc = "disabled"; };
            ENABLE = 0x1 { desc = "enabled"; };
        };

        field {
            name = "uart3_cken";
            encode = PERI_CRG57_uart3_cken_enum;
            reset = 0x1;
        } uart3_cken[18:18];

        enum PERI_CRG57_uart2_cken_enum {
            DISABLE = 0x0 { desc = "disabled"; };
            ENABLE = 0x1 { desc = "enabled"; };
        };

        field {
            name = "uart2_cken";
            encode = PERI_CRG57_uart2_cken_enum;
            reset = 0x1;
        } uart2_cken[17:17];

        enum PERI_CRG57_uart1_cken_enum {
            DISABLE = 0x0 { desc = "disabled"; };
            ENABLE = 0x1 { desc = "enabled"; };
        };

        field {
            name = "uart1_cken";
            encode = PERI_CRG57_uart1_cken_enum;
            reset = 0x1;
        } uart1_cken[16:16];

        enum PERI_CRG57_uart0_cken_enum {
            DISABLE = 0x0 { desc = "disabled"; };
            ENABLE = 0x1 { desc = "enabled"; };
        };

        field {
            name = "uart0_cken";
            encode = PERI_CRG57_uart0_cken_enum;
            reset = 0x1;
        } uart0_cken[15:15];

        enum PERI_CRG57_uart_cksel_enum {
            APB_CLOCK = 0x0 { desc = "APB clock (82.5 MHz)"; };
            V_2_MHZ_CLOCK = 0x1 { desc = "2 MHz clock"; };
        };

        field {
            name = "uart_cksel";
            desc = "UART clock select. Hardware verified polarity (docs/hi3520d-clocks.md): 0 selects the APB clock, 1 the 2 MHz clock; the data sheet prints it the other way round (DS error). Reset 1 = 2 MHz matches the vendor U-Boot comment 'default is 2MHz'.";
            encode = PERI_CRG57_uart_cksel_enum;
            reset = 0x1;
        } uart_cksel[14:14];

        enum PERI_CRG57_ssp_cken_enum {
            DISABLE = 0x0 { desc = "disabled"; };
            ENABLE = 0x1 { desc = "enabled"; };
        };

        field {
            name = "ssp_cken";
            encode = PERI_CRG57_ssp_cken_enum;
            reset = 0x1;
        } ssp_cken[13:13];

        enum PERI_CRG57_ir_cken_enum {
            DISABLE = 0x0 { desc = "disabled"; };
            ENABLE = 0x1 { desc = "enabled"; };
        };

        field {
            name = "ir_cken";
            encode = PERI_CRG57_ir_cken_enum;
            reset = 0x1;
        } ir_cken[12:12];

        enum PERI_CRG57_uart3_srst_req_enum {
            DEASSERT_RESET = 0x0 { desc = "deassert reset"; };
            RESET = 0x1 { desc = "reset"; };
        };

        field {
            name = "uart3_srst_req";
            encode = PERI_CRG57_uart3_srst_req_enum;
            reset = 0x0;
        } uart3_srst_req[10:10];

        enum PERI_CRG57_uart2_srst_req_enum {
            DEASSERT_RESET = 0x0 { desc = "deassert reset"; };
            RESET = 0x1 { desc = "reset"; };
        };

        field {
            name = "uart2_srst_req";
            encode = PERI_CRG57_uart2_srst_req_enum;
            reset = 0x0;
        } uart2_srst_req[9:9];

        enum PERI_CRG57_uart1_srst_req_enum {
            DEASSERT_RESET = 0x0 { desc = "deassert reset"; };
            RESET = 0x1 { desc = "reset"; };
        };

        field {
            name = "uart1_srst_req";
            encode = PERI_CRG57_uart1_srst_req_enum;
            reset = 0x0;
        } uart1_srst_req[8:8];

        enum PERI_CRG57_uart0_srst_req_enum {
            DEASSERT_RESET = 0x0 { desc = "deassert reset"; };
            RESET = 0x1 { desc = "reset"; };
        };

        field {
            name = "uart0_srst_req";
            encode = PERI_CRG57_uart0_srst_req_enum;
            reset = 0x0;
        } uart0_srst_req[7:7];

        enum PERI_CRG57_ssp_srst_req_enum {
            DEASSERT_RESET = 0x0 { desc = "deassert reset"; };
            RESET = 0x1 { desc = "reset"; };
        };

        field {
            name = "ssp_srst_req";
            encode = PERI_CRG57_ssp_srst_req_enum;
            reset = 0x0;
        } ssp_srst_req[5:5];

        enum PERI_CRG57_ir_srst_req_enum {
            DEASSERT_RESET = 0x0 { desc = "deassert reset"; };
            RESET = 0x1 { desc = "reset"; };
        };

        field {
            name = "ir_srst_req";
            encode = PERI_CRG57_ir_srst_req_enum;
            reset = 0x0;
        } ir_srst_req[4:4];

        enum PERI_CRG57_rtc_srst_req_enum {
            DEASSERT_RESET = 0x0 { desc = "deassert reset"; };
            RESET = 0x1 { desc = "reset"; };
        };

        field {
            name = "rtc_srst_req";
            encode = PERI_CRG57_rtc_srst_req_enum;
            reset = 0x0;
        } rtc_srst_req[2:2];

        enum PERI_CRG57_i2c_srst_req_enum {
            DEASSERT_RESET = 0x0 { desc = "deassert reset"; };
            RESET = 0x1 { desc = "reset"; };
        };

        field {
            name = "i2c_srst_req";
            encode = PERI_CRG57_i2c_srst_req_enum;
            reset = 0x0;
        } i2c_srst_req[1:1];

        enum PERI_CRG57_test_clk_en_enum {
            ALL_TEST_CLOCKS = 0x0 { desc = "all test clocks disabled"; };
            ALL_TEST_CLOCKS_1 = 0x1 { desc = "all test clocks enabled"; };
        };

        field {
            name = "test_clk_en";
            encode = PERI_CRG57_test_clk_en_enum;
            reset = 0x0;
        } test_clk_en[0:0];

    } PERI_CRG57 @ 0x00E4;

    reg {
        name = "CRG status register";
        desc = "Hardware (Hi3520D V100 board, read on hardware 2026-11-08, stock U-Boot prompt after a cold boot): reads 0x00000007 (all three PLLs locked). Status, not a reset value: the lock bits depend on the PLL state, so the reset stays 0.";

        enum lock_unlock_enum {
            unlocked = 0x0 { desc = "unlocked"; };
            locked = 0x1 { desc = "locked"; };
        };

        field {
            name = "EPLL lock status";
            encode = lock_unlock_enum;
            sw = r;
            hw = w;
            reset = 0x0;
        } epll_lock[2:2];

        field {
            name = "VPLL0 lock status";
            encode = lock_unlock_enum;
            sw = r;
            hw = w;
            reset = 0x0;
        } vpll0_lock[1:1];

        field {
            name = "APLL lock status";
            encode = lock_unlock_enum;
            sw = r;
            hw = w;
            reset = 0x0;
        } apll_lock[0:0];

    } PERI_CRG58 @ 0x00E8;

    reg {
        name = "SpeedMonitor Control Register";

        enum PERI_CRG61_osc_en_enum {
            DISABLE = 0x0 { desc = "disabled"; };
            ENABLE = 0x1 { desc = "enabled"; };
        };

        field {
            name = "osc_en";
            encode = PERI_CRG61_osc_en_enum;
            reset = 0x0;
        } osc_en[2:2];

        enum PERI_CRG61_osc_mode_enum {
            V_150_STEP_LEVEL = 0x0 { desc = "150-step level"; };
            V_200_STEP_LEVEL = 0x1 { desc = "200-step level"; };
        };

        field {
            name = "osc_mode";
            encode = PERI_CRG61_osc_mode_enum;
            reset = 0x0;
        } osc_mode[1:1];

        enum PERI_CRG61_osc_clk_en_enum {
            DISABLE = 0x0 { desc = "disabled"; };
            ENABLE = 0x1 { desc = "enabled"; };
        };

        field {
            name = "osc_clk_en";
            encode = PERI_CRG61_osc_clk_en_enum;
            reset = 0x0;
        } osc_clk_en[0:0];

    } PERI_CRG61 @ 0x00F4;

    reg {
        name = "SpeedMonitor Status Register 1";

        enum PERI_CRG62_osc_valid_enum {
            INVALID = 0x0 { desc = "invalid"; };
            VALID = 0x1 { desc = "valid"; };
        };

        field {
            name = "osc_valid";
            sw = r;
            hw = w;
            encode = PERI_CRG62_osc_valid_enum;
            reset = 0x0;
        } osc_valid[9:9];

        field {
            name = "osc_value";
            sw = r;
            hw = w;
            reset = 0x0;
        } osc_value[8:0];

    } PERI_CRG62 @ 0x00F8;

};
`endif
