`include "defines.rdl"

`include "CRG.rdl"
`include "../common/ARM_PL011.rdl"
`include "../common/ARM_PL061.rdl"
`include "../common/ARM_PL190.rdl"
`include "../common/HISI_AIAO.rdl"
`include "../common/HISI_CIPHER_MC.rdl"
`include "../common/HISI_DDRC_V2.rdl"
`include "../common/HISI_DDRT.rdl"
`include "../common/HISI_DMAC.rdl"
`include "../common/HISI_DWMMC.rdl"
`include "../common/HISI_FEMAC.rdl"
`include "../common/HISI_FMC.rdl"
`include "../common/HISI_HASH.rdl"
`include "../common/HISI_I2C_DW.rdl"
`include "../common/HISI_IO_CONFIG_V2.rdl"
`include "../common/HISI_IR.rdl"
`include "../common/HISI_ISP.rdl"
`include "../common/HISI_IVE.rdl"
`include "../common/HISI_JPGE.rdl"
`include "../common/HISI_KEY_CTRL.rdl"
`include "../common/HISI_LSADC.rdl"
`include "../common/HISI_MIPI_RX.rdl"
`include "../common/HISI_MISC_CTRL.rdl"
`include "../common/HISI_PMC.rdl"
`include "../common/HISI_PWM.rdl"
`include "../common/HISI_RNG.rdl"
`include "../common/HISI_RSA.rdl"
`include "../common/HISI_RTC_SPI.rdl"
`include "../common/HISI_RTC_SPI_V2.rdl"
`include "../common/HISI_SPI.rdl"
`include "../common/HISI_SYS_CTRL_V2.rdl"
`include "../common/HISI_TDE.rdl"
`include "../common/HISI_TIMER_SP804.rdl"
`include "../common/HISI_USB_DEVICE.rdl"
`include "../common/HISI_USB_HOST.rdl"
`include "../common/HISI_VDP_V2.rdl"
`include "../common/HISI_VEDU.rdl"
`include "../common/HISI_VICAP_V2.rdl"
`include "../common/HISI_VGS.rdl"
`include "../common/HISI_VPSS.rdl"
`include "../common/HISI_WDG_SP805.rdl"

addrmap hi3516cv200 {
    name = "hi3516cv200 registers";
    desc = "
        **Hi3516C V200**: the 273-pin member of the Hi3518E V20X / Hi3516C V200 family. Its register map, CRG, SYS_CTRL, MISC, IO-config and peripheral blocks are the ones of the `hi3518ev200` addrmap (same data sheet, same block instances); this entry exists so that the chip is found under its own name. It differs from the Hi3518E V200 in the CPU speed (600 MHz), the external DDR2/DDR3/DDR3L interface (up to 4 Gbit, 400 MHz), the package (more pins exposed, differential MIPI) and the encoder performance; SCSYSID0[31:24] reads 0x01.

        ## Datasheets

        * [Full Datasheet](assets/Hi3518EV20X-Hi3516CV200-Datasheet.pdf): Hi3518E V20X / Hi3516C V200 Economical HD IP Camera SoC Data Sheet, issue 02 (2017-06-12). One document for the Hi3518E V200, Hi3518E V201 and Hi3516C V200: one address map (Table 1-4), one CRG/SYS_CTRL/MISC/IO-config register set, one interrupt table; the chips differ only in package/pin list, CPU speed, DDR and codec performance (see Variants). This is HiSilicon's own English edition; no Chinese original is available in this workspace, so vendor code (U-Boot 2010.06 `hi3518ev200`, Linux `clk-hi3518ev20x.c`, OpenIPC `hi3518ev20x.dtsi`) was used to settle disputed values, as noted in the block descriptions.

        ## Facts

        * CPU: ARM926EJ-S (ARMv5TEJ), 32 KB I-cache + 32 KB D-cache, 600 MHz (Hi3518E V20X: 540 MHz); no VFP/NEON, no L2, no GIC: the interrupt controller is an ARM PL190 VIC at 0x100D0000 (32 sources, see Interrupts).
        * DDR: external 16-bit DDR2/DDR3/DDR3L, up to 4 Gbit (512 MB), max 400 MHz (the Hi3518E V200/V201 have an embedded 512 / 256 Mbit DDR2 instead); DDR window 0x80000000. SPI flash window 0x58000000 (64 MB). On-chip RAM 0x04010000 (64 KB), BOOTROM 0x04000000. DDRC at 0x20110000 (eHISI_DDRC_V2), the DDR PHY at 0x20118000 inside the same window (vendor U-Boot `DDR_PHY0_REG_BASE`).
        * Boot: BOOTROM_SEL (pin MDCK) = 1: serial download (BOOTROM); BOOTROM_SEL = 0: BOOT_SEL (pin EPHY_RST) 0 = SPI flash (NOR 3/4-byte or NAND 1/4-wire by the SFC_DEVICE_MODE (pin SHUTTER_TRIG) / SFC_EMMC_BOOT_MODE (pin FLASH_TRIG) straps), 1 = eMMC (4/8-wire by SFC_EMMC_BOOT_MODE). The straps are readable in SYS_CTRL SYSSTAT. After POR the boot memory (BOOTROM, or SFC CS0) is remapped to address 0 (SC_CTRL remapstat); the boot code clears the remap with SC_CTRL remapclear.
        * Clocks: 24 MHz XIN crystal into three PLLs (APLL = CPU, VPLL = 1188 MHz video/bus tree, EPLL = 1000 MHz) in the CRG; the CPU and the bus run from the crystal after reset. 32.768 kHz RTC_XIN for the RTC.
        * Chip ID: SYS_CTRL SCSYSID3..0 = 0x3518E200 for all three chips; SCSYSID0[31:24] (`chipid`) distinguishes them: 0x01 = Hi3516C V200, 0x02 = Hi3518E V200, 0x03 = Hi3518E V201. The vendor U-Boot only checks the 32-bit ID (`_HI3518EV200 0x3518e200`), which is why its SoC string reads `hi3518ev200` on this chip too (tools print it as `hi3518ev200 (hi3516cv200)`).

        ## Variants (data sheet chapter 1 and 4.1)

        | | Hi3518E V200 | Hi3518E V201 | Hi3516C V200 |
        |---|---|---|---|
        | SCSYSID0[31:24] | 0x02 | 0x03 | 0x01 |
        | CPU | ARM926 @ 540 MHz | ARM926 @ 540 MHz | ARM926 @ 600 MHz |
        | DDR | embedded 16-bit DDR2, 512 Mbit, 360 MHz | embedded 16-bit DDR2, 256 Mbit, 360 MHz | external 16-bit DDR2/DDR3/DDR3L, up to 4 Gbit, 400 MHz |
        | Package | TFBGA 192, 10 x 10 mm | TFBGA 192, 10 x 10 mm | TFBGA 273, 12 x 12 mm |
        | Encoder | 1080p@20 | 960p@25, no lens distortion correction, no 90/270 rotation | 1080p@30 |
        | MIPI | - | - | differential (MIPI/LVDS) and single-ended modes on the VI pins |

        The register map, the CRG, SYS_CTRL, MISC, IO-config (same mux register set; the 273-pin part exposes more of the pins) and all peripheral blocks are documented once for the three chips; this `hi3516cv200` entry is the same map under the chip's own name (`hi3518ev200` is the primary entry).

        ## Interrupts (PL190 VIC source numbers, data sheet Table 3-8)

        | # | Source | # | Source | # | Source | # | Source |
        |---|--------|---|--------|---|--------|---|--------|
        | 0 | Global soft interrupt (SYS_CTRL SOLFINT) | 8 | GZIP / SDIO1 | 16 | USB OHCI | 24 | AVC (H.264 encoder) |
        | 1 | Watchdog | 9 | AIAO | 17 | VPSS | 25 | UART2 |
        | 2 | RTC / Temper_Cap | 10 | USB device | 18 | SDIO0 | 26 | JPGE |
        | 3 | Timer0 / Timer1 | 11 | FMC | 19 | IR / SAR ADC | 27 | TDE |
        | 4 | Timer2 / Timer3 | 12 | ETH | 20 | I2C0 / I2C1 / I2C2 | 28 | MIPI |
        | 5 | UART0 | 13 | CIPHER | 21 | IVE | 29 | VGS |
        | 6 | SSP0 (SPI0) | 14 | DMAC | 22 | VICAP | 30 | UART1 |
        | 7 | SSP1 (SPI1) | 15 | USB EHCI | 23 | VDP | 31 | GPIO0-GPIO8 (one shared line) |

        Shared lines (timers, GZIP/SDIO1, RTC/Temper_Cap, IR/SAR ADC, the three I2Cs, the nine GPIOs) must be demultiplexed from the peripheral's own status registers. The OpenIPC/vendor device tree `hi3518ev20x.dtsi` uses the same numbers (timers 3/4, UART0/1/2 = 5/30/25, SPI 6/7, SDIO0/1 = 18/8, USB 10/15/16, ETH 12, I2C 20, GPIO 31).

        ## Addresses

        | Start Address | End Address | Description | Capacity | Documented Here |
        |---------------|-------------|-------------|----------|-----------------|
        | 0x00000000    | 0x03FFFFFF  | Boot memory (remapped): SPI flash when {BOOT_SEL, BOOTROM_SEL} = 00, else BOOTROM; the on-chip RAM after the remap is cleared (SC_CTRL remapclear) | 64 MB | &#10060; |
        | 0x04000000    | 0x0400FFFF  | BOOTROM | 64 KB | &#10060; |
        | 0x04010000    | 0x0401FFFF  | On-chip RAM | 64 KB | &#10060; |
        | 0x04020000    | 0x0FFFFFFF  | Reserved | - | &#10060; |
        | 0x10000000    | 0x1000FFFF  | Reserved | 64 KB | &#10060; |
        | 0x10010000    | 0x1001FFFF  | FMC control register | 64 KB | &#9989; |
        | 0x10020000    | 0x1002FFFF  | SDIO0 register | 64 KB | &#9989; |
        | 0x10030000    | 0x1003FFFF  | SDIO1 register | 64 KB | &#9989; |
        | 0x10040000    | 0x1004FFFF  | Reserved | 64 KB | &#10060; |
        | 0x10050000    | 0x1005FFFF  | Reserved | 64 KB | &#10060; |
        | 0x10060000    | 0x1006FFFF  | DMAC register | 64 KB | &#9989; |
        | 0x10070000    | 0x1007FFFF  | HASH register | 64 KB | &#9989; |
        | 0x10080000    | 0x1008FFFF  | USB device register | 64 KB | &#9989; |
        | 0x10090000    | 0x1009FFFF  | ETH register | 64 KB | &#9989; |
        | 0x100A0000    | 0x100AFFFF  | USB OHCI register | 64 KB | &#9989; |
        | 0x100B0000    | 0x100BFFFF  | USB EHCI register | 64 KB | &#9989; |
        | 0x100C0000    | 0x100CFFFF  | Cipher register | 64 KB | &#9989; |
        | 0x100D0000    | 0x100DFFFF  | Interrupt control register | 64 KB | &#9989; |
        | 0x100E0000    | 0x1FFFFFFF  | Reserved | - | &#10060; |
        | 0x20000000    | 0x2000FFFF  | Timer 0/Timer 1 register | 64 KB | &#9989; |
        | 0x20010000    | 0x2001FFFF  | Timer 2/Timer 3 register | 64 KB | &#9989; |
        | 0x20020000    | 0x2002FFFF  | Reserved | 64 KB | &#10060; |
        | 0x20030000    | 0x2003FFFF  | CRG register | 64 KB | &#9989; |
        | 0x20040000    | 0x2004FFFF  | WDG register | 64 KB | &#9989; |
        | 0x20050000    | 0x2005FFFF  | SYS_CTRL register | 64 KB | &#9989; |
        | 0x20060000    | 0x2006FFFF  | RTC register | 64 KB | &#9989; |
        | 0x20070000    | 0x2007FFFF  | IR register | 64 KB | &#9989; |
        | 0x20080000    | 0x2008FFFF  | UART0 register | 64 KB | &#9989; |
        | 0x20090000    | 0x2009FFFF  | UART1 register | 64 KB | &#9989; |
        | 0x200A0000    | 0x200AFFFF  | UART2 register | 64 KB | &#9989; |
        | 0x200B0000    | 0x200BFFFF  | SAR_ADC register | 64 KB | &#9989; |
        | 0x200C0000    | 0x200CFFFF  | SPI0 register | 64 KB | &#9989; |
        | 0x200D0000    | 0x200DFFFF  | I2C0 register | 64 KB | &#9989; |
        | 0x200E0000    | 0x200EFFFF  | SPI1 register | 64 KB | &#9989; |
        | 0x200F0000    | 0x200F07FF  | IO MUX register | 2 KB | &#9989; |
        | 0x200F0800    | 0x200FFFFF  | IO CTR register | 62 KB | &#10060; |
        | 0x20100000    | 0x201007FF  | Reserved | 2 KB | &#10060; |
        | 0x20100800    | 0x2010FFFF  | cipher_hash_key_ctrl register | 62 KB | &#9989; |
        | 0x20110000    | 0x2011FFFF  | DDRC/DDR PHY register (DDRC at 0x20110000, DDR PHY at 0x20118000) | 64 KB | &#9989; |
        | 0x20120000    | 0x2012FFFF  | MISC register | 64 KB | &#9989; |
        | 0x20130000    | 0x2013FFFF  | PWM register | 64 KB | &#9989; |
        | 0x20140000    | 0x2014FFFF  | GPIO0 register | 64 KB | &#9989; |
        | 0x20150000    | 0x2015FFFF  | GPIO1 register | 64 KB | &#9989; |
        | 0x20160000    | 0x2016FFFF  | GPIO2 register | 64 KB | &#9989; |
        | 0x20170000    | 0x2017FFFF  | GPIO3 register | 64 KB | &#9989; |
        | 0x20180000    | 0x2018FFFF  | GPIO4 register | 64 KB | &#9989; |
        | 0x20190000    | 0x2019FFFF  | GPIO5 register | 64 KB | &#9989; |
        | 0x201A0000    | 0x201AFFFF  | GPIO6 register | 64 KB | &#9989; |
        | 0x201B0000    | 0x201BFFFF  | GPIO7 register | 64 KB | &#9989; |
        | 0x201C0000    | 0x201CFFFF  | GPIO8 register | 64 KB | &#9989; |
        | 0x201D0000    | 0x201DFFFF  | Reserved | 64 KB | &#10060; |
        | 0x201E0000    | 0x201EFFFF  | Reserved | 64 KB | &#10060; |
        | 0x201F0000    | 0x201FFFFF  | Reserved | 64 KB | &#10060; |
        | 0x20200000    | 0x2020FFFF  | Reserved | 64 KB | &#10060; |
        | 0x20210000    | 0x2021FFFF  | Reserved | 64 KB | &#10060; |
        | 0x20220000    | 0x2022FFFF  | Reserved | 64 KB | &#10060; |
        | 0x20230000    | 0x2023FFFF  | Reserved | 64 KB | &#10060; |
        | 0x20240000    | 0x2024FFFF  | I2C1 register | 64 KB | &#9989; |
        | 0x20250000    | 0x2025FFFF  | I2C2 register | 64 KB | &#9989; |
        | 0x20260000    | 0x2026FFFF  | RSA register | 64 KB | &#9989; |
        | 0x20270000    | 0x2027FFFF  | PMC register | 64 KB | &#9989; |
        | 0x20280000    | 0x2028FFFF  | TRNG register | 64 KB | &#9989; |
        | 0x20290000    | 0x2057FFFF  | Reserved | - | &#10060; |
        | 0x20580000    | 0x205BFFFF  | VICAP register | 256 KB | &#9989; |
        | 0x205C0000    | 0x205CFFFF  | VDP register | 64 KB | &#9989; |
        | 0x205D0000    | 0x205FFFFF  | Reserved | - | &#10060; |
        | 0x20600000    | 0x2060FFFF  | VPSS register | 64 KB | &#9989;  |
        | 0x20610000    | 0x2061FFFF  | TDE register | 64 KB | &#9989;  |
        | 0x20620000    | 0x2062FFFF  | AVC register | 64 KB | &#9989;  |
        | 0x20630000    | 0x2063FFFF  | VGS register | 64 KB | &#9989; |
        | 0x20640000    | 0x2064FFFF  | Reserved | 64 KB | &#10060; |
        | 0x20650000    | 0x2065FFFF  | AIAO register | 64 KB | &#9989; |
        | 0x20660000    | 0x2066FFFF  | JPGE register | 64 KB | &#9989; |
        | 0x20670000    | 0x2067FFFF  | Reserved | - | &#10060; |
        | 0x20680000    | 0x2068FFFF  | MIPI register | 64 KB | &#9989; |
        | 0x20690000    | 0x2069FFFF  | Reserved | 64 KB | &#10060; |
        | 0x206A0000    | 0x206AFFFF  | IVE register | 64 KB | &#9989; |
        | 0x206B0000    | 0x206BFFFF  | Reserved (GZIP in the vendor U-Boot, `GZIP_REG_BASE`, used for the fast-boot snapshot) | - | &#10060; |
        | 0x206C0000    | 0x206CFFFF  | Reserved | 64 KB | &#10060; |
        | 0x206D0000    | 0x206DFFFF  | DDR test module | 64 KB | &#9989;  |
        | 0x206E0000    | 0x206EFFFF  | Reserved | 64 KB | &#10060; |
        | 0x206F0000    | 0x206FFFFF  | Reserved | 64 KB | &#10060; |
        | 0x20700000    | 0x4FFFFFFF  | Reserved | - | &#10060; |
        | 0x50000000    | 0x53FFFFFF  | Reserved | 64 MB | &#10060; |
        | 0x54000000    | 0x57FFFFFF  | Reserved | 64 MB | &#10060; |
        | 0x58000000    | 0x5BFFFFFF  | Storage space of the SPI flash | 64 MB | &#10060; |
        | 0x5C000000    | 0x7FFFFFFF  | Reserved | - | &#10060; |
        | 0x80000000    | 0x9FFFFFFF  | Address space of the connected external DDR (Hi3518E V200: 64 MB, Hi3518E V201: 32 MB, Hi3516C V200: up to 512 MB) | 512 MB | &#10060; |
        | 0xA0000000    | 0xFFFFFFFF  | Reserved | - | &#10060; |

        &#9989; = a register block is described in this addrmap; &#10060; = not described (reserved, memory window, or media/ISP/security block outside the bring-up scope). The address table is the data sheet's Table 1-4 (the on-chip RAM/BOOTROM remark of the 0x00000000 row and the DDR size remark of the 0x80000000 row are restored from the data sheet text). This file and `hi3518ev200.rdl` carry the same table and instance list: change both.

        <!-- overview:begin -->

        ### Diagrams

        ![Logic block diagram](assets/diagrams/hi3516cv200-logic.svg)

        ![Register blocks by function](assets/diagrams/hi3516cv200-blocks.svg)

        ![Clock tree](assets/diagrams/hi3516cv200-clocks.svg)

        ![Boot flow](assets/diagrams/hi3516cv200-boot.svg)

        ![Video pipeline](assets/diagrams/hi3516cv200-video.svg)

        ![Reset tree](assets/diagrams/hi3516cv200-resets.svg)

        ![Storage, USB and Ethernet paths](assets/diagrams/hi3516cv200-io.svg)

        ![DMA request lines](assets/diagrams/hi3516cv200-dma.svg)

        ![Bus masters and DDR QoS groups](assets/diagrams/hi3516cv200-busqos.svg)

        ![Power domains](assets/diagrams/hi3516cv200-power.svg)

        ![CRG register map](assets/diagrams/hi3516cv200-crgmap.svg)

        ![IP editions across the camera family](assets/diagrams/hi3516cv200-editions.svg)

        ### Pass-2 additions (2026-11-15)

        The Hi3518E V200 / V201 / Hi3516C V200 root descriptions above already carry the variants table, the boot description, the interrupt table and the facts list; the additions below are the DMA lines, pin multiplexing, clocks, reset/power, bus ports and the extra diagrams.

        ### Camera family comparison (data sheet chapter 1)

        One column per chip, taken from the data sheets named in the header row below; `-` = the sheet gives no value. The Hi3518 sheet covers the A and C variants; the Hi3518E V200 sheet covers V200, V201 and Hi3516C V200.

        | Item | Hi3516 V100 | Hi3516C V100 | Hi3518A V100 | Hi3518C V100 | Hi3518E V100 | Hi3516C V300 | Hi3516E V100 | Hi3518E V200 | Hi3518E V201 | Hi3516C V200 |
        |---|---|---|---|---|---|---|---|---|---|---|
        | Data sheet (issue, date, language) | 00B60 2011-08-12, Chinese | 00B02 2013-02-05 | Hi3518 sheet (A and C in one document) | same document as A | 03 2015-11-26 | 05 2018-05-10 (C V300 and E V100 in one document) | same document as C V300 | 02 2017-06-12 (one document for V200, V201, Hi3516C V200) | same document | same document |
        | CPU | Cortex-A9 up to 800 MHz, VFP, 32 KB I + 32 KB D L1, 256 KB L2, about 2000 DMIPS | ARM926 up to 440 MHz, 16 KB I + 16 KB D, 2 KB ITCM | ARM926 up to 440 MHz, 16 KB I + 16 KB D, 2 KB ITCM | ARM926 up to 440 MHz, 16 KB I + 16 KB D, 2 KB ITCM | ARM926 up to 440 MHz, 16 KB I + 16 KB D | ARM926 up to 800 MHz, 32 KB I + 32 KB D | ARM926 up to 800 MHz, 32 KB I + 32 KB D | ARM926 540 MHz, 32 KB I + 32 KB D | ARM926 540 MHz, 32 KB I + 32 KB D | ARM926 600 MHz, 32 KB I + 32 KB D |
        | Interrupt controller | ARM GIC (A9 MPCore), IDs 0-31 internal | PL190 VIC | PL190 VIC | PL190 VIC | PL190 VIC | PL190 VIC | PL190 VIC | PL190 VIC | PL190 VIC | PL190 VIC |
        | DDR | DDR2/DDR3, 32 or 16 bit, up to 500 MHz, 1 GB (32 bit) / 512 MB (16 bit) | DDR2/DDR3, 16 bit, up to 440 MHz, up to 256 MB | DDR2/DDR3, 16 bit, up to 400 MHz, up to 256 MB | DDR2/DDR3, 16 bit, up to 400 MHz, up to 128 MB | embedded 16-bit DDR2, up to 512 Mbit | external 16-bit DDR3/DDR3L, up to 4 Gbit | embedded 512 Mbit DDR (1.8 V) | embedded 16-bit DDR2 512 Mbit, 360 MHz | embedded 16-bit DDR2 256 Mbit, 360 MHz | external 16-bit DDR2/DDR3/DDR3L, up to 4 Gbit, 400 MHz |
        | Boot media | NAND, SPI flash, or PCIe load into DDR | SPI NOR, NAND | SPI NOR, NAND | SPI NOR only | SPI NOR only | SPI NOR/NAND, eMMC (4-bit), serial (fastboot), SD/USB update | same as C V300 (SPI NOR/NAND, eMMC, fastboot, update) | serial (BOOTROM), SPI NOR/NAND, eMMC | same as V200 | same as V200 |
        | Flash controllers | NANDC (2 CS), SFC (2 CS) | SFC (1 CS), NANDC | SFC (1 CS), NANDC | SFC (1 CS) | SFC (1 CS) | FMC (SPI NOR/NAND), eMMC via MMC | FMC, eMMC via MMC | FMC, eMMC | FMC, eMMC | FMC, eMMC |
        | Video encoder | H.264 BP/MP/HP, MPEG4 SP, JPEG; up to 16 Mpixel | H.264 BP/MP, MJPEG/JPEG; 1080p@30 + VGA@30 + JPEG 1080p@1 | H.264 BP/MP, MJPEG/JPEG; 720p@30 + VGA@30 + QVGA@30 + JPEG 720p@1 | H.264 BP/MP, MJPEG/JPEG; 720p@30 + QVGA@30 + JPEG 720p@1 | H.264 BP/MP, MJPEG/JPEG; 720p@25 + JPEG 720p@3 | H.264 BP/MP/HP, H.265 Main, MJPEG/JPEG; 2048x2048@15 + 640x640@15, or 1080p@30 + 480p@30 + 240p@30 | same codecs; 1536x1536 (width up to 2048); 1080p@20 + 576p@20 | H.264 BP/MP/HP, MJPEG/JPEG; 1080p@20 | H.264 BP/MP/HP, MJPEG/JPEG; 960p@25 (no LDC, no 90/270 rotation) | H.264 BP/MP/HP, MJPEG/JPEG; 1080p@30 |
        | Video in | 8-16 bit RGB Bayer up to 150 MHz, BT.601/656/1120, dual sensor | 8/10/12-bit Bayer up to 74.25 MHz, BT.656/BT.1120 | 8/10/12-bit Bayer up to 74.25 MHz, BT.656/BT.1120 | 8/10/12-bit Bayer up to 74.25 MHz, BT.656/BT.1120 | 8/10/12-bit Bayer up to 74.25 MHz, BT.656/BT.1120, 1080p@30 / 720p@30 | 8-14 bit Bayer DC, BT.601/656/1120, MIPI, LVDS/sub-LVDS, HiSPi, up to 2048x2048 and 250 Mpixel/s | same as C V300 | MIPI / LVDS / HiSPi / BT.656 (VICAP) | same as V200 | same as V200, plus differential and single-ended pin modes |
        | Video out | CVBS, BT.656, BT.1120 (1080p@30) | CVBS, BT.1120 (1080p@30) | CVBS, BT.1120 | BT.1120 (no CVBS) | BT.1120 (no CVBS) | PAL/NTSC CVBS, BT.656, 6-bit RGB565 LCD | BT.656, RGB565 LCD (no CVBS) | - | - | - |
        | Ethernet | GMAC 10/100/1000, RGMII/MII | MAC 10/100, RGMII/MII | MAC 10/100, RGMII/MII | MAC 10/100, RGMII/MII | MAC 10/100, RMII/MII | MAC 10/100 RMII, TSO | MAC 10/100 RMII, TSO | MAC + internal FE PHY | MAC + internal FE PHY | MAC + internal FE PHY |
        | USB | 2 x USB 2.0 host | 1 x USB 2.0 host | 1 x USB 2.0 host | 1 x USB 2.0 host | 1 x USB 2.0 host | 1 x USB 2.0 host/device | 1 x USB 2.0 host/device | USB 2.0 host/device | USB 2.0 host/device | USB 2.0 host/device |
        | SDIO/MMC | 2 x MMC (SD/SDIO/eMMC) | 1 x SDIO 2.0 | 1 x SDIO 2.0 | 1 x SDIO 2.0 | 1 x SDIO 2.0 | 3 x SDIO 2.0 (two with 3.3/1.8 V) + eMMC 4.5 | 3 x SDIO 2.0 + eMMC 4.5 | 2 x SDIO + eMMC | 2 x SDIO + eMMC | 2 x SDIO + eMMC |
        | Package | FC-CSP 416, 15x15 mm, 0.65 mm | FCBGA 293, 13x13x1.37 mm, 0.65 mm | FCBGA 293, 13x13x1.37 mm, 0.65 mm | ePad QFP, 20x20x1.0 mm, 0.4 mm | BGA 220, 11x11 mm, 0.65 mm | TFBGA 273, 12x12 mm, 0.65 mm | TFBGA 231, 10x14 mm, 0.65 mm | TFBGA 192, 10x10 mm | TFBGA 192, 10x10 mm | TFBGA 273, 12x12 mm |
        | Typical power | 1200 mW | 850 mW | 700 mW | 700 mW (one value for the Hi3518 sheet) | 900 mW | 550 mW (1080p30) | 600 mW (1080p20) | - | - | - |
        | Core / DDR voltage | 1.0 V core; 1.8/1.5 V DDR; 2.5 V, 3.3 V | 1.2 V; 1.5/1.8 V DDR; 3.3 V I/O | 1.2 V; 1.5/1.8 V DDR; 3.3 V I/O | 1.2 V; 1.5/1.8 V DDR; 3.3 V I/O | 1.2 V; 1.8 V embedded DDR; 3.3 V I/O | 0.9 V; 1.5/1.35 V DDR; 3.3 V I/O | 0.9 V; 1.8 V DDR; 3.3 V I/O | - | - | - |
        | Chip ID (SC_SYSID) | 0x3516_0100 | 0x3518_0100 (as printed in the sheet) | 0x3518_0100 | 0x3518_0100 | 0x3518_0100 (as printed) | 0x3516_C300 | 0x3516_C300 (one value printed for both) | 0x3518E200, SCSYSID0[31:24] = 0x02 | 0x3518E200, [31:24] = 0x03 | 0x3518E200, [31:24] = 0x01 |
        | SDK kernel | - | Linux 3.0.y | Linux 3.0.y | Linux 3.0.y | Linux 3.0.y | Linux 3.18 | Linux 3.18 | - | - | - |

        Differences the data sheets state: the Hi3518C has no NAND controller, no CVBS output, no 90/270 degree rotation, no autofocus, two UARTs, no SSP/IR and 128 MB maximum DDR; the Hi3516C V100 is the Hi3518A with 1080p encoding; the Hi3518E V100 is a 720p part with embedded DDR2 and no NAND controller; the Hi3516E V100 differs from the Hi3516C V300 by embedded 512 Mbit DDR, a 231-pin package, no CVBS output, no two-frame WDR and the lower encoder limit; the Hi3518E V200/V201/Hi3516C V200 differ in CPU speed, DDR, package and encoder performance (table in the root description above).

        ### Memory map notes

        * See the address table above (Table 1-4): on-chip RAM 0x04010000, BOOTROM 0x04000000, SPI flash 0x58000000, DDR 0x80000000; the register windows of CRG 0x20030000, SYS_CTRL 0x20050000, MISC 0x20120000, IO mux 0x200F0000 and DDRC 0x20110000 are shared by Hi3518E V200, V201 and Hi3516C V200.

        ### DMA request lines (data sheet Table 3-12, DMAC at 0x10060000)

        | Req | Peripheral | Req | Peripheral | Req | Peripheral | Req | Peripheral |
        |---|---|---|---|---|---|---|---|
        | 0 | I2C0 RX | 4 | UART0 RX | 8 | UART2 RX | 12 | SSP1 RX |
        | 1 | I2C0 TX | 5 | UART0 TX | 9 | UART2 TX | 13 | SSP1 TX |
        | 2 | I2C1 RX | 6 | UART1 RX | 10 | I2C2 RX | 14 | SSP0 RX |
        | 3 | I2C1 TX | 7 | UART1 TX | 11 | I2C2 TX | 15 | SSP0 TX |

        The sheet example describes UART0 RX as request 4, matching the table. Channel priority as in the other sheets: channel 0 highest.

        ### Pin multiplexing summary (generated from the IO_CONFIG registers)

        66 one-per-pin `muxctrl_regN` registers. Alternate functions per interface, as named in the register enumerations (GPIO is always one of the choices); 1 pins have no alternate function other than GPIO. Per-pin choices are in the IO_CONFIG register pages.

        | Interface | Functions |
        |---|---|
        | Serial flash (SFC / FMC) | SFC_DEVICE_MODE, SFC_EMMC_BOOT |
        | SD / SDIO / eMMC | EMMC_DATA1-7, EMMC_DS, SDIO0_CARD_DETECT, SDIO0_CARD_POWER, SDIO0_CCLK_OUT, SDIO0_CCMD, SDIO0_CDATA0-3, SDIO0_CWPR, SDIO1_CARD_DETECT, SDIO1_CARD_POWER, SDIO1_CCLK_OUT, SDIO1_CCMD_OTHER, SDIO1_CDATA0_OTHER, SDIO1_CDATA1_OTHER, SDIO1_CDATA2_OTHER, SDIO1_CDATA3_OTHER, SDIO1_CWPR_OTHER |
        | Ethernet (MAC, MII/RMII/RGMII, MDIO, PHY clock) | EPHY_CLK, EPHY_RST, MDCK, MDIO, RMII_CLK, RMII_RXD0, RMII_RXD1, RMII_RX_DV, RMII_TXD0, RMII_TXD1, RMII_TX_EN |
        | Video input (VI / VIU) | VI_DATA9-14, VI_HS_BT1120, VI_HS_SEN, VI_VS_BT1120 |
        | Video output (VO / LCD) | VO_CLK, VO_DATA0_OTHER, VO_DATA1-7, VO_DE, VO_HS, VO_VS |
        | Sensor control | FLASH_TRIG, SENSOR_CLK, SENSOR_RSTN, SHUTTER_TRIG |
        | UART | UART1_CTSN, UART1_RTSN, UART1_RTSN_OTHER, UART1_RXD, UART1_TXD, UART1_TXD_OTHER, UART2_RXD_OTHER, UART2_TXD, UART2_TXD_OTHER |
        | SPI / SSP | SPI0_CSN, SPI0_SCLK, SPI0_SDI, SPI0_SDO, SPI1_CSN0, SPI1_CSN1, SPI1_CSN1_OTHER, SPI1_SCLK, SPI1_SDI, SPI1_SDO |
        | I2C | I2C0_SCL_OTHER, I2C0_SDA, I2C1_SCL, I2C1_SCL_OTHER, I2C1_SDA, I2C2_SCL, I2C2_SDA |
        | Audio (I2S / SIO) | I2S_BCLK_RX, I2S_BCLK_TX, I2S_MCLK, I2S_SD_RX, I2S_SD_TX, I2S_WS_TX |
        | PWM | PWM0_OTHER_VALUES, PWM1-3 |
        | IR, ADC, USB, JTAG | IR, JTAG_TCK, JTAG_TDI, JTAG_TDO, JTAG_TMS, JTAG_TRSTN, SAR_ADC_CH0-3, USB_OVRCUR, USB_PWREN |
        | Boot straps and test | BOOTROM_SEL, BOOT_SEL |
        | Other | GPIO5_4_OTHER, PMC_PWM, TEMPER_DQ_OTHER, TEST_CLK |

        ### Clocks (data sheet 3.2, Tables 3-2 to 3-6)

        Three PLLs from the XIN crystal (24 MHz), two configuration registers each: APLL PERI_CRG0/1 (programmable, feeds the ARM subsystem), VPLL PERI_CRG4/5, EPLL PERI_CRG8/9. FOUTVCO = 24 MHz x (fbdiv + frac/2^24) / refdiv, must be above 600 MHz and at most 2.4 GHz. After reset the ARM9 runs from the crystal (slow mode); the PLL may only be changed in slow mode; lock status in PERI_CRG58 bit[2:0].

        | Selection / divider | Register field |
        |---|---|
        | CPU clock source / divider / skip | PERI_CRG12 bit[8] cpu_sc_sel, bit[5:4] cpu_clk_div; PERI_CRG10 bit[17] cpuclk_loaden, bit[16:12] cpuclk_skipcfg |
        | bus clock source | PERI_CRG12 bit[0] bus_sc_sel |
        | sensor clock out | PERI_CRG11 bit[18:16] sensor_cksel; vi0_sc_sel bit[2] |
        | VDP / LCD | PERI_CRG13 hd_cksel [13:12], vo_out_cksel [14], hd_lcd_cksel [17], lcd_cksel [20]; lcd_mclk_div PERI_CRG26 [26:0] |
        | AVC, VPSS, TDE, VGS, JPGE (loaden + skip) | PERI_CRG16, 18, 22, 23, 24 |
        | FMC (SFC) | PERI_CRG48 bit[3:2] sfc_cksel |
        | SDIO0 / SDIO1 | PERI_CRG49 bit[11:10] sdxc0_cksel / bit[3:2] sdxc1_cksel |
        | PWM / UART | PERI_CRG14 bit[3:2] pwm_cksel; PERI_CRG57 bit[20:19] uart_cksel |
        | ETH | PERI_CRG59 bit[7] ethcore_cksel, bit[5:4] ethphy_cksel, bit[2] eth_rmiick_sel |

        Timer count clocks: SC_CTRL timeren0ov/1ov/2ov/3ov (bits 16, 18, 20, 22): 3 MHz clock (0) or bus clock (1) per timer (the vendor U-Boot selects the bus clock for timer 0).

        ### Reset and power

        * Reset sources (data sheet 3.1): internal POR (low pulse longer than 12 XIN cycles), global soft reset from the system controller (deasserts after at least 360 system clocks, excludes clock/test circuits and registers without soft reset), per-module soft resets from the CRG (not self-clearing).
        * Power: PMC block at 0x20270000 (temperature/voltage monitor registers in the RDL); no switchable power domain is described. Modes of the system controller: normal (APLL feeds the ARM subsystem) and slow (24 MHz crystal feeds the ARM subsystem, APLL off); PLL frequency may only be changed in slow mode, the PLL needs 0.1 ms to lock, lock status is PERI_CRG58 bit[2:0].

        ### Bus ports (system controller registers)

        | Bus | Masters | Slaves |
        |---|---|---|
        | SYS AXI | CPU (M1), AHB0 (M2), AHB1 (M3) | s1 ahb_cfg, s2 sysapb, s3 mediaapb, s4 mddrc |
        | media0 AXI | AVC (M1), VGS (M2) | (towards DDR) |
        | media1 AXI | TDE / DDRT (M1), JPGE (M2), AIAO (M3), IVE / GZIP (M4) | (towards DDR) |

        Source: MISC_CTRL registers (SYS AXI, media0 AXI, media1 AXI timeout and priority fields). The data sheets name only the bus master ports of the registers; which peripheral sits behind each AHB master port is not stated (the SYS AXI masters are arbitrated at the MDDRC slave port s4).

        ### Clock-gate and reset map (generated from the CRG registers)

        | Offset | Register | Description | Gate / reset fields |
        |---|---|---|---|
        | 0x028 | PERI_CRG10 | ARM9 frequency mode and reset configuration register | arm_core_srst_req |
        | 0x02C | PERI_CRG11 | VICAP&MIPI CTRL and sensor clock and reset configuration register | vi0_cken, vi0_srst_req, vi_hrst_req, mipi_srst_req, isp_core_srst_req, isp_cfg_srst_req, mipi_cken, sensor_cken, sensor_srst_req |
        | 0x034 | PERI_CRG13 | VOU clock and reset control register | vo_srst_req, vou_cfg_cken, vou_ppc_cken, vou_pcken, vo_out_cken, vou_acken, vou_hd_cken, lcd_cken |
        | 0x038 | PERI_CRG14 | PWM clock and reset control register | pwm_srst_req, pwm_cken |
        | 0x040 | PERI_CRG16 | AVC clock and soft reset control register | avc_srst_req, avc_cken |
        | 0x048 | PERI_CRG18 | VPSS clock and reset control register | vps_srst_req, vps_cken |
        | 0x058 | PERI_CRG22 | TDE clock and soft reset control register | tde_srst_req, tde_cken |
        | 0x05C | PERI_CRG23 | VGS clock and soft reset control register | vgs_srst_req, vgs_cken |
        | 0x060 | PERI_CRG24 | JPGE clock and soft reset control register | jpge_srst_req, jpge_cken |
        | 0x06C | PERI_CRG27 | IVE&HASH clock and soft reset control register | ive_srst_req, ive_cken, hash_srst_req, hash_cken |
        | 0x07C | PERI_CRG31 | SAR_ADC&cipher clock and soft reset control register | cipher_srst_req, cipher_cken, sar_adc_srst_req |
        | 0x08C | PERI_CRG35 | AIAO clock and soft reset control register | aiao_srst_req, aiao_cken |
        | 0x0B8 | PERI_CRG46 | USB clock and soft reset control register | usb_hrst_req, usb_cken, usb_device_ctrl_srst_req |
        | 0x0C0 | PERI_CRG48 | FMC clock and soft reset control register | sfc_srst_req, sfc_cken |
        | 0x0C4 | PERI_CRG49 | SDIO0/1 clock and soft reset control register | sdxc1_srst_req, sdxc1_cken, sdxc0_srst_req, sdxc0_cken, sdxc0_dll_cken, sdxc0_dll_srst_req |
        | 0x0D4 | PERI_CRG53 | GZIP clock and soft reset control register | gzip_cken, gzip_acken, gzip_pcken, gzip_srst_req |
        | 0x0D8 | PERI_CRG54 | DMA/DDRTEST clock and soft reset control register | ddrtest_srst_req, ddrtest_cken, dma_srst_req, dma_cken |
        | 0x0E0 | PERI_CRG56 | GZIP reset status register | gzip_rst_ok |
        | 0x0E4 | PERI_CRG57 | Soft reset control register for other CRG interface modules | test_clk_en, rtc_srst_req, ir_srst_req, ssp0_srst_req, ssp1_srst_req, uart0_srst_req, uart1_srst_req, uart2_srst_req, ir_cken, ssp0_cken, ... |
        | 0x0EC | PERI_CRG59 | ETH clock and soft reset control register | hrst_eth_s, eth_cken, ext_fephy_srst_req |
        | 0x100 | PERI_CRG64 | RSA clock and soft reset control register | rsa_srst_req, rsa_cken |
        | 0x108 | PERI_CRG66 | APLL spread spectrum configuration register | ssmod_cken, ssmod_rst_req |
        | 0x110 | PERI_CRG68 | VPLL spread spectrum configuration register | ssmod_cken, ssmod_rst_req |
        | 0x118 | PERI_CRG70 | EPLL spread spectrum configuration register | ssmod_cken, ssmod_rst_req |

        Only fields whose names contain a clock-enable or reset keyword are listed; the field descriptions in the register pages give the polarity and the clocks they gate.

        ### Register blocks (generated from this description)

        | Base | Instance | Block | Register space |
        |---|---|---|---|
        | 0x10010000 | FMC | HiSilicon flash memory controller v100 (SPI NOR / SPI NAND) | 224 B |
        | 0x10020000 | SDIO0 | HiSilicon MMC/SD/SDIO controller (DesignWare-MMC based, himciv200) | 516 B |
        | 0x10030000 | SDIO1 | HiSilicon MMC/SD/SDIO controller (DesignWare-MMC based, himciv200) | 516 B |
        | 0x10060000 | DMAC | HiSilicon DMA controller (PL080-compatible, 4 or 8 channels) | 384 B |
        | 0x10070000 | HASH | HASH (SHA1 / SHA256 / HMAC) | 176 B |
        | 0x10080000 | USB_DEV | HiSilicon USB 2.0 device controller (DesignWare DWC_otg, device mode) | 3328 B |
        | 0x10090000 | ETH | HiSilicon femac v2 Fast Ethernet MAC with MDIO | 5184 B |
        | 0x100A0000 | OHCI | HiSilicon USB 2.0 host controller - OHCI | 92 B |
        | 0x100B0000 | EHCI | HiSilicon USB 2.0 host controller - EHCI | 176 B |
        | 0x100C0000 | CIPHER | CIPHER (8 channels) | 5184 B |
        | 0x100D0000 | VIC | Vectored interrupt controller (ARM PrimeCell PL190) | 4 KB |
        | 0x20000000 | TIMER0 | Timer Registers | 28 B |
        | 0x20000020 | TIMER1 | Timer Registers | 28 B |
        | 0x20010000 | TIMER2 | Timer Registers | 28 B |
        | 0x20010020 | TIMER3 | Timer Registers | 28 B |
        | 0x20030000 | CRG | Clock and reset generator (CRG), Hi3518E V20X | 284 B |
        | 0x20040000 | WDG | Watchdog Registers | 3076 B |
        | 0x20050000 | SYS_CTRL | System controller, Hi3518E V20X / Hi3516C V200 | 3821 B |
        | 0x20060000 | RTC | HiSilicon SPI-bridged RTC (APB registers) | 164 B |
        | 0x20070000 | IR | HiSilicon IR receiver | 56 B |
        | 0x20080000 | UART0 | UART (ARM PrimeCell PL011) | 4 KB |
        | 0x20090000 | UART1 | UART (ARM PrimeCell PL011) | 4 KB |
        | 0x200A0000 | UART2 | UART (ARM PrimeCell PL011) | 4 KB |
        | 0x200B0000 | LSADC | HiSilicon LSADC controller (SAR ADC, 4 channels) | 36 B |
        | 0x200C0000 | SPI0 | SPI Registers | 48 B |
        | 0x200D0000 | I2C0 | HiSilicon I2C Master Controller (DesignWare-style register map) | 196 B |
        | 0x200E0000 | SPI1 | SPI Registers | 48 B |
        | 0x200F0000 | IO_CONFIG | IO configuration (pin multiplexing and pad control), Hi3518E V20X | 2360 B |
        | 0x20100800 | KEY_CTRL | Cipher hash key control (key ladder) | 24 B |
        | 0x20110000 | DDRC | HiSilicon DDRC V2 (DDR2/DDR3 controller and DDR PHY, Hi3518E V20X / Hi3516C V200 / Hi3516A/D V100 / Hi3516C V300) | 34876 B |
        | 0x20120000 | MISC_CTRL | MISC control registers, Hi3518E V20X / Hi3516C V200 | 328 B |
        | 0x20130000 | PWM0 | HiSilicon PWM | 28 B |
        | 0x20130020 | PWM1 | HiSilicon PWM | 28 B |
        | 0x20130040 | PWM2 | HiSilicon PWM | 28 B |
        | 0x20130060 | PWM3 | HiSilicon PWM | 28 B |
        | 0x20140000 | GPIO0 | ARM PL061 | 1053 B |
        | 0x20150000 | GPIO1 | ARM PL061 | 1053 B |
        | 0x20160000 | GPIO2 | ARM PL061 | 1053 B |
        | 0x20170000 | GPIO3 | ARM PL061 | 1053 B |
        | 0x20180000 | GPIO4 | ARM PL061 | 1053 B |
        | 0x20190000 | GPIO5 | ARM PL061 | 1053 B |
        | 0x201A0000 | GPIO6 | ARM PL061 | 1053 B |
        | 0x201B0000 | GPIO7 | ARM PL061 | 1053 B |
        | 0x201C0000 | GPIO8 | ARM PL061 | 1053 B |
        | 0x20240000 | I2C1 | HiSilicon I2C Master Controller (DesignWare-style register map) | 196 B |
        | 0x20250000 | I2C2 | HiSilicon I2C Master Controller (DesignWare-style register map) | 196 B |
        | 0x20260000 | RSA | RSA (SEC_RSA modular exponentiation engine) | 120 B |
        | 0x20270000 | PMC | HiSilicon Power Management Controller (AVS PWM, core HPM, temperature sensor) | 288 B |
        | 0x20280000 | TRNG | RNG_GEN (true random number generator) | 12 B |
        | 0x20580000 | VICAP | VICAP (video capture, single channel) | 104452 B |
        | 0x205A0000 | ISP | ISP (image signal processor) | 74536 B |
        | 0x205C0000 | VDP | VDP (video display processor, V1 + G2 + DHD1) | 54284 B |
        | 0x20600000 | VPSS | HiSilicon VPSS (registers not described) | 64 KB |
        | 0x20610000 | TDE | HiSilicon TDE, Hi3516A/D and Hi3518E V200 / Hi3516C V200 generation (vendor-derived) | 2160 B |
        | 0x20620000 | VEDU | HiSilicon VEDU (Hi3520D V100 edition, vendor-derived registers) | 64 KB |
        | 0x20630000 | VGS | HiSilicon VGS (registers not described) | 64 KB |
        | 0x20650000 | AIAO | AIAO (audio input/output) | 8368 B |
        | 0x20660000 | JPGE | HiSilicon JPEG encoder (JPGE, r004 register layout) | 4288 B |
        | 0x20680000 | MIPI | MIPI RX (sensor serial interface receiver) | 4648 B |
        | 0x206A0000 | IVE | HiSilicon intelligent video engine | 140 B |
        | 0x206D0000 | DDRT | HiSilicon DDR test module | 132 B |

        The table is generated from the elaborated root (instances at their absolute addresses; register space is the span of the block's registers, not the data sheet window).

        <!-- overview:end -->
    ";

    eHISI_FMC              FMC          @ 0x10010000;
    eHISI_DWMMC            SDIO0        @ 0x10020000;
    eHISI_DWMMC            SDIO1        @ 0x10030000;
    eHISI_DMAC             DMAC         @ 0x10060000;
    eHISI_HASH             HASH         @ 0x10070000;
    eHISI_USB_DEVICE       USB_DEV      @ 0x10080000;
    eHISI_FEMAC            ETH          @ 0x10090000;
    eHISI_USB_OHCI         OHCI         @ 0x100A0000;
    eHISI_USB_EHCI         EHCI         @ 0x100B0000;
    eHISI_CIPHER_MC        CIPHER       @ 0x100C0000;
    eARM_PL190             VIC          @ 0x100D0000;
    eHISI_TIMER_SP804      TIMER0       @ 0x20000000;
    eHISI_TIMER_SP804      TIMER1       @ 0x20000020;
    eHISI_TIMER_SP804      TIMER2       @ 0x20010000;
    eHISI_TIMER_SP804      TIMER3       @ 0x20010020;
    eCRG                   CRG          @ 0x20030000;
    eHISI_WDG_SP805        WDG          @ 0x20040000;
    eHISI_SYS_CTRL_V2      SYS_CTRL     @ 0x20050000;
    eHISI_RTC_SPI          RTC          @ 0x20060000;
    eHISI_IR               IR           @ 0x20070000;
    eARM_PL011             UART0        @ 0x20080000;
    eARM_PL011             UART1        @ 0x20090000;
    eARM_PL011             UART2        @ 0x200A0000;
    eHISI_LSADC            LSADC        @ 0x200B0000;
    eHISI_SPI              SPI0         @ 0x200C0000;
    eHISI_I2C_DW           I2C0         @ 0x200D0000;
    eHISI_SPI              SPI1         @ 0x200E0000;
    eHISI_IO_CONFIG_V2     IO_CONFIG    @ 0x200F0000;
    eHISI_KEY_CTRL         KEY_CTRL     @ 0x20100800;
    eHISI_DDRC_V2          DDRC         @ 0x20110000;
    eHISI_MISC_CTRL        MISC_CTRL    @ 0x20120000;
    eHISI_PWM              PWM0         @ 0x20130000;
    eHISI_PWM              PWM1         @ 0x20130020;
    eHISI_PWM              PWM2         @ 0x20130040;
    eHISI_PWM              PWM3         @ 0x20130060;
    eARM_PL061             GPIO0        @ 0x20140000;
    eARM_PL061             GPIO1        @ 0x20150000;
    eARM_PL061             GPIO2        @ 0x20160000;
    eARM_PL061             GPIO3        @ 0x20170000;
    eARM_PL061             GPIO4        @ 0x20180000;
    eARM_PL061             GPIO5        @ 0x20190000;
    eARM_PL061             GPIO6        @ 0x201A0000;
    eARM_PL061             GPIO7        @ 0x201B0000;
    eARM_PL061             GPIO8        @ 0x201C0000;
    eHISI_I2C_DW           I2C1         @ 0x20240000;
    eHISI_I2C_DW           I2C2         @ 0x20250000;
    eHISI_RSA              RSA          @ 0x20260000;
    eHISI_PMC              PMC          @ 0x20270000;
    eHISI_RNG              TRNG         @ 0x20280000;
    eHISI_VICAP_V2         VICAP        @ 0x20580000;
    eHISI_ISP              ISP          @ 0x205A0000;
    eHISI_VDP_V2           VDP          @ 0x205C0000;
    aHISI_VPSS             VPSS         @ 0x20600000;
    eHISI_TDE_G2             TDE          @ 0x20610000;
    aHISI_VEDU_V100        VEDU         @ 0x20620000;
    aHISI_VGS           VGS             @ 0x20630000;
    eHISI_AIAO             AIAO         @ 0x20650000;
    eHISI_JPGE             JPGE         @ 0x20660000;
    eHISI_MIPI_RX          MIPI         @ 0x20680000;
    eHISI_IVE              IVE          @ 0x206A0000;
    eHISI_DDRT             DDRT         @ 0x206D0000;
};
