`include "defines.rdl"

`include "CRG.rdl"
`include "../common/ARM_PL011.rdl"
`include "../common/ARM_PL061.rdl"
`include "../common/ARM_PL190.rdl"
`include "../common/HISI_AIAO.rdl"
`include "../common/HISI_CIPHER_MC.rdl"
`include "../common/HISI_DDRC_V2.rdl"
`include "../common/HISI_DDRT.rdl"
`include "../common/HISI_DMAC.rdl"
`include "../common/HISI_DWMMC.rdl"
`include "../common/HISI_FEMAC.rdl"
`include "../common/HISI_FMC.rdl"
`include "../common/HISI_HASH.rdl"
`include "../common/HISI_I2C_DW.rdl"
`include "../common/HISI_IO_CONFIG_V2.rdl"
`include "../common/HISI_IR.rdl"
`include "../common/HISI_ISP.rdl"
`include "../common/HISI_IVE.rdl"
`include "../common/HISI_JPGE.rdl"
`include "../common/HISI_KEY_CTRL.rdl"
`include "../common/HISI_LSADC.rdl"
`include "../common/HISI_MIPI_RX.rdl"
`include "../common/HISI_MISC_CTRL.rdl"
`include "../common/HISI_PMC.rdl"
`include "../common/HISI_PWM.rdl"
`include "../common/HISI_RNG.rdl"
`include "../common/HISI_RSA.rdl"
`include "../common/HISI_RTC_SPI.rdl"
`include "../common/HISI_RTC_SPI_V2.rdl"
`include "../common/HISI_SPI.rdl"
`include "../common/HISI_SYS_CTRL_V2.rdl"
`include "../common/HISI_TDE.rdl"
`include "../common/HISI_TIMER_SP804.rdl"
`include "../common/HISI_USB_DEVICE.rdl"
`include "../common/HISI_USB_HOST.rdl"
`include "../common/HISI_VDP_V2.rdl"
`include "../common/HISI_VEDU.rdl"
`include "../common/HISI_VICAP_V2.rdl"
`include "../common/HISI_VGS.rdl"
`include "../common/HISI_VPSS.rdl"
`include "../common/HISI_WDG_SP805.rdl"

addrmap hi3516cv200 {
    name = "hi3516cv200 registers";
    desc = "
        **Hi3516C V200**: the 273-pin member of the Hi3518E V20X / Hi3516C V200 family. Its register map, CRG, SYS_CTRL, MISC, IO-config and peripheral blocks are the ones of the `hi3518ev200` addrmap (same data sheet, same block instances); this entry exists so that the chip is found under its own name. It differs from the Hi3518E V200 in the CPU speed (600 MHz), the external DDR2/DDR3/DDR3L interface (up to 4 Gbit, 400 MHz), the package (more pins exposed, differential MIPI) and the encoder performance; SCSYSID0[31:24] reads 0x01.

        ## Datasheets

        * [Full Datasheet](assets/Hi3518EV20X-Hi3516CV200-Datasheet.pdf): Hi3518E V20X / Hi3516C V200 Economical HD IP Camera SoC Data Sheet, issue 02 (2017-06-12). One document for the Hi3518E V200, Hi3518E V201 and Hi3516C V200: one address map (Table 1-4), one CRG/SYS_CTRL/MISC/IO-config register set, one interrupt table; the chips differ only in package/pin list, CPU speed, DDR and codec performance (see Variants). This is HiSilicon's own English edition; no Chinese original is available in this workspace, so vendor code (U-Boot 2010.06 `hi3518ev200`, Linux `clk-hi3518ev20x.c`, OpenIPC `hi3518ev20x.dtsi`) was used to settle disputed values, as noted in the block descriptions.

        ## Facts

        * CPU: ARM926EJ-S (ARMv5TEJ), 32 KB I-cache + 32 KB D-cache, 600 MHz (Hi3518E V20X: 540 MHz); no VFP/NEON, no L2, no GIC: the interrupt controller is an ARM PL190 VIC at 0x100D0000 (32 sources, see Interrupts).
        * DDR: external 16-bit DDR2/DDR3/DDR3L, up to 4 Gbit (512 MB), max 400 MHz (the Hi3518E V200/V201 have an embedded 512 / 256 Mbit DDR2 instead); DDR window 0x80000000. SPI flash window 0x58000000 (64 MB). On-chip RAM 0x04010000 (64 KB), BOOTROM 0x04000000. DDRC at 0x20110000 (eHISI_DDRC_V2), the DDR PHY at 0x20118000 inside the same window (vendor U-Boot `DDR_PHY0_REG_BASE`).
        * Boot: BOOTROM_SEL (pin MDCK) = 1: serial download (BOOTROM); BOOTROM_SEL = 0: BOOT_SEL (pin EPHY_RST) 0 = SPI flash (NOR 3/4-byte or NAND 1/4-wire by the SFC_DEVICE_MODE (pin SHUTTER_TRIG) / SFC_EMMC_BOOT_MODE (pin FLASH_TRIG) straps), 1 = eMMC (4/8-wire by SFC_EMMC_BOOT_MODE). The straps are readable in SYS_CTRL SYSSTAT. After POR the boot memory (BOOTROM, or SFC CS0) is remapped to address 0 (SC_CTRL remapstat); the boot code clears the remap with SC_CTRL remapclear.
        * Clocks: 24 MHz XIN crystal into three PLLs (APLL = CPU, VPLL = 1188 MHz video/bus tree, EPLL = 1000 MHz) in the CRG; the CPU and the bus run from the crystal after reset. 32.768 kHz RTC_XIN for the RTC.
        * Chip ID: SYS_CTRL SCSYSID3..0 = 0x3518E200 for all three chips; SCSYSID0[31:24] (`chipid`) distinguishes them: 0x01 = Hi3516C V200, 0x02 = Hi3518E V200, 0x03 = Hi3518E V201. The vendor U-Boot only checks the 32-bit ID (`_HI3518EV200 0x3518e200`), which is why its SoC string reads `hi3518ev200` on this chip too (tools print it as `hi3518ev200 (hi3516cv200)`).

        ## Variants (data sheet chapter 1 and 4.1)

        | | Hi3518E V200 | Hi3518E V201 | Hi3516C V200 |
        |---|---|---|---|
        | SCSYSID0[31:24] | 0x02 | 0x03 | 0x01 |
        | CPU | ARM926 @ 540 MHz | ARM926 @ 540 MHz | ARM926 @ 600 MHz |
        | DDR | embedded 16-bit DDR2, 512 Mbit, 360 MHz | embedded 16-bit DDR2, 256 Mbit, 360 MHz | external 16-bit DDR2/DDR3/DDR3L, up to 4 Gbit, 400 MHz |
        | Package | TFBGA 192, 10 x 10 mm | TFBGA 192, 10 x 10 mm | TFBGA 273, 12 x 12 mm |
        | Encoder | 1080p@20 | 960p@25, no lens distortion correction, no 90/270 rotation | 1080p@30 |
        | MIPI | - | - | differential (MIPI/LVDS) and single-ended modes on the VI pins |

        The register map, the CRG, SYS_CTRL, MISC, IO-config (same mux register set; the 273-pin part exposes more of the pins) and all peripheral blocks are documented once for the three chips; this `hi3516cv200` entry is the same map under the chip's own name (`hi3518ev200` is the primary entry).

        ## Interrupts (PL190 VIC source numbers, data sheet Table 3-8)

        | # | Source | # | Source | # | Source | # | Source |
        |---|--------|---|--------|---|--------|---|--------|
        | 0 | Global soft interrupt (SYS_CTRL SOLFINT) | 8 | GZIP / SDIO1 | 16 | USB OHCI | 24 | AVC (H.264 encoder) |
        | 1 | Watchdog | 9 | AIAO | 17 | VPSS | 25 | UART2 |
        | 2 | RTC / Temper_Cap | 10 | USB device | 18 | SDIO0 | 26 | JPGE |
        | 3 | Timer0 / Timer1 | 11 | FMC | 19 | IR / SAR ADC | 27 | TDE |
        | 4 | Timer2 / Timer3 | 12 | ETH | 20 | I2C0 / I2C1 / I2C2 | 28 | MIPI |
        | 5 | UART0 | 13 | CIPHER | 21 | IVE | 29 | VGS |
        | 6 | SSP0 (SPI0) | 14 | DMAC | 22 | VICAP | 30 | UART1 |
        | 7 | SSP1 (SPI1) | 15 | USB EHCI | 23 | VDP | 31 | GPIO0-GPIO8 (one shared line) |

        Shared lines (timers, GZIP/SDIO1, RTC/Temper_Cap, IR/SAR ADC, the three I2Cs, the nine GPIOs) must be demultiplexed from the peripheral's own status registers. The OpenIPC/vendor device tree `hi3518ev20x.dtsi` uses the same numbers (timers 3/4, UART0/1/2 = 5/30/25, SPI 6/7, SDIO0/1 = 18/8, USB 10/15/16, ETH 12, I2C 20, GPIO 31).

        ## Addresses

        | Start Address | End Address | Description | Capacity | Documented Here |
        |---------------|-------------|-------------|----------|-----------------|
        | 0x00000000    | 0x03FFFFFF  | Boot memory (remapped): SPI flash when {BOOT_SEL, BOOTROM_SEL} = 00, else BOOTROM; the on-chip RAM after the remap is cleared (SC_CTRL remapclear) | 64 MB | &#10060; |
        | 0x04000000    | 0x0400FFFF  | BOOTROM | 64 KB | &#10060; |
        | 0x04010000    | 0x0401FFFF  | On-chip RAM | 64 KB | &#10060; |
        | 0x04020000    | 0x0FFFFFFF  | Reserved | - | &#10060; |
        | 0x10000000    | 0x1000FFFF  | Reserved | 64 KB | &#10060; |
        | 0x10010000    | 0x1001FFFF  | FMC control register | 64 KB | &#9989; |
        | 0x10020000    | 0x1002FFFF  | SDIO0 register | 64 KB | &#9989; |
        | 0x10030000    | 0x1003FFFF  | SDIO1 register | 64 KB | &#9989; |
        | 0x10040000    | 0x1004FFFF  | Reserved | 64 KB | &#10060; |
        | 0x10050000    | 0x1005FFFF  | Reserved | 64 KB | &#10060; |
        | 0x10060000    | 0x1006FFFF  | DMAC register | 64 KB | &#9989; |
        | 0x10070000    | 0x1007FFFF  | HASH register | 64 KB | &#9989; |
        | 0x10080000    | 0x1008FFFF  | USB device register | 64 KB | &#9989; |
        | 0x10090000    | 0x1009FFFF  | ETH register | 64 KB | &#9989; |
        | 0x100A0000    | 0x100AFFFF  | USB OHCI register | 64 KB | &#9989; |
        | 0x100B0000    | 0x100BFFFF  | USB EHCI register | 64 KB | &#9989; |
        | 0x100C0000    | 0x100CFFFF  | Cipher register | 64 KB | &#9989; |
        | 0x100D0000    | 0x100DFFFF  | Interrupt control register | 64 KB | &#9989; |
        | 0x100E0000    | 0x1FFFFFFF  | Reserved | - | &#10060; |
        | 0x20000000    | 0x2000FFFF  | Timer 0/Timer 1 register | 64 KB | &#9989; |
        | 0x20010000    | 0x2001FFFF  | Timer 2/Timer 3 register | 64 KB | &#9989; |
        | 0x20020000    | 0x2002FFFF  | Reserved | 64 KB | &#10060; |
        | 0x20030000    | 0x2003FFFF  | CRG register | 64 KB | &#9989; |
        | 0x20040000    | 0x2004FFFF  | WDG register | 64 KB | &#9989; |
        | 0x20050000    | 0x2005FFFF  | SYS_CTRL register | 64 KB | &#9989; |
        | 0x20060000    | 0x2006FFFF  | RTC register | 64 KB | &#9989; |
        | 0x20070000    | 0x2007FFFF  | IR register | 64 KB | &#9989; |
        | 0x20080000    | 0x2008FFFF  | UART0 register | 64 KB | &#9989; |
        | 0x20090000    | 0x2009FFFF  | UART1 register | 64 KB | &#9989; |
        | 0x200A0000    | 0x200AFFFF  | UART2 register | 64 KB | &#9989; |
        | 0x200B0000    | 0x200BFFFF  | SAR_ADC register | 64 KB | &#9989; |
        | 0x200C0000    | 0x200CFFFF  | SPI0 register | 64 KB | &#9989; |
        | 0x200D0000    | 0x200DFFFF  | I2C0 register | 64 KB | &#9989; |
        | 0x200E0000    | 0x200EFFFF  | SPI1 register | 64 KB | &#9989; |
        | 0x200F0000    | 0x200F07FF  | IO MUX register | 2 KB | &#9989; |
        | 0x200F0800    | 0x200FFFFF  | IO CTR register | 62 KB | &#10060; |
        | 0x20100000    | 0x201007FF  | Reserved | 2 KB | &#10060; |
        | 0x20100800    | 0x2010FFFF  | cipher_hash_key_ctrl register | 62 KB | &#9989; |
        | 0x20110000    | 0x2011FFFF  | DDRC/DDR PHY register (DDRC at 0x20110000, DDR PHY at 0x20118000) | 64 KB | &#9989; |
        | 0x20120000    | 0x2012FFFF  | MISC register | 64 KB | &#9989; |
        | 0x20130000    | 0x2013FFFF  | PWM register | 64 KB | &#9989; |
        | 0x20140000    | 0x2014FFFF  | GPIO0 register | 64 KB | &#9989; |
        | 0x20150000    | 0x2015FFFF  | GPIO1 register | 64 KB | &#9989; |
        | 0x20160000    | 0x2016FFFF  | GPIO2 register | 64 KB | &#9989; |
        | 0x20170000    | 0x2017FFFF  | GPIO3 register | 64 KB | &#9989; |
        | 0x20180000    | 0x2018FFFF  | GPIO4 register | 64 KB | &#9989; |
        | 0x20190000    | 0x2019FFFF  | GPIO5 register | 64 KB | &#9989; |
        | 0x201A0000    | 0x201AFFFF  | GPIO6 register | 64 KB | &#9989; |
        | 0x201B0000    | 0x201BFFFF  | GPIO7 register | 64 KB | &#9989; |
        | 0x201C0000    | 0x201CFFFF  | GPIO8 register | 64 KB | &#9989; |
        | 0x201D0000    | 0x201DFFFF  | Reserved | 64 KB | &#10060; |
        | 0x201E0000    | 0x201EFFFF  | Reserved | 64 KB | &#10060; |
        | 0x201F0000    | 0x201FFFFF  | Reserved | 64 KB | &#10060; |
        | 0x20200000    | 0x2020FFFF  | Reserved | 64 KB | &#10060; |
        | 0x20210000    | 0x2021FFFF  | Reserved | 64 KB | &#10060; |
        | 0x20220000    | 0x2022FFFF  | Reserved | 64 KB | &#10060; |
        | 0x20230000    | 0x2023FFFF  | Reserved | 64 KB | &#10060; |
        | 0x20240000    | 0x2024FFFF  | I2C1 register | 64 KB | &#9989; |
        | 0x20250000    | 0x2025FFFF  | I2C2 register | 64 KB | &#9989; |
        | 0x20260000    | 0x2026FFFF  | RSA register | 64 KB | &#9989; |
        | 0x20270000    | 0x2027FFFF  | PMC register | 64 KB | &#9989; |
        | 0x20280000    | 0x2028FFFF  | TRNG register | 64 KB | &#9989; |
        | 0x20290000    | 0x2057FFFF  | Reserved | - | &#10060; |
        | 0x20580000    | 0x205BFFFF  | VICAP register | 256 KB | &#9989; |
        | 0x205C0000    | 0x205CFFFF  | VDP register | 64 KB | &#9989; |
        | 0x205D0000    | 0x205FFFFF  | Reserved | - | &#10060; |
        | 0x20600000    | 0x2060FFFF  | VPSS register | 64 KB | &#9989;  |
        | 0x20610000    | 0x2061FFFF  | TDE register | 64 KB | &#9989;  |
        | 0x20620000    | 0x2062FFFF  | AVC register | 64 KB | &#9989;  |
        | 0x20630000    | 0x2063FFFF  | VGS register | 64 KB | &#9989; |
        | 0x20640000    | 0x2064FFFF  | Reserved | 64 KB | &#10060; |
        | 0x20650000    | 0x2065FFFF  | AIAO register | 64 KB | &#9989; |
        | 0x20660000    | 0x2066FFFF  | JPGE register | 64 KB | &#9989; |
        | 0x20670000    | 0x2067FFFF  | Reserved | - | &#10060; |
        | 0x20680000    | 0x2068FFFF  | MIPI register | 64 KB | &#9989; |
        | 0x20690000    | 0x2069FFFF  | Reserved | 64 KB | &#10060; |
        | 0x206A0000    | 0x206AFFFF  | IVE register | 64 KB | &#9989; |
        | 0x206B0000    | 0x206BFFFF  | Reserved (GZIP in the vendor U-Boot, `GZIP_REG_BASE`, used for the fast-boot snapshot) | - | &#10060; |
        | 0x206C0000    | 0x206CFFFF  | Reserved | 64 KB | &#10060; |
        | 0x206D0000    | 0x206DFFFF  | DDR test module | 64 KB | &#9989;  |
        | 0x206E0000    | 0x206EFFFF  | Reserved | 64 KB | &#10060; |
        | 0x206F0000    | 0x206FFFFF  | Reserved | 64 KB | &#10060; |
        | 0x20700000    | 0x4FFFFFFF  | Reserved | - | &#10060; |
        | 0x50000000    | 0x53FFFFFF  | Reserved | 64 MB | &#10060; |
        | 0x54000000    | 0x57FFFFFF  | Reserved | 64 MB | &#10060; |
        | 0x58000000    | 0x5BFFFFFF  | Storage space of the SPI flash | 64 MB | &#10060; |
        | 0x5C000000    | 0x7FFFFFFF  | Reserved | - | &#10060; |
        | 0x80000000    | 0x9FFFFFFF  | Address space of the connected external DDR (Hi3518E V200: 64 MB, Hi3518E V201: 32 MB, Hi3516C V200: up to 512 MB) | 512 MB | &#10060; |
        | 0xA0000000    | 0xFFFFFFFF  | Reserved | - | &#10060; |

        &#9989; = a register block is described in this addrmap; &#10060; = not described (reserved, memory window, or media/ISP/security block outside the bring-up scope). The address table is the data sheet's Table 1-4 (the on-chip RAM/BOOTROM remark of the 0x00000000 row and the DDR size remark of the 0x80000000 row are restored from the data sheet text). This file and `hi3518ev200.rdl` carry the same table and instance list: change both.

        <!-- overview:begin -->

        ### Diagrams

        ![Logic block diagram](assets/diagrams/hi3516cv200-logic.svg)

        ![Register blocks by function](assets/diagrams/hi3516cv200-blocks.svg)

        ![Boot flow](assets/diagrams/hi3516cv200-boot.svg)

        ### Clock-gate and reset map (generated from the CRG registers)

        | Offset | Register | Description | Gate / reset fields |
        |---|---|---|---|
        | 0x028 | PERI_CRG10 | ARM9 frequency mode and reset configuration register | arm_core_srst_req |
        | 0x02C | PERI_CRG11 | VICAP&MIPI CTRL and sensor clock and reset configuration register | vi0_cken, vi0_srst_req, vi_hrst_req, mipi_srst_req, isp_core_srst_req, isp_cfg_srst_req, mipi_cken, sensor_cken, sensor_srst_req |
        | 0x034 | PERI_CRG13 | VOU clock and reset control register | vo_srst_req, vou_cfg_cken, vou_ppc_cken, vou_pcken, vo_out_cken, vou_acken, vou_hd_cken, lcd_cken |
        | 0x038 | PERI_CRG14 | PWM clock and reset control register | pwm_srst_req, pwm_cken |
        | 0x040 | PERI_CRG16 | AVC clock and soft reset control register | avc_srst_req, avc_cken |
        | 0x048 | PERI_CRG18 | VPSS clock and reset control register | vps_srst_req, vps_cken |
        | 0x058 | PERI_CRG22 | TDE clock and soft reset control register | tde_srst_req, tde_cken |
        | 0x05C | PERI_CRG23 | VGS clock and soft reset control register | vgs_srst_req, vgs_cken |
        | 0x060 | PERI_CRG24 | JPGE clock and soft reset control register | jpge_srst_req, jpge_cken |
        | 0x06C | PERI_CRG27 | IVE&HASH clock and soft reset control register | ive_srst_req, ive_cken, hash_srst_req, hash_cken |
        | 0x07C | PERI_CRG31 | SAR_ADC&cipher clock and soft reset control register | cipher_srst_req, cipher_cken, sar_adc_srst_req |
        | 0x08C | PERI_CRG35 | AIAO clock and soft reset control register | aiao_srst_req, aiao_cken |
        | 0x0B8 | PERI_CRG46 | USB clock and soft reset control register | usb_hrst_req, usb_cken, usb_device_ctrl_srst_req |
        | 0x0C0 | PERI_CRG48 | FMC clock and soft reset control register | sfc_srst_req, sfc_cken |
        | 0x0C4 | PERI_CRG49 | SDIO0/1 clock and soft reset control register | sdxc1_srst_req, sdxc1_cken, sdxc0_srst_req, sdxc0_cken, sdxc0_dll_cken, sdxc0_dll_srst_req |
        | 0x0D4 | PERI_CRG53 | GZIP clock and soft reset control register | gzip_cken, gzip_acken, gzip_pcken, gzip_srst_req |
        | 0x0D8 | PERI_CRG54 | DMA/DDRTEST clock and soft reset control register | ddrtest_srst_req, ddrtest_cken, dma_srst_req, dma_cken |
        | 0x0E0 | PERI_CRG56 | GZIP reset status register | gzip_rst_ok |
        | 0x0E4 | PERI_CRG57 | Soft reset control register for other CRG interface modules | test_clk_en, rtc_srst_req, ir_srst_req, ssp0_srst_req, ssp1_srst_req, uart0_srst_req, uart1_srst_req, uart2_srst_req, ir_cken, ssp0_cken, ... |
        | 0x0EC | PERI_CRG59 | ETH clock and soft reset control register | hrst_eth_s, eth_cken, ext_fephy_srst_req |
        | 0x100 | PERI_CRG64 | RSA clock and soft reset control register | rsa_srst_req, rsa_cken |
        | 0x108 | PERI_CRG66 | APLL spread spectrum configuration register | ssmod_cken, ssmod_rst_req |
        | 0x110 | PERI_CRG68 | VPLL spread spectrum configuration register | ssmod_cken, ssmod_rst_req |
        | 0x118 | PERI_CRG70 | EPLL spread spectrum configuration register | ssmod_cken, ssmod_rst_req |

        Only fields whose names contain a clock-enable or reset keyword are listed; the field descriptions in the register pages give the polarity and the clocks they gate.

        ### Register blocks (generated from this description)

        | Base | Instance | Block | Register space |
        |---|---|---|---|
        | 0x10010000 | FMC | HiSilicon flash memory controller v100 (SPI NOR / SPI NAND) | 224 B |
        | 0x10020000 | SDIO0 | HiSilicon MMC/SD/SDIO controller (DesignWare-MMC based, himciv200) | 516 B |
        | 0x10030000 | SDIO1 | HiSilicon MMC/SD/SDIO controller (DesignWare-MMC based, himciv200) | 516 B |
        | 0x10060000 | DMAC | HiSilicon DMA controller (PL080-compatible, 4 or 8 channels) | 384 B |
        | 0x10070000 | HASH | HASH (SHA1 / SHA256 / HMAC) | 176 B |
        | 0x10080000 | USB_DEV | HiSilicon USB 2.0 device controller (DesignWare DWC_otg, device mode) | 3328 B |
        | 0x10090000 | ETH | HiSilicon femac v2 Fast Ethernet MAC with MDIO | 5184 B |
        | 0x100A0000 | OHCI | HiSilicon USB 2.0 host controller - OHCI | 92 B |
        | 0x100B0000 | EHCI | HiSilicon USB 2.0 host controller - EHCI | 176 B |
        | 0x100C0000 | CIPHER | CIPHER (8 channels) | 5184 B |
        | 0x100D0000 | VIC | Vectored interrupt controller (ARM PrimeCell PL190) | 4 KB |
        | 0x20000000 | TIMER0 | Timer Registers | 28 B |
        | 0x20000020 | TIMER1 | Timer Registers | 28 B |
        | 0x20010000 | TIMER2 | Timer Registers | 28 B |
        | 0x20010020 | TIMER3 | Timer Registers | 28 B |
        | 0x20030000 | CRG | Clock and reset generator (CRG), Hi3518E V20X | 284 B |
        | 0x20040000 | WDG | Watchdog Registers | 3076 B |
        | 0x20050000 | SYS_CTRL | System controller, Hi3518E V20X / Hi3516C V200 | 3821 B |
        | 0x20060000 | RTC | HiSilicon SPI-bridged RTC (APB registers) | 164 B |
        | 0x20070000 | IR | HiSilicon IR receiver | 56 B |
        | 0x20080000 | UART0 | UART (ARM PrimeCell PL011) | 4 KB |
        | 0x20090000 | UART1 | UART (ARM PrimeCell PL011) | 4 KB |
        | 0x200A0000 | UART2 | UART (ARM PrimeCell PL011) | 4 KB |
        | 0x200B0000 | LSADC | HiSilicon LSADC controller (SAR ADC, 4 channels) | 36 B |
        | 0x200C0000 | SPI0 | SPI Registers | 48 B |
        | 0x200D0000 | I2C0 | HiSilicon I2C Master Controller (DesignWare-style register map) | 196 B |
        | 0x200E0000 | SPI1 | SPI Registers | 48 B |
        | 0x200F0000 | IO_CONFIG | IO configuration (pin multiplexing and pad control), Hi3518E V20X | 2360 B |
        | 0x20100800 | KEY_CTRL | Cipher hash key control (key ladder) | 24 B |
        | 0x20110000 | DDRC | HiSilicon DDRC V2 (DDR2/DDR3 controller and DDR PHY, Hi3518E V20X / Hi3516C V200 / Hi3516A/D V100 / Hi3516C V300) | 34876 B |
        | 0x20120000 | MISC_CTRL | MISC control registers, Hi3518E V20X / Hi3516C V200 | 328 B |
        | 0x20130000 | PWM0 | HiSilicon PWM | 28 B |
        | 0x20130020 | PWM1 | HiSilicon PWM | 28 B |
        | 0x20130040 | PWM2 | HiSilicon PWM | 28 B |
        | 0x20130060 | PWM3 | HiSilicon PWM | 28 B |
        | 0x20140000 | GPIO0 | ARM PL061 | 1053 B |
        | 0x20150000 | GPIO1 | ARM PL061 | 1053 B |
        | 0x20160000 | GPIO2 | ARM PL061 | 1053 B |
        | 0x20170000 | GPIO3 | ARM PL061 | 1053 B |
        | 0x20180000 | GPIO4 | ARM PL061 | 1053 B |
        | 0x20190000 | GPIO5 | ARM PL061 | 1053 B |
        | 0x201A0000 | GPIO6 | ARM PL061 | 1053 B |
        | 0x201B0000 | GPIO7 | ARM PL061 | 1053 B |
        | 0x201C0000 | GPIO8 | ARM PL061 | 1053 B |
        | 0x20240000 | I2C1 | HiSilicon I2C Master Controller (DesignWare-style register map) | 196 B |
        | 0x20250000 | I2C2 | HiSilicon I2C Master Controller (DesignWare-style register map) | 196 B |
        | 0x20260000 | RSA | RSA (SEC_RSA modular exponentiation engine) | 120 B |
        | 0x20270000 | PMC | HiSilicon Power Management Controller (AVS PWM, core HPM, temperature sensor) | 288 B |
        | 0x20280000 | TRNG | RNG_GEN (true random number generator) | 12 B |
        | 0x20580000 | VICAP | VICAP (video capture, single channel) | 104452 B |
        | 0x205A0000 | ISP | ISP (image signal processor) | 74536 B |
        | 0x205C0000 | VDP | VDP (video display processor, V1 + G2 + DHD1) | 54284 B |
        | 0x20600000 | VPSS | HiSilicon VPSS (registers not described) | 64 KB |
        | 0x20610000 | TDE | HiSilicon TDE, Hi3516A/D and Hi3518E V200 / Hi3516C V200 generation (vendor-derived) | 2160 B |
        | 0x20620000 | VEDU | HiSilicon VEDU (Hi3520D V100 edition, vendor-derived registers) | 64 KB |
        | 0x20630000 | VGS | HiSilicon VGS (registers not described) | 64 KB |
        | 0x20650000 | AIAO | AIAO (audio input/output) | 8368 B |
        | 0x20660000 | JPGE | HiSilicon JPEG encoder (JPGE, r004 register layout) | 4288 B |
        | 0x20680000 | MIPI | MIPI RX (sensor serial interface receiver) | 4648 B |
        | 0x206A0000 | IVE | HiSilicon intelligent video engine | 140 B |
        | 0x206D0000 | DDRT | HiSilicon DDR test module | 132 B |

        The table is generated from the elaborated root (instances at their absolute addresses; register space is the span of the block's registers, not the data sheet window).

        <!-- overview:end -->
    ";

    eHISI_FMC              FMC          @ 0x10010000;
    eHISI_DWMMC            SDIO0        @ 0x10020000;
    eHISI_DWMMC            SDIO1        @ 0x10030000;
    eHISI_DMAC             DMAC         @ 0x10060000;
    eHISI_HASH             HASH         @ 0x10070000;
    eHISI_USB_DEVICE       USB_DEV      @ 0x10080000;
    eHISI_FEMAC            ETH          @ 0x10090000;
    eHISI_USB_OHCI         OHCI         @ 0x100A0000;
    eHISI_USB_EHCI         EHCI         @ 0x100B0000;
    eHISI_CIPHER_MC        CIPHER       @ 0x100C0000;
    eARM_PL190             VIC          @ 0x100D0000;
    eHISI_TIMER_SP804      TIMER0       @ 0x20000000;
    eHISI_TIMER_SP804      TIMER1       @ 0x20000020;
    eHISI_TIMER_SP804      TIMER2       @ 0x20010000;
    eHISI_TIMER_SP804      TIMER3       @ 0x20010020;
    eCRG                   CRG          @ 0x20030000;
    eHISI_WDG_SP805        WDG          @ 0x20040000;
    eHISI_SYS_CTRL_V2      SYS_CTRL     @ 0x20050000;
    eHISI_RTC_SPI          RTC          @ 0x20060000;
    eHISI_IR               IR           @ 0x20070000;
    eARM_PL011             UART0        @ 0x20080000;
    eARM_PL011             UART1        @ 0x20090000;
    eARM_PL011             UART2        @ 0x200A0000;
    eHISI_LSADC            LSADC        @ 0x200B0000;
    eHISI_SPI              SPI0         @ 0x200C0000;
    eHISI_I2C_DW           I2C0         @ 0x200D0000;
    eHISI_SPI              SPI1         @ 0x200E0000;
    eHISI_IO_CONFIG_V2     IO_CONFIG    @ 0x200F0000;
    eHISI_KEY_CTRL         KEY_CTRL     @ 0x20100800;
    eHISI_DDRC_V2          DDRC         @ 0x20110000;
    eHISI_MISC_CTRL        MISC_CTRL    @ 0x20120000;
    eHISI_PWM              PWM0         @ 0x20130000;
    eHISI_PWM              PWM1         @ 0x20130020;
    eHISI_PWM              PWM2         @ 0x20130040;
    eHISI_PWM              PWM3         @ 0x20130060;
    eARM_PL061             GPIO0        @ 0x20140000;
    eARM_PL061             GPIO1        @ 0x20150000;
    eARM_PL061             GPIO2        @ 0x20160000;
    eARM_PL061             GPIO3        @ 0x20170000;
    eARM_PL061             GPIO4        @ 0x20180000;
    eARM_PL061             GPIO5        @ 0x20190000;
    eARM_PL061             GPIO6        @ 0x201A0000;
    eARM_PL061             GPIO7        @ 0x201B0000;
    eARM_PL061             GPIO8        @ 0x201C0000;
    eHISI_I2C_DW           I2C1         @ 0x20240000;
    eHISI_I2C_DW           I2C2         @ 0x20250000;
    eHISI_RSA              RSA          @ 0x20260000;
    eHISI_PMC              PMC          @ 0x20270000;
    eHISI_RNG              TRNG         @ 0x20280000;
    eHISI_VICAP_V2         VICAP        @ 0x20580000;
    eHISI_ISP              ISP          @ 0x205A0000;
    eHISI_VDP_V2           VDP          @ 0x205C0000;
    aHISI_VPSS             VPSS         @ 0x20600000;
    eHISI_TDE_G2             TDE          @ 0x20610000;
    aHISI_VEDU_V100        VEDU         @ 0x20620000;
    aHISI_VGS           VGS             @ 0x20630000;
    eHISI_AIAO             AIAO         @ 0x20650000;
    eHISI_JPGE             JPGE         @ 0x20660000;
    eHISI_MIPI_RX          MIPI         @ 0x20680000;
    eHISI_IVE              IVE          @ 0x206A0000;
    eHISI_DDRT             DDRT         @ 0x206D0000;
};
