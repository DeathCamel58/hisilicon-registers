`ifndef HI3520DV300_DDRC_PHY_RDL
`define HI3520DV300_DDRC_PHY_RDL
regfile eHI3520DV300_DDRC_PHY {
    name = "DDR PHY";
    desc = "DDR PHY of the Hi3521A/Hi3520D V300 at base 0x1211_C000. 128 registers extracted programmatically from the Hi3521A/Hi3520D V300 data sheet (Issue 00B07, 2015-12-10) (Table 4-12 Summary of DDR PHY registers (base address: 0x1211_C000)): register headings, offsets, total reset values, field bit ranges, access types, names, reset values and descriptions, with PDF page numbers in each register description. Field names, bit ranges, access types and offsets are exact; the free-text descriptions are taken from the cell text of the field table and were checked by sampling only. Hardware not verified.";
    reg {
        name = "REVISION";
        desc = "REVISION is a PHY control block version register. (offset 0x0; total reset 0x00000012; PROVEN: Hi3521A/Hi3520D V300 data sheet (Issue 00B07, 2015-12-10), section 4.1.9.2, PDF page 854).";
        field {
            name = "reserved";
            desc = "Reserved.";
            sw = r; hw = w;
            reset = 0x0;
        } reserved_31_16[31:16];
        field {
            name = "major";
            desc = "Major version of the PHY control block.";
            sw = r; hw = w;
            reset = 0x0;
        } major[15:8];
        field {
            name = "minor";
            desc = "Minor version of the PHY control block.";
            sw = r; hw = w;
            reset = 0x12;
        } minor[7:0];
    } REVISION @ 0x0;
    reg {
        name = "PHYINITCTRL";
        desc = "PHYINITCTRL is a PHY initialization control register. Writing to this register has no effect if init_en is 1. (offset 0x4; total reset 0x0000000E; PROVEN: Hi3521A/Hi3520D V300 data sheet (Issue 00B07, 2015-12-10), section 4.1.9.2, PDF page 855).";
        field {
            name = "ctl_cke_bypass";
            desc = "PACK CKE bypass function enable. 1'b1: CKE is controlled by MC even when PACK controls the DFI interface. 1'b0: CKE is controlled by PACK when PACK controls the DFI interface.";
            sw = rw; hw = r;
            reset = 0x0;
        } ctl_cke_bypass[31:31];
        field {
            name = "reserved";
            desc = "Reserved.";
            sw = r; hw = w;
            reset = 0x0;
        } reserved_30_16[30:16];
        field {
            name = "phyconn_rst";
            desc = "PHY counter reset. This field is used to set the PHY counter reset signal. To issue a reset signal to PHY counter, this field should be set to 1. To end the reset signal to PHY counter, this field should be cleared. Note that the reset signal connects to the A/C block counter and the counter of all of the data blocks.";
            sw = rw; hw = r;
            reset = 0x0;
        } phyconn_rst[15:15];
        field {
            name = "pack_rst";
            desc = "PACK reset. This field is used to issue reset to all the digital circuits of the PACK including the register file. If this field is set to 1, all of the digital parts (including control registers) of the PHY will be set to default value. The reset will be automatically executed, and this bit will be cleared after reset is complete.";
            sw = rw; hw = r;
            reset = 0x0;
        } pack_rst[14:14];
        field {
            name = "phy_rst";
            desc = "PHY reset. This field is used to set PHY reset signal. To issue a reset signal to the PHY, this field should be set to 1. To end the reset signal to the PHY, this field should be cleared. Note that the reset signal connects to the A/C block and all of the data blocks.";
            sw = rw; hw = r;
            reset = 0x0;
        } phy_rst[13:13];
        field {
            name = "dram_rst";
            desc = "DRAM reset. This field is used to initiate the DRAM reset sequence. If this field is set to 1, RESET# and CKE will be pulled low for t_dram_rst. After t_dram_rst, the CKE RESET# is pulled to high while keeping CKE at low for t_cke_low. After t_cke_low, CKE is pulled to high, and after t_cke_high, this field is cleared automatically. For LPDDR2/LPDDR3, only CKE will be active during DRAM reset sequence.";
            sw = rw; hw = r;
            reset = 0x0;
        } dram_rst[12:12];
        field {
            name = "cat_en";
            desc = "HW CA training enable. Writing 1 to this field starts the HW CA training sequence. This field will be cleared after CA training is complete. Note that the CA training applies only to LPDDR3.";
            sw = rw; hw = r;
            reset = 0x0;
        } cat_en[11:11];
        field {
            name = "dram_init_en";
            desc = "DRAM initialization enable. This field is used to control whether the internal DRAM initialization sequence is executed after PHY initialization is complete. For LPDDR2/LPDDR3, this field will complete the initial sequence including tINIT3-tINIT5 & tZQC.";
            sw = rw; hw = r;
            reset = 0x0;
        } dram_init_en[10:10];
        field {
            name = "wdet_en";
            desc = "Write data eye training enable. Writing 1 to this field starts the write data eye training sequence. This field will be cleared after the write data eye training is complete.";
            sw = rw; hw = r;
            reset = 0x0;
        } wdet_en[9:9];
        field {
            name = "rdet_en";
            desc = "Read data eye training enable. Writing 1 to this field starts the read data eye training sequence. This field will be cleared after the read data eye training is complete.";
            sw = rw; hw = r;
            reset = 0x0;
        } rdet_en[8:8];
        field {
            name = "wl2_en";
            desc = "Second write leveling enable. Writing 1 to this field starts write latency adjustment. This field will be cleared after adjustment is complete. Note that write leveling adjustment applies only to DDR3.";
            sw = rw; hw = r;
            reset = 0x0;
        } wl2_en[7:7];
        field {
            name = "gdst_en";
            desc = "PHY read data latch train enable. Writing 1 to this field starts the read data latch position training. This field will be cleared after write leveling is complete.";
            sw = rw; hw = r;
            reset = 0x0;
        } gdst_en[6:6];
        field {
            name = "gt_en";
            desc = "Gate training enable. Writing 1 to this field starts the gate training sequence. This field will be cleared after the gate training is complete.";
            sw = rw; hw = r;
            reset = 0x0;
        } gt_en[5:5];
        field {
            name = "wl_en";
            desc = "Write leveling enable. Writing 1 to this field starts the write leveling sequence. This field will be cleared after write leveling is complete. Note that write leveling applies only to DDR3.";
            sw = rw; hw = r;
            reset = 0x0;
        } wl_en[4:4];
        field {
            name = "zcal_en";
            desc = "Impedance calibration enable. This field is used to specify whether impedance calibration is executed. This bit will be cleared after impedance calibration is complete.";
            sw = rw; hw = r;
            reset = 0x1;
        } zcal_en[3:3];
        field {
            name = "dlymeas_en";
            desc = "Delay measurement enable. This field is used to enable initial delay measurement of the activated read delay line. If it is set to 1, delay measurement is enabled.";
            sw = rw; hw = r;
            reset = 0x1;
        } dlymeas_en[2:2];
        field {
            name = "pll_init_en";
            desc = "PLL initialization enable. If this field is used to activate the PLL initialization. If it is set to 1, the PLL is reset and waiting for a period of time for PLL to be locked.";
            sw = rw; hw = r;
            reset = 0x1;
        } pll_init_en[1:1];
        field {
            name = "init_en";
            desc = "PHY initialization enable. Writing 1 to this field triggers the PHY initialization sequence. The exact initialization executed is specified in bits 1-15 of this register. If PHY initialization is complete, this bit will be cleared. Note that writing 0 to this field has no effect.";
            sw = rw; hw = r;
            reset = 0x0;
        } init_en[0:0];
    } PHYINITCTRL @ 0x4;
    reg {
        name = "PHYINITSTATUS";
        desc = "PHYINITSTATUS is a PHY status register. (offset 0x8; total reset 0x00000000; PROVEN: Hi3521A/Hi3520D V300 data sheet (Issue 00B07, 2015-12-10), section 4.1.9.2, PDF page 857).";
        field {
            name = "reserved";
            desc = "Reserved.";
            sw = r; hw = w;
            reset = 0x0;
        } reserved_31_11[31:11];
        field {
            name = "cat_err";
            desc = "CA training error. This field indicates whether an error occurs during CA training. Writing 1 to this field clears the error status.

Access type RWC in the data sheet: written 1 clears the bit.";
            sw = rw; hw = w; onwrite = woclr;
            reset = 0x0;
        } cat_err[10:10];
        field {
            name = "wdet_err";
            desc = "Write data eye calibration error. This field indicates whether an error occurs during write data eye calibration. Writing 1 to this field clears the error status.

Access type RWC in the data sheet: written 1 clears the bit.";
            sw = rw; hw = w; onwrite = woclr;
            reset = 0x0;
        } wdet_err[9:9];
        field {
            name = "rdet_err";
            desc = "Read data eye calibration error. This field indicates whether an error occurs during read data eye calibration. Writing 1 to this field clears the error status.

Access type RWC in the data sheet: written 1 clears the bit.";
            sw = rw; hw = w; onwrite = woclr;
            reset = 0x0;
        } rdet_err[8:8];
        field {
            name = "wl2_err";
            desc = "Write leveling adjustment error. This field indicates whether an error occurs during write leveling adjustment. Writing 1 to this field clears the error status.

Access type RWC in the data sheet: written 1 clears the bit.";
            sw = rw; hw = w; onwrite = woclr;
            reset = 0x0;
        } wl2_err[7:7];
        field {
            name = "gdst_err";
            desc = "PHY read data latch train error. This field indicates whether an error occurs during read data latch training. Writing 1 to this field clears the error status.

Access type RWC in the data sheet: written 1 clears the bit.";
            sw = rw; hw = w; onwrite = woclr;
            reset = 0x0;
        } gdst_err[6:6];
        field {
            name = "gt_err";
            desc = "Gate training error. This field indicates whether an error occurs during gate training. Writing 1 to this field clears the error status.

Access type RWC in the data sheet: written 1 clears the bit.";
            sw = rw; hw = w; onwrite = woclr;
            reset = 0x0;
        } gt_err[5:5];
        field {
            name = "wl_err";
            desc = "Write leveling error. This field indicates whether an error occurs during write leveling. Writing 1 to this field clears the error status.

Access type RWC in the data sheet: written 1 clears the bit.";
            sw = rw; hw = w; onwrite = woclr;
            reset = 0x0;
        } wl_err[4:4];
        field {
            name = "zcal_err";
            desc = "Impedance calibration error. This field indicates whether an error occurs during impedance calibration. Writing 1 to this field clears the error status.

Access type RWC in the data sheet: written 1 clears the bit.";
            sw = rw; hw = w; onwrite = woclr;
            reset = 0x0;
        } zcal_err[3:3];
        field {
            name = "dlymeas_err";
            desc = "Delay measurement fail. This field indicates whether one of the initial delay measurements fails. Writing 1 to this field clears the error status.

Access type RWC in the data sheet: written 1 clears the bit.";
            sw = rw; hw = w; onwrite = woclr;
            reset = 0x0;
        } dlymeas_err[2:2];
        field {
            name = "pll_lock_err";
            desc = "PLL locked fail. This field indicates whether one of the PLLs within the PHY fails to assert locked flag after t_pll_lock timer. Writing 1 to this field clears the error status.

Access type RWC in the data sheet: written 1 clears the bit.";
            sw = rw; hw = w; onwrite = woclr;
            reset = 0x0;
        } pll_lock_err[1:1];
        field {
            name = "reserved";
            desc = "Reserved.";
            sw = r; hw = w;
            reset = 0x0;
        } reserved_0_0[0:0];
    } PHYINITSTATUS @ 0x8;
    reg {
        name = "PHYCLKGATED";
        desc = "PHYCLKGATED is a PHY clock gating control register. (offset 0xC; total reset 0x00000400; PROVEN: Hi3521A/Hi3520D V300 data sheet (Issue 00B07, 2015-12-10), section 4.1.9.2, PDF page 859).";
        field {
            name = "byp_pll_lock";
            desc = "PLL lock bypass. The user can assert this field to bypass the PLL lock signal when re-locking the PLL in the bypass mode (DFS) or when the PLL lock signal cannot be used.
- 0: use the PLL lock to gate the PHY clocks to prevent clock glitch
- 1: bypass the PLL lock (do not use the PLL lock signal to gate the

PHY clocks)";
            sw = rw; hw = r;
            reset = 0x0;
        } byp_pll_lock[31:31];
        field {
            name = "reserved";
            desc = "Reserved.";
            sw = r; hw = w;
            reset = 0x0;
        } reserved_30_13[30:13];
        field {
            name = "dx_phgated_men";
            desc = "PHY phase clock gated manual control enable. This field takes effect only when dx_phgated_en is 1'b0. If dx_phgated_en is high and this field is high, the user can use dx_phclkgated to manually control the clock gating of the PHY phase clock.
- 0: disabled
- 1: enabled";
            sw = rw; hw = r;
            reset = 0x0;
        } dx_phgated_men[12:12];
        field {
            name = "dx_phclkgated";
            desc = "PHY phase clock gated control. This field takes effect only when dx_phgated_en is 1'b0. If dx_phgated_en is '1b1, this field is used, and the gated function is automatically controlled by PACK FSM.
- 0: The clock is disabled.
- 1: The clock is enabled.";
            sw = rw; hw = r;
            reset = 0x0;
        } dx_phclkgated[11:11];
        field {
            name = "dx_phgated_en";
            desc = "PHY phase clock gated function (automatically controlled by PACK FSM) enable.
- 0: disabled
- 1: enabled";
            sw = rw; hw = r;
            reset = 0x1;
        } dx_phgated_en[10:10];
        field {
            name = "ck_phy_clkgated";
            desc = "Dedicated clock gated control for the output CK and related circuits.
- 0: The clock is gated.
- 1: The clock is enabled.

This field is automatically set to 1 when the PLL is locked without error.";
            sw = rw; hw = r;
            reset = 0x0;
        } ck_phy_clkgated[9:9];
        field {
            name = "ac_phy_clkgated";
            desc = "Clock gated for the circuits in AC block except CK and CK related circuits.
- 0: The clock is gated.
- 1: The clock is enabled.

This field is automatically set to 1 when the PLL is locked without error.";
            sw = rw; hw = r;
            reset = 0x0;
        } ac_phy_clkgated[8:8];
        field {
            name = "reserved";
            desc = "Reserved.";
            sw = r; hw = w;
            reset = 0x0;
        } reserved_7_4[7:4];
        field {
            name = "dx_phy_clkgated";
            desc = "Clock gated for circuits in data blocks.
- 0: The clock is gated.
- 1: The clock is enabled.

This field is automatically set to 1 when the PLL is locked without error.";
            sw = rw; hw = r;
            reset = 0x0;
        } dx_phy_clkgated[3:0];
    } PHYCLKGATED @ 0xC;
    reg {
        name = "PHYTIMER0";
        desc = "PHYTIMER0 is a PHY timing parameter register. The timing parameters are required by the PHY. (offset 0x10; total reset 0x2710000F; PROVEN: Hi3521A/Hi3520D V300 data sheet (Issue 00B07, 2015-12-10), section 4.1.9.2, PDF page 860).";
        field {
            name = "t_dram_cke_high";
            desc = "DRAM CKE high initialization. This field specifies the number of PCLK clock cycles of the first DRAM command from CKE pulled to high (LPDDR2/LPDDR3 tINIT3).";
            sw = rw; hw = r;
            reset = 0x27100;
        } t_dram_cke_high[31:12];
        field {
            name = "reserved";
            desc = "Reserved.";
            sw = r; hw = w;
            reset = 0x0;
        } reserved_11_8[11:8];
        field {
            name = "t_dram_reset";
            desc = "DDR3 DRAM reset. This field is used to specify the time issuing reset signaling to the DRAM (number of PCLK clock cycles).";
            sw = rw; hw = r;
            reset = 0xf;
        } t_dram_reset[7:0];
    } PHYTIMER0 @ 0x10;
    reg {
        name = "PHYTIMER1";
        desc = "PHYTIMER1 is a DRAM CKE low initialization register. (offset 0x14; total reset 0x00002000; PROVEN: Hi3521A/Hi3520D V300 data sheet (Issue 00B07, 2015-12-10), section 4.1.9.2, PDF page 861).";
        field {
            name = "reserved";
            desc = "Reserved.";
            sw = r; hw = w;
            reset = 0x0;
        } reserved_31_16[31:16];
        field {
            name = "t_dram_cke_low";
            desc = "DRAM CKE low initialization. This field specifies the number of PCLK clock cycles during which CKE should be kept low after power is reset and the clock is stable.";
            sw = rw; hw = r;
            reset = 0x2000;
        } t_dram_cke_low[15:0];
    } PHYTIMER1 @ 0x14;
    reg {
        name = "PLLCTRL";
        desc = "PLLCTRL is a timing parameter register for the PLL in both address/command and data block. (offset 0x18; total reset 0x00000000; PROVEN: Hi3521A/Hi3520D V300 data sheet (Issue 00B07, 2015-12-10), section 4.1.9.2, PDF page 861).";
        field {
            name = "reserved";
            desc = "Reserved.";
            sw = r; hw = w;
            reset = 0x0;
        } reserved_31_6[31:6];
        field {
            name = "pll_freq_range";
            desc = "PLL frequency range select. This field specifies the frequency input range of the PLLs.";
            sw = rw; hw = r;
            reset = 0x0;
        } pll_freq_range[5:4];
        field {
            name = "reserved";
            desc = "Reserved.";
            sw = r; hw = w;
            reset = 0x0;
        } reserved_3_3[3:3];
        field {
            name = "pll_pwdn";
            desc = "PLL power down. This field is used to set the power-down status of the PLL input. If this field is set to 1, the PLL power-down pin is activated. Writing 0 to this field will remove the deactivated PLL power down pin. Bit[2] for AC PLL Bit[1] for DX1 (DATA1) PLL Bit[0] for DX0 (DATA0) PLL";
            sw = rw; hw = r;
            reset = 0x0;
        } pll_pwdn[2:0];
    } PLLCTRL @ 0x18;
    reg {
        name = "PLLTIMER";
        desc = "PLLTIMER is a PLL address/command and data block control register. (offset 0x1C; total reset 0x4E200080; PROVEN: Hi3521A/Hi3520D V300 data sheet (Issue 00B07, 2015-12-10), section 4.1.9.2, PDF page 862).";
        field {
            name = "t_pll_lock";
            desc = "PLL lock time. This field specifies the number of PCLK clock cycles waiting for the PLL to be locked.";
            sw = rw; hw = r;
            reset = 0x4e20;
        } t_pll_lock[31:16];
        field {
            name = "reserved";
            desc = "Reserved.";
            sw = r; hw = w;
            reset = 0x0;
        } reserved_15_8[15:8];
        field {
            name = "t_pll_rst";
            desc = "PLL reset time. This field specifies the number of PCLK clock cycles to issue reset to the PLL.";
            sw = rw; hw = r;
            reset = 0x80;
        } t_pll_rst[7:0];
    } PLLTIMER @ 0x1C;
    reg {
        name = "DLYMEASCTRL";
        desc = "DLYMEASCTRL is a read delay line delay measurement control register. (offset 0x20; total reset 0x00000471; PROVEN: Hi3521A/Hi3520D V300 data sheet (Issue 00B07, 2015-12-10), section 4.1.9.2, PDF page 862).";
        field {
            name = "reserved";
            desc = "Reserved.";
            sw = r; hw = w;
            reset = 0x0;
        } reserved_31_15[31:15];
        field {
            name = "dly_track_limit";
            desc = "Delay tracking limit. This field specifies the maximum number of accumulated taps allowed while dynamic tracking.";
            sw = rw; hw = r;
            reset = 0x4;
        } dly_track_limit[14:8];
        field {
            name = "reserved";
            desc = "Reserved.";
            sw = r; hw = w;
            reset = 0x0;
        } reserved_7_7[7:7];
        field {
            name = "phy_autoref_en";
            desc = "PHY auto-refresh tracking enable.";
            sw = rw; hw = r;
            reset = 0x1;
        } phy_autoref_en[6:6];
        field {
            name = "dynamic_dqsen";
            desc = "Dynamic DQS tracking enable. This field should be set to high during delay measurement.";
            sw = rw; hw = r;
            reset = 0x1;
        } dynamic_dqsen[5:5];
        field {
            name = "dynamic_dqsgen";
            desc = "Dynamic DQSG tracking enable.";
            sw = rw; hw = r;
            reset = 0x1;
        } dynamic_dqsgen[4:4];
        field {
            name = "dynamic_dqsgth";
            desc = "Dynamic DQSG update threshold. This field specifies the number of taps accumulated before the RDQSG delay line is updated.
- 0: update every 4 times
- 1: update every 2 times 2 or 3: update each time";
            sw = rw; hw = r;
            reset = 0x0;
        } dynamic_dqsgth[3:2];
        field {
            name = "dly_track_type";
            desc = "Delay tracking type. This field specifies whether priority updated from the PHY is used during dynamic tracking. If this field is set to 1, the priority updated from the PHY is used.";
            sw = rw; hw = r;
            reset = 0x0;
        } dly_track_type[1:1];
        field {
            name = "dly_meas_type";
            desc = "Delay measurement type. This field specifies whether the delay measurement is for one clock cycle or half a clock cycle. If this field is set to 1, a full clock cycle is measured.";
            sw = rw; hw = r;
            reset = 0x1;
        } dly_meas_type[0:0];
    } DLYMEASCTRL @ 0x20;
    reg {
        name = "IMPCTRL";
        desc = "IMPCTRL is a ZQ calibration control register. (offset 0x24; total reset 0x80008020; PROVEN: Hi3521A/Hi3520D V300 data sheet (Issue 00B07, 2015-12-10), section 4.1.9.2, PDF page 863).";
        field {
            name = "zcfuzzy_en";
            desc = "ZQ comparator result selection by weighted method. When this function is disabled, the precision is improved but ZQ comparison may fail. When this function is enabled, ZQ comparison is successful.
- 0: disabled
- 1: enabled (default)";
            sw = rw; hw = r;
            reset = 0x1;
        } zcfuzzy_en[31:31];
        field {
            name = "reserved";
            desc = "Reserved.";
            sw = r; hw = w;
            reset = 0x0;
        } reserved_30_16[30:16];
        field {
            name = "zcomp_num";
            desc = "ZQ comparator iteration time. This field specifies the iteration time of zcomp changing detection.";
            sw = rw; hw = r;
            reset = 0x8;
        } zcomp_num[15:12];
        field {
            name = "reserved";
            desc = "Reserved.";
            sw = r; hw = w;
            reset = 0x0;
        } reserved_11_6[11:6];
        field {
            name = "zcomp_rsp_dly";
            desc = "ZQ comparator response time. This field specifies the delay of the zcomp result after zctrl is used.";
            sw = rw; hw = r;
            reset = 0x20;
        } zcomp_rsp_dly[5:0];
    } IMPCTRL @ 0x24;
    reg {
        name = "IMPSTATUS";
        desc = "IMPSTATUS is a ZQ calibration status register. (offset 0x28; total reset 0x00200020; PROVEN: Hi3521A/Hi3520D V300 data sheet (Issue 00B07, 2015-12-10), section 4.1.9.2, PDF page 864).";
        field {
            name = "reserved";
            desc = "Reserved.";
            sw = r; hw = w;
            reset = 0x0;
        } reserved_31_31[31:31];
        field {
            name = "zcode_pdrv_cal";
            desc = "P-drive impedance calibration code. This field shows the p-drive calibration code during impedance calibration.";
            sw = r; hw = w;
            reset = 0x0;
        } zcode_pdrv_cal[30:24];
        field {
            name = "pdrv_cal_result";
            desc = "P-drive calibration result. This field specifies the ZQ calibration result. The valid values are as follows:
- 0: calibration done with OK.
- 1: calibration done with error.

Writing 1 to this field clears this field.";
            sw = r; hw = w;
            reset = 0x0;
        } pdrv_cal_result[23:23];
        field {
            name = "reserved";
            desc = "Reserved.";
            sw = r; hw = w;
            reset = 0x0;
        } reserved_22_22[22:22];
        field {
            name = "zcode_pdrv";
            desc = "P-drive impedance control code. This field is used to specify the p-drive impedance control code. This register is updated by the user or is updated each time the ZQ calibration is complete.";
            sw = rw; hw = r;
            reset = 0x20;
        } zcode_pdrv[21:16];
        field {
            name = "reserved";
            desc = "Reserved.";
            sw = r; hw = w;
            reset = 0x0;
        } reserved_15_15[15:15];
        field {
            name = "zcode_ndrv_cal";
            desc = "N-drive impedance calibration code. This field shows the n-driver calibration code during impedance calibration.";
            sw = r; hw = w;
            reset = 0x0;
        } zcode_ndrv_cal[14:8];
        field {
            name = "ndrv_cal_result";
            desc = "N-drive calibration result. This field specifies the ZQ calibration result. The valid values are as follows:
- 0: calibration done with OK.
- 1: calibration done with error

Writing 1 to this field clears this field.";
            sw = r; hw = w;
            reset = 0x0;
        } ndrv_cal_result[7:7];
        field {
            name = "reserved";
            desc = "Reserved.";
            sw = r; hw = w;
            reset = 0x0;
        } reserved_6_6[6:6];
        field {
            name = "zcode_ndrv";
            desc = "N-drive impedance control code. This field is used to specify the n-drive impedance control code. This register is updated by the user or is updated each time the ZQ calibration is complete.";
            sw = rw; hw = r;
            reset = 0x20;
        } zcode_ndrv[5:0];
    } IMPSTATUS @ 0x28;
    reg {
        name = "DRAMCFG";
        desc = "DRAMCFG is a DRAM system configuration register. (offset 0x2C; total reset 0x00000405; PROVEN: Hi3521A/Hi3520D V300 data sheet (Issue 00B07, 2015-12-10), section 4.1.9.2, PDF page 865).";
        field {
            name = "reserved";
            desc = "Reserved.";
            sw = r; hw = w;
            reset = 0x0;
        } reserved_31_11[31:11];
        field {
            name = "lpddr23_zqc_en";
            desc = "LPDDR2/LPDDR3 initialization ZQC (init) enable.
- 0: disabled
- 1: issue ZQC(init) commands during initialization sequence rank by rank (default).";
            sw = rw; hw = r;
            reset = 0x1;
        } lpddr23_zqc_en[10:10];
        field {
            name = "lpddr23_mrw1617_en";
            desc = "LPDDR2/LPDDR3 initialization MRW16/17 enable.
- 0: disabled (default)
- 1: issue MRW16 then MRW17 commands during initialization sequence";
            sw = rw; hw = r;
            reset = 0x0;
        } lpddr23_mrw1617_en[9:9];
        field {
            name = "lpddr23_pre_en";
            desc = "LPDDR2/LPDDR3 initialization precharge all enable.
- 0: disabled (default)
- 1: issue the precharge all command before the reset command during initialization sequence";
            sw = rw; hw = r;
            reset = 0x0;
        } lpddr23_pre_en[8:8];
        field {
            name = "reserved";
            desc = "Address mirroring. This bit should be set to 0 in single rank configuration";
            sw = r; hw = w;
            reset = 0x0;
        } reserved_7_7[7:7];
        field {
            name = "maddr_mir";
            desc = "Address mirroring. This bit should be set to 0 in single rank configuration";
            sw = rw; hw = r;
            reset = 0x0;
        } maddr_mir[6:6];
        field {
            name = "ma2t";
            desc = "Two cycles on address/command. This field specifies whether the 2T timing should be used by the PHY controller that internally generates the DRAM command.";
            sw = rw; hw = r;
            reset = 0x0;
        } ma2t[5:5];
        field {
            name = "nosra";
            desc = "No simultaneous rank access. This field specifies whether simultaneously rank access in the same clock cycle is allowed. If it set to 1, the rank access will be taken in turn. Note that this field can be enabled only when the number of ranks is 2 or 4. This field should be set to 0 in single rank configuration";
            sw = rw; hw = r;
            reset = 0x0;
        } nosra[4:4];
        field {
            name = "reserved";
            desc = "Reserved.";
            sw = r; hw = w;
            reset = 0x0;
        } reserved_3_3[3:3];
        field {
            name = "dcfg_type";
            desc = "DRAM type selection. This field specifies the DDR RAM type. The valid values are as follows:
- 010: DDR3
- 101: LPDDR2/LPDDR3

Other values: reserved";
            sw = rw; hw = r;
            reset = 0x5;
        } dcfg_type[2:0];
    } DRAMCFG @ 0x2C;
    reg {
        name = "DRAMTIMER0";
        desc = "DRAMTIMER0 is a DRAM timing parameter register. The command delay specified in this register applies only to the command issued by the PHY controller internally. (offset 0x30; total reset 0x00000000; PROVEN: Hi3521A/Hi3520D V300 data sheet (Issue 00B07, 2015-12-10), section 4.1.9.2, PDF page 866).";
        field {
            name = "t_rc";
            desc = "Activated to activated on same bank command delay.";
            sw = rw; hw = r;
            reset = 0x0;
        } t_rc[31:26];
        field {
            name = "t_rrd";
            desc = "Activated to activated on different bank command delay.";
            sw = rw; hw = r;
            reset = 0x0;
        } t_rrd[25:22];
        field {
            name = "t_ras";
            desc = "Activated to precharge command delay.";
            sw = rw; hw = r;
            reset = 0x0;
        } t_ras[21:16];
        field {
            name = "t_rcd";
            desc = "Activated to read/write delay.";
            sw = rw; hw = r;
            reset = 0x0;
        } t_rcd[15:12];
        field {
            name = "t_rp";
            desc = "Precharge command period. The unit is two clock cycles.";
            sw = rw; hw = r;
            reset = 0x0;
        } t_rp[11:8];
        field {
            name = "t_wtr";
            desc = "Write to read command delay.";
            sw = rw; hw = r;
            reset = 0x0;
        } t_wtr[7:4];
        field {
            name = "t_rtp";
            desc = "Read to precharge command delay.";
            sw = rw; hw = r;
            reset = 0x0;
        } t_rtp[3:0];
    } DRAMTIMER0 @ 0x30;
    reg {
        name = "DRAMTIMER1";
        desc = "DRAMTIMER1 (offset 0x34; total reset 0x00000000; PROVEN: Hi3521A/Hi3520D V300 data sheet (Issue 00B07, 2015-12-10), section 4.1.9.2, PDF page 867).";
        field {
            name = "reserved";
            desc = "Reserved.";
            sw = r; hw = w;
            reset = 0x0;
        } reserved_31_30[31:30];
        field {
            name = "t_rtw";
            desc = "Read to write command delay. This field specifies whether to insert extra cycles between read and write commands to compensate tdqsck. This value should be 3 for the common condition when DDR3 is used. This value should be 6 for the common condition when LPDDR2/LPDDR3 is used.";
            sw = rw; hw = r;
            reset = 0x0;
        } t_rtw[29:25];
        field {
            name = "t_rfc";
            desc = "Refresh to refresh command delay.";
            sw = rw; hw = r;
            reset = 0x0;
        } t_rfc[24:16];
        field {
            name = "reserved";
            desc = "Reserved.";
            sw = r; hw = w;
            reset = 0x0;
        } reserved_15_15[15:15];
        field {
            name = "t_faw";
            desc = "Four-bank activated period. This field applies only to the 8-bank device.";
            sw = rw; hw = r;
            reset = 0x0;
        } t_faw[14:9];
        field {
            name = "t_mod";
            desc = "Load mode register to non load mode register command delay. This field is used as max (t_mod, t_mrd) in DDR3, max (t_mrw, tmrd) in LPDDR3, and t_mrw in LPDDR2.";
            sw = rw; hw = r;
            reset = 0x0;
        } t_mod[8:4];
        field {
            name = "t_mrd";
            desc = "Load mode register to load mode register command delay. Not used.";
            sw = rw; hw = r;
            reset = 0x0;
        } t_mrd[3:0];
    } DRAMTIMER1 @ 0x34;
    reg {
        name = "DRAMTIMER2";
        desc = "DRAMTIMER2 (offset 0x38; total reset 0x00000000; PROVEN: Hi3521A/Hi3520D V300 data sheet (Issue 00B07, 2015-12-10), section 4.1.9.2, PDF page 868).";
        field {
            name = "t_ccd";
            desc = "Read to read and write to write command delay.
- 0 = BL/2 (for DDR3, this value should be 4)
- 1 = BL/2 + 1 (for DDR3, this value should be 5)";
            sw = rw; hw = r;
            reset = 0x0;
        } t_ccd[31:31];
        field {
            name = "reserved";
            desc = "Reserved.";
            sw = r; hw = w;
            reset = 0x0;
        } reserved_30_30[30:30];
        field {
            name = "t_dllk";
            desc = "DLL lock time.";
            sw = rw; hw = r;
            reset = 0x0;
        } t_dllk[29:20];
        field {
            name = "t_cke";
            desc = "CKE minimum pulse width.";
            sw = rw; hw = r;
            reset = 0x0;
        } t_cke[19:16];
        field {
            name = "reserved";
            desc = "Reserved.";
            sw = r; hw = w;
            reset = 0x0;
        } reserved_15_15[15:15];
        field {
            name = "t_xp";
            desc = "Power down exit delay.";
            sw = rw; hw = r;
            reset = 0x0;
        } t_xp[14:10];
        field {
            name = "t_xs";
            desc = "Self refresh exit delay.";
            sw = rw; hw = r;
            reset = 0x0;
        } t_xs[9:0];
    } DRAMTIMER2 @ 0x38;
    reg {
        name = "DRAMTIMER3";
        desc = "DRAMTIMER3 (offset 0x3C; total reset 0x00100200; PROVEN: Hi3521A/Hi3520D V300 data sheet (Issue 00B07, 2015-12-10), section 4.1.9.2, PDF page 868).";
        field {
            name = "t_wr";
            desc = "Write recovery cycle.";
            sw = rw; hw = r;
            reset = 0x0;
        } t_wr[31:28];
        field {
            name = "t_wl";
            desc = "Write latency (AL + CWL).";
            sw = rw; hw = r;
            reset = 0x0;
        } t_wl[27:24];
        field {
            name = "t_init5";
            desc = "LPDDR device initialization time. This field specifies the time during which the LPDDR sets the DAI bit to 1.";
            sw = rw; hw = r;
            reset = 0x400;
        } t_init5[23:10];
        field {
            name = "t_zcal";
            desc = "ZQ calibration to command delay. This field specifies the number of clock cycles to wait after initial ZQ calibration. For DDR3 ZQ normal operation full calibration, this value is divided by 2. For DDR3 ZQ initialization calibration, this value is divided by 4. For LPDDR2/3, this field specifies the value of tZQINIT during initialization.";
            sw = rw; hw = r;
            reset = 0x200;
        } t_zcal[9:0];
    } DRAMTIMER3 @ 0x3C;
    reg {
        name = "DRAMTIMER4";
        desc = "DRAMTIMER4 is a DRAM write leveling timing parameter register. This register applies only to the DDR3/LPDDR3 SDRAM. (offset 0x40; total reset 0x00000000; PROVEN: Hi3521A/Hi3520D V300 data sheet (Issue 00B07, 2015-12-10), section 4.1.9.2, PDF page 869).";
        field {
            name = "reserved";
            desc = "Reserved.";
            sw = r; hw = w;
            reset = 0x0;
        } reserved_31_28[31:28];
        field {
            name = "t_odton";
            desc = "ODT turn-on latency (number of cycles from write command to assert of ODT).";
            sw = rw; hw = r;
            reset = 0x0;
        } t_odton[27:24];
        field {
            name = "reserved";
            desc = "Reserved.";
            sw = r; hw = w;
            reset = 0x0;
        } reserved_23_16[23:16];
        field {
            name = "t_odt";
            desc = "ODT turn-on cycles.";
            sw = rw; hw = r;
            reset = 0x0;
        } t_odt[15:12];
        field {
            name = "t_wlo";
            desc = "Write leveling output delay. This field specifies the write leveling output delay in cycles (dficlk cycle).";
            sw = rw; hw = r;
            reset = 0x0;
        } t_wlo[11:7];
        field {
            name = "reserved";
            desc = "Reserved.";
            sw = r; hw = w;
            reset = 0x0;
        } reserved_6_6[6:6];
        field {
            name = "t_wlmrd";
            desc = "Write leveling mode programmed (load mode register) to first DQS/DQS# rising edge delay (dficlk cycle).";
            sw = rw; hw = r;
            reset = 0x0;
        } t_wlmrd[5:0];
    } DRAMTIMER4 @ 0x40;
    reg {
        name = "ODTCR";
        desc = "ODTCR is a rank ODT control register while reading or writing to particular ranks. (offset 0x44; total reset 0x00000000; PROVEN: Hi3521A/Hi3520D V300 data sheet (Issue 00B07, 2015-12-10), section 4.1.9.2, PDF page 870).";
        field {
            name = "reserved";
            desc = "Reserved.";
            sw = r; hw = w;
            reset = 0x0;
        } reserved_31_16[31:16];
        field {
            name = "wodt_rank3";
            desc = "Write rank 3 ODT control. This field specifies the ODT issued while write on rank 3. The valid bit width is the number of ranks.";
            sw = rw; hw = r;
            reset = 0x0;
        } wodt_rank3[15:12];
        field {
            name = "wodt_rank2";
            desc = "Write rank 2 ODT control. This field specifies the ODT issued while write on rank 2. The valid bit width is the number of ranks.";
            sw = rw; hw = r;
            reset = 0x0;
        } wodt_rank2[11:8];
        field {
            name = "wodt_rank1";
            desc = "Write rank 1 ODT control. This field specifies the ODT issued while write on rank 1. The valid bit width is the number of ranks.";
            sw = rw; hw = r;
            reset = 0x0;
        } wodt_rank1[7:4];
        field {
            name = "wodt_rank0";
            desc = "Write rank 0 ODT control. This field specifies the ODT issued while write on rank 0. The valid bit width is the number of ranks.";
            sw = rw; hw = r;
            reset = 0x0;
        } wodt_rank0[3:0];
    } ODTCR @ 0x44;
    reg {
        name = "TRAINCTRL0";
        desc = "TRAINCTRL0 is a training control register. (offset 0x48; total reset 0xD0441080; PROVEN: Hi3521A/Hi3520D V300 data sheet (Issue 00B07, 2015-12-10), section 4.1.9.2, PDF page 871).";
        field {
            name = "skip_eye_opening";
            desc = "Skip eye opening of data eye training. This field specifies whether the eye opening should be skipped. If this field is set to 1, the eye opening before data eye training is skipped. If this field is set to 0, the eye opening is executed before data eye training.";
            sw = rw; hw = r;
            reset = 0x1;
        } skip_eye_opening[31:31];
        field {
            name = "dtrerrstop";
            desc = "Data training error stop. This field controls whether the data training is terminated if an error occurs. The data training is stopped if this bit is set to 1. If this bit set to 0, the training will continue even an error occurs. The error status is recorded no matter when this field is set to 0 or 1.";
            sw = rw; hw = r;
            reset = 0x1;
        } dtrerrstop[30:30];
        field {
            name = "gtds_rspdly";
            desc = "Gate/Read latch training response delay. This field specifies the waiting time to check the response from PHY while gate and read latch training is performed (dficlk cycle).";
            sw = rw; hw = r;
            reset = 0x10;
        } gtds_rspdly[29:24];
        field {
            name = "dqsg_cstep";
            desc = "Gate training coarse tuning step (the unit is phase). The recommended values are 0x0-0x2. 2'd0: step = 1 2'd1: step = 2 (default) 2'd2: step = 3 2'd3: step = 4";
            sw = rw; hw = r;
            reset = 0x1;
        } dqsg_cstep[23:22];
        field {
            name = "dqsgrt_chk";
            desc = "Gate retraining check window. This field specifies the delta value to be checked during gate retraining check. The delta is added/subtracted to/from the read DQS gate. This position is checked to determine whether gating phase adjustment is required. The phase movement is the configured value multiple by 2. Note that 3'b000 is reserved and should not be used. The recommended values are 0x1-0x3.";
            sw = rw; hw = r;
            reset = 0x4;
        } dqsgrt_chk[21:16];
        field {
            name = "dqsgrt_shft";
            desc = "Gate retraining shift window. This field specifies the value to be shifted if gate phase adjustment is required after gate retraining checks. The phase movement is the configured value multiple by 2. Note that 3'b000 is reserved and should not be used. The recommended value is dqsgrt_chk.";
            sw = rw; hw = r;
            reset = 0x4;
        } dqsgrt_shft[15:10];
        field {
            name = "dqsgsl_mrgn";
            desc = "Read DQS gate margin. This field specifies the margin to be reserved after the DQS gate training. The number of phases specified in this field is decreased to create DQS gating margin. The valid values are as follows: 6'b00100: 1/4 cycle 6'b01000: 1/2 cycle (recommended) 6'b01100: 3/4 cycle 6'b10000: 1 cycle Other values: reserved";
            sw = rw; hw = r;
            reset = 0x8;
        } dqsgsl_mrgn[9:4];
        field {
            name = "dtr_rank";
            desc = "Training rank. This field specifies the rank used for training. After the training, this field is used to select the source of rank specific settings.";
            sw = rw; hw = r;
            reset = 0x0;
        } dtr_rank[3:0];
    } TRAINCTRL0 @ 0x48;
    reg {
        name = "RANKEN";
        desc = "RANKEN is a training rank control register. (offset 0x4C; total reset 0x00000003; PROVEN: Hi3521A/Hi3520D V300 data sheet (Issue 00B07, 2015-12-10), section 4.1.9.2, PDF page 872).";
        field {
            name = "reserved";
            desc = "Reserved.";
            sw = r; hw = w;
            reset = 0x0;
        } reserved_31_16[31:16];
        field {
            name = "rank_en";
            desc = "Training rank enable. This field specifies whether the dtr_rank is enabled.
- 0: disabled
- 1: enabled (default)

Bit 0 indicates rank 0. Bit 1 indicates rank 1. ... Bit 15 indicates rank 15. The maximum number of ranks is specified by the system.";
            sw = rw; hw = r;
            reset = 0x3;
        } rank_en[15:0];
    } RANKEN @ 0x4C;
    reg {
        name = "TRAINMADDR";
        desc = "TRAINMADDR is a data training memory start address register. The minimum space required for the data training is 64 bytes, and the allocated memory must be 64-byte-aligned. (offset 0x50; total reset 0x00000000; PROVEN: Hi3521A/Hi3520D V300 data sheet (Issue 00B07, 2015-12-10), section 4.1.9.2, PDF page 873).";
        field {
            name = "dtrow";
            desc = "Data training row address. This field is used to configure the memory row address required for the data training.";
            sw = rw; hw = r;
            reset = 0x0;
        } dtrow[31:16];
        field {
            name = "dtcol";
            desc = "Data training column address. This field is used to configure the column address required for the data training. The field should be 0.";
            sw = rw; hw = r;
            reset = 0x0;
        } dtcol[15:4];
        field {
            name = "reserved";
            desc = "Reserved.";
            sw = r; hw = w;
            reset = 0x0;
        } reserved_3_3[3:3];
        field {
            name = "dtbank";
            desc = "Data training bank address. This field is used to configure the memory bank address required for the data training.";
            sw = rw; hw = r;
            reset = 0x0;
        } dtbank[2:0];
    } TRAINMADDR @ 0x50;
    reg {
        name = "BISTCTRL";
        desc = "BISTCTRL is a BIST behavior register. (offset 0x54; total reset 0x00000000; PROVEN: Hi3521A/Hi3520D V300 data sheet (Issue 00B07, 2015-12-10), section 4.1.9.2, PDF page 874).";
        field {
            name = "reserved";
            desc = "Reserved.";
            sw = r; hw = w;
            reset = 0x0;
        } reserved_31_24[31:24];
        field {
            name = "bist_fail_stop";
            desc = "BIST stop error count. This field specifies the number of failures at which the BIST should be stopped. If this field is set to 0x00, the BIST will run infinite until the BIST operation is stopped or reset. If a non-zero value is specified, the BIST is stopped while the accumulated errors reach the count specified in this field.";
            sw = rw; hw = r;
            reset = 0x0;
        } bist_fail_stop[23:16];
        field {
            name = "reserved";
            desc = "Reserved.";
            sw = r; hw = w;
            reset = 0x0;
        } reserved_15_10[15:10];
        field {
            name = "bist_pat";
            desc = "BIST pattern generation. This field specifies the BIST pattern generated for test. Note that bist_pat can be changed only when bist_done is 1.
- 00: walking 0
- 01: walking 1
- 10: LFSR-based random generation
- 11: user programmed";
            sw = rw; hw = r;
            reset = 0x0;
        } bist_pat[9:8];
        field {
            name = "reserved";
            desc = "Reserved.";
            sw = r; hw = w;
            reset = 0x0;
        } reserved_7_7[7:7];
        field {
            name = "bist_mode";
            desc = "BIST mode select. This field specifies the BIST mode. The valid values are as follows:
- 000: pattern generated only
- 100: loopback before output buffer
- 101: loopback after output buffer
- 110: DRAM read/write mode

Other values: reserved Note that bist_mode can be changed only when bist_done is 1. When the data loopback mode is selected, swapwl_en/swap_en must be set to all zeros (no swap).";
            sw = rw; hw = r;
            reset = 0x0;
        } bist_mode[6:4];
        field {
            name = "reserved";
            desc = "Reserved.";
            sw = r; hw = w;
            reset = 0x0;
        } reserved_3_2[3:2];
        field {
            name = "bist_op";
            desc = "During Reg write, this field is used for selecting the BIST operation. The valid values are as follows:
- 00: BIST stop
- 01: BIST run
- 10: BIST reset
- 11: reserved

Writing the Reset clears all the status registers, and this field is cleared to BIST Stop. During Reg read, this field is for BIST active status (only bit 0 is valid, and bit1 is read as 1'b0).
- 0: BIST inactive
- 1: BIST active";
            sw = rw; hw = r;
            reset = 0x0;
        } bist_op[1:0];
    } BISTCTRL @ 0x54;
    reg {
        name = "BISTDATA0";
        desc = "BISTDATA0 is DRAM loopback test BIST data register 0. This register is valid only when bist_pat is set to \"User Defined.\" (offset 0x58; total reset 0x00000000; PROVEN: Hi3521A/Hi3520D V300 data sheet (Issue 00B07, 2015-12-10), section 4.1.9.2, PDF page 875).";
        field {
            name = "bist_data_b3";
            desc = "BIST data byte 3. This field is used as the fourth beat of burst during BIST test";
            sw = rw; hw = r;
            reset = 0x0;
        } bist_data_b3[31:24];
        field {
            name = "bist_data_b2";
            desc = "BIST data byte 2. This field is used as the third beat of burst during BIST test.";
            sw = rw; hw = r;
            reset = 0x0;
        } bist_data_b2[23:16];
        field {
            name = "bist_data_b1";
            desc = "BIST data byte 1. This field is used as the second beat of burst during BIST test.";
            sw = rw; hw = r;
            reset = 0x0;
        } bist_data_b1[15:8];
        field {
            name = "bist_data_b0";
            desc = "BIST data byte 0. This field is used as the first beat of burst during BIST test.";
            sw = rw; hw = r;
            reset = 0x0;
        } bist_data_b0[7:0];
    } BISTDATA0 @ 0x58;
    reg {
        name = "BISTDATA1";
        desc = "BISTDATA1 is DRAM loopback test BIST data register 1. (offset 0x5C; total reset 0x00000000; PROVEN: Hi3521A/Hi3520D V300 data sheet (Issue 00B07, 2015-12-10), section 4.1.9.2, PDF page 876).";
        field {
            name = "bist_data_b7";
            desc = "BIST data byte 7. This field is used as the eighth beat of burst during BIST test";
            sw = rw; hw = r;
            reset = 0x0;
        } bist_data_b7[31:24];
        field {
            name = "bist_data_b6";
            desc = "BIST data byte 6. This field is used as the sixth beat of burst during BIST test.";
            sw = rw; hw = r;
            reset = 0x0;
        } bist_data_b6[23:16];
        field {
            name = "bist_data_b5";
            desc = "BIST data byte 5. This field is used as the fifth beat of burst during BIST test.";
            sw = rw; hw = r;
            reset = 0x0;
        } bist_data_b5[15:8];
        field {
            name = "bist_data_b4";
            desc = "BIST data byte 4. This field is used as the fourth beat of burst during BIST test.";
            sw = rw; hw = r;
            reset = 0x0;
        } bist_data_b4[7:0];
    } BISTDATA1 @ 0x5C;
    reg {
        name = "BISTSTATUS";
        desc = "BISTSTATUS is a BIST test result and status register. (offset 0x60; total reset 0x00000001; PROVEN: Hi3521A/Hi3520D V300 data sheet (Issue 00B07, 2015-12-10), section 4.1.9.2, PDF page 876).";
        field {
            name = "reserved";
            desc = "Reserved.";
            sw = r; hw = w;
            reset = 0x0;
        } reserved_31_3[31:3];
        field {
            name = "bist_dxerr";
            desc = "BIST error on DX blocks. This bit shows whether any error occurs on the DXn during BIST test.";
            sw = r; hw = w;
            reset = 0x0;
        } bist_dxerr[2:2];
        field {
            name = "bist_acerr";
            desc = "BIST error on AC block. This bit shows whether any error occurs on the AC during BIST test.";
            sw = r; hw = w;
            reset = 0x0;
        } bist_acerr[1:1];
        field {
            name = "bist_done";
            desc = "BIST done. This field shows whether the BIST is complete. Note that if the BIST Stop Error Count field (bist_fail_stop) is set to 0, this field is never asserted.";
            sw = r; hw = w;
            reset = 0x1;
        } bist_done[0:0];
    } BISTSTATUS @ 0x60;
    reg {
        name = "MODEREG01";
        desc = "MODEREG01 is mode register content register 1. (offset 0x64; total reset 0x00000000; PROVEN: Hi3521A/Hi3520D V300 data sheet (Issue 00B07, 2015-12-10), section 4.1.9.2, PDF page 877).";
        field {
            name = "mr1";
            desc = "Mode register 1. For DDR/DDR2/DDR3/LPDDR, this field specifies the content of extend mode register 1. For LPDDR2/LPDDR3, this field defines the content of MR3/MR9 (mode register). bit[31:24]: MR9 OP bit[23:16]: MR3 OP";
            sw = rw; hw = r;
            reset = 0x0;
        } mr1[31:16];
        field {
            name = "mr0";
            desc = "Mode register 0. For DDR/DDR2/DDR3/LPDDR, this field specifies the content of mode register 0. For LPDDR2/LPDDR3, this field defines the mode registers MR1/MR2. bit[15:8]: MR2 OP bit[7:0]: MR1 OP";
            sw = rw; hw = r;
            reset = 0x0;
        } mr0[15:0];
    } MODEREG01 @ 0x64;
    reg {
        name = "MODEREG23";
        desc = "MODEREG23 is mode register content register 2. (offset 0x68; total reset 0xFF0A0000; PROVEN: Hi3521A/Hi3520D V300 data sheet (Issue 00B07, 2015-12-10), section 4.1.9.2, PDF page 878).";
        field {
            name = "mr3";
            desc = "Mode register 3. For DDR/DDR2/DDR3, this field specifies extend mode register 3. For LPDDR2/LPDDR3, this field is for the ZQ commands. bit[31:24]: OP bit[23:16]: MA The ZQ commands are issued rank by rank after tINIT5. bit[31:24]: MR10 OP bit[23:16]: MR10 MA";
            sw = rw; hw = r;
            reset = 0xff0a;
        } mr3[31:16];
        field {
            name = "mr2";
            desc = "Mode register 2. For DDR/DDR2/DDR3, this field specifies extend mode register 2. For LPDDR2/LPDDR3, this field specifies MR16/MR17. bit[15:8]: MR17 OP bit[7:0]: MR16 OP";
            sw = rw; hw = r;
            reset = 0x0;
        } mr2[15:0];
    } MODEREG23 @ 0x68;
    reg {
        name = "DETPATTERN";
        desc = "DETPATTERN is a write/read DET pattern register. These fields are used to fine-tune the training procedure. You are advised not to modify them. (offset 0x6C; total reset 0x00FFAA55; PROVEN: Hi3521A/Hi3520D V300 data sheet (Issue 00B07, 2015-12-10), section 4.1.9.2, PDF page 878).";
        field {
            name = "reserved";
            desc = "Reserved.";
            sw = r; hw = w;
            reset = 0x0;
        } reserved_31_24[31:24];
        field {
            name = "det_patFF";
            desc = "DET pattern 2.";
            sw = rw; hw = r;
            reset = 0xff;
        } det_patFF[23:16];
        field {
            name = "det_patAA";
            desc = "DET pattern 1.";
            sw = rw; hw = r;
            reset = 0xaa;
        } det_patAA[15:8];
        field {
            name = "det_pat55";
            desc = "DET pattern 0.";
            sw = rw; hw = r;
            reset = 0x55;
        } det_pat55[7:0];
    } DETPATTERN @ 0x6C;
    reg {
        name = "MISC";
        desc = "MISC is a miscellaneous control register. (offset 0x70; total reset 0x00080000; PROVEN: Hi3521A/Hi3520D V300 data sheet (Issue 00B07, 2015-12-10), section 4.1.9.2, PDF page 879).";
        field {
            name = "swapdfibyte_en";
            desc = "Swap DFI byte lane.
- 00: no swap
- 01: swap";
            sw = rw; hw = r;
            reset = 0x0;
        } swapdfibyte_en[31:30];
        field {
            name = "swapwl_en";
            desc = "Swap WL/CA result.
- 000: no swap
- 001: swap 1
- 010: swap 2
- 011: swap 3
- 100: swap 4

Note: When the data BIST loopback mode is selected, this field must be set to 0x0.";
            sw = rw; hw = r;
            reset = 0x0;
        } swapwl_en[29:27];
        field {
            name = "swapdm_en";
            desc = "Swap DM bus.
- 00: no swap
- 01: 16-bit T2 swap";
            sw = rw; hw = r;
            reset = 0x0;
        } swapdm_en[26:25];
        field {
            name = "swapaddr_en";
            desc = "Swap address bus.
- 00: no swap
- 01: 32-bit flyby-4, flyby-2 swap
- 10: 16-bit T-2 swap";
            sw = rw; hw = r;
            reset = 0x0;
        } swapaddr_en[24:23];
        field {
            name = "swap_en";
            desc = "Swap DQ bus bit[1:0].
- 000: no swap
- 001: swap 1
- 010: swap 2
- 011: swap 3
- 100: swap 4

When the data BIST loopback mode is selected, this field must be set to 0x0.";
            sw = rw; hw = r;
            reset = 0x0;
        } swap_en[22:21];
        field {
            name = "cfg_dlyupd";
            desc = "Transparent mode for the delay update module. When this bit is set to 1, the delay setting in registers are applied to the PHY immediately.";
            sw = rw; hw = r;
            reset = 0x0;
        } cfg_dlyupd[20:20];
        field {
            name = "addr_delay";
            desc = "Add 1-T delay on address/command. This bit must be set to 1 when CWL is 5.";
            sw = rw; hw = r;
            reset = 0x1;
        } addr_delay[19:19];
        field {
            name = "swap_en_msb";
            desc = "Swap DQ bus bit[2].
- 000: no swap
- 001: swap 1
- 010: swap 2
- 011: swap 3
- 100: swap 4

When the data BIST loopback mode is selected, this field must be set to 0x0.";
            sw = rw; hw = r;
            reset = 0x0;
        } swap_en_msb[18:18];
        field {
            name = "addr_toggle";
            desc = "Toggle address bus every clock cycle. This bit is set to 1 only for the burn-in test.";
            sw = rw; hw = r;
            reset = 0x0;
        } addr_toggle[17:17];
        field {
            name = "scramb_en";
            desc = "Data scrambler enable. Set this field to 1 to enable data scramble function";
            sw = rw; hw = r;
            reset = 0x0;
        } scramb_en[16:16];
        field {
            name = "reserved";
            desc = "Reserved.";
            sw = r; hw = w;
            reset = 0x0;
        } reserved_15_12[15:12];
        field {
            name = "cfg_rl";
            desc = "PHY read latency. It defines the number of cycles from read command to assert of rddata_en and is equal to CL + AL - 2 (for LPDDR2/3, the field should be RL-2).";
            sw = rw; hw = r;
            reset = 0x0;
        } cfg_rl[11:7];
        field {
            name = "reserved";
            desc = "Reserved.";
            sw = r; hw = w;
            reset = 0x0;
        } reserved_6_5[6:5];
        field {
            name = "cfg_wl";
            desc = "PHY write latency. It defines the number of cycles from write command to assert of wrdata_en and is equal to CWL + AL - 1 (for LPDDR2/3, the field should be WL + 1). If the DFI clock ratio is 1:2, cfg_wl must be greater than or equal to 2.";
            sw = rw; hw = r;
            reset = 0x0;
        } cfg_wl[4:0];
    } MISC @ 0x70;
    reg {
        name = "RNK2RNK";
        desc = "RNK2RNK is a rank-to-rank delay control register. (offset 0x74; total reset 0x00000000; PROVEN: Hi3521A/Hi3520D V300 data sheet (Issue 00B07, 2015-12-10), section 4.1.9.2, PDF page 881).";
        field {
            name = "reserved";
            desc = "Reserved.";
            sw = r; hw = w;
            reset = 0x0;
        } reserved_31_20[31:20];
        field {
            name = "trnkwtr";
            desc = "Delay from write to read command targeted to different ranks.";
            sw = rw; hw = r;
            reset = 0x0;
        } trnkwtr[19:15];
        field {
            name = "trnkrtw";
            desc = "Delay from read to write command targeted to different ranks.";
            sw = rw; hw = r;
            reset = 0x0;
        } trnkrtw[14:10];
        field {
            name = "trnkrtr";
            desc = "Delay from read to read command targeted to different ranks.";
            sw = rw; hw = r;
            reset = 0x0;
        } trnkrtr[9:5];
        field {
            name = "trnkwtw";
            desc = "Delay from write to write command targeted to different ranks.";
            sw = rw; hw = r;
            reset = 0x0;
        } trnkwtw[4:0];
    } RNK2RNK @ 0x74;
    reg {
        name = "PHYCTRL0";
        desc = "PHYCTRL0 is PHY control register 0. Register in this field are connected to PHY interface directly (offset 0x78; total reset 0x00003980; PROVEN: Hi3521A/Hi3520D V300 data sheet (Issue 00B07, 2015-12-10), section 4.1.9.2, PDF page 881).";
        field {
            name = "reserved";
            desc = "Reserved.";
            sw = r; hw = w;
            reset = 0x0;
        } reserved_31_14[31:14];
        field {
            name = "resetoen";
            desc = "Set this field to default value.";
            sw = rw; hw = r;
            reset = 0x1;
        } resetoen[13:13];
        field {
            name = "csoen";
            desc = "Set this field to default value.";
            sw = rw; hw = r;
            reset = 0x1;
        } csoen[12:12];
        field {
            name = "ckeoen";
            desc = "Set this field to default value.";
            sw = rw; hw = r;
            reset = 0x1;
        } ckeoen[11:11];
        field {
            name = "ckoen";
            desc = "Set this field to default value.";
            sw = rw; hw = r;
            reset = 0x1;
        } ckoen[10:8];
        field {
            name = "cmdoen";
            desc = "Set this field to default value.";
            sw = rw; hw = r;
            reset = 0x1;
        } cmdoen[7:7];
        field {
            name = "reserved";
            desc = "Set this field to default value.";
            sw = r; hw = w;
            reset = 0x0;
        } reserved_6_5[6:5];
        field {
            name = "lp_ck_sel";
            desc = "Set this field to default value.";
            sw = rw; hw = r;
            reset = 0x0;
        } lp_ck_sel[4:3];
        field {
            name = "sel_pos_rx";
            desc = "PHY output trigger edge select.
- 0: falling edge
- 1: rising edge";
            sw = rw; hw = r;
            reset = 0x0;
        } sel_pos_rx[2:2];
        field {
            name = "reserved";
            desc = "Reserved.";
            sw = r; hw = w;
            reset = 0x0;
        } reserved_1_0[1:0];
    } PHYCTRL0 @ 0x78;
    reg {
        name = "PHYDBG";
        desc = "PHYDBG is a PHY debug register. (offset 0x7C; total reset 0x00000000; PROVEN: Hi3521A/Hi3520D V300 data sheet (Issue 00B07, 2015-12-10), section 4.1.9.2, PDF page 882).";
        field {
            name = "reserved";
            desc = "Reserved.";
            sw = r; hw = w;
            reset = 0x0;
        } reserved_31_24[31:24];
        field {
            name = "dqsb_gated_error";
            desc = "DQSN gated error flag. This error flag can be cleared only by issuing PHY reset.";
            sw = r; hw = w;
            reset = 0x0;
        } dqsb_gated_error[23:16];
        field {
            name = "reserved";
            desc = "Reserved.";
            sw = r; hw = w;
            reset = 0x0;
        } reserved_15_8[15:8];
        field {
            name = "dqs_gated_error";
            desc = "DQS gated error flag. This error flag can be cleared only by issuing PHY reset.";
            sw = r; hw = w;
            reset = 0x0;
        } dqs_gated_error[7:0];
    } PHYDBG @ 0x7C;
    reg {
        name = "RETCTRL0";
        desc = "RETCTRL0 is a retraining control register. (offset 0x80; total reset 0x00012400; PROVEN: Hi3521A/Hi3520D V300 data sheet (Issue 00B07, 2015-12-10), section 4.1.9.2, PDF page 883).";
        field {
            name = "retrain_thrd";
            desc = "Retraining threshold. The PHY counts the number of AREFs issued by MC. When the number reaches the threshold, the retraining operation is triggered to be started. Only a non-zero value is valid.";
            sw = rw; hw = r;
            reset = 0x1;
        } retrain_thrd[31:16];
        field {
            name = "reserved";
            desc = "Reserved.";
            sw = r; hw = w;
            reset = 0x0;
        } reserved_15_15[15:15];
        field {
            name = "gtrten";
            desc = "Gate retraining active. This field controls whether the gate retraining is executed during retraining on-going. This field should be asserted only after the initial gate training is complete.";
            sw = rw; hw = r;
            reset = 0x0;
        } gtrten[14:14];
        field {
            name = "retrain_en";
            desc = "PHY retraining enable. This field controls whether the PHY is enabled to request memory controller for retraining.";
            sw = rw; hw = r;
            reset = 0x1;
        } retrain_en[13:13];
        field {
            name = "phyupd_resp";
            desc = "PHY update response latency. When the PHY asserts dfi_phyupd_req to MC, MC should assert dfi_phyupd_ack no later than the number of cycles configured by the response latency.";
            sw = rw; hw = r;
            reset = 0x400;
        } phyupd_resp[12:0];
    } RETCTRL0 @ 0x80;
    reg {
        name = "DMSEL";
        desc = "DMSEL is a DM swap selection register. (offset 0x84; total reset 0x0000000A; PROVEN: Hi3521A/Hi3520D V300 data sheet (Issue 00B07, 2015-12-10), section 4.1.9.2, PDF page 883).";
        field {
            name = "reserved";
            desc = "Reserved.";
            sw = r; hw = w;
            reset = 0x0;
        } reserved_31_4[31:4];
        field {
            name = "dxctl_dmswap_sel";
            desc = "bit[3:2]: DM1 swap select bit[1:0]: DM0 swap select";
            sw = rw; hw = r;
            reset = 0xa;
        } dxctl_dmswap_sel[3:0];
    } DMSEL @ 0x84;
    reg {
        name = "IOCTL";
        desc = "IOCTL is an I/O control register. (offset 0x88; total reset 0x4BFFF801; PROVEN: Hi3521A/Hi3520D V300 data sheet (Issue 00B07, 2015-12-10), section 4.1.9.2, PDF page 884).";
        field {
            name = "odtsel_dqs";
            desc = "Set this field to default value.";
            sw = rw; hw = r;
            reset = 0x2;
        } odtsel_dqs[31:29];
        field {
            name = "odtsel";
            desc = "Set this field to default value.";
            sw = rw; hw = r;
            reset = 0x2;
        } odtsel[28:26];
        field {
            name = "ronsel_ck";
            desc = "Set this field to default value.";
            sw = rw; hw = r;
            reset = 0x7;
        } ronsel_ck[25:23];
        field {
            name = "ronsel_ac2t";
            desc = "Set this field to default value.";
            sw = rw; hw = r;
            reset = 0x7;
        } ronsel_ac2t[22:20];
        field {
            name = "ronsel_ac1t";
            desc = "Set this field to default value.";
            sw = rw; hw = r;
            reset = 0x7;
        } ronsel_ac1t[19:17];
        field {
            name = "ronsel_dqs";
            desc = "Set this field to default value.";
            sw = rw; hw = r;
            reset = 0x7;
        } ronsel_dqs[16:14];
        field {
            name = "ronsel";
            desc = "Set this field to default value.";
            sw = rw; hw = r;
            reset = 0x7;
        } ronsel[13:11];
        field {
            name = "reserved";
            desc = "Set this field to default value.";
            sw = r; hw = w;
            reset = 0x0;
        } reserved_10_10[10:10];
        field {
            name = "reserved";
            desc = "Reserved.";
            sw = r; hw = w;
            reset = 0x0;
        } reserved_9_3[9:3];
        field {
            name = "aciopldn";
            desc = "Set this field to default value.";
            sw = rw; hw = r;
            reset = 0x0;
        } aciopldn[2:2];
        field {
            name = "dxiopldn";
            desc = "Set this field to default value.";
            sw = rw; hw = r;
            reset = 0x0;
        } dxiopldn[1:1];
        field {
            name = "diff_dqs_en";
            desc = "Differential DQS enable.";
            sw = rw; hw = r;
            reset = 0x1;
        } diff_dqs_en[0:0];
    } IOCTL @ 0x88;
    reg {
        name = "DQSSEL";
        desc = "DQSSEL is a PHY DQ swap register. (offset 0x8C; total reset 0xFF00FF00; PROVEN: Hi3521A/Hi3520D V300 data sheet (Issue 00B07, 2015-12-10), section 4.1.9.2, PDF page 885).";
        field {
            name = "dqswap_sel";
            desc = "DQ swap in PHY. Each bit determines the relative DQS with DQ.
- 0: relative to DQS0
- 1: relative to DQS1";
            sw = rw; hw = r;
            reset = 0xff00ff00;
        } dqswap_sel[31:0];
    } DQSSEL @ 0x8C;
    reg {
        name = "PHYCTRL1";
        desc = "PHYCTRL1 is an AC PHY control register. Register in this field are connected to PHY interface directly (offset 0x90; total reset 0x00000000; PROVEN: Hi3521A/Hi3520D V300 data sheet (Issue 00B07, 2015-12-10), section 4.1.9.2, PDF page 885).";
        field {
            name = "reserved";
            desc = "Reserved.";
            sw = r; hw = w;
            reset = 0x0;
        } reserved_31_31[31:31];
        field {
            name = "ac_pll_cal";
            desc = "The value 0x0 is recommended.";
            sw = rw; hw = r;
            reset = 0x0;
        } ac_pll_cal[30:30];
        field {
            name = "ac_pll_calm";
            desc = "The value 0x0 is recommended.";
            sw = rw; hw = r;
            reset = 0x0;
        } ac_pll_calm[29:29];
        field {
            name = "ac_pll_calt";
            desc = "The value 0x0 is recommended.";
            sw = rw; hw = r;
            reset = 0x0;
        } ac_pll_calt[28:28];
        field {
            name = "ac_pll_lt";
            desc = "The value 0x0 is recommended.";
            sw = rw; hw = r;
            reset = 0x0;
        } ac_pll_lt[27:26];
        field {
            name = "ac_pll_sp";
            desc = "The value 0x2 is recommended.";
            sw = rw; hw = r;
            reset = 0x0;
        } ac_pll_sp[25:23];
        field {
            name = "ac_pll_cpi";
            desc = "The value 0x4 is recommended.";
            sw = rw; hw = r;
            reset = 0x0;
        } ac_pll_cpi[22:20];
        field {
            name = "ac_pll_init";
            desc = "The value 0x0 is recommended.";
            sw = rw; hw = r;
            reset = 0x0;
        } ac_pll_init[19:19];
        field {
            name = "ac_pll_testen";
            desc = "The value 0x0 is recommended.";
            sw = rw; hw = r;
            reset = 0x0;
        } ac_pll_testen[18:18];
        field {
            name = "ac_pll_testpem";
            desc = "The value 0x0 is recommended.";
            sw = rw; hw = r;
            reset = 0x0;
        } ac_pll_testpem[17:17];
        field {
            name = "ac_pll_thrm";
            desc = "The value 0x0 is recommended.";
            sw = rw; hw = r;
            reset = 0x0;
        } ac_pll_thrm[16:16];
        field {
            name = "reserved";
            desc = "Reserved.";
            sw = r; hw = w;
            reset = 0x0;
        } reserved_15_0[15:0];
    } PHYCTRL1 @ 0x90;
    reg {
        name = "DXNCKCTRL";
        desc = "DXNCKCTRL is a PLL phase selection (within the PHY) register. You are advised not to modify this register. (offset 0x94; total reset 0x00000000; PROVEN: Hi3521A/Hi3520D V300 data sheet (Issue 00B07, 2015-12-10), section 4.1.9.2, PDF page 886).";
        field {
            name = "reserved";
            desc = "Reserved.";
            sw = r; hw = w;
            reset = 0x0;
        } reserved_31_6[31:6];
        field {
            name = "dx_ckd2";
            desc = "Set this field to default value.";
            sw = rw; hw = r;
            reset = 0x0;
        } dx_ckd2[5:3];
        field {
            name = "dx_ck0p_mclk";
            desc = "Set this field to default value.";
            sw = rw; hw = r;
            reset = 0x0;
        } dx_ck0p_mclk[2:0];
    } DXNCKCTRL @ 0x94;
    reg {
        name = "PHYPLLCTRL_AC";
        desc = "PHYPLLCTRL_AC is PHY PLL control register 1. Register in this field are connected to PHY interface directly (offset 0x98; total reset 0x00000000; PROVEN: Hi3521A/Hi3520D V300 data sheet (Issue 00B07, 2015-12-10), section 4.1.9.2, PDF page 887).";
        field {
            name = "ac_pll_lock";
            desc = "AC PLL lock signal.
- 0: not locked
- 1: locked";
            sw = r; hw = w;
            reset = 0x0;
        } ac_pll_lock[31:31];
        field {
            name = "reserved";
            desc = "Reserved.";
            sw = r; hw = w;
            reset = 0x0;
        } reserved_30_8[30:8];
        field {
            name = "ac_pll_test";
            desc = "AC PLL test mode.
- 0: normal mode
- 1: test mode";
            sw = rw; hw = r;
            reset = 0x0;
        } ac_pll_test[7:0];
    } PHYPLLCTRL_AC @ 0x98;
    reg {
        name = "PHYPLLCTRL_DX";
        desc = "PHYPLLCTRL_DX is PHY PLL control register 2. (offset 0x9C; total reset 0x00000000; PROVEN: Hi3521A/Hi3520D V300 data sheet (Issue 00B07, 2015-12-10), section 4.1.9.2, PDF page 887).";
        field {
            name = "dx_pll_lock";
            desc = "ND: number of data PHY blocks DX PLL lock signals for each byte lane
- 0: not locked
- 1: locked";
            sw = r; hw = w;
            reset = 0x0;
        } dx_pll_lock[31:28];
        field {
            name = "reserved";
            desc = "Reserved.";
            sw = r; hw = w;
            reset = 0x0;
        } reserved_27_16[27:16];
        field {
            name = "dx_pll_test";
            desc = "PLL test for 16-bit data block bit[7:0]: 16-bit block 0 bit[15:8]: 16-bit block 1";
            sw = rw; hw = r;
            reset = 0x0;
        } dx_pll_test[15:0];
    } PHYPLLCTRL_DX @ 0x9C;
    reg {
        name = "SWTMODE";
        desc = "SWTMODE is an S/W training mode register. (offset 0xA0; total reset 0x00000000; PROVEN: Hi3521A/Hi3520D V300 data sheet (Issue 00B07, 2015-12-10), section 4.1.9.2, PDF page 888).";
        field {
            name = "wl_wdqs_gated";
            desc = "Write leveling WDQS strobe disable when the related PH/BDL is tuned to prevent glitch.
- 0: not gated
- 1: gated (disable WDQS strobe)";
            sw = rw; hw = r;
            reset = 0x0;
        } wl_wdqs_gated[31:31];
        field {
            name = "reserved";
            desc = "Reserved.";
            sw = r; hw = w;
            reset = 0x0;
        } reserved_30_2[30:2];
        field {
            name = "sw_gtmode";
            desc = "Set this bit to 1 when performing S/W gate training or GDS training.";
            sw = rw; hw = r;
            reset = 0x0;
        } sw_gtmode[1:1];
        field {
            name = "sw_wlmode";
            desc = "Set this bit to 1 when performing S/W write leveling training.";
            sw = rw; hw = r;
            reset = 0x0;
        } sw_wlmode[0:0];
    } SWTMODE @ 0xA0;
    reg {
        name = "SWTWLDQS";
        desc = "SWTWLDQS is a write DQS issue register during S/W write leveling training. (offset 0xA4; total reset 0x00000000; PROVEN: Hi3521A/Hi3520D V300 data sheet (Issue 00B07, 2015-12-10), section 4.1.9.2, PDF page 888).";
        field {
            name = "reserved";
            desc = "Reserved.";
            sw = r; hw = w;
            reset = 0x0;
        } reserved_31_1[31:1];
        field {
            name = "sw_wl_dqs";
            desc = "Writing 1 to this bit once issues one DQS pulse from the PHY to DRAM.";
            sw = w; hw = r;
            reset = 0x0;
        } sw_wl_dqs[0:0];
    } SWTWLDQS @ 0xA4;
    reg {
        name = "SWTRLT";
        desc = "SWTRLT is an S/W training result register. (offset 0xA8; total reset 0x00000000; PROVEN: Hi3521A/Hi3520D V300 data sheet (Issue 00B07, 2015-12-10), section 4.1.9.2, PDF page 889).";
        field {
            name = "reserved";
            desc = "Reserved.";
            sw = r; hw = w;
            reset = 0x0;
        } reserved_31_24[31:24];
        field {
            name = "gds_result";
            desc = "Each bit corresponds to one byte lane.";
            sw = r; hw = w;
            reset = 0x0;
        } gds_result[23:16];
        field {
            name = "gt_result";
            desc = "Each bit corresponds to one byte lane.";
            sw = r; hw = w;
            reset = 0x0;
        } gt_result[15:8];
        field {
            name = "wl_dq_result";
            desc = "Each bit corresponds to one byte lane.";
            sw = r; hw = w;
            reset = 0x0;
        } wl_dq_result[7:0];
    } SWTRLT @ 0xA8;
    reg {
        name = "PHYCTRL2";
        desc = "PHYCTRL2 is PHY control register 2. Register in this field are connected to PHY interface directly (offset 0xAC; total reset 0x0000000B; PROVEN: Hi3521A/Hi3520D V300 data sheet (Issue 00B07, 2015-12-10), section 4.1.9.2, PDF page 889).";
        field {
            name = "reserved";
            desc = "Reserved.";
            sw = r; hw = w;
            reset = 0x0;
        } reserved_31_5[31:5];
        field {
            name = "phy_dyn_pupden";
            desc = "DATA16BIT_blk.reg_dynamic_PUPDEN_16b control.";
            sw = rw; hw = r;
            reset = 0x0;
        } phy_dyn_pupden[4:4];
        field {
            name = "phy_dummypad_use";
            desc = "DATA16BIT_blk.reg_dummypad_use control.";
            sw = rw; hw = r;
            reset = 0x1;
        } phy_dummypad_use[3:3];
        field {
            name = "phy_odten_gated";
            desc = "DATA16BIT_blk.reg_ODTEN_Gated control.";
            sw = rw; hw = r;
            reset = 0x0;
        } phy_odten_gated[2:2];
        field {
            name = "phy_gatetdc";
            desc = "DATA16BIT_blk.BUFRESETCONTN_gated_TDC control.";
            sw = rw; hw = r;
            reset = 0x1;
        } phy_gatetdc[1:1];
        field {
            name = "phy_dqsgerror";
            desc = "DATA16BIT_blk.BUFRESETCONTN_gated_DQSGERROR control.";
            sw = rw; hw = r;
            reset = 0x1;
        } phy_dqsgerror[0:0];
    } PHYCTRL2 @ 0xAC;
    reg {
        name = "IOCTL1";
        desc = "IOCTL1 is I/O PHY control register 1. Register in this field are connected to PHY interface directly (offset 0xB0; total reset 0x00000000; PROVEN: Hi3521A/Hi3520D V300 data sheet (Issue 00B07, 2015-12-10), section 4.1.9.2, PDF page 890).";
        field {
            name = "reserved";
            desc = "Reserved.";
            sw = r; hw = w;
            reset = 0x0;
        } reserved_31_28[31:28];
        field {
            name = "ioctl_squeach_pd";
            desc = "Set this field to default value.";
            sw = rw; hw = r;
            reset = 0x0;
        } ioctl_squeach_pd[27:24];
        field {
            name = "reserved";
            desc = "Reserved.";
            sw = r; hw = w;
            reset = 0x0;
        } reserved_23_18[23:18];
        field {
            name = "ioctl_genvref_pd";
            desc = "Set this field to default value.";
            sw = rw; hw = r;
            reset = 0x0;
        } ioctl_genvref_pd[17:12];
        field {
            name = "ioctl_genvref_ie";
            desc = "Set this field to default value.";
            sw = rw; hw = r;
            reset = 0x0;
        } ioctl_genvref_ie[11:6];
        field {
            name = "ioctl_popmode";
            desc = "Set this field to default value.";
            sw = rw; hw = r;
            reset = 0x0;
        } ioctl_popmode[5:0];
    } IOCTL1 @ 0xB0;
    reg {
        name = "IOCTL2";
        desc = "IOCTL2 is I/O PHY control register 2. Register in this field are connected to PHY interface directly (offset 0xB4; total reset 0x00000000; PROVEN: Hi3521A/Hi3520D V300 data sheet (Issue 00B07, 2015-12-10), section 4.1.9.2, PDF page 891).";
        field {
            name = "reserved";
            desc = "Reserved.";
            sw = r; hw = w;
            reset = 0x0;
        } reserved_31_30[31:30];
        field {
            name = "ioctl_genvref_refsel_2";
            desc = "Set this field to default value.";
            sw = rw; hw = r;
            reset = 0x0;
        } ioctl_genvref_refsel_2[29:24];
        field {
            name = "ioctl_genvref_refsel_1";
            desc = "Set this field to default value.";
            sw = rw; hw = r;
            reset = 0x0;
        } ioctl_genvref_refsel_1[23:18];
        field {
            name = "ioctl_genvref_refsel_0";
            desc = "Set this field to default value.";
            sw = rw; hw = r;
            reset = 0x0;
        } ioctl_genvref_refsel_0[17:12];
        field {
            name = "ioctl_genvref_rangel_1";
            desc = "Set this field to default value.";
            sw = rw; hw = r;
            reset = 0x0;
        } ioctl_genvref_rangel_1[11:6];
        field {
            name = "ioctl_genvref_rangel_0";
            desc = "Set this field to default value.";
            sw = rw; hw = r;
            reset = 0x0;
        } ioctl_genvref_rangel_0[5:0];
    } IOCTL2 @ 0xB4;
    reg {
        name = "BISTTIMER";
        desc = "BISTTIMER is a code update period register during BIST running. (offset 0xB8; total reset 0x00000000; PROVEN: Hi3521A/Hi3520D V300 data sheet (Issue 00B07, 2015-12-10), section 4.1.9.2, PDF page 891).";
        field {
            name = "reserved";
            desc = "Reserved.";
            sw = r; hw = w;
            reset = 0x0;
        } reserved_31_16[31:16];
        field {
            name = "bstupdt_timer";
            desc = "BIST update code timer. This field controls the code update period. If this field is programmed to a non-zero value, the BIST is temporarily stopped, and the internal delay code is updated to the PHY when the timer reaches the configured value. The BIST will continue if the code update is complete. If this field is programmed to zero, the update code mechanism is disabled.";
            sw = rw; hw = r;
            reset = 0x0;
        } bstupdt_timer[15:0];
    } BISTTIMER @ 0xB8;
    reg {
        name = "TRAINCTRL1";
        desc = "TRAINCTRL1 is data training control register 1. (offset 0xD0; total reset 0xF036F026; PROVEN: Hi3521A/Hi3520D V300 data sheet (Issue 00B07, 2015-12-10), section 4.1.9.2, PDF page 892).";
        field {
            name = "rdet_lbs_en";
            desc = "Read DET left boundary search enable.";
            sw = rw; hw = r;
            reset = 0x1;
        } rdet_lbs_en[31:31];
        field {
            name = "rdet_ds_en";
            desc = "Read DET deskew enable.";
            sw = rw; hw = r;
            reset = 0x1;
        } rdet_ds_en[30:30];
        field {
            name = "rdet_rbs_en";
            desc = "Read DET right boundary search enable.";
            sw = rw; hw = r;
            reset = 0x1;
        } rdet_rbs_en[29:29];
        field {
            name = "rdet_av_en";
            desc = "Read DET average stage enable";
            sw = rw; hw = r;
            reset = 0x1;
        } rdet_av_en[28:28];
        field {
            name = "reserved";
            desc = "Reserved.";
            sw = r; hw = w;
            reset = 0x0;
        } reserved_27_27[27:27];
        field {
            name = "rdet_rb_backtap";
            desc = "Read DET right boundary back tap. This field is used to offset (+) the rdqsbdl before the right boundary search is started to overcome meta-sable zone.";
            sw = rw; hw = r;
            reset = 0x3;
        } rdet_rb_backtap[26:20];
        field {
            name = "rdet_samp_num";
            desc = "Read DET sample number control. The multiple sample is used to overcome the meta situations. Valid value: 1-15";
            sw = rw; hw = r;
            reset = 0x6;
        } rdet_samp_num[19:16];
        field {
            name = "wdet_lbs_en";
            desc = "Write DET left boundary search enable.";
            sw = rw; hw = r;
            reset = 0x1;
        } wdet_lbs_en[15:15];
        field {
            name = "wdet_ds_en";
            desc = "Write DET deskew enable.";
            sw = rw; hw = r;
            reset = 0x1;
        } wdet_ds_en[14:14];
        field {
            name = "wdet_rbs_en";
            desc = "Write DET right boundary search enable.";
            sw = rw; hw = r;
            reset = 0x1;
        } wdet_rbs_en[13:13];
        field {
            name = "wrdet_av_en";
            desc = "Write DET average stage enable.";
            sw = rw; hw = r;
            reset = 0x1;
        } wrdet_av_en[12:12];
        field {
            name = "reserved";
            desc = "Reserved.";
            sw = r; hw = w;
            reset = 0x0;
        } reserved_11_8[11:8];
        field {
            name = "wdet_rb_backtap";
            desc = "Write DET right boundary back tap. This field is used to offset (-) the wdqphase before the right boundary search is started to overcome meta-sable zone.";
            sw = rw; hw = r;
            reset = 0x2;
        } wdet_rb_backtap[7:4];
        field {
            name = "wdet_samp_num";
            desc = "Write DET sample number control. The multiple sample is used to overcome the meta situations. Valid value: 1-15";
            sw = rw; hw = r;
            reset = 0x6;
        } wdet_samp_num[3:0];
    } TRAINCTRL1 @ 0xD0;
    reg {
        name = "TRAINCTRL2";
        desc = "TRAINCTRL2 is data training control register 2. (offset 0xD4; total reset 0x0000CC55; PROVEN: Hi3521A/Hi3520D V300 data sheet (Issue 00B07, 2015-12-10), section 4.1.9.2, PDF page 893).";
        field {
            name = "rdet_method_sel";
            desc = "Read DET method select.
- 0: write-then-read
- 1: MRR32/40 (only for LPDDR3)";
            sw = rw; hw = r;
            reset = 0x0;
        } rdet_method_sel[31:31];
        field {
            name = "mrr_pat_order";
            desc = "MRR pattern order. If MRR is used in the read DET, PACK will issue three MRR commands. The order is indicated by bit 2 -> bit 1 -> bit 0.
- 0: MRR32
- 1: MRR40";
            sw = rw; hw = r;
            reset = 0x0;
        } mrr_pat_order[30:28];
        field {
            name = "mrr_bl4";
            desc = "MRR burst 4 indicator. If MRR is used in the read DET, PACK needs to know whether MRR burst is 4 (LPDDR2) or 8 (LPDDR3).
- 0: MRR32/40 burst length = 8 (default)
- 1: MRR32/40 burst length = 4";
            sw = rw; hw = r;
            reset = 0x0;
        } mrr_bl4[27:27];
        field {
            name = "reserved";
            desc = "Reserved.";
            sw = r; hw = w;
            reset = 0x0;
        } reserved_26_25[26:25];
        field {
            name = "gds_automrg_en";
            desc = "GDS training/retraining auto tuning enable.
- 0: disable GDS auto margin tuning (will increase GDS when GDS training/retraining is complete)
- 1: enable GDS auto margin tuning (default)";
            sw = rw; hw = r;
            reset = 0x0;
        } gds_automrg_en[24:24];
        field {
            name = "mrr_pat_mask";
            desc = "MRR pattern mask.
- 0: not masked
- 1: masked (does not compare data)";
            sw = rw; hw = r;
            reset = 0x0;
        } mrr_pat_mask[23:16];
        field {
            name = "mrr_pat_B";
            desc = "MRR40 pattern. This field should comply with the LPDDR2/LPDDR3 specifications.";
            sw = rw; hw = r;
            reset = 0xcc;
        } mrr_pat_B[15:8];
        field {
            name = "mrr_pat_A";
            desc = "MRR32 pattern. This field should comply with the LPDDR2/LPDDR3 specifications.";
            sw = rw; hw = r;
            reset = 0x55;
        } mrr_pat_A[7:0];
    } TRAINCTRL2 @ 0xD4;
    reg {
        name = "REGBANKCTRL";
        desc = "REGBANKCTRL is register bank control register. (offset 0xD8; total reset 0x00000000; PROVEN: Hi3521A/Hi3520D V300 data sheet (Issue 00B07, 2015-12-10), section 4.1.9.2, PDF page 894).";
        field {
            name = "reserved";
            desc = "Reserved.";
            sw = r; hw = w;
            reset = 0x0;
        } reserved_31_2[31:2];
        field {
            name = "op_sel";
            desc = "Register bank select related to DFS.
- 0: bank 0 for PHY operating
- 1: bank 1 for PHY operating";
            sw = rw; hw = r;
            reset = 0x0;
        } op_sel[1:1];
        field {
            name = "wr_sel";
            desc = "Register bank select related to DFS.
- 0: bank 0 while APB read/write
- 1: bank 1 while APB read/write";
            sw = rw; hw = r;
            reset = 0x0;
        } wr_sel[0:0];
    } REGBANKCTRL @ 0xD8;
    reg {
        name = "TRAINCTRL3";
        desc = "TRAINCTRL3 is data training control register 3. (offset 0xDC; total reset 0x80020300; PROVEN: Hi3521A/Hi3520D V300 data sheet (Issue 00B07, 2015-12-10), section 4.1.9.2, PDF page 895).";
        field {
            name = "exd_gtres_en";
            desc = "Extended gate result enable. When this field is set as high, the PACK will use additional information (EN_DQSx_regread) to help extend the gate result in the \"fine tune stage of gate training\" and \"gate retraining.\"
- 0: disabled
- 1: enabled (default)";
            sw = rw; hw = r;
            reset = 0x1;
        } exd_gtres_en[31:31];
        field {
            name = "reserved";
            desc = "Reserved.";
            sw = r; hw = w;
            reset = 0x0;
        } reserved_30_19[30:19];
        field {
            name = "gdsrt_backtap";
            desc = "GDS retraining back tap. This field controls the number of back taps during GDS retraining. The value range is 1-7. The recommended value range is 1-2.";
            sw = rw; hw = r;
            reset = 0x2;
        } gdsrt_backtap[18:16];
        field {
            name = "reserved";
            desc = "Reserved.";
            sw = r; hw = w;
            reset = 0x0;
        } reserved_15_12[15:12];
        field {
            name = "rpat_cnt_num_open";
            desc = "RDET pattern length control for eye open. This field is used to set the pattern length for eye open. The same RDET pattern will be extended as the following settings (field value + 1):
- 0x0: pattern length = 1
- 0x1: pattern length = 2 ...
- 0xF: pattern length = 16";
            sw = rw; hw = r;
            reset = 0x3;
        } rpat_cnt_num_open[11:8];
        field {
            name = "reserved";
            desc = "Reserved.";
            sw = r; hw = w;
            reset = 0x0;
        } reserved_7_4[7:4];
        field {
            name = "rpat_cnt_num";
            desc = "RDET pattern length control. This field is used to set the pattern length. The same RDET pattern will be extended as the following settings (field value + 1):
- 0x0: pattern length = 1
- 0x1: pattern length = 2 ...
- 0xF: pattern length = 16";
            sw = rw; hw = r;
            reset = 0x0;
        } rpat_cnt_num[3:0];
    } TRAINCTRL3 @ 0xDC;
    reg {
        name = "ACBISTCTRL0";
        desc = "ACBISTCTRL0 is comparison control register 0 while BIST activated. (offset 0x100; total reset 0x40000000; PROVEN: Hi3521A/Hi3520D V300 data sheet (Issue 00B07, 2015-12-10), section 4.1.9.2, PDF page 896).";
        field {
            name = "ac_rdffsel";
            desc = "AC loopback read latch select.";
            sw = rw; hw = r;
            reset = 0x2;
        } ac_rdffsel[31:29];
        field {
            name = "aclpbk_tg";
            desc = "AC loopback toggle control. The user should not modify this bit. It is related to the analog PHY design.
- 0: 28LPP PHY (default)
- 1: 40PHY";
            sw = rw; hw = r;
            reset = 0x0;
        } aclpbk_tg[28:28];
        field {
            name = "acbist_en";
            desc = "BIST enable. This field specifies whether the AC block is included for loopback test while bist_op is set to BIST Enable.";
            sw = rw; hw = r;
            reset = 0x0;
        } acbist_en[27:27];
        field {
            name = "rst_cmp_mask";
            desc = "RST loopback compare mask. This field controls whether the comparison of the loopback data on the RST bit is disabled.
- 0: not compared
- 1: compared";
            sw = rw; hw = r;
            reset = 0x0;
        } rst_cmp_mask[26:26];
        field {
            name = "cs_cmp_mask";
            desc = "CS loopback compare mask. This field controls whether the comparison of the loopback data on the CS bits is disabled.
- 0: not compared
- 1: compared";
            sw = rw; hw = r;
            reset = 0x0;
        } cs_cmp_mask[25:22];
        field {
            name = "ras_cmp_mask";
            desc = "RAS loopback compare mask. This field controls whether the comparison of the loopback data on RAS is disabled.
- 0: not compared
- 1: compared";
            sw = rw; hw = r;
            reset = 0x0;
        } ras_cmp_mask[21:21];
        field {
            name = "cas_cmp_mask";
            desc = "CAS loopback compare mask. This field controls whether the comparison of the loopback data on CAS is disabled.
- 0: not compared
- 1: compared";
            sw = rw; hw = r;
            reset = 0x0;
        } cas_cmp_mask[20:20];
        field {
            name = "we_cmp_mask";
            desc = "Write enable loopback compare mask. This field controls whether the comparison of the loopback data on WE is disabled.
- 0: not compared
- 1: compared";
            sw = rw; hw = r;
            reset = 0x0;
        } we_cmp_mask[19:19];
        field {
            name = "ba_cmp_mask";
            desc = "Bank address loopback compare mask. This field controls whether the comparison of the loopback data on bank address bits is disabled.
- 0: not compared
- 1: compared";
            sw = rw; hw = r;
            reset = 0x0;
        } ba_cmp_mask[18:16];
        field {
            name = "addr_cmp_mask";
            desc = "Memory address loopback compare mask. This field controls whether the comparison of the loopback data on address bits is disabled.
- 0: not compared
- 1: compared";
            sw = rw; hw = r;
            reset = 0x0;
        } addr_cmp_mask[15:0];
    } ACBISTCTRL0 @ 0x100;
    reg {
        name = "ACBISTCTRL1";
        desc = "ACBISTCTRL1 is comparison control register 1 while BIST activated. (offset 0x104; total reset 0x00000000; PROVEN: Hi3521A/Hi3520D V300 data sheet (Issue 00B07, 2015-12-10), section 4.1.9.2, PDF page 897).";
        field {
            name = "reserved";
            desc = "Reserved.";
            sw = r; hw = w;
            reset = 0x0;
        } reserved_31_16[31:16];
        field {
            name = "ac_lfsr_seed";
            desc = "LFSR seed value. This field specifies the initial seed value of the LFSR generator to this byte lane.";
            sw = rw; hw = r;
            reset = 0x0;
        } ac_lfsr_seed[15:8];
        field {
            name = "cke_cmp_mask";
            desc = "CKE loopback compare mask. This field controls whether the comparison of the loopback data on CKE bits is disabled.
- 0: not compared
- 1: compared";
            sw = rw; hw = r;
            reset = 0x0;
        } cke_cmp_mask[7:4];
        field {
            name = "odt_cmp_mask";
            desc = "ODT loopback compare mask. This field controls whether the comparison of the loopback data on ODT bits is disabled.
- 0: not compared
- 1: compared";
            sw = rw; hw = r;
            reset = 0x0;
        } odt_cmp_mask[3:0];
    } ACBISTCTRL1 @ 0x104;
    reg {
        name = "ACBISTSTS0";
        desc = "ACBISTSTS0 is BIST test result and status register 0. This register is read-only, and can only be reset by setting bist_op to BIST Reset. (offset 0x108; total reset 0x00000000; PROVEN: Hi3521A/Hi3520D V300 data sheet (Issue 00B07, 2015-12-10), section 4.1.9.2, PDF page 898).";
        field {
            name = "reserved";
            desc = "Reserved.";
            sw = r; hw = w;
            reset = 0x0;
        } reserved_31_27[31:27];
        field {
            name = "rst_bist_err";
            desc = "BIST error on RST.";
            sw = r; hw = w;
            reset = 0x0;
        } rst_bist_err[26:26];
        field {
            name = "cs_bist_err";
            desc = "BIST error on CS.";
            sw = r; hw = w;
            reset = 0x0;
        } cs_bist_err[25:22];
        field {
            name = "ras_bist_err";
            desc = "BIST error on RAS.";
            sw = r; hw = w;
            reset = 0x0;
        } ras_bist_err[21:21];
        field {
            name = "cas_bist_err";
            desc = "BIST error on CAS.";
            sw = r; hw = w;
            reset = 0x0;
        } cas_bist_err[20:20];
        field {
            name = "we_bist_err";
            desc = "BIST error on write enable.";
            sw = r; hw = w;
            reset = 0x0;
        } we_bist_err[19:19];
        field {
            name = "ba_bist_err";
            desc = "BIST error on bank address.";
            sw = r; hw = w;
            reset = 0x0;
        } ba_bist_err[18:16];
        field {
            name = "addr_bist_err";
            desc = "BIST error on address bus.";
            sw = r; hw = w;
            reset = 0x0;
        } addr_bist_err[15:0];
    } ACBISTSTS0 @ 0x108;
    reg {
        name = "ACBISTSTS1";
        desc = "ACBISTSTS1 is BIST test result and status register 1. This register is read-only, and can only be reset by setting bist_op to BIST Reset. (offset 0x10C; total reset 0x00000000; PROVEN: Hi3521A/Hi3520D V300 data sheet (Issue 00B07, 2015-12-10), section 4.1.9.2, PDF page 899).";
        field {
            name = "reserved";
            desc = "Reserved.";
            sw = r; hw = w;
            reset = 0x0;
        } reserved_31_8[31:8];
        field {
            name = "cke_bist_err";
            desc = "BIST error on CKE.";
            sw = r; hw = w;
            reset = 0x0;
        } cke_bist_err[7:4];
        field {
            name = "odt_bist_err";
            desc = "BIST error on ODT.";
            sw = r; hw = w;
            reset = 0x0;
        } odt_bist_err[3:0];
    } ACBISTSTS1 @ 0x10C;
    reg {
        name = "ACCMDBDL0";
        desc = "ACCMDBDL0 is AC command bit delay line configuration register 0. (offset 0x120; total reset 0x00000000; PROVEN: Hi3521A/Hi3520D V300 data sheet (Issue 00B07, 2015-12-10), section 4.1.9.2, PDF page 899).";
        field {
            name = "reserved";
            desc = "Reserved.";
            sw = r; hw = w;
            reset = 0x0;
        } reserved_31_21[31:21];
        field {
            name = "odt1_bdl";
            desc = "Bit delay line of ODT1.";
            sw = rw; hw = r;
            reset = 0x0;
        } odt1_bdl[20:16];
        field {
            name = "reserved";
            desc = "Reserved.";
            sw = r; hw = w;
            reset = 0x0;
        } reserved_15_5[15:5];
        field {
            name = "odt0_bdl";
            desc = "Bit delay line of ODT0.";
            sw = rw; hw = r;
            reset = 0x0;
        } odt0_bdl[4:0];
    } ACCMDBDL0 @ 0x120;
    reg {
        name = "ACCMDBDL1";
        desc = "ACCMDBDL1 is AC command bit delay line configuration register 1. (offset 0x124; total reset 0x00000000; PROVEN: Hi3521A/Hi3520D V300 data sheet (Issue 00B07, 2015-12-10), section 4.1.9.2, PDF page 900).";
        field {
            name = "reserved";
            desc = "Reserved.";
            sw = r; hw = w;
            reset = 0x0;
        } reserved_31_21[31:21];
        field {
            name = "odt3_bdl";
            desc = "Bit delay line of ODT3.";
            sw = rw; hw = r;
            reset = 0x0;
        } odt3_bdl[20:16];
        field {
            name = "reserved";
            desc = "Reserved.";
            sw = r; hw = w;
            reset = 0x0;
        } reserved_15_5[15:5];
        field {
            name = "odt2_bdl";
            desc = "Bit delay line of ODT2.";
            sw = rw; hw = r;
            reset = 0x0;
        } odt2_bdl[4:0];
    } ACCMDBDL1 @ 0x124;
    reg {
        name = "ACCMDBDL2";
        desc = "ACCMDBDL2 is AC command bit delay line configuration register 2. (offset 0x128; total reset 0x00000000; PROVEN: Hi3521A/Hi3520D V300 data sheet (Issue 00B07, 2015-12-10), section 4.1.9.2, PDF page 900).";
        field {
            name = "reserved";
            desc = "Reserved.";
            sw = r; hw = w;
            reset = 0x0;
        } reserved_31_21[31:21];
        field {
            name = "cs1_bdl";
            desc = "Bit delay line of CS1.";
            sw = rw; hw = r;
            reset = 0x0;
        } cs1_bdl[20:16];
        field {
            name = "reserved";
            desc = "Reserved.";
            sw = r; hw = w;
            reset = 0x0;
        } reserved_15_5[15:5];
        field {
            name = "cs0_bdl";
            desc = "Bit delay line of CS0.";
            sw = rw; hw = r;
            reset = 0x0;
        } cs0_bdl[4:0];
    } ACCMDBDL2 @ 0x128;
    reg {
        name = "ACCMDBDL3";
        desc = "ACCMDBDL3 is AC command bit delay line configuration register 3. (offset 0x12C; total reset 0x00000000; PROVEN: Hi3521A/Hi3520D V300 data sheet (Issue 00B07, 2015-12-10), section 4.1.9.2, PDF page 901).";
        field {
            name = "reserved";
            desc = "Reserved.";
            sw = r; hw = w;
            reset = 0x0;
        } reserved_31_21[31:21];
        field {
            name = "cs3_bdl";
            desc = "Bit delay line of CS3.";
            sw = rw; hw = r;
            reset = 0x0;
        } cs3_bdl[20:16];
        field {
            name = "reserved";
            desc = "Reserved.";
            sw = r; hw = w;
            reset = 0x0;
        } reserved_15_5[15:5];
        field {
            name = "cs2_bdl";
            desc = "Bit delay line of CS2.";
            sw = rw; hw = r;
            reset = 0x0;
        } cs2_bdl[4:0];
    } ACCMDBDL3 @ 0x12C;
    reg {
        name = "ACCMDBDL4";
        desc = "ACCMDBDL4 is AC command bit delay line configuration register 4. (offset 0x130; total reset 0x00000000; PROVEN: Hi3521A/Hi3520D V300 data sheet (Issue 00B07, 2015-12-10), section 4.1.9.2, PDF page 901).";
        field {
            name = "reserved";
            desc = "Reserved.";
            sw = r; hw = w;
            reset = 0x0;
        } reserved_31_21[31:21];
        field {
            name = "cke1_bdl";
            desc = "Bit delay line of CKE1.";
            sw = rw; hw = r;
            reset = 0x0;
        } cke1_bdl[20:16];
        field {
            name = "reserved";
            desc = "Reserved.";
            sw = r; hw = w;
            reset = 0x0;
        } reserved_15_5[15:5];
        field {
            name = "cke0_bdl";
            desc = "Bit delay line of CKE0.";
            sw = rw; hw = r;
            reset = 0x0;
        } cke0_bdl[4:0];
    } ACCMDBDL4 @ 0x130;
    reg {
        name = "ACCMDBDL5";
        desc = "ACCMDBDL5 is AC command bit delay line configuration register 5. (offset 0x134; total reset 0x00000000; PROVEN: Hi3521A/Hi3520D V300 data sheet (Issue 00B07, 2015-12-10), section 4.1.9.2, PDF page 902).";
        field {
            name = "reserved";
            desc = "Reserved.";
            sw = r; hw = w;
            reset = 0x0;
        } reserved_31_21[31:21];
        field {
            name = "cke3_bdl";
            desc = "Bit delay line of CKE3.";
            sw = rw; hw = r;
            reset = 0x0;
        } cke3_bdl[20:16];
        field {
            name = "reserved";
            desc = "Reserved.";
            sw = r; hw = w;
            reset = 0x0;
        } reserved_15_5[15:5];
        field {
            name = "cke2_bdl";
            desc = "Bit delay line of CKE2.";
            sw = rw; hw = r;
            reset = 0x0;
        } cke2_bdl[4:0];
    } ACCMDBDL5 @ 0x134;
    reg {
        name = "ACCMDBDL6";
        desc = "ACCMDBDL6 is AC command bit delay line configuration register 6. (offset 0x138; total reset 0x00000000; PROVEN: Hi3521A/Hi3520D V300 data sheet (Issue 00B07, 2015-12-10), section 4.1.9.2, PDF page 902).";
        field {
            name = "reserved";
            desc = "Reserved.";
            sw = r; hw = w;
            reset = 0x0;
        } reserved_31_21[31:21];
        field {
            name = "cas_bdl";
            desc = "Bit delay line of CAS.";
            sw = rw; hw = r;
            reset = 0x0;
        } cas_bdl[20:16];
        field {
            name = "reserved";
            desc = "Reserved.";
            sw = r; hw = w;
            reset = 0x0;
        } reserved_15_5[15:5];
        field {
            name = "we_bdl";
            desc = "Bit delay line of WE.";
            sw = rw; hw = r;
            reset = 0x0;
        } we_bdl[4:0];
    } ACCMDBDL6 @ 0x138;
    reg {
        name = "ACCMDBDL7";
        desc = "ACCMDBDL7 is AC command bit delay line configuration register 7. (offset 0x13C; total reset 0x00000000; PROVEN: Hi3521A/Hi3520D V300 data sheet (Issue 00B07, 2015-12-10), section 4.1.9.2, PDF page 903).";
        field {
            name = "reserved";
            desc = "Reserved.";
            sw = r; hw = w;
            reset = 0x0;
        } reserved_31_21[31:21];
        field {
            name = "resetn_bdl";
            desc = "Bit delay line of RESETN.";
            sw = rw; hw = r;
            reset = 0x0;
        } resetn_bdl[20:16];
        field {
            name = "reserved";
            desc = "Reserved.";
            sw = r; hw = w;
            reset = 0x0;
        } reserved_15_5[15:5];
        field {
            name = "ras_bdl";
            desc = "Bit delay line of RAS.";
            sw = rw; hw = r;
            reset = 0x0;
        } ras_bdl[4:0];
    } ACCMDBDL7 @ 0x13C;
    reg {
        name = "ACADDRBDL0";
        desc = "ACADDRBDL0 is AC address bit delay line configuration register 0. (offset 0x140; total reset 0x00000000; PROVEN: Hi3521A/Hi3520D V300 data sheet (Issue 00B07, 2015-12-10), section 4.1.9.2, PDF page 903).";
        field {
            name = "reserved";
            desc = "Reserved.";
            sw = r; hw = w;
            reset = 0x0;
        } reserved_31_21[31:21];
        field {
            name = "addr1_bdl";
            desc = "Bit delay line of ADDR1.";
            sw = rw; hw = r;
            reset = 0x0;
        } addr1_bdl[20:16];
        field {
            name = "reserved";
            desc = "Reserved.";
            sw = r; hw = w;
            reset = 0x0;
        } reserved_15_5[15:5];
        field {
            name = "addr0_bdl";
            desc = "Bit delay line of ADDR0.";
            sw = rw; hw = r;
            reset = 0x0;
        } addr0_bdl[4:0];
    } ACADDRBDL0 @ 0x140;
    reg {
        name = "ACADDRBDL1";
        desc = "ACADDRBDL1 is AC address bit delay line configuration register 1. (offset 0x144; total reset 0x00000000; PROVEN: Hi3521A/Hi3520D V300 data sheet (Issue 00B07, 2015-12-10), section 4.1.9.2, PDF page 904).";
        field {
            name = "reserved";
            desc = "Reserved.";
            sw = r; hw = w;
            reset = 0x0;
        } reserved_31_21[31:21];
        field {
            name = "addr3_bdl";
            desc = "Bit delay line of ADDR3.";
            sw = rw; hw = r;
            reset = 0x0;
        } addr3_bdl[20:16];
        field {
            name = "reserved";
            desc = "Reserved.";
            sw = r; hw = w;
            reset = 0x0;
        } reserved_15_5[15:5];
        field {
            name = "addr2_bdl";
            desc = "Bit delay line of ADDR2.";
            sw = rw; hw = r;
            reset = 0x0;
        } addr2_bdl[4:0];
    } ACADDRBDL1 @ 0x144;
    reg {
        name = "ACADDRBDL2";
        desc = "ACADDRBDL2 is AC address bit delay line configuration register 2. (offset 0x148; total reset 0x00000000; PROVEN: Hi3521A/Hi3520D V300 data sheet (Issue 00B07, 2015-12-10), section 4.1.9.2, PDF page 904).";
        field {
            name = "reserved";
            desc = "Reserved.";
            sw = r; hw = w;
            reset = 0x0;
        } reserved_31_21[31:21];
        field {
            name = "addr5_bdl";
            desc = "Bit delay line of ADDR5.";
            sw = rw; hw = r;
            reset = 0x0;
        } addr5_bdl[20:16];
        field {
            name = "reserved";
            desc = "Reserved.";
            sw = r; hw = w;
            reset = 0x0;
        } reserved_15_5[15:5];
        field {
            name = "addr4_bdl";
            desc = "Bit delay line of ADDR4.";
            sw = rw; hw = r;
            reset = 0x0;
        } addr4_bdl[4:0];
    } ACADDRBDL2 @ 0x148;
    reg {
        name = "ACADDRBDL3";
        desc = "ACADDRBDL3 is AC address bit delay line configuration register 3. (offset 0x14C; total reset 0x00000000; PROVEN: Hi3521A/Hi3520D V300 data sheet (Issue 00B07, 2015-12-10), section 4.1.9.2, PDF page 905).";
        field {
            name = "reserved";
            desc = "Reserved.";
            sw = r; hw = w;
            reset = 0x0;
        } reserved_31_21[31:21];
        field {
            name = "addr7_bdl";
            desc = "Bit delay line of ADDR7.";
            sw = rw; hw = r;
            reset = 0x0;
        } addr7_bdl[20:16];
        field {
            name = "reserved";
            desc = "Reserved.";
            sw = r; hw = w;
            reset = 0x0;
        } reserved_15_5[15:5];
        field {
            name = "addr6_bdl";
            desc = "Bit delay line of ADDR6.";
            sw = rw; hw = r;
            reset = 0x0;
        } addr6_bdl[4:0];
    } ACADDRBDL3 @ 0x14C;
    reg {
        name = "ACADDRBDL4";
        desc = "ACADDRBDL4 is AC address bit delay line configuration register 4. (offset 0x150; total reset 0x00000000; PROVEN: Hi3521A/Hi3520D V300 data sheet (Issue 00B07, 2015-12-10), section 4.1.9.2, PDF page 905).";
        field {
            name = "reserved";
            desc = "Reserved.";
            sw = r; hw = w;
            reset = 0x0;
        } reserved_31_21[31:21];
        field {
            name = "addr9_bdl";
            desc = "Bit delay line of ADDR9.";
            sw = rw; hw = r;
            reset = 0x0;
        } addr9_bdl[20:16];
        field {
            name = "reserved";
            desc = "Reserved.";
            sw = r; hw = w;
            reset = 0x0;
        } reserved_15_5[15:5];
        field {
            name = "addr8_bdl";
            desc = "Bit delay line of ADDR8.";
            sw = rw; hw = r;
            reset = 0x0;
        } addr8_bdl[4:0];
    } ACADDRBDL4 @ 0x150;
    reg {
        name = "ACADDRBDL5";
        desc = "ACADDRBDL5 is AC address bit delay line configuration register 5. (offset 0x154; total reset 0x00000000; PROVEN: Hi3521A/Hi3520D V300 data sheet (Issue 00B07, 2015-12-10), section 4.1.9.2, PDF page 906).";
        field {
            name = "reserved";
            desc = "Reserved.";
            sw = r; hw = w;
            reset = 0x0;
        } reserved_31_21[31:21];
        field {
            name = "addr11_bdl";
            desc = "Bit delay line of ADDR11.";
            sw = rw; hw = r;
            reset = 0x0;
        } addr11_bdl[20:16];
        field {
            name = "reserved";
            desc = "Reserved.";
            sw = r; hw = w;
            reset = 0x0;
        } reserved_15_5[15:5];
        field {
            name = "addr10_bdl";
            desc = "Bit delay line of ADDR10.";
            sw = rw; hw = r;
            reset = 0x0;
        } addr10_bdl[4:0];
    } ACADDRBDL5 @ 0x154;
    reg {
        name = "ACADDRBDL6";
        desc = "ACADDRBDL6 is AC address bit delay line configuration register 6. (offset 0x158; total reset 0x00000000; PROVEN: Hi3521A/Hi3520D V300 data sheet (Issue 00B07, 2015-12-10), section 4.1.9.2, PDF page 906).";
        field {
            name = "reserved";
            desc = "Reserved.";
            sw = r; hw = w;
            reset = 0x0;
        } reserved_31_21[31:21];
        field {
            name = "addr13_bdl";
            desc = "Bit delay line of ADDR13.";
            sw = rw; hw = r;
            reset = 0x0;
        } addr13_bdl[20:16];
        field {
            name = "reserved";
            desc = "Reserved.";
            sw = r; hw = w;
            reset = 0x0;
        } reserved_15_5[15:5];
        field {
            name = "addr12_bdl";
            desc = "Bit delay line of ADDR12.";
            sw = rw; hw = r;
            reset = 0x0;
        } addr12_bdl[4:0];
    } ACADDRBDL6 @ 0x158;
    reg {
        name = "ACADDRBDL7";
        desc = "ACADDRBDL7 is AC address bit delay line configuration register 7. (offset 0x15C; total reset 0x00000000; PROVEN: Hi3521A/Hi3520D V300 data sheet (Issue 00B07, 2015-12-10), section 4.1.9.2, PDF page 907).";
        field {
            name = "reserved";
            desc = "Reserved.";
            sw = r; hw = w;
            reset = 0x0;
        } reserved_31_21[31:21];
        field {
            name = "addr15_bdl";
            desc = "Bit delay line of ADDR15.";
            sw = rw; hw = r;
            reset = 0x0;
        } addr15_bdl[20:16];
        field {
            name = "reserved";
            desc = "Reserved.";
            sw = r; hw = w;
            reset = 0x0;
        } reserved_15_5[15:5];
        field {
            name = "addr14_bdl";
            desc = "Bit delay line of ADDR14.";
            sw = rw; hw = r;
            reset = 0x0;
        } addr14_bdl[4:0];
    } ACADDRBDL7 @ 0x15C;
    reg {
        name = "ACADDRBDL8";
        desc = "ACADDRBDL8 is AC address bit delay line configuration register 8. (offset 0x160; total reset 0x00000000; PROVEN: Hi3521A/Hi3520D V300 data sheet (Issue 00B07, 2015-12-10), section 4.1.9.2, PDF page 907).";
        field {
            name = "reserved";
            desc = "Reserved.";
            sw = r; hw = w;
            reset = 0x0;
        } reserved_31_21[31:21];
        field {
            name = "ba1_bdl";
            desc = "Bit delay line of BA1.";
            sw = rw; hw = r;
            reset = 0x0;
        } ba1_bdl[20:16];
        field {
            name = "reserved";
            desc = "Reserved.";
            sw = r; hw = w;
            reset = 0x0;
        } reserved_15_5[15:5];
        field {
            name = "ba0_bdl";
            desc = "Bit delay line of BA0.";
            sw = rw; hw = r;
            reset = 0x0;
        } ba0_bdl[4:0];
    } ACADDRBDL8 @ 0x160;
    reg {
        name = "ACADDRBDL9";
        desc = "ACADDRBDL9 is AC address bit delay line configuration register 9. (offset 0x164; total reset 0x00000000; PROVEN: Hi3521A/Hi3520D V300 data sheet (Issue 00B07, 2015-12-10), section 4.1.9.2, PDF page 908).";
        field {
            name = "reserved";
            desc = "Reserved.";
            sw = r; hw = w;
            reset = 0x0;
        } reserved_31_5[31:5];
        field {
            name = "ba2_bdl";
            desc = "Bit delay line of BA2.";
            sw = rw; hw = r;
            reset = 0x0;
        } ba2_bdl[4:0];
    } ACADDRBDL9 @ 0x164;
    reg {
        name = "ACCLKBDL";
        desc = "ACCLKBDL is an AC clock bit delay line configuration register. (offset 0x168; total reset 0x00000000; PROVEN: Hi3521A/Hi3520D V300 data sheet (Issue 00B07, 2015-12-10), section 4.1.9.2, PDF page 908).";
        field {
            name = "reserved";
            desc = "Reserved.";
            sw = r; hw = w;
            reset = 0x0;
        } reserved_31_29[31:29];
        field {
            name = "fbclk_bdl";
            desc = "Bit delay line of FBCLK.";
            sw = rw; hw = r;
            reset = 0x0;
        } fbclk_bdl[28:24];
        field {
            name = "reserved";
            desc = "Reserved.";
            sw = r; hw = w;
            reset = 0x0;
        } reserved_23_21[23:21];
        field {
            name = "refclk_bdl";
            desc = "Bit delay line of REFCLK.";
            sw = rw; hw = r;
            reset = 0x0;
        } refclk_bdl[20:16];
        field {
            name = "reserved";
            desc = "Reserved.";
            sw = r; hw = w;
            reset = 0x0;
        } reserved_15_13[15:13];
        field {
            name = "dramclk1_bdl";
            desc = "Set this field to default value.";
            sw = rw; hw = r;
            reset = 0x0;
        } dramclk1_bdl[12:8];
        field {
            name = "reserved";
            desc = "Reserved.";
            sw = r; hw = w;
            reset = 0x0;
        } reserved_7_5[7:5];
        field {
            name = "dramclk0_bdl";
            desc = "Set this field to default value.";
            sw = rw; hw = r;
            reset = 0x0;
        } dramclk0_bdl[4:0];
    } ACCLKBDL @ 0x168;
    reg {
        name = "ACPHYCTL0";
        desc = "ACPHYCTL0 is AC block PHY control register 0. This register is used to control the PHY and should not be modified. (offset 0x170; total reset 0x00000010; PROVEN: Hi3521A/Hi3520D V300 data sheet (Issue 00B07, 2015-12-10), section 4.1.9.2, PDF page 909).";
        field {
            name = "reserved";
            desc = "Reserved.";
            sw = r; hw = w;
            reset = 0x0;
        } reserved_31_7[31:7];
        field {
            name = "bufphyclk_div2";
            desc = "PHY control.";
            sw = rw; hw = r;
            reset = 0x0;
        } bufphyclk_div2[6:6];
        field {
            name = "lvdqclkdiv2";
            desc = "PHY control.";
            sw = rw; hw = r;
            reset = 0x0;
        } lvdqclkdiv2[5:5];
        field {
            name = "dramclk_l";
            desc = "PHY control.";
            sw = rw; hw = r;
            reset = 0x1;
        } dramclk_l[4:4];
        field {
            name = "dramclk_h";
            desc = "PHY control.";
            sw = rw; hw = r;
            reset = 0x0;
        } dramclk_h[3:3];
        field {
            name = "margin_a1";
            desc = "PHY control.";
            sw = rw; hw = r;
            reset = 0x0;
        } margin_a1[2:2];
        field {
            name = "margin_a0";
            desc = "PHY control.";
            sw = rw; hw = r;
            reset = 0x0;
        } margin_a0[1:1];
        field {
            name = "enshift_a0";
            desc = "PHY control.";
            sw = rw; hw = r;
            reset = 0x0;
        } enshift_a0[0:0];
    } ACPHYCTL0 @ 0x170;
    reg {
        name = "ACPHYCTL1";
        desc = "ACPHYCTL1 is AC block PHY control register 1. This register is used to control the PHY and should not be modified. (offset 0x174; total reset 0x00000000; PROVEN: Hi3521A/Hi3520D V300 data sheet (Issue 00B07, 2015-12-10), section 4.1.9.2, PDF page 910).";
        field {
            name = "dram1sel_addr";
            desc = "PHY control.";
            sw = rw; hw = r;
            reset = 0x0;
        } dram1sel_addr[31:16];
        field {
            name = "Reserved.";
            desc = "Reserved.";
            sw = r; hw = w;
            reset = 0x0;
        } reserved_15_11[15:11];
        field {
            name = "dram1sel_ba";
            desc = "PHY control.";
            sw = rw; hw = r;
            reset = 0x0;
        } dram1sel_ba[10:8];
        field {
            name = "Reserved.";
            desc = "Reserved.";
            sw = r; hw = w;
            reset = 0x0;
        } reserved_7_7[7:7];
        field {
            name = "dram1sel_we";
            desc = "PHY control.";
            sw = rw; hw = r;
            reset = 0x0;
        } dram1sel_we[6:6];
        field {
            name = "dram1sel_cas";
            desc = "PHY control.";
            sw = rw; hw = r;
            reset = 0x0;
        } dram1sel_cas[5:5];
        field {
            name = "dram1sel_ras";
            desc = "PHY control.";
            sw = rw; hw = r;
            reset = 0x0;
        } dram1sel_ras[4:4];
        field {
            name = "dram1sel_odt";
            desc = "PHY control.";
            sw = rw; hw = r;
            reset = 0x0;
        } dram1sel_odt[3:3];
        field {
            name = "dram1sel_cke";
            desc = "PHY control.";
            sw = rw; hw = r;
            reset = 0x0;
        } dram1sel_cke[2:2];
        field {
            name = "dram1sel_cs";
            desc = "PHY control.";
            sw = rw; hw = r;
            reset = 0x0;
        } dram1sel_cs[1:1];
        field {
            name = "dram1sel_reset";
            desc = "PHY control.";
            sw = rw; hw = r;
            reset = 0x0;
        } dram1sel_reset[0:0];
    } ACPHYCTL1 @ 0x174;
    reg {
        name = "ACPHYCTL2";
        desc = "ACPHYCTL2 is AC block PHY control register 2. This register is used to control the PHY and should not be modified. (offset 0x178; total reset 0x00000000; PROVEN: Hi3521A/Hi3520D V300 data sheet (Issue 00B07, 2015-12-10), section 4.1.9.2, PDF page 911).";
        field {
            name = "sdrsel_addr";
            desc = "PHY control.";
            sw = rw; hw = r;
            reset = 0x0;
        } sdrsel_addr[31:16];
        field {
            name = "Reserved.";
            desc = "Reserved.";
            sw = r; hw = w;
            reset = 0x0;
        } reserved_15_11[15:11];
        field {
            name = "sdrsel_ba";
            desc = "PHY control.";
            sw = rw; hw = r;
            reset = 0x0;
        } sdrsel_ba[10:8];
        field {
            name = "Reserved.";
            desc = "Reserved.";
            sw = r; hw = w;
            reset = 0x0;
        } reserved_7_7[7:7];
        field {
            name = "sdrsel_we";
            desc = "PHY control.";
            sw = rw; hw = r;
            reset = 0x0;
        } sdrsel_we[6:6];
        field {
            name = "sdrsel_cas";
            desc = "PHY control.";
            sw = rw; hw = r;
            reset = 0x0;
        } sdrsel_cas[5:5];
        field {
            name = "sdrsel_ras";
            desc = "PHY control.";
            sw = rw; hw = r;
            reset = 0x0;
        } sdrsel_ras[4:4];
        field {
            name = "sdrsel_odt";
            desc = "PHY control.";
            sw = rw; hw = r;
            reset = 0x0;
        } sdrsel_odt[3:3];
        field {
            name = "sdrsel_cke";
            desc = "PHY control.";
            sw = rw; hw = r;
            reset = 0x0;
        } sdrsel_cke[2:2];
        field {
            name = "sdrsel_cs";
            desc = "PHY control.";
            sw = rw; hw = r;
            reset = 0x0;
        } sdrsel_cs[1:1];
        field {
            name = "sdrsel_reset";
            desc = "PHY control.";
            sw = rw; hw = r;
            reset = 0x0;
        } sdrsel_reset[0:0];
    } ACPHYCTL2 @ 0x178;
    reg {
        name = "ACPHYCTL3";
        desc = "ACPHYCTL3 is AC block PHY control register 3. This register is used to control the PHY and should not be modified. (offset 0x17C; total reset 0x00000000; PROVEN: Hi3521A/Hi3520D V300 data sheet (Issue 00B07, 2015-12-10), section 4.1.9.2, PDF page 912).";
        field {
            name = "posedge_addr";
            desc = "PHY control.";
            sw = rw; hw = r;
            reset = 0x0;
        } posedge_addr[31:16];
        field {
            name = "Reserved.";
            desc = "Reserved.";
            sw = r; hw = w;
            reset = 0x0;
        } reserved_15_11[15:11];
        field {
            name = "posedge_ba";
            desc = "PHY control.";
            sw = rw; hw = r;
            reset = 0x0;
        } posedge_ba[10:8];
        field {
            name = "Reserved.";
            desc = "Reserved.";
            sw = r; hw = w;
            reset = 0x0;
        } reserved_7_7[7:7];
        field {
            name = "posedge_we";
            desc = "PHY control.";
            sw = rw; hw = r;
            reset = 0x0;
        } posedge_we[6:6];
        field {
            name = "posedge_cas";
            desc = "PHY control.";
            sw = rw; hw = r;
            reset = 0x0;
        } posedge_cas[5:5];
        field {
            name = "posedge_ras";
            desc = "PHY control.";
            sw = rw; hw = r;
            reset = 0x0;
        } posedge_ras[4:4];
        field {
            name = "posedge_odt";
            desc = "PHY control.";
            sw = rw; hw = r;
            reset = 0x0;
        } posedge_odt[3:3];
        field {
            name = "posedge_cke";
            desc = "PHY control.";
            sw = rw; hw = r;
            reset = 0x0;
        } posedge_cke[2:2];
        field {
            name = "posedge_cs";
            desc = "PHY control.";
            sw = rw; hw = r;
            reset = 0x0;
        } posedge_cs[1:1];
        field {
            name = "posedge_reset";
            desc = "PHY control.";
            sw = rw; hw = r;
            reset = 0x0;
        } posedge_reset[0:0];
    } ACPHYCTL3 @ 0x17C;
    reg {
        name = "ACPHYCTL4";
        desc = "ACPHYCTL4 is AC block PHY control register 4. This register is used to control the PHY and should not be modified. (offset 0x180; total reset 0x00000000; PROVEN: Hi3521A/Hi3520D V300 data sheet (Issue 00B07, 2015-12-10), section 4.1.9.2, PDF page 913).";
        field {
            name = "timing2T_addr";
            desc = "PHY control.";
            sw = rw; hw = r;
            reset = 0x0;
        } timing2T_addr[31:16];
        field {
            name = "Reserved.";
            desc = "Reserved.";
            sw = r; hw = w;
            reset = 0x0;
        } reserved_15_11[15:11];
        field {
            name = "timing2T_ba";
            desc = "PHY control.";
            sw = rw; hw = r;
            reset = 0x0;
        } timing2T_ba[10:8];
        field {
            name = "Reserved.";
            desc = "Reserved.";
            sw = r; hw = w;
            reset = 0x0;
        } reserved_7_7[7:7];
        field {
            name = "timing2T_we";
            desc = "PHY control.";
            sw = rw; hw = r;
            reset = 0x0;
        } timing2T_we[6:6];
        field {
            name = "timing2T_cas";
            desc = "PHY control.";
            sw = rw; hw = r;
            reset = 0x0;
        } timing2T_cas[5:5];
        field {
            name = "timing2T_ras";
            desc = "PHY control.";
            sw = rw; hw = r;
            reset = 0x0;
        } timing2T_ras[4:4];
        field {
            name = "timing2T_odt";
            desc = "PHY control.";
            sw = rw; hw = r;
            reset = 0x0;
        } timing2T_odt[3:3];
        field {
            name = "timing2T_cke";
            desc = "PHY control.";
            sw = rw; hw = r;
            reset = 0x0;
        } timing2T_cke[2:2];
        field {
            name = "timing2T_cs";
            desc = "PHY control.";
            sw = rw; hw = r;
            reset = 0x0;
        } timing2T_cs[1:1];
        field {
            name = "timing2T_reset";
            desc = "PHY control.";
            sw = rw; hw = r;
            reset = 0x0;
        } timing2T_reset[0:0];
    } ACPHYCTL4 @ 0x180;
    reg {
        name = "ACPHYCTL5";
        desc = "ACPHYCTL5 is AC block PHY control register 5. This register is used to control the PHY and should not be modified. (offset 0x184; total reset 0x00000000; PROVEN: Hi3521A/Hi3520D V300 data sheet (Issue 00B07, 2015-12-10), section 4.1.9.2, PDF page 913).";
        field {
            name = "Reserved.";
            desc = "Reserved.";
            sw = r; hw = w;
            reset = 0x0;
        } reserved_31_28[31:28];
        field {
            name = "clk1x_cmd2t_ctl2";
            desc = "PHY control.";
            sw = rw; hw = r;
            reset = 0x0;
        } clk1x_cmd2t_ctl2[27:24];
        field {
            name = "clk1x_mclk";
            desc = "PHY control.";
            sw = rw; hw = r;
            reset = 0x0;
        } clk1x_mclk[23:20];
        field {
            name = "clk1x_cmd1t";
            desc = "PHY control.";
            sw = rw; hw = r;
            reset = 0x0;
        } clk1x_cmd1t[19:16];
        field {
            name = "clk1x_cmd2t";
            desc = "PHY control.";
            sw = rw; hw = r;
            reset = 0x0;
        } clk1x_cmd2t[15:12];
        field {
            name = "clk1x_cmd2t_ctl";
            desc = "PHY control.";
            sw = rw; hw = r;
            reset = 0x0;
        } clk1x_cmd2t_ctl[11:8];
        field {
            name = "clk1x_dramclk1";
            desc = "PHY control.";
            sw = rw; hw = r;
            reset = 0x0;
        } clk1x_dramclk1[7:4];
        field {
            name = "clk1x_dramclk0";
            desc = "PHY control.";
            sw = rw; hw = r;
            reset = 0x0;
        } clk1x_dramclk0[3:0];
    } ACPHYCTL5 @ 0x184;
    reg {
        name = "ACPHYCTL6";
        desc = "ACPHYCTL6 is AC block PHY control register 6. This register is used to control the PHY and should not be modified. (offset 0x188; total reset 0x00000000; PROVEN: Hi3521A/Hi3520D V300 data sheet (Issue 00B07, 2015-12-10), section 4.1.9.2, PDF page 914).";
        field {
            name = "Reserved.";
            desc = "Reserved.";
            sw = r; hw = w;
            reset = 0x0;
        } reserved_31_28[31:28];
        field {
            name = "clk2x_cmd2t_ctl2";
            desc = "PHY control.";
            sw = rw; hw = r;
            reset = 0x0;
        } clk2x_cmd2t_ctl2[27:24];
        field {
            name = "clk2x_mclk";
            desc = "PHY control.";
            sw = rw; hw = r;
            reset = 0x0;
        } clk2x_mclk[23:20];
        field {
            name = "clk2x_cmd1t";
            desc = "PHY control.";
            sw = rw; hw = r;
            reset = 0x0;
        } clk2x_cmd1t[19:16];
        field {
            name = "clk2x_cmd2t";
            desc = "PHY control.";
            sw = rw; hw = r;
            reset = 0x0;
        } clk2x_cmd2t[15:12];
        field {
            name = "clk2x_cmd2t_ctl";
            desc = "PHY control.";
            sw = rw; hw = r;
            reset = 0x0;
        } clk2x_cmd2t_ctl[11:8];
        field {
            name = "clk2x_dramclk1";
            desc = "PHY control.";
            sw = rw; hw = r;
            reset = 0x0;
        } clk2x_dramclk1[7:4];
        field {
            name = "clk2x_dramclk0";
            desc = "PHY control.";
            sw = rw; hw = r;
            reset = 0x0;
        } clk2x_dramclk0[3:0];
    } ACPHYCTL6 @ 0x188;
    reg {
        name = "ACPHYCTL7";
        desc = "ACPHYCTL7 is AC block PHY control register 7. This register is used to control the PHY and should not be modified. (offset 0x18C; total reset 0x00800000; PROVEN: Hi3521A/Hi3520D V300 data sheet (Issue 00B07, 2015-12-10), section 4.1.9.2, PDF page 915).";
        field {
            name = "Reserved.";
            desc = "Reserved.";
            sw = r; hw = w;
            reset = 0x0;
        } reserved_31_27[31:27];
        field {
            name = "halft_cmd2tctl2";
            desc = "Set this field to default value.";
            sw = rw; hw = r;
            reset = 0x0;
        } halft_cmd2tctl2[26:26];
        field {
            name = "halft_dramclk0";
            desc = "Set this field to default value.";
            sw = rw; hw = r;
            reset = 0x0;
        } halft_dramclk0[25:25];
        field {
            name = "halft_dramclk1";
            desc = "Set this field to default value.";
            sw = rw; hw = r;
            reset = 0x0;
        } halft_dramclk1[24:24];
        field {
            name = "halft_cmd1t";
            desc = "Set this field to default value.";
            sw = rw; hw = r;
            reset = 0x1;
        } halft_cmd1t[23:23];
        field {
            name = "Reserved.";
            desc = "Reserved.";
            sw = r; hw = w;
            reset = 0x0;
        } reserved_22_22[22:22];
        field {
            name = "halft_cmd2tctl";
            desc = "Set this field to default value.";
            sw = rw; hw = r;
            reset = 0x0;
        } halft_cmd2tctl[21:21];
        field {
            name = "ck5p_cmd2tc";
            desc = "Set this field to default value.";
            sw = rw; hw = r;
            reset = 0x0;
        } ck5p_cmd2tc[20:18];
        field {
            name = "Reserved.";
            desc = "Reserved.";
            sw = r; hw = w;
            reset = 0x0;
        } reserved_17_15[17:15];
        field {
            name = "ck3p_cmd1t";
            desc = "Set this field to default value.";
            sw = rw; hw = r;
            reset = 0x0;
        } ck3p_cmd1t[14:12];
        field {
            name = "ck2p_dclk1";
            desc = "Configure DRAM CK1 clock phase from PLL1 tap: 1/16 T";
            sw = rw; hw = r;
            reset = 0x0;
        } ck2p_dclk1[11:9];
        field {
            name = "ck1p_dclk0";
            desc = "Configure DRAM CK0 clock phase from PLL1 tap: 1/16 T";
            sw = rw; hw = r;
            reset = 0x0;
        } ck1p_dclk0[8:6];
        field {
            name = "ck0p_mclk";
            desc = "Set this field to default value.";
            sw = rw; hw = r;
            reset = 0x0;
        } ck0p_mclk[5:3];
        field {
            name = "ckd2_mclk";
            desc = "Set this field to default value.";
            sw = rw; hw = r;
            reset = 0x0;
        } ckd2_mclk[2:0];
    } ACPHYCTL7 @ 0x18C;
    reg {
        name = "ACDEBUG";
        desc = "ACDEBUG is a PHY debugging register. (offset 0x190; total reset 0x00000000; PROVEN: Hi3521A/Hi3520D V300 data sheet (Issue 00B07, 2015-12-10), section 4.1.9.2, PDF page 916).";
        field {
            name = "Reserved.";
            desc = "Reserved.";
            sw = r; hw = w;
            reset = 0x0;
        } reserved_31_20[31:20];
        field {
            name = "acdbg_config";
            desc = "Set this field to default value.";
            sw = rw; hw = r;
            reset = 0x0;
        } acdbg_config[19:16];
        field {
            name = "Reserved.";
            desc = "Reserved.";
            sw = r; hw = w;
            reset = 0x0;
        } reserved_15_9[15:9];
        field {
            name = "DESKEW_regread";
            desc = "Set this field to default value.";
            sw = r; hw = w;
            reset = 0x0;
        } DESKEW_regread[8:8];
        field {
            name = "Reserved.";
            desc = "Reserved.";
            sw = r; hw = w;
            reset = 0x0;
        } reserved_7_3[7:3];
        field {
            name = "ac_rdcnt";
            desc = "Set this field to default value.";
            sw = r; hw = w;
            reset = 0x0;
        } ac_rdcnt[2:0];
    } ACDEBUG @ 0x190;
    reg {
        name = "ACPHYRSVDC";
        desc = "ACPHYRSVDC is AC block PHY reserved control pin register 1. This register is used to control the PHY and should not be modified. (offset 0x194; total reset 0xFFFF0000; PROVEN: Hi3521A/Hi3520D V300 data sheet (Issue 00B07, 2015-12-10), section 4.1.9.2, PDF page 916).";
        field {
            name = "ac_rsv_control";
            desc = "Reserved.";
            sw = rw; hw = r;
            reset = 0xffff0000;
        } ac_rsv_control[31:0];
    } ACPHYRSVDC @ 0x194;
    reg {
        name = "ACPHYRSVDS";
        desc = "ACPHYRSVDS is AC block PHY reserved control pin register 2. This register is used to control the PHY and should not be modified. (offset 0x198; total reset 0xFFFF0000; PROVEN: Hi3521A/Hi3520D V300 data sheet (Issue 00B07, 2015-12-10), section 4.1.9.2, PDF page 917).";
        field {
            name = "ac_rsv_status";
            desc = "Reserved.";
            sw = r; hw = w;
            reset = 0xffff0000;
        } ac_rsv_status[31:0];
    } ACPHYRSVDS @ 0x198;
    reg {
        name = "ACPHYCTL8";
        desc = "ACPHYCTL8 is AC block PHY control register 8. This register is used to control the PHY and should not be modified. (offset 0x19C; total reset 0x00000000; PROVEN: Hi3521A/Hi3520D V300 data sheet (Issue 00B07, 2015-12-10), section 4.1.9.2, PDF page 917).";
        field {
            name = "Reserved.";
            desc = "Reserved.";
            sw = r; hw = w;
            reset = 0x0;
        } reserved_31_21[31:21];
        field {
            name = "ac_ck12p_reserve";
            desc = "Set this field to default value.";
            sw = rw; hw = r;
            reset = 0x0;
        } ac_ck12p_reserve[20:18];
        field {
            name = "ac_ck11p_reserve";
            desc = "Set this field to default value.";
            sw = rw; hw = r;
            reset = 0x0;
        } ac_ck11p_reserve[17:15];
        field {
            name = "ac_ck10p_reserve";
            desc = "Set this field to default value.";
            sw = rw; hw = r;
            reset = 0x0;
        } ac_ck10p_reserve[14:12];
        field {
            name = "ac_ck9p_reserve";
            desc = "Set this field to default value.";
            sw = rw; hw = r;
            reset = 0x0;
        } ac_ck9p_reserve[11:9];
        field {
            name = "ac_ck8p_reserve";
            desc = "Set this field to default value.";
            sw = rw; hw = r;
            reset = 0x0;
        } ac_ck8p_reserve[8:6];
        field {
            name = "ac_ck7p_reserve";
            desc = "Set this field to default value.";
            sw = rw; hw = r;
            reset = 0x0;
        } ac_ck7p_reserve[5:3];
        field {
            name = "ac_ck6p_reserve";
            desc = "Set this field to default value.";
            sw = rw; hw = r;
            reset = 0x0;
        } ac_ck6p_reserve[2:0];
    } ACPHYCTL8 @ 0x19C;
    reg {
        name = "ACCMDBDL8";
        desc = "ACCMDBDL8 is AC command bit delay line configuration register 8. (offset 0x1A0; total reset 0x00000000; PROVEN: Hi3521A/Hi3520D V300 data sheet (Issue 00B07, 2015-12-10), section 4.1.9.2, PDF page 918).";
        field {
            name = "Reserved.";
            desc = "Reserved.";
            sw = r; hw = w;
            reset = 0x0;
        } reserved_31_21[31:21];
        field {
            name = "odt1_bdl1";
            desc = "Set this field to default value.";
            sw = rw; hw = r;
            reset = 0x0;
        } odt1_bdl1[20:16];
        field {
            name = "Reserved.";
            desc = "Reserved.";
            sw = r; hw = w;
            reset = 0x0;
        } reserved_15_5[15:5];
        field {
            name = "odt1_bdl0";
            desc = "Set this field to default value.";
            sw = rw; hw = r;
            reset = 0x0;
        } odt1_bdl0[4:0];
    } ACCMDBDL8 @ 0x1A0;
    reg {
        name = "ACCMDBDL9";
        desc = "ACCMDBDL9 is AC command bit delay line configuration register 9. (offset 0x1A4; total reset 0x00000000; PROVEN: Hi3521A/Hi3520D V300 data sheet (Issue 00B07, 2015-12-10), section 4.1.9.2, PDF page 918).";
        field {
            name = "Reserved.";
            desc = "Reserved.";
            sw = r; hw = w;
            reset = 0x0;
        } reserved_31_21[31:21];
        field {
            name = "odt1_bdl3";
            desc = "Set this field to default value.";
            sw = rw; hw = r;
            reset = 0x0;
        } odt1_bdl3[20:16];
        field {
            name = "Reserved.";
            desc = "Reserved.";
            sw = r; hw = w;
            reset = 0x0;
        } reserved_15_5[15:5];
        field {
            name = "odt1_bdl2";
            desc = "Set this field to default value.";
            sw = rw; hw = r;
            reset = 0x0;
        } odt1_bdl2[4:0];
    } ACCMDBDL9 @ 0x1A4;
    reg {
        name = "ACCMDBDL10";
        desc = "ACCMDBDL10 is AC command bit delay line configuration register 10. (offset 0x1A8; total reset 0x00000000; PROVEN: Hi3521A/Hi3520D V300 data sheet (Issue 00B07, 2015-12-10), section 4.1.9.2, PDF page 919).";
        field {
            name = "Reserved.";
            desc = "Reserved.";
            sw = r; hw = w;
            reset = 0x0;
        } reserved_31_21[31:21];
        field {
            name = "cs1_bdl1";
            desc = "Set this field to default value.";
            sw = rw; hw = r;
            reset = 0x0;
        } cs1_bdl1[20:16];
        field {
            name = "Reserved.";
            desc = "Reserved.";
            sw = r; hw = w;
            reset = 0x0;
        } reserved_15_5[15:5];
        field {
            name = "cs1_bdl0";
            desc = "Set this field to default value.";
            sw = rw; hw = r;
            reset = 0x0;
        } cs1_bdl0[4:0];
    } ACCMDBDL10 @ 0x1A8;
    reg {
        name = "ACCMDBDL11";
        desc = "ACCMDBDL11 is AC command bit delay line configuration register 11. (offset 0x1AC; total reset 0x00000000; PROVEN: Hi3521A/Hi3520D V300 data sheet (Issue 00B07, 2015-12-10), section 4.1.9.2, PDF page 919).";
        field {
            name = "Reserved.";
            desc = "Reserved.";
            sw = r; hw = w;
            reset = 0x0;
        } reserved_31_21[31:21];
        field {
            name = "cs1_bdl3";
            desc = "Set this field to default value.";
            sw = rw; hw = r;
            reset = 0x0;
        } cs1_bdl3[20:16];
        field {
            name = "Reserved.";
            desc = "Reserved.";
            sw = r; hw = w;
            reset = 0x0;
        } reserved_15_5[15:5];
        field {
            name = "cs1_bdl2";
            desc = "Set this field to default value.";
            sw = rw; hw = r;
            reset = 0x0;
        } cs1_bdl2[4:0];
    } ACCMDBDL11 @ 0x1AC;
    reg {
        name = "ACPHYDCC";
        desc = "ACPHYDCC is an AC block PHY DCC control register. This register is used to control the PHY and should not be modified. (offset 0x1B0; total reset 0x00000000; PROVEN: Hi3521A/Hi3520D V300 data sheet (Issue 00B07, 2015-12-10), section 4.1.9.2, PDF page 920).";
        field {
            name = "Reserved.";
            desc = "Reserved.";
            sw = r; hw = w;
            reset = 0x0;
        } reserved_31_19[31:19];
        field {
            name = "acdcc_mclk";
            desc = "Set this field to default value.";
            sw = rw; hw = r;
            reset = 0x0;
        } acdcc_mclk[18:16];
        field {
            name = "Reserved.";
            desc = "Reserved.";
            sw = r; hw = w;
            reset = 0x0;
        } reserved_15_15[15:15];
        field {
            name = "acdcc_dqs0";
            desc = "Set this field to default value.";
            sw = rw; hw = r;
            reset = 0x0;
        } acdcc_dqs0[14:12];
        field {
            name = "Reserved.";
            desc = "Reserved.";
            sw = r; hw = w;
            reset = 0x0;
        } reserved_11_11[11:11];
        field {
            name = "acdcc_dqs1";
            desc = "Set this field to default value.";
            sw = rw; hw = r;
            reset = 0x0;
        } acdcc_dqs1[10:8];
        field {
            name = "Reserved.";
            desc = "Reserved.";
            sw = r; hw = w;
            reset = 0x0;
        } reserved_7_7[7:7];
        field {
            name = "acdcc_dq0";
            desc = "Set this field to default value.";
            sw = rw; hw = r;
            reset = 0x0;
        } acdcc_dq0[6:4];
        field {
            name = "Reserved.";
            desc = "Reserved.";
            sw = r; hw = w;
            reset = 0x0;
        } reserved_3_3[3:3];
        field {
            name = "acdcc_dq1";
            desc = "Set this field to default value.";
            sw = rw; hw = r;
            reset = 0x0;
        } acdcc_dq1[2:0];
    } ACPHYDCC @ 0x1B0;
    reg {
        name = "ACPHYCTL9";
        desc = "ACPHYCTL9 is AC block PHY control register 9. This register is used to control the PHY and should not be modified. (offset 0x1B4; total reset 0x00000000; PROVEN: Hi3521A/Hi3520D V300 data sheet (Issue 00B07, 2015-12-10), section 4.1.9.2, PDF page 920).";
        field {
            name = "Reserved.";
            desc = "Reserved.";
            sw = r; hw = w;
            reset = 0x0;
        } reserved_31_12[31:12];
        field {
            name = "actiming2t_odt1";
            desc = "Set this field to default value.";
            sw = rw; hw = r;
            reset = 0x0;
        } actiming2t_odt1[11:11];
        field {
            name = "actiming2t_cke1";
            desc = "Set this field to default value.";
            sw = rw; hw = r;
            reset = 0x0;
        } actiming2t_cke1[10:10];
        field {
            name = "actiming2t_cs1";
            desc = "Set this field to default value.";
            sw = rw; hw = r;
            reset = 0x0;
        } actiming2t_cs1[9:9];
        field {
            name = "acdram1sel_odt1";
            desc = "Set this field to default value.";
            sw = rw; hw = r;
            reset = 0x0;
        } acdram1sel_odt1[8:8];
        field {
            name = "acdram1sel_cke1";
            desc = "Set this field to default value.";
            sw = rw; hw = r;
            reset = 0x0;
        } acdram1sel_cke1[7:7];
        field {
            name = "acdram1sel_cs1";
            desc = "Set this field to default value.";
            sw = rw; hw = r;
            reset = 0x0;
        } acdram1sel_cs1[6:6];
        field {
            name = "acposedge_odt1";
            desc = "Set this field to default value.";
            sw = rw; hw = r;
            reset = 0x0;
        } acposedge_odt1[5:5];
        field {
            name = "acposedge_cke1";
            desc = "Set this field to default value.";
            sw = rw; hw = r;
            reset = 0x0;
        } acposedge_cke1[4:4];
        field {
            name = "acposedge_cs1";
            desc = "Set this field to default value.";
            sw = rw; hw = r;
            reset = 0x0;
        } acposedge_cs1[3:3];
        field {
            name = "acsdrsel_odt1";
            desc = "Set this field to default value.";
            sw = rw; hw = r;
            reset = 0x0;
        } acsdrsel_odt1[2:2];
        field {
            name = "acsdrsel_cke1";
            desc = "Set this field to default value.";
            sw = rw; hw = r;
            reset = 0x0;
        } acsdrsel_cke1[1:1];
        field {
            name = "acsdrsel_cs1";
            desc = "Set this field to default value.";
            sw = rw; hw = r;
            reset = 0x0;
        } acsdrsel_cs1[0:0];
    } ACPHYCTL9 @ 0x1B4;
    reg {
        name = "CATTIMER0";
        desc = "CATTIMER0 is a CA training timer 0 register. (offset 0x1C0; total reset 0x0B170B0B; PROVEN: Hi3521A/Hi3520D V300 data sheet (Issue 00B07, 2015-12-10), section 4.1.9.2, PDF page 921).";
        field {
            name = "Reserved.";
            desc = "Reserved.";
            sw = r; hw = w;
            reset = 0x0;
        } reserved_31_30[31:30];
        field {
            name = "tcackeh";
            desc = "tCACKEH (dficlk cycle).";
            sw = rw; hw = r;
            reset = 0xb;
        } tcackeh[29:24];
        field {
            name = "Reserved.";
            desc = "Reserved.";
            sw = r; hw = w;
            reset = 0x0;
        } reserved_23_22[23:22];
        field {
            name = "tcacd";
            desc = "tCACD (dficlk cycle).";
            sw = rw; hw = r;
            reset = 0x17;
        } tcacd[21:16];
        field {
            name = "Reserved.";
            desc = "Reserved.";
            sw = r; hw = w;
            reset = 0x0;
        } reserved_15_14[15:14];
        field {
            name = "tcaent";
            desc = "tCAENT (dficlk cycle).";
            sw = rw; hw = r;
            reset = 0xb;
        } tcaent[13:8];
        field {
            name = "Reserved.";
            desc = "Reserved.";
            sw = r; hw = w;
            reset = 0x0;
        } reserved_7_6[7:6];
        field {
            name = "tcackel";
            desc = "tCACKEL (dficlk cycle).";
            sw = rw; hw = r;
            reset = 0xb;
        } tcackel[5:0];
    } CATTIMER0 @ 0x1C0;
    reg {
        name = "CATTIMER1";
        desc = "CATTIMER1 is CA training timer 1 register. (offset 0x1C4; total reset 0x0000040B; PROVEN: Hi3521A/Hi3520D V300 data sheet (Issue 00B07, 2015-12-10), section 4.1.9.2, PDF page 922).";
        field {
            name = "Reserved.";
            desc = "Reserved.";
            sw = r; hw = w;
            reset = 0x0;
        } reserved_31_14[31:14];
        field {
            name = "tmrz";
            desc = "tMRZ (dficlk cycle).";
            sw = rw; hw = r;
            reset = 0x4;
        } tmrz[13:8];
        field {
            name = "Reserved.";
            desc = "Reserved.";
            sw = r; hw = w;
            reset = 0x0;
        } reserved_7_6[7:6];
        field {
            name = "tcaext";
            desc = "tCAEXT (dficlk cycle).";
            sw = rw; hw = r;
            reset = 0xb;
        } tcaext[5:0];
    } CATTIMER1 @ 0x1C4;
    reg {
        name = "CATCONFIG";
        desc = "CATCONFIG is a CA training configuration register. (offset 0x1C8; total reset 0x00082606; PROVEN: Hi3521A/Hi3520D V300 data sheet (Issue 00B07, 2015-12-10), section 4.1.9.2, PDF page 922).";
        field {
            name = "sw_cat_en";
            desc = "SW CA training enable. When this field is asserted, PACK will enter the SW CA training state. After the SW CA training is complete, this bit should be deasserted by firmware.
- 0: disabled (default)
- 1: enabled";
            sw = rw; hw = r;
            reset = 0x0;
        } sw_cat_en[31:31];
        field {
            name = "sw_cat_dqvalid";
            desc = "SW CA training. This field indicates whether the CA result is ready. This bit is cleared when sw_cat_strobe is asserted. Then after the timing tCACD, this bit is asserted.
- 0: not valid
- 1: valid";
            sw = rw; hw = r;
            reset = 0x0;
        } sw_cat_dqvalid[30:30];
        field {
            name = "sw_cat_cke_low";
            desc = "SW CA training. This field is used to request the CKE to be low and it cleared by HW.";
            sw = rw; hw = r;
            reset = 0x0;
        } sw_cat_cke_low[29:29];
        field {
            name = "sw_cat_cke_high";
            desc = "SW CA training. This field is used to request the CKE to be high and is cleared by HW.";
            sw = rw; hw = r;
            reset = 0x0;
        } sw_cat_cke_high[28:28];
        field {
            name = "sw_cat_strobe";
            desc = "SW CA training. This field is used to issue the predefined SW CA pattern and is cleared by HW.";
            sw = rw; hw = r;
            reset = 0x0;
        } sw_cat_strobe[27:27];
        field {
            name = "sw_cat_mrw41";
            desc = "SW CA training. This field is used to issue the MRW41 command and is cleared by HW.";
            sw = rw; hw = r;
            reset = 0x0;
        } sw_cat_mrw41[26:26];
        field {
            name = "sw_cat_mrw48";
            desc = "SW CA training. This field is used to issue the MRW48 command and is cleared by HW.";
            sw = rw; hw = r;
            reset = 0x0;
        } sw_cat_mrw48[25:25];
        field {
            name = "sw_cat_mrw42";
            desc = "SW CA training. This field is used to issue the MRW42 command and is cleared by HW.";
            sw = rw; hw = r;
            reset = 0x0;
        } sw_cat_mrw42[24:24];
        field {
            name = "Reserved.";
            desc = "Reserved.";
            sw = r; hw = w;
            reset = 0x0;
        } reserved_23_21[23:21];
        field {
            name = "cat_openeye_en";
            desc = "HW CA training open eye enable.
- 0: disabled (default)
- 1: enabled";
            sw = rw; hw = r;
            reset = 0x0;
        } cat_openeye_en[20:20];
        field {
            name = "cat_restore_en";
            desc = "HW CA training restore enable. If this field is set to high, the CA training will restore the CA phase before the second CA training (mapping stage) starts. This field is recommended to set to high.
- 0: disabled
- 1: enabled (default)";
            sw = rw; hw = r;
            reset = 0x1;
        } cat_restore_en[19:19];
        field {
            name = "cat_cat_phydq_sel";
            desc = "HW CA training PHY DQ CA result select.
- 0: LSB (default)
- 1: MSB";
            sw = rw; hw = r;
            reset = 0x0;
        } cat_cat_phydq_sel[18:18];
        field {
            name = "Reserved.";
            desc = "Reserved.";
            sw = r; hw = w;
            reset = 0x0;
        } reserved_17_16[17:16];
        field {
            name = "cat_rb_backtap";
            desc = "HW CA training right boundary back tap. This field is used to offset the addrph_a before the right boundary search is started to overcome meta-sable zone.";
            sw = rw; hw = r;
            reset = 0x2;
        } cat_rb_backtap[15:12];
        field {
            name = "ca_samp_num_ph";
            desc = "HW CA training sample count for CA phase. Value range: 1-15";
            sw = rw; hw = r;
            reset = 0x6;
        } ca_samp_num_ph[11:8];
        field {
            name = "Reserved.";
            desc = "Reserved.";
            sw = r; hw = w;
            reset = 0x0;
        } reserved_7_4[7:4];
        field {
            name = "ca_samp_num_bdl";
            desc = "HW CA training sample count for CA BDL. Value range: 1-15";
            sw = rw; hw = r;
            reset = 0x6;
        } ca_samp_num_bdl[3:0];
    } CATCONFIG @ 0x1C8;
    reg {
        name = "CATRESULT";
        desc = "CATRESULT is a CA training result register (for debugging). (offset 0x1CC; total reset 0x00000000; PROVEN: Hi3521A/Hi3520D V300 data sheet (Issue 00B07, 2015-12-10), section 4.1.9.2, PDF page 924).";
        field {
            name = "Reserved.";
            desc = "Reserved.";
            sw = r; hw = w;
            reset = 0x0;
        } reserved_31_10[31:10];
        field {
            name = "cat_reault";
            desc = "CA training. HW CA training result for each address bit during each HW CA training state. This field is meaningful only after the HW CA training is complete and is only for debugging.
- 0: Failed
- 1: OK";
            sw = r; hw = w;
            reset = 0x0;
        } cat_reault[9:0];
    } CATRESULT @ 0x1CC;
    reg {
        name = "PHYDQRESULT";
        desc = "PHYDQRESULT is a SW CA training DQ result (from PHY) register. (offset 0x1D0; total reset 0x00000000; PROVEN: Hi3521A/Hi3520D V300 data sheet (Issue 00B07, 2015-12-10), section 4.1.9.2, PDF page 924).";
        field {
            name = "phy_dq_result";
            desc = "SW CA training. SW CA training latched results from the DRAM device. For the LPDDR3 CA training, the meaningful bits are [15:0] (mapped to DQ[15:0]). PACK and PHY will not latch these bits, so these bits are those you obtained on DQ of the DRAM device.";
            sw = r; hw = w;
            reset = 0x0;
        } phy_dq_result[31:0];
    } PHYDQRESULT @ 0x1D0;
    reg {
        name = "ADDRPHBOUND";
        desc = "ADDRPHBOUND is a CA training address phase boundary register. (offset 0x1D4; total reset 0x00080000; PROVEN: Hi3521A/Hi3520D V300 data sheet (Issue 00B07, 2015-12-10), section 4.1.9.2, PDF page 925).";
        field {
            name = "Reserved.";
            desc = "Reserved.";
            sw = r; hw = w;
            reset = 0x0;
        } reserved_31_29[31:29];
        field {
            name = "addrph_a_ori";
            desc = "HW CA training. This field records the address phase before the HW CA training (for debugging).";
            sw = r; hw = w;
            reset = 0x0;
        } addrph_a_ori[28:24];
        field {
            name = "Reserved.";
            desc = "Reserved.";
            sw = r; hw = w;
            reset = 0x0;
        } reserved_23_21[23:21];
        field {
            name = "addrph_a";
            desc = "HW CA training. This field records the left boundary of the address phase after the HW CA training (for debugging).";
            sw = rw; hw = r;
            reset = 0x8;
        } addrph_a[20:16];
        field {
            name = "Reserved.";
            desc = "Reserved.";
            sw = r; hw = w;
            reset = 0x0;
        } reserved_15_13[15:13];
        field {
            name = "addrph_a_left";
            desc = "HW CA training. This field records the left boundary of the address phase after the HW CA training (for debugging).";
            sw = r; hw = w;
            reset = 0x0;
        } addrph_a_left[12:8];
        field {
            name = "Reserved.";
            desc = "Reserved.";
            sw = r; hw = w;
            reset = 0x0;
        } reserved_7_5[7:5];
        field {
            name = "addrph_a_right";
            desc = "HW CA training. This field records the right boundary of the address phase after the HW CA training (for debugging).";
            sw = r; hw = w;
            reset = 0x0;
        } addrph_a_right[4:0];
    } ADDRPHBOUND @ 0x1D4;
    reg {
        name = "SWCATPATTERN_P";
        desc = "SWCATPATTERN_P is an SW CA training pattern register for the positive CK edge. (offset 0x1D8; total reset 0x00000000; PROVEN: Hi3521A/Hi3520D V300 data sheet (Issue 00B07, 2015-12-10), section 4.1.9.2, PDF page 925).";
        field {
            name = "Reserved.";
            desc = "Reserved.";
            sw = r; hw = w;
            reset = 0x0;
        } reserved_31_10[31:10];
        field {
            name = "sw_cat_pat_p";
            desc = "SW CA training pattern for the positive CK edge. You can fill any pattern.";
            sw = rw; hw = r;
            reset = 0x0;
        } sw_cat_pat_p[9:0];
    } SWCATPATTERN_P @ 0x1D8;
    reg {
        name = "SWCATPATTERN_N";
        desc = "SWCATPATTERN_N is an SW CA training pattern register for the negative CK edge. (offset 0x1DC; total reset 0x000003FF; PROVEN: Hi3521A/Hi3520D V300 data sheet (Issue 00B07, 2015-12-10), section 4.1.9.2, PDF page 926).";
        field {
            name = "Reserved.";
            desc = "Reserved.";
            sw = r; hw = w;
            reset = 0x0;
        } reserved_31_10[31:10];
        field {
            name = "sw_cat_pat_n";
            desc = "SW CA training pattern for the negative CK edge. You can fill any pattern.";
            sw = rw; hw = r;
            reset = 0x3ff;
        } sw_cat_pat_n[9:0];
    } SWCATPATTERN_N @ 0x1DC;
    reg {
        name = "LPCTRL";
        desc = "LPCTRL is a low-power control register. (offset 0x1E4; total reset 0xFE808688; PROVEN: Hi3521A/Hi3520D V300 data sheet (Issue 00B07, 2015-12-10), section 4.1.9.2, PDF page 926).";
        field {
            name = "gcken_auto_en";
            desc = "Auto gated clock control enable. If this field is set to high, HW automatically/dynamically controls the PACK high-level clock gating.
- 0: off
- 1: on (default)";
            sw = rw; hw = r;
            reset = 0x1;
        } gcken_auto_en[31:31];
        field {
            name = "gcken_dfi_main";
            desc = "Manual gating control, main DFI clock gating switch.
- 0: clock off
- 1: clock on (default)

When this field is set to low (clock off), some control registers that use the dfi_main clock are affected.";
            sw = rw; hw = r;
            reset = 0x1;
        } gcken_dfi_main[30:30];
        field {
            name = "gcken_dinit";
            desc = "Manual gating control, DRAM initialization clock gating.
- 0: clock off
- 1: clock on (default)";
            sw = rw; hw = r;
            reset = 0x1;
        } gcken_dinit[29:29];
        field {
            name = "gcken_dtrain";
            desc = "Manual gating control, data training clock gating.
- 0: clock off
- 1: clock on (default)";
            sw = rw; hw = r;
            reset = 0x1;
        } gcken_dtrain[28:28];
        field {
            name = "gcken_retrain";
            desc = "Manual gating control, retraining clock gating.
- 0: clock off
- 1: clock on (default)";
            sw = rw; hw = r;
            reset = 0x1;
        } gcken_retrain[27:27];
        field {
            name = "gcken_acbist";
            desc = "Manual gating control, AC BIST clock gating.
- 0: clock off
- 1: clock on (default)";
            sw = rw; hw = r;
            reset = 0x1;
        } gcken_acbist[26:26];
        field {
            name = "gcken_dxbist";
            desc = "Manual gating control, data BIST clock gating.
- 0: clock off
- 1: clock on (default)";
            sw = rw; hw = r;
            reset = 0x1;
        } gcken_dxbist[25:25];
        field {
            name = "t_wakeup_thrd_lv2";
            desc = "DFI low-power control interface timing threshold. ≥ wakeup_thrd_lv2: PHY clock gating, disable AC output enable ≥ wakeup_thrd_lv3: PHY clock gating, disable AC output enable, PHY PLL disable wakeup_thrd_lv3 should ≥ wakeup_thrd_lv2";
            sw = rw; hw = r;
            reset = 0x4;
        } t_wakeup_thrd_lv2[24:21];
        field {
            name = "lp_cmdoen_disable";
            desc = "LP CMDOEN function disable when low-power assert. If this function is enabled, the I/O output of CA is floating to reduce I/O power.
- 0: LP-related function enabled (default)
- 1: LP-related function disabled";
            sw = rw; hw = r;
            reset = 0x0;
        } lp_cmdoen_disable[20:20];
        field {
            name = "lp_ac_phy_clkgated_disable";
            desc = "LP AC PHY clock gating disable when low-power assert.
- 0: LP-related function enabled (default)
- 1: LP-related function disabled";
            sw = rw; hw = r;
            reset = 0x0;
        } lp_ac_phy_clkgated_disable[19:19];
        field {
            name = "lp_dx_phy_clkgated_disable";
            desc = "LP DX PHY clock gating disable when low-power assert.
- 0: LP-related function enabled (default)
- 1: LP-related function disabled";
            sw = rw; hw = r;
            reset = 0x0;
        } lp_dx_phy_clkgated_disable[18:18];
        field {
            name = "lp_dx_phy_phgated_disable";
            desc = "DX PHY clock phase gating disable when low-power assert.
- 0: LP-related function enabled (default)
- 1: LP-related function disabled";
            sw = rw; hw = r;
            reset = 0x0;
        } lp_dx_phy_phgated_disable[17:17];
        field {
            name = "lp_pll_powerdown_disable";
            desc = "LP PLL disable function disable when low-power assert.
- 0: LP-related function enabled (default)
- 1: LP-related function disabled";
            sw = rw; hw = r;
            reset = 0x0;
        } lp_pll_powerdown_disable[16:16];
        field {
            name = "t_resp";
            desc = "DFI low-power control interface timing parameter. The field value must be smaller than DFI tlp_resp.";
            sw = rw; hw = r;
            reset = 0x8;
        } t_resp[15:12];
        field {
            name = "t_wakeup_thrd_lv3";
            desc = "DFI low-power control interface timing threshold. ≥ wakeup_thrd_lv2: PHY clock gating, disable AC output enable ≥ wakeup_thrd_lv3: PHY clock gating, disable AC output enable, PHY PLL power down Note: wakeup_thrd_lv3 should ≥ wakeup_thrd_lv2";
            sw = rw; hw = r;
            reset = 0x6;
        } t_wakeup_thrd_lv3[11:8];
        field {
            name = "t_dram_clk_disable";
            desc = "DFI DRAM clock disable timing parameter. This field is used to count down before DRAM CK is disabled.";
            sw = rw; hw = r;
            reset = 0x8;
        } t_dram_clk_disable[7:4];
        field {
            name = "t_dram_clk_enable";
            desc = "DFI DRAM clock enable timing parameter. This field is used to count down before DRAM CK is enabled.";
            sw = rw; hw = r;
            reset = 0x8;
        } t_dram_clk_enable[3:0];
    } LPCTRL @ 0x1E4;
    reg DXNBISTCTRL_t {
        name = "DXNBISTCTRL";
        desc = "DXNBISTCTRL is a loopback data comparison control register during BIST of data blocks. (offset 0x200, 4 instances at stride 0x80; total reset 0x00000000; PROVEN: Hi3521A/Hi3520D V300 data sheet (Issue 00B07, 2015-12-10), section 4.1.9.2, PDF page 928).";
        field {
            name = "lfsr_seed";
            desc = "LFSR seed value. This field specifies the initial seed value of the LFSR generator to this byte lane.";
            sw = rw; hw = r;
            reset = 0x0;
        } lfsr_seed[31:24];
        field {
            name = "Reserved.";
            desc = "Reserved.";
            sw = r; hw = w;
            reset = 0x0;
        } reserved_23_17[23:17];
        field {
            name = "dqm_cmp_mask";
            desc = "DQM loopback compare mask. This field controls whether the comparison of the loopback data on DQM bits is disabled.
- 0: not compared
- 1: compared";
            sw = rw; hw = r;
            reset = 0x0;
        } dqm_cmp_mask[16:16];
        field {
            name = "dq_cmp_mask";
            desc = "DQ loopback compare mask. This field controls whether the comparison of the loopback data on DQ bits is disabled.
- 0: not compared
- 1: compared";
            sw = rw; hw = r;
            reset = 0x0;
        } dq_cmp_mask[15:8];
        field {
            name = "Reserved.";
            desc = "Reserved.";
            sw = r; hw = w;
            reset = 0x0;
        } reserved_7_1[7:1];
        field {
            name = "bist_en";
            desc = "BIST enable. This field specifies whether the data block is included for the loopback test while bist_op is set to BIST Enable.";
            sw = rw; hw = r;
            reset = 0x0;
        } bist_en[0:0];
    };
    DXNBISTCTRL_t DXNBISTCTRL_0 @ 0x200;
    DXNBISTCTRL_t DXNBISTCTRL_1 @ 0x280;
    DXNBISTCTRL_t DXNBISTCTRL_2 @ 0x300;
    DXNBISTCTRL_t DXNBISTCTRL_3 @ 0x380;
    reg DXNBISTSTS_t {
        name = "DXNBISTSTS";
        desc = "DXNBISTSTS is a BIST test result and status register. Note that this register is read-only, and can be reset only by setting bist_op to BIST Reset. (offset 0x204, 4 instances at stride 0x80; total reset 0x00000000; PROVEN: Hi3521A/Hi3520D V300 data sheet (Issue 00B07, 2015-12-10), section 4.1.9.2, PDF page 929).";
        field {
            name = "Reserved.";
            desc = "Reserved.";
            sw = r; hw = w;
            reset = 0x0;
        } reserved_31_17[31:17];
        field {
            name = "dqm_cmp_err";
            desc = "BIST error on DQM.";
            sw = r; hw = w;
            reset = 0x0;
        } dqm_cmp_err[16:16];
        field {
            name = "dq_cmp_ferr";
            desc = "BIST error on DQ at the falling edge of DQS.";
            sw = r; hw = w;
            reset = 0x0;
        } dq_cmp_ferr[15:8];
        field {
            name = "dq_cmp_rerr";
            desc = "BIST error on DQ at the rising edge of DQS";
            sw = r; hw = w;
            reset = 0x0;
        } dq_cmp_rerr[7:0];
    };
    DXNBISTSTS_t DXNBISTSTS_0 @ 0x204;
    DXNBISTSTS_t DXNBISTSTS_1 @ 0x284;
    DXNBISTSTS_t DXNBISTSTS_2 @ 0x304;
    DXNBISTSTS_t DXNBISTSTS_3 @ 0x384;
    reg DXNCTRL_t {
        name = "DXNCTRL";
        desc = "DXNCTRL is a data block control register. (offset 0x208, 4 instances at stride 0x80; total reset 0x00000000; PROVEN: Hi3521A/Hi3520D V300 data sheet (Issue 00B07, 2015-12-10), section 4.1.9.2, PDF page 930).";
        field {
            name = "Reserved.";
            desc = "Reserved.";
            sw = r; hw = w;
            reset = 0x0;
        } reserved_31_2[31:2];
        field {
            name = "dm_dis";
            desc = "Data mask disable. This field specifies whether the corresponding write data mask (DM) is enabled. When this field is set to 1, the corresponding DM is not used and calibrated during training.";
            sw = rw; hw = r;
            reset = 0x0;
        } dm_dis[1:1];
        field {
            name = "bl_dis";
            desc = "Byte lane disable. This field specifies whether the corresponding byte lane is in use. If the corresponding byte lane is not used, the PLL/DDL is powered down, and the output driver is turned off.";
            sw = rw; hw = r;
            reset = 0x0;
        } bl_dis[0:0];
    };
    DXNCTRL_t DXNCTRL_0 @ 0x208;
    DXNCTRL_t DXNCTRL_1 @ 0x288;
    DXNCTRL_t DXNCTRL_2 @ 0x308;
    DXNCTRL_t DXNCTRL_3 @ 0x388;
    reg DXNWDQNBDL0_t {
        name = "DXNWDQNBDL0";
        desc = "DXNWDQNBDL0 is data block bit delay configuration register 0. (offset 0x210, 4 instances at stride 0x80; total reset 0x00000000; PROVEN: Hi3521A/Hi3520D V300 data sheet (Issue 00B07, 2015-12-10), section 4.1.9.2, PDF page 930).";
        field {
            name = "Reserved.";
            desc = "Reserved.";
            sw = r; hw = w;
            reset = 0x0;
        } reserved_31_29[31:29];
        field {
            name = "wdq3bdl";
            desc = "Delay select of WDQ3. This field specifies the delay value of the bit delay line on the write path of DQ3.";
            sw = rw; hw = r;
            reset = 0x0;
        } wdq3bdl[28:24];
        field {
            name = "Reserved.";
            desc = "Reserved.";
            sw = r; hw = w;
            reset = 0x0;
        } reserved_23_21[23:21];
        field {
            name = "wdq2bdl";
            desc = "Delay select of WDQ2. This field specifies the delay value of the bit delay line on the write path of DQ2.";
            sw = rw; hw = r;
            reset = 0x0;
        } wdq2bdl[20:16];
        field {
            name = "Reserved.";
            desc = "Reserved.";
            sw = r; hw = w;
            reset = 0x0;
        } reserved_15_13[15:13];
        field {
            name = "wdq1bdl";
            desc = "Delay select of WDQ1. This field specifies the delay value of the bit delay line on the write path of DQ1.";
            sw = rw; hw = r;
            reset = 0x0;
        } wdq1bdl[12:8];
        field {
            name = "Reserved.";
            desc = "Reserved.";
            sw = r; hw = w;
            reset = 0x0;
        } reserved_7_5[7:5];
        field {
            name = "wdq0bdl";
            desc = "Delay select of WDQ0. This field specifies the delay value of the bit delay line on the write path of DQ0.";
            sw = rw; hw = r;
            reset = 0x0;
        } wdq0bdl[4:0];
    };
    DXNWDQNBDL0_t DXNWDQNBDL0_0 @ 0x210;
    DXNWDQNBDL0_t DXNWDQNBDL0_1 @ 0x290;
    DXNWDQNBDL0_t DXNWDQNBDL0_2 @ 0x310;
    DXNWDQNBDL0_t DXNWDQNBDL0_3 @ 0x390;
    reg DXNWDQNBDL1_t {
        name = "DXNWDQNBDL1";
        desc = "DXNWDQNBDL1 is data block bit delay configuration register 1. (offset 0x214, 4 instances at stride 0x80; total reset 0x00000000; PROVEN: Hi3521A/Hi3520D V300 data sheet (Issue 00B07, 2015-12-10), section 4.1.9.2, PDF page 931).";
        field {
            name = "Reserved.";
            desc = "Reserved.";
            sw = r; hw = w;
            reset = 0x0;
        } reserved_31_29[31:29];
        field {
            name = "wdq7bdl";
            desc = "Delay select of WDQ7. This field specifies the delay value of the bit delay line on the write path of DQ3.";
            sw = rw; hw = r;
            reset = 0x0;
        } wdq7bdl[28:24];
        field {
            name = "Reserved.";
            desc = "Reserved.";
            sw = r; hw = w;
            reset = 0x0;
        } reserved_23_21[23:21];
        field {
            name = "wdq6bdl";
            desc = "Delay select of WDQ6. This field specifies the delay value of the bit delay line on the write path of DQ2.";
            sw = rw; hw = r;
            reset = 0x0;
        } wdq6bdl[20:16];
        field {
            name = "Reserved.";
            desc = "Reserved.";
            sw = r; hw = w;
            reset = 0x0;
        } reserved_15_13[15:13];
        field {
            name = "wdq5bdl";
            desc = "Delay select of WDQ5. This field specifies the delay value of the bit delay line on the write path of DQ1.";
            sw = rw; hw = r;
            reset = 0x0;
        } wdq5bdl[12:8];
        field {
            name = "Reserved.";
            desc = "Reserved.";
            sw = r; hw = w;
            reset = 0x0;
        } reserved_7_5[7:5];
        field {
            name = "wdq4bdl";
            desc = "Delay select of WDQ4. This field specifies the delay value of the bit delay line on the write path of DQ0.";
            sw = rw; hw = r;
            reset = 0x0;
        } wdq4bdl[4:0];
    };
    DXNWDQNBDL1_t DXNWDQNBDL1_0 @ 0x214;
    DXNWDQNBDL1_t DXNWDQNBDL1_1 @ 0x294;
    DXNWDQNBDL1_t DXNWDQNBDL1_2 @ 0x314;
    DXNWDQNBDL1_t DXNWDQNBDL1_3 @ 0x394;
    reg DXNWDQNBDL2_t {
        name = "DXNWDQNBDL2";
        desc = "DXNWDQNBDL2 is data block bit delay configuration register 2. (offset 0x218, 4 instances at stride 0x80; total reset 0x00000000; PROVEN: Hi3521A/Hi3520D V300 data sheet (Issue 00B07, 2015-12-10), section 4.1.9.2, PDF page 932).";
        field {
            name = "Reserved.";
            desc = "Reserved.";
            sw = r; hw = w;
            reset = 0x0;
        } reserved_31_5[31:5];
        field {
            name = "wdmbdl";
            desc = "Delay select of WDQM. This field specifies the delay value of the bit delay line on DQM.";
            sw = rw; hw = r;
            reset = 0x0;
        } wdmbdl[4:0];
    };
    DXNWDQNBDL2_t DXNWDQNBDL2_0 @ 0x218;
    DXNWDQNBDL2_t DXNWDQNBDL2_1 @ 0x298;
    DXNWDQNBDL2_t DXNWDQNBDL2_2 @ 0x318;
    DXNWDQNBDL2_t DXNWDQNBDL2_3 @ 0x398;
    reg DXNRDQNBDL0_t {
        name = "DXNRDQNBDL0";
        desc = "DXNRDQNBDL0 is data block bit delay configuration register 4. (offset 0x21C, 4 instances at stride 0x80; total reset 0x00000000; PROVEN: Hi3521A/Hi3520D V300 data sheet (Issue 00B07, 2015-12-10), section 4.1.9.2, PDF page 932).";
        field {
            name = "Reserved.";
            desc = "Reserved.";
            sw = r; hw = w;
            reset = 0x0;
        } reserved_31_29[31:29];
        field {
            name = "rdq3bdl";
            desc = "Delay select of RDQ3. This field specifies the delay value of the bit delay line on the write path of DQ3.";
            sw = rw; hw = r;
            reset = 0x0;
        } rdq3bdl[28:24];
        field {
            name = "Reserved.";
            desc = "Reserved.";
            sw = r; hw = w;
            reset = 0x0;
        } reserved_23_21[23:21];
        field {
            name = "rdq2bdl";
            desc = "Delay select of RDQ2. This field specifies the delay value of the bit delay line on the write path of DQ2.";
            sw = rw; hw = r;
            reset = 0x0;
        } rdq2bdl[20:16];
        field {
            name = "Reserved.";
            desc = "Reserved.";
            sw = r; hw = w;
            reset = 0x0;
        } reserved_15_13[15:13];
        field {
            name = "rdq1bdl";
            desc = "Delay select of RDQ1. This field specifies the delay value of the bit delay line on the write path of DQ1.";
            sw = rw; hw = r;
            reset = 0x0;
        } rdq1bdl[12:8];
        field {
            name = "Reserved.";
            desc = "Reserved.";
            sw = r; hw = w;
            reset = 0x0;
        } reserved_7_5[7:5];
        field {
            name = "rdq0bdl";
            desc = "Delay select of RDQ0. This field specifies the delay value of the bit delay line on the write path of DQ0.";
            sw = rw; hw = r;
            reset = 0x0;
        } rdq0bdl[4:0];
    };
    DXNRDQNBDL0_t DXNRDQNBDL0_0 @ 0x21C;
    DXNRDQNBDL0_t DXNRDQNBDL0_1 @ 0x29C;
    DXNRDQNBDL0_t DXNRDQNBDL0_2 @ 0x31C;
    DXNRDQNBDL0_t DXNRDQNBDL0_3 @ 0x39C;
    reg DXNRDQNBDL1_t {
        name = "DXNRDQNBDL1";
        desc = "DXNRDQNBDL1 is data block bit delay configuration register 5. (offset 0x220, 4 instances at stride 0x80; total reset 0x00000000; PROVEN: Hi3521A/Hi3520D V300 data sheet (Issue 00B07, 2015-12-10), section 4.1.9.2, PDF page 933).";
        field {
            name = "Reserved.";
            desc = "Reserved.";
            sw = r; hw = w;
            reset = 0x0;
        } reserved_31_29[31:29];
        field {
            name = "rdq7bdl";
            desc = "Delay select of RDQ7. This field specifies the delay value of the bit delay line on the write path of DQ3.";
            sw = rw; hw = r;
            reset = 0x0;
        } rdq7bdl[28:24];
        field {
            name = "Reserved.";
            desc = "Reserved.";
            sw = r; hw = w;
            reset = 0x0;
        } reserved_23_21[23:21];
        field {
            name = "rdq6bdl";
            desc = "Delay select of RDQ6. This field specifies the delay value of the bit delay line on the write path of DQ2.";
            sw = rw; hw = r;
            reset = 0x0;
        } rdq6bdl[20:16];
        field {
            name = "Reserved.";
            desc = "Reserved.";
            sw = r; hw = w;
            reset = 0x0;
        } reserved_15_13[15:13];
        field {
            name = "rdq5bdl";
            desc = "Delay select of RDQ5. This field specifies the delay value of the bit delay line on the write path of DQ1.";
            sw = rw; hw = r;
            reset = 0x0;
        } rdq5bdl[12:8];
        field {
            name = "Reserved.";
            desc = "Reserved.";
            sw = r; hw = w;
            reset = 0x0;
        } reserved_7_5[7:5];
        field {
            name = "rdq4bdl";
            desc = "Delay select of RDQ4. This field specifies the delay value of the bit delay line on the write path of DQ0.";
            sw = rw; hw = r;
            reset = 0x0;
        } rdq4bdl[4:0];
    };
    DXNRDQNBDL1_t DXNRDQNBDL1_0 @ 0x220;
    DXNRDQNBDL1_t DXNRDQNBDL1_1 @ 0x2A0;
    DXNRDQNBDL1_t DXNRDQNBDL1_2 @ 0x320;
    DXNRDQNBDL1_t DXNRDQNBDL1_3 @ 0x3A0;
    reg DXNRDQNBDL2_t {
        name = "DXNRDQNBDL2";
        desc = "DXNRDQNBDL2 is data block bit delay configuration register 6. (offset 0x224, 4 instances at stride 0x80; total reset 0x00000000; PROVEN: Hi3521A/Hi3520D V300 data sheet (Issue 00B07, 2015-12-10), section 4.1.9.2, PDF page 934).";
        field {
            name = "Reserved.";
            desc = "Reserved.";
            sw = r; hw = w;
            reset = 0x0;
        } reserved_31_5[31:5];
        field {
            name = "rdmbdl";
            desc = "Delay select of RDQM. This field specifies the delay value of the bit delay line on loopback read path of DQM.";
            sw = rw; hw = r;
            reset = 0x0;
        } rdmbdl[4:0];
    };
    DXNRDQNBDL2_t DXNRDQNBDL2_0 @ 0x224;
    DXNRDQNBDL2_t DXNRDQNBDL2_1 @ 0x2A4;
    DXNRDQNBDL2_t DXNRDQNBDL2_2 @ 0x324;
    DXNRDQNBDL2_t DXNRDQNBDL2_3 @ 0x3A4;
    reg DXNRDQSDLY_t {
        name = "DXNRDQSDLY";
        desc = "DXNRDQSDLY is a local delay line control register. (offset 0x22C, 4 instances at stride 0x80; total reset 0x00000000; PROVEN: Hi3521A/Hi3520D V300 data sheet (Issue 00B07, 2015-12-10), section 4.1.9.2, PDF page 934).";
        field {
            name = "Reserved.";
            desc = "Reserved.";
            sw = r; hw = w;
            reset = 0x0;
        } reserved_31_23[31:23];
        field {
            name = "rdqscyc";
            desc = "Read DQS clock phase select. This field specifies the number of taps in one clock cycle for the 1-T delay measurement type or the number of taps in half of clock cycle for the half-T delay measurement type. This field is used to create 90 degree delays for RDQS.";
            sw = rw; hw = r;
            reset = 0x0;
        } rdqscyc[22:16];
        field {
            name = "Reserved.";
            desc = "Reserved.";
            sw = r; hw = w;
            reset = 0x0;
        } reserved_15_7[15:7];
        field {
            name = "rdqsbdl";
            desc = "Read DQS delay select. This field specifies the phase shift of the read DQS to create 90 degree delays.";
            sw = rw; hw = r;
            reset = 0x0;
        } rdqsbdl[6:0];
    };
    DXNRDQSDLY_t DXNRDQSDLY_0 @ 0x22C;
    DXNRDQSDLY_t DXNRDQSDLY_1 @ 0x2AC;
    DXNRDQSDLY_t DXNRDQSDLY_2 @ 0x32C;
    DXNRDQSDLY_t DXNRDQSDLY_3 @ 0x3AC;
    reg DXNWDQSDLY_t {
        name = "DXNWDQSDLY";
        desc = "DXNWDQSDLY is a write leveling DQS delay control register. (offset 0x230, 4 instances at stride 0x80; total reset 0x00000000; PROVEN: Hi3521A/Hi3520D V300 data sheet (Issue 00B07, 2015-12-10), section 4.1.9.2, PDF page 935).";
        field {
            name = "Reserved.";
            desc = "Reserved.";
            sw = r; hw = w;
            reset = 0x0;
        } reserved_31_12[31:12];
        field {
            name = "wdqsphase";
            desc = "Write DQS clock phase select.";
            sw = rw; hw = r;
            reset = 0x0;
        } wdqsphase[11:8];
        field {
            name = "Reserved.";
            desc = "Reserved.";
            sw = r; hw = w;
            reset = 0x0;
        } reserved_7_5[7:5];
        field {
            name = "wdqsbdl";
            desc = "Write leveling DQS delay select. This field specifies the delay value of delay applied on WDQS for write leveling.";
            sw = rw; hw = r;
            reset = 0x0;
        } wdqsbdl[4:0];
    };
    DXNWDQSDLY_t DXNWDQSDLY_0 @ 0x230;
    DXNWDQSDLY_t DXNWDQSDLY_1 @ 0x2B0;
    DXNWDQSDLY_t DXNWDQSDLY_2 @ 0x330;
    DXNWDQSDLY_t DXNWDQSDLY_3 @ 0x3B0;
    reg DXNWDQDLY_t {
        name = "DXNWDQDLY";
        desc = "DXNWDQDLY is a write leveling delay line control register. (offset 0x234, 4 instances at stride 0x80; total reset 0x00000C00; PROVEN: Hi3521A/Hi3520D V300 data sheet (Issue 00B07, 2015-12-10), section 4.1.9.2, PDF page 935).";
        field {
            name = "Reserved.";
            desc = "Reserved.";
            sw = r; hw = w;
            reset = 0x0;
        } reserved_31_13[31:13];
        field {
            name = "wdqphase";
            desc = "Write data eye clock phase select.";
            sw = rw; hw = r;
            reset = 0xc;
        } wdqphase[12:8];
        field {
            name = "Reserved.";
            desc = "Reserved.";
            sw = r; hw = w;
            reset = 0x0;
        } reserved_7_0[7:0];
    };
    DXNWDQDLY_t DXNWDQDLY_0 @ 0x234;
    DXNWDQDLY_t DXNWDQDLY_1 @ 0x2B4;
    DXNWDQDLY_t DXNWDQDLY_2 @ 0x334;
    DXNWDQDLY_t DXNWDQDLY_3 @ 0x3B4;
    reg DXNWLSL_t {
        name = "DXNWLSL";
        desc = "DXNWLSL is an extra system latency addition control register. (offset 0x238, 4 instances at stride 0x80; total reset 0x00010000; PROVEN: Hi3521A/Hi3520D V300 data sheet (Issue 00B07, 2015-12-10), section 4.1.9.2, PDF page 936).";
        field {
            name = "Reserved.";
            desc = "Reserved.";
            sw = r; hw = w;
            reset = 0x0;
        } reserved_31_18[31:18];
        field {
            name = "wlsl";
            desc = "Write leveling system latency. This field is used to adjust the write latency after write leveling.";
            sw = rw; hw = r;
            reset = 0x1;
        } wlsl[17:16];
        field {
            name = "Reserved.";
            desc = "Reserved.";
            sw = r; hw = w;
            reset = 0x0;
        } reserved_15_0[15:0];
    };
    DXNWLSL_t DXNWLSL_0 @ 0x238;
    DXNWLSL_t DXNWLSL_1 @ 0x2B8;
    DXNWLSL_t DXNWLSL_2 @ 0x338;
    DXNWLSL_t DXNWLSL_3 @ 0x3B8;
    reg DXNRDQSGDLY_t {
        name = "DXNRDQSGDLY";
        desc = "DXNRDQSGDLY is a local delay line control register. (offset 0x23C + n x 0x80 + m x 0x400, n = 0-3, m = 0-1; total reset 0x00000010; PROVEN: Hi3521A/Hi3520D V300 data sheet (Issue 00B07, 2015-12-10), section 4.1.9.2, PDF pages 936-937). Instances DXNRDQSGDLY_n are m = 0, DXNRDQSGDLY_M1_n are m = 1. INFERRED: the m term is as printed in the data sheet; every other data block register has only the n term, so the m = 1 instances are UNVERIFIED.";
        field {
            name = "Reserved.";
            desc = "Reserved.";
            sw = r; hw = w;
            reset = 0x0;
        } reserved_31_30[31:30];
        field {
            name = "org_rdqsgph";
            desc = "Original read DQS gate phase before HW gate training post-update stage (for debugging).";
            sw = r; hw = w;
            reset = 0x0;
        } org_rdqsgph[29:24];
        field {
            name = "Reserved.";
            desc = "Reserved.";
            sw = r; hw = w;
            reset = 0x0;
        } reserved_23_21[23:21];
        field {
            name = "rdqsgtxbdl";
            desc = "Read DQS gate delay select. This field specifies the delay value of the read gating delay before DQS dummy PAD.";
            sw = rw; hw = r;
            reset = 0x0;
        } rdqsgtxbdl[20:16];
        field {
            name = "Reserved.";
            desc = "Reserved.";
            sw = r; hw = w;
            reset = 0x0;
        } reserved_15_14[15:14];
        field {
            name = "rdqsgphase";
            desc = "Read DQS gating clock phase select.";
            sw = rw; hw = r;
            reset = 0x0;
        } rdqsgphase[13:8];
        field {
            name = "Reserved.";
            desc = "Reserved.";
            sw = r; hw = w;
            reset = 0x0;
        } reserved_7_6[7:6];
        field {
            name = "rdqsgbdl";
            desc = "Read DQS gating delay select. This field specifies the delay value of the read gating delay after DQS dummy PAD.";
            sw = rw; hw = r;
            reset = 0x10;
        } rdqsgbdl[5:0];
    };
    DXNRDQSGDLY_t DXNRDQSGDLY_0 @ 0x23C;
    DXNRDQSGDLY_t DXNRDQSGDLY_1 @ 0x2BC;
    DXNRDQSGDLY_t DXNRDQSGDLY_2 @ 0x33C;
    DXNRDQSGDLY_t DXNRDQSGDLY_3 @ 0x3BC;
    DXNRDQSGDLY_t DXNRDQSGDLY_M1_0 @ 0x63C;
    DXNRDQSGDLY_t DXNRDQSGDLY_M1_1 @ 0x6BC;
    DXNRDQSGDLY_t DXNRDQSGDLY_M1_2 @ 0x73C;
    DXNRDQSGDLY_t DXNRDQSGDLY_M1_3 @ 0x7BC;
    reg DXPHYCTRL_t {
        name = "DXPHYCTRL";
        desc = "DXPHYCTRL is a DX PHY control register. (offset 0x240, 4 instances at stride 0x80; total reset 0x00000000; PROVEN: Hi3521A/Hi3520D V300 data sheet (Issue 00B07, 2015-12-10), section 4.1.9.2, PDF page 937).";
        field {
            name = "Reserved.";
            desc = "Reserved.";
            sw = r; hw = w;
            reset = 0x0;
        } reserved_31_15[31:15];
        field {
            name = "dx_pll_cal";
            desc = "The value 0x0 is recommended.";
            sw = rw; hw = r;
            reset = 0x0;
        } dx_pll_cal[14:14];
        field {
            name = "dx_pll_calm";
            desc = "The value 0x0 is recommended.";
            sw = rw; hw = r;
            reset = 0x0;
        } dx_pll_calm[13:13];
        field {
            name = "dx_pll_calt";
            desc = "The value 0x0 is recommended.";
            sw = rw; hw = r;
            reset = 0x0;
        } dx_pll_calt[12:12];
        field {
            name = "dx_pll_lt";
            desc = "The value 0x0 is recommended.";
            sw = rw; hw = r;
            reset = 0x0;
        } dx_pll_lt[11:10];
        field {
            name = "dx_pll_sp";
            desc = "The value 0x2 is recommended.";
            sw = rw; hw = r;
            reset = 0x0;
        } dx_pll_sp[9:7];
        field {
            name = "dx_pll_cpi";
            desc = "The value 0x4 is recommended.";
            sw = rw; hw = r;
            reset = 0x0;
        } dx_pll_cpi[6:4];
        field {
            name = "dx_pll_init";
            desc = "The value 0x0 is recommended.";
            sw = rw; hw = r;
            reset = 0x0;
        } dx_pll_init[3:3];
        field {
            name = "dx_pll_testen";
            desc = "The value 0x0 is recommended.";
            sw = rw; hw = r;
            reset = 0x0;
        } dx_pll_testen[2:2];
        field {
            name = "dx_pll_testpem";
            desc = "The value 0x0 is recommended.";
            sw = rw; hw = r;
            reset = 0x0;
        } dx_pll_testpem[1:1];
        field {
            name = "dx_pll_thrm";
            desc = "The value 0x0 is recommended.";
            sw = rw; hw = r;
            reset = 0x0;
        } dx_pll_thrm[0:0];
    };
    DXPHYCTRL_t DXPHYCTRL_0 @ 0x240;
    DXPHYCTRL_t DXPHYCTRL_1 @ 0x2C0;
    DXPHYCTRL_t DXPHYCTRL_2 @ 0x340;
    DXPHYCTRL_t DXPHYCTRL_3 @ 0x3C0;
    reg DXNGDS_t {
        name = "DXNGDS";
        desc = "DXNGDS is a latch enable register. It is used to control the latch enable within the PHY to obtain stable data. (offset 0x248, 4 instances at stride 0x80; total reset 0x00000000; PROVEN: Hi3521A/Hi3520D V300 data sheet (Issue 00B07, 2015-12-10), section 4.1.9.2, PDF page 938).";
        field {
            name = "Reserved.";
            desc = "Reserved.";
            sw = r; hw = w;
            reset = 0x0;
        } reserved_31_3[31:3];
        field {
            name = "gds";
            desc = "Rank 0 read data latch delay. This field is used as a reference stable region for the PHY to latch the read data.";
            sw = rw; hw = r;
            reset = 0x0;
        } gds[2:0];
    };
    DXNGDS_t DXNGDS_0 @ 0x248;
    DXNGDS_t DXNGDS_1 @ 0x2C8;
    DXNGDS_t DXNGDS_2 @ 0x348;
    DXNGDS_t DXNGDS_3 @ 0x3C8;
    reg DXNCLKBDL_t {
        name = "DXNCLKBDL";
        desc = "DXNCLKBDL is a data block clock bit delay line configuration register. (offset 0x24C, 4 instances at stride 0x80; total reset 0x00000000; PROVEN: Hi3521A/Hi3520D V300 data sheet (Issue 00B07, 2015-12-10), section 4.1.9.2, PDF page 938).";
        field {
            name = "Reserved.";
            desc = "Reserved.";
            sw = r; hw = w;
            reset = 0x0;
        } reserved_31_21[31:21];
        field {
            name = "dx_refclk_bdl";
            desc = "Bit delay line of REFCLK.";
            sw = rw; hw = r;
            reset = 0x0;
        } dx_refclk_bdl[20:16];
        field {
            name = "Reserved.";
            desc = "Reserved.";
            sw = r; hw = w;
            reset = 0x0;
        } reserved_15_5[15:5];
        field {
            name = "dx_fbclk_bdl";
            desc = "Bit delay line of FBCLK.";
            sw = rw; hw = r;
            reset = 0x0;
        } dx_fbclk_bdl[4:0];
    };
    DXNCLKBDL_t DXNCLKBDL_0 @ 0x24C;
    DXNCLKBDL_t DXNCLKBDL_1 @ 0x2CC;
    DXNCLKBDL_t DXNCLKBDL_2 @ 0x34C;
    DXNCLKBDL_t DXNCLKBDL_3 @ 0x3CC;
    reg DXNRDBOUND_t {
        name = "DXNRDBOUND";
        desc = "DXNRDBOUND is a read data eye boundary register. This register indicates the left and right boundaries of RDQSQDL of the data eye. (offset 0x250, 4 instances at stride 0x80; total reset 0x00000000; PROVEN: Hi3521A/Hi3520D V300 data sheet (Issue 00B07, 2015-12-10), section 4.1.9.2, PDF page 939).";
        field {
            name = "Reserved.";
            desc = "Reserved.";
            sw = r; hw = w;
            reset = 0x0;
        } reserved_31_23[31:23];
        field {
            name = "rdqsbdl_left";
            desc = "Left boundary of read data eye.";
            sw = r; hw = w;
            reset = 0x0;
        } rdqsbdl_left[22:16];
        field {
            name = "Reserved.";
            desc = "Reserved.";
            sw = r; hw = w;
            reset = 0x0;
        } reserved_15_7[15:7];
        field {
            name = "rdqsbdl_right";
            desc = "Right boundary of read data eye.";
            sw = r; hw = w;
            reset = 0x0;
        } rdqsbdl_right[6:0];
    };
    DXNRDBOUND_t DXNRDBOUND_0 @ 0x250;
    DXNRDBOUND_t DXNRDBOUND_1 @ 0x2D0;
    DXNRDBOUND_t DXNRDBOUND_2 @ 0x350;
    DXNRDBOUND_t DXNRDBOUND_3 @ 0x3D0;
    reg DXNWRBOUND_t {
        name = "DXNWRBOUND";
        desc = "DXNWRBOUND is a write data eye boundary register. This register indicates the left and right boundaries of WDQSQDL of the data eye. (offset 0x254, 4 instances at stride 0x80; total reset 0x00000000; PROVEN: Hi3521A/Hi3520D V300 data sheet (Issue 00B07, 2015-12-10), section 4.1.9.2, PDF page 939).";
        field {
            name = "Reserved.";
            desc = "Reserved.";
            sw = r; hw = w;
            reset = 0x0;
        } reserved_31_21[31:21];
        field {
            name = "wdqphase_left";
            desc = "Left boundary of the write data eye.";
            sw = r; hw = w;
            reset = 0x0;
        } wdqphase_left[20:16];
        field {
            name = "Reserved.";
            desc = "Reserved.";
            sw = r; hw = w;
            reset = 0x0;
        } reserved_15_5[15:5];
        field {
            name = "wdqphase_right";
            desc = "Right boundary of the write data eye.";
            sw = r; hw = w;
            reset = 0x0;
        } wdqphase_right[4:0];
    };
    DXNWRBOUND_t DXNWRBOUND_0 @ 0x254;
    DXNWRBOUND_t DXNWRBOUND_1 @ 0x2D4;
    DXNWRBOUND_t DXNWRBOUND_2 @ 0x354;
    DXNWRBOUND_t DXNWRBOUND_3 @ 0x3D4;
    reg DXNOEBDL_t {
        name = "DXNOEBDL";
        desc = "DXNOEBDL is an output enable delay line control register. This register specifies the delay line value of the output enable delay line within the PHY data block. (offset 0x258, 4 instances at stride 0x80; total reset 0x00000000; PROVEN: Hi3521A/Hi3520D V300 data sheet (Issue 00B07, 2015-12-10), section 4.1.9.2, PDF page 940).";
        field {
            name = "Reserved.";
            desc = "Reserved.";
            sw = r; hw = w;
            reset = 0x0;
        } reserved_31_21[31:21];
        field {
            name = "wdqsoe_bdl";
            desc = "Write DQS output enable delay control.";
            sw = rw; hw = r;
            reset = 0x0;
        } wdqsoe_bdl[20:16];
        field {
            name = "Reserved.";
            desc = "Reserved.";
            sw = r; hw = w;
            reset = 0x0;
        } reserved_15_5[15:5];
        field {
            name = "oen_bdl";
            desc = "DQ output enable delay control.";
            sw = rw; hw = r;
            reset = 0x0;
        } oen_bdl[4:0];
    };
    DXNOEBDL_t DXNOEBDL_0 @ 0x258;
    DXNOEBDL_t DXNOEBDL_1 @ 0x2D8;
    DXNOEBDL_t DXNOEBDL_2 @ 0x358;
    DXNOEBDL_t DXNOEBDL_3 @ 0x3D8;
    reg DXNMISCCTRL0_t {
        name = "DXNMISCCTRL0";
        desc = "DXNMISCCTRL0 is data block PHY miscellaneous control register 0. This register is used to control the PHY and should not be modified. (offset 0x260, 4 instances at stride 0x80; total reset 0x00020000; PROVEN: Hi3521A/Hi3520D V300 data sheet (Issue 00B07, 2015-12-10), section 4.1.9.2, PDF page 940).";
        field {
            name = "Reserved.";
            desc = "Reserved.";
            sw = r; hw = w;
            reset = 0x0;
        } reserved_31_27[31:27];
        field {
            name = "ptrgated_en";
            desc = "Set this field to default value.";
            sw = rw; hw = r;
            reset = 0x0;
        } ptrgated_en[26:26];
        field {
            name = "enshift_a0";
            desc = "Set this field to default value.";
            sw = rw; hw = r;
            reset = 0x0;
        } enshift_a0[25:25];
        field {
            name = "margin_a0";
            desc = "After this field is modified, \"phyconn_rst\" is required to update the latest setting. If the dly_track_type=1 tracking type is required, this field should be set to 0x1 before initial trainings and dly_track_type should be set to 0x1 after initial trainings.";
            sw = rw; hw = r;
            reset = 0x0;
        } margin_a0[24:24];
        field {
            name = "bufphyclkdiv2";
            desc = "Set this field to default value.";
            sw = rw; hw = r;
            reset = 0x0;
        } bufphyclkdiv2[23:23];
        field {
            name = "lvdqclkdiv2";
            desc = "Set this field to default value.";
            sw = rw; hw = r;
            reset = 0x0;
        } lvdqclkdiv2[22:22];
        field {
            name = "dqsgatedla";
            desc = "Set this field to default value.";
            sw = rw; hw = r;
            reset = 0x0;
        } dqsgatedla[21:21];
        field {
            name = "dx_rxp_2nd_dm";
            desc = "After this field is modified, \"phyconn_rst\" is required to update the latest setting. If the dly_track_type=1 tracking type is required, this field should be set to 0x1 before initial trainings and dly_track_type should be set to 0x1 after initial trainings.";
            sw = rw; hw = r;
            reset = 0x0;
        } dx_rxp_2nd_dm[20:20];
        field {
            name = "dx_rxn_2nd_dm";
            desc = "After this field is modified, \"phyconn_rst\" is required to update the latest setting. If the dly_track_type=1 tracking type is required, this field should be set to 0x1 before initial trainings and dly_track_type should be set to 0x1 after initial trainings.";
            sw = rw; hw = r;
            reset = 0x0;
        } dx_rxn_2nd_dm[19:19];
        field {
            name = "dx_dqs_h";
            desc = "Set this field to default value.";
            sw = rw; hw = r;
            reset = 0x0;
        } dx_dqs_h[18:18];
        field {
            name = "dx_dqs_l";
            desc = "Set this field to default value.";
            sw = rw; hw = r;
            reset = 0x1;
        } dx_dqs_l[17:17];
        field {
            name = "dx_margin_a1";
            desc = "After this field is modified, \"phyconn_rst\" is required to update the latest setting. If the dly_track_type=1 tracking type is required, this field should be set to 0x1 before initial trainings and dly_track_type should be set to 0x1 after initial trainings.";
            sw = rw; hw = r;
            reset = 0x0;
        } dx_margin_a1[16:16];
        field {
            name = "rxp_2nd_dq";
            desc = "After this field is modified, \"phyconn_rst\" is required to update the latest setting. When the dly_track_type=1 tracking type is required, this field should be set to 0xFF before initial trainings and dly_track_type should be set to 0x1 after initial trainings.";
            sw = rw; hw = r;
            reset = 0x0;
        } rxp_2nd_dq[15:8];
        field {
            name = "rxn_2nd_dq";
            desc = "After this field is modified, \"phyconn_rst\" is required to update the latest setting. When the dly_track_type=1 tracking type is required, this field should be set to 0xFF before initial trainings and dly_track_type should be set to 0x1 after initial trainings.";
            sw = rw; hw = r;
            reset = 0x0;
        } rxn_2nd_dq[7:0];
    };
    DXNMISCCTRL0_t DXNMISCCTRL0_0 @ 0x260;
    DXNMISCCTRL0_t DXNMISCCTRL0_1 @ 0x2E0;
    DXNMISCCTRL0_t DXNMISCCTRL0_2 @ 0x360;
    DXNMISCCTRL0_t DXNMISCCTRL0_3 @ 0x3E0;
    reg DXNMISCCTRL1_t {
        name = "DXNMISCCTRL1";
        desc = "DXNMISCCTRL1 is data block PHY miscellaneous control register 1. This register is used to control the PHY and should not be modified. (offset 0x264, 4 instances at stride 0x80; total reset 0x00000000; PROVEN: Hi3521A/Hi3520D V300 data sheet (Issue 00B07, 2015-12-10), section 4.1.9.2, PDF page 942).";
        field {
            name = "dqclk1x";
            desc = "Set this field to default value.";
            sw = rw; hw = r;
            reset = 0x0;
        } dqclk1x[31:28];
        field {
            name = "dqclk2x";
            desc = "Set this field to default value.";
            sw = rw; hw = r;
            reset = 0x0;
        } dqclk2x[27:24];
        field {
            name = "dqsgclk1x";
            desc = "Set this field to default value.";
            sw = rw; hw = r;
            reset = 0x0;
        } dqsgclk1x[23:20];
        field {
            name = "dqsgclk2x";
            desc = "Set this field to default value.";
            sw = rw; hw = r;
            reset = 0x0;
        } dqsgclk2x[19:16];
        field {
            name = "dqsclk1x";
            desc = "Set this field to default value.";
            sw = rw; hw = r;
            reset = 0x0;
        } dqsclk1x[15:12];
        field {
            name = "dqsclk2x";
            desc = "Set this field to default value.";
            sw = rw; hw = r;
            reset = 0x0;
        } dqsclk2x[11:8];
        field {
            name = "mclk1x";
            desc = "Set this field to default value.";
            sw = rw; hw = r;
            reset = 0x0;
        } mclk1x[7:4];
        field {
            name = "mclk2x";
            desc = "Set this field to default value.";
            sw = rw; hw = r;
            reset = 0x0;
        } mclk2x[3:0];
    };
    DXNMISCCTRL1_t DXNMISCCTRL1_0 @ 0x264;
    DXNMISCCTRL1_t DXNMISCCTRL1_1 @ 0x2E4;
    DXNMISCCTRL1_t DXNMISCCTRL1_2 @ 0x364;
    DXNMISCCTRL1_t DXNMISCCTRL1_3 @ 0x3E4;
    reg DXDEBUG0_t {
        name = "DXDEBUG0";
        desc = "DXDEBUG0 is data block PHY debug signal register 0. (offset 0x268, 4 instances at stride 0x80; total reset 0x00005415; PROVEN: Hi3521A/Hi3520D V300 data sheet (Issue 00B07, 2015-12-10), section 4.1.9.2, PDF page 942).";
        field {
            name = "Reserved.";
            desc = "Debug signal.";
            sw = r; hw = w;
            reset = 0x0;
        } reserved_31_15[31:15];
        field {
            name = "s0a";
            desc = "Set this field to default value.";
            sw = r; hw = w;
            reset = 0x1;
        } s0a[14:14];
        field {
            name = "s0b";
            desc = "Set this field to default value.";
            sw = r; hw = w;
            reset = 0x0;
        } s0b[13:13];
        field {
            name = "s1a";
            desc = "Set this field to default value.";
            sw = r; hw = w;
            reset = 0x1;
        } s1a[12:12];
        field {
            name = "s1b";
            desc = "Reserved.";
            sw = r; hw = w;
            reset = 0x0;
        } s1b[11:11];
        field {
            name = "s2a";
            desc = "Reserved.";
            sw = r; hw = w;
            reset = 0x1;
        } s2a[10:10];
        field {
            name = "s2b";
            desc = "Reserved.";
            sw = r; hw = w;
            reset = 0x0;
        } s2b[9:9];
        field {
            name = "dqs_rdcnt";
            desc = "Reserved.";
            sw = r; hw = w;
            reset = 0x0;
        } dqs_rdcnt[8:6];
        field {
            name = "dqs_ca";
            desc = "Reserved.";
            sw = r; hw = w;
            reset = 0x2;
        } dqs_ca[5:3];
        field {
            name = "dqs_cb";
            desc = "Reserved.";
            sw = r; hw = w;
            reset = 0x5;
        } dqs_cb[2:0];
    };
    DXDEBUG0_t DXDEBUG0_0 @ 0x268;
    DXDEBUG0_t DXDEBUG0_1 @ 0x2E8;
    DXDEBUG0_t DXDEBUG0_2 @ 0x368;
    DXDEBUG0_t DXDEBUG0_3 @ 0x3E8;
    reg DXDEBUG1_t {
        name = "DXDEBUG1";
        desc = "DXDEBUG1 is data block PHY debug signal register 1. (offset 0x26C, 4 instances at stride 0x80; total reset 0x00000001; PROVEN: Hi3521A/Hi3520D V300 data sheet (Issue 00B07, 2015-12-10), section 4.1.9.2, PDF page 943). INFERRED: the dqs0 range [23:16] (printed as [23:0] in the data sheet, overlapping the next two fields); the total reset 0x1 puts the set bit in dqs0_gold.";
        field {
            name = "Reserved.";
            desc = "Debug signal. Note that the field may have unknown values in the simulation.";
            sw = r; hw = w;
            reset = 0x0;
        } reserved_31_24[31:24];
        field {
            name = "dqs0";
            desc = "Reserved. (INFERRED range: the data sheet prints [23:0], which overlaps dqs0b and dqs0_gold; [23:16] is the remaining bits.)";
            sw = r; hw = w;
            reset = 0x0;
        } dqs0[23:16];
        field {
            name = "dqs0b";
            desc = "Reserved.";
            sw = r; hw = w;
            reset = 0x0;
        } dqs0b[15:8];
        field {
            name = "dqs0_gold";
            desc = "Reserved.";
            sw = r; hw = w;
            reset = 0x1;
        } dqs0_gold[7:0];
    };
    DXDEBUG1_t DXDEBUG1_0 @ 0x26C;
    DXDEBUG1_t DXDEBUG1_1 @ 0x2EC;
    DXDEBUG1_t DXDEBUG1_2 @ 0x36C;
    DXDEBUG1_t DXDEBUG1_3 @ 0x3EC;
    reg DXPHYRSVD_t {
        name = "DXPHYRSVD";
        desc = "DXPHYRSVD is a data block PHY reserved control pin register. This register is used to control the PHY and should not be modified. (offset 0x270, 4 instances at stride 0x80; total reset 0x0000FF00; PROVEN: Hi3521A/Hi3520D V300 data sheet (Issue 00B07, 2015-12-10), section 4.1.9.2, PDF page 943).";
        field {
            name = "dx_rsv_status";
            desc = "Reserved.";
            sw = r; hw = w;
            reset = 0x0;
        } dx_rsv_status[31:16];
        field {
            name = "dx_rsv_control";
            desc = "Reserved. The followings are for (n = 0, 2): Bit 1 (reg_DQSG_extend_2T): 0/1: extend DQSG 1T/2T dfi_clk, when reg_DQSG_extend_en is 1 Bit 0 (reg_DQSG_extend_en): 0/1: disable/enable the DQSG extend function";
            sw = rw; hw = r;
            reset = 0xff00;
        } dx_rsv_control[15:0];
    };
    DXPHYRSVD_t DXPHYRSVD_0 @ 0x270;
    DXPHYRSVD_t DXPHYRSVD_1 @ 0x2F0;
    DXPHYRSVD_t DXPHYRSVD_2 @ 0x370;
    DXPHYRSVD_t DXPHYRSVD_3 @ 0x3F0;
    reg DXNMISCCTRL2_t {
        name = "DXNMISCCTRL2";
        desc = "DXNMISCCTRL2 is data block PHY miscellaneous control register 2. This register is used to control the PHY and should not be modified. (offset 0x274, 4 instances at stride 0x80; total reset 0x0000026F; PROVEN: Hi3521A/Hi3520D V300 data sheet (Issue 00B07, 2015-12-10), section 4.1.9.2, PDF page 944).";
        field {
            name = "Reserved.";
            desc = "Reserved.";
            sw = r; hw = w;
            reset = 0x0;
        } reserved_31_11[31:11];
        field {
            name = "reg_OE_extend1T_en";
            desc = "Set this field to default value.";
            sw = rw; hw = r;
            reset = 0x0;
        } reg_OE_extend1T_en[10:10];
        field {
            name = "reg_dqsg_TX_2path";
            desc = "Set this field to default value.";
            sw = rw; hw = r;
            reset = 0x1;
        } reg_dqsg_TX_2path[9:9];
        field {
            name = "reg_squeach_en";
            desc = "Set this field to default value.";
            sw = rw; hw = r;
            reset = 0x0;
        } reg_squeach_en[8:8];
        field {
            name = "reg_dqsglat1T_en";
            desc = "Set this field to default value.";
            sw = rw; hw = r;
            reset = 0x0;
        } reg_dqsglat1T_en[7:7];
        field {
            name = "reg_sel_halfT_gated_16b";
            desc = "Set this field to default value.";
            sw = rw; hw = r;
            reset = 0x1;
        } reg_sel_halfT_gated_16b[6:6];
        field {
            name = "reg_dynamic_PUPDEN_16b";
            desc = "Set this field to default value.";
            sw = rw; hw = r;
            reset = 0x1;
        } reg_dynamic_PUPDEN_16b[5:5];
        field {
            name = "reg_dummypad_use";
            desc = "Set this field to default value.";
            sw = rw; hw = r;
            reset = 0x0;
        } reg_dummypad_use[4:4];
        field {
            name = "reg_ODTEN_gated";
            desc = "Set this field to default value.";
            sw = rw; hw = r;
            reset = 0x1;
        } reg_ODTEN_gated[3:3];
        field {
            name = "reg_GDS_r1T_sel_16b";
            desc = "Set this field to default value.";
            sw = rw; hw = r;
            reset = 0x1;
        } reg_GDS_r1T_sel_16b[2:2];
        field {
            name = "BUFRESETCONTN_gated_TDC";
            desc = "Set this field to default value.";
            sw = rw; hw = r;
            reset = 0x1;
        } BUFRESETCONTN_gated_TDC[1:1];
        field {
            name = "BUFRESETCONTN_gated_DQSGERROR";
            desc = "Set this field to default value.";
            sw = rw; hw = r;
            reset = 0x1;
        } BUFRESETCONTN_gated_DQSGERROR[0:0];
    };
    DXNMISCCTRL2_t DXNMISCCTRL2_6 @ 0x274;
    DXNMISCCTRL2_t DXNMISCCTRL2_7 @ 0x2F4;
    DXNMISCCTRL2_t DXNMISCCTRL2_8 @ 0x374;
    DXNMISCCTRL2_t DXNMISCCTRL2_9 @ 0x3F4;
    reg DXDEBUGCONFIG_t {
        name = "DXDEBUGCONFIG";
        desc = "DXDEBUGCONFIG is a data block PHY debugging control register. This register is used to control the PHY and should not be modified. (offset 0x278, 4 instances at stride 0x80; total reset 0x00000000; PROVEN: Hi3521A/Hi3520D V300 data sheet (Issue 00B07, 2015-12-10), section 4.1.9.2, PDF page 945).";
        field {
            name = "Reserved.";
            desc = "Reserved.";
            sw = r; hw = w;
            reset = 0x0;
        } reserved_31_5[31:5];
        field {
            name = "DESKEW_regread";
            desc = "Reserved. registers for the future.";
            sw = r; hw = w;
            reset = 0x0;
        } DESKEW_regread[4:4];
        field {
            name = "reg_dbg_prepost_sel";
            desc = "Set this field to default value.";
            sw = rw; hw = r;
            reset = 0x0;
        } reg_dbg_prepost_sel[3:3];
        field {
            name = "reg_dbg_pllclk_sel";
            desc = "Set this field to default value.";
            sw = rw; hw = r;
            reset = 0x0;
        } reg_dbg_pllclk_sel[2:2];
        field {
            name = "reg_dbg_REFFB_predly";
            desc = "Set this field to default value.";
            sw = rw; hw = r;
            reset = 0x0;
        } reg_dbg_REFFB_predly[1:1];
        field {
            name = "reg_dbg_REFFB_postdly";
            desc = "Set this field to default value.";
            sw = rw; hw = r;
            reset = 0x0;
        } reg_dbg_REFFB_postdly[0:0];
    };
    DXDEBUGCONFIG_t DXDEBUGCONFIG_1 @ 0x278;
    DXDEBUGCONFIG_t DXDEBUGCONFIG_2 @ 0x2F8;
    DXDEBUGCONFIG_t DXDEBUGCONFIG_3 @ 0x378;
    DXDEBUGCONFIG_t DXDEBUGCONFIG_4 @ 0x3F8;
    reg DXNDCC_t {
        name = "DXNDCC";
        desc = "DXNDCC is a data block PHY DCC control register. This register is used to control the PHY and should not be modified. (offset 0x27C, 4 instances at stride 0x80; total reset 0x00000000; PROVEN: Hi3521A/Hi3520D V300 data sheet (Issue 00B07, 2015-12-10), section 4.1.9.2, PDF page 946).";
        field {
            name = "Reserved.";
            desc = "Reserved.";
            sw = r; hw = w;
            reset = 0x0;
        } reserved_31_12[31:12];
        field {
            name = "dxctl_mclk_dcc";
            desc = "bit[11]: dly_sel_xxx_DCC_16b bit[10]: ctrlC_xxx_DCC_16b bit[9]: ctrl2_xxx_DCC_16b";
            sw = rw; hw = r;
            reset = 0x0;
        } dxctl_mclk_dcc[11:9];
        field {
            name = "dxctl_dqs_dcc";
            desc = "bit[8]: dly_sel_xxx_DCC_16b bit[7]: ctrlC_xxx_DCC_16b bit[6]: ctrl2_xxx_DCC_16b";
            sw = rw; hw = r;
            reset = 0x0;
        } dxctl_dqs_dcc[8:6];
        field {
            name = "dxctl_dqsg_dcc";
            desc = "bit[5]: dly_sel_xxx_DCC_16b bit[4]: ctrlC_xxx_DCC_16b bit[3]: ctrl2_xxx_DCC_16b";
            sw = rw; hw = r;
            reset = 0x0;
        } dxctl_dqsg_dcc[5:3];
        field {
            name = "dxctl_dq_dcc";
            desc = "bit[2]: dly_sel_xxx_DCC_16b bit[1]: ctrlC_xxx_DCC_16b bit[0]: ctrl2_xxx_DCC_16b";
            sw = rw; hw = r;
            reset = 0x0;
        } dxctl_dq_dcc[2:0];
    };
    DXNDCC_t DXNDCC_0 @ 0x27C;
    DXNDCC_t DXNDCC_1 @ 0x2FC;
    DXNDCC_t DXNDCC_2 @ 0x37C;
    DXNDCC_t DXNDCC_3 @ 0x3FC;
};
`endif
