`include "hi3520dv300_includes.rdl"

addrmap hi3521av100 {
    name = "hi3521av100 registers";
    desc = "
        ## Status

        Hi3521A: same silicon family and register set as the Hi3520D V300 (this data sheet covers both): 32-bit DDR3 interface up to 1 GB, SATA 3.0, Cortex-A7 at 1.1 GHz. The register chapters do not mark per-chip differences, so both chips instantiate the same blocks.

        Built on 2026-11-14 from the HiSilicon Hi3521A/Hi3520D V300 H.264 CODEC Processor data sheet, Issue 00B07 (2015-12-10), by programmatic extraction (scripts/rdl-extract/dsextract.py + gen_rdl.py in the hi3520d-nvr workspace). Every register block marked modelled below is PROVEN against the data sheet tables (offsets, names, bit ranges, access types, reset values: exact; free-text descriptions taken from the cell text, spot-checked only). Blocks the data sheet has no register chapter for (SCD, DDRT, HDMI, AVC/VEDU, TDE, IVE, JPGD, JPGE, VGS, VPSS, OHCI register window) are not instantiated. The SP804 timers and PL061 GPIOs use the shared common blocks. Hardware not verified.

        ## Addresses

        | Start Address | End Address | Description | Evidence |
        |---------------|-------------|-------------|----------|
        | 0x00000000 | 0x03FFFFFF | Boot window: the boot address space (BOOTROM, NAND/SFC CS0) while the remap is active, on-chip RAM after SC_CTRL.remapclear | data sheet Table 1-2 |
        | 0x04000000 | 0x0400FFFF | BOOTROM (4 KB actually implemented) | Table 1-2 |
        | 0x04010000 | 0x0401FFFF | On-chip RAM (16 KB actually implemented) | Table 1-2 |
        | 0x10000000 | 0x1000FFFF | FMC registers (modelled: FMC) | Table 1-2, 4.x FMC |
        | 0x10030000 | 0x1003FFFF | USB 2.0 host OHCI (standard OHCI registers, not tabulated in the data sheet) | Table 1-2 |
        | 0x10040000 | 0x1004FFFF | USB 2.0 host EHCI, vendor control registers at +0x90 (modelled: USB_EHCI) | Table 1-2, Table 13-15 |
        | 0x10060000 | 0x1006FFFF | DMAC (modelled: DMAC) | Table 1-2, Table 3-14 |
        | 0x10070000 | 0x1007FFFF | CIPHER (modelled: CIPHER) | Table 1-2, Table 3-15 |
        | 0x10080000 | 0x1008FFFF | SCD (not modelled: no register chapter) | Table 1-2 |
        | 0x100A0000 | 0x100AFFFF | GSF gigabit Ethernet MAC (modelled: GSF) | Table 1-2, Table 5-3 |
        | 0x11010000 | 0x1101FFFF | SATA 3.0 (Hi3521A; 2.0 on the Hi3520D V300): AHCI global registers at +0x000, ports at +0x100 + n x 0x80 (modelled: SATA_AHCI, SATA_PORT) | Table 1-2, Tables 13-12, 13-13 |
        | 0x12000000 | 0x1203FFFF | Timer0/1, Timer2/3, Timer4/5, Timer6/7 (SP804, common block) | Table 1-2, Table 3-16 |
        | 0x12040000 | 0x1204FFFF | CRG (modelled: CRG) | Table 1-2, Table 3-6 |
        | 0x12050000 | 0x1205FFFF | System controller (modelled: SYS_CTRL); SC_SYSID 0x3521A100 | Table 1-2, Table 3-8 |
        | 0x12070000 | 0x1207FFFF | Watchdog (modelled: WDG) | Table 1-2, Table 3-17 |
        | 0x12080000 | 0x120AFFFF | UART0, UART1, UART2 (modelled: UART) | Table 1-2, Table 13-2 |
        | 0x120B0000 | 0x120BFFFF | RTC SPI interface (internal RTC register file modelled separately: RTC_INT, byte-wide, address space of the RTC chip) | Table 1-2, Tables 3-18, 3-19 |
        | 0x120C0000 | 0x120CFFFF | I2C (modelled: I2C) | Table 1-2, Table 13-1 |
        | 0x120D0000 | 0x120DFFFF | SSP/SPI (modelled: SPI) | Table 1-2, Table 13-4 |
        | 0x120E0000 | 0x120EFFFF | PMC (modelled: PMC) | Table 1-2, Table 3-20 |
        | 0x120F0000 | 0x120F7FFF | Pin multiplexing (modelled: PINMUX) | Table 1-2, Table 2-28 |
        | 0x120F0800 | 0x120FFFFF | Pin (pad) control (modelled: PADCTRL) | Table 1-2, Table 2-29 |
        | 0x12100000 | 0x12100FFF | DDRT0 (not modelled: no register chapter) | Table 1-2 |
        | 0x12110000 | 0x1211FFFF | DDRC: AXI 0x12110000, QoS buffer 0x12114000, AWADDR surveillance 0x12115000, DMC 0x12118000, DDR PHY 0x1211C000 | Table 1-2, Tables 4-5 to 4-12 |
        | 0x12120000 | 0x1212FFFF | Peripheral control registers (modelled: MISC_CTRL) | Table 1-2, Table 3-9 |
        | 0x12140000 | 0x1214FFFF | IR receiver (modelled: IR) | Table 1-2, Table 13-8 |
        | 0x12150000 | 0x1222FFFF | GPIO0-GPIO13 (PL061, 0x10000 apart, common block) | Table 1-2, Table 13-10 |
        | 0x13010000 | 0x1301FFFF | HDMI (not modelled: no register chapter) | Table 1-2 |
        | 0x13020000 | 0x1302FFFF | VDP (modelled: VDP) | Table 1-2, Table 10-6 |
        | 0x13040000 | 0x1304FFFF | AVC0 H.264 codec (not modelled: no register chapter) | Table 1-2 |
        | 0x13050000 | 0x1305FFFF | TDE (not modelled) | Table 1-2 |
        | 0x13060000 | 0x1306FFFF | IVE (not modelled) | Table 1-2 |
        | 0x13070000 | 0x1307FFFF | JPGD (not modelled) | Table 1-2 |
        | 0x13080000 | 0x1308FFFF | VGS (not modelled) | Table 1-2 |
        | 0x130C0000 | 0x130FFFFF | VICAP (modelled: VICAP) | Table 1-2, Table 10-5 |
        | 0x13100000 | 0x1310FFFF | AVC1 H.264 codec (not modelled) | Table 1-2 |
        | 0x13110000 | 0x1311FFFF | VPSS (not modelled) | Table 1-2 |
        | 0x13120000 | 0x1312FFFF | VOIE (modelled: VOIE) | Table 1-2, Table 11-1 |
        | 0x13130000 | 0x1313FFFF | JPGE (not modelled) | Table 1-2 |
        | 0x13140000 | 0x1314FFFF | AIAO (modelled: AIAO) | Table 1-2, Table 12-2 |
        | 0x13150000 | 0x1315FFFF | MDU motion detection (modelled: MDU) | Table 1-2, Table 8-1 |
        | 0x14000000 | 0x14FFFFFF | SFC NAND/NOR memory window (16 MB) | Table 1-2 |
        | 0x80000000 | 0xFFFFFFFF | DDR (2 GB address space; Hi3521A 32-bit bus up to 1 GB, Hi3520D V300 16-bit bus up to 512 MB) | Table 1-2, 1.2.14 |

        ## Interrupts (GIC interrupt IDs, data sheet Table 3-7)

        | Interrupt bit (GIC ID) | Source |
        |---|---|
        | 0-15 | SGI0-SGI15 |
        | 32 | WDG |
        | 33 | Timer0/Timer1 |
        | 34 | Timer2/Timer3 |
        | 35 | Timer4/Timer5 |
        | 36 | Timer6/Timer7 |
        | 37 | RTC |
        | 38 | UART0 |
        | 39 | UART1 |
        | 40 | UART2 |
        | 41 | IR |
        | 42 | DMA |
        | 43 | FMC |
        | 44 | I2C |
        | 45 | CIPHER |
        | 46 | SSP |
        | 47 | DDRT |
        | 48 | GMAC (GSF) |
        | 49 | SATA |
        | 50 | USB2_OHCI |
        | 51 | USB2_EHCI |
        | 60 | VICAP |
        | 61 | HDMI |
        | 62 | VDP0 |
        | 63 | AVC0 |
        | 64 | TDE |
        | 65 | IVE |
        | 66 | JPGD |
        | 67 | VGS |
        | 68 | AVC1 |
        | 69 | VPSS |
        | 70 | VOIE |
        | 71 | JPGE |
        | 72 | AIAO |
        | 73 | SCD |
        | 74 | VDP1 |
        | 75 | MDU |
        | 83 | SOFTWARE_INT |
        | 84 | A7_COMMTX |
        | 85 | A7_COMMRX |
        | 86 | A7_PMUIRQ |
        | 87 | A7_CTIIRQ |
        | 89 | GPIO0-GPIO4 (shared) |
        | 90 | GPIO5-GPIO9 (shared) |
        | 91 | GPIO10-GPIO13 (shared) |
        | 92 | DDRC_ERR_INT |
        | other | not connected (16-31, 52-59, 76-82, 88, 93-95) |

        <!-- overview:begin -->

        ### Diagrams

        ![Logic block diagram](assets/diagrams/hi3521av100-logic.svg)

        ![Register blocks by function](assets/diagrams/hi3521av100-blocks.svg)

        ![Clock tree](assets/diagrams/hi3521av100-clocks.svg)

        ![Boot flow](assets/diagrams/hi3521av100-boot.svg)

        ![Video pipeline](assets/diagrams/hi3521av100-video.svg)

        ![Interrupt topology](assets/diagrams/hi3521av100-irq.svg)

        ![Reset tree](assets/diagrams/hi3521av100-resets.svg)

        ![CRG register map](assets/diagrams/hi3521av100-crgmap.svg)

        ![bus clock domains](assets/diagrams/hi3521av100-bus.svg)

        ![IP edition per chip](assets/diagrams/hi3521av100-family.svg)

        ### Variants (data sheet chapter 1)

        One data sheet covers the Hi3521A and the Hi3520D V300: one address map, one set of register blocks. The chips differ as follows.

        | | Hi3521A | Hi3520D V300 |
        |---|---|---|
        | CPU | Cortex-A7, up to 1.1 GHz, NEON and FPU | Cortex-A7, up to 800 MHz, NEON and FPU |
        | Caches | 32 KB L1 I + 32 KB L1 D, 128 KB L2 | same |
        | DDR | one 32-bit DDR3/DDR3L controller, up to 800 MHz, up to 512 MB | one 16-bit DDR3/DDR3L controller, up to 800 MHz, up to 512 MB (brief data sheet) |
        | SATA | 2 x SATA 3.0 | 2 x SATA 2.0 |
        | H.264 | enc 4x1080p@30 + 4xCIF@30 + dec 1x1080p@30; dec 5x1080p@30 or 10x720p@30 | enc 4x720p@30 + 4xCIF@30 + dec 4x720p@30; dec 2x1080p@30 or 4x720p@30 |
        | Video input (VI) | four 8-bit or two 16-bit ports (up to 16xD1/960H, 16x720p, 8x1080p TDM) | two 8-bit or one 16-bit port (up to 8xD1/960H, 8x720p, 4x1080p TDM) |
        | Package | TFBGA, 19 x 19 mm, 0.8 mm pitch | Epad-LQFP256, 28 x 28 mm, 0.4 mm pitch |
        | Supplies | core 1.1 V, CPU 1.25 V, I/O 3.3 V, DDR 1.5 V; 3 W typical | core and CPU 1.15 V, I/O 3.3 V, DDR 1.5 V; 2.5 W typical |
        | Common | H.264 baseline/main/high decode L4.2 and encode L5.1, MJPEG/JPEG, IVE, HDMI 1.4 + VGA + CVBS (1080p@60), one HD and one SD graphics layer plus a 128x128 cursor, 3 unidirectional I2S/PCM, integrated audio codec, 1 gigabit Ethernet (RGMII/RMII/MII, TSO), 2 USB 2.0 host, 3 UART, 1 SPI (2 CS), IR, I2C, GPIO, SPI NOR/NAND (1/2/4 bit, 2 CS), 4 KB BOOTROM + 16 KB SRAM, AES/DES/3DES, RTC | |

        ### Boot (data sheet 1.3)

        * BOOTROM_SEL (pin MDCK) = 1: boot from the BOOTROM, which starts the serial download mechanism (HiTool); if the serial link times out the chip boots from the external SPI NAND/NOR flash.
        * BOOTROM_SEL = 0: boot from the external SPI NOR/NAND flash (SFC).

        ### Chip ID

        | Chip | System controller ID registers (0xEE0 .. 0xEEC) | Value read as SC_SYSID |
        |---|---|---|
        | hi3520dv300 | SYSID0..3 reset values from the RDL | 0x3521A100 |
        | hi3521av100 | SYSID0..3 reset values from the RDL | 0x3521A100 |

        The four 8-bit registers form the 32-bit chip ID (SYSID3 is the most significant byte). The values are the reset values of the register descriptions: one data sheet documents one ID for all chips it covers, so the chips of a shared data sheet are not distinguished here (the real value of each variant is not stated).

        ### Memory map notes (data sheet 1.3, Table 1-2)

        * 0x00000000-0x03FFFFFF (64 MB) is the boot window: it points to the boot address space (BOOTROM or the SFC NAND/NOR memory space) while the remap is active and to the on-chip RAM after SC_CTRL remapclear (the Hi3520D V100 data sheet words the same mechanism).
        * BOOTROM window 0x04000000 (4 KB implemented), on-chip RAM window 0x04010000 (16 KB implemented).
        * SFC NAND/NOR memory window 0x14000000-0x14FFFFFF (16 MB); FMC registers at 0x10000000.
        * DDR: 0x80000000-0xFFFFFFFF address space (2 GB); the Hi3521A 32-bit bus supports up to 1 GB, the Hi3520D V300 16-bit bus up to 512 MB (1.2.14).
        * Blocks without register chapter in the data sheet but with a memory-map entry: SCD 0x10080000, DDRT0 0x12100000, HDMI 0x13010000, AVC0/AVC1 H.264 codecs 0x13040000 / 0x13100000, TDE, IVE, JPGD, VGS, VPSS, JPGE (see the register-block table: these are not modelled).

        ### DMA request lines (data sheet 3.6, Table 3-10)

        One DMAC (PL080-style, register block DMAC at 0x10060000, interrupt 42): 4 channels, 2 AHB masters, 16 hardware request lines; each peripheral has a burst (DMACBREQ) and a single (DMACSREQ) request, selected per channel in DMAC_Cn_CONFIG src_periph / dest_periph. Memory has no request line (always ready).

        | Line | Peripheral | Line | Peripheral |
        |---|---|---|---|
        | 0 | UART0 RX | 8 | I2C RX |
        | 1 | UART0 TX | 9 | I2C TX |
        | 2 | UART1 RX | 10-15 | Reserved |
        | 3 | UART1 TX | | |
        | 4 | UART2 RX | | |
        | 5 | UART2 TX | | |
        | 6 | SSP RX | | |
        | 7 | SSP TX | | |

        Idle cycles are inserted after each bus operation on channels 2 and 3, so memory-to-memory transfers should use those two channels (data sheet recommendation).

        ### Pin multiplexing summary (PINMUX at 0x120F0000)

        Generated from the pin mux registers of this description (register offsets are relative to the block base; the function lists are the value-ordered choices of each register). Pads that repeat a pattern in consecutive registers are merged into one row.

        | Pads | Mux register (offset from 0x120F0000) | Function choices (value 0, 1, ...) |
        |---|---|---|
        | VI0_CLK | muxctrl_reg0 @0x000 | 0=GPIO5_7 / 1=VI0_CLK / 2=VI_ADC_REFCLK0 |
        | VI0_DAT7 ... VI0_DAT0 (8) | muxctrl_reg1 ... muxctrl_reg8 @0x004 ... 0x020 | 0=GPIO1_0 / 1=VI0_DAT7 (first pad; others the same pattern with the pad's own number) |
        | VI1_CLK | muxctrl_reg9 @0x024 | 0=GPIO10_6 / 1=VI1_CLK / 2=VI0_CLK |
        | VI1_DAT7 ... VI1_DAT0 (8) | muxctrl_reg10 ... muxctrl_reg17 @0x028 ... 0x044 | 0=GPIO2_0 / 1=VI1_DAT7 (first pad; others the same pattern with the pad's own number) |
        | VI_ADC_REFCLK0 | muxctrl_reg18 @0x048 | 0=GPIO6_0 / 1=VI_ADC_REFCLK0 / 2=VI1_CLK |
        | VI2_CLK | muxctrl_reg19 @0x04C | 0=GPIO11_7 / 1=VI2_CLK / 2=VI_ADC_REFCLK1 |
        | VI2_DAT7 ... VI2_DAT0 (8) | muxctrl_reg20 ... muxctrl_reg27 @0x050 ... 0x06C | 0=GPIO3_0 / 1=VI2_DAT7 (first pad; others the same pattern with the pad's own number) |
        | VI3_CLK | muxctrl_reg28 @0x070 | 0=GPIO10_5 / 1=VI3_CLK / 2=VI2_CLK |
        | VI3_DAT7 ... VI3_DAT0 (8) | muxctrl_reg29 ... muxctrl_reg36 @0x074 ... 0x090 | 0=GPIO4_0 / 1=VI3_DAT7 (first pad; others the same pattern with the pad's own number) |
        | VI_ADC_REFCLK1 | muxctrl_reg37 @0x094 | 0=GPIO6_1 / 1=VI_ADC_REFCLK1 / 2=VI3_CLK |
        | VGA_HS | muxctrl_reg38 @0x098 | 0=GPIO11_6 / 1=VGA_HS |
        | VGA_VS | muxctrl_reg39 @0x09C | 0=GPIO11_3 / 1=VGA_VS |
        | I2S0_BCLK_RX | muxctrl_reg40 @0x0A0 | 0=GPIO9_0 / 1=I2S0_BCLK_RX |
        | I2S0_WS_RX | muxctrl_reg41 @0x0A4 | 0=GPIO9_1 / 1=I2S0_WS_RX |
        | I2S0_SD_RX | muxctrl_reg42 @0x0A8 | 0=GPIO9_2 / 1=I2S0_SD_RX |
        | I2S1_BCLK_RX | muxctrl_reg43 @0x0AC | 0=GPIO9_3 / 1=I2S1_BCLK_RX / 2=I2S2_MCLK |
        | I2S1_WS_RX | muxctrl_reg44 @0x0B0 | 0=GPIO9_4 / 1=I2S1_WS_RX |
        | I2S1_SD_RX | muxctrl_reg45 @0x0B4 | 0=GPIO9_5 / 1=I2S1_SD_RX |
        | I2S2_BCLK_TX | muxctrl_reg46 @0x0B8 | 0=GPIO9_6 / 1=I2S2_BCLK_TX |
        | I2S2_WS_TX | muxctrl_reg47 @0x0BC | 0=GPIO9_7 / 1=I2S2_WS_TX |
        | I2S2_SD_TX | muxctrl_reg48 @0x0C0 | 0=GPIO5_4 / 1=I2S2_SD_TX |
        | SPI_SCLK | muxctrl_reg49 @0x0C4 | 0=TEST_CLK / 1=SPI_SCLK / 2=GPIO5_0 |
        | SPI_SDO | muxctrl_reg50 @0x0C8 | 0=GPIO5_1 / 1=SPI_SDO |
        | SPI_SDI | muxctrl_reg51 @0x0CC | 0=GPIO5_2 / 1=SPI_SDI |
        | SPI_CSN0 ... SPI_CSN1 (2) | muxctrl_reg52 ... muxctrl_reg53 @0x0D0 ... 0x0D4 | 0=GPIO5_3 / 1=SPI_CSN0 (first pad; others the same pattern with the pad's own number) |
        | PWM_OUT0 ... PWM_OUT1 (2) | muxctrl_reg54 ... muxctrl_reg55 @0x0D8 ... 0x0DC | 0=PWM_OUT0 / 1=GPIO5_5 (first pad; others the same pattern with the pad's own number) |
        | I2C_SDA | muxctrl_reg56 @0x0E0 | 0=GPIO12_6 / 1=I2C_SDA |
        | I2C_SCL | muxctrl_reg57 @0x0E4 | 0=GPIO12_7 / 1=I2C_SCL |
        | UART0_RXD | muxctrl_reg58 @0x0E8 | 0=UART0_RXD / 1=GPIO10_7 |
        | UART0_TXD | muxctrl_reg59 @0x0EC | 0=UART0_TXD / 1=GPIO12_5 |
        | UART0_CTSN | muxctrl_reg60 @0x0F0 | 0=UART0_CTSN / 1=GPIO6_2 |
        | UART0_RTSN | muxctrl_reg61 @0x0F4 | 0=UART0_RTSN / 1=GPIO6_3 |
        | UART1_RXD | muxctrl_reg62 @0x0F8 | 0=GPIO6_5 / 1=UART1_RXD |
        | UART1_TXD | muxctrl_reg63 @0x0FC | 0=GPIO6_7 / 1=UART1_TXD |
        | UART2_RXD | muxctrl_reg64 @0x100 | 0=GPIO11_4 / 1=UART2_RXD |
        | UART2_TXD | muxctrl_reg65 @0x104 | 0=GPIO11_5 / 1=UART2_TXD |
        | RGMII_RXDV | muxctrl_reg66 @0x108 | 0=GPIO7_0 / 1=RGMII_RXDV |
        | RGMII_RXD3 ... RGMII_RXD0 (4) | muxctrl_reg67 ... muxctrl_reg70 @0x10C ... 0x118 | 0=GPIO7_1 / 1=RGMII_RXD3 (first pad; others the same pattern with the pad's own number) |
        | RGMII_RXCK | muxctrl_reg71 @0x11C | 0=GPIO7_5 / 1=RGMII_RXCK |
        | RGMII_TXEN | muxctrl_reg72 @0x120 | 0=GPIO7_6 / 1=RGMII_TXEN |
        | RGMII_TXD3 ... RGMII_TXD0 (4) | muxctrl_reg73 ... muxctrl_reg76 @0x124 ... 0x130 | 0=GPIO7_7 / 1=RGMII_TXD3 (first pad; others the same pattern with the pad's own number) |
        | RGMII_TXCKOUT | muxctrl_reg77 @0x134 | 0=GPIO8_3 / 1=RGMII_TXCKOUT / 2=MII_TXCK / 3=RMII_CLK |
        | RGMII_CRS | muxctrl_reg78 @0x138 | 0=GPIO8_4 / 1=RGMII_CRS |
        | RGMII_COL | muxctrl_reg79 @0x13C | 0=GPIO8_5 / 1=RGMII_COL |
        | RGMII_RXER | muxctrl_reg80 @0x140 | 0=GPIO8_6 / 1=RGMII_RXER |
        | EPHY_CLK | muxctrl_reg81 @0x144 | 0=GPIO6_6 / 1=EPHY_CLK |
        | EPHY_RSTN | muxctrl_reg82 @0x148 | 0=GPIO6_4 / 1=EPHY_RSTN |
        | MDCK | muxctrl_reg83 @0x14C | 0=GPIO10_0 / 1=MDCK / 2=BOOTROM_SEL |
        | MDIO | muxctrl_reg84 @0x150 | 0=GPIO10_1 / 1=MDIO |
        | IR_IN | muxctrl_reg85 @0x154 | 0=GPIO10_2 / 1=IR_IN |
        | SFC_DIO | muxctrl_reg86 @0x158 | 0=SFC_DIO / 1=GPIO11_0 |
        | SFC_WP_IO2 | muxctrl_reg87 @0x15C | 0=SFC_WP_IO2 / 1=GPIO11_1 |
        | SFC_DOI | muxctrl_reg88 @0x160 | 0=SFC_DOI / 1=GPIO11_2 |
        | USB2_OVRCUR0 | muxctrl_reg89 @0x164 | 0=GPIO13_0 / 1=USB2_OVRCUR0 |
        | USB2_PWREN0 | muxctrl_reg90 @0x168 | 0=GPIO13_1 / 1=USB2_PWREN0 |
        | USB2_OVRCUR1 | muxctrl_reg91 @0x16C | 0=GPIO13_2 / 1=USB2_OVRCUR1 |
        | USB2_PWREN1 | muxctrl_reg92 @0x170 | 0=GPIO13_3 / 1=USB2_PWREN1 |
        | HDMI_HOTPLUG | muxctrl_reg93 @0x174 | 0=GPIO13_4 / 1=HDMI_HOTPLUG |
        | HDMI_CEC | muxctrl_reg94 @0x178 | 0=GPIO13_5 / 1=HDMI_CEC |
        | HDMI_SDA | muxctrl_reg95 @0x17C | 0=GPIO13_6 / 1=HDMI_SDA |
        | HDMI_SCL | muxctrl_reg96 @0x180 | 0=GPIO13_7 / 1=HDMI_SCL |
        | SATA_LED_N0 ... SATA_LED_N1 (2) | muxctrl_reg97 ... muxctrl_reg98 @0x184 ... 0x188 | 0=GPIO10_3 / 1=SATA_LED_N0 (first pad; others the same pattern with the pad's own number) |

        Pad drive-strength and pull controls are in the separate pad control registers of the same description (not repeated here).

        ### Power, reset and clock modes (data sheet 3.1, 3.2)

        * Resets: hard reset npor from the RSTN pin or the internal POR modules (POR_CORE / POR_IP, selected by POR_SEL; the low pulse must last more than 130 ms, XIN stable); global soft reset sys_rst_n (system controller, level-1 reset control; at least 130 system clock cycles); per-module soft resets xx_rst_n (CRG PERI_CRG registers, level-2 reset control), not released automatically. Diagram: reset tree.
        * A7/DDR/bus clocks start from the 24 MHz crystal; a PLL may be reprogrammed only while the system runs from the crystal; stable 0.1 ms after the change; the lock bits are in PERI_CRG34[4:0] (data sheet 3.2.5, as printed; INFERRED to be the PLL status register of this chip).
        * Spread spectrum control per PLL: VPLL0 PERI_CRG37, VPLL2 PERI_CRG38, APLL PERI_CRG39, EPLL PERI_CRG40, DPLL PERI_CRG46 (bits 11:0 ssmod_cfg).
        * Several modules use a skip-cycle clock divider (clkskipcfg 5 bits + clkloaden load strobe): VEDU0 PERI_CRG15, VEDU1 PERI_CRG16, VPSS PERI_CRG17, TDE PERI_CRG18, VGS PERI_CRG19, JPGE/VOIE PERI_CRG20, JPGD PERI_CRG21, MDU PERI_CRG22.
        * The data sheet has no separate power-domain table or low-power chapter text in the range read for this note; PMC (0x120E0000) is the power-management register block (modelled).

        ### Clock-gate and reset map (generated from the CRG registers)

        | Offset | Register | Description | Gate / reset fields |
        |---|---|---|---|
        | 0x028 | PERI_CRG10 | PERI_CRG10 | pclkdbg_cken, arm_core_srst_req, arm_dbg_srst_req, etm_srst_req, l2_srst_req, socdbg_srst_req, cs_srst_req |
        | 0x02C | PERI_CRG11 | PERI_CRG11 | vi0_cken, vi0_srst_req, vi1_cken, vi1_srst_req, vi2_cken, vi2_srst_req, vi3_cken, vi3_srst_req, vi_ppc_srst_req, vi_bus_srst_req, ... |
        | 0x030 | PERI_CRG12 | PERI_CRG12 | vo_srst_req, vo_cken, vo_hd_cken, vo_sd_cken, vo_pcken, vo_acken, vo_dac_cken, vo_sd_dac_cken, vo_hd_dac_cken |
        | 0x034 | PERI_CRG13 | PERI_CRG13 | ddr_apb_cken, ddr_hipack_cken, ddr_cfg_cken, ddr_apb_srst_req, ddr_hipack_srst_req |
        | 0x038 | PERI_CRG14 | PERI_CRG14 | hdmitx_ctrl_bus_cken, hdmitx_ctrl_cec_cken, hdmitx_ctrl_id_cken, hdmitx_ctrl_mhl_cken, hdmitx_ctrl_os_cken, hdmitx_ctrl_as_cken, hdmitx_ctrl_bus_srst_req, hdmitx_ctrl_srst_req |
        | 0x03C | PERI_CRG15 | PERI_CRG15 | vedu0_srst_req, vedu0_cken, sed0_srst_req, sed0_cken |
        | 0x040 | PERI_CRG16 | PERI_CRG16 | vedu1_srst_req, vedu1_cken, sed1_srst_req, sed1_cken |
        | 0x044 | PERI_CRG17 | PERI_CRG17 | vps_srst_req, vps_cken |
        | 0x048 | PERI_CRG18 | PERI_CRG18 | tde_srst_req, tde_cken |
        | 0x04C | PERI_CRG19 | PERI_CRG19 | vgs_srst_req, vgs_cken |
        | 0x050 | PERI_CRG20 | PERI_CRG20 | jpge_srst_req, jpge_cken, voie_srst_req, voie_cken |
        | 0x054 | PERI_CRG21 | PERI_CRG21 | jpgd_srst_req, jpgd_cken |
        | 0x058 | PERI_CRG22 | PERI_CRG22 | mdu_srst_req, mdu_cken |
        | 0x05C | PERI_CRG23 | PERI_CRG23 | ive_srst_req, ive_cken |
        | 0x060 | PERI_CRG24 | PERI_CRG24 | cipher_srst_req, cipher_cken |
        | 0x064 | PERI_CRG25 | PERI_CRG25 | aio_srst_req, aiao_cken |
        | 0x068 | PERI_CRG26 | PERI_CRG26 | sata_phy0_ref_cken, sata_phy1_ref_cken |
        | 0x06C | PERI_CRG27 | PERI_CRG27 | sata_bus_cken, sata_rx0_cken, sata_rx1_cken, sata_cko_alive_cken, sata_mpll_dword0_cken, sata_refclk0_cken, sata_bus_srst_req, sata_cko_alive_srst_req, sata_mpll_dword1_cken, sata_refclk1_cken |
        | 0x070 | PERI_CRG28 | PERI_CRG28 | usb2_ahb_srst_req, usb2_cken |
        | 0x074 | PERI_CRG29 | PERI_CRG29 | fmc_srst_req, fmc_cken |
        | 0x078 | PERI_CRG30 | PERI_CRG30 | gsf_srst_req, gsf_cken, gmac_if_srst_req, gmac_if_cken, ext_fephy_srst_req |
        | 0x07C | PERI_CRG31 | PERI_CRG31 | scd_srst_req, scd_cken |
        | 0x080 | PERI_CRG32 | PERI_CRG32 | ddrtest_srst_req, ddrtest_cken, dma_srst_req, dma_cken |
        | 0x084 | PERI_CRG33 | PERI_CRG33 | test_clk_en, i2c_srst_req, rtc_srst_req, ir_srst_req, ssp_srst_req, uart0_srst_req, uart1_srst_req, uart2_srst_req, ir_cken, ssp_cken, ... |
        | 0x0A4 | PERI_CRG41 | PERI_CRG41 | dll0_slave_en |
        | 0x0A8 | PERI_CRG42 | PERI_CRG42 | dll1_slave_en |
        | 0x0AC | PERI_CRG43 | PERI_CRG43 | dll2_slave_en |
        | 0x0B0 | PERI_CRG44 | PERI_CRG44 | dll3_slave_en |
        | 0x0B4 | PERI_CRG45 | PERI_CRG45 | adc_ref0_cken, adc_ref1_cken |

        Only fields whose names contain a clock-enable or reset keyword are listed; the field descriptions in the register pages give the polarity and the clocks they gate.

        ### Register blocks (generated from this description)

        | Base | Instance | Block | Register space |
        |---|---|---|---|
        | 0x10000000 | FMC | Flash memory controller (FMC) | 224 B |
        | 0x10040000 | USB_EHCI | USB 2.0 host control registers | 176 B |
        | 0x10060000 | DMAC | DMAC | 372 B |
        | 0x10070000 | CIPHER | CIPHER | 5140 B |
        | 0x100A0000 | GSF | Gigabit Ethernet MAC (GSF) | 2596 B |
        | 0x11010000 | SATA_AHCI | SATA AHCI global and vendor registers | 236 B |
        | 0x11010100 | SATA_PORT | SATA port configuration registers | 256 B |
        | 0x12000000 | TIMER0 | Timer Registers | 28 B |
        | 0x12000020 | TIMER1 | Timer Registers | 28 B |
        | 0x12010000 | TIMER2 | Timer Registers | 28 B |
        | 0x12010020 | TIMER3 | Timer Registers | 28 B |
        | 0x12020000 | TIMER4 | Timer Registers | 28 B |
        | 0x12020020 | TIMER5 | Timer Registers | 28 B |
        | 0x12030000 | TIMER6 | Timer Registers | 28 B |
        | 0x12030020 | TIMER7 | Timer Registers | 28 B |
        | 0x12040000 | CRG | Clock and reset generator (CRG) | 188 B |
        | 0x12050000 | SYS_CTRL | System controller (SC) | 3824 B |
        | 0x12070000 | WDG | Watchdog (SP805) | 3076 B |
        | 0x12080000 | UART0 | UART (PL011) | 76 B |
        | 0x12090000 | UART1 | UART (PL011) | 76 B |
        | 0x120A0000 | UART2 | UART (PL011) | 76 B |
        | 0x120B0000 | RTC | RTC SPI interface | 8 B |
        | 0x120B0100 | RTC_INT | Internal RTC register file (device addresses reached through the RTC SPI interface, NOT memory mapped; the instance base 0x120B0100 in the SoC map is a placeholder) | 91 B |
        | 0x120C0000 | I2C | I2C | 196 B |
        | 0x120D0000 | SPI | SPI (SSP, PL022) | 48 B |
        | 0x120E0000 | PMC | Power management controller (PMC) | 288 B |
        | 0x120F0000 | PINMUX | Pin multiplexing control registers | 396 B |
        | 0x120F0800 | PADCTRL | Pad (pin drive capability) control registers | 488 B |
        | 0x12110000 | DDRC_AXI | DDRC AXI interface | 1556 B |
        | 0x12114000 | DDRC_QOSB | DDRC QoS buffer | 508 B |
        | 0x12115000 | DDRC_AWADDR | DDRC AWADDR surveillance | 516 B |
        | 0x12118000 | DDRC_DMC | DDRC DMC | 1208 B |
        | 0x1211C000 | DDRC_PHY | DDR PHY | 1984 B |
        | 0x12120000 | MISC_CTRL | Peripheral control registers (MISC_CTRL) | 152 B |
        | 0x12140000 | IR | IR receiver | 56 B |
        | 0x12150000 | GPIO0 | ARM PL061 | 1053 B |
        | 0x12160000 | GPIO1 | ARM PL061 | 1053 B |
        | 0x12170000 | GPIO2 | ARM PL061 | 1053 B |
        | 0x12180000 | GPIO3 | ARM PL061 | 1053 B |
        | 0x12190000 | GPIO4 | ARM PL061 | 1053 B |
        | 0x121A0000 | GPIO5 | ARM PL061 | 1053 B |
        | 0x121B0000 | GPIO6 | ARM PL061 | 1053 B |
        | 0x121C0000 | GPIO7 | ARM PL061 | 1053 B |
        | 0x121D0000 | GPIO8 | ARM PL061 | 1053 B |
        | 0x121E0000 | GPIO9 | ARM PL061 | 1053 B |
        | 0x121F0000 | GPIO10 | ARM PL061 | 1053 B |
        | 0x12200000 | GPIO11 | ARM PL061 | 1053 B |
        | 0x12210000 | GPIO12 | ARM PL061 | 1053 B |
        | 0x12220000 | GPIO13 | ARM PL061 | 1053 B |
        | 0x13020000 | VDP | Video display processor (VDP) | 62192 B |
        | 0x130C0000 | VICAP | Video capture (VICAP) | 68616 B |
        | 0x13120000 | VOIE | Video output image enhancement (VOIE) | 136 B |
        | 0x13140000 | AIAO | Audio input/output (AIAO) | 8624 B |
        | 0x13150000 | MDU | Motion detection unit (MDU) | 188 B |

        The table is generated from the elaborated root (instances at their absolute addresses; register space is the span of the block's registers, not the data sheet window).

        <!-- overview:end -->
    ";

    eHI3520DV300_FMC          FMC          @ 0x10000000;
    eHI3520DV300_USB2         USB_EHCI     @ 0x10040000;
    eHI3520DV300_DMAC         DMAC         @ 0x10060000;
    eHI3520DV300_CIPHER       CIPHER       @ 0x10070000;
    eHI3520DV300_GSF          GSF          @ 0x100A0000;
    eHI3520DV300_SATA_AHCI    SATA_AHCI    @ 0x11010000;
    eHI3520DV300_SATA_PORT    SATA_PORT    @ 0x11010100;
    eHI3520DV300_CRG          CRG          @ 0x12040000;
    eHI3520DV300_SYS_CTRL     SYS_CTRL     @ 0x12050000;
    eHI3520DV300_WDG          WDG          @ 0x12070000;
    eHI3520DV300_UART         UART0        @ 0x12080000;
    eHI3520DV300_UART         UART1        @ 0x12090000;
    eHI3520DV300_UART         UART2        @ 0x120A0000;
    eHISI_RTC_SPI_IF          RTC          @ 0x120B0000;
    eHI3520DV300_RTC_INT      RTC_INT      @ 0x120B0100;
    eHI3520DV300_I2C          I2C          @ 0x120C0000;
    eHI3520DV300_SPI          SPI          @ 0x120D0000;
    eHI3520DV300_PMC          PMC          @ 0x120E0000;
    eHI3520DV300_PINMUX       PINMUX       @ 0x120F0000;
    eHI3520DV300_PADCTRL      PADCTRL      @ 0x120F0800;
    eHI3520DV300_DDRC_AXI     DDRC_AXI     @ 0x12110000;
    eHI3520DV300_DDRC_QOSB    DDRC_QOSB    @ 0x12114000;
    eHI3520DV300_DDRC_AWADDR  DDRC_AWADDR  @ 0x12115000;
    eHI3520DV300_DDRC_DMC     DDRC_DMC     @ 0x12118000;
    eHI3520DV300_DDRC_PHY     DDRC_PHY     @ 0x1211C000;
    eHI3520DV300_MISC_CTRL    MISC_CTRL    @ 0x12120000;
    eHI3520DV300_IR           IR           @ 0x12140000;
    eHI3520DV300_VDP          VDP          @ 0x13020000;
    eHI3520DV300_VICAP        VICAP        @ 0x130C0000;
    eHI3520DV300_VOIE         VOIE         @ 0x13120000;
    eHI3520DV300_AIAO         AIAO         @ 0x13140000;
    eHI3520DV300_MDU          MDU          @ 0x13150000;
    eHISI_TIMER_SP804    TIMER0       @ 0x12000000;
    eHISI_TIMER_SP804    TIMER1       @ 0x12000020;
    eHISI_TIMER_SP804    TIMER2       @ 0x12010000;
    eHISI_TIMER_SP804    TIMER3       @ 0x12010020;
    eHISI_TIMER_SP804    TIMER4       @ 0x12020000;
    eHISI_TIMER_SP804    TIMER5       @ 0x12020020;
    eHISI_TIMER_SP804    TIMER6       @ 0x12030000;
    eHISI_TIMER_SP804    TIMER7       @ 0x12030020;
    eARM_PL061           GPIO0        @ 0x12150000;
    eARM_PL061           GPIO1        @ 0x12160000;
    eARM_PL061           GPIO2        @ 0x12170000;
    eARM_PL061           GPIO3        @ 0x12180000;
    eARM_PL061           GPIO4        @ 0x12190000;
    eARM_PL061           GPIO5        @ 0x121A0000;
    eARM_PL061           GPIO6        @ 0x121B0000;
    eARM_PL061           GPIO7        @ 0x121C0000;
    eARM_PL061           GPIO8        @ 0x121D0000;
    eARM_PL061           GPIO9        @ 0x121E0000;
    eARM_PL061           GPIO10       @ 0x121F0000;
    eARM_PL061           GPIO11       @ 0x12200000;
    eARM_PL061           GPIO12       @ 0x12210000;
    eARM_PL061           GPIO13       @ 0x12220000;
};
