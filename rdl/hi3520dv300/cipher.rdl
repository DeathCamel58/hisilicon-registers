`ifndef HI3520DV300_CIPHER_RDL
`define HI3520DV300_CIPHER_RDL
regfile eHI3520DV300_CIPHER {
    name = "CIPHER";
    desc = "CIPHER of the Hi3521A/Hi3520D V300 at base 0x1007_0000. 25 registers extracted programmatically from the Hi3521A/Hi3520D V300 data sheet (Issue 00B07, 2015-12-10) (Table 3-15 Summary of cipher registers (base address: 0x1007_0000)): register headings, offsets, total reset values, field bit ranges, access types, names, reset values and descriptions, with PDF page numbers in each register description. Field names, bit ranges, access types and offsets are exact; the free-text descriptions are taken from the cell text of the field table and were checked by sampling only. Hardware not verified.";
    reg CHAN0_CIPHER_DOUT_t {
        name = "CHAN0_CIPHER_DOUT";
        desc = "CHAN0_CIPHER_DOUT is a cipher output register for channel 0 (for single-block encryption/decryption). The data read from this register is the results of a single-block operation. The results of the AES algorithm are different from those of the DES or 3DES algorithm. The details are as follows: For the AES algorithm - If the 1-CFB mode is selected, the least significant bit (LSB) is valid, that is, CIPHER_DOUT bit[0] is valid. - If the 8-CFB mode is selected, lower eight bits are valid, that is, CIPHER_DOUT bit[7:0] is valid. - If the 128-CFB mode is selected, 128 bits are valid. - In other modes, 128 bits are valid. For the DES or 3DES algorithm - If the 1-CFB or 1-OFB mode is selected, the LSB is valid, that is, CIPHER_DOUT bit[0] is valid. - If the 8-CFB or 8-OFB mode is selected, lower eight bits are valid, that is, CIPHER_DOUT bit[7:0] is valid. - If the 64-CFB or 64-OFB mode is selected, lower 64 bits are valid, that is, CIPHER_DOUT bit[63:0] is valid. - In other modes, lower 64 bits are valid, that is, CIPHER_DOUT bit[63:0] is valid. (offset 0x0, 4 instances at stride 0x4; total reset 0x00000000; PROVEN: Hi3521A/Hi3520D V300 data sheet (Issue 00B07, 2015-12-10), section 3.7.5.2, PDF page 635).";
        field {
            name = "chan0_cipher_dout";
            desc = "128-bit block output of the cipher module. Each address maps to a 32-bit data segment. CIPHER_DOUT[31:0]: address 0x0000 CIPHER_DOUT[63:32]: address 0x0004 CIPHER_DOUT[95:64]: address 0x0008 CIPHER_DOUT[127:96]: address 0x000C";
            sw = r; hw = w;
            reset = 0x0;
        } chan0_cipher_dout[31:0];
    };
    CHAN0_CIPHER_DOUT_t CHAN0_CIPHER_DOUT_0 @ 0x0;
    CHAN0_CIPHER_DOUT_t CHAN0_CIPHER_DOUT_1 @ 0x4;
    CHAN0_CIPHER_DOUT_t CHAN0_CIPHER_DOUT_2 @ 0x8;
    CHAN0_CIPHER_DOUT_t CHAN0_CIPHER_DOUT_3 @ 0xC;
    reg CHAN0_CIPHER_IVOUT_t {
        name = "CHAN0_CIPHER_IVOUT";
        desc = "CHAN0_CIPHER_IVOUT is an operation complete IV output register of the cipher module. Note the following points when reading this register: This register can be ignored in ECB or CTR mode. If a single-block operation is performed, the data of this register is the vector output of the block. The data can be used as the vector input in the next block operation for the same data packet. - If the AES algorithm is selected, 128 bits are valid. - If the DES or 3DES algorithm is selected (CIPHER_CTRL[cipher_mode] = 0b00, 0b01, or 0b11), lower 64 bits are valid, that is, CIPHER_IVOUT bit[63:0] is valid. If a multi-block operation is performed, the data read from this register is the output vector of the last block operation. - If the AES algorithm is selected, 128 bits are valid. - If the DES or 3DES algorithm is selected, lower 64 bits are valid, that is, CIPHER_IVOUT bit[63:0] is valid. (offset 0x10, 4 instances at stride 0x4; total reset 0x00000000; PROVEN: Hi3521A/Hi3520D V300 data sheet (Issue 00B07, 2015-12-10), section 3.7.5.2, PDF page 636).";
        field {
            name = "chan0_cipher_ivout";
            desc = "Vector output after the operation of the cipher module is complete. It can be ignored in ECB or CTR mode. Each address maps to a 32-bit data segment. CIPHER_DOUT[31:0]: address 0x0010 CIPHER_IVOUT[63:32]: address 0x0014 CIPHER_IVOUT[95:64]: address 0x0018 CIPHER_IVOUT[127:96]: address 0x001C";
            sw = r; hw = w;
            reset = 0x0;
        } chan0_cipher_ivout[31:0];
    };
    CHAN0_CIPHER_IVOUT_t CHAN0_CIPHER_IVOUT_0 @ 0x10;
    CHAN0_CIPHER_IVOUT_t CHAN0_CIPHER_IVOUT_1 @ 0x14;
    CHAN0_CIPHER_IVOUT_t CHAN0_CIPHER_IVOUT_2 @ 0x18;
    CHAN0_CIPHER_IVOUT_t CHAN0_CIPHER_IVOUT_3 @ 0x1C;
    reg CHAN_CIPHER_IVOUT_t {
        name = "CHAN_CIPHER_IVOUT";
        desc = "CHAN_CIPHER_IVOUT is an IV output register for channels 1-7. (offset 0x20, 28 instances at stride 0x4; total reset 0x00000000; PROVEN: Hi3521A/Hi3520D V300 data sheet (Issue 00B07, 2015-12-10), section 3.7.5.2, PDF page 636).";
        field {
            name = "chan_cipher_ivout";
            desc = "0x0020-0x002C: channel 1 0x0030-0x003C: channel 2 0x0040-0x004C: channel 3 0x0050-0x005C: channel 4 0x0060-0x006C: channel 5 0x0070-0x007C: channel 6 0x0080-0x008C: channel 7";
            sw = r; hw = w;
            reset = 0x0;
        } chan_cipher_ivout[31:0];
    };
    CHAN_CIPHER_IVOUT_t CHAN_CIPHER_IVOUT_0 @ 0x20;
    CHAN_CIPHER_IVOUT_t CHAN_CIPHER_IVOUT_1 @ 0x24;
    CHAN_CIPHER_IVOUT_t CHAN_CIPHER_IVOUT_2 @ 0x28;
    CHAN_CIPHER_IVOUT_t CHAN_CIPHER_IVOUT_3 @ 0x2C;
    CHAN_CIPHER_IVOUT_t CHAN_CIPHER_IVOUT_4 @ 0x30;
    CHAN_CIPHER_IVOUT_t CHAN_CIPHER_IVOUT_5 @ 0x34;
    CHAN_CIPHER_IVOUT_t CHAN_CIPHER_IVOUT_6 @ 0x38;
    CHAN_CIPHER_IVOUT_t CHAN_CIPHER_IVOUT_7 @ 0x3C;
    CHAN_CIPHER_IVOUT_t CHAN_CIPHER_IVOUT_8 @ 0x40;
    CHAN_CIPHER_IVOUT_t CHAN_CIPHER_IVOUT_9 @ 0x44;
    CHAN_CIPHER_IVOUT_t CHAN_CIPHER_IVOUT_10 @ 0x48;
    CHAN_CIPHER_IVOUT_t CHAN_CIPHER_IVOUT_11 @ 0x4C;
    CHAN_CIPHER_IVOUT_t CHAN_CIPHER_IVOUT_12 @ 0x50;
    CHAN_CIPHER_IVOUT_t CHAN_CIPHER_IVOUT_13 @ 0x54;
    CHAN_CIPHER_IVOUT_t CHAN_CIPHER_IVOUT_14 @ 0x58;
    CHAN_CIPHER_IVOUT_t CHAN_CIPHER_IVOUT_15 @ 0x5C;
    CHAN_CIPHER_IVOUT_t CHAN_CIPHER_IVOUT_16 @ 0x60;
    CHAN_CIPHER_IVOUT_t CHAN_CIPHER_IVOUT_17 @ 0x64;
    CHAN_CIPHER_IVOUT_t CHAN_CIPHER_IVOUT_18 @ 0x68;
    CHAN_CIPHER_IVOUT_t CHAN_CIPHER_IVOUT_19 @ 0x6C;
    CHAN_CIPHER_IVOUT_t CHAN_CIPHER_IVOUT_20 @ 0x70;
    CHAN_CIPHER_IVOUT_t CHAN_CIPHER_IVOUT_21 @ 0x74;
    CHAN_CIPHER_IVOUT_t CHAN_CIPHER_IVOUT_22 @ 0x78;
    CHAN_CIPHER_IVOUT_t CHAN_CIPHER_IVOUT_23 @ 0x7C;
    CHAN_CIPHER_IVOUT_t CHAN_CIPHER_IVOUT_24 @ 0x80;
    CHAN_CIPHER_IVOUT_t CHAN_CIPHER_IVOUT_25 @ 0x84;
    CHAN_CIPHER_IVOUT_t CHAN_CIPHER_IVOUT_26 @ 0x88;
    CHAN_CIPHER_IVOUT_t CHAN_CIPHER_IVOUT_27 @ 0x8C;
    reg CIPHER_KEY_t {
        name = "CIPHER_KEY";
        desc = "CIPHER_KEY is a CPU configuration key register of the cipher module. The key is the configured value of the CPU, and the CPU can be read or written. Note the following points when configuring this register: If the DES algorithm is selected, lower 64 bits are valid, that is, CIPHER_KEY[63:0] is valid. For the 3DES algorithm If a 3-key operation is performed (CIPHER_CTRL[key_length] = 0b00, 0b01, or 0b10), low 192 bits are valid. where - CIPHER_KEY bit[63:0] indicates key 1. - CIPHER_KEY bit[127:64] indicates key 2. - CIPHER_KEY bit[191:128] indicates key 3. If a 2-key operation is selected (CIPHER_CTRL[key_length] = 0b11), lower 128 bits are valid. where - CIPHER_KEY bit[63:0] indicates key 1. - CIPHER_KEY bit[127:64] indicates key 2. For the AES algorithm - If a 128-bit key operation is performed, lower 128 bits are valid, that is, CIPHER_KEY bit[127:0] is valid. - If a 192-bit key operation is performed, lower 192 bits are valid, that is, CIPHER_KEY bit[191:0] is valid. - If a 256-bit key operation is performed, 256 bits are valid. The cipher module allows you to configure eight keys. Each channel can use one key, and multiple channels can share one key. (offset 0x90, 64 instances at stride 0x4; total reset 0x00000000; PROVEN: Hi3521A/Hi3520D V300 data sheet (Issue 00B07, 2015-12-10), section 3.7.5.2, PDF page 638).";
        field {
            name = "cipher_key";
            desc = "Key input of the cipher module. Each address maps to a 32-bit data segment. CIPHER_KEY[31:0]: address 0x0090 CIPHER_KEY[63:32]: address 0x0094 CIPHER_KEY[95:64]: address 0x0098 CIPHER_KEY[127:96]: address 0x009C CIPHER_KEY[159: 128]: address 0x00A0 CIPHER_KEY[191:160]: address 0x00A4 CIPHER_KEY[223:192]: address 0x00A8 CIPHER_KEY[255:224]: address 0x00AC 0x0090-0x00AC: host_key0 0x00B0-0x00CC: host_key1 0x00D0-0x00EC: host_key2 0x00F0-0x010C: host_key3 0x0110-0x012C: host_key4 0x0130-0x014C: host_key5 0x0150-0x016C: host_key6 0x0170-0x018C: host_key7";
            sw = w; hw = r;
            reset = 0x0;
        } cipher_key[31:0];
    };
    CIPHER_KEY_t CIPHER_KEY_0 @ 0x90;
    CIPHER_KEY_t CIPHER_KEY_1 @ 0x94;
    CIPHER_KEY_t CIPHER_KEY_2 @ 0x98;
    CIPHER_KEY_t CIPHER_KEY_3 @ 0x9C;
    CIPHER_KEY_t CIPHER_KEY_4 @ 0xA0;
    CIPHER_KEY_t CIPHER_KEY_5 @ 0xA4;
    CIPHER_KEY_t CIPHER_KEY_6 @ 0xA8;
    CIPHER_KEY_t CIPHER_KEY_7 @ 0xAC;
    CIPHER_KEY_t CIPHER_KEY_8 @ 0xB0;
    CIPHER_KEY_t CIPHER_KEY_9 @ 0xB4;
    CIPHER_KEY_t CIPHER_KEY_10 @ 0xB8;
    CIPHER_KEY_t CIPHER_KEY_11 @ 0xBC;
    CIPHER_KEY_t CIPHER_KEY_12 @ 0xC0;
    CIPHER_KEY_t CIPHER_KEY_13 @ 0xC4;
    CIPHER_KEY_t CIPHER_KEY_14 @ 0xC8;
    CIPHER_KEY_t CIPHER_KEY_15 @ 0xCC;
    CIPHER_KEY_t CIPHER_KEY_16 @ 0xD0;
    CIPHER_KEY_t CIPHER_KEY_17 @ 0xD4;
    CIPHER_KEY_t CIPHER_KEY_18 @ 0xD8;
    CIPHER_KEY_t CIPHER_KEY_19 @ 0xDC;
    CIPHER_KEY_t CIPHER_KEY_20 @ 0xE0;
    CIPHER_KEY_t CIPHER_KEY_21 @ 0xE4;
    CIPHER_KEY_t CIPHER_KEY_22 @ 0xE8;
    CIPHER_KEY_t CIPHER_KEY_23 @ 0xEC;
    CIPHER_KEY_t CIPHER_KEY_24 @ 0xF0;
    CIPHER_KEY_t CIPHER_KEY_25 @ 0xF4;
    CIPHER_KEY_t CIPHER_KEY_26 @ 0xF8;
    CIPHER_KEY_t CIPHER_KEY_27 @ 0xFC;
    CIPHER_KEY_t CIPHER_KEY_28 @ 0x100;
    CIPHER_KEY_t CIPHER_KEY_29 @ 0x104;
    CIPHER_KEY_t CIPHER_KEY_30 @ 0x108;
    CIPHER_KEY_t CIPHER_KEY_31 @ 0x10C;
    CIPHER_KEY_t CIPHER_KEY_32 @ 0x110;
    CIPHER_KEY_t CIPHER_KEY_33 @ 0x114;
    CIPHER_KEY_t CIPHER_KEY_34 @ 0x118;
    CIPHER_KEY_t CIPHER_KEY_35 @ 0x11C;
    CIPHER_KEY_t CIPHER_KEY_36 @ 0x120;
    CIPHER_KEY_t CIPHER_KEY_37 @ 0x124;
    CIPHER_KEY_t CIPHER_KEY_38 @ 0x128;
    CIPHER_KEY_t CIPHER_KEY_39 @ 0x12C;
    CIPHER_KEY_t CIPHER_KEY_40 @ 0x130;
    CIPHER_KEY_t CIPHER_KEY_41 @ 0x134;
    CIPHER_KEY_t CIPHER_KEY_42 @ 0x138;
    CIPHER_KEY_t CIPHER_KEY_43 @ 0x13C;
    CIPHER_KEY_t CIPHER_KEY_44 @ 0x140;
    CIPHER_KEY_t CIPHER_KEY_45 @ 0x144;
    CIPHER_KEY_t CIPHER_KEY_46 @ 0x148;
    CIPHER_KEY_t CIPHER_KEY_47 @ 0x14C;
    CIPHER_KEY_t CIPHER_KEY_48 @ 0x150;
    CIPHER_KEY_t CIPHER_KEY_49 @ 0x154;
    CIPHER_KEY_t CIPHER_KEY_50 @ 0x158;
    CIPHER_KEY_t CIPHER_KEY_51 @ 0x15C;
    CIPHER_KEY_t CIPHER_KEY_52 @ 0x160;
    CIPHER_KEY_t CIPHER_KEY_53 @ 0x164;
    CIPHER_KEY_t CIPHER_KEY_54 @ 0x168;
    CIPHER_KEY_t CIPHER_KEY_55 @ 0x16C;
    CIPHER_KEY_t CIPHER_KEY_56 @ 0x170;
    CIPHER_KEY_t CIPHER_KEY_57 @ 0x174;
    CIPHER_KEY_t CIPHER_KEY_58 @ 0x178;
    CIPHER_KEY_t CIPHER_KEY_59 @ 0x17C;
    CIPHER_KEY_t CIPHER_KEY_60 @ 0x180;
    CIPHER_KEY_t CIPHER_KEY_61 @ 0x184;
    CIPHER_KEY_t CIPHER_KEY_62 @ 0x188;
    CIPHER_KEY_t CIPHER_KEY_63 @ 0x18C;
    reg {
        name = "CHAN0_CIPHER_CTRL";
        desc = "CHAN0_CIPHER_CTRL is an encryption/decryption control register for channel 0. Channel 0 is a single-block encryption/decryption channel. Note the following points when configuring this register: Configure this register before configuring others registers of the cipher module. In the modes except the CFB mode of the AES algorithm, the CIPHER_CTRL[width] cannot be set to 01 or 10. In the modes except the CFB and OFB modes of the DES and 3DES algorithms, CIPHER_CTRL[width] cannot be set to 01 or 10. (offset 0x1000; total reset 0x00000000; PROVEN: Hi3521A/Hi3520D V300 data sheet (Issue 00B07, 2015-12-10), section 3.7.5.2, PDF page 639).";
        field {
            name = "reserved";
            desc = "Reserved";
            sw = r; hw = w;
            reset = 0x0;
        } reserved_31_17[31:17];
        field {
            name = "key_adder";
            desc = "ID of the key used by the current channel
- 000: host_key0
- 001: host_key1
- 010: host_key2
- 011: host_key3
- 100: host_key4
- 101: host_key5
- 110: host_key6
- 111: host_key7";
            sw = rw; hw = r;
            reset = 0x0;
        } key_adder[16:14];
        field {
            name = "key_sel";
            desc = "Key select
- 0: keys configured by the CPU
- 1: reserved";
            sw = rw; hw = r;
            reset = 0x0;
        } key_sel[13:13];
        field {
            name = "reserved";
            desc = "Reserved";
            sw = r; hw = w;
            reset = 0x0;
        } reserved_12_12[12:12];
        field {
            name = "reserved";
            desc = "Reserved";
            sw = r; hw = w;
            reset = 0x0;
        } reserved_11_11[11:11];
        field {
            name = "key_length";
            desc = "Key length select For the AES algorithm:
- 00: 128 bits
- 01: 192 bits
- 10: 256 bits
- 11: 128 bits

For the DES algorithm:
- 00: 3 keys
- 01: 3 keys
- 10: 3 keys
- 11: 2 keys";
            sw = rw; hw = r;
            reset = 0x0;
        } key_length[10:9];
        field {
            name = "ivin_sel";
            desc = "Input select of CIPHER_IVIN
- 0: do not configure CIPHER_IVIN
- 1: configure CIPHER_IVIN";
            sw = rw; hw = r;
            reset = 0x0;
        } ivin_sel[8:8];
        field {
            name = "width";
            desc = "Bit width control For the DES or 3DES algorithm:
- 00: 64 bits
- 01: 8 bits
- 10: 1 bit
- 11: 64 bits

For the AES algorithm:
- 00: 128 bits
- 01: 8 bits
- 10: 1 bit
- 11: 128 bits";
            sw = rw; hw = r;
            reset = 0x0;
        } width[7:6];
        field {
            name = "alg_sel";
            desc = "Algorithm select
- 00: DES algorithm
- 01: 3DES algorithm
- 10: AES algorithm
- 11: DES algorithm";
            sw = rw; hw = r;
            reset = 0x0;
        } alg_sel[5:4];
        field {
            name = "mode";
            desc = "Operating mode select For the AES algorithm:
- 000: ECB mode
- 001: CBC mode
- 010: CFB mode
- 011: OFB mode
- 100: CTR mode

Other values: ECB mode For the DES algorithm:
- 000: ECB mode
- 001: CBC mode
- 010: CFB mode
- 011: OFB mode

Other values: ECB mode";
            sw = rw; hw = r;
            reset = 0x0;
        } mode[3:1];
        field {
            name = "decrypt";
            desc = "Encryption/decryption select
- 0: encryption
- 1: decryption";
            sw = rw; hw = r;
            reset = 0x0;
        } decrypt[0:0];
    } CHAN0_CIPHER_CTRL @ 0x1000;
    reg CHAN0_CIPHER_IVIN_t {
        name = "CHAN0_CIPHER_IVIN";
        desc = "CHAN0_CIPHER_IVIN is a cipher VI block input register for channel 0. Assume that channel 0 is selected for the single-block encryption/decryption and the selected mode is not ECB mode (CIPHER_CTRL[mode] = 0b001, 0b010, 0b011, or 0b100). If you do not want to configure the input vector (CIPHER_CTRL[ivin_sel] = 0b0), CIPHER_IVIN can be ignored. If you want to configure the input vector (CIPHER_CTRL[ivin_sel] = 0b1), CIPHER_IVIN needs to be configured. If the AES algorithm is selected (CIPHER_CTRL [alg_sel] = 0b10), CIPHER_IVIN bit[127:0] is valid. If the DES or 3DES algorithm is selected (CIPHER_CTRL[alg_sel] = 0b00, 0b01, or 0b11), lower 64 bits are valid, that is, CIPHER_IVIN bit[63:0] is valid. (offset 0x1004, 4 instances at stride 0x4; total reset 0x00000000; PROVEN: Hi3521A/Hi3520D V300 data sheet (Issue 00B07, 2015-12-10), section 3.7.5.2, PDF page 641).";
        field {
            name = "chan0_cipher_ivin";
            desc = "128-bit IV of the cipher module for channel 0 or the data input from the counter. Each address maps to a 32-bit data segment. CIPHER_IVIN[31:0]: address 0x1004 CIPHER_IVIN[63:32]: address 0x1008 CIPHER_IVIN[95:64]: address 0x100C CIPHER_IVIN[127:96]: address 0x1010";
            sw = rw; hw = r;
            reset = 0x0;
        } chan0_cipher_ivin[31:0];
    };
    CHAN0_CIPHER_IVIN_t CHAN0_CIPHER_IVIN_0 @ 0x1004;
    CHAN0_CIPHER_IVIN_t CHAN0_CIPHER_IVIN_1 @ 0x1008;
    CHAN0_CIPHER_IVIN_t CHAN0_CIPHER_IVIN_2 @ 0x100C;
    CHAN0_CIPHER_IVIN_t CHAN0_CIPHER_IVIN_3 @ 0x1010;
    reg CHAN0_CIPHER_DIN_t {
        name = "CHAN0_CIPHER_DIN";
        desc = "CHAN0_CIPHER_DIN is a 128-bit block input register of the cipher module. Note the following points when configuring this register: If channel 0 is selected for the single-block operation, this register needs to be configured. Assume that the AES algorithm (CIPHER_CTRL[alg_sel] = 0b10) is selected. - If the 1-CFB mode is selected, the LSB is valid, that is, CIPHER_DIN bit[0] is valid. - If the 8-CFB mode is selected, lower eight bits are valid, that is, CIPHER_DIN bit[7:0] is valid. - If the 128-CFB mode is selected, 128 bits are valid. - In other modes, 128 bits are valid. Assume that the DES or the 3DES algorithm (CIPHER_CTRL[alg_sel] = 0b00, 0b01, or 0b11) is selected. - If the 1-CFB or 1-OFB mode is selected, the LSB is valid, that is, CIPHER_DIN bit[0] is valid. - If the 8-CFB or 8-OFB mode is selected, lower eight bits are valid, that is, CIPHER_DIN bit[7:0] is valid. - If the 64-CFB or 64-OFB mode is selected, lower 64 bits are valid, that is, CIPHER_DIN bit[63:0] is valid. - In other modes, lower 64 bits are valid, that is, CIPHER_DIN bit[63:0] is valid. (offset 0x1014, 4 instances at stride 0x4; total reset 0x00000000; PROVEN: Hi3521A/Hi3520D V300 data sheet (Issue 00B07, 2015-12-10), section 3.7.5.2, PDF page 642).";
        field {
            name = "chan0_cipher_din";
            desc = "128-bit block input of the cipher module for channel 0. Each address maps to a 32-bit data segment. CIPHER_DIN[31:0]: address 0x1014 CIPHER_DIN[63:32]: address 0x1018 CIPHER_DIN[95:64]: address 0x101c CIPHER_DIN[127:96]: address 0x1020";
            sw = rw; hw = r;
            reset = 0x0;
        } chan0_cipher_din[31:0];
    };
    CHAN0_CIPHER_DIN_t CHAN0_CIPHER_DIN_0 @ 0x1014;
    CHAN0_CIPHER_DIN_t CHAN0_CIPHER_DIN_1 @ 0x1018;
    CHAN0_CIPHER_DIN_t CHAN0_CIPHER_DIN_2 @ 0x101C;
    CHAN0_CIPHER_DIN_t CHAN0_CIPHER_DIN_3 @ 0x1020;
    reg CHANn_IBUF_NUM_t {
        name = "CHANn_IBUF_NUM";
        desc = "CHANn_IBUF_NUM is an input queue total depth register for channel n (n = 1-7). This register can be used to configure the count of linked list headers. (offset 0x1080, 7 instances at stride 0x80; total reset 0x00000000; PROVEN: Hi3521A/Hi3520D V300 data sheet (Issue 00B07, 2015-12-10), section 3.7.5.2, PDF page 642).";
        field {
            name = "reserved";
            desc = "Reserved";
            sw = r; hw = w;
            reset = 0x0;
        } reserved_31_16[31:16];
        field {
            name = "ibuf_num";
            desc = "Input queue depth, that is, count of linked list headers configured for each channel.";
            sw = rw; hw = r;
            reset = 0x0;
        } ibuf_num[15:0];
    };
    CHANn_IBUF_NUM_t CHAN0_IBUF_NUM @ 0x1080;
    CHANn_IBUF_NUM_t CHAN1_IBUF_NUM @ 0x1100;
    CHANn_IBUF_NUM_t CHAN2_IBUF_NUM @ 0x1180;
    CHANn_IBUF_NUM_t CHAN3_IBUF_NUM @ 0x1200;
    CHANn_IBUF_NUM_t CHAN4_IBUF_NUM @ 0x1280;
    CHANn_IBUF_NUM_t CHAN5_IBUF_NUM @ 0x1300;
    CHANn_IBUF_NUM_t CHAN6_IBUF_NUM @ 0x1380;
    reg CHANn_IBUF_CNT_t {
        name = "CHANn_IBUF_CNT";
        desc = "CHANn_IBUF_CNT is a pending data buffer count register for channel n in the input queue. When this register is written by using software, the logic adds the original value of the register and the written value. After the logic processes a buffer, the value of this register is decreased by 1. (offset 0x1084, 7 instances at stride 0x80; total reset 0x00000000; PROVEN: Hi3521A/Hi3520D V300 data sheet (Issue 00B07, 2015-12-10), section 3.7.5.2, PDF page 643).";
        field {
            name = "reserved";
            desc = "Reserved";
            sw = r; hw = w;
            reset = 0x0;
        } reserved_31_16[31:16];
        field {
            name = "ibuf_cnt";
            desc = "Count of buffers to be processed in the input queue";
            sw = rw; hw = r;
            reset = 0x0;
        } ibuf_cnt[15:0];
    };
    CHANn_IBUF_CNT_t CHAN0_IBUF_CNT @ 0x1084;
    CHANn_IBUF_CNT_t CHAN1_IBUF_CNT @ 0x1104;
    CHANn_IBUF_CNT_t CHAN2_IBUF_CNT @ 0x1184;
    CHANn_IBUF_CNT_t CHAN3_IBUF_CNT @ 0x1204;
    CHANn_IBUF_CNT_t CHAN4_IBUF_CNT @ 0x1284;
    CHANn_IBUF_CNT_t CHAN5_IBUF_CNT @ 0x1304;
    CHANn_IBUF_CNT_t CHAN6_IBUF_CNT @ 0x1384;
    reg CHANn_IEMPTY_CNT_t {
        name = "CHANn_IEMPTY_CNT";
        desc = "CHANn_IEMPTY_CNT is a processed buffer count register for channel n in the input queue. When this register is written by software, the logic subtracts the written value from the original value of this register. After the logic processes a buffer, the value of this register is increased by 1. (offset 0x1088, 7 instances at stride 0x80; total reset 0x00000000; PROVEN: Hi3521A/Hi3520D V300 data sheet (Issue 00B07, 2015-12-10), section 3.7.5.2, PDF page 643).";
        field {
            name = "reserved";
            desc = "Reserved";
            sw = r; hw = w;
            reset = 0x0;
        } reserved_31_16[31:16];
        field {
            name = "iempty_cnt";
            desc = "Count of processed buffers in the input queue";
            sw = rw; hw = r;
            reset = 0x0;
        } iempty_cnt[15:0];
    };
    CHANn_IEMPTY_CNT_t CHAN0_IEMPTY_CNT @ 0x1088;
    CHANn_IEMPTY_CNT_t CHAN1_IEMPTY_CNT @ 0x1108;
    CHANn_IEMPTY_CNT_t CHAN2_IEMPTY_CNT @ 0x1188;
    CHANn_IEMPTY_CNT_t CHAN3_IEMPTY_CNT @ 0x1208;
    CHANn_IEMPTY_CNT_t CHAN4_IEMPTY_CNT @ 0x1288;
    CHANn_IEMPTY_CNT_t CHAN5_IEMPTY_CNT @ 0x1308;
    CHANn_IEMPTY_CNT_t CHAN6_IEMPTY_CNT @ 0x1388;
    reg CHANn_INT_ICNTCFG_t {
        name = "CHANn_INT_ICNTCFG";
        desc = "CHANn_INT_ICNTCFG is an input queue multi-packet interrupt threshold register for channel n. When the count of buffers in the input queue processed by the logic is above the threshold, an input queue interrupt is reported. (offset 0x108C, 7 instances at stride 0x80; total reset 0x00000000; PROVEN: Hi3521A/Hi3520D V300 data sheet (Issue 00B07, 2015-12-10), section 3.7.5.2, PDF page 643).";
        field {
            name = "reserved";
            desc = "Reserved";
            sw = r; hw = w;
            reset = 0x0;
        } reserved_31_16[31:16];
        field {
            name = "int_icnt_cfg";
            desc = "Input queue multi-packet interrupt threshold";
            sw = rw; hw = r;
            reset = 0x0;
        } int_icnt_cfg[15:0];
    };
    CHANn_INT_ICNTCFG_t CHAN0_INT_ICNTCFG @ 0x108C;
    CHANn_INT_ICNTCFG_t CHAN1_INT_ICNTCFG @ 0x110C;
    CHANn_INT_ICNTCFG_t CHAN2_INT_ICNTCFG @ 0x118C;
    CHANn_INT_ICNTCFG_t CHAN3_INT_ICNTCFG @ 0x120C;
    CHANn_INT_ICNTCFG_t CHAN4_INT_ICNTCFG @ 0x128C;
    CHANn_INT_ICNTCFG_t CHAN5_INT_ICNTCFG @ 0x130C;
    CHANn_INT_ICNTCFG_t CHAN6_INT_ICNTCFG @ 0x138C;
    reg CHANn_CIPHER_CTRL_t {
        name = "CHANn_CIPHER_CTRL";
        desc = "CHANn_CIPHER_CTRL is an encryption/decryption control register for channel n. Note the following points when configuring this register: You must configure this register before performing encryption or decryption using the channel. In the modes other than the CFB mode of the AES algorithm, CIPHER_CTRL[width] cannot be set to 01 or 10. In the modes other than the CFB and OFB modes of the DES or 3DES algorithm, CIPHER_CTRL[width] cannot be set to 01 or 10. (offset 0x1090, 7 instances at stride 0x80; total reset 0x00000000; PROVEN: Hi3521A/Hi3520D V300 data sheet (Issue 00B07, 2015-12-10), section 3.7.5.2, PDF page 644).";
        field {
            name = "weight";
            desc = "Weighted value of the current channel, in the unit of 64 bytes";
            sw = r; hw = w;
            reset = 0x0;
        } weight[31:22];
        field {
            name = "reserved";
            desc = "Reserved";
            sw = r; hw = w;
            reset = 0x0;
        } reserved_21_17[21:17];
        field {
            name = "key_adder";
            desc = "ID of the key used by the current channel. The key can be any one in the addresses 0-7.";
            sw = rw; hw = r;
            reset = 0x0;
        } key_adder[16:14];
        field {
            name = "key_sel";
            desc = "Key select
- 0: keys configured by the CPU
- 1: reserved";
            sw = rw; hw = r;
            reset = 0x0;
        } key_sel[13:13];
        field {
            name = "reserved";
            desc = "Reserved";
            sw = r; hw = w;
            reset = 0x0;
        } reserved_12_11[12:11];
        field {
            name = "key_length";
            desc = "Key length select For the AES algorithm:
- 00: 128 bits
- 01: 192 bits
- 10: 256 bits
- 11: 128 bits

For the DES algorithm:
- 00: 3 keys
- 01: 3 keys
- 10: 3 keys
- 11: 2 keys";
            sw = rw; hw = r;
            reset = 0x0;
        } key_length[10:9];
        field {
            name = "reserved";
            desc = "Reserved";
            sw = r; hw = w;
            reset = 0x0;
        } reserved_8_8[8:8];
        field {
            name = "width";
            desc = "Bit width control For the DES or 3DES algorithm:
- 00: 64 bits
- 01: 8 bits
- 10: 1 bit
- 11: 64 bits

For the AES algorithm:
- 00: 128 bits
- 01: 8 bits
- 10: 1 bit
- 11: 128 bits";
            sw = rw; hw = r;
            reset = 0x0;
        } width[7:6];
        field {
            name = "alg_sel";
            desc = "Algorithm select
- 00: DES algorithm
- 01: 3DES algorithm
- 10: AES algorithm
- 11: DES algorithm";
            sw = rw; hw = r;
            reset = 0x0;
        } alg_sel[5:4];
        field {
            name = "mode";
            desc = "Operating mode select For the AES algorithm:
- 000: ECB mode
- 001: CBC mode
- 010: CFB mode
- 011: OFB mode
- 100: CTR mode

Other values: ECB mode For the DES algorithm:
- 000: ECB mode
- 001: CBC mode
- 010: CFB mode
- 011: OFB mode

Other values: ECB mode";
            sw = rw; hw = r;
            reset = 0x0;
        } mode[3:1];
        field {
            name = "decrypt";
            desc = "Encryption/decryption select
- 0: encryption
- 1: decryption";
            sw = rw; hw = r;
            reset = 0x0;
        } decrypt[0:0];
    };
    CHANn_CIPHER_CTRL_t CHAN0_CIPHER_CTRL_1090 @ 0x1090;
    CHANn_CIPHER_CTRL_t CHAN1_CIPHER_CTRL @ 0x1110;
    CHANn_CIPHER_CTRL_t CHAN2_CIPHER_CTRL @ 0x1190;
    CHANn_CIPHER_CTRL_t CHAN3_CIPHER_CTRL @ 0x1210;
    CHANn_CIPHER_CTRL_t CHAN4_CIPHER_CTRL @ 0x1290;
    CHANn_CIPHER_CTRL_t CHAN5_CIPHER_CTRL @ 0x1310;
    CHANn_CIPHER_CTRL_t CHAN6_CIPHER_CTRL @ 0x1390;
    reg CHANn_SRC_LST_SADDR_t {
        name = "CHANn_SRC_LST_SADDR";
        desc = "CHANn_SRC_LST_SADDR is an input queue start address register for channel n. The address must be aligned by word. (offset 0x1094, 7 instances at stride 0x80; total reset 0x00000000; PROVEN: Hi3521A/Hi3520D V300 data sheet (Issue 00B07, 2015-12-10), section 3.7.5.2, PDF page 646).";
        field {
            name = "src_lst_saddr";
            desc = "Start address for the input queue";
            sw = rw; hw = r;
            reset = 0x0;
        } src_lst_saddr[31:0];
    };
    CHANn_SRC_LST_SADDR_t CHAN0_SRC_LST_SADDR @ 0x1094;
    CHANn_SRC_LST_SADDR_t CHAN1_SRC_LST_SADDR @ 0x1114;
    CHANn_SRC_LST_SADDR_t CHAN2_SRC_LST_SADDR @ 0x1194;
    CHANn_SRC_LST_SADDR_t CHAN3_SRC_LST_SADDR @ 0x1214;
    CHANn_SRC_LST_SADDR_t CHAN4_SRC_LST_SADDR @ 0x1294;
    CHANn_SRC_LST_SADDR_t CHAN5_SRC_LST_SADDR @ 0x1314;
    CHANn_SRC_LST_SADDR_t CHAN6_SRC_LST_SADDR @ 0x1394;
    reg CHANn_IAGE_TIMER_t {
        name = "CHANn_IAGE_TIMER";
        desc = "CHANn_IAGE_TIMER is an input queue interrupt aging time configuration register for channel n. If overflow occurs in the aging time counter and the count of processed buffers in the input queue is greater than 0, an input queue processing complete interrupt is reported. (offset 0x1098, 7 instances at stride 0x80; total reset 0x00000000; PROVEN: Hi3521A/Hi3520D V300 data sheet (Issue 00B07, 2015-12-10), section 3.7.5.2, PDF page 647).";
        field {
            name = "reserved";
            desc = "Reserved";
            sw = r; hw = w;
            reset = 0x0;
        } reserved_31_16[31:16];
        field {
            name = "iage_timer";
            desc = "Aging interrupt timer";
            sw = rw; hw = r;
            reset = 0x0;
        } iage_timer[15:0];
    };
    CHANn_IAGE_TIMER_t CHAN0_IAGE_TIMER @ 0x1098;
    CHANn_IAGE_TIMER_t CHAN1_IAGE_TIMER @ 0x1118;
    CHANn_IAGE_TIMER_t CHAN2_IAGE_TIMER @ 0x1198;
    CHANn_IAGE_TIMER_t CHAN3_IAGE_TIMER @ 0x1218;
    CHANn_IAGE_TIMER_t CHAN4_IAGE_TIMER @ 0x1298;
    CHANn_IAGE_TIMER_t CHAN5_IAGE_TIMER @ 0x1318;
    CHANn_IAGE_TIMER_t CHAN6_IAGE_TIMER @ 0x1398;
    reg CHANn_OBUF_NUM_t {
        name = "CHANn_OBUF_NUM";
        desc = "CHANn_OBUF_NUM is an output queue total depth register for channel n. This register can be used to configure the count of linked list headers. (offset 0x10BC, 7 instances at stride 0x80; total reset 0x00000000; PROVEN: Hi3521A/Hi3520D V300 data sheet (Issue 00B07, 2015-12-10), section 3.7.5.2, PDF page 647).";
        field {
            name = "reserved";
            desc = "Reserved";
            sw = r; hw = w;
            reset = 0x0;
        } reserved_31_16[31:16];
        field {
            name = "obuf_num";
            desc = "Total depth of the output queue";
            sw = rw; hw = r;
            reset = 0x0;
        } obuf_num[15:0];
    };
    CHANn_OBUF_NUM_t CHAN0_OBUF_NUM @ 0x10BC;
    CHANn_OBUF_NUM_t CHAN1_OBUF_NUM @ 0x113C;
    CHANn_OBUF_NUM_t CHAN2_OBUF_NUM @ 0x11BC;
    CHANn_OBUF_NUM_t CHAN3_OBUF_NUM @ 0x123C;
    CHANn_OBUF_NUM_t CHAN4_OBUF_NUM @ 0x12BC;
    CHANn_OBUF_NUM_t CHAN5_OBUF_NUM @ 0x133C;
    CHANn_OBUF_NUM_t CHAN6_OBUF_NUM @ 0x13BC;
    reg CHANn_OBUF_CNT_t {
        name = "CHANn_OBUF_CNT";
        desc = "CHANn_OBUF_CNT is a pending data buffer count register for channel n in the output queue. When this register is written by using software, the logic adds the original value of the register and the written value. After the logic processes a buffer, the value of this register is decreased by 1. (offset 0x10C0, 7 instances at stride 0x80; total reset 0x00000000; PROVEN: Hi3521A/Hi3520D V300 data sheet (Issue 00B07, 2015-12-10), section 3.7.5.2, PDF page 647).";
        field {
            name = "reserved";
            desc = "Reserved";
            sw = r; hw = w;
            reset = 0x0;
        } reserved_31_16[31:16];
        field {
            name = "obuf_cnt";
            desc = "Count of buffers to be processed in the output queue";
            sw = rw; hw = r;
            reset = 0x0;
        } obuf_cnt[15:0];
    };
    CHANn_OBUF_CNT_t CHAN0_OBUF_CNT @ 0x10C0;
    CHANn_OBUF_CNT_t CHAN1_OBUF_CNT @ 0x1140;
    CHANn_OBUF_CNT_t CHAN2_OBUF_CNT @ 0x11C0;
    CHANn_OBUF_CNT_t CHAN3_OBUF_CNT @ 0x1240;
    CHANn_OBUF_CNT_t CHAN4_OBUF_CNT @ 0x12C0;
    CHANn_OBUF_CNT_t CHAN5_OBUF_CNT @ 0x1340;
    CHANn_OBUF_CNT_t CHAN6_OBUF_CNT @ 0x13C0;
    reg CHANn_OFULL_CNT_t {
        name = "CHANn_OFULL_CNT";
        desc = "CHANn_OFULL_CNT is a processed buffer count register for channel n in the output queue. When this register is written by software, the logic subtracts the written value from the original value of this register. After the logic processes a buffer, the value of this register is increased by 1. (offset 0x10C4, 7 instances at stride 0x80; total reset 0x00000000; PROVEN: Hi3521A/Hi3520D V300 data sheet (Issue 00B07, 2015-12-10), section 3.7.5.2, PDF page 648).";
        field {
            name = "reserved";
            desc = "Reserved";
            sw = r; hw = w;
            reset = 0x0;
        } reserved_31_16[31:16];
        field {
            name = "ofull_cnt";
            desc = "Count of processed buffers in the output queue";
            sw = rw; hw = r;
            reset = 0x0;
        } ofull_cnt[15:0];
    };
    CHANn_OFULL_CNT_t CHAN0_OFULL_CNT @ 0x10C4;
    CHANn_OFULL_CNT_t CHAN1_OFULL_CNT @ 0x1144;
    CHANn_OFULL_CNT_t CHAN2_OFULL_CNT @ 0x11C4;
    CHANn_OFULL_CNT_t CHAN3_OFULL_CNT @ 0x1244;
    CHANn_OFULL_CNT_t CHAN4_OFULL_CNT @ 0x12C4;
    CHANn_OFULL_CNT_t CHAN5_OFULL_CNT @ 0x1344;
    CHANn_OFULL_CNT_t CHAN6_OFULL_CNT @ 0x13C4;
    reg CHANn_INT_OCNTCFG_t {
        name = "CHANn_INT_OCNTCFG";
        desc = "CHANn_INT_OCNTCFG is an output queue multi-packet interrupt threshold register for channel n. When the count of buffers in the output queue processed by the logic is above the threshold, an output queue interrupt is reported. (offset 0x10C8, 7 instances at stride 0x80; total reset 0x00000000; PROVEN: Hi3521A/Hi3520D V300 data sheet (Issue 00B07, 2015-12-10), section 3.7.5.2, PDF page 648).";
        field {
            name = "reserved";
            desc = "Reserved";
            sw = r; hw = w;
            reset = 0x0;
        } reserved_31_16[31:16];
        field {
            name = "int_ocnt_cfg";
            desc = "Output queue multi-packet interrupt threshold";
            sw = rw; hw = r;
            reset = 0x0;
        } int_ocnt_cfg[15:0];
    };
    CHANn_INT_OCNTCFG_t CHAN0_INT_OCNTCFG @ 0x10C8;
    CHANn_INT_OCNTCFG_t CHAN1_INT_OCNTCFG @ 0x1148;
    CHANn_INT_OCNTCFG_t CHAN2_INT_OCNTCFG @ 0x11C8;
    CHANn_INT_OCNTCFG_t CHAN3_INT_OCNTCFG @ 0x1248;
    CHANn_INT_OCNTCFG_t CHAN4_INT_OCNTCFG @ 0x12C8;
    CHANn_INT_OCNTCFG_t CHAN5_INT_OCNTCFG @ 0x1348;
    CHANn_INT_OCNTCFG_t CHAN6_INT_OCNTCFG @ 0x13C8;
    reg CHANn_DEST_LST_SADDR_t {
        name = "CHANn_DEST_LST_SADDR";
        desc = "CHANn_DEST_LST_SADDR is an output queue start address register for channel n. The address must be aligned by word. (offset 0x10CC, 7 instances at stride 0x80; total reset 0x00000000; PROVEN: Hi3521A/Hi3520D V300 data sheet (Issue 00B07, 2015-12-10), section 3.7.5.2, PDF page 649).";
        field {
            name = "dest_lst_saddr";
            desc = "Start address for the output queue";
            sw = rw; hw = r;
            reset = 0x0;
        } dest_lst_saddr[31:0];
    };
    CHANn_DEST_LST_SADDR_t CHAN0_DEST_LST_SADDR @ 0x10CC;
    CHANn_DEST_LST_SADDR_t CHAN1_DEST_LST_SADDR @ 0x114C;
    CHANn_DEST_LST_SADDR_t CHAN2_DEST_LST_SADDR @ 0x11CC;
    CHANn_DEST_LST_SADDR_t CHAN3_DEST_LST_SADDR @ 0x124C;
    CHANn_DEST_LST_SADDR_t CHAN4_DEST_LST_SADDR @ 0x12CC;
    CHANn_DEST_LST_SADDR_t CHAN5_DEST_LST_SADDR @ 0x134C;
    CHANn_DEST_LST_SADDR_t CHAN6_DEST_LST_SADDR @ 0x13CC;
    reg CHANn_OAGE_TIMER_t {
        name = "CHANn_OAGE_TIMER";
        desc = "CHANn_OAGE_TIMER is an output queue interrupt aging time configuration register for channel n. If overflow occurs in the aging time counter and the count of processed buffers in the output queue is greater than 0, an output queue processing complete interrupt is reported. (offset 0x10D0, 7 instances at stride 0x80; total reset 0x00000000; PROVEN: Hi3521A/Hi3520D V300 data sheet (Issue 00B07, 2015-12-10), section 3.7.5.2, PDF page 649).";
        field {
            name = "reserved";
            desc = "Reserved";
            sw = r; hw = w;
            reset = 0x0;
        } reserved_31_16[31:16];
        field {
            name = "oage_timer";
            desc = "Aging interrupt timer";
            sw = rw; hw = r;
            reset = 0x0;
        } oage_timer[15:0];
    };
    CHANn_OAGE_TIMER_t CHAN0_OAGE_TIMER @ 0x10D0;
    CHANn_OAGE_TIMER_t CHAN1_OAGE_TIMER @ 0x1150;
    CHANn_OAGE_TIMER_t CHAN2_OAGE_TIMER @ 0x11D0;
    CHANn_OAGE_TIMER_t CHAN3_OAGE_TIMER @ 0x1250;
    CHANn_OAGE_TIMER_t CHAN4_OAGE_TIMER @ 0x12D0;
    CHANn_OAGE_TIMER_t CHAN5_OAGE_TIMER @ 0x1350;
    CHANn_OAGE_TIMER_t CHAN6_OAGE_TIMER @ 0x13D0;
    reg {
        name = "INT_STATUS";
        desc = "INT_STATUS is an interrupt status register. (offset 0x1400; total reset 0x00000000; PROVEN: Hi3521A/Hi3520D V300 data sheet (Issue 00B07, 2015-12-10), section 3.7.5.2, PDF page 649).";
        field {
            name = "reserved";
            desc = "Reserved";
            sw = r; hw = w;
            reset = 0x0;
        } reserved_31_16[31:16];
        field {
            name = "ch7_ibuf_int";
            desc = "Input queue data interrupt for channel 7";
            sw = r; hw = w;
            reset = 0x0;
        } ch7_ibuf_int[15:15];
        field {
            name = "ch6_ibuf_int";
            desc = "Input queue data interrupt for channel 6";
            sw = r; hw = w;
            reset = 0x0;
        } ch6_ibuf_int[14:14];
        field {
            name = "ch5_ibuf_int";
            desc = "Input queue data interrupt for channel 5";
            sw = r; hw = w;
            reset = 0x0;
        } ch5_ibuf_int[13:13];
        field {
            name = "ch4_ibuf_int";
            desc = "Input queue data interrupt for channel 4";
            sw = r; hw = w;
            reset = 0x0;
        } ch4_ibuf_int[12:12];
        field {
            name = "ch3_ibuf_int";
            desc = "Input queue data interrupt for channel 3";
            sw = r; hw = w;
            reset = 0x0;
        } ch3_ibuf_int[11:11];
        field {
            name = "ch2_ibuf_int";
            desc = "Input queue data interrupt for channel 2";
            sw = r; hw = w;
            reset = 0x0;
        } ch2_ibuf_int[10:10];
        field {
            name = "ch1_ibuf_int";
            desc = "Input queue data interrupt for channel 1";
            sw = r; hw = w;
            reset = 0x0;
        } ch1_ibuf_int[9:9];
        field {
            name = "ch0_ibuf_int";
            desc = "Data processing complete interrupt for channel 0";
            sw = r; hw = w;
            reset = 0x0;
        } ch0_ibuf_int[8:8];
        field {
            name = "ch7_obuf_int";
            desc = "Output queue data interrupt for channel 7";
            sw = r; hw = w;
            reset = 0x0;
        } ch7_obuf_int[7:7];
        field {
            name = "ch6_obuf_int";
            desc = "Output queue data interrupt for channel 6";
            sw = r; hw = w;
            reset = 0x0;
        } ch6_obuf_int[6:6];
        field {
            name = "ch5_obuf_int";
            desc = "Output queue data interrupt for channel 5";
            sw = r; hw = w;
            reset = 0x0;
        } ch5_obuf_int[5:5];
        field {
            name = "ch4_obuf_int";
            desc = "Output queue data interrupt for channel 4";
            sw = r; hw = w;
            reset = 0x0;
        } ch4_obuf_int[4:4];
        field {
            name = "ch3_obuf_int";
            desc = "Output queue data interrupt for channel 3";
            sw = r; hw = w;
            reset = 0x0;
        } ch3_obuf_int[3:3];
        field {
            name = "ch2_obuf_int";
            desc = "Output queue data interrupt for channel 2";
            sw = r; hw = w;
            reset = 0x0;
        } ch2_obuf_int[2:2];
        field {
            name = "ch1_obuf_int";
            desc = "Output queue data interrupt for channel 1";
            sw = r; hw = w;
            reset = 0x0;
        } ch1_obuf_int[1:1];
        field {
            name = "reserved";
            desc = "Reserved";
            sw = r; hw = w;
            reset = 0x0;
        } reserved_0_0[0:0];
    } INT_STATUS @ 0x1400;
    reg {
        name = "INT_EN";
        desc = "INT_EN is an interrupt enable register. (offset 0x1404; total reset 0x00000000; PROVEN: Hi3521A/Hi3520D V300 data sheet (Issue 00B07, 2015-12-10), section 3.7.5.2, PDF page 650).";
        field {
            name = "int_en";
            desc = "Total interrupt enable for the cipher module";
            sw = rw; hw = r;
            reset = 0x0;
        } int_en[31:31];
        field {
            name = "reserved";
            desc = "Reserved";
            sw = r; hw = w;
            reset = 0x0;
        } reserved_30_16[30:16];
        field {
            name = "ch7_ibuf_en";
            desc = "Input queue data interrupt enable for channel 7";
            sw = rw; hw = r;
            reset = 0x0;
        } ch7_ibuf_en[15:15];
        field {
            name = "ch6_ibuf_en";
            desc = "Input queue data interrupt enable for channel 6";
            sw = rw; hw = r;
            reset = 0x0;
        } ch6_ibuf_en[14:14];
        field {
            name = "ch5_ibuf_en";
            desc = "Input queue data interrupt enable for channel 5";
            sw = rw; hw = r;
            reset = 0x0;
        } ch5_ibuf_en[13:13];
        field {
            name = "ch4_ibuf_en";
            desc = "Input queue data interrupt enable for channel 4";
            sw = rw; hw = r;
            reset = 0x0;
        } ch4_ibuf_en[12:12];
        field {
            name = "ch3_ibuf_en";
            desc = "Input queue data interrupt enable for channel 3";
            sw = rw; hw = r;
            reset = 0x0;
        } ch3_ibuf_en[11:11];
        field {
            name = "ch2_ibuf_en";
            desc = "Input queue data interrupt enable for channel 2";
            sw = rw; hw = r;
            reset = 0x0;
        } ch2_ibuf_en[10:10];
        field {
            name = "ch1_ibuf_en";
            desc = "Input queue data interrupt enable for channel 1";
            sw = rw; hw = r;
            reset = 0x0;
        } ch1_ibuf_en[9:9];
        field {
            name = "ch0_ibuf_en";
            desc = "Data processing complete interrupt enable for channel 0";
            sw = rw; hw = r;
            reset = 0x0;
        } ch0_ibuf_en[8:8];
        field {
            name = "ch7_obuf_en";
            desc = "Output queue data interrupt enable for channel 7";
            sw = rw; hw = r;
            reset = 0x0;
        } ch7_obuf_en[7:7];
        field {
            name = "ch6_obuf_en";
            desc = "Output queue data interrupt enable for channel 6";
            sw = rw; hw = r;
            reset = 0x0;
        } ch6_obuf_en[6:6];
        field {
            name = "ch5_obuf_en";
            desc = "Output queue data interrupt enable for channel 5";
            sw = rw; hw = r;
            reset = 0x0;
        } ch5_obuf_en[5:5];
        field {
            name = "ch4_obuf_en";
            desc = "Output queue data interrupt enable for channel 4";
            sw = rw; hw = r;
            reset = 0x0;
        } ch4_obuf_en[4:4];
        field {
            name = "ch3_obuf_en";
            desc = "Output queue data interrupt enable for channel 3";
            sw = rw; hw = r;
            reset = 0x0;
        } ch3_obuf_en[3:3];
        field {
            name = "ch2_obuf_en";
            desc = "Output queue data interrupt enable for channel 2";
            sw = rw; hw = r;
            reset = 0x0;
        } ch2_obuf_en[2:2];
        field {
            name = "ch1_obuf_en";
            desc = "Output queue data interrupt enable for channel 1";
            sw = rw; hw = r;
            reset = 0x0;
        } ch1_obuf_en[1:1];
        field {
            name = "reserved";
            desc = "Reserved";
            sw = r; hw = w;
            reset = 0x0;
        } reserved_0_0[0:0];
    } INT_EN @ 0x1404;
    reg {
        name = "INT_RAW";
        desc = "INT_RAW is a raw interrupt status register. (offset 0x1408; total reset 0x00000000; PROVEN: Hi3521A/Hi3520D V300 data sheet (Issue 00B07, 2015-12-10), section 3.7.5.2, PDF page 651).";
        field {
            name = "reserved";
            desc = "Reserved";
            sw = r; hw = w;
            reset = 0x0;
        } reserved_31_16[31:16];
        field {
            name = "ch7_ibuf_raw";
            desc = "Raw input queue data interrupt for channel 7

Access type RWC in the data sheet: written 1 clears the bit.";
            sw = rw; hw = w; onwrite = woclr;
            reset = 0x0;
        } ch7_ibuf_raw[15:15];
        field {
            name = "ch6_ibuf_raw";
            desc = "Raw input queue data interrupt for channel 6

Access type RWC in the data sheet: written 1 clears the bit.";
            sw = rw; hw = w; onwrite = woclr;
            reset = 0x0;
        } ch6_ibuf_raw[14:14];
        field {
            name = "ch5_ibuf_raw";
            desc = "Raw input queue data interrupt for channel 5

Access type RWC in the data sheet: written 1 clears the bit.";
            sw = rw; hw = w; onwrite = woclr;
            reset = 0x0;
        } ch5_ibuf_raw[13:13];
        field {
            name = "ch4_ibuf_raw";
            desc = "Raw input queue data interrupt for channel 4

Access type RWC in the data sheet: written 1 clears the bit.";
            sw = rw; hw = w; onwrite = woclr;
            reset = 0x0;
        } ch4_ibuf_raw[12:12];
        field {
            name = "ch3_ibuf_raw";
            desc = "Raw input queue data interrupt for channel 3

Access type RWC in the data sheet: written 1 clears the bit.";
            sw = rw; hw = w; onwrite = woclr;
            reset = 0x0;
        } ch3_ibuf_raw[11:11];
        field {
            name = "ch2_ibuf_raw";
            desc = "Raw input queue data interrupt for channel 2

Access type RWC in the data sheet: written 1 clears the bit.";
            sw = rw; hw = w; onwrite = woclr;
            reset = 0x0;
        } ch2_ibuf_raw[10:10];
        field {
            name = "ch1_ibuf_raw";
            desc = "Raw input queue data interrupt for channel 1

Access type RWC in the data sheet: written 1 clears the bit.";
            sw = rw; hw = w; onwrite = woclr;
            reset = 0x0;
        } ch1_ibuf_raw[9:9];
        field {
            name = "ch0_ibuf_raw";
            desc = "Raw data processing complete interrupt for channel 0

Access type RWC in the data sheet: written 1 clears the bit.";
            sw = rw; hw = w; onwrite = woclr;
            reset = 0x0;
        } ch0_ibuf_raw[8:8];
        field {
            name = "ch7_obuf_raw";
            desc = "Raw output queue data interrupt for channel 7

Access type RWC in the data sheet: written 1 clears the bit.";
            sw = rw; hw = w; onwrite = woclr;
            reset = 0x0;
        } ch7_obuf_raw[7:7];
        field {
            name = "ch6_obuf_raw";
            desc = "Raw output queue data interrupt for channel 6

Access type RWC in the data sheet: written 1 clears the bit.";
            sw = rw; hw = w; onwrite = woclr;
            reset = 0x0;
        } ch6_obuf_raw[6:6];
        field {
            name = "ch5_obuf_raw";
            desc = "Raw output queue data interrupt for channel 5

Access type RWC in the data sheet: written 1 clears the bit.";
            sw = rw; hw = w; onwrite = woclr;
            reset = 0x0;
        } ch5_obuf_raw[5:5];
        field {
            name = "ch4_obuf_raw";
            desc = "Raw output queue data interrupt for channel 4

Access type RWC in the data sheet: written 1 clears the bit.";
            sw = rw; hw = w; onwrite = woclr;
            reset = 0x0;
        } ch4_obuf_raw[4:4];
        field {
            name = "ch3_obuf_raw";
            desc = "Raw output queue data interrupt for channel 3

Access type RWC in the data sheet: written 1 clears the bit.";
            sw = rw; hw = w; onwrite = woclr;
            reset = 0x0;
        } ch3_obuf_raw[3:3];
        field {
            name = "ch2_obuf_raw";
            desc = "Raw output queue data interrupt for channel 2

Access type RWC in the data sheet: written 1 clears the bit.";
            sw = rw; hw = w; onwrite = woclr;
            reset = 0x0;
        } ch2_obuf_raw[2:2];
        field {
            name = "ch1_obuf_raw";
            desc = "Raw output queue data interrupt for channel 1

Access type RWC in the data sheet: written 1 clears the bit.";
            sw = rw; hw = w; onwrite = woclr;
            reset = 0x0;
        } ch1_obuf_raw[1:1];
        field {
            name = "reserved";
            desc = "Reserved";
            sw = r; hw = w;
            reset = 0x0;
        } reserved_0_0[0:0];
    } INT_RAW @ 0x1408;
    reg {
        name = "RST_STATUS";
        desc = "RST_STATUS is a reset status indicator register. (offset 0x140C; total reset 0x00000000; PROVEN: Hi3521A/Hi3520D V300 data sheet (Issue 00B07, 2015-12-10), section 3.7.5.2, PDF page 652).";
        field {
            name = "reserved";
            desc = "Reserved";
            sw = r; hw = w;
            reset = 0x0;
        } reserved_31_1[31:1];
        field {
            name = "rst_status";
            desc = "Reset status indicator of the cipher module
- 0: The cipher module is being reset.
- 1: The cipher module is working properly.";
            sw = r; hw = w;
            reset = 0x0;
        } rst_status[0:0];
    } RST_STATUS @ 0x140C;
    reg {
        name = "CHAN0_CFG";
        desc = "CHAN0_CFG is channel 0 configuration register. (offset 0x1410; total reset 0x00000000; PROVEN: Hi3521A/Hi3520D V300 data sheet (Issue 00B07, 2015-12-10), section 3.7.5.2, PDF page 653).";
        field {
            name = "reserved";
            desc = "Reserved";
            sw = r; hw = w;
            reset = 0x0;
        } reserved_31_2[31:2];
        field {
            name = "ch0_busy";
            desc = "Status signal of channel 0";
            sw = r; hw = w;
            reset = 0x0;
        } ch0_busy[1:1];
        field {
            name = "ch0_start";
            desc = "Encryption/Decryption start signal of channel 0";
            sw = rw; hw = r;
            reset = 0x0;
        } ch0_start[0:0];
    } CHAN0_CFG @ 0x1410;
};
`endif
