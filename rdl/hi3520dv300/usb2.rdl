`ifndef HI3520DV300_USB2_RDL
`define HI3520DV300_USB2_RDL
regfile eHI3520DV300_USB2 {
    name = "USB 2.0 host control registers";
    desc = "USB 2.0 host control registers of the Hi3521A/Hi3520D V300 at base 0x1004_0000. 8 registers extracted programmatically from the Hi3521A/Hi3520D V300 data sheet (Issue 00B07, 2015-12-10) (Table 13-15 Summary of USB 2.0 registers (base address: 0x1004_0000)): register headings, offsets, total reset values, field bit ranges, access types, names, reset values and descriptions, with PDF page numbers in each register description. Field names, bit ranges, access types and offsets are exact; the free-text descriptions are taken from the cell text of the field table and were checked by sampling only. Hardware not verified.";
    reg {
        name = "INTNREG00";
        desc = "INTNREG00 is a micro-frame length configuration register. (offset 0x90; total reset 0x00000000; PROVEN: Hi3521A/Hi3520D V300 data sheet (Issue 00B07, 2015-12-10), section 13.7.5, PDF page 1639).";
        field {
            name = "reserved";
            desc = "Reserved";
            sw = r; hw = w;
            reset = 0x0;
        } reserved_31_14[31:14];
        field {
            name = "val";
            desc = "Value of the micro-frame counter. This register is used only for emulation. In normal mode, the micro-frame length is 125 μs defined by the protocol. During emulation, you can change the micro-frame length by configuring this register as required to reduce the emulation time.";
            sw = rw; hw = r;
            reset = 0x0;
        } val[13:1];
        field {
            name = "en";
            desc = "Register enable
- 0: disabled
- 1: enabled";
            sw = rw; hw = r;
            reset = 0x0;
        } en[0:0];
    } INTNREG00 @ 0x90;
    reg {
        name = "INSNREG01";
        desc = "INTNREG01 is a PBUF out/in configuration register. (offset 0x94; total reset 0x00200020; PROVEN: Hi3521A/Hi3520D V300 data sheet (Issue 00B07, 2015-12-10), section 13.7.5, PDF page 1640).";
        field {
            name = "out_threshold";
            desc = "TX threshold. If the data amount in the PBUF is above the TX threshold, data starts to be transmitted. The depth is measured by 32 bits.";
            sw = rw; hw = r;
            reset = 0x20;
        } out_threshold[31:16];
        field {
            name = "in_threshold";
            desc = "RX threshold. If the data amount in the PBUF is above the RX threshold, data is read from the PBUF. The depth is measured by 32 bits.";
            sw = rw; hw = r;
            reset = 0x20;
        } in_threshold[15:0];
    } INSNREG01 @ 0x94;
    reg {
        name = "INSNREG02";
        desc = "INSNREG02 is a PBUF depth configuration register. (offset 0x98; total reset 0x00000080; PROVEN: Hi3521A/Hi3520D V300 data sheet (Issue 00B07, 2015-12-10), section 13.7.5, PDF page 1640).";
        field {
            name = "reserved";
            desc = "Reserved";
            sw = r; hw = w;
            reset = 0x0;
        } reserved_31_12[31:12];
        field {
            name = "pbuf_depth";
            desc = "PBUF depth. The depth is measured by 32 bits.";
            sw = rw; hw = r;
            reset = 0x80;
        } pbuf_depth[11:0];
    } INSNREG02 @ 0x98;
    reg {
        name = "INSNREG03";
        desc = "INSNREG03 is an interrupt memory transfer enable register. (offset 0x9C; total reset 0x00000001; PROVEN: Hi3521A/Hi3520D V300 data sheet (Issue 00B07, 2015-12-10), section 13.7.5, PDF page 1641).";
        field {
            name = "reserved";
            desc = "Reserved";
            sw = r; hw = w;
            reset = 0x0;
        } reserved_31_15[31:15];
        field {
            name = "dis";
            desc = "256 MHz clock check enable
- 0: disabled
- 1: enabled";
            sw = rw; hw = r;
            reset = 0x0;
        } dis[14:14];
        field {
            name = "ctrl";
            desc = "Line state ignore during TESTSE0 NAK";
            sw = rw; hw = r;
            reset = 0x0;
        } ctrl[13:13];
        field {
            name = "val";
            desc = "tx-tx turnaround delay addition";
            sw = rw; hw = r;
            reset = 0x0;
        } val[12:10];
        field {
            name = "fetch";
            desc = "Periodic frame list RX";
            sw = rw; hw = r;
            reset = 0x0;
        } fetch[9:9];
        field {
            name = "offset";
            desc = "Available time offset";
            sw = rw; hw = r;
            reset = 0x0;
        } offset[8:1];
        field {
            name = "brk_en";
            desc = "Interrupt memory transfer enable
- 0: disabled
- 1: enabled";
            sw = r; hw = w;
            reset = 0x1;
        } brk_en[0:0];
    } INSNREG03 @ 0x9C;
    reg {
        name = "INTNREG04";
        desc = "INTNREG04 is a debug register. (offset 0xA0; total reset 0x00000000; PROVEN: Hi3521A/Hi3520D V300 data sheet (Issue 00B07, 2015-12-10), section 13.7.5, PDF page 1641).";
        field {
            name = "reserved";
            desc = "Reserved";
            sw = r; hw = w;
            reset = 0x0;
        } reserved_31_6[31:6];
        field {
            name = "auto_en";
            desc = "Automatic feature enable
- 0: enabled. The suspend signal is valid when the run/stop bit is reset by software, but the hchalted bit is not set.
- 1: disabled. The port is not suspended when software clears the run/stop bit.

The default value is 0.";
            sw = rw; hw = r;
            reset = 0x0;
        } auto_en[5:5];
        field {
            name = "nak_reldfix_en";
            desc = "NAK reload enable
- 0: enabled
- 1: disabled";
            sw = rw; hw = r;
            reset = 0x0;
        } nak_reldfix_en[4:4];
        field {
            name = "reserved";
            desc = "Reserved";
            sw = r; hw = w;
            reset = 0x0;
        } reserved_3_3[3:3];
        field {
            name = "scaledwn_enum_time";
            desc = "Port enumeration time scale down enable
- 0: disabled
- 1: enabled";
            sw = rw; hw = r;
            reset = 0x0;
        } scaledwn_enum_time[2:2];
        field {
            name = "hccparam_en";
            desc = "HCCPARAMS register write enable
- 0: disabled
- 1: enabled";
            sw = rw; hw = r;
            reset = 0x0;
        } hccparam_en[1:1];
        field {
            name = "hcsparam_en";
            desc = "HCSPARAMS register write enable
- 0: disabled
- 1: enabled";
            sw = rw; hw = r;
            reset = 0x0;
        } hcsparam_en[0:0];
    } INTNREG04 @ 0xA0;
    reg {
        name = "INTNREG05";
        desc = "INTNREG05 is a control and status register. It is used to read or write to the PHY. (offset 0xA4; total reset 0x00001000; PROVEN: Hi3521A/Hi3520D V300 data sheet (Issue 00B07, 2015-12-10), section 13.7.5, PDF page 1642).";
        field {
            name = "reserved";
            desc = "Reserved";
            sw = r; hw = w;
            reset = 0x0;
        } reserved_31_18[31:18];
        field {
            name = "vbusy";
            desc = "The value 1 indicates that the hardware is writing data. This bit is cleared only when the process ends.";
            sw = r; hw = w;
            reset = 0x0;
        } vbusy[17:17];
        field {
            name = "vport";
            desc = "Port ID. It cannot exceed the supported number of ports.";
            sw = rw; hw = r;
            reset = 0x0;
        } vport[16:13];
        field {
            name = "vcontrol_loadm";
            desc = "Load enable
- 0: enabled
- 1: disabled";
            sw = rw; hw = r;
            reset = 0x1;
        } vcontrol_loadm[12:12];
        field {
            name = "vcontrol";
            desc = "Port control signal";
            sw = rw; hw = r;
            reset = 0x0;
        } vcontrol[11:8];
        field {
            name = "vstatus";
            desc = "Port status signal";
            sw = r; hw = w;
            reset = 0x0;
        } vstatus[7:0];
    } INTNREG05 @ 0xA4;
    reg {
        name = "INTNREG06";
        desc = "INTNREG06 is an AHB error status register. (offset 0xA8; total reset 0x00000000; PROVEN: Hi3521A/Hi3520D V300 data sheet (Issue 00B07, 2015-12-10), section 13.7.5, PDF page 1643).";
        field {
            name = "err_capture";
            desc = "AHB error";
            sw = rw; hw = r;
            reset = 0x0;
        } err_capture[31:31];
        field {
            name = "reserved";
            desc = "Reserved";
            sw = r; hw = w;
            reset = 0x0;
        } reserved_30_12[30:12];
        field {
            name = "hbusrt_err";
            desc = "hbrust value during a control transfer when an AHB error occurs";
            sw = r; hw = w;
            reset = 0x0;
        } hbusrt_err[11:9];
        field {
            name = "num_beat_err";
            desc = "Number of beats during a burst transfer when an AHB error occurs. The maximum number of beats is 16. 0x00-0x10: valid 0x11-0x1F: reserved";
            sw = r; hw = w;
            reset = 0x0;
        } num_beat_err[8:4];
        field {
            name = "num_beat_ok";
            desc = "Number of completed beats during a burst transfer when an AHB error occurs";
            sw = r; hw = w;
            reset = 0x0;
        } num_beat_ok[3:0];
    } INTNREG06 @ 0xA8;
    reg {
        name = "INTNREG07";
        desc = "INTNREG07 is an AHB error address register. (offset 0xAC; total reset 0x00000000; PROVEN: Hi3521A/Hi3520D V300 data sheet (Issue 00B07, 2015-12-10), section 13.7.5, PDF page 1644).";
        field {
            name = "err_addr";
            desc = "Address during a control transfer when an AHB error occurs Contents";
            sw = r; hw = w;
            reset = 0x0;
        } err_addr[31:0];
    } INTNREG07 @ 0xAC;
};
`endif
