`ifndef HI3520DV300_SATA_AHCI_RDL
`define HI3520DV300_SATA_AHCI_RDL
regfile eHI3520DV300_SATA_AHCI {
    name = "SATA AHCI global and vendor registers";
    desc = "SATA AHCI global and vendor registers of the Hi3521A/Hi3520D V300 at base 0x1101_0000. 25 registers extracted programmatically from the Hi3521A/Hi3520D V300 data sheet (Issue 00B07, 2015-12-10) (Table 13-12 Summary of SATA registers (base address: 0x1101_0000)): register headings, offsets, total reset values, field bit ranges, access types, names, reset values and descriptions, with PDF page numbers in each register description. Field names, bit ranges, access types and offsets are exact; the free-text descriptions are taken from the cell text of the field table and were checked by sampling only. Hardware not verified.";
    reg {
        name = "SATA_GHC_CAP1";
        desc = "SATA_GHC_CAP1 is feature support register 1. (offset 0x0; total reset 0x6F377FA1; PROVEN: Hi3521A/Hi3520D V300 data sheet (Issue 00B07, 2015-12-10), section 13.6.7.1, PDF page 1589).";
        field {
            name = "s64a";
            desc = "Fixed at 0, indicating that the 64-bit data structure cannot be accessed.";
            sw = r; hw = w;
            reset = 0x0;
        } s64a[31:31];
        field {
            name = "sncq";
            desc = "Fixed at 1, indicating that NCQ is supported.";
            sw = r; hw = w;
            reset = 0x1;
        } sncq[30:30];
        field {
            name = "ssntf";
            desc = "Fixed at 1, indicating that the port SNTF register is supported.";
            sw = r; hw = w;
            reset = 0x1;
        } ssntf[29:29];
        field {
            name = "smps";
            desc = "Fixed at 0, indicating that mechanical hot-plugging is not supported.";
            sw = r; hw = w;
            reset = 0x0;
        } smps[28:28];
        field {
            name = "sss";
            desc = "Fixed at 1, indicating that staggered spin-up is supported.";
            sw = r; hw = w;
            reset = 0x1;
        } sss[27:27];
        field {
            name = "salp";
            desc = "Fixed at 1, indicating that power supply management is supported.";
            sw = r; hw = w;
            reset = 0x1;
        } salp[26:26];
        field {
            name = "sal";
            desc = "Fixed at 1, indicating that the LED pin is supported.";
            sw = r; hw = w;
            reset = 0x1;
        } sal[25:25];
        field {
            name = "sclo";
            desc = "Fixed at 1, indicating that command linked list override is supported.";
            sw = r; hw = w;
            reset = 0x1;
        } sclo[24:24];
        field {
            name = "iss";
            desc = "Fixed at 0x3, indicating that the maximum rate is 6 Gbit/s.";
            sw = r; hw = w;
            reset = 0x3;
        } iss[23:20];
        field {
            name = "reserved";
            desc = "Reserved";
            sw = r; hw = w;
            reset = 0x0;
        } reserved_19_19[19:19];
        field {
            name = "sam";
            desc = "Fixed at 1, indicating that only the AHCI mode is supported.";
            sw = r; hw = w;
            reset = 0x1;
        } sam[18:18];
        field {
            name = "spm";
            desc = "Fixed at 1, indicating that the port multiplier is supported.";
            sw = r; hw = w;
            reset = 0x1;
        } spm[17:17];
        field {
            name = "fbss";
            desc = "Fixed at 1, indicating that FIS-based switching is supported.";
            sw = r; hw = w;
            reset = 0x1;
        } fbss[16:16];
        field {
            name = "pmd";
            desc = "Fixed at 0, indicating that multiple DRQ blocks cannot be transferred in PIO mode.";
            sw = r; hw = w;
            reset = 0x0;
        } pmd[15:15];
        field {
            name = "ssc";
            desc = "Fixed at 1, indicating that the transition to the slumber status is supported.";
            sw = r; hw = w;
            reset = 0x1;
        } ssc[14:14];
        field {
            name = "psc";
            desc = "Fixed at 1, indicating that the transition to the partial status is supported.";
            sw = r; hw = w;
            reset = 0x1;
        } psc[13:13];
        field {
            name = "ncs";
            desc = "Fixed at 0x1F, indicating that 32 command slots are supported.";
            sw = r; hw = w;
            reset = 0x1f;
        } ncs[12:8];
        field {
            name = "cccs";
            desc = "Fixed at 1, indicating that the CCC function is supported.";
            sw = r; hw = w;
            reset = 0x1;
        } cccs[7:7];
        field {
            name = "ems";
            desc = "Fixed at 0, indicating that enclose management is not supported.";
            sw = r; hw = w;
            reset = 0x0;
        } ems[6:6];
        field {
            name = "sxs";
            desc = "Fixed at 1, indicating that the external SATA port is supported.";
            sw = r; hw = w;
            reset = 0x1;
        } sxs[5:5];
        field {
            name = "np";
            desc = "Fixed at 0x01, indicating that two SATA ports are supported.";
            sw = r; hw = w;
            reset = 0x1;
        } np[4:0];
    } SATA_GHC_CAP1 @ 0x0;
    reg {
        name = "SATA_GHC_GHC";
        desc = "SATA_GHC_GHC is a global control register. (offset 0x4; total reset 0x80000000; PROVEN: Hi3521A/Hi3520D V300 data sheet (Issue 00B07, 2015-12-10), section 13.6.7.1, PDF page 1590).";
        field {
            name = "ahci_en";
            desc = "Fixed at 1, indicating that the software can interact with the controller only through the AHCI mechanism.";
            sw = r; hw = w;
            reset = 0x1;
        } ahci_en[31:31];
        field {
            name = "reserved";
            desc = "Reserved";
            sw = r; hw = w;
            reset = 0x0;
        } reserved_30_2[30:2];
        field {
            name = "int_enable";
            desc = "Controller interrupt enable
- 0: disabled
- 1: enabled";
            sw = rw; hw = r;
            reset = 0x0;
        } int_enable[1:1];
        field {
            name = "hba_rst";
            desc = "Soft reset control for the controller
- 0: not reset
- 1: reset

Writing 1 resets the controller and this bit is automatically cleared after reset; writing 0 has no effect. In addition, reset has no effect on the registers SATA_GHC_BOHC, SATA_PORT_FB, and SATA_PORT_CLB.";
            sw = rw; hw = r;
            reset = 0x0;
        } hba_rst[0:0];
    } SATA_GHC_GHC @ 0x4;
    reg {
        name = "SATA_GHC_IS";
        desc = "SATA_GHC_IS is an interrupt status register. (offset 0x8; total reset 0x00000000; PROVEN: Hi3521A/Hi3520D V300 data sheet (Issue 00B07, 2015-12-10), section 13.6.7.1, PDF page 1591).";
        field {
            name = "ips_ccc";
            desc = "CCC interrupt status
- 0: No CCC interrupt is generated.
- 1: A CCC interrupt is generated.

Access type WC in the data sheet: written 1 clears the bit.";
            sw = rw; hw = w; onwrite = woclr;
            reset = 0x0;
        } ips_ccc[31:31];
        field {
            name = "reserved";
            desc = "Reserved";
            sw = r; hw = w;
            reset = 0x0;
        } reserved_30_2[30:2];
        field {
            name = "ips_port1";
            desc = "Interrupt status of port 1
- 0: No interrupt is reported.
- 1: An interrupt is reported.

Access type WC in the data sheet: written 1 clears the bit.";
            sw = rw; hw = w; onwrite = woclr;
            reset = 0x0;
        } ips_port1[1:1];
        field {
            name = "ips_port0";
            desc = "Interrupt status of port 0
- 0: No interrupt is reported.
- 1: An interrupt is reported.

Access type WC in the data sheet: written 1 clears the bit.";
            sw = rw; hw = w; onwrite = woclr;
            reset = 0x0;
        } ips_port0[0:0];
    } SATA_GHC_IS @ 0x8;
    reg {
        name = "SATA_GHC_PI";
        desc = "SATA_GHC_PI is a port implementation register. (offset 0xC; total reset 0x00000003; PROVEN: Hi3521A/Hi3520D V300 data sheet (Issue 00B07, 2015-12-10), section 13.6.7.1, PDF page 1591).";
        field {
            name = "reserved";
            desc = "Reserved";
            sw = r; hw = w;
            reset = 0x0;
        } reserved_31_2[31:2];
        field {
            name = "port_imp";
            desc = "Port validity indicator. If the value is 0x3, three ports (ports 0-1) are valid. Bit[1] to bit[0] correspond to port 1 to port 0 respectively.
- 0: invalid
- 1: valid";
            sw = r; hw = w;
            reset = 0x3;
        } port_imp[1:0];
    } SATA_GHC_PI @ 0xC;
    reg {
        name = "SATA_GHC_VS";
        desc = "SATA_GHC_VS is an AHCI version identifier register. (offset 0x10; total reset 0x00010300; PROVEN: Hi3521A/Hi3520D V300 data sheet (Issue 00B07, 2015-12-10), section 13.6.7.1, PDF page 1592).";
        field {
            name = "achi_vs";
            desc = "The supported AHCI version is V1.3.";
            sw = r; hw = w;
            reset = 0x10300;
        } achi_vs[31:0];
    } SATA_GHC_VS @ 0x10;
    reg {
        name = "SATA_GHC_CCC_CTL";
        desc = "SATA_GHC_CCC_CTL is a CCC control register. (offset 0x14; total reset 0x000101F8; PROVEN: Hi3521A/Hi3520D V300 data sheet (Issue 00B07, 2015-12-10), section 13.6.7.1, PDF page 1592).";
        field {
            name = "ccc_tv";
            desc = "CCC timeout parameter, in the unit of ms When the CCC function is enabled, the timeout counter loads this parameter value. If a command is executed on a port involved in CCC counting, the counter decreases by 1 every 1 ms until a CCC interrupt is generated when the counter reaches 0. Then the counter reloads the parameter value for the next counting. Note that these bits cannot be set to 0s.";
            sw = rw; hw = r;
            reset = 0x1;
        } ccc_tv[31:16];
        field {
            name = "ccc_cc";
            desc = "CCC command completion upper limit When the CCC function is enabled, the counter is cleared after commands are executed. Then the counter starts to count the number of completed commands on the ports involved in CCC counting. If the count value is greater than or equal to the parameter value, a CCC interrupt is generated. In this case, the counter is cleared again for the next counting. If the value 0 is written, the command completion interrupt is disabled and the CCC interrupt is generated only after timeout.";
            sw = rw; hw = r;
            reset = 0x1;
        } ccc_cc[15:8];
        field {
            name = "ccc_int";
            desc = "CCC interrupt vector ID. If the value is 0x1F (31), SATA_GHC_IS bit[31] indicates the CCC interrupt status.";
            sw = r; hw = w;
            reset = 0x1f;
        } ccc_int[7:3];
        field {
            name = "reserved";
            desc = "Reserved";
            sw = r; hw = w;
            reset = 0x0;
        } reserved_2_1[2:1];
        field {
            name = "ccc_en";
            desc = "CCC function enable
- 0: disabled
- 1: enabled

When the CCC function is enabled, the values of ccc_tv and ccc_cc cannot be changed.";
            sw = rw; hw = r;
            reset = 0x0;
        } ccc_en[0:0];
    } SATA_GHC_CCC_CTL @ 0x14;
    reg {
        name = "SATA_GHC_CCC_PORTS";
        desc = "SATA_GHC_CCC_PORTS is a CCC port enable register. (offset 0x18; total reset 0x00000000; PROVEN: Hi3521A/Hi3520D V300 data sheet (Issue 00B07, 2015-12-10), section 13.6.7.1, PDF page 1593).";
        field {
            name = "reserved";
            desc = "Reserved";
            sw = r; hw = w;
            reset = 0x0;
        } reserved_31_2[31:2];
        field {
            name = "ccc_prt";
            desc = "Specifies the port that is involved in CCC counting. Bit[1] to bit[0] correspond to port 1 to port 0 respectively. If the related bit is 1, the port is involved in CCC counting. If the related bit is 0. The port is not involved in CCC counting. The value of this register can be changed at any time and the changed value takes effect immediately.";
            sw = rw; hw = r;
            reset = 0x0;
        } ccc_prt[1:0];
    } SATA_GHC_CCC_PORTS @ 0x18;
    reg {
        name = "SATA_GHC_CAP2";
        desc = "SATA_GHC_CAP2 is feature support register 2. (offset 0x24; total reset 0x00000001; PROVEN: Hi3521A/Hi3520D V300 data sheet (Issue 00B07, 2015-12-10), section 13.6.7.1, PDF page 1594).";
        field {
            name = "reserved";
            desc = "Reserved";
            sw = r; hw = w;
            reset = 0x0;
        } reserved_31_1[31:1];
        field {
            name = "cap_boh";
            desc = "Fixed at 1, indicating that BIOS/OS handoff control is supported.";
            sw = r; hw = w;
            reset = 0x1;
        } cap_boh[0:0];
    } SATA_GHC_CAP2 @ 0x24;
    reg {
        name = "SATA_GHC_BOHC";
        desc = "SATA_GHC_BOHC is a BIOS/OS handoff control register. (offset 0x28; total reset 0x00000000; PROVEN: Hi3521A/Hi3520D V300 data sheet (Issue 00B07, 2015-12-10), section 13.6.7.1, PDF page 1594).";
        field {
            name = "reserved";
            desc = "Reserved";
            sw = r; hw = w;
            reset = 0x0;
        } reserved_31_5[31:5];
        field {
            name = "bohc_bb";
            desc = "BIOS status indicator
- 0: The BIOS is not busy.
- 1: The BIOS is busy in performing certain operations and is ready to hand the control permission off to the OS.";
            sw = rw; hw = r;
            reset = 0x0;
        } bohc_bb[4:4];
        field {
            name = "bohc_ooc";
            desc = "When the value of bohc_oos is changed from 0 to 1, this bit is fixed at 1. Writing 1 clears this bit and writing 0 has no effect.

Access type WC in the data sheet: written 1 clears the bit.";
            sw = rw; hw = w; onwrite = woclr;
            reset = 0x0;
        } bohc_ooc[3:3];
        field {
            name = "bohc_sooe";
            desc = "Message interrupt enable
- 0: No message interrupt is generated.
- 1: When bohc_ooc is set to 1, a message interrupt is generated.";
            sw = rw; hw = r;
            reset = 0x0;
        } bohc_sooe[2:2];
        field {
            name = "bohc_oos";
            desc = "Request applied by the OS for controlling the controller
- 0: The OS does not apply for the control permission on the controller.
- 1: The OS applies for the control permission on the controller. If bohc_oos is 1 and bios_bos is 0, it indicates that the OS has obtained the control permission on the SATA controller. Resetting the SATA controller through SATA_GHC_GHC[hab_rst] has no effect on this bit.";
            sw = rw; hw = r;
            reset = 0x0;
        } bohc_oos[1:1];
        field {
            name = "bohc_bos";
            desc = "Flag indicating that the BIOS has the control permission on the controller
- 0: The BIOS does not have the control permission on the controller.
- 1: The BIOS has the control permission on the controller. If the

OS applies for the control permission on the controller, the BIOS clears this bit. Resetting the SATA controller through SATA_GHC_GHC[hab_rst] has no effect on this bit.";
            sw = rw; hw = r;
            reset = 0x0;
        } bohc_bos[0:0];
    } SATA_GHC_BOHC @ 0x28;
    reg {
        name = "SATA_PHY0_CTLL";
        desc = "SATA_PHY0_CTLL is a lower-bit PHY 0 global control register. (offset 0xA0; total reset 0x4980003C; PROVEN: Hi3521A/Hi3520D V300 data sheet (Issue 00B07, 2015-12-10), section 13.6.7.1, PDF page 1595).";
        field {
            name = "los_bias";
            desc = "Loss-of-signal detection voltage threshold. This field must be set to 0x2.";
            sw = rw; hw = r;
            reset = 0x2;
        } los_bias[31:29];
        field {
            name = "los_level";
            desc = "Loss-of-signal detection voltage threshold. This field must be set to 0x9.";
            sw = rw; hw = r;
            reset = 0x9;
        } los_level[28:24];
        field {
            name = "reserved";
            desc = "Reserved";
            sw = r; hw = w;
            reset = 0x1;
        } reserved_23_23[23:23];
        field {
            name = "ssc_ref_clk_sel";
            desc = "Spread spectrum clocking shifting";
            sw = rw; hw = r;
            reset = 0x0;
        } ssc_ref_clk_sel[22:14];
        field {
            name = "ssc_range";
            desc = "Clock frequency offset when ssc_en is valid
- 000: -4980
- 001: -4492
- 010: -4003
- 011: -2000
- 100: +4980
- 101: +4492
- 110: +4003
- 111: +2000";
            sw = rw; hw = r;
            reset = 0x0;
        } ssc_range[13:11];
        field {
            name = "ssc_en";
            desc = "Clock spread spectrum enable
- 0: disabled
- 1: enabled";
            sw = rw; hw = r;
            reset = 0x0;
        } ssc_en[10:10];
        field {
            name = "ref_ssp_en";
            desc = "Reference clock enable
- 0: disabled
- 1: enabled";
            sw = rw; hw = r;
            reset = 0x0;
        } ref_ssp_en[9:9];
        field {
            name = "ref_clkdiv2";
            desc = "Whether frequency division is performed on the input reference clock. If the input reference clock is higher than 100 MHz, this bit must be set to 1.";
            sw = rw; hw = r;
            reset = 0x0;
        } ref_clkdiv2[8:8];
        field {
            name = "mpll_multiplier";
            desc = "SerDes MPLL frequency output. The reference clock frequency is multiplied based on the MPLL frequency output to generate required high-frequency clocks. If the reference clock is 100 MHz, the value is set to 7'b0011110.";
            sw = rw; hw = r;
            reset = 0x1e;
        } mpll_multiplier[7:1];
        field {
            name = "reset";
            desc = "Reset signal, active high. This signal must be retained for 5 ns at least.";
            sw = rw; hw = r;
            reset = 0x0;
        } reset_f[0:0];
    } SATA_PHY0_CTLL @ 0xA0;
    reg {
        name = "SATA_PHY0_CTLH";
        desc = "SATA_PHY0_CTLH is an upper-bit PHY 0 global control register. (offset 0xA4; total reset 0x00000008; PROVEN: Hi3521A/Hi3520D V300 data sheet (Issue 00B07, 2015-12-10), section 13.6.7.1, PDF page 1596).";
        field {
            name = "reserved";
            desc = "Reserved";
            sw = r; hw = w;
            reset = 0x0;
        } reserved_31_4[31:4];
        field {
            name = "data_invert";
            desc = "- 0: The endian modes of the PHY and parallel data interface connected to the SATA controller are the same.
- 1: The endian modes of the PHY and parallel data interface connected to the SATA controller are opposite.";
            sw = rw; hw = r;
            reset = 0x1;
        } data_invert[3:3];
        field {
            name = "test_powerdown";
            desc = "Test control signal for controlling the power-down mode of all circuits. This field is used during the IDDQ test.
- 0: not powered down
- 1: powered down";
            sw = rw; hw = r;
            reset = 0x0;
        } test_powerdown[2:2];
        field {
            name = "test_bypass";
            desc = "Test control signal, connected to ground";
            sw = rw; hw = r;
            reset = 0x0;
        } test_bypass[1:1];
        field {
            name = "test_burnin";
            desc = "Test control signal, connected to ground";
            sw = rw; hw = r;
            reset = 0x0;
        } test_burnin[0:0];
    } SATA_PHY0_CTLH @ 0xA4;
    reg {
        name = "SATA_PHY0_STS";
        desc = "SATA_PHY0_STS is a PHY 0 global status register. (offset 0xA8; total reset 0x00000000; PROVEN: Hi3521A/Hi3520D V300 data sheet (Issue 00B07, 2015-12-10), section 13.6.7.1, PDF page 1597).";
        field {
            name = "phy0_sts";
            desc = "Status of the common part of SATA PHY 0";
            sw = r; hw = w;
            reset = 0x0;
        } phy0_sts[31:0];
    } SATA_PHY0_STS @ 0xA8;
    reg {
        name = "SATA_PHY1_CTLL";
        desc = "SATA_PHY1_CTLL is a lower-bit PHY 1 global control register. (offset 0xAC; total reset 0x4980003C; PROVEN: Hi3521A/Hi3520D V300 data sheet (Issue 00B07, 2015-12-10), section 13.6.7.1, PDF page 1597).";
        field {
            name = "los_bias";
            desc = "Loss-of-signal detection voltage threshold. This field must be set to 0x2.";
            sw = rw; hw = r;
            reset = 0x2;
        } los_bias[31:29];
        field {
            name = "los_level";
            desc = "Loss-of-signal detection voltage threshold. This field must be set to 0x9.";
            sw = rw; hw = r;
            reset = 0x9;
        } los_level[28:24];
        field {
            name = "reserved";
            desc = "Reserved";
            sw = r; hw = w;
            reset = 0x1;
        } reserved_23_23[23:23];
        field {
            name = "ssc_ref_clk_sel";
            desc = "Spread spectrum clocking shifting";
            sw = rw; hw = r;
            reset = 0x0;
        } ssc_ref_clk_sel[22:14];
        field {
            name = "ssc_range";
            desc = "Clock frequency offset when ssc_en is valid
- 000: -4980
- 001: -4492
- 010: -4003
- 011: -2000
- 100: +4980
- 101: +4492
- 110: +4003
- 111: +2000";
            sw = rw; hw = r;
            reset = 0x0;
        } ssc_range[13:11];
        field {
            name = "ssc_en";
            desc = "Clock spread spectrum enable
- 0: disabled
- 1: enabled";
            sw = rw; hw = r;
            reset = 0x0;
        } ssc_en[10:10];
        field {
            name = "ref_ssp_en";
            desc = "Reference clock enable
- 0: disabled
- 1: enabled";
            sw = rw; hw = r;
            reset = 0x0;
        } ref_ssp_en[9:9];
        field {
            name = "ref_clkdiv2";
            desc = "Whether frequency division is performed on the input reference clock. If the input reference clock is higher than 100 MHz, this bit must be set to 1.";
            sw = rw; hw = r;
            reset = 0x0;
        } ref_clkdiv2[8:8];
        field {
            name = "mpll_multiplier";
            desc = "SerDes MPLL frequency output. The reference clock frequency is multiplied based on the MPLL frequency output to generate required high-frequency clocks. If the reference clock is 100 MHz, the value is set to 7'b0011110.";
            sw = rw; hw = r;
            reset = 0x1e;
        } mpll_multiplier[7:1];
        field {
            name = "reset";
            desc = "Reset signal, active high. This signal must be retained for 5 ns at least.";
            sw = rw; hw = r;
            reset = 0x0;
        } reset_f[0:0];
    } SATA_PHY1_CTLL @ 0xAC;
    reg {
        name = "SATA_PHY1_CTLH";
        desc = "SATA_PHY1_CTLH is an upper-bit PHY 1 global control register. (offset 0xB0; total reset 0x00000008; PROVEN: Hi3521A/Hi3520D V300 data sheet (Issue 00B07, 2015-12-10), section 13.6.7.1, PDF page 1599).";
        field {
            name = "reserved";
            desc = "Reserved";
            sw = r; hw = w;
            reset = 0x0;
        } reserved_31_4[31:4];
        field {
            name = "data_invert";
            desc = "- 0: The endian modes of the PHY and parallel data interface connected to the SATA controller are the same.
- 1: The endian modes of the PHY and parallel data interface connected to the SATA controller are opposite.";
            sw = rw; hw = r;
            reset = 0x1;
        } data_invert[3:3];
        field {
            name = "test_powerdown";
            desc = "Test control signal for controlling the power-down mode of all circuits. This field is used during the IDDQ test.
- 0: not powered down
- 1: powered down";
            sw = rw; hw = r;
            reset = 0x0;
        } test_powerdown[2:2];
        field {
            name = "test_bypass";
            desc = "Test control signal, connected to ground";
            sw = rw; hw = r;
            reset = 0x0;
        } test_bypass[1:1];
        field {
            name = "test_burnin";
            desc = "Test control signal, connected to ground";
            sw = rw; hw = r;
            reset = 0x0;
        } test_burnin[0:0];
    } SATA_PHY1_CTLH @ 0xB0;
    reg {
        name = "SATA_PHY1_STS";
        desc = "SATA_PHY1_STS is a PHY 1 global status register. (offset 0xB4; total reset 0x00000000; PROVEN: Hi3521A/Hi3520D V300 data sheet (Issue 00B07, 2015-12-10), section 13.6.7.1, PDF page 1599).";
        field {
            name = "phy1_sts";
            desc = "Status of the common part of SATA PHY 1";
            sw = r; hw = w;
            reset = 0x0;
        } phy1_sts[31:0];
    } SATA_PHY1_STS @ 0xB4;
    reg {
        name = "SATA_OOB_CTL";
        desc = "SATA_OOB_CTL is a PHY OOB control register. (offset 0xB8; total reset 0x84060C15; PROVEN: Hi3521A/Hi3520D V300 data sheet (Issue 00B07, 2015-12-10), section 13.6.7.1, PDF page 1600).";
        field {
            name = "oob_ctrl_valid";
            desc = "Configuration bit of the OOB detection parameter. For high level, this bit is used to select the parameter configurations of this register.";
            sw = rw; hw = r;
            reset = 0x1;
        } oob_ctrl_valid[31:31];
        field {
            name = "min_comiwake";
            desc = "Minimum space required for the COMWAKE space detection";
            sw = rw; hw = r;
            reset = 0x4;
        } min_comiwake[30:24];
        field {
            name = "max_comwake";
            desc = "Maximum space required for the COMWAKE space detection";
            sw = rw; hw = r;
            reset = 0x6;
        } max_comwake[23:16];
        field {
            name = "min_cominit";
            desc = "Minimum space required for the COMINIT space detection";
            sw = rw; hw = r;
            reset = 0xc;
        } min_cominit[15:8];
        field {
            name = "max_cominit";
            desc = "Maximum space required for the COMINIT space detection";
            sw = rw; hw = r;
            reset = 0x15;
        } max_cominit[7:0];
    } SATA_OOB_CTL @ 0xB8;
    reg {
        name = "SATA_AXI_DFX0";
        desc = "SATA_AXI_DFX0 is a SATA AXI bus control register. (offset 0xBC; total reset 0x00000000; PROVEN: Hi3521A/Hi3520D V300 data sheet (Issue 00B07, 2015-12-10), section 13.6.7.1, PDF page 1600).";
        field {
            name = "reserved";
            desc = "Reserved";
            sw = r; hw = w;
            reset = 0x0;
        } reserved_31_16[31:16];
        field {
            name = "cnt_wr3";
            desc = "Whether to enable the DFX function on internal AXI channel 3 (SATA port 1 RX DMAC) in the write direction. This bit is active high.
- 0: disabled
- 1: enabled";
            sw = rw; hw = r;
            reset = 0x0;
        } cnt_wr3[15:15];
        field {
            name = "cnt_wr2";
            desc = "Whether to enable the DFX function on internal AXI channel 2 (SATA port 1 RX DMAC) in the write direction. This bit is active high.
- 0: disabled
- 1: enabled";
            sw = rw; hw = r;
            reset = 0x0;
        } cnt_wr2[14:14];
        field {
            name = "cnt_wr1";
            desc = "Whether to enable the DFX function on internal AXI channel 1 (SATA port 0 RX DMAC) in the write direction. This bit is active high.
- 0: disabled
- 1: enabled";
            sw = rw; hw = r;
            reset = 0x0;
        } cnt_wr1[13:13];
        field {
            name = "cnt_wr0";
            desc = "Whether to enable the DFX function on internal AXI channel 0 (SATA port 0 TX DMAC) in the write direction. This bit is active high.
- 0: disabled
- 1: enabled";
            sw = rw; hw = r;
            reset = 0x0;
        } cnt_wr0[12:12];
        field {
            name = "reserved";
            desc = "Reserved";
            sw = r; hw = w;
            reset = 0x0;
        } reserved_11_8[11:8];
        field {
            name = "cnt_rd3";
            desc = "Whether to enable the DFX function on internal AXI channel 3 (SATA port 1 RX DMAC) in the read direction. This bit is active high.
- 0: disabled
- 1: enabled";
            sw = rw; hw = r;
            reset = 0x0;
        } cnt_rd3[7:7];
        field {
            name = "cnt_rd2";
            desc = "Whether to enable the DFX function on internal AXI channel 2 (SATA port 1 TX DMAC) in the read direction. This bit is active high.
- 0: disabled
- 1: enabled";
            sw = rw; hw = r;
            reset = 0x0;
        } cnt_rd2[6:6];
        field {
            name = "cnt_rd1";
            desc = "Whether to enable the DFX function on internal AXI channel 1 (SATA port 0 RX DMAC) in the read direction. This bit is active high.
- 0: disabled
- 1: enabled";
            sw = rw; hw = r;
            reset = 0x0;
        } cnt_rd1[5:5];
        field {
            name = "cnt_rd0";
            desc = "Whether to enable the DFX function on internal AXI channel 0 (SATA port 0 TX DMAC) in the read direction. This bit is active high.
- 0: disabled
- 1: enabled";
            sw = rw; hw = r;
            reset = 0x0;
        } cnt_rd0[4:4];
        field {
            name = "cnt_wr_latency_clr";
            desc = "Clear of the latency debugging register of the current write channel, active high
- 0: not cleared
- 1: cleared";
            sw = rw; hw = r;
            reset = 0x0;
        } cnt_wr_latency_clr[3:3];
        field {
            name = "cnt_wr_acc_clr";
            desc = "Clear of the total command number debugging register of the current write channel, active high
- 0: not cleared
- 1: cleared";
            sw = rw; hw = r;
            reset = 0x0;
        } cnt_wr_acc_clr[2:2];
        field {
            name = "cnt_rd_latency_clr";
            desc = "Clear of the latency debugging register of the current read channel, active high
- 0: not cleared
- 1: cleared";
            sw = rw; hw = r;
            reset = 0x0;
        } cnt_rd_latency_clr[1:1];
        field {
            name = "cnt_rd_acc_clr";
            desc = "Clear of the total command number debugging register of the current read channel, active high
- 0: not cleared
- 1: cleared";
            sw = rw; hw = r;
            reset = 0x0;
        } cnt_rd_acc_clr[0:0];
    } SATA_AXI_DFX0 @ 0xBC;
    reg {
        name = "SATA_AXI_DFX1";
        desc = "SATA_AXI_DFX1 is SATA AXI bus status register 1. (offset 0xC0; total reset 0x00000000; PROVEN: Hi3521A/Hi3520D V300 data sheet (Issue 00B07, 2015-12-10), section 13.6.7.1, PDF page 1602).";
        field {
            name = "reserved";
            desc = "Reserved";
            sw = r; hw = w;
            reset = 0x0;
        } reserved_31_16[31:16];
        field {
            name = "cnt_rd_latency_max";
            desc = "DFX signals, indicating the maximum latency (in cycle) of the current read channel";
            sw = r; hw = w;
            reset = 0x0;
        } cnt_rd_latency_max[15:0];
    } SATA_AXI_DFX1 @ 0xC0;
    reg {
        name = "SATA_AXI_DFX2";
        desc = "SATA_AXI_DFX2 is SATA AXI bus status register 2. (offset 0xC4; total reset 0x0000001F; PROVEN: Hi3521A/Hi3520D V300 data sheet (Issue 00B07, 2015-12-10), section 13.6.7.1, PDF page 1602).";
        field {
            name = "reserved";
            desc = "Reserved";
            sw = r; hw = w;
            reset = 0x0;
        } reserved_31_16[31:16];
        field {
            name = "cnt_rd_latency_avg";
            desc = "DFX signals, indicating the average latency (in cycle) of the current read channel";
            sw = r; hw = w;
            reset = 0x1f;
        } cnt_rd_latency_avg[15:0];
    } SATA_AXI_DFX2 @ 0xC4;
    reg {
        name = "SATA_AXI_DFX3";
        desc = "SATA_AXI_DFX3 is SATA AXI bus to the status register 3. (offset 0xC8; total reset 0x00000000; PROVEN: Hi3521A/Hi3520D V300 data sheet (Issue 00B07, 2015-12-10), section 13.6.7.1, PDF page 1603).";
        field {
            name = "reserved";
            desc = "Reserved";
            sw = r; hw = w;
            reset = 0x0;
        } reserved_31_16[31:16];
        field {
            name = "cnt_wr_latency_max";
            desc = "DFX signals, indicating the maximum latency (in cycle) of the current write channel";
            sw = r; hw = w;
            reset = 0x0;
        } cnt_wr_latency_max[15:0];
    } SATA_AXI_DFX3 @ 0xC8;
    reg {
        name = "SATA_AXI_DFX4";
        desc = "SATA_AXI_DFX4 is SATA AXI bus status register 4. (offset 0xCC; total reset 0x0000001F; PROVEN: Hi3521A/Hi3520D V300 data sheet (Issue 00B07, 2015-12-10), section 13.6.7.1, PDF page 1603).";
        field {
            name = "reserved";
            desc = "Reserved";
            sw = r; hw = w;
            reset = 0x0;
        } reserved_31_16[31:16];
        field {
            name = "cnt_wr_latency_avg";
            desc = "DFX signal, indicating the average latency (in cycle) of the current write channel";
            sw = r; hw = w;
            reset = 0x1f;
        } cnt_wr_latency_avg[15:0];
    } SATA_AXI_DFX4 @ 0xCC;
    reg {
        name = "SATA_AXI_DFX5";
        desc = "SATA_AXI_DFX5 is SATA AXI bus status register 5. (offset 0xD0; total reset 0x00000000; PROVEN: Hi3521A/Hi3520D V300 data sheet (Issue 00B07, 2015-12-10), section 13.6.7.1, PDF page 1604).";
        field {
            name = "cnt_rd_acc3";
            desc = "DFX signal, indicating the total number of current read commands of AXI master port 3 (corresponding to the SATA port 1 RX DMAC)";
            sw = r; hw = w;
            reset = 0x0;
        } cnt_rd_acc3[31:24];
        field {
            name = "cnt_rd_acc2";
            desc = "DFX signal, indicating the total number of current read commands of AXI master port 2 (corresponding to the SATA port 1 TX DMAC)";
            sw = r; hw = w;
            reset = 0x0;
        } cnt_rd_acc2[23:16];
        field {
            name = "cnt_rd_acc1";
            desc = "DFX signal, indicating the total number of current read commands of AXI master port 1 (corresponding to the SATA port 0 RX DMAC)";
            sw = r; hw = w;
            reset = 0x0;
        } cnt_rd_acc1[15:8];
        field {
            name = "cnt_rd_acc0";
            desc = "DFX signal, indicating the total number of current read commands of AXI master port 0 (corresponding to the SATA port 0 TX DMAC)";
            sw = r; hw = w;
            reset = 0x0;
        } cnt_rd_acc0[7:0];
    } SATA_AXI_DFX5 @ 0xD0;
    reg {
        name = "SATA_AXI_DFX7";
        desc = "SATA_AXI_DFX7 is SATA AXI bus status register 7. (offset 0xD8; total reset 0x00000000; PROVEN: Hi3521A/Hi3520D V300 data sheet (Issue 00B07, 2015-12-10), section 13.6.7.1, PDF page 1604).";
        field {
            name = "cnt_wr_acc3";
            desc = "DFX signal, indicating the total number of current write commands of AXI master port 3 (corresponding to the SATA port 1 RX DMAC)";
            sw = r; hw = w;
            reset = 0x0;
        } cnt_wr_acc3[31:24];
        field {
            name = "cnt_wr_acc2";
            desc = "DFX signal, indicating the total number of current write commands of AXI master port 2 (corresponding to the SATA port 1 TX DMAC)";
            sw = r; hw = w;
            reset = 0x0;
        } cnt_wr_acc2[23:16];
        field {
            name = "cnt_wr_acc1";
            desc = "DFX signal, indicating the total number of current write commands of AXI master port 1 (corresponding to the SATA port 0 RX DMAC)";
            sw = r; hw = w;
            reset = 0x0;
        } cnt_wr_acc1[15:8];
        field {
            name = "cnt_wr_acc0";
            desc = "DFX signal, indicating the total number of current write commands of AXI master port 0 (corresponding to the SATA port 0 TX DMAC)";
            sw = r; hw = w;
            reset = 0x0;
        } cnt_wr_acc0[7:0];
    } SATA_AXI_DFX7 @ 0xD8;
    reg {
        name = "SATA_AXI_DFX9";
        desc = "SATA_AXI_DFX9 is SATA AXI bus status register 9. (offset 0xE0; total reset 0x00000000; PROVEN: Hi3521A/Hi3520D V300 data sheet (Issue 00B07, 2015-12-10), section 13.6.7.1, PDF page 1605).";
        field {
            name = "cnt_rd_otd3";
            desc = "DFX signal, indicating the total number of current read outstanding commands of AXI master port 3 (corresponding to the SATA port 1 RX DMAC)";
            sw = r; hw = w;
            reset = 0x0;
        } cnt_rd_otd3[31:24];
        field {
            name = "cnt_rd_otd2";
            desc = "DFX signal, indicating the total number of current read outstanding commands of AXI master port 2 (corresponding to the SATA port 1 TX DMAC)";
            sw = r; hw = w;
            reset = 0x0;
        } cnt_rd_otd2[23:16];
        field {
            name = "cnt_rd_otd1";
            desc = "DFX signal, indicating the total number of current read outstanding commands of AXI master port 1 (corresponding to the SATA port 0 RX DMAC)";
            sw = r; hw = w;
            reset = 0x0;
        } cnt_rd_otd1[15:8];
        field {
            name = "cnt_rd_otd0";
            desc = "DFX signal, indicating the total number of current read outstanding commands of AXI master port 0 (corresponding to the SATA port 0 TX DMAC)";
            sw = r; hw = w;
            reset = 0x0;
        } cnt_rd_otd0[7:0];
    } SATA_AXI_DFX9 @ 0xE0;
    reg {
        name = "SATA_AXI_DFX11";
        desc = "SATA_AXI_DFX11 SATA AXI bus to the status register 11. (offset 0xE8; total reset 0x00000000; PROVEN: Hi3521A/Hi3520D V300 data sheet (Issue 00B07, 2015-12-10), section 13.6.7.1, PDF page 1605).";
        field {
            name = "cnt_wr_otd3";
            desc = "DFX signal, indicating the total number of current write outstanding commands of AXI master port 3 (corresponding to the SATA port 1 RX DMAC)";
            sw = r; hw = w;
            reset = 0x0;
        } cnt_wr_otd3[31:24];
        field {
            name = "cnt_wr_otd2";
            desc = "DFX signal, indicating the total number of current write outstanding commands of AXI master port 2 (corresponding to the SATA port 1 TX DMAC)";
            sw = r; hw = w;
            reset = 0x0;
        } cnt_wr_otd2[23:16];
        field {
            name = "cnt_wr_otd1";
            desc = "DFX signal, indicating the total number of current write outstanding commands of AXI master port 1 (corresponding to the SATA port 0 RX DMAC)";
            sw = r; hw = w;
            reset = 0x0;
        } cnt_wr_otd1[15:8];
        field {
            name = "cnt_wr_otd0";
            desc = "DFX signal, indicating the total number of current write outstanding commands of AXI master port 0 (corresponding to the SATA port 0 TX DMAC)";
            sw = r; hw = w;
            reset = 0x0;
        } cnt_wr_otd0[7:0];
    } SATA_AXI_DFX11 @ 0xE8;
};
`endif
