`ifndef HI3520DV300_I2C_RDL
`define HI3520DV300_I2C_RDL
regfile eHI3520DV300_I2C {
    name = "I2C";
    desc = "I2C of the Hi3521A/Hi3520D V300 at base 0x120C0000. 28 registers extracted programmatically from the Hi3521A/Hi3520D V300 data sheet (Issue 00B07, 2015-12-10) (Table 13-1 Summary of I2C registers (base addresses 0x120C_0000.) Offset Register Description Page Address): register headings, offsets, total reset values, field bit ranges, access types, names, reset values and descriptions, with PDF page numbers in each register description. Field names, bit ranges, access types and offsets are exact; the free-text descriptions are taken from the cell text of the field table and were checked by sampling only. Hardware not verified.";
    reg {
        name = "I2C_CON";
        desc = "I2C_CON is an I2C control register. (offset 0x0; total reset 0x00000065; PROVEN: Hi3521A/Hi3520D V300 data sheet (Issue 00B07, 2015-12-10), section 13.1.5, PDF page 1486).";
        field {
            name = "reserved";
            desc = "Reserved";
            sw = r; hw = w;
            reset = 0x0;
        } reserved_31_7[31:7];
        field {
            name = "reserved";
            desc = "Reserved";
            sw = r; hw = w;
            reset = 0x1;
        } reserved_6_6[6:6];
        field {
            name = "restart_en";
            desc = "Restart command TX enable in master mode
- 0: disabled
- 1: enabled

If the Restart function is disabled, the following functions are not supported: 1. Sending the start bit 2. High-speed mode 3. Read operation in 10-bit addressing mode 4. Combined addressing mode";
            sw = rw; hw = r;
            reset = 0x1;
        } restart_en[5:5];
        field {
            name = "reserved";
            desc = "Reserved";
            sw = r; hw = w;
            reset = 0x0;
        } reserved_4_4[4:4];
        field {
            name = "reserved";
            desc = "Reserved";
            sw = r; hw = w;
            reset = 0x0;
        } reserved_3_3[3:3];
        field {
            name = "reserved";
            desc = "Reserved";
            sw = r; hw = w;
            reset = 0x2;
        } reserved_2_1[2:1];
        field {
            name = "reserved";
            desc = "Reserved";
            sw = r; hw = w;
            reset = 0x1;
        } reserved_0_0[0:0];
    } I2C_CON @ 0x0;
    reg {
        name = "I2C_TAR";
        desc = "I2C_TAR is an I2C access slave device address register. (offset 0x4; total reset 0x0000002C; PROVEN: Hi3521A/Hi3520D V300 data sheet (Issue 00B07, 2015-12-10), section 13.1.5, PDF page 1487).";
        field {
            name = "reserved";
            desc = "Reserved";
            sw = r; hw = w;
            reset = 0x0;
        } reserved_31_13[31:13];
        field {
            name = "master_10bit";
            desc = "Address length in master mode
- 0: 7 bits
- 1: 10 bits";
            sw = rw; hw = r;
            reset = 0x0;
        } master_10bit[12:12];
        field {
            name = "special";
            desc = "General call or start byte function enable
- 0: disabled
- 1: enabled";
            sw = rw; hw = r;
            reset = 0x0;
        } special[11:11];
        field {
            name = "gc_or_start";
            desc = "I2C command to be executed when the Special bit is 1
- 0: general call command (After the general call command is sent, you can perform only write operations. If you perform read operations, tx_abort interrupt is triggered. For details about the definition.)
- 1: start byte command";
            sw = rw; hw = r;
            reset = 0x0;
        } gc_or_start[10:10];
        field {
            name = "i2c_tar";
            desc = "Slave address that is accessed by the I2C when I2C acts as a master device If the address length of the slave device is set to 7 bits, only bit [6:0] are valid.";
            sw = rw; hw = r;
            reset = 0x2c;
        } i2c_tar[9:0];
    } I2C_TAR @ 0x4;
    reg {
        name = "I2C_DATA_CMD";
        desc = "I2C_DATA_CMD is an I2C data operation register. (offset 0x10; total reset 0x00000000; PROVEN: Hi3521A/Hi3520D V300 data sheet (Issue 00B07, 2015-12-10), section 13.1.5, PDF page 1488).";
        field {
            name = "reserved";
            desc = "Reserved";
            sw = r; hw = w;
            reset = 0x0;
        } reserved_31_9[31:9];
        field {
            name = "reserved";
            desc = "Reserved";
            sw = r; hw = w;
            reset = 0x0;
        } reserved_8_8[8:8];
        field {
            name = "data";
            desc = "Data to be transmitted or received through the I2C bus Read: The data received from the I2C bus is read. Write: The written data is transmitted to the I2C.";
            sw = rw; hw = r;
            reset = 0x0;
        } data[7:0];
    } I2C_DATA_CMD @ 0x10;
    reg {
        name = "I2C_SCL_HCNT";
        desc = "I2C_SCL_HCNT is an I2C_SCL high level configuration register. (offset 0x1C; total reset 0x00000010; PROVEN: Hi3521A/Hi3520D V300 data sheet (Issue 00B07, 2015-12-10), section 13.1.5, PDF page 1488).";
        field {
            name = "reserved";
            desc = "Reserved";
            sw = r; hw = w;
            reset = 0x0;
        } reserved_31_16[31:16];
        field {
            name = "i2c_scl_hcnt";
            desc = "Number of SCL clock high-level cycles 1. The field must be configured to obtain the appropriate I/O timing before data is transmitted through the I2C bus. 2. You can perform write operations only when the I2C interface is disabled (I2C_ENABLE = 0).";
            sw = rw; hw = r;
            reset = 0x10;
        } i2c_scl_hcnt[15:0];
    } I2C_SCL_HCNT @ 0x1C;
    reg {
        name = "I2C_SCL_LCNT";
        desc = "I2C_SCL_LCNT is an I2C_SCL low level configuration register. (offset 0x20; total reset 0x00000010; PROVEN: Hi3521A/Hi3520D V300 data sheet (Issue 00B07, 2015-12-10), section 13.1.5, PDF page 1489).";
        field {
            name = "reserved";
            desc = "Reserved";
            sw = r; hw = w;
            reset = 0x0;
        } reserved_31_16[31:16];
        field {
            name = "i2c_scl_lcnt";
            desc = "Number of SCL clock low-level cycles 1. The field must be correctly configured to obtain the appropriate I/O timing before data is transmitted through the I2C bus. 2. You can perform write operations only when the I2C interface is disabled (I2C_ENABLE = 0).";
            sw = rw; hw = r;
            reset = 0x10;
        } i2c_scl_lcnt[15:0];
    } I2C_SCL_LCNT @ 0x20;
    reg {
        name = "I2C_INTR_STAT";
        desc = "I2C_INTR_STAT is an interrupt status register after the I2C is masked. (offset 0x2C; total reset 0x00000000; PROVEN: Hi3521A/Hi3520D V300 data sheet (Issue 00B07, 2015-12-10), section 13.1.5, PDF page 1489).";
        field {
            name = "reserved";
            desc = "Reserved";
            sw = r; hw = w;
            reset = 0x0;
        } reserved_31_12[31:12];
        field {
            name = "gen_call";
            desc = "Status of the interrupt indicating that a general call request is received
- 0: No interrupt is generated.
- 1: An interrupt is generated.";
            sw = r; hw = w;
            reset = 0x0;
        } gen_call[11:11];
        field {
            name = "start_det";
            desc = "Status of the start detect interrupt indicating the I2C bus interface has the START or RESTART condition
- 0: No interrupt is generated.
- 1: An interrupt is generated.";
            sw = r; hw = w;
            reset = 0x0;
        } start_det[10:10];
        field {
            name = "stop_det";
            desc = "Status of the start detect interrupt indicating the I2C bus interface has the STOP condition
- 0: No interrupt is generated.
- 1: An interrupt is generated.";
            sw = r; hw = w;
            reset = 0x0;
        } stop_det[9:9];
        field {
            name = "activity";
            desc = "Activity interrupt status. The I2C activity status is recorded until the interrupt is cleared.
- 0: No interrupt is generated.
- 1: An interrupt is generated.";
            sw = r; hw = w;
            reset = 0x0;
        } activity[8:8];
        field {
            name = "reserved";
            desc = "Reserved";
            sw = r; hw = w;
            reset = 0x0;
        } reserved_7_7[7:7];
        field {
            name = "tx_abrt";
            desc = "TX abort interrupt status
- 0: No interrupt is generated.
- 1: An interrupt is generated.";
            sw = r; hw = w;
            reset = 0x0;
        } tx_abrt[6:6];
        field {
            name = "reserved";
            desc = "Reserved";
            sw = r; hw = w;
            reset = 0x0;
        } reserved_5_5[5:5];
        field {
            name = "tx_empty";
            desc = "Status of the interrupt indicating that TX_FIFO reaches or is below the threshold
- 0: No interrupt is generated.
- 1: An interrupt is generated.";
            sw = r; hw = w;
            reset = 0x0;
        } tx_empty[4:4];
        field {
            name = "tx_over";
            desc = "TX_FIFO overflow interrupt status
- 0: No interrupt is generated.
- 1: An interrupt is generated.";
            sw = r; hw = w;
            reset = 0x0;
        } tx_over[3:3];
        field {
            name = "rx_full";
            desc = "Status of the interrupt indicating that RX_FIFO reaches or is above the threshold
- 0: No interrupt is generated.
- 1: An interrupt is generated.";
            sw = r; hw = w;
            reset = 0x0;
        } rx_full[2:2];
        field {
            name = "rx_over";
            desc = "RX_FIFO overflow interrupt status
- 0: No interrupt is generated.
- 1: An interrupt is generated.";
            sw = r; hw = w;
            reset = 0x0;
        } rx_over[1:1];
        field {
            name = "rx_under";
            desc = "Read data overflow (that is, the CPU reads the FIFO when RX_FIFO is empty) interrupt status
- 0: No interrupt is generated.
- 1: An interrupt is generated.";
            sw = r; hw = w;
            reset = 0x0;
        } rx_under[0:0];
    } I2C_INTR_STAT @ 0x2C;
    reg {
        name = "I2C_INTR_MASK";
        desc = "I2C_INTR_MASK is an I2C interrupt mask register. (offset 0x30; total reset 0x00000000; PROVEN: Hi3521A/Hi3520D V300 data sheet (Issue 00B07, 2015-12-10), section 13.1.5, PDF page 1491).";
        field {
            name = "reserved";
            desc = "Reserved";
            sw = r; hw = w;
            reset = 0x0;
        } reserved_31_12[31:12];
        field {
            name = "gen_call_mask";
            desc = "Interrupt mask when a general call request is received
- 0: not masked
- 1: masked";
            sw = rw; hw = r;
            reset = 0x0;
        } gen_call_mask[11:11];
        field {
            name = "start_det_mask";
            desc = "Start detect interrupt mask
- 0: not masked
- 1: masked";
            sw = rw; hw = r;
            reset = 0x0;
        } start_det_mask[10:10];
        field {
            name = "stop_det";
            desc = "Stop detect interrupt mask
- 0: not masked
- 1: masked";
            sw = rw; hw = r;
            reset = 0x0;
        } stop_det[9:9];
        field {
            name = "activity";
            desc = "Activity interrupt mask
- 0: not masked
- 1: masked";
            sw = rw; hw = r;
            reset = 0x0;
        } activity[8:8];
        field {
            name = "reserved";
            desc = "Reserved";
            sw = r; hw = w;
            reset = 0x0;
        } reserved_7_7[7:7];
        field {
            name = "tx_abrt";
            desc = "TX abort interrupt mask
- 0: not masked
- 1: masked";
            sw = rw; hw = r;
            reset = 0x0;
        } tx_abrt[6:6];
        field {
            name = "reserved";
            desc = "Reserved";
            sw = r; hw = w;
            reset = 0x0;
        } reserved_5_5[5:5];
        field {
            name = "tx_empty";
            desc = "Interrupt mask when TX_FIFO reaches or is below the threshold
- 0: not masked
- 1: masked";
            sw = rw; hw = r;
            reset = 0x0;
        } tx_empty[4:4];
        field {
            name = "tx_over";
            desc = "TX_FIFO overflow interrupt mask
- 0: not masked
- 1: masked";
            sw = rw; hw = r;
            reset = 0x0;
        } tx_over[3:3];
        field {
            name = "rx_full";
            desc = "Interrupt mask when RX_FIFO reaches or is below the threshold
- 0: not masked
- 1: masked";
            sw = rw; hw = r;
            reset = 0x0;
        } rx_full[2:2];
        field {
            name = "rx_over";
            desc = "RX_FIFO overflow interrupt mask
- 0: not masked
- 1: masked";
            sw = rw; hw = r;
            reset = 0x0;
        } rx_over[1:1];
        field {
            name = "rx_under";
            desc = "Interrupt mask when read data overflows (The CPU reads the FIFO when RX_FIFO is empty.)
- 0: not masked
- 1: masked";
            sw = rw; hw = r;
            reset = 0x0;
        } rx_under[0:0];
    } I2C_INTR_MASK @ 0x30;
    reg {
        name = "I2C_INTR_RAW";
        desc = "I2C_INTR_RAW is an I2C raw interrupt status register. (offset 0x34; total reset 0x00000000; PROVEN: Hi3521A/Hi3520D V300 data sheet (Issue 00B07, 2015-12-10), section 13.1.5, PDF page 1492).";
        field {
            name = "reserved";
            desc = "Reserved";
            sw = r; hw = w;
            reset = 0x0;
        } reserved_31_12[31:12];
        field {
            name = "gen_call";
            desc = "Interrupt status when a general call request is received
- 0: No interrupt is generated.
- 1: The slave receives the general call.

This bit is set to 1 only when the general call request is received and confirmed. This value is retained unless being cleared.";
            sw = r; hw = w;
            reset = 0x0;
        } gen_call[11:11];
        field {
            name = "start_det";
            desc = "Start detect interrupt status, indicating whether the I2C bus interface has the START or RESTART condition
- 0: No interrupt is generated.
- 1: The START or RESTART condition is detected.";
            sw = r; hw = w;
            reset = 0x0;
        } start_det[10:10];
        field {
            name = "stop_det";
            desc = "Stop detect interrupt status, indicating whether the I2C bus interface has the STOP condition
- 0: No interrupt is generated.
- 1: The STOP condition is detected.";
            sw = r; hw = w;
            reset = 0x0;
        } stop_det[9:9];
        field {
            name = "activity";
            desc = "Activity interrupt status. The I2C activity status is recorded until the interrupt is cleared.
- 0: idle
- 1: busy";
            sw = r; hw = w;
            reset = 0x0;
        } activity[8:8];
        field {
            name = "reserved";
            desc = "Reserved";
            sw = r; hw = w;
            reset = 0x0;
        } reserved_7_7[7:7];
        field {
            name = "tx_abrt";
            desc = "TX abort interrupt status
- 0: No interrupt is generated.
- 1: An interrupt is generated.

When this bit is set to 1, the I2C_TX_ABRT_SRC register indicates the reason for sending the interrupt. If this bit is set to a value, the I2C clears TX_FIFO. TX_FIFO remains in this state until the interrupt is cleared. After the interrupt is cleared, TX_FIFO reads more data over the APB interface.";
            sw = r; hw = w;
            reset = 0x0;
        } tx_abrt[6:6];
        field {
            name = "reserved";
            desc = "Reserved";
            sw = r; hw = w;
            reset = 0x0;
        } reserved_5_5[5:5];
        field {
            name = "tx_empty";
            desc = "Interrupt status when TX_FIFO reaches or is below the threshold
- 0: No interrupt is generated.
- 1: An interrupt is generated.

When data amount of TX_FIFO is below the threshold, this interrupt is automatically cleared. If the I2C is disabled, TX_FIFO is cleared.";
            sw = r; hw = w;
            reset = 0x0;
        } tx_empty[4:4];
        field {
            name = "tx_over";
            desc = "TX_FIFO overflow interrupt status
- 0: No interrupt is generated.
- 1: An interrupt is generated.";
            sw = r; hw = w;
            reset = 0x0;
        } tx_over[3:3];
        field {
            name = "rx_full";
            desc = "Interrupt status when RX_FIFO reaches or is below the threshold
- 0: No interrupt is generated.
- 1: An interrupt is generated.

This bit is set to 1 when RX_FIFO reaches or is below the threshold set by I2C_RX_TL. When RX_FIFO is below the threshold, this interrupt is automatically cleared. If the I2C is disabled, RX_FIFO and this interrupt are automatically cleared.";
            sw = r; hw = w;
            reset = 0x0;
        } rx_full[2:2];
        field {
            name = "rx_over";
            desc = "RX_FIFO overflow interrupt status
- 0: No interrupt is generated.
- 1: An interrupt is generated.

This bit is set to 1 if RX_FIFO is full but still receives bytes from the external I2C device. The I2C responds to data received over the I2C bus. However, bytes received after RX_FIFO is full are lost.";
            sw = r; hw = w;
            reset = 0x0;
        } rx_over[1:1];
        field {
            name = "rx_under";
            desc = "Interrupt status when read data overflows (The CPU reads the FIFO when RX_FIFO is empty.)
- 0: No interrupt is generated.
- 1: An interrupt is generated.";
            sw = r; hw = w;
            reset = 0x0;
        } rx_under[0:0];
    } I2C_INTR_RAW @ 0x34;
    reg {
        name = "I2C_RX_TL";
        desc = "I2C_RX_TL is an RX_FIFO threshold configuration register. (offset 0x38; total reset 0x00000003; PROVEN: Hi3521A/Hi3520D V300 data sheet (Issue 00B07, 2015-12-10), section 13.1.5, PDF page 1494).";
        field {
            name = "reserved";
            desc = "Reserved";
            sw = r; hw = w;
            reset = 0x0;
        } reserved_31_4[31:4];
        field {
            name = "rx_tl";
            desc = "RX_FIFO threshold Valid values: 0-15. The actual value is the configured value plus 1. An rx_full interrupt is triggered when the number of data items in RX_FIFO is greater than or equal to the value. The upper threshold is configured as the RX_FIFO depth by default if the configured value is greater than the RX_FIFO depth.";
            sw = rw; hw = r;
            reset = 0x3;
        } rx_tl[3:0];
    } I2C_RX_TL @ 0x38;
    reg {
        name = "I2C_TX_TL";
        desc = "I2C_TX_TL is a TX_FIFO threshold configuration register. (offset 0x3C; total reset 0x00000004; PROVEN: Hi3521A/Hi3520D V300 data sheet (Issue 00B07, 2015-12-10), section 13.1.5, PDF page 1494).";
        field {
            name = "reserved";
            desc = "Reserved";
            sw = r; hw = w;
            reset = 0x0;
        } reserved_31_4[31:4];
        field {
            name = "tx_tl";
            desc = "TX_FIFO threshold Valid values: 0-15. The actual value is equal to the configured value. A tx_empty interrupt is triggered when the amount of data in TX_FIFO is less than or equal to the value. The upper threshold is configured as the TX_FIFO depth by default if the configured value is greater than the TX_FIFO depth.";
            sw = rw; hw = r;
            reset = 0x4;
        } tx_tl[3:0];
    } I2C_TX_TL @ 0x3C;
    reg {
        name = "I2C_CLR_INTR";
        desc = "I2C_CLR_INTR is an I2C interrupt clear register. (offset 0x40; total reset 0x00000000; PROVEN: Hi3521A/Hi3520D V300 data sheet (Issue 00B07, 2015-12-10), section 13.1.5, PDF page 1495).";
        field {
            name = "reserved";
            desc = "Reserved";
            sw = r; hw = w;
            reset = 0x0;
        } reserved_31_1[31:1];
        field {
            name = "clr_intr";
            desc = "Combined interrupts, all independent interrupts, and the I2C_TX_ABRT_SRC register are cleared when 1 is written to this bit.";
            sw = w; hw = r;
            reset = 0x0;
        } clr_intr[0:0];
    } I2C_CLR_INTR @ 0x40;
    reg {
        name = "I2C_ENABLE";
        desc = "I2C_ENABLE is an I2C enable register. (offset 0x6C; total reset 0x00000000; PROVEN: Hi3521A/Hi3520D V300 data sheet (Issue 00B07, 2015-12-10), section 13.1.5, PDF page 1495).";
        field {
            name = "reserved";
            desc = "Reserved";
            sw = r; hw = w;
            reset = 0x0;
        } reserved_31_1[31:1];
        field {
            name = "enable";
            desc = "I2C enable
- 0: disabled
- 1: enabled";
            sw = rw; hw = r;
            reset = 0x0;
        } enable[0:0];
    } I2C_ENABLE @ 0x6C;
    reg {
        name = "I2C_STATUS";
        desc = "I2C_STATUS is an I2C status register. (offset 0x70; total reset 0x00000006; PROVEN: Hi3521A/Hi3520D V300 data sheet (Issue 00B07, 2015-12-10), section 13.1.5, PDF page 1496).";
        field {
            name = "reserved";
            desc = "Reserved";
            sw = r; hw = w;
            reset = 0x0;
        } reserved_31_7[31:7];
        field {
            name = "reserved";
            desc = "Reserved";
            sw = r; hw = w;
            reset = 0x0;
        } reserved_6_6[6:6];
        field {
            name = "mst_activity";
            desc = "I2C master activity status
- 0: The master enters the idle state, and the I2C is deactivated.
- 1: The master does not enter the idle state, and the I2C is activated.";
            sw = r; hw = w;
            reset = 0x0;
        } mst_activity[5:5];
        field {
            name = "rx_fifo_full";
            desc = "RX_FIFO full flag
- 0: not full
- 1: full";
            sw = r; hw = w;
            reset = 0x0;
        } rx_fifo_full[4:4];
        field {
            name = "rx_fifo_nempty";
            desc = "RX_FIFO non-empty flag
- 0: empty
- 1: non-empty";
            sw = r; hw = w;
            reset = 0x0;
        } rx_fifo_nempty[3:3];
        field {
            name = "tx_fifo_nempty";
            desc = "TX_FIFO empty flag
- 0: non-empty
- 1: empty";
            sw = r; hw = w;
            reset = 0x1;
        } tx_fifo_nempty[2:2];
        field {
            name = "tx_fifo_full";
            desc = "TX_FIFO non-full flag
- 0: full
- 1: not full";
            sw = r; hw = w;
            reset = 0x1;
        } tx_fifo_full[1:1];
        field {
            name = "i2c_activity";
            desc = "I2C operating status
- 0: idle
- 1: active";
            sw = r; hw = w;
            reset = 0x0;
        } i2c_activity[0:0];
    } I2C_STATUS @ 0x70;
    reg {
        name = "I2C_TXFLR";
        desc = "I2C_TXFLR is a TX_FIFO valid data indicator register. (offset 0x74; total reset 0x00000000; PROVEN: Hi3521A/Hi3520D V300 data sheet (Issue 00B07, 2015-12-10), section 13.1.5, PDF page 1497).";
        field {
            name = "reserved";
            desc = "Reserved";
            sw = r; hw = w;
            reset = 0x0;
        } reserved_31_5[31:5];
        field {
            name = "tx_flr";
            desc = "Number of valid data items in TX_FIFO The register is cleared when a tx_abort interrupt is generated.";
            sw = r; hw = w;
            reset = 0x0;
        } tx_flr[4:0];
    } I2C_TXFLR @ 0x74;
    reg {
        name = "I2C_RXFLR";
        desc = "I2C_RXFLR is an RX_FIFO valid data indicator register. (offset 0x78; total reset 0x00000000; PROVEN: Hi3521A/Hi3520D V300 data sheet (Issue 00B07, 2015-12-10), section 13.1.5, PDF page 1497).";
        field {
            name = "reserved";
            desc = "Reserved";
            sw = r; hw = w;
            reset = 0x0;
        } reserved_31_5[31:5];
        field {
            name = "rx_flr";
            desc = "Number of valid data items in RX_FIFO The register is cleared when a tx_abort interrupt is generated.";
            sw = r; hw = w;
            reset = 0x0;
        } rx_flr[4:0];
    } I2C_RXFLR @ 0x78;
    reg {
        name = "I2C_SDA_HOLD";
        desc = "I2C_SDA_HOLD is an SDA hold time register. (offset 0x7C; total reset 0x00000001; PROVEN: Hi3521A/Hi3520D V300 data sheet (Issue 00B07, 2015-12-10), section 13.1.5, PDF page 1498).";
        field {
            name = "reserved";
            desc = "Reserved";
            sw = r; hw = w;
            reset = 0x0;
        } reserved_31_16[31:16];
        field {
            name = "sda_hold_fs";
            desc = "SDA hold time. The unit is the I2C working frequency i2c_clk (50 MHz in normal mode). This bit indicates the delay from the SCL falling edge to SDA change. The SDA changes after the SCL falling edge and the delay (value of sda_hold_fs x cycle of i2c_clk). This bit must be set based on the speed mode.";
            sw = rw; hw = r;
            reset = 0x1;
        } sda_hold_fs[15:0];
    } I2C_SDA_HOLD @ 0x7C;
    reg {
        name = "I2C_TX_ABRT_SRC";
        desc = "I2C_TX_ABRT_SRC is an I2C TX failure interrupt source register. (offset 0x80; total reset 0x00000000; PROVEN: Hi3521A/Hi3520D V300 data sheet (Issue 00B07, 2015-12-10), section 13.1.5, PDF page 1498).";
        field {
            name = "reserved";
            desc = "Reserved";
            sw = r; hw = w;
            reset = 0x0;
        } reserved_31_16[31:16];
        field {
            name = "reserved";
            desc = "Reserved";
            sw = r; hw = w;
            reset = 0x0;
        } reserved_15_15[15:15];
        field {
            name = "reserved";
            desc = "Reserved";
            sw = r; hw = w;
            reset = 0x0;
        } reserved_14_14[14:14];
        field {
            name = "reserved";
            desc = "Reserved";
            sw = r; hw = w;
            reset = 0x0;
        } reserved_13_13[13:13];
        field {
            name = "arb_lost";
            desc = "Whether an error occurs after the master loses the bus control permission
- 0: No error occurs.
- 1: An error occurs.";
            sw = r; hw = w;
            reset = 0x0;
        } arb_lost[12:12];
        field {
            name = "reserved";
            desc = "Reserved";
            sw = r; hw = w;
            reset = 0x0;
        } reserved_11_11[11:11];
        field {
            name = "abrt_10b_rd_norstrt";
            desc = "Whether an error occurs after the restart is disabled (I2C_CON[restart_en] set to 0) and the master attempts to initiate a read operation in 10-bit mode
- 0: No error occurs.
- 1: An error occurs.";
            sw = r; hw = w;
            reset = 0x0;
        } abrt_10b_rd_norstrt[10:10];
        field {
            name = "abrt_sbyte_norstrt";
            desc = "Whether an error occurs after the restart is disabled (I2C_CON[restart_en] set to 0) and a user attempts to initiate a start operation
- 0: No error occurs.
- 1: An error occurs.";
            sw = r; hw = w;
            reset = 0x0;
        } abrt_sbyte_norstrt[9:9];
        field {
            name = "reserved";
            desc = "Reserved";
            sw = r; hw = w;
            reset = 0x0;
        } reserved_8_8[8:8];
        field {
            name = "abrt_sbyte_ackdet";
            desc = "Whether an error occurs when the master sends a start command and receives a response
- 0: No error occurs.
- 1: An error occurs. (The slave does not need to respond to the start command.)";
            sw = r; hw = w;
            reset = 0x0;
        } abrt_sbyte_ackdet[7:7];
        field {
            name = "reserved";
            desc = "Reserved";
            sw = r; hw = w;
            reset = 0x0;
        } reserved_6_6[6:6];
        field {
            name = "abrt_gcall_read";
            desc = "tx_abort generation cause
- 0: tx_abort is triggered due to a reason not defined by the bit.
- 1: The master sends a common request, but the user initiates a read operation after the request.";
            sw = r; hw = w;
            reset = 0x0;
        } abrt_gcall_read[5:5];
        field {
            name = "abrt_gcall_noack";
            desc = "tx_abort generation cause
- 0: tx_abort is triggered due to a reason not defined by the bit.
- 1: The master sends a common request but does not receive a response from the slave over the bus.";
            sw = r; hw = w;
            reset = 0x0;
        } abrt_gcall_noack[4:4];
        field {
            name = "abrt_txdata_noack";
            desc = "tx_abort generation cause
- 0: tx_abort is triggered due to a reason not defined by the bit.
- 1: After the master sends an address and receives a response from the slave, the master sends data to the slave but does not receive any response.";
            sw = r; hw = w;
            reset = 0x0;
        } abrt_txdata_noack[3:3];
        field {
            name = "abrt_10addr2_noack";
            desc = "tx_abort generation cause
- 0: tx_abort is triggered due to a reason not defined by the bit.
- 1: The master sends address bit[10:8] the second time but does not receive any response from the slave when the master operates in 10-bit mode.";
            sw = r; hw = w;
            reset = 0x0;
        } abrt_10addr2_noack[2:2];
        field {
            name = "abrt_10addr1_noack";
            desc = "tx_abort generation cause
- 0: tx_abort is triggered due to a reason not defined by the bit.
- 1: The master sends address bit[7:0] the first time but does not receive any response from the slave when the master operates in 10-bit mode.";
            sw = r; hw = w;
            reset = 0x0;
        } abrt_10addr1_noack[1:1];
        field {
            name = "abrt_7b_addr_noack";
            desc = "tx_abort generation cause
- 0: tx_abort is triggered due to a reason not defined by the bit.
- 1: The master sends an address but does not receive the response from any slave on the bus when the master operates in 7-bit mode.";
            sw = r; hw = w;
            reset = 0x0;
        } abrt_7b_addr_noack[0:0];
    } I2C_TX_ABRT_SRC @ 0x80;
    reg {
        name = "I2C_DMA_CR";
        desc = "I2C_DMA_CR is an I2C DMA interface control register. (offset 0x88; total reset 0x00000000; PROVEN: Hi3521A/Hi3520D V300 data sheet (Issue 00B07, 2015-12-10), section 13.1.5, PDF page 1500).";
        field {
            name = "reserved";
            desc = "Reserved";
            sw = r; hw = w;
            reset = 0x0;
        } reserved_31_2[31:2];
        field {
            name = "rdmae";
            desc = "DMA enable for the TX FIFO
- 0: disabled
- 1: enabled";
            sw = rw; hw = r;
            reset = 0x0;
        } rdmae[1:1];
        field {
            name = "tdmae";
            desc = "DMA enable for the RX FIFO
- 0: disabled
- 1: enabled";
            sw = rw; hw = r;
            reset = 0x0;
        } tdmae[0:0];
    } I2C_DMA_CR @ 0x88;
    reg {
        name = "I2C_DMA_TDLR";
        desc = "I2C_DMA_TDLR is a TX_FIFO DMA operation threshold register. (offset 0x8C; total reset 0x00000004; PROVEN: Hi3521A/Hi3520D V300 data sheet (Issue 00B07, 2015-12-10), section 13.1.5, PDF page 1501).";
        field {
            name = "reserved";
            desc = "Reserved";
            sw = r; hw = w;
            reset = 0x0;
        } reserved_31_4[31:4];
        field {
            name = "dma_txtl";
            desc = "TX FIFO DMA threshold. When the number of data items of the TX FIFO is less than or equal to this value, a DMA operation request is sent. The DMA moves data to the TX FIFO.";
            sw = rw; hw = r;
            reset = 0x4;
        } dma_txtl[3:0];
    } I2C_DMA_TDLR @ 0x8C;
    reg {
        name = "I2C_DMA_RDLR";
        desc = "I2C_DMA_RDLR is an RX_FIFO DMA operation threshold register. (offset 0x90; total reset 0x00000004; PROVEN: Hi3521A/Hi3520D V300 data sheet (Issue 00B07, 2015-12-10), section 13.1.5, PDF page 1501).";
        field {
            name = "reserved";
            desc = "Reserved";
            sw = r; hw = w;
            reset = 0x0;
        } reserved_31_4[31:4];
        field {
            name = "dma_rxtl";
            desc = "RX FIFO DMA threshold. When the number of data items of the TX FIFO is greater than or equal to this value, a DMA operation request is sent. The DMA moves data of the RX FIFO to the specified destination. The actual value is equal to the configured value plus 1.";
            sw = rw; hw = r;
            reset = 0x4;
        } dma_rxtl[3:0];
    } I2C_DMA_RDLR @ 0x90;
    reg {
        name = "I2C_SCL_SWITCH";
        desc = "I2C_SCL_SWITCH is an I2C anti-suspend enable register. (offset 0xA0; total reset 0x00000000; PROVEN: Hi3521A/Hi3520D V300 data sheet (Issue 00B07, 2015-12-10), section 13.1.5, PDF page 1502).";
        field {
            name = "reserved";
            desc = "Reserved";
            sw = r; hw = w;
            reset = 0x0;
        } reserved_31_1[31:1];
        field {
            name = "scl_switch";
            desc = "Master simulate SCL signal enable
- 0: disabled
- 1: enabled";
            sw = rw; hw = r;
            reset = 0x0;
        } scl_switch[0:0];
    } I2C_SCL_SWITCH @ 0xA0;
    reg {
        name = "I2C_SCL_SIM";
        desc = "I2C_SCL_SIM is an I2C anti-suspend analog register. (offset 0xA4; total reset 0x00000001; PROVEN: Hi3521A/Hi3520D V300 data sheet (Issue 00B07, 2015-12-10), section 13.1.5, PDF page 1502).";
        field {
            name = "reserved";
            desc = "Reserved";
            sw = r; hw = w;
            reset = 0x0;
        } reserved_31_1[31:1];
        field {
            name = "scl_sim";
            desc = "SCL enable signals simulated by the master
- 0: The output SCL is 0.
- 1: The output SCL is 1.";
            sw = rw; hw = r;
            reset = 0x1;
        } scl_sim[0:0];
    } I2C_SCL_SIM @ 0xA4;
    reg {
        name = "I2C_LOCK";
        desc = "I2C_LOCK is an I2C lock register. (offset 0xAC; total reset 0x00000001; PROVEN: Hi3521A/Hi3520D V300 data sheet (Issue 00B07, 2015-12-10), section 13.1.5, PDF page 1503).";
        field {
            name = "reserved";
            desc = "Reserved";
            sw = r; hw = w;
            reset = 0x0;
        } reserved_31_1[31:1];
        field {
            name = "i2c_lock";
            desc = "I2C lock register. To unlock the register, write 1ACCE551 to the register. To lock the register, write other values. When this register is read:
- 0: The register is unlocked, and all registers can be configured.
- 1: The register is locked, and only this register can be configured.";
            sw = rw; hw = r;
            reset = 0x1;
        } i2c_lock[0:0];
    } I2C_LOCK @ 0xAC;
    reg {
        name = "I2C_MST_SINGLE_CTRL";
        desc = "I2C_MST_SINGLE_CTRL is an I2C_MST_SINGLE_CTRL register. (offset 0xB0; total reset 0x00300000; PROVEN: Hi3521A/Hi3520D V300 data sheet (Issue 00B07, 2015-12-10), section 13.1.5, PDF page 1503).";
        field {
            name = "single_model_en";
            desc = "I2C master single operation enable control
- 0: disabled
- 1: enabled";
            sw = rw; hw = r;
            reset = 0x0;
        } single_model_en[31:31];
        field {
            name = "single_model";
            desc = "I2C master single operation mode control
- 0: write
- 1: read";
            sw = rw; hw = r;
            reset = 0x0;
        } single_model[30:30];
        field {
            name = "single_addr_model";
            desc = "I2C master single operation address mode control
- 0: The slave register has an 8-bit address width.
- 1: The slave register has a 16-bit address width.";
            sw = rw; hw = r;
            reset = 0x0;
        } single_addr_model[29:29];
        field {
            name = "single_data_model";
            desc = "I2C master single operation data mode control
- 0: The slave register has an 8-bit data width.
- 1: The slave register has a 16-bit data width.";
            sw = rw; hw = r;
            reset = 0x0;
        } single_data_model[28:28];
        field {
            name = "single_mst_tx_abrt_clr";
            desc = "Transmission failure indicator clear in single-operation mode

Access type WC in the data sheet: written 1 clears the bit.";
            sw = rw; hw = w; onwrite = woclr;
            reset = 0x0;
        } single_mst_tx_abrt_clr[27:27];
        field {
            name = "single_tx_cmd_fifo_over_clr";
            desc = "SINGLE_TX_FIFO overflow indicator clear

Access type WC in the data sheet: written 1 clears the bit.";
            sw = rw; hw = w; onwrite = woclr;
            reset = 0x0;
        } single_tx_cmd_fifo_over_clr[26:26];
        field {
            name = "single_rx_cmd_fifo_under_clr";
            desc = "SINGLE_RX_FIFO read data overflow indicator clear

Access type WC in the data sheet: written 1 clears the bit.";
            sw = rw; hw = w; onwrite = woclr;
            reset = 0x0;
        } single_rx_cmd_fifo_under_clr[25:25];
        field {
            name = "single_rx_cmd_fifo_over_clr";
            desc = "SINGLE_RX_FIFO overflow indicator clear

Access type WC in the data sheet: written 1 clears the bit.";
            sw = rw; hw = w; onwrite = woclr;
            reset = 0x0;
        } single_rx_cmd_fifo_over_clr[24:24];
        field {
            name = "single_mst_tx_abrt";
            desc = "Transmission failure indicator in single-operation mode
- 0: No transmission failures occur.
- 1: A transmission failure occurs.";
            sw = r; hw = w;
            reset = 0x0;
        } single_mst_tx_abrt[23:23];
        field {
            name = "single_tx_cmd_fifo_over";
            desc = "SINGLE_TX_FIFO overflow indicator
- 0: Data in SINGLE_TX_FIFO does not overflow.
- 1: Data in SINGLE_TX_FIFO overflows.";
            sw = r; hw = w;
            reset = 0x0;
        } single_tx_cmd_fifo_over[22:22];
        field {
            name = "single_tx_cmd_fifo_not_full";
            desc = "SINGLE_TX_FIFO non-full indicator
- 0: SINGLE_TX_FIFO is full. The FIFO has at least 16 data items.
- 1: SINGLE_TX_FIFO is not full. The FIFO has less than 16 data items.";
            sw = r; hw = w;
            reset = 0x1;
        } single_tx_cmd_fifo_not_full[21:21];
        field {
            name = "single_tx_cmd_fifo_empty";
            desc = "SINGLE_TX_FIFO empty indicator
- 0: There is data in the FIFO.
- 1: There is no data in the FIFO.";
            sw = r; hw = w;
            reset = 0x1;
        } single_tx_cmd_fifo_empty[20:20];
        field {
            name = "reserved";
            desc = "Reserved";
            sw = r; hw = w;
            reset = 0x0;
        } reserved_19_17[19:17];
        field {
            name = "single_tx_cmd_fifo_cnt";
            desc = "Number of valid data items in SINGLE_TX_FIFO This register is cleared when the I2C master single operation is disabled (I2C_MST_SINGLE_CTRL[31] set to 0).";
            sw = r; hw = w;
            reset = 0x0;
        } single_tx_cmd_fifo_cnt[16:12];
        field {
            name = "single_rx_cmd_fifo_under";
            desc = "Overflow status when read data overflows (The CPU reads the FIFO when SINGLE_RX_FIFO is empty.)
- 0: No read data overflows.
- 1: Read data overflows.";
            sw = r; hw = w;
            reset = 0x0;
        } single_rx_cmd_fifo_under[11:11];
        field {
            name = "single_rx_cmd_fifo_over";
            desc = "SINGLE_RX_FIFO overflow status
- 0: Data in SINGLE_RX_FIFO does not overflow.
- 1: Data in SINGLE_RX_FIFO overflows.";
            sw = r; hw = w;
            reset = 0x0;
        } single_rx_cmd_fifo_over[10:10];
        field {
            name = "single_rx_cmd_fifo_full";
            desc = "SINGLE_RX_FIFO full indicator
- 0: SINGLE_RX_FIFO is not full. The FIFO has less than 16 data items.
- 1: SINGLE_RX_FIFO is full. The FIFO has at least 16 data items.";
            sw = r; hw = w;
            reset = 0x0;
        } single_rx_cmd_fifo_full[9:9];
        field {
            name = "single_rx_cmd_fifo_not_empty";
            desc = "SINGLE_RX_FIFO non-empty indicator
- 0: There is no data in the FIFO.
- 1: There is data in the FIFO.";
            sw = r; hw = w;
            reset = 0x0;
        } single_rx_cmd_fifo_not_empty[8:8];
        field {
            name = "reserved";
            desc = "Reserved";
            sw = r; hw = w;
            reset = 0x0;
        } reserved_7_5[7:5];
        field {
            name = "single_rx_cmd_fifo_cnt";
            desc = "Number of valid data items in SINGLE_RX_FIFO This register is cleared when the I2C master single operation is disabled (I2C_MST_SINGLE_CTRL[31] set to 0).";
            sw = r; hw = w;
            reset = 0x0;
        } single_rx_cmd_fifo_cnt[4:0];
    } I2C_MST_SINGLE_CTRL @ 0xB0;
    reg {
        name = "I2C_MST_SINGLE_CMD";
        desc = "I2C_MST_SINGLE_CMD is an I2C_MST_SINGLE_CMD register. (offset 0xB4; total reset 0x00000000; PROVEN: Hi3521A/Hi3520D V300 data sheet (Issue 00B07, 2015-12-10), section 13.1.5, PDF page 1505).";
        field {
            name = "single_addr";
            desc = "Address of the slave register accessed using the I2C master single operation The lower 8 bits are sent first, and the upper 8 bits are sent at last.";
            sw = w; hw = r;
            reset = 0x0;
        } single_addr[31:16];
        field {
            name = "single_data";
            desc = "Data of the slave register accessed using the I2C master single operation The lower 8 bits are sent first, and the upper 8 bits are sent at last.";
            sw = rw; hw = r;
            reset = 0x0;
        } single_data[15:0];
    } I2C_MST_SINGLE_CMD @ 0xB4;
    reg {
        name = "I2C_SEQUENCE_CMD0";
        desc = "I2C_SEQUENCE_CMD0 is an I2C_SEQUENCE_CMD0 register. (offset 0xB8; total reset 0x00000000; PROVEN: Hi3521A/Hi3520D V300 data sheet (Issue 00B07, 2015-12-10), section 13.1.5, PDF page 1506).";
        field {
            name = "sequential_mode_en";
            desc = "Sequential mode enable (This function must be used together with the DMA.)
- 0: disabled
- 1: enabled";
            sw = rw; hw = r;
            reset = 0x0;
        } sequential_mode_en[31:31];
        field {
            name = "sequential_rw";
            desc = "Operation type in sequential mode
- 0: read
- 1: write";
            sw = rw; hw = r;
            reset = 0x0;
        } sequential_rw[30:30];
        field {
            name = "sequential_addr_mode";
            desc = "Start address type in sequential mode
- 00: 8 bits
- 00: 16 bits
- 10: 24 bits
- 11: 32 bits";
            sw = rw; hw = r;
            reset = 0x0;
        } sequential_addr_mode[29:28];
        field {
            name = "reserved";
            desc = "Reserved";
            sw = rw; hw = r;
            reset = 0x0;
        } reserved_27_27[27:27];
        field {
            name = "reserved";
            desc = "Reserved";
            sw = r; hw = w;
            reset = 0x0;
        } reserved_26_24[26:24];
        field {
            name = "reserved";
            desc = "Reserved";
            sw = rw; hw = r;
            reset = 0x0;
        } reserved_23_23[23:23];
        field {
            name = "add_cnt_full";
            desc = "Start address transmission completion indicator, indicating that the DMA can be started";
            sw = r; hw = w;
            reset = 0x0;
        } add_cnt_full[22:22];
        field {
            name = "sequential_busy";
            desc = "Operation busy indicator in sequential mode";
            sw = r; hw = w;
            reset = 0x0;
        } sequential_busy[21:21];
        field {
            name = "sequential_finish";
            desc = "Operation completion indicator in sequential mode";
            sw = r; hw = w;
            reset = 0x0;
        } sequential_finish[20:20];
        field {
            name = "sequential_tx_fifo_cnt";
            desc = "Number of completed operations in sequential mode";
            sw = r; hw = w;
            reset = 0x0;
        } sequential_tx_fifo_cnt[19:0];
    } I2C_SEQUENCE_CMD0 @ 0xB8;
    reg {
        name = "I2C_SEQUENCE_CMD1";
        desc = "I2C_SEQUENCE_CMD1 is an I2C_SEQUENCE_CMD1 register. (offset 0xBC; total reset 0x00000000; PROVEN: Hi3521A/Hi3520D V300 data sheet (Issue 00B07, 2015-12-10), section 13.1.5, PDF page 1507).";
        field {
            name = "sequential_addr";
            desc = "Start address in sequential mode The lower 8 bits are sent first, and the upper 8 bits are sent at last.";
            sw = rw; hw = r;
            reset = 0x0;
        } sequential_addr[31:0];
    } I2C_SEQUENCE_CMD1 @ 0xBC;
    reg {
        name = "I2C_SEQUENCE_CMD2";
        desc = "I2C_SEQUENCE_CMD2 is an I2C_SEQUENCE_CMD2 register. (offset 0xC0; total reset 0x00000000; PROVEN: Hi3521A/Hi3520D V300 data sheet (Issue 00B07, 2015-12-10), section 13.1.5, PDF page 1507).";
        field {
            name = "sequential_length";
            desc = "Sequential mode length The configured value is the actual value minus 1.";
            sw = rw; hw = r;
            reset = 0x0;
        } sequential_length[31:0];
    } I2C_SEQUENCE_CMD2 @ 0xC0;
};
`endif
