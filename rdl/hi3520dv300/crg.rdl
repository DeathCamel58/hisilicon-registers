`ifndef HI3520DV300_CRG_RDL
`define HI3520DV300_CRG_RDL
regfile eHI3520DV300_CRG {
    name = "Clock and reset generator (CRG)";
    desc = "Clock and reset generator (CRG) of the Hi3521A/Hi3520D V300 at base 0x1204_0000. 47 registers extracted programmatically from the Hi3521A/Hi3520D V300 data sheet (Issue 00B07, 2015-12-10) (Table 3-6 Summary of CRG registers (base address: 0x1204_0000)): register headings, offsets, total reset values, field bit ranges, access types, names, reset values and descriptions, with PDF page numbers in each register description. Field names, bit ranges, access types and offsets are exact; the free-text descriptions are taken from the cell text of the field table and were checked by sampling only. Hardware not verified.";
    reg {
        name = "PERI_CRG_PLL0";
        desc = "PERI_CRG_PLL0 is APLL configuration register 0. (offset 0x0; total reset 0x12000000; PROVEN: Hi3521A/Hi3520D V300 data sheet (Issue 00B07, 2015-12-10), section 3.2.7, PDF page 503).";
        field {
            name = "reserved";
            desc = "Reserved";
            sw = r; hw = w;
            reset = 0x0;
        } reserved_31_31[31:31];
        field {
            name = "apll_postdiv2";
            desc = "Level-2 output divider of the APLL";
            sw = rw; hw = r;
            reset = 0x1;
        } apll_postdiv2[30:28];
        field {
            name = "reserved";
            desc = "Reserved";
            sw = r; hw = w;
            reset = 0x0;
        } reserved_27_27[27:27];
        field {
            name = "apll_postdiv1";
            desc = "Level-1 output divider of the APLL";
            sw = rw; hw = r;
            reset = 0x2;
        } apll_postdiv1[26:24];
        field {
            name = "apll_frac";
            desc = "Decimal divider of the APLL";
            sw = rw; hw = r;
            reset = 0x0;
        } apll_frac[23:0];
    } PERI_CRG_PLL0 @ 0x0;
    reg {
        name = "PERI_CRG_PLL1";
        desc = "PERI_CRG_PLL1 is APLL configuration register 1. (offset 0x4; total reset 0x02003064; PROVEN: Hi3521A/Hi3520D V300 data sheet (Issue 00B07, 2015-12-10), section 3.2.7, PDF page 503).";
        field {
            name = "reserved";
            desc = "Reserved";
            sw = r; hw = w;
            reset = 0x0;
        } reserved_31_27[31:27];
        field {
            name = "apll_bypass";
            desc = "APLL clock frequency-division bypass control
- 0: not bypassed
- 1: bypassed";
            sw = rw; hw = r;
            reset = 0x0;
        } apll_bypass[26:26];
        field {
            name = "apll_dacpd";
            desc = "APLL test signal control
- 0: normal operating mode
- 1: power-down mode";
            sw = rw; hw = r;
            reset = 0x1;
        } apll_dacpd[25:25];
        field {
            name = "apll_dsmpd";
            desc = "APLL decimal frequency-division control
- 0: decimal frequency-division mode
- 1: integer frequency-division mode";
            sw = rw; hw = r;
            reset = 0x0;
        } apll_dsmpd[24:24];
        field {
            name = "apll_pd";
            desc = "APLL power-down control
- 0: normal operating mode
- 1: power-down mode";
            sw = rw; hw = r;
            reset = 0x0;
        } apll_pd[23:23];
        field {
            name = "apll_foutvcopd";
            desc = "Power-down control for the APLL VCO output
- 0: normal output clock
- 1: no output clock";
            sw = rw; hw = r;
            reset = 0x0;
        } apll_foutvcopd[22:22];
        field {
            name = "apll_postdivpd";
            desc = "Power-down control for the APLL POSTDIV output
- 0: normal output clock
- 1: no output clock";
            sw = rw; hw = r;
            reset = 0x0;
        } apll_postdivpd[21:21];
        field {
            name = "apll_fout4phasepd";
            desc = "Power-down control for the APLL FOUT output
- 0: normal output clock
- 1: no output clock";
            sw = rw; hw = r;
            reset = 0x0;
        } apll_fout4phasepd[20:20];
        field {
            name = "reserved";
            desc = "Reserved";
            sw = r; hw = w;
            reset = 0x0;
        } reserved_19_18[19:18];
        field {
            name = "apll_refdiv";
            desc = "Divider of the APLL reference clock";
            sw = rw; hw = r;
            reset = 0x3;
        } apll_refdiv[17:12];
        field {
            name = "apll_fbdiv";
            desc = "Integral multiplier of the APLL";
            sw = rw; hw = r;
            reset = 0x64;
        } apll_fbdiv[11:0];
    } PERI_CRG_PLL1 @ 0x4;
    reg {
        name = "PERI_CRG_PLL2";
        desc = "PERI_CRG_PLL2 is VPLL0 configuration register 0. (offset 0x8; total reset 0x51000000; PROVEN: Hi3521A/Hi3520D V300 data sheet (Issue 00B07, 2015-12-10), section 3.2.7, PDF page 504).";
        field {
            name = "reserved";
            desc = "Reserved";
            sw = r; hw = w;
            reset = 0x0;
        } reserved_31_31[31:31];
        field {
            name = "vpll0_postdiv2";
            desc = "Level-2 output divider of the VPLL0";
            sw = rw; hw = r;
            reset = 0x5;
        } vpll0_postdiv2[30:28];
        field {
            name = "reserved";
            desc = "Reserved";
            sw = r; hw = w;
            reset = 0x0;
        } reserved_27_27[27:27];
        field {
            name = "vpll0_postdiv1";
            desc = "Level-1 output divider of the VPLL0";
            sw = rw; hw = r;
            reset = 0x1;
        } vpll0_postdiv1[26:24];
        field {
            name = "vpll0_frac";
            desc = "Decimal divider of the VPLL0";
            sw = rw; hw = r;
            reset = 0x0;
        } vpll0_frac[23:0];
    } PERI_CRG_PLL2 @ 0x8;
    reg {
        name = "PERI_CRG_PLL3";
        desc = "PERI_CRG_PLL3 is VPLL0 configuration register 1. (offset 0xC; total reset 0x02002087; PROVEN: Hi3521A/Hi3520D V300 data sheet (Issue 00B07, 2015-12-10), section 3.2.7, PDF page 505).";
        field {
            name = "reserved";
            desc = "Reserved";
            sw = r; hw = w;
            reset = 0x0;
        } reserved_31_27[31:27];
        field {
            name = "vpll0_bypass";
            desc = "VPLL0 clock frequency-division bypass control
- 0: not bypassed
- 1: bypassed";
            sw = rw; hw = r;
            reset = 0x0;
        } vpll0_bypass[26:26];
        field {
            name = "vpll0_dacpd";
            desc = "VPLL0 test signal control
- 0: normal operating mode
- 1: power-down mode";
            sw = rw; hw = r;
            reset = 0x1;
        } vpll0_dacpd[25:25];
        field {
            name = "vpll0_dsmpd";
            desc = "VPLL0 decimal frequency-division control
- 0: decimal frequency-division mode
- 1: integer frequency-division mode";
            sw = rw; hw = r;
            reset = 0x0;
        } vpll0_dsmpd[24:24];
        field {
            name = "vpll0_pd";
            desc = "VPLL0 power-down control
- 0: normal operating mode
- 1: power-down mode";
            sw = rw; hw = r;
            reset = 0x0;
        } vpll0_pd[23:23];
        field {
            name = "vpll0_foutvcopd";
            desc = "Power-down control for the VPLL0 VCO output
- 0: normal output clock
- 1: no output clock";
            sw = rw; hw = r;
            reset = 0x0;
        } vpll0_foutvcopd[22:22];
        field {
            name = "vpll0_postdivpd";
            desc = "Power-down control for the VPLL0 POSTDIV output
- 0: normal output clock
- 1: no output clock";
            sw = rw; hw = r;
            reset = 0x0;
        } vpll0_postdivpd[21:21];
        field {
            name = "vpll0_fout4phasepd";
            desc = "Power-down control for the VPLL0 FOUT output
- 0: normal output clock
- 1: no output clock";
            sw = rw; hw = r;
            reset = 0x0;
        } vpll0_fout4phasepd[20:20];
        field {
            name = "reserved";
            desc = "Reserved";
            sw = r; hw = w;
            reset = 0x0;
        } reserved_19_18[19:18];
        field {
            name = "vpll0_refdiv";
            desc = "Divider of the VPLL0 reference clock";
            sw = rw; hw = r;
            reset = 0x2;
        } vpll0_refdiv[17:12];
        field {
            name = "vpll0_fbdiv";
            desc = "Integral multiplier of the VPLL0";
            sw = rw; hw = r;
            reset = 0x87;
        } vpll0_fbdiv[11:0];
    } PERI_CRG_PLL3 @ 0xC;
    reg {
        name = "PERI_CRG_PLL4";
        desc = "PERI_CRG_PLL4 is VPLL2 configuration register 0. (offset 0x10; total reset 0x21000000; PROVEN: Hi3521A/Hi3520D V300 data sheet (Issue 00B07, 2015-12-10), section 3.2.7, PDF page 506).";
        field {
            name = "reserved";
            desc = "Reserved";
            sw = r; hw = w;
            reset = 0x0;
        } reserved_31_31[31:31];
        field {
            name = "vpll2_postdiv2";
            desc = "Level-2 output divider of VPLL2";
            sw = rw; hw = r;
            reset = 0x2;
        } vpll2_postdiv2[30:28];
        field {
            name = "reserved";
            desc = "Reserved";
            sw = r; hw = w;
            reset = 0x0;
        } reserved_27_27[27:27];
        field {
            name = "vpll2_postdiv1";
            desc = "Level-1 output divider of VPLL2";
            sw = rw; hw = r;
            reset = 0x1;
        } vpll2_postdiv1[26:24];
        field {
            name = "vpll2_frac";
            desc = "Decimal divider of VPLL2";
            sw = rw; hw = r;
            reset = 0x0;
        } vpll2_frac[23:0];
    } PERI_CRG_PLL4 @ 0x10;
    reg {
        name = "PERI_CRG_PLL5";
        desc = "PERI_CRG_PLL5 is VPLL2 configuration register 1. (offset 0x14; total reset 0x02002087; PROVEN: Hi3521A/Hi3520D V300 data sheet (Issue 00B07, 2015-12-10), section 3.2.7, PDF page 507).";
        field {
            name = "reserved";
            desc = "Reserved";
            sw = r; hw = w;
            reset = 0x0;
        } reserved_31_27[31:27];
        field {
            name = "vpll2_bypass";
            desc = "VPLL2 clock frequency-division bypass control
- 0: not bypassed
- 1: bypassed";
            sw = rw; hw = r;
            reset = 0x0;
        } vpll2_bypass[26:26];
        field {
            name = "vpll2_dacpd";
            desc = "VPLL2 test signal control
- 0: normal operating mode
- 1: power-down mode";
            sw = rw; hw = r;
            reset = 0x1;
        } vpll2_dacpd[25:25];
        field {
            name = "vpll2_dsmpd";
            desc = "VPLL2 decimal frequency-division control
- 0: decimal frequency-division mode
- 1: integer frequency-division mode";
            sw = rw; hw = r;
            reset = 0x0;
        } vpll2_dsmpd[24:24];
        field {
            name = "vpll2_pd";
            desc = "VPLL2 power-down control
- 0: normal operating mode
- 1: power-down mode";
            sw = rw; hw = r;
            reset = 0x0;
        } vpll2_pd[23:23];
        field {
            name = "vpll2_foutvcopd";
            desc = "Power-down control for the VPLL2 VCO output
- 0: normal output clock
- 1: no output clock";
            sw = rw; hw = r;
            reset = 0x0;
        } vpll2_foutvcopd[22:22];
        field {
            name = "vpll2_postdivpd";
            desc = "Power-down control for the VPLL2 POSTDIV output
- 0: normal output clock
- 1: no output clock";
            sw = rw; hw = r;
            reset = 0x0;
        } vpll2_postdivpd[21:21];
        field {
            name = "vpll2_fout4phasepd";
            desc = "Power-down control for the VPLL2 FOUT output
- 0: normal output clock
- 1: no output clock";
            sw = rw; hw = r;
            reset = 0x0;
        } vpll2_fout4phasepd[20:20];
        field {
            name = "reserved";
            desc = "Reserved";
            sw = r; hw = w;
            reset = 0x0;
        } reserved_19_18[19:18];
        field {
            name = "vpll2_refdiv";
            desc = "Divider of the VPLL2 reference clock";
            sw = rw; hw = r;
            reset = 0x2;
        } vpll2_refdiv[17:12];
        field {
            name = "vpll2_fbdiv";
            desc = "Integral multiplier of VPLL2";
            sw = rw; hw = r;
            reset = 0x87;
        } vpll2_fbdiv[11:0];
    } PERI_CRG_PLL5 @ 0x14;
    reg {
        name = "PERI_CRG_PLL6";
        desc = "PERI_CRG_PLL6 is EPLL configuration register 0. (offset 0x18; total reset 0x31000000; PROVEN: Hi3521A/Hi3520D V300 data sheet (Issue 00B07, 2015-12-10), section 3.2.7, PDF page 508).";
        field {
            name = "reserved";
            desc = "Reserved";
            sw = r; hw = w;
            reset = 0x0;
        } reserved_31_31[31:31];
        field {
            name = "epll_postdiv2";
            desc = "Level-2 output divider of EPLL";
            sw = rw; hw = r;
            reset = 0x3;
        } epll_postdiv2[30:28];
        field {
            name = "reserved";
            desc = "Reserved";
            sw = r; hw = w;
            reset = 0x0;
        } reserved_27_27[27:27];
        field {
            name = "epll_postdiv1";
            desc = "Level-1 output divider of EPLL";
            sw = rw; hw = r;
            reset = 0x1;
        } epll_postdiv1[26:24];
        field {
            name = "epll_frac";
            desc = "Decimal divider of EPLL";
            sw = rw; hw = r;
            reset = 0x0;
        } epll_frac[23:0];
    } PERI_CRG_PLL6 @ 0x18;
    reg {
        name = "PERI_CRG_PLL7";
        desc = "PERI_CRG_PLL7 is EPLL configuration register 1. (offset 0x1C; total reset 0x0200207D; PROVEN: Hi3521A/Hi3520D V300 data sheet (Issue 00B07, 2015-12-10), section 3.2.7, PDF page 508).";
        field {
            name = "reserved";
            desc = "Reserved";
            sw = r; hw = w;
            reset = 0x0;
        } reserved_31_27[31:27];
        field {
            name = "epll_bypass";
            desc = "EPLL clock frequency-division bypass control
- 0: not bypassed
- 1: bypassed";
            sw = rw; hw = r;
            reset = 0x0;
        } epll_bypass[26:26];
        field {
            name = "epll_dacpd";
            desc = "EPLL test signal control
- 0: normal operating mode
- 1: power-down mode";
            sw = rw; hw = r;
            reset = 0x1;
        } epll_dacpd[25:25];
        field {
            name = "epll_dsmpd";
            desc = "EPLL decimal frequency-division control
- 0: decimal frequency-division mode
- 1: integer frequency-division mode";
            sw = rw; hw = r;
            reset = 0x0;
        } epll_dsmpd[24:24];
        field {
            name = "epll_pd";
            desc = "EPLL power-down control
- 0: normal operating mode
- 1: power-down mode";
            sw = rw; hw = r;
            reset = 0x0;
        } epll_pd[23:23];
        field {
            name = "epll_foutvcopd";
            desc = "Power-down control for the EPLL VCO output
- 0: normal output clock
- 1: no output clock";
            sw = rw; hw = r;
            reset = 0x0;
        } epll_foutvcopd[22:22];
        field {
            name = "epll_postdivpd";
            desc = "Power-down control for the EPLL POSTDIV output
- 0: normal output clock
- 1: no output clock";
            sw = rw; hw = r;
            reset = 0x0;
        } epll_postdivpd[21:21];
        field {
            name = "epll_fout4phasepd";
            desc = "Power-down control for the EPLL FOUT output
- 0: normal output clock
- 1: no output clock";
            sw = rw; hw = r;
            reset = 0x0;
        } epll_fout4phasepd[20:20];
        field {
            name = "reserved";
            desc = "Reserved";
            sw = r; hw = w;
            reset = 0x0;
        } reserved_19_18[19:18];
        field {
            name = "epll_refdiv";
            desc = "Divider of the EPLL reference clock";
            sw = rw; hw = r;
            reset = 0x2;
        } epll_refdiv[17:12];
        field {
            name = "epll_fbdiv";
            desc = "Integral multiplier of the EPLL";
            sw = rw; hw = r;
            reset = 0x7d;
        } epll_fbdiv[11:0];
    } PERI_CRG_PLL7 @ 0x1C;
    reg {
        name = "PERI_CRG_PLL8";
        desc = "PERI_CRG_PLL8 is DPLL configuration register 0. (offset 0x20; total reset 0x11000000; PROVEN: Hi3521A/Hi3520D V300 data sheet (Issue 00B07, 2015-12-10), section 3.2.7, PDF page 509).";
        field {
            name = "reserved";
            desc = "Reserved";
            sw = r; hw = w;
            reset = 0x0;
        } reserved_31_31[31:31];
        field {
            name = "dpll_postdiv2";
            desc = "Level-2 output divider of the DPLL";
            sw = rw; hw = r;
            reset = 0x1;
        } dpll_postdiv2[30:28];
        field {
            name = "reserved";
            desc = "Reserved";
            sw = r; hw = w;
            reset = 0x0;
        } reserved_27_27[27:27];
        field {
            name = "dpll_postdiv1";
            desc = "Level-1 output divider of the DPLL";
            sw = rw; hw = r;
            reset = 0x1;
        } dpll_postdiv1[26:24];
        field {
            name = "dpll_frac";
            desc = "Decimal divider of the DPLL";
            sw = rw; hw = r;
            reset = 0x0;
        } dpll_frac[23:0];
    } PERI_CRG_PLL8 @ 0x20;
    reg {
        name = "PERI_CRG_PLL9";
        desc = "PERI_CRG9 is DPLL configuration register 1. (offset 0x24; total reset 0x02003032; PROVEN: Hi3521A/Hi3520D V300 data sheet (Issue 00B07, 2015-12-10), section 3.2.7, PDF page 510).";
        field {
            name = "reserved";
            desc = "Reserved";
            sw = r; hw = w;
            reset = 0x0;
        } reserved_31_27[31:27];
        field {
            name = "dpll_bypass";
            desc = "DPLL clock frequency-division bypass control
- 0: not bypassed
- 1: bypassed";
            sw = rw; hw = r;
            reset = 0x0;
        } dpll_bypass[26:26];
        field {
            name = "dpll_dacpd";
            desc = "DPLL test signal control
- 0: normal operating mode
- 1: power-down mode";
            sw = rw; hw = r;
            reset = 0x1;
        } dpll_dacpd[25:25];
        field {
            name = "dpll_dsmpd";
            desc = "DPLL decimal frequency-division control
- 0: decimal frequency-division mode
- 1: integer frequency-division mode";
            sw = rw; hw = r;
            reset = 0x0;
        } dpll_dsmpd[24:24];
        field {
            name = "dpll_pd";
            desc = "DPLL power-down control
- 0: normal operating mode
- 1: power-down mode";
            sw = rw; hw = r;
            reset = 0x0;
        } dpll_pd[23:23];
        field {
            name = "dpll_foutvcopd";
            desc = "Power-down control for the DPLL VCO output
- 0: normal output clock
- 1: no output clock";
            sw = rw; hw = r;
            reset = 0x0;
        } dpll_foutvcopd[22:22];
        field {
            name = "dpll_postdivpd";
            desc = "Power-down control for the EPLL POSTDIV output
- 0: normal output clock
- 1: no output clock";
            sw = rw; hw = r;
            reset = 0x0;
        } dpll_postdivpd[21:21];
        field {
            name = "dpll_fout4phasepd";
            desc = "Power-down control for the DPLL FOUT output
- 0: normal output clock
- 1: no output clock";
            sw = rw; hw = r;
            reset = 0x0;
        } dpll_fout4phasepd[20:20];
        field {
            name = "reserved";
            desc = "Reserved";
            sw = r; hw = w;
            reset = 0x0;
        } reserved_19_18[19:18];
        field {
            name = "dpll_refdiv";
            desc = "Divider of the DPLL reference clock";
            sw = rw; hw = r;
            reset = 0x3;
        } dpll_refdiv[17:12];
        field {
            name = "dpll_fbdiv";
            desc = "Integral multiplier of the DPLL";
            sw = rw; hw = r;
            reset = 0x32;
        } dpll_fbdiv[11:0];
    } PERI_CRG_PLL9 @ 0x24;
    reg {
        name = "PERI_CRG10";
        desc = "PERI_CRG10 is an A7 frequency mode and reset configuration register. (offset 0x28; total reset 0x00000001; PROVEN: Hi3521A/Hi3520D V300 data sheet (Issue 00B07, 2015-12-10), section 3.2.7, PDF page 511).";
        field {
            name = "reserved";
            desc = "Reserved";
            sw = r; hw = w;
            reset = 0x0;
        } reserved_31_30[31:30];
        field {
            name = "a7_sm_cnt_cfg";
            desc = "Initial value of the SM counter";
            sw = rw; hw = r;
            reset = 0x0;
        } a7_sm_cnt_cfg[29:22];
        field {
            name = "a7_sm_bypass_pos";
            desc = "Frequency gradient bypass after clock switching
- 0: The frequency gradient takes effect.
- 1: The frequency gradient is bypassed.";
            sw = rw; hw = r;
            reset = 0x0;
        } a7_sm_bypass_pos[21:21];
        field {
            name = "a7_sm_bypass_pre";
            desc = "Frequency gradient bypass before clock switching
- 0: The frequency gradient takes effect.
- 1: The frequency gradient is bypassed.";
            sw = rw; hw = r;
            reset = 0x0;
        } a7_sm_bypass_pre[20:20];
        field {
            name = "a7_sm_step_sel";
            desc = "Decreasing step select for the SM counter
- 00: The decreasing step is 1.
- 01: The decreasing step is 2.
- 10: The decreasing step is 3.
- 11: The decreasing step is 4.";
            sw = rw; hw = r;
            reset = 0x0;
        } a7_sm_step_sel[19:18];
        field {
            name = "a7clk_loaden";
            desc = "Skip configuration enable for the CPU clock To change the skip configuration, perform the following steps: 1. Write a new skip configuration value. 2. Write 0 to a7clk_loaden. 3. Write 1 to a7clk_loaden.";
            sw = rw; hw = r;
            reset = 0x0;
        } a7clk_loaden[17:17];
        field {
            name = "a7clk_skipcfg";
            desc = "Skip configuration of the CPU clock. N: N-beat clocks are disabled every 32-beat CPU clocks.";
            sw = rw; hw = r;
            reset = 0x0;
        } a7clk_skipcfg[16:12];
        field {
            name = "reserved";
            desc = "Reserved";
            sw = r; hw = w;
            reset = 0x0;
        } reserved_11_11[11:11];
        field {
            name = "cs_srst_req";
            desc = "Chip select (CS) soft reset
- 0: deassert reset
- 1: reset";
            sw = rw; hw = r;
            reset = 0x0;
        } cs_srst_req[10:10];
        field {
            name = "socdbg_srst_req";
            desc = "SOCDBG soft reset
- 0: deassert reset
- 1: reset";
            sw = rw; hw = r;
            reset = 0x0;
        } socdbg_srst_req[9:9];
        field {
            name = "l2_srst_req";
            desc = "L2 soft reset
- 0: deassert reset
- 1: reset";
            sw = rw; hw = r;
            reset = 0x0;
        } l2_srst_req[8:8];
        field {
            name = "etm_srst_req";
            desc = "ETM soft reset
- 0: deassert reset
- 1: reset";
            sw = rw; hw = r;
            reset = 0x0;
        } etm_srst_req[7:7];
        field {
            name = "arm_dbg_srst_req";
            desc = "ARM DBG soft reset
- 0: deassert reset
- 1: reset";
            sw = rw; hw = r;
            reset = 0x0;
        } arm_dbg_srst_req[6:6];
        field {
            name = "arm_core_srst_req";
            desc = "ARM core soft reset
- 0: deassert reset
- 1: reset";
            sw = rw; hw = r;
            reset = 0x0;
        } arm_core_srst_req[5:5];
        field {
            name = "reserved";
            desc = "Reserved";
            sw = r; hw = w;
            reset = 0x0;
        } reserved_4_1[4:1];
        field {
            name = "pclkdbg_cken";
            desc = "A7 PCLKDBG clock gating
- 0: The clock is disabled.
- 1: The clock is enabled.";
            sw = rw; hw = r;
            reset = 0x1;
        } pclkdbg_cken[0:0];
    } PERI_CRG10 @ 0x28;
    reg {
        name = "PERI_CRG11";
        desc = "PERI_CRG11 is a VICAP clock and reset configuration register. (offset 0x2C; total reset 0x1FFE9999; PROVEN: Hi3521A/Hi3520D V300 data sheet (Issue 00B07, 2015-12-10), section 3.2.7, PDF page 513).";
        field {
            name = "reserved";
            desc = "Reserved";
            sw = r; hw = w;
            reset = 0x0;
        } reserved_31_31[31:31];
        field {
            name = "vi_ppc_cksel";
            desc = "Frequency select for the VI working clock
- 0: 300 MHz
- 1: reserved
- 2: 150 MHz
- 3: reserved";
            sw = rw; hw = r;
            reset = 0x0;
        } vi_ppc_cksel[30:29];
        field {
            name = "vi_apb_cken";
            desc = "VI APB bus gating
- 0: The clock is disabled.
- 1: The clock is enabled.";
            sw = rw; hw = r;
            reset = 0x1;
        } vi_apb_cken[28:28];
        field {
            name = "vi_axi_cken";
            desc = "VI AXI bus gating
- 0: The clock is disabled.
- 1: The clock is enabled.";
            sw = rw; hw = r;
            reset = 0x1;
        } vi_axi_cken[27:27];
        field {
            name = "vi_ppc_cken";
            desc = "VI PPC gating
- 0: The clock is disabled.
- 1: The clock is enabled.";
            sw = rw; hw = r;
            reset = 0x1;
        } vi_ppc_cken[26:26];
        field {
            name = "vi_bus_srst_req";
            desc = "VI PPC bus soft reset
- 0: deassert reset
- 1: reset";
            sw = rw; hw = r;
            reset = 0x1;
        } vi_bus_srst_req[25:25];
        field {
            name = "reserved";
            desc = "Reserved";
            sw = r; hw = w;
            reset = 0xff;
        } reserved_24_17[24:17];
        field {
            name = "vi_ppc_srst_req";
            desc = "VI PPC soft reset
- 0: deassert reset
- 1: reset";
            sw = rw; hw = r;
            reset = 0x0;
        } vi_ppc_srst_req[16:16];
        field {
            name = "vi3_srst_req";
            desc = "VI CH3 soft reset
- 0: deassert reset
- 1: reset";
            sw = rw; hw = r;
            reset = 0x1;
        } vi3_srst_req[15:15];
        field {
            name = "vi3_ch_cksel";
            desc = "VI CH3 clock select
- 0: VI3 PAD input clock
- 1: VI3 2-multiplier clock";
            sw = rw; hw = r;
            reset = 0x0;
        } vi3_ch_cksel[14:14];
        field {
            name = "vi3_pctrl";
            desc = "Phase of the VI CH3 interface clock 0 (default): positive phase
- 1: negative phase";
            sw = rw; hw = r;
            reset = 0x0;
        } vi3_pctrl[13:13];
        field {
            name = "vi3_cken";
            desc = "VI CH3 clock gating
- 0: The clock is disabled.
- 1: The clock is enabled.";
            sw = rw; hw = r;
            reset = 0x1;
        } vi3_cken[12:12];
        field {
            name = "vi2_srst_req";
            desc = "VI CH2 soft reset
- 0: deassert reset
- 1: reset";
            sw = rw; hw = r;
            reset = 0x1;
        } vi2_srst_req[11:11];
        field {
            name = "vi2_ch_cksel";
            desc = "VI CH2 clock select
- 0: VI2 PAD input clock
- 1: VI2 2-multiplier clock";
            sw = rw; hw = r;
            reset = 0x0;
        } vi2_ch_cksel[10:10];
        field {
            name = "vi2_pctrl";
            desc = "Phase of the VI CH2 interface clock 0 (default): positive phase
- 1: negative phase";
            sw = rw; hw = r;
            reset = 0x0;
        } vi2_pctrl[9:9];
        field {
            name = "vi2_cken";
            desc = "VI CH2 clock gating
- 0: The clock is disabled.
- 1: The clock is enabled.";
            sw = rw; hw = r;
            reset = 0x1;
        } vi2_cken[8:8];
        field {
            name = "vi1_srst_req";
            desc = "VI CH1 soft reset
- 0: deassert reset
- 1: reset";
            sw = rw; hw = r;
            reset = 0x1;
        } vi1_srst_req[7:7];
        field {
            name = "vi1_ch_cksel";
            desc = "VI CH1 clock select
- 0: VI1 PAD input clock
- 1: VI1 2-multiplier clock";
            sw = rw; hw = r;
            reset = 0x0;
        } vi1_ch_cksel[6:6];
        field {
            name = "vi1_pctrl";
            desc = "Phase of the VI CH1 interface clock 0 (default): positive phase
- 1: negative phase";
            sw = rw; hw = r;
            reset = 0x0;
        } vi1_pctrl[5:5];
        field {
            name = "vi1_cken";
            desc = "VI CH1 clock gating
- 0: The clock is disabled.
- 1: The clock is enabled.";
            sw = rw; hw = r;
            reset = 0x1;
        } vi1_cken[4:4];
        field {
            name = "vi0_srst_req";
            desc = "VI CH0 soft reset
- 0: deassert reset
- 1: reset";
            sw = rw; hw = r;
            reset = 0x1;
        } vi0_srst_req[3:3];
        field {
            name = "vi0_ch_cksel";
            desc = "VI CH0 clock select
- 0: VI0 PAD input clock
- 1: VI0 2-multiplier clock";
            sw = rw; hw = r;
            reset = 0x0;
        } vi0_ch_cksel[2:2];
        field {
            name = "vi0_pctrl";
            desc = "Phase of the VI CH0 interface clock 0 (default): positive phase
- 1: negative phase";
            sw = rw; hw = r;
            reset = 0x0;
        } vi0_pctrl[1:1];
        field {
            name = "vi0_cken";
            desc = "VI CH0 clock gating
- 0: The clock is disabled.
- 1: The clock is enabled.";
            sw = rw; hw = r;
            reset = 0x1;
        } vi0_cken[0:0];
    } PERI_CRG11 @ 0x2C;
    reg {
        name = "PERI_CRG12";
        desc = "PERI_CRG12 is a VOU clock and reset control register. (offset 0x30; total reset 0x00000CFC; PROVEN: Hi3521A/Hi3520D V300 data sheet (Issue 00B07, 2015-12-10), section 3.2.7, PDF page 515).";
        field {
            name = "reserved";
            desc = "Reserved";
            sw = r; hw = w;
            reset = 0x0;
        } reserved_31_16[31:16];
        field {
            name = "vosd_cksel";
            desc = "VO SD frequency divider
- 0: 4
- 1: 2";
            sw = rw; hw = r;
            reset = 0x0;
        } vosd_cksel[15:15];
        field {
            name = "vohd_cksel";
            desc = "VO HD frequency divider
- 0: 1
- 1: 2";
            sw = rw; hw = r;
            reset = 0x0;
        } vohd_cksel[14:14];
        field {
            name = "vosd_out_pctrl";
            desc = "Phase of the VDAC clock
- 0: positive phase 1 (default): negative phase";
            sw = rw; hw = r;
            reset = 0x0;
        } vosd_out_pctrl[13:13];
        field {
            name = "vohd_out_pctrl";
            desc = "Phase of the VOU HD output associate clock
- 0: positive phase 1 (default): negative phase";
            sw = rw; hw = r;
            reset = 0x0;
        } vohd_out_pctrl[12:12];
        field {
            name = "vo_hd_dac_cken";
            desc = "VOU HD DAC clock gating
- 0: The clock is disabled.
- 1: The clock is enabled.";
            sw = rw; hw = r;
            reset = 0x1;
        } vo_hd_dac_cken[11:11];
        field {
            name = "vo_sd_dac_cken";
            desc = "VOU SD DAC clock gating
- 0: The clock is disabled.
- 1: The clock is enabled.";
            sw = rw; hw = r;
            reset = 0x1;
        } vo_sd_dac_cken[10:10];
        field {
            name = "reserved";
            desc = "Reserved";
            sw = r; hw = w;
            reset = 0x0;
        } reserved_9_8[9:8];
        field {
            name = "vo_dac_cken";
            desc = "VOU DAC clock gating
- 0: The clock is disabled.
- 1: The clock is enabled.";
            sw = rw; hw = r;
            reset = 0x1;
        } vo_dac_cken[7:7];
        field {
            name = "vo_acken";
            desc = "VOU AXI bus clock gating
- 0: The clock is disabled.
- 1: The clock is enabled.";
            sw = rw; hw = r;
            reset = 0x1;
        } vo_acken[6:6];
        field {
            name = "vo_pcken";
            desc = "VO APB clock gating
- 0: The clock is disabled.
- 1: The clock is enabled.";
            sw = rw; hw = r;
            reset = 0x1;
        } vo_pcken[5:5];
        field {
            name = "vo_sd_cken";
            desc = "VO SD clock gating
- 0: The clock is disabled.
- 1: The clock is enabled.";
            sw = rw; hw = r;
            reset = 0x1;
        } vo_sd_cken[4:4];
        field {
            name = "vo_hd_cken";
            desc = "VOU HD clock gating
- 0: The clock is disabled.
- 1: The clock is enabled.";
            sw = rw; hw = r;
            reset = 0x1;
        } vo_hd_cken[3:3];
        field {
            name = "vo_cken";
            desc = "VO PPC/CFG clock gating (internally configured)
- 0: The clock is disabled.
- 1: The clock is enabled.";
            sw = rw; hw = r;
            reset = 0x1;
        } vo_cken[2:2];
        field {
            name = "reserved";
            desc = "Reserved";
            sw = r; hw = w;
            reset = 0x0;
        } reserved_1_1[1:1];
        field {
            name = "vo_srst_req";
            desc = "VOU soft reset
- 0: deassert reset
- 1: reset";
            sw = rw; hw = r;
            reset = 0x0;
        } vo_srst_req[0:0];
    } PERI_CRG12 @ 0x30;
    reg {
        name = "PERI_CRG13";
        desc = "PERI_CRG13 is an SoC/DDR clock configuration register. (offset 0x34; total reset 0x07000000; PROVEN: Hi3521A/Hi3520D V300 data sheet (Issue 00B07, 2015-12-10), section 3.2.7, PDF page 517).";
        field {
            name = "reserved";
            desc = "Reserved";
            sw = r; hw = w;
            reset = 0x0;
        } reserved_31_29[31:29];
        field {
            name = "ddr_hipack_srst_req";
            desc = "DDR HIPACK soft reset
- 0: deassert reset
- 1: reset";
            sw = rw; hw = r;
            reset = 0x0;
        } ddr_hipack_srst_req[28:28];
        field {
            name = "ddr_apb_srst_req";
            desc = "DDR APB soft reset
- 0: deassert reset
- 1: reset";
            sw = rw; hw = r;
            reset = 0x0;
        } ddr_apb_srst_req[27:27];
        field {
            name = "ddr_cfg_cken";
            desc = "DDR CFG clock gating
- 0: The clock is disabled.
- 1: The clock is enabled.";
            sw = rw; hw = r;
            reset = 0x1;
        } ddr_cfg_cken[26:26];
        field {
            name = "ddr_hipack_cken";
            desc = "DDR HIPACK clock gating
- 0: The clock is disabled.
- 1: The clock is enabled.";
            sw = rw; hw = r;
            reset = 0x1;
        } ddr_hipack_cken[25:25];
        field {
            name = "ddr_apb_cken";
            desc = "DDR APB clock gating
- 0: The clock is disabled.
- 1: The clock is enabled.";
            sw = rw; hw = r;
            reset = 0x1;
        } ddr_apb_cken[24:24];
        field {
            name = "reserved";
            desc = "Reserved";
            sw = r; hw = w;
            reset = 0x0;
        } reserved_23_14[23:14];
        field {
            name = "bus_cksel";
            desc = "BUS clock configuration [9:8]: MDA_300_AXI clock configuration
- 00: XTAL clock
- 01: 250 MHz clock
- 10: 300 MHz clock
- 11: reserved [10]: MDA_270M_AXI clock configuration
- 0: XTAL clock
- 1: 270 MHz clock [13:12]: SYS AXI clock configuration
- 00: XTAL clock
- 01: 250 MHz clock
- 10: 202.5 MHz clock
- 11: reserved";
            sw = rw; hw = r;
            reset = 0x0;
        } bus_cksel[13:8];
        field {
            name = "reserved";
            desc = "Reserved";
            sw = r; hw = w;
            reset = 0x0;
        } reserved_7_6[7:6];
        field {
            name = "vedu1_cksel1";
            desc = "VEDU1 clock frequency select. This bit works with PERI_CRG16[vedu1_cksel] for selecting the clock. {vedu1_cksel1, vedu1_cksel} x0: 324 MHz
- 01: 405 MHz
- 11: reserved";
            sw = rw; hw = r;
            reset = 0x0;
        } vedu1_cksel1[5:5];
        field {
            name = "Vedu0_cksel1";
            desc = "VEDU0 clock frequency select. This bit works with PERI_CRG15[vedu0_cksel] for selecting the clock. {vedu0_cksel1, vedu0_cksel} x0: 324 MHz
- 01: 405 MHz
- 11: reserved";
            sw = rw; hw = r;
            reset = 0x0;
        } Vedu0_cksel1[4:4];
        field {
            name = "cpu_cksel";
            desc = "CPU clock configuration
- 00: XTAL clock
- 01: APLL POSTDIV
- 10: 750 MHZ (internal frequency division)
- 11: reserved";
            sw = rw; hw = r;
            reset = 0x0;
        } cpu_cksel[3:2];
        field {
            name = "ddr_cksel";
            desc = "DDR clock configuration
- 00: XTAL clock
- 01: DDR POSTDIV 1x: reserved";
            sw = rw; hw = r;
            reset = 0x0;
        } ddr_cksel[1:0];
    } PERI_CRG13 @ 0x34;
    reg {
        name = "PERI_CRG14";
        desc = "PERI_CRG14 is an HDMI clock and reset control register. (offset 0x38; total reset 0x0000003F; PROVEN: Hi3521A/Hi3520D V300 data sheet (Issue 00B07, 2015-12-10), section 3.2.7, PDF page 519).";
        field {
            name = "reserved";
            desc = "Reserved";
            sw = r; hw = w;
            reset = 0x0;
        } reserved_31_15[31:15];
        field {
            name = "hdmitx_ctrl_asclk_sel";
            desc = "HDMI TX asclk clock select
- 1: internal CRG clock
- 0: HDMI TX PHY clock";
            sw = rw; hw = r;
            reset = 0x0;
        } hdmitx_ctrl_asclk_sel[14:14];
        field {
            name = "hdmitx_asin_cksel";
            desc = "HDMI TX asclk internal clock select
- 0: 125 MHz clock
- 1: 100 MHz clock";
            sw = rw; hw = r;
            reset = 0x0;
        } hdmitx_asin_cksel[13:13];
        field {
            name = "hdmitx_ctrl_cec_clk_sel";
            desc = "HDMI TX cec clock select
- 0: 2 MHz clock
- 1: 2.02 MHz clock";
            sw = rw; hw = r;
            reset = 0x0;
        } hdmitx_ctrl_cec_clk_sel[12:12];
        field {
            name = "reserved";
            desc = "Reserved";
            sw = r; hw = w;
            reset = 0x0;
        } reserved_11_10[11:10];
        field {
            name = "hdmitx_ctrl_srst_req";
            desc = "HDMI TX soft reset
- 0: deassert reset
- 1: reset";
            sw = rw; hw = r;
            reset = 0x0;
        } hdmitx_ctrl_srst_req[9:9];
        field {
            name = "hdmitx_ctrl_bus_srst_req";
            desc = "HDMI TX bus soft reset
- 0: deassert reset
- 1: reset";
            sw = rw; hw = r;
            reset = 0x0;
        } hdmitx_ctrl_bus_srst_req[8:8];
        field {
            name = "reserved";
            desc = "Reserved";
            sw = r; hw = w;
            reset = 0x0;
        } reserved_7_6[7:6];
        field {
            name = "hdmitx_ctrl_as_cken";
            desc = "HDMI TX AS clock gating
- 0: disabled
- 1: enabled";
            sw = rw; hw = r;
            reset = 0x1;
        } hdmitx_ctrl_as_cken[5:5];
        field {
            name = "HDMIhdmitx_ctrl_os_cke0:n1:";
            desc = "TX OS clock gating disabled enabled";
            sw = rw; hw = r;
            reset = 0x1;
        } HDMIhdmitx_ctrl_os_cke0_n1[4:4];
        field {
            name = "HDMIhdmitx_ctrl_mhl_c0:ken1:";
            desc = "TX clock gating disabled enabled";
            sw = rw; hw = r;
            reset = 0x1;
        } HDMIhdmitx_ctrl_mhl_c0_ken1[3:3];
        field {
            name = "HDMIhdmitx_ctrl_id_cke0:n1:";
            desc = "TX ID clock gating disabled enabled";
            sw = rw; hw = r;
            reset = 0x1;
        } HDMIhdmitx_ctrl_id_cke0_n1[2:2];
        field {
            name = "HDMIhdmitx_ctrl_cec_ck0:en1:";
            desc = "TX CEC clock gating disabled enabled";
            sw = rw; hw = r;
            reset = 0x1;
        } HDMIhdmitx_ctrl_cec_ck0_en1[1:1];
        field {
            name = "HDMIhdmitx_ctrl_bus_ck0:en1:";
            desc = "TX bus clock gating disabled enabled";
            sw = rw; hw = r;
            reset = 0x1;
        } HDMIhdmitx_ctrl_bus_ck0_en1[0:0];
    } PERI_CRG14 @ 0x38;
    reg {
        name = "PERI_CRG15";
        desc = "PERI_CRG15 is a VEDU0 clock and soft reset control register. (offset 0x3C; total reset 0x00000802; PROVEN: Hi3521A/Hi3520D V300 data sheet (Issue 00B07, 2015-12-10), section 3.2.7, PDF page 520).";
        field {
            name = "reserved";
            desc = "Reserved";
            sw = r; hw = w;
            reset = 0x0;
        } reserved_31_12[31:12];
        field {
            name = "sed0_cken";
            desc = "SED0 clock gating
- 0: The clock is disabled.
- 1: The clock is enabled.";
            sw = rw; hw = r;
            reset = 0x1;
        } sed0_cken[11:11];
        field {
            name = "sed0_srst_req";
            desc = "SED0 soft reset
- 0: deassert reset
- 1: reset";
            sw = rw; hw = r;
            reset = 0x0;
        } sed0_srst_req[10:10];
        field {
            name = "vedu0clk_loaden";
            desc = "VEDU0 clock skip configuration enable To change the skip configuration, perform the following steps: 1. Write a new skip configuration value. 2. Write 0 to vedu0clk_loaden. 3. Write 1 to vedu0clk_loaden.";
            sw = rw; hw = r;
            reset = 0x0;
        } vedu0clk_loaden[9:9];
        field {
            name = "vedu0clk_skipcfg";
            desc = "VEDU0 clock skip configuration N: N-beat clocks are disabled every 32-beat VEDU clocks.";
            sw = rw; hw = r;
            reset = 0x0;
        } vedu0clk_skipcfg[8:4];
        field {
            name = "sed0_cksel";
            desc = "SED0 clock frequency select
- 0: 187 MHz
- 1: reserved";
            sw = rw; hw = r;
            reset = 0x0;
        } sed0_cksel[3:3];
        field {
            name = "vedu0_cksel";
            desc = "VEDU0 clock frequency select. This bit works with PERI_CRG13[vedu0_cksel1] for selecting the clock. {vedu0_cksel1, vedu0_cksel} x0: 324MHz
- 01: 405MHz
- 11: reserved";
            sw = rw; hw = r;
            reset = 0x0;
        } vedu0_cksel[2:2];
        field {
            name = "vedu0_cken";
            desc = "VEDU0 clock gating
- 0: The clock is disabled.
- 1: The clock is enabled.";
            sw = rw; hw = r;
            reset = 0x1;
        } vedu0_cken[1:1];
        field {
            name = "vedu0_srst_req";
            desc = "VEDU0 soft reset
- 0: deassert reset
- 1: reset";
            sw = rw; hw = r;
            reset = 0x0;
        } vedu0_srst_req[0:0];
    } PERI_CRG15 @ 0x3C;
    reg {
        name = "PERI_CRG16";
        desc = "PERI_CRG16 is a VEDU1 clock and soft reset control register. (offset 0x40; total reset 0x00000802; PROVEN: Hi3521A/Hi3520D V300 data sheet (Issue 00B07, 2015-12-10), section 3.2.7, PDF page 522).";
        field {
            name = "reserved";
            desc = "Reserved";
            sw = r; hw = w;
            reset = 0x0;
        } reserved_31_12[31:12];
        field {
            name = "sed1_cken";
            desc = "SED1 clock gating
- 0: The clock is disabled.
- 1: The clock is enabled.";
            sw = rw; hw = r;
            reset = 0x1;
        } sed1_cken[11:11];
        field {
            name = "sed1_srst_req";
            desc = "SED1 soft reset
- 0: deassert reset
- 1: reset";
            sw = rw; hw = r;
            reset = 0x0;
        } sed1_srst_req[10:10];
        field {
            name = "vedu1clk_loaden";
            desc = "VEDU1 clock skip configuration enable To change the skip configuration, perform the following steps: 1. Write a new skip configuration value. 2. Write 0 to vedu1clk_loaden. 3. Write 1 to vedu1clk_loaden.";
            sw = rw; hw = r;
            reset = 0x0;
        } vedu1clk_loaden[9:9];
        field {
            name = "vedu1clk_skipcfg";
            desc = "VEDU1 clock skip configuration. N: N-beat clocks are disabled every 32-beat VEDU clocks.";
            sw = rw; hw = r;
            reset = 0x0;
        } vedu1clk_skipcfg[8:4];
        field {
            name = "sed1_cksel";
            desc = "SED1 clock frequency select
- 0: 187 MHz
- 1: reserved";
            sw = rw; hw = r;
            reset = 0x0;
        } sed1_cksel[3:3];
        field {
            name = "vedu1_cksel";
            desc = "VEDU1 clock frequency select. This bit works with PERI_CRG13[vedu1_cksel1] for selecting the clock. {vedu1_cksel1, vedu1_cksel} x0: 324 MHz
- 01: 405 MHz
- 11: reserved";
            sw = rw; hw = r;
            reset = 0x0;
        } vedu1_cksel[2:2];
        field {
            name = "vedu1_cken";
            desc = "VEDU1 clock gating
- 0: The clock is disabled.
- 1: The clock is enabled.";
            sw = rw; hw = r;
            reset = 0x1;
        } vedu1_cken[1:1];
        field {
            name = "vedu1_srst_req";
            desc = "VEDU1 soft reset
- 0: deassert reset
- 1: reset";
            sw = rw; hw = r;
            reset = 0x0;
        } vedu1_srst_req[0:0];
    } PERI_CRG16 @ 0x40;
    reg {
        name = "PERI_CRG17";
        desc = "PERI_CRG17 is a VPSS clock and soft reset control register. (offset 0x44; total reset 0x00000002; PROVEN: Hi3521A/Hi3520D V300 data sheet (Issue 00B07, 2015-12-10), section 3.2.7, PDF page 523).";
        field {
            name = "reserved";
            desc = "Reserved";
            sw = r; hw = w;
            reset = 0x0;
        } reserved_31_10[31:10];
        field {
            name = "vpsclk_loaden";
            desc = "VPSS clock skip configuration enable To change the skip configuration, perform the following steps: 1. Write a new skip configuration value. 2. Write 0 to vpsclk_loaden. 3. Write 1 to vpsclk_loaden.";
            sw = rw; hw = r;
            reset = 0x0;
        } vpsclk_loaden[9:9];
        field {
            name = "vpsclk_skipcfg";
            desc = "VPSS clock skip configuration N: N-beat clocks are disabled every 32-beat VPS clocks.";
            sw = rw; hw = r;
            reset = 0x0;
        } vpsclk_skipcfg[8:4];
        field {
            name = "vps_cksel";
            desc = "Frequency select for the VPSS working clock
- 00: 375 MHz
- 01: 405 MHz
- 10: reserved
- 11: reserved";
            sw = rw; hw = r;
            reset = 0x0;
        } vps_cksel[3:2];
        field {
            name = "vps_cken";
            desc = "VPSS clock gating
- 0: The clock is disabled.
- 1: The clock is enabled.";
            sw = rw; hw = r;
            reset = 0x1;
        } vps_cken[1:1];
        field {
            name = "vps_srst_req";
            desc = "VPSS soft reset
- 0: deassert reset
- 1: reset";
            sw = rw; hw = r;
            reset = 0x0;
        } vps_srst_req[0:0];
    } PERI_CRG17 @ 0x44;
    reg {
        name = "PERI_CRG18";
        desc = "PERI_CRG18 is a TDE clock and soft reset control register. (offset 0x48; total reset 0x00000002; PROVEN: Hi3521A/Hi3520D V300 data sheet (Issue 00B07, 2015-12-10), section 3.2.7, PDF page 524).";
        field {
            name = "reserved";
            desc = "Reserved";
            sw = r; hw = w;
            reset = 0x0;
        } reserved_31_10[31:10];
        field {
            name = "tdeclk_loaden";
            desc = "TDE clock skip configuration enable To change the skip configuration, perform the following steps: 1. Write a new skip configuration value. 2. Write 0 to tdeclk_loaden. 3. Write 1 to tdeclk_loaden.";
            sw = rw; hw = r;
            reset = 0x0;
        } tdeclk_loaden[9:9];
        field {
            name = "tdeclk_skipcfg";
            desc = "TDE clock skip configuration N: N-beat clocks are disabled every 32-beat TDE clocks.";
            sw = rw; hw = r;
            reset = 0x0;
        } tdeclk_skipcfg[8:4];
        field {
            name = "reserved";
            desc = "Reserved";
            sw = r; hw = w;
            reset = 0x0;
        } reserved_3_2[3:2];
        field {
            name = "tde_cken";
            desc = "TDE clock gating
- 0: The clock is disabled.
- 1: The clock is enabled.";
            sw = rw; hw = r;
            reset = 0x1;
        } tde_cken[1:1];
        field {
            name = "tde_srst_req";
            desc = "TDE soft reset
- 0: deassert reset
- 1: reset";
            sw = rw; hw = r;
            reset = 0x0;
        } tde_srst_req[0:0];
    } PERI_CRG18 @ 0x48;
    reg {
        name = "PERI_CRG19";
        desc = "PERI_CRG19 is a VGS clock and soft reset control register. (offset 0x4C; total reset 0x00000002; PROVEN: Hi3521A/Hi3520D V300 data sheet (Issue 00B07, 2015-12-10), section 3.2.7, PDF page 525).";
        field {
            name = "reserved";
            desc = "Reserved";
            sw = r; hw = w;
            reset = 0x0;
        } reserved_31_10[31:10];
        field {
            name = "vgsclk_loaden";
            desc = "VGS clock skip configuration enable To change the skip configuration, perform the following steps: 1. Write a new skip configuration value. 2. Write 0 to vgsclk_loaden. 3. Write 1 to vgsclk_loaden.";
            sw = rw; hw = r;
            reset = 0x0;
        } vgsclk_loaden[9:9];
        field {
            name = "vgsclk_skipcfg";
            desc = "VGS clock skip configuration N: N-beat clocks are disabled every 32-beat TDE clocks.";
            sw = rw; hw = r;
            reset = 0x0;
        } vgsclk_skipcfg[8:4];
        field {
            name = "reserved";
            desc = "Reserved";
            sw = r; hw = w;
            reset = 0x0;
        } reserved_3_3[3:3];
        field {
            name = "vgs_cksel";
            desc = "Frequency select for the VGS clock
- 0: 300 MHz
- 1: reserved";
            sw = rw; hw = r;
            reset = 0x0;
        } vgs_cksel[2:2];
        field {
            name = "vgs_cken";
            desc = "VGS clock gating
- 0: The clock is disabled.
- 1: The clock is enabled.";
            sw = rw; hw = r;
            reset = 0x1;
        } vgs_cken[1:1];
        field {
            name = "vgs_srst_req";
            desc = "VGS soft reset
- 0: deassert reset
- 1: reset";
            sw = rw; hw = r;
            reset = 0x0;
        } vgs_srst_req[0:0];
    } PERI_CRG19 @ 0x4C;
    reg {
        name = "PERI_CRG20";
        desc = "PERI_CRG20 is a JPGE/VOIE clock and soft reset control register. (offset 0x50; total reset 0x00020002; PROVEN: Hi3521A/Hi3520D V300 data sheet (Issue 00B07, 2015-12-10), section 3.2.7, PDF page 526).";
        field {
            name = "reserved";
            desc = "Reserved";
            sw = r; hw = w;
            reset = 0x0;
        } reserved_31_26[31:26];
        field {
            name = "voieclk_loaden";
            desc = "VOIE clock skip configuration enable To change the skip configuration, perform the following steps: 1. Write a new skip configuration value. 2. Write 0 to voieclk_loaden. 3. Write 1 to voieclk_loaden.";
            sw = rw; hw = r;
            reset = 0x0;
        } voieclk_loaden[25:25];
        field {
            name = "voieclk_skipcfg";
            desc = "VOIE clock skip configuration N: N-beat clocks are disabled every 32-beat TDE clocks.";
            sw = rw; hw = r;
            reset = 0x0;
        } voieclk_skipcfg[24:20];
        field {
            name = "reserved";
            desc = "Reserved";
            sw = r; hw = w;
            reset = 0x0;
        } reserved_19_18[19:18];
        field {
            name = "voie_cken";
            desc = "VOIE clock gating
- 0: The clock is disabled.
- 1: The clock is enabled.";
            sw = rw; hw = r;
            reset = 0x1;
        } voie_cken[17:17];
        field {
            name = "voie_srst_req";
            desc = "VOIE soft reset
- 0: deassert reset
- 1: reset";
            sw = rw; hw = r;
            reset = 0x0;
        } voie_srst_req[16:16];
        field {
            name = "reserved";
            desc = "Reserved";
            sw = r; hw = w;
            reset = 0x0;
        } reserved_15_10[15:10];
        field {
            name = "jpgeclk_loaden";
            desc = "JPGE clock skip configuration enable To change the skip configuration, perform the following steps: 1. Write a new skip configuration value. 2. Write 0 to jpgeclk_loaden. 3. Write 1 to jpgeclk_loaden.";
            sw = rw; hw = r;
            reset = 0x0;
        } jpgeclk_loaden[9:9];
        field {
            name = "jpgeclk_skipcfg";
            desc = "JPGE clock skip configuration N: N-beat clocks are disabled every 32-beat TDE clocks.";
            sw = rw; hw = r;
            reset = 0x0;
        } jpgeclk_skipcfg[8:4];
        field {
            name = "reserved";
            desc = "Reserved";
            sw = r; hw = w;
            reset = 0x0;
        } reserved_3_2[3:2];
        field {
            name = "jpge_cken";
            desc = "JPGE clock gating
- 0: The clock is disabled.
- 1: The clock is enabled.";
            sw = rw; hw = r;
            reset = 0x1;
        } jpge_cken[1:1];
        field {
            name = "jpge_srst_req";
            desc = "JPGE soft reset
- 0: deassert reset
- 1: reset";
            sw = rw; hw = r;
            reset = 0x0;
        } jpge_srst_req[0:0];
    } PERI_CRG20 @ 0x50;
    reg {
        name = "PERI_CRG21";
        desc = "PERI_CRG21 is a JPGD clock and soft reset control register. (offset 0x54; total reset 0x00000002; PROVEN: Hi3521A/Hi3520D V300 data sheet (Issue 00B07, 2015-12-10), section 3.2.7, PDF page 527).";
        field {
            name = "reserved";
            desc = "Reserved";
            sw = r; hw = w;
            reset = 0x0;
        } reserved_31_10[31:10];
        field {
            name = "jpgdclk_loaden";
            desc = "JPGD clock skip configuration enable To change the skip configuration, perform the following steps: 1. Write a new skip configuration value. 2. Write 0 to jpgdclk_loaden. 3. Write 1 to jpgdclk_loaden.";
            sw = rw; hw = r;
            reset = 0x0;
        } jpgdclk_loaden[9:9];
        field {
            name = "jpgdclk_skipcfg";
            desc = "JPGD clock skip configuration N: N-beat clocks are disabled every 32-beat TDE clocks.";
            sw = rw; hw = r;
            reset = 0x0;
        } jpgdclk_skipcfg[8:4];
        field {
            name = "reserved";
            desc = "Reserved";
            sw = r; hw = w;
            reset = 0x0;
        } reserved_3_2[3:2];
        field {
            name = "jpgd_cken";
            desc = "JPGD clock gating
- 0: The clock is disabled.
- 1: The clock is enabled.";
            sw = rw; hw = r;
            reset = 0x1;
        } jpgd_cken[1:1];
        field {
            name = "jpgd_srst_req";
            desc = "JPGD soft reset
- 0: deassert reset
- 1: reset";
            sw = rw; hw = r;
            reset = 0x0;
        } jpgd_srst_req[0:0];
    } PERI_CRG21 @ 0x54;
    reg {
        name = "PERI_CRG22";
        desc = "PERI_CRG22 is an MDU clock and soft reset control register. (offset 0x58; total reset 0x00000002; PROVEN: Hi3521A/Hi3520D V300 data sheet (Issue 00B07, 2015-12-10), section 3.2.7, PDF page 528).";
        field {
            name = "reserved";
            desc = "Reserved";
            sw = r; hw = w;
            reset = 0x0;
        } reserved_31_10[31:10];
        field {
            name = "mduclk_loaden";
            desc = "MDU clock skip configuration enable To change the skip configuration, perform the following steps: 1. Write a new skip configuration value. 2. Write 0 to mduclk_loaden. 3. Write 1 to mduclk_loaden.";
            sw = rw; hw = r;
            reset = 0x0;
        } mduclk_loaden[9:9];
        field {
            name = "mduclk_skipcfg";
            desc = "MDU clock skip configuration N: N-beat clocks are disabled every 32-beat TDE clocks.";
            sw = rw; hw = r;
            reset = 0x0;
        } mduclk_skipcfg[8:4];
        field {
            name = "reserved";
            desc = "Reserved";
            sw = r; hw = w;
            reset = 0x0;
        } reserved_3_2[3:2];
        field {
            name = "mdu_cken";
            desc = "MDU clock gating
- 0: The clock is disabled.
- 1: The clock is enabled.";
            sw = rw; hw = r;
            reset = 0x1;
        } mdu_cken[1:1];
        field {
            name = "mdu_srst_req";
            desc = "MDU soft reset
- 0: deassert reset
- 1: reset";
            sw = rw; hw = r;
            reset = 0x0;
        } mdu_srst_req[0:0];
    } PERI_CRG22 @ 0x58;
    reg {
        name = "PERI_CRG23";
        desc = "PERI_CRG23 is an IVE clock and soft reset control register. (offset 0x5C; total reset 0x00000002; PROVEN: Hi3521A/Hi3520D V300 data sheet (Issue 00B07, 2015-12-10), section 3.2.7, PDF page 529).";
        field {
            name = "reserved";
            desc = "Reserved";
            sw = r; hw = w;
            reset = 0x0;
        } reserved_31_2[31:2];
        field {
            name = "ive_cken";
            desc = "IVE clock gating
- 0: The clock is disabled.
- 1: The clock is enabled.";
            sw = rw; hw = r;
            reset = 0x1;
        } ive_cken[1:1];
        field {
            name = "ive_srst_req";
            desc = "IVE soft reset
- 0: deassert reset
- 1: reset";
            sw = rw; hw = r;
            reset = 0x0;
        } ive_srst_req[0:0];
    } PERI_CRG23 @ 0x5C;
    reg {
        name = "PERI_CRG24";
        desc = "PERI_CRG24 is a cipher clock and soft reset control register. (offset 0x60; total reset 0x00000002; PROVEN: Hi3521A/Hi3520D V300 data sheet (Issue 00B07, 2015-12-10), section 3.2.7, PDF page 529).";
        field {
            name = "reserved";
            desc = "Reserved";
            sw = r; hw = w;
            reset = 0x0;
        } reserved_31_2[31:2];
        field {
            name = "cipher_cken";
            desc = "Cipher clock gating
- 0: The clock is disabled.
- 1: The clock is enabled.";
            sw = rw; hw = r;
            reset = 0x1;
        } cipher_cken[1:1];
        field {
            name = "cipher_srst_req";
            desc = "Cipher soft reset
- 0: deassert reset
- 1: reset";
            sw = rw; hw = r;
            reset = 0x0;
        } cipher_srst_req[0:0];
    } PERI_CRG24 @ 0x60;
    reg {
        name = "PERI_CRG25";
        desc = "PERI_CRG25 is an AIAO clock and reset control register. (offset 0x64; total reset 0x00000002; PROVEN: Hi3521A/Hi3520D V300 data sheet (Issue 00B07, 2015-12-10), section 3.2.7, PDF page 530).";
        field {
            name = "reserved";
            desc = "Reserved";
            sw = r; hw = w;
            reset = 0x0;
        } reserved_31_4[31:4];
        field {
            name = "aio_cksel";
            desc = "AIAO MCLK PLL source select
- 00: 500 MHz
- 01: EPLL_FOUTVCO 1x: reserved";
            sw = rw; hw = r;
            reset = 0x0;
        } aio_cksel[3:2];
        field {
            name = "aiao_cken";
            desc = "AIAO clock gating
- 0: The clock is disabled.
- 1: The clock is enabled.";
            sw = rw; hw = r;
            reset = 0x1;
        } aiao_cken[1:1];
        field {
            name = "aio_srst_req";
            desc = "AIAO soft reset
- 0: deassert reset
- 1: reset";
            sw = rw; hw = r;
            reset = 0x0;
        } aio_srst_req[0:0];
    } PERI_CRG25 @ 0x64;
    reg {
        name = "PERI_CRG26";
        desc = "PERI_CRG26 is an SATA PHY clock and reset control register. (offset 0x68; total reset 0x00000005; PROVEN: Hi3521A/Hi3520D V300 data sheet (Issue 00B07, 2015-12-10), section 3.2.7, PDF page 531).";
        field {
            name = "reserved";
            desc = "Reserved";
            sw = r; hw = w;
            reset = 0x0;
        } reserved_31_4[31:4];
        field {
            name = "sata_phy1_refclk_sel";
            desc = "SATA PHY1 refclk select
- 0: 100 MHz
- 1: 24 MHz";
            sw = rw; hw = r;
            reset = 0x0;
        } sata_phy1_refclk_sel[3:3];
        field {
            name = "sata_phy1_ref_cken";
            desc = "SATA PHY1 refclk clock gating
- 0: disabled
- 1: enabled";
            sw = rw; hw = r;
            reset = 0x1;
        } sata_phy1_ref_cken[2:2];
        field {
            name = "sata_phy0_refclk_sel";
            desc = "SATA PHY0 refclk select
- 0: 100 MHz
- 1: 24 MHz";
            sw = rw; hw = r;
            reset = 0x0;
        } sata_phy0_refclk_sel[1:1];
        field {
            name = "sata_phy0_ref_cken";
            desc = "SATA PHY0 refclk clock gating
- 0: disabled
- 1: enabled";
            sw = rw; hw = r;
            reset = 0x1;
        } sata_phy0_ref_cken[0:0];
    } PERI_CRG26 @ 0x68;
    reg {
        name = "PERI_CRG27";
        desc = "PERI_CRG27 is an SATA controller clock and reset control register. (offset 0x6C; total reset 0x00030770; PROVEN: Hi3521A/Hi3520D V300 data sheet (Issue 00B07, 2015-12-10), section 3.2.7, PDF page 532).";
        field {
            name = "reserved";
            desc = "Reserved";
            sw = r; hw = w;
            reset = 0x0;
        } reserved_31_18[31:18];
        field {
            name = "sata_refclk1_cken";
            desc = "SATA CTRL port 1 refclk clock gating
- 0: disabled
- 1: enabled";
            sw = rw; hw = r;
            reset = 0x1;
        } sata_refclk1_cken[17:17];
        field {
            name = "sata_mpll_dword1_cken";
            desc = "SATA CTRL port 1 mpll_dword clock gating
- 0: disabled
- 1: enabled";
            sw = rw; hw = r;
            reset = 0x1;
        } sata_mpll_dword1_cken[16:16];
        field {
            name = "reserved";
            desc = "Reserved";
            sw = r; hw = w;
            reset = 0x0;
        } reserved_15_14[15:14];
        field {
            name = "sata_cko_alive_srst_req";
            desc = "SATA CTRL cko_alive soft reset
- 0: deassert reset
- 1: reset";
            sw = rw; hw = r;
            reset = 0x0;
        } sata_cko_alive_srst_req[13:13];
        field {
            name = "sata_bus_srst_req";
            desc = "SATA CTRL bus soft reset
- 0: deassert reset
- 1: reset";
            sw = rw; hw = r;
            reset = 0x0;
        } sata_bus_srst_req[12:12];
        field {
            name = "reserved";
            desc = "Reserved";
            sw = r; hw = w;
            reset = 0x0;
        } reserved_11_11[11:11];
        field {
            name = "sata_refclk0_cken";
            desc = "SATA CTRL port 0 refclk clock gating
- 0: disabled
- 1: enabled";
            sw = rw; hw = r;
            reset = 0x1;
        } sata_refclk0_cken[10:10];
        field {
            name = "sata_mpll_dword0_cken";
            desc = "SATA CTRL port 0 mpll_dword clock gating
- 0: disabled
- 1: enabled";
            sw = rw; hw = r;
            reset = 0x1;
        } sata_mpll_dword0_cken[9:9];
        field {
            name = "sata_cko_alive_cken";
            desc = "SATA CTRL cko_alive clock gating
- 0: disabled
- 1: enabled";
            sw = rw; hw = r;
            reset = 0x1;
        } sata_cko_alive_cken[8:8];
        field {
            name = "reserved";
            desc = "Reserved";
            sw = r; hw = w;
            reset = 0x0;
        } reserved_7_7[7:7];
        field {
            name = "sata_rx1_cken";
            desc = "SATA CTRL RX1 clock gating
- 0: disabled
- 1: enabled";
            sw = rw; hw = r;
            reset = 0x1;
        } sata_rx1_cken[6:6];
        field {
            name = "sata_rx0_cken";
            desc = "SATA ctrl rx0 clock gating
- 0: disabled
- 1: enabled";
            sw = rw; hw = r;
            reset = 0x1;
        } sata_rx0_cken[5:5];
        field {
            name = "sata_bus_cken";
            desc = "SATA CTRL bus clock gating
- 0: disabled
- 1: enabled";
            sw = rw; hw = r;
            reset = 0x1;
        } sata_bus_cken[4:4];
        field {
            name = "reserved";
            desc = "Reserved";
            sw = r; hw = w;
            reset = 0x0;
        } reserved_3_0[3:0];
    } PERI_CRG27 @ 0x6C;
    reg {
        name = "PERI_CRG28";
        desc = "PERI_CRG28 is a USB clock and soft reset control register. (offset 0x70; total reset 0x0000008E; PROVEN: Hi3521A/Hi3520D V300 data sheet (Issue 00B07, 2015-12-10), section 3.2.7, PDF page 533).";
        field {
            name = "reserved";
            desc = "Reserved";
            sw = r; hw = w;
            reset = 0x0;
        } reserved_31_8[31:8];
        field {
            name = "usb2_cken";
            desc = "USB PHY reference clock gating
- 0: disabled
- 1: enabled";
            sw = rw; hw = r;
            reset = 0x1;
        } usb2_cken[7:7];
        field {
            name = "usb2_ctrl_utmi1_req";
            desc = "USB controller port 1 soft reset
- 0: deassert reset
- 1: reset";
            sw = rw; hw = r;
            reset = 0x0;
        } usb2_ctrl_utmi1_req[6:6];
        field {
            name = "usb2_ctrl_utmi0_req";
            desc = "USB controller port 0 soft reset
- 0: deassert reset
- 1: reset";
            sw = rw; hw = r;
            reset = 0x0;
        } usb2_ctrl_utmi0_req[5:5];
        field {
            name = "usb2_ctrl_hub_req";
            desc = "USB controller hub soft reset
- 0: deassert reset
- 1: reset";
            sw = rw; hw = r;
            reset = 0x0;
        } usb2_ctrl_hub_req[4:4];
        field {
            name = "usb2phy_port1_treq";
            desc = "USB PHY port 1 soft reset
- 0: deassert reset
- 1: reset";
            sw = rw; hw = r;
            reset = 0x1;
        } usb2phy_port1_treq[3:3];
        field {
            name = "usb2phy_port0_treq";
            desc = "USB PHY port 0 soft reset
- 0: deassert reset
- 1: reset";
            sw = rw; hw = r;
            reset = 0x1;
        } usb2phy_port0_treq[2:2];
        field {
            name = "usb2phy_req";
            desc = "USB PHY soft reset
- 0: deassert reset
- 1: reset";
            sw = rw; hw = r;
            reset = 0x1;
        } usb2phy_req[1:1];
        field {
            name = "usb2_ahb_srst_req";
            desc = "USB controller bus soft reset
- 0: deassert reset
- 1: reset";
            sw = rw; hw = r;
            reset = 0x0;
        } usb2_ahb_srst_req[0:0];
    } PERI_CRG28 @ 0x70;
    reg {
        name = "PERI_CRG29";
        desc = "PERI_CRG29 is an FMC clock and soft reset control register. (offset 0x74; total reset 0x00000002; PROVEN: Hi3521A/Hi3520D V300 data sheet (Issue 00B07, 2015-12-10), section 3.2.7, PDF page 534).";
        field {
            name = "reserved";
            desc = "Reserved";
            sw = r; hw = w;
            reset = 0x0;
        } reserved_31_4[31:4];
        field {
            name = "fmc_cksel";
            desc = "FMC clock source select
- 00: 24 MHz clock
- 01: 83 MHz clock
- 10: 150 MHz clock
- 11: reserved";
            sw = rw; hw = r;
            reset = 0x0;
        } fmc_cksel[3:2];
        field {
            name = "fmc_cken";
            desc = "FMC clock gating
- 0: The clock is disabled.
- 1: The clock is enabled.";
            sw = rw; hw = r;
            reset = 0x1;
        } fmc_cken[1:1];
        field {
            name = "fmc_srst_req";
            desc = "FMC soft reset
- 0: deassert reset
- 1: reset";
            sw = rw; hw = r;
            reset = 0x0;
        } fmc_srst_req[0:0];
    } PERI_CRG29 @ 0x74;
    reg {
        name = "PERI_CRG30";
        desc = "PERI_CRG30 is a GSF/GMAC/FEPHY clock and soft reset control register. (offset 0x78; total reset 0x0000000A; PROVEN: Hi3521A/Hi3520D V300 data sheet (Issue 00B07, 2015-12-10), section 3.2.7, PDF page 535).";
        field {
            name = "reserved";
            desc = "Reserved";
            sw = r; hw = w;
            reset = 0x0;
        } reserved_31_8[31:8];
        field {
            name = "gsf_cksel";
            desc = "GSF working clock select
- 0: 125 MHz clock
- 1: 75 MHz clock";
            sw = rw; hw = r;
            reset = 0x0;
        } gsf_cksel[7:7];
        field {
            name = "ext_fephy_cksel";
            desc = "External FEPHY clock select
- 1: 25 MHz clock
- 0: 50 MHz clock";
            sw = rw; hw = r;
            reset = 0x0;
        } ext_fephy_cksel[6:6];
        field {
            name = "ext_fephy_srst_req";
            desc = "External FEPHY soft reset
- 0: deassert reset
- 1: reset";
            sw = rw; hw = r;
            reset = 0x0;
        } ext_fephy_srst_req[5:5];
        field {
            name = "rmii_cksel";
            desc = "RMII clock select
- 1: PAD input clock
- 0: CRG clock";
            sw = rw; hw = r;
            reset = 0x0;
        } rmii_cksel[4:4];
        field {
            name = "gmac_if_cken";
            desc = "GMAC clock gating
- 0: The clock is disabled.
- 1: The clock is enabled.";
            sw = rw; hw = r;
            reset = 0x1;
        } gmac_if_cken[3:3];
        field {
            name = "gmac_if_srst_req";
            desc = "GMAC soft reset
- 0: deassert reset
- 1: reset";
            sw = rw; hw = r;
            reset = 0x0;
        } gmac_if_srst_req[2:2];
        field {
            name = "gsf_cken";
            desc = "GSF clock gating
- 0: The clock is disabled.
- 1: The clock is enabled.";
            sw = rw; hw = r;
            reset = 0x1;
        } gsf_cken[1:1];
        field {
            name = "gsf_srst_req";
            desc = "GSF soft rest
- 0: deassert reset
- 1: reset";
            sw = rw; hw = r;
            reset = 0x0;
        } gsf_srst_req[0:0];
    } PERI_CRG30 @ 0x78;
    reg {
        name = "PERI_CRG31";
        desc = "PERI_CRG31 is an SCD clock and soft reset control register. (offset 0x7C; total reset 0x00000002; PROVEN: Hi3521A/Hi3520D V300 data sheet (Issue 00B07, 2015-12-10), section 3.2.7, PDF page 536).";
        field {
            name = "reserved";
            desc = "Reserved";
            sw = r; hw = w;
            reset = 0x0;
        } reserved_31_2[31:2];
        field {
            name = "scd_cken";
            desc = "SCD clock gating
- 0: The clock is disabled.
- 1: The clock is enabled.";
            sw = rw; hw = r;
            reset = 0x1;
        } scd_cken[1:1];
        field {
            name = "scd_srst_req";
            desc = "SCD soft reset
- 0: deassert reset
- 1: reset";
            sw = rw; hw = r;
            reset = 0x0;
        } scd_srst_req[0:0];
    } PERI_CRG31 @ 0x7C;
    reg {
        name = "PERI_CRG32";
        desc = "PERI_CRG32 is a DMA/DDRTEST/EFUSE clock and soft reset control register. (offset 0x80; total reset 0x0000002A; PROVEN: Hi3521A/Hi3520D V300 data sheet (Issue 00B07, 2015-12-10), section 3.2.7, PDF page 537).";
        field {
            name = "reserved";
            desc = "Reserved";
            sw = r; hw = w;
            reset = 0x0;
        } reserved_31_6[31:6];
        field {
            name = "dma_cken";
            desc = "DMA clock gating
- 0: The clock is disabled.
- 1: The clock is enabled.";
            sw = rw; hw = r;
            reset = 0x1;
        } dma_cken[5:5];
        field {
            name = "dma_srst_req";
            desc = "DMA soft reset
- 0: deassert reset
- 1: reset";
            sw = rw; hw = r;
            reset = 0x0;
        } dma_srst_req[4:4];
        field {
            name = "ddrtest_cken";
            desc = "DDRTEST clock gating
- 0: The clock is disabled.
- 1: The clock is enabled.";
            sw = rw; hw = r;
            reset = 0x1;
        } ddrtest_cken[3:3];
        field {
            name = "ddrtest_srst_req";
            desc = "DDRTEST soft reset
- 0: deassert reset
- 1: reset";
            sw = rw; hw = r;
            reset = 0x0;
        } ddrtest_srst_req[2:2];
        field {
            name = "reserved";
            desc = "Reserved";
            sw = r; hw = w;
            reset = 0x1;
        } reserved_1_1[1:1];
        field {
            name = "reserved";
            desc = "Reserved";
            sw = r; hw = w;
            reset = 0x0;
        } reserved_0_0[0:0];
    } PERI_CRG32 @ 0x80;
    reg {
        name = "PERI_CRG33";
        desc = "PERI_CRG33 is an APB peripheral clock and reset control register. (offset 0x84; total reset 0x0003B001; PROVEN: Hi3521A/Hi3520D V300 data sheet (Issue 00B07, 2015-12-10), section 3.2.7, PDF page 538).";
        field {
            name = "reserved";
            desc = "Reserved";
            sw = r; hw = w;
            reset = 0x0;
        } reserved_31_20[31:20];
        field {
            name = "uart_cksel";
            desc = "UART clock select
- 00: APB clock
- 01: 2 MHz clock
- 10: crystal oscillator clock
- 11: reserved";
            sw = rw; hw = r;
            reset = 0x0;
        } uart_cksel[19:18];
        field {
            name = "uart2_cken";
            desc = "UART2 clock gating
- 0: The clock is disabled.
- 1: The clock is enabled.";
            sw = rw; hw = r;
            reset = 0x1;
        } uart2_cken[17:17];
        field {
            name = "uart1_cken";
            desc = "UART1 clock gating
- 0: The clock is disabled.
- 1: The clock is enabled.";
            sw = rw; hw = r;
            reset = 0x1;
        } uart1_cken[16:16];
        field {
            name = "uart0_cken";
            desc = "UART0 clock gating
- 0: The clock is disabled.
- 1: The clock is enabled.";
            sw = rw; hw = r;
            reset = 0x1;
        } uart0_cken[15:15];
        field {
            name = "reserved";
            desc = "Reserved";
            sw = r; hw = w;
            reset = 0x0;
        } reserved_14_14[14:14];
        field {
            name = "ssp_cken";
            desc = "SSP clock gating
- 0: The clock is disabled.
- 1: The clock is enabled.";
            sw = rw; hw = r;
            reset = 0x1;
        } ssp_cken[13:13];
        field {
            name = "ir_cken";
            desc = "IR clock gating
- 0: The clock is disabled.
- 1: The clock is enabled.";
            sw = rw; hw = r;
            reset = 0x1;
        } ir_cken[12:12];
        field {
            name = "reserved";
            desc = "Reserved";
            sw = r; hw = w;
            reset = 0x0;
        } reserved_11_10[11:10];
        field {
            name = "uart2_srst_req";
            desc = "UART2 soft reset
- 0: deassert reset
- 1: reset";
            sw = rw; hw = r;
            reset = 0x0;
        } uart2_srst_req[9:9];
        field {
            name = "uart1_srst_req";
            desc = "UART1 soft reset
- 0: deassert reset
- 1: reset";
            sw = rw; hw = r;
            reset = 0x0;
        } uart1_srst_req[8:8];
        field {
            name = "uart0_srst_req";
            desc = "UART0 soft reset
- 0: deassert reset
- 1: reset";
            sw = rw; hw = r;
            reset = 0x0;
        } uart0_srst_req[7:7];
        field {
            name = "reserved";
            desc = "Reserved";
            sw = rw; hw = r;
            reset = 0x0;
        } reserved_6_6[6:6];
        field {
            name = "ssp_srst_req";
            desc = "SSP soft reset
- 0: deassert reset
- 1: reset";
            sw = rw; hw = r;
            reset = 0x0;
        } ssp_srst_req[5:5];
        field {
            name = "ir_srst_req";
            desc = "IR soft reset
- 0: deassert reset
- 1: reset";
            sw = rw; hw = r;
            reset = 0x0;
        } ir_srst_req[4:4];
        field {
            name = "rtc_srst_req";
            desc = "RTC soft reset
- 0: deassert reset
- 1: reset";
            sw = rw; hw = r;
            reset = 0x0;
        } rtc_srst_req[3:3];
        field {
            name = "reserved";
            desc = "Reserved";
            sw = rw; hw = r;
            reset = 0x0;
        } reserved_2_2[2:2];
        field {
            name = "i2c_srst_req";
            desc = "I2C soft reset
- 0: deassert reset
- 1: reset";
            sw = rw; hw = r;
            reset = 0x0;
        } i2c_srst_req[1:1];
        field {
            name = "test_clk_en";
            desc = "Test clock enable
- 0: All test clocks are disabled.
- 1: All test clocks are enabled.";
            sw = rw; hw = r;
            reset = 0x1;
        } test_clk_en[0:0];
    } PERI_CRG33 @ 0x84;
    reg {
        name = "PERI_CRG34";
        desc = "PERI_CRG34 is a CRG status register. (offset 0x88; total reset 0x00000000; PROVEN: Hi3521A/Hi3520D V300 data sheet (Issue 00B07, 2015-12-10), section 3.2.7, PDF page 540).";
        field {
            name = "reserved";
            desc = "Reserved";
            sw = r; hw = w;
            reset = 0x0;
        } reserved_31_5[31:5];
        field {
            name = "dpll_lock";
            desc = "DPLL lock status
- 0: unlocked
- 1: locked";
            sw = r; hw = w;
            reset = 0x0;
        } dpll_lock[4:4];
        field {
            name = "epll_lock";
            desc = "EPLL lock status
- 0: unlocked
- 1: locked";
            sw = r; hw = w;
            reset = 0x0;
        } epll_lock[3:3];
        field {
            name = "vpll2_lock";
            desc = "VPLL2 lock status
- 0: unlocked
- 1: locked";
            sw = r; hw = w;
            reset = 0x0;
        } vpll2_lock[2:2];
        field {
            name = "vpll0_lock";
            desc = "VPLL0 lock status
- 0: unlocked
- 1: locked";
            sw = r; hw = w;
            reset = 0x0;
        } vpll0_lock[1:1];
        field {
            name = "apll_lock";
            desc = "APLL lock status
- 0: unlocked
- 1: locked";
            sw = r; hw = w;
            reset = 0x0;
        } apll_lock[0:0];
    } PERI_CRG34 @ 0x88;
    reg {
        name = "PERI_CRG35";
        desc = "PERI_CRG35 is a GMAC interface control register. (offset 0x8C; total reset 0x0000003F; PROVEN: Hi3521A/Hi3520D V300 data sheet (Issue 00B07, 2015-12-10), section 3.2.7, PDF page 541).";
        field {
            name = "reserved";
            desc = "Reserved";
            sw = r; hw = w;
            reset = 0x0;
        } reserved_31_9[31:9];
        field {
            name = "loopback_mode";
            desc = "Loopback mode enable
- 0: disabled
- 1: enabled";
            sw = rw; hw = r;
            reset = 0x0;
        } loopback_mode[8:8];
        field {
            name = "phy_select";
            desc = "PHY interface mode
- 000: GMII/MII mode
- 001: RGMII mode
- 100: RMII mode

Other values: reserved";
            sw = rw; hw = r;
            reset = 0x1;
        } phy_select[7:5];
        field {
            name = "duplex_mode";
            desc = "PHY duplex mode
- 0: half-duplex mode
- 1: full-duplex mode";
            sw = rw; hw = r;
            reset = 0x1;
        } duplex_mode[4:4];
        field {
            name = "tx_config";
            desc = "TX configuration enable
- 0: disabled
- 1: enabled";
            sw = rw; hw = r;
            reset = 0x1;
        } tx_config[3:3];
        field {
            name = "link_status";
            desc = "PHY connection status control
- 0: link down
- 1: link up";
            sw = rw; hw = r;
            reset = 0x1;
        } link_status[2:2];
        field {
            name = "mac_speed";
            desc = "10/100 Mbit/s mode select
- 0: 10 Mbit/s
- 1: 100 Mbit/s";
            sw = rw; hw = r;
            reset = 0x1;
        } mac_speed[1:1];
        field {
            name = "port_select";
            desc = "Gigabit mode select
- 0: 1000 Mbit/s
- 1: 10/100 Mbit/s";
            sw = rw; hw = r;
            reset = 0x1;
        } port_select[0:0];
    } PERI_CRG35 @ 0x8C;
    reg {
        name = "PERI_CRG36";
        desc = "PERI_CRG36 is a GMAC interface status register. (offset 0x90; total reset 0x00000000; PROVEN: Hi3521A/Hi3520D V300 data sheet (Issue 00B07, 2015-12-10), section 3.2.7, PDF page 542).";
        field {
            name = "reserved";
            desc = "Reserved";
            sw = r; hw = w;
            reset = 0x0;
        } reserved_31_4[31:4];
        field {
            name = "Link_status";
            desc = "Connection status when rxdv and rxer are both 0 in RGMII mode
- 0: link down
- 1: link up";
            sw = r; hw = w;
            reset = 0x0;
        } Link_status[3:3];
        field {
            name = "Link_speed";
            desc = "Rate status when rxdv and rxer are both 0 in RGMII mode
- 00: 2.5 MHz
- 01: 25 MHz
- 10: 125 MHz
- 11: reserved";
            sw = r; hw = w;
            reset = 0x0;
        } Link_speed[2:1];
        field {
            name = "Link_mode";
            desc = "Duplex mode when rxdv and rxer are both 0 in RGMII mode
- 0: half-duplex mode
- 1: full-duplex mode";
            sw = r; hw = w;
            reset = 0x0;
        } Link_mode[0:0];
    } PERI_CRG36 @ 0x90;
    reg {
        name = "PERI_CRG37";
        desc = "PERI_CRG37 is a VPLL0 spread spectrum configuration register. (offset 0x94; total reset 0x00000004; PROVEN: Hi3521A/Hi3520D V300 data sheet (Issue 00B07, 2015-12-10), section 3.2.7, PDF page 542).";
        field {
            name = "reserved";
            desc = "Reserved";
            sw = r; hw = w;
            reset = 0x0;
        } reserved_31_12[31:12];
        field {
            name = "vpll0_ssmod_cfg";
            desc = "ssmod divval[11:8] SSMOD divval control ssmod spread[6:4] SSMOD spread control
- 0: 0
- 1: 0.049%
- 2: 0.098%
- 3: 0.195%
- 4: 0.391%
- 5: 0.781%
- 6: 1.563%
- 7: 3.125% ssmod downspread[3]

SSMOD down spread control
- 0: central spread spectrum
- 1: down spread spectrum ssmod_disable[2]

SSMOD disable
- 0: enabled
- 1: disabled ssmod_rst_req [1]

SSMOD reset
- 0: deassert reset
- 1: reset ssmod_cken [0]

SSMOD clock gating 0 (default): disabled
- 1: enabled";
            sw = rw; hw = r;
            reset = 0x4;
        } vpll0_ssmod_cfg[11:0];
    } PERI_CRG37 @ 0x94;
    reg {
        name = "PERI_CRG38";
        desc = "PERI_CRG38 is a VPLL2 spread spectrum configuration register. (offset 0x98; total reset 0x00000004; PROVEN: Hi3521A/Hi3520D V300 data sheet (Issue 00B07, 2015-12-10), section 3.2.7, PDF page 544).";
        field {
            name = "reserved";
            desc = "Reserved";
            sw = r; hw = w;
            reset = 0x0;
        } reserved_31_12[31:12];
        field {
            name = "vpll2_ssmod_cfg";
            desc = "ssmod divval[11:8] SSMOD divval control ssmod spread[6:4] SSMOD spread control
- 0: 0
- 1: 0.049%
- 2: 0.098%
- 3: 0.195%
- 4: 0.391%
- 5: 0.781%
- 6: 1.563%
- 7: 3.125% ssmod downspread[3]

SSMOD down spread control
- 0: central spread spectrum
- 1: down spread spectrum ssmod_disable[2]

SSMOD disable control
- 0: enabled
- 1: disabled ssmod_rst_req [1]

SSMOD reset
- 0: deassert reset
- 1: reset ssmod_cken [0]

SSMOD clock gating 0 (default): disabled
- 1: enabled";
            sw = rw; hw = r;
            reset = 0x4;
        } vpll2_ssmod_cfg[11:0];
    } PERI_CRG38 @ 0x98;
    reg {
        name = "PERI_CRG39";
        desc = "PERI_CRG39 is an APLL spread spectrum configuration register. (offset 0x9C; total reset 0x00000004; PROVEN: Hi3521A/Hi3520D V300 data sheet (Issue 00B07, 2015-12-10), section 3.2.7, PDF page 545).";
        field {
            name = "reserved";
            desc = "Reserved";
            sw = r; hw = w;
            reset = 0x0;
        } reserved_31_12[31:12];
        field {
            name = "apll_ssmod_cfg";
            desc = "ssmod divval[11:8] SSMOD divval control ssmod spread[6:4] SSMOD spread control
- 0: 0
- 1: 0.049%
- 2: 0.098%
- 3: 0.195%
- 4: 0.391%
- 5: 0.781%
- 6: 1.563%
- 7: 3.125% ssmod downspread[3]

SSMOD down spread control
- 0: central spread spectrum
- 1: down spread spectrum ssmod_disable[2]

SSMOD disable
- 0: enabled
- 1: disabled ssmod_rst_req [1]

SSMOD reset
- 0: deassert reset
- 1: reset ssmod_cken [0]

SSMOD clock gating 0 (default): disabled
- 1: enabled";
            sw = rw; hw = r;
            reset = 0x4;
        } apll_ssmod_cfg[11:0];
    } PERI_CRG39 @ 0x9C;
    reg {
        name = "PERI_CRG40";
        desc = "PERI_CRG40 is an EPLL spread spectrum configuration register. (offset 0xA0; total reset 0x00000004; PROVEN: Hi3521A/Hi3520D V300 data sheet (Issue 00B07, 2015-12-10), section 3.2.7, PDF page 546).";
        field {
            name = "reserved";
            desc = "Reserved";
            sw = r; hw = w;
            reset = 0x0;
        } reserved_31_12[31:12];
        field {
            name = "epll_ssmod_cfg";
            desc = "ssmod divval[11:8] SSMOD divval control ssmod spread[6:4] SSMOD spread control
- 0: 0
- 1: 0.049%
- 2: 0.098%
- 3: 0.195%
- 4: 0.391%
- 5: 0.781%
- 6: 1.563%
- 7: 3.125% ssmod downspread[3]

SSMOD down spread control
- 0: central spread spectrum
- 1: down spread spectrum ssmod_disable[2]

SSMOD disable
- 0: enabled
- 1: disabled ssmod_rst_req [1]

SSMOD reset
- 0: deassert reset
- 1: reset ssmod_cken [0]

SSMOD clock gating 0 (default): disabled
- 1: enabled";
            sw = rw; hw = r;
            reset = 0x4;
        } epll_ssmod_cfg[11:0];
    } PERI_CRG40 @ 0xA0;
    reg {
        name = "PERI_CRG41";
        desc = "PERI_CRG41 is a DLL0 control and status register. (offset 0xA4; total reset 0x00000010; PROVEN: Hi3521A/Hi3520D V300 data sheet (Issue 00B07, 2015-12-10), section 3.2.7, PDF page 547).";
        field {
            name = "reserved";
            desc = "Reserved";
            sw = r; hw = w;
            reset = 0x0;
        } reserved_31_18[31:18];
        field {
            name = "dll0_dsel";
            desc = "DLL0 DLY_ELEMENT delay step select
- 00: step 0
- 01: step 1
- 10: reserved
- 11: step 3";
            sw = rw; hw = r;
            reset = 0x0;
        } dll0_dsel[17:16];
        field {
            name = "dll0_dllssel";
            desc = "Step select for DLL0 slave delay line, valid when dll_dllmode is high";
            sw = rw; hw = r;
            reset = 0x0;
        } dll0_dllssel[15:8];
        field {
            name = "dll0_dllmode";
            desc = "DLL0 mode select
- 0: normal mode
- 1: The slave line is controlled by dll_dllssel.";
            sw = rw; hw = r;
            reset = 0x0;
        } dll0_dllmode[7:7];
        field {
            name = "dll0_bypass";
            desc = "DLL0 slave line bypass
- 0: normal mode
- 1: The slave line is bypassed.";
            sw = rw; hw = r;
            reset = 0x0;
        } dll0_bypass[6:6];
        field {
            name = "dll0_stop";
            desc = "Master counting clock cycle disable
- 0: The clock detection is enabled.
- 1: The clock detection is disabled.";
            sw = rw; hw = r;
            reset = 0x0;
        } dll0_stop[5:5];
        field {
            name = "dll0_slave_en";
            desc = "DLL0 slave delay line enable
- 0: disabled
- 1: enabled";
            sw = rw; hw = r;
            reset = 0x1;
        } dll0_slave_en[4:4];
        field {
            name = "dll0_tune";
            desc = "DLL0 slave tap calibration
- 0000: no calibration
- 0001: increase delay by one step
- 0010: increase delay by two steps
- 0011: increase delay by three steps …
- 0111: increase delay by seven steps
- 1000: no calibration
- 1001: decrease delay by one step
- 1010: decrease delay by two steps
- 1011: decrease delay by three steps …
- 1111: decrease delay by seven steps";
            sw = rw; hw = r;
            reset = 0x0;
        } dll0_tune[3:0];
    } PERI_CRG41 @ 0xA4;
    reg {
        name = "PERI_CRG42";
        desc = "PERI_CRG42 is a DLL1 control and status register. (offset 0xA8; total reset 0x00000010; PROVEN: Hi3521A/Hi3520D V300 data sheet (Issue 00B07, 2015-12-10), section 3.2.7, PDF page 548).";
        field {
            name = "reserved";
            desc = "Reserved";
            sw = r; hw = w;
            reset = 0x0;
        } reserved_31_18[31:18];
        field {
            name = "dll1_dsel";
            desc = "DLL1 DLY_ELEMENT delay step select
- 00: step 0
- 01: step 1
- 10: reserved
- 11: step 3";
            sw = rw; hw = r;
            reset = 0x0;
        } dll1_dsel[17:16];
        field {
            name = "dll1_dllssel";
            desc = "Step select for DLL1 slave delay line";
            sw = rw; hw = r;
            reset = 0x0;
        } dll1_dllssel[15:8];
        field {
            name = "dll1_dllmode";
            desc = "DLL1 mode select
- 0: normal mode
- 1: The slave line is controlled by dll_dllssel.";
            sw = rw; hw = r;
            reset = 0x0;
        } dll1_dllmode[7:7];
        field {
            name = "dll1_bypass";
            desc = "DLL1 slave line bypass
- 0: normal mode
- 1: The slave line is bypassed.";
            sw = rw; hw = r;
            reset = 0x0;
        } dll1_bypass[6:6];
        field {
            name = "dll1_stop";
            desc = "Master counting clock cycle disable
- 0: The clock detection is enabled.
- 1: The clock detection is disabled.";
            sw = rw; hw = r;
            reset = 0x0;
        } dll1_stop[5:5];
        field {
            name = "dll1_slave_en";
            desc = "DLL1 slave delay line enable
- 0: disabled
- 1: enabled";
            sw = rw; hw = r;
            reset = 0x1;
        } dll1_slave_en[4:4];
        field {
            name = "dll1_tune";
            desc = "DLL1 slave tap calibration
- 0000: no calibration
- 0001: increase delay by one step
- 0010: increase delay by two steps
- 0011: increase delay by three steps …
- 0111: increase delay by seven steps
- 1000: no calibration
- 1001: decrease delay by one step
- 1010: decrease delay by two steps
- 1011: decrease delay by three steps …
- 1111: decrease delay by seven steps";
            sw = rw; hw = r;
            reset = 0x0;
        } dll1_tune[3:0];
    } PERI_CRG42 @ 0xA8;
    reg {
        name = "PERI_CRG43";
        desc = "PERI_CRG43 is a DLL2 control and status register. (offset 0xAC; total reset 0x00000010; PROVEN: Hi3521A/Hi3520D V300 data sheet (Issue 00B07, 2015-12-10), section 3.2.7, PDF page 549).";
        field {
            name = "reserved";
            desc = "Reserved";
            sw = r; hw = w;
            reset = 0x0;
        } reserved_31_18[31:18];
        field {
            name = "dll2_dsel";
            desc = "DLL2 DLY_ELEMENT delay step select
- 00: step 0
- 01: step 1
- 10: reserved
- 11: step 3";
            sw = rw; hw = r;
            reset = 0x0;
        } dll2_dsel[17:16];
        field {
            name = "dll2_dllssel";
            desc = "Step select for DLL2 slave delay line, valid when dll_dllmode is high";
            sw = rw; hw = r;
            reset = 0x0;
        } dll2_dllssel[15:8];
        field {
            name = "dll2_dllmode";
            desc = "DLL2 mode select
- 0: normal mode
- 1: The slave line is controlled by dll_dllssel.";
            sw = rw; hw = r;
            reset = 0x0;
        } dll2_dllmode[7:7];
        field {
            name = "dll2_bypass";
            desc = "DLL2 slave line bypass
- 0: normal mode
- 1: The slave line is bypassed.";
            sw = rw; hw = r;
            reset = 0x0;
        } dll2_bypass[6:6];
        field {
            name = "dll2_stop";
            desc = "Master counting clock cycle disable
- 0: The clock detection is enabled.
- 1: The clock detection is disabled.";
            sw = rw; hw = r;
            reset = 0x0;
        } dll2_stop[5:5];
        field {
            name = "dll2_slave_en";
            desc = "DLL2 slave delay line enable
- 0: disabled
- 1: enabled";
            sw = rw; hw = r;
            reset = 0x1;
        } dll2_slave_en[4:4];
        field {
            name = "dll2_tune";
            desc = "DLL2 slave tap calibration
- 0000: no calibration
- 0001: increase delay by one step
- 0010: increase delay by two steps
- 0011: increase delay by three steps …
- 0111: increase delay by seven steps
- 1000: no calibration
- 1001: decrease delay by one step
- 1010: decrease delay by two steps
- 1011: decrease delay by three steps …
- 1111: decrease delay by seven steps";
            sw = rw; hw = r;
            reset = 0x0;
        } dll2_tune[3:0];
    } PERI_CRG43 @ 0xAC;
    reg {
        name = "PERI_CRG44";
        desc = "PERI_CRG44 is a DLL3 control and status register. (offset 0xB0; total reset 0x00000010; PROVEN: Hi3521A/Hi3520D V300 data sheet (Issue 00B07, 2015-12-10), section 3.2.7, PDF page 551).";
        field {
            name = "reserved";
            desc = "Reserved";
            sw = r; hw = w;
            reset = 0x0;
        } reserved_31_18[31:18];
        field {
            name = "dll3_dsel";
            desc = "DLL3 DLY_ELEMENT delay step select
- 00: step 0
- 01: step 1
- 10: reserved
- 11: step 3";
            sw = rw; hw = r;
            reset = 0x0;
        } dll3_dsel[17:16];
        field {
            name = "dll3_dllssel";
            desc = "Step select for DLL3 slave delay line, valid when dll_dllmode is high";
            sw = rw; hw = r;
            reset = 0x0;
        } dll3_dllssel[15:8];
        field {
            name = "dll3_dllmode";
            desc = "DLL3 mode select
- 0: normal mode
- 1: The slave line is controlled by dll_dllssel.";
            sw = rw; hw = r;
            reset = 0x0;
        } dll3_dllmode[7:7];
        field {
            name = "dll3_bypass";
            desc = "DLL3 slave line bypass
- 0: normal mode
- 1: The slave line is bypassed.";
            sw = rw; hw = r;
            reset = 0x0;
        } dll3_bypass[6:6];
        field {
            name = "dll3_stop";
            desc = "Master counting clock cycle disable
- 0: The clock detection is enabled.
- 1: The clock detection is disabled.";
            sw = rw; hw = r;
            reset = 0x0;
        } dll3_stop[5:5];
        field {
            name = "dll3_slave_en";
            desc = "DLL3 slave delay line enable
- 0: disabled
- 1: enabled";
            sw = rw; hw = r;
            reset = 0x1;
        } dll3_slave_en[4:4];
        field {
            name = "dll3_tune";
            desc = "DLL3 slave tap calibration
- 0000: no calibration
- 0001: increase delay by one step
- 0010: increase delay by two steps
- 0011: increase delay by three steps …
- 0111: increase delay by seven steps
- 1000: no calibration
- 1001: decrease delay by one step
- 1010: decrease delay by two steps
- 1011: decrease delay by three steps …
- 1111: decrease delay by seven steps";
            sw = rw; hw = r;
            reset = 0x0;
        } dll3_tune[3:0];
    } PERI_CRG44 @ 0xB0;
    reg {
        name = "PERI_CRG45";
        desc = "PERI_CRG45 is an ADC REF0/REF1 clock configuration register. (offset 0xB4; total reset 0x00000030; PROVEN: Hi3521A/Hi3520D V300 data sheet (Issue 00B07, 2015-12-10), section 3.2.7, PDF page 552).";
        field {
            name = "reserved";
            desc = "Reserved";
            sw = r; hw = w;
            reset = 0x0;
        } reserved_31_6[31:6];
        field {
            name = "adc_ref1_cken";
            desc = "ADC1 REF clock gating
- 0: The clock is disabled.
- 1: The clock is enabled.";
            sw = rw; hw = r;
            reset = 0x1;
        } adc_ref1_cken[5:5];
        field {
            name = "adc_ref0_cken";
            desc = "ADC0 REF clock gating
- 0: The clock is disabled.
- 1: The clock is enabled.";
            sw = rw; hw = r;
            reset = 0x1;
        } adc_ref0_cken[4:4];
        field {
            name = "adc_ref1_cksel";
            desc = "ADC1 REF clock select
- 00: 24 MHz clock
- 01: 27 MHz clock
- 10: 54 MHz clock
- 11: reserved";
            sw = rw; hw = r;
            reset = 0x0;
        } adc_ref1_cksel[3:2];
        field {
            name = "adc_ref0_cksel";
            desc = "ADC0 REF clock select
- 00: 24 MHz clock
- 01: 27 MHz clock
- 10: 54 MHz clock
- 11: reserved";
            sw = rw; hw = r;
            reset = 0x0;
        } adc_ref0_cksel[1:0];
    } PERI_CRG45 @ 0xB4;
    reg {
        name = "PERI_CRG46";
        desc = "PERI_CRG46 is a DPLL spread spectrum configuration register. (offset 0xB8; total reset 0x00000004; PROVEN: Hi3521A/Hi3520D V300 data sheet (Issue 00B07, 2015-12-10), section 3.2.7, PDF page 553).";
        field {
            name = "reserved";
            desc = "Reserved";
            sw = r; hw = w;
            reset = 0x0;
        } reserved_31_12[31:12];
        field {
            name = "dpll_ssmod_cfg";
            desc = "ssmod divval[11:8] SSMOD divval control ssmod spread[6:4] SSMOD spread control
- 0: 0
- 1: 0.049%
- 2: 0.098%
- 3: 0.195%
- 4: 0.391%
- 5: 0.781%
- 6: 1.563%
- 7: 3.125% ssmod downspread[3]

SSMOD down spread control
- 0: central spread spectrum
- 1: down spread spectrum ssmod_disable[2]

SSMOD disable
- 0: enabled
- 1: disabled ssmod_rst_req [1]

SSMOD reset
- 0: deassert reset
- 1: reset ssmod_cken [0]

SSMOD clock gating 0 (default): disabled
- 1: enabled";
            sw = rw; hw = r;
            reset = 0x4;
        } dpll_ssmod_cfg[11:0];
    } PERI_CRG46 @ 0xB8;
};
`endif
