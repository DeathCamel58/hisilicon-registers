`ifndef HI3520DV300_DMAC_RDL
`define HI3520DV300_DMAC_RDL
regfile eHI3520DV300_DMAC {
    name = "DMAC";
    desc = "DMAC of the Hi3521A/Hi3520D V300 at base 0x1006_0000. 19 registers extracted programmatically from the Hi3521A/Hi3520D V300 data sheet (Issue 00B07, 2015-12-10) (Table 3-14 Summary of the DMAC registers (base address: 0x1006_0000)): register headings, offsets, total reset values, field bit ranges, access types, names, reset values and descriptions, with PDF page numbers in each register description. Field names, bit ranges, access types and offsets are exact; the free-text descriptions are taken from the cell text of the field table and were checked by sampling only. Hardware not verified.";
    reg {
        name = "DMAC_INT_STAT";
        desc = "DMAC_INT_STAT is an interrupt status register. (offset 0x0; total reset 0x00000000; PROVEN: Hi3521A/Hi3520D V300 data sheet (Issue 00B07, 2015-12-10), section 3.6.6, PDF page 602).";
        field {
            name = "reserved";
            desc = "Reserved";
            sw = r; hw = w;
            reset = 0x0;
        } reserved_31_4[31:4];
        field {
            name = "ch3_int_stat";
            desc = "Masked interrupt status of channel 3
- 0: No interrupt is generated.
- 1: A transfer error interrupt or transfer terminal interrupt is generated.";
            sw = r; hw = w;
            reset = 0x0;
        } ch3_int_stat[3:3];
        field {
            name = "ch2_int_stat";
            desc = "Masked interrupt status of channel 2
- 0: No interrupt is generated.
- 1: A transfer error interrupt or transfer terminal interrupt is generated.";
            sw = r; hw = w;
            reset = 0x0;
        } ch2_int_stat[2:2];
        field {
            name = "ch1_int_stat";
            desc = "Masked interrupt status of channel 1
- 0: No interrupt is generated.
- 1: A transfer error interrupt or transfer terminal interrupt is generated.";
            sw = r; hw = w;
            reset = 0x0;
        } ch1_int_stat[1:1];
        field {
            name = "ch0_int_stat";
            desc = "Masked interrupt status of channel 0
- 0: No interrupt is generated.
- 1: A transfer error interrupt or transfer terminal interrupt is generated.";
            sw = r; hw = w;
            reset = 0x0;
        } ch0_int_stat[0:0];
    } DMAC_INT_STAT @ 0x0;
    reg {
        name = "DMAC_INT_TC_STAT";
        desc = "DMAC_INT_TC_STAT is a DMAC transfer terminal interrupt status register. (offset 0x4; total reset 0x00000000; PROVEN: Hi3521A/Hi3520D V300 data sheet (Issue 00B07, 2015-12-10), section 3.6.6, PDF page 603).";
        field {
            name = "reserved";
            desc = "Reserved";
            sw = r; hw = w;
            reset = 0x0;
        } reserved_31_4[31:4];
        field {
            name = "ch3_int_tc_stat";
            desc = "Status of the masked transfer terminal interrupt of channel 3
- 0: No interrupt is generated.
- 1: An interrupt is generated.";
            sw = r; hw = w;
            reset = 0x0;
        } ch3_int_tc_stat[3:3];
        field {
            name = "ch2_int_tc_stat";
            desc = "Status of the masked transfer terminal interrupt of channel 2
- 0: No interrupt is generated.
- 1: An interrupt is generated.";
            sw = r; hw = w;
            reset = 0x0;
        } ch2_int_tc_stat[2:2];
        field {
            name = "ch1_int_tc_stat";
            desc = "Status of the masked transfer terminal interrupt of channel 1
- 0: No interrupt is generated.
- 1: An interrupt is generated.";
            sw = r; hw = w;
            reset = 0x0;
        } ch1_int_tc_stat[1:1];
        field {
            name = "ch0_int_tc_stat";
            desc = "Status of the masked transfer terminal interrupt of channel 0
- 0: No interrupt is generated.
- 1: An interrupt is generated.";
            sw = r; hw = w;
            reset = 0x0;
        } ch0_int_tc_stat[0:0];
    } DMAC_INT_TC_STAT @ 0x4;
    reg {
        name = "DMAC_INT_TC_CLR";
        desc = "DMAC_INT_TC_CLR is a DMAC transfer terminal interrupt clear register. (offset 0x8; total reset 0x00000000; PROVEN: Hi3521A/Hi3520D V300 data sheet (Issue 00B07, 2015-12-10), section 3.6.6, PDF page 604).";
        field {
            name = "reserved";
            desc = "Reserved";
            sw = r; hw = w;
            reset = 0x0;
        } reserved_31_4[31:4];
        field {
            name = "ch3_int_tc_clr";
            desc = "Transfer terminal interrupt clear for channel 3
- 0: not cleared
- 1: cleared";
            sw = w; hw = r;
            reset = 0x0;
        } ch3_int_tc_clr[3:3];
        field {
            name = "ch2_int_tc_clr";
            desc = "Transfer terminal interrupt clear for channel 2
- 0: not cleared
- 1: cleared";
            sw = w; hw = r;
            reset = 0x0;
        } ch2_int_tc_clr[2:2];
        field {
            name = "ch1_int_tc_clr";
            desc = "Transfer terminal interrupt clear for channel 1
- 0: not cleared
- 1: cleared";
            sw = w; hw = r;
            reset = 0x0;
        } ch1_int_tc_clr[1:1];
        field {
            name = "ch0_int_tc_clr";
            desc = "Transfer terminal interrupt clear for channel 0
- 0: not cleared
- 1: cleared";
            sw = w; hw = r;
            reset = 0x0;
        } ch0_int_tc_clr[0:0];
    } DMAC_INT_TC_CLR @ 0x8;
    reg {
        name = "DMAC_INT_ERR_STAT";
        desc = "DMAC_INT_ERR_STAT is a DMAC error interrupt status register. (offset 0xC; total reset 0x00000000; PROVEN: Hi3521A/Hi3520D V300 data sheet (Issue 00B07, 2015-12-10), section 3.6.6, PDF page 605).";
        field {
            name = "reserved";
            desc = "Reserved";
            sw = r; hw = w;
            reset = 0x0;
        } reserved_31_4[31:4];
        field {
            name = "ch3_int_err_stat";
            desc = "Status of the masked error interrupt of channel 3
- 0: No interrupt is generated.
- 1: An interrupt is generated.";
            sw = r; hw = w;
            reset = 0x0;
        } ch3_int_err_stat[3:3];
        field {
            name = "ch2_int_err_stat";
            desc = "Status of the masked error interrupt of channel 2
- 0: No interrupt is generated.
- 1: An interrupt is generated.";
            sw = r; hw = w;
            reset = 0x0;
        } ch2_int_err_stat[2:2];
        field {
            name = "ch1_int_err_stat";
            desc = "Status of the masked error interrupt of channel 1
- 0: No interrupt is generated.
- 1: An interrupt is generated.";
            sw = r; hw = w;
            reset = 0x0;
        } ch1_int_err_stat[1:1];
        field {
            name = "ch0_int_err_stat";
            desc = "Status of the masked error interrupt of channel 0
- 0: No interrupt is generated.
- 1: An interrupt is generated.";
            sw = r; hw = w;
            reset = 0x0;
        } ch0_int_err_stat[0:0];
    } DMAC_INT_ERR_STAT @ 0xC;
    reg {
        name = "DMAC_INT_ERR_CLR";
        desc = "DMAC_INT_ERR_CLR is a DMAC transfer error interrupt clear register. (offset 0x10; total reset 0x00000000; PROVEN: Hi3521A/Hi3520D V300 data sheet (Issue 00B07, 2015-12-10), section 3.6.6, PDF page 606).";
        field {
            name = "reserved";
            desc = "Reserved";
            sw = r; hw = w;
            reset = 0x0;
        } reserved_31_4[31:4];
        field {
            name = "ch3_int_err_clr";
            desc = "Error interrupt clear for channel 3
- 0: not cleared
- 1: cleared";
            sw = w; hw = r;
            reset = 0x0;
        } ch3_int_err_clr[3:3];
        field {
            name = "ch2_int_err_clr";
            desc = "Error interrupt clear for channel 2
- 0: not cleared
- 1: cleared";
            sw = w; hw = r;
            reset = 0x0;
        } ch2_int_err_clr[2:2];
        field {
            name = "ch1_int_err_clr";
            desc = "Error interrupt clear for channel 1
- 0: not cleared
- 1: cleared";
            sw = w; hw = r;
            reset = 0x0;
        } ch1_int_err_clr[1:1];
        field {
            name = "ch0_int_err_clr";
            desc = "Error interrupt clear for channel 0
- 0: not cleared
- 1: cleared";
            sw = w; hw = r;
            reset = 0x0;
        } ch0_int_err_clr[0:0];
    } DMAC_INT_ERR_CLR @ 0x10;
    reg {
        name = "DMAC_RAW_INT_TC_STAT";
        desc = "DMAC_RAW_INT_TC_STAT is a DMAC raw transfer terminal interrupt status register. (offset 0x14; total reset 0x00000000; PROVEN: Hi3521A/Hi3520D V300 data sheet (Issue 00B07, 2015-12-10), section 3.6.6, PDF page 607).";
        field {
            name = "reserved";
            desc = "Reserved";
            sw = r; hw = w;
            reset = 0x0;
        } reserved_31_4[31:4];
        field {
            name = "ch3_raw_int_tc";
            desc = "Status of the raw transfer terminal interrupt of channel 3
- 0: No interrupt is generated.
- 1: An interrupt is generated.";
            sw = r; hw = w;
            reset = 0x0;
        } ch3_raw_int_tc[3:3];
        field {
            name = "ch2_raw_int_tc";
            desc = "Status of the raw transfer terminal interrupt of channel 2
- 0: No interrupt is generated.
- 1: An interrupt is generated.";
            sw = r; hw = w;
            reset = 0x0;
        } ch2_raw_int_tc[2:2];
        field {
            name = "ch1_raw_int_tc";
            desc = "Status of the raw transfer terminal interrupt of channel 1
- 0: No interrupt is generated.
- 1: An interrupt is generated.";
            sw = r; hw = w;
            reset = 0x0;
        } ch1_raw_int_tc[1:1];
        field {
            name = "ch0_raw_int_tc";
            desc = "Status of the raw transfer terminal interrupt of channel 0
- 0: No interrupt is generated.
- 1: An interrupt is generated.";
            sw = r; hw = w;
            reset = 0x0;
        } ch0_raw_int_tc[0:0];
    } DMAC_RAW_INT_TC_STAT @ 0x14;
    reg {
        name = "DMAC_RAW_INT_ERR_STAT";
        desc = "DMAC_RAW_INT_ERR_STAT is a DMAC raw error interrupt status register. (offset 0x18; total reset 0x00000000; PROVEN: Hi3521A/Hi3520D V300 data sheet (Issue 00B07, 2015-12-10), section 3.6.6, PDF page 608).";
        field {
            name = "reserved";
            desc = "Reserved";
            sw = r; hw = w;
            reset = 0x0;
        } reserved_31_4[31:4];
        field {
            name = "ch3_raw_int_err";
            desc = "Status of the raw error interrupt of channel 3
- 0: No interrupt is generated.
- 1: An interrupt is generated.";
            sw = r; hw = w;
            reset = 0x0;
        } ch3_raw_int_err[3:3];
        field {
            name = "ch2_raw_int_err";
            desc = "Status of the raw error interrupt of channel 2
- 0: No interrupt is generated.
- 1: An interrupt is generated.";
            sw = r; hw = w;
            reset = 0x0;
        } ch2_raw_int_err[2:2];
        field {
            name = "ch1_raw_int_err";
            desc = "Status of the raw error interrupt of channel 1
- 0: No interrupt is generated.
- 1: An interrupt is generated.";
            sw = r; hw = w;
            reset = 0x0;
        } ch1_raw_int_err[1:1];
        field {
            name = "ch0_raw_int_err";
            desc = "Status of the raw error interrupt of channel 0
- 0: No interrupt is generated.
- 1: An interrupt is generated.";
            sw = r; hw = w;
            reset = 0x0;
        } ch0_raw_int_err[0:0];
    } DMAC_RAW_INT_ERR_STAT @ 0x18;
    reg {
        name = "DMAC_ENABLED_CHNS";
        desc = "DMAC_ENABLED_CHNS is a DMAC channel enable status register. (offset 0x1C; total reset 0x00000000; PROVEN: Hi3521A/Hi3520D V300 data sheet (Issue 00B07, 2015-12-10), section 3.6.6, PDF page 609).";
        field {
            name = "reserved";
            desc = "Reserved";
            sw = r; hw = w;
            reset = 0x0;
        } reserved_31_4[31:4];
        field {
            name = "ch3_enabled";
            desc = "Channel 3 enable
- 0: disabled
- 1: enabled";
            sw = r; hw = w;
            reset = 0x0;
        } ch3_enabled[3:3];
        field {
            name = "ch2_enabled";
            desc = "Channel 2 enable
- 0: disabled
- 1: enabled";
            sw = r; hw = w;
            reset = 0x0;
        } ch2_enabled[2:2];
        field {
            name = "ch1_enabled";
            desc = "Channel 1 enable
- 0: disabled
- 1: enabled";
            sw = r; hw = w;
            reset = 0x0;
        } ch1_enabled[1:1];
        field {
            name = "ch0_enabled";
            desc = "Channel 0 enable
- 0: disabled
- 1: enabled";
            sw = r; hw = w;
            reset = 0x0;
        } ch0_enabled[0:0];
    } DMAC_ENABLED_CHNS @ 0x1C;
    reg {
        name = "DMAC_SOFT_BREQ";
        desc = "DMAC_SOFT_BREQ is a DMAC software burst transfer request register. Software controls the generation of a DMA burst transfer request by using this register. When this register is read, the device that is requesting the DMA burst transfer can be queried. This register and any peripheral can generate a DMA request each. (offset 0x20; total reset 0x00000000; PROVEN: Hi3521A/Hi3520D V300 data sheet (Issue 00B07, 2015-12-10), section 3.6.6, PDF page 610).";
        field {
            name = "reserved";
            desc = "Reserved";
            sw = r; hw = w;
            reset = 0x0;
        } reserved_31_16[31:16];
        field {
            name = "soft_breq";
            desc = "Whether to generate a DMA burst transfer request When this register is written:
- 0: No effect.
- 1: A DMA burst transfer request is generated. When the transfer is complete, the corresponding bit is cleared.

When this register is read:
- 0: The peripheral corresponding to the request signal

DMACBREQ[15:0] does not send any DMA burst request.
- 1: The peripheral corresponding to the request signal

DMACBREQ[15:0] is requesting the DMA burst transfer.";
            sw = rw; hw = r;
            reset = 0x0;
        } soft_breq[15:0];
    } DMAC_SOFT_BREQ @ 0x20;
    reg {
        name = "DMAC_SOFT_SREQ";
        desc = "DMAC_SOFT_SREQ is a DMAC software single transfer request register. Software controls the generation of DMA single transfer requests by using this register. When this register is read, the device that is requesting the DMA single transfer can be queried. This register and any of the 16 DMA request input signals of the DMAC can generate a DMA request each. (offset 0x24; total reset 0x00000000; PROVEN: Hi3521A/Hi3520D V300 data sheet (Issue 00B07, 2015-12-10), section 3.6.6, PDF page 610).";
        field {
            name = "reserved";
            desc = "Reserved";
            sw = r; hw = w;
            reset = 0x0;
        } reserved_31_16[31:16];
        field {
            name = "soft_sreq";
            desc = "Whether to generate a DMA single transfer request When this register is written:
- 0: no effect
- 1: A DMA single transfer request is generated. When the transfer is complete, the corresponding bit is cleared.

When this register is read:
- 0: The peripheral corresponding to the request signal

DMACSREQ[15:0] does not send a DMA single request.
- 1: The peripheral corresponding to the request signal

DMACSREQ[15:0] is requesting the DMA single transfer.";
            sw = rw; hw = r;
            reset = 0x0;
        } soft_sreq[15:0];
    } DMAC_SOFT_SREQ @ 0x24;
    reg {
        name = "DMAC_SOFT_LBREQ";
        desc = "DMAC_SOFT_LBREQ is a DMAC software last burst request register. Software controls the generation of the DMA last burst transfer requests by using this register. (offset 0x28; total reset 0x00000000; PROVEN: Hi3521A/Hi3520D V300 data sheet (Issue 00B07, 2015-12-10), section 3.6.6, PDF page 611).";
        field {
            name = "reserved";
            desc = "Reserved";
            sw = r; hw = w;
            reset = 0x0;
        } reserved_31_16[31:16];
        field {
            name = "soft_lbreq";
            desc = "Last burst request issued by the software
- 0: no effect
- 1: A DMA last burst transfer request is generated. When the transfer is complete, the corresponding bit is cleared.";
            sw = rw; hw = r;
            reset = 0x0;
        } soft_lbreq[15:0];
    } DMAC_SOFT_LBREQ @ 0x28;
    reg {
        name = "DMAC_SOFT_LSREQ";
        desc = "DMAC_SOFT_LSREQ is a DMAC software last single transfer request register. Software controls the generation of the DMA last single transfer requests by using this register. (offset 0x2C; total reset 0x00000000; PROVEN: Hi3521A/Hi3520D V300 data sheet (Issue 00B07, 2015-12-10), section 3.6.6, PDF page 612).";
        field {
            name = "reserved";
            desc = "Reserved";
            sw = r; hw = w;
            reset = 0x0;
        } reserved_31_16[31:16];
        field {
            name = "soft_lsreq";
            desc = "Last single transfer request issued by the software
- 0: no effect
- 1: A DMA last single transfer request is generated. When the transfer is complete, the corresponding bit is cleared.";
            sw = rw; hw = r;
            reset = 0x0;
        } soft_lsreq[15:0];
    } DMAC_SOFT_LSREQ @ 0x2C;
    reg {
        name = "DMAC_CONFIG";
        desc = "DMAC_CONFIG is a DMAC configuration register. (offset 0x30; total reset 0x00000000; PROVEN: Hi3521A/Hi3520D V300 data sheet (Issue 00B07, 2015-12-10), section 3.6.6, PDF page 612).";
        field {
            name = "reserved";
            desc = "Reserved";
            sw = r; hw = w;
            reset = 0x0;
        } reserved_31_3[31:3];
        field {
            name = "m2_endianness";
            desc = "Byte endianness of master 2
- 0: little endian
- 1: big endian";
            sw = rw; hw = r;
            reset = 0x0;
        } m2_endianness[2:2];
        field {
            name = "m1_endianness";
            desc = "Byte endianness of master 1
- 0: little endian
- 1: big endian";
            sw = rw; hw = r;
            reset = 0x0;
        } m1_endianness[1:1];
        field {
            name = "dmac_enable";
            desc = "DMAC enable
- 0: disabled
- 1: enabled";
            sw = rw; hw = r;
            reset = 0x0;
        } dmac_enable[0:0];
    } DMAC_CONFIG @ 0x30;
    reg {
        name = "DMAC_SYNC";
        desc = "DMAC_SYNC is a DMAC request line sync enable register. (offset 0x34; total reset 0x00000000; PROVEN: Hi3521A/Hi3520D V300 data sheet (Issue 00B07, 2015-12-10), section 3.6.6, PDF page 613).";
        field {
            name = "reserved";
            desc = "Reserved";
            sw = r; hw = w;
            reset = 0x0;
        } reserved_31_16[31:16];
        field {
            name = "dmac_sync";
            desc = "Whether to synchronize the request signals
- 0: The sync logic provided for the DMA request signals of the corresponding peripheral is enabled.
- 1: The sync logic provided for the DMA request signals of the corresponding peripheral is disabled.";
            sw = rw; hw = r;
            reset = 0x0;
        } dmac_sync[15:0];
    } DMAC_SYNC @ 0x34;
    reg DMAC_Cn_SRC_ADDR_t {
        name = "DMAC_Cn_SRC_ADDR";
        desc = "DMAC_Cn_SRC_ADDR is a source address register of DMA channel n (n = 0-3). Its offset address is 0x100 + n x 0x20. The value of n ranges from 0 to 3. The values 0-3 correspond to DMA channels 0-3. Before a channel is enabled, its corresponding register must be programmed by using software. After the channel is enabled, the register is updated in any of the following cases: The source address is incremented. A complete data block is transferred and then loaded from LLI nodes. If a channel is active, no valid information is obtained when this register is read. This is because that after software obtains the register value, the value changes during data transfer. Therefore, the register is read after the channel stops data transfer. At this time, the read value is the last source address read by the DMAC. (offset 0x100, 4 instances at stride 0x20; total reset 0x00000000; PROVEN: Hi3521A/Hi3520D V300 data sheet (Issue 00B07, 2015-12-10), section 3.6.6, PDF page 614).";
        field {
            name = "src_addr";
            desc = "DMA source address";
            sw = rw; hw = r;
            reset = 0x0;
        } src_addr[31:0];
    };
    DMAC_Cn_SRC_ADDR_t DMAC_C0_SRC_ADDR @ 0x100;
    DMAC_Cn_SRC_ADDR_t DMAC_C1_SRC_ADDR @ 0x120;
    DMAC_Cn_SRC_ADDR_t DMAC_C2_SRC_ADDR @ 0x140;
    DMAC_Cn_SRC_ADDR_t DMAC_C3_SRC_ADDR @ 0x160;
    reg DMAC_Cn_DEST_ADDR_t {
        name = "DMAC_Cn_DEST_ADDR";
        desc = "DMAC_Cn_DEST_ADDR is a destination address register of DMA channel n (n = 0-3). Its offset address is 0x104 + n x 0x20. The value of n ranges from 0 to 3. The values 0-3 correspond to DMA channels 0-3. This register contains the destination address for the data to be transferred. Before a channel is enabled, its corresponding register must be programmed by using software. After the channel is enabled, the register is updated in any of the following cases: Destination address increment. A complete data block is transferred and then loaded from LLI nodes. If a channel is active, no valid information is obtained when this register is read. This is because that after software obtains the register value, the value changes during data transfer. Therefore, the register is read after the channel stops data transfer. At this time, the read value is the last destination address written by the DMAC. (offset 0x104, 4 instances at stride 0x20; total reset 0x00000000; PROVEN: Hi3521A/Hi3520D V300 data sheet (Issue 00B07, 2015-12-10), section 3.6.6, PDF page 614).";
        field {
            name = "dest_addr";
            desc = "DMA destination address";
            sw = rw; hw = r;
            reset = 0x0;
        } dest_addr[31:0];
    };
    DMAC_Cn_DEST_ADDR_t DMAC_C0_DEST_ADDR @ 0x104;
    DMAC_Cn_DEST_ADDR_t DMAC_C1_DEST_ADDR @ 0x124;
    DMAC_Cn_DEST_ADDR_t DMAC_C2_DEST_ADDR @ 0x144;
    DMAC_Cn_DEST_ADDR_t DMAC_C3_DEST_ADDR @ 0x164;
    reg DMAC_Cn_LLI_t {
        name = "DMAC_Cn_LLI";
        desc = "DMAC_Cn_LLI is an LLI information register of DMA channel n (n = 0-3). Its offset address is 0x108 + n x 0x20. The value of n ranges from 0 to 3. The values 0-3 correspond to DMA channels 0-3. For details, see section \"DMA Linked List.\" (offset 0x108, 4 instances at stride 0x20; total reset 0x00000000; PROVEN: Hi3521A/Hi3520D V300 data sheet (Issue 00B07, 2015-12-10), section 3.6.6, PDF page 615).";
        field {
            name = "ll_item";
            desc = "The bit[31:2] in the next LLI node address and the address bit[1:0] are set to 0. A linked list address must be 4-byte aligned.";
            sw = rw; hw = r;
            reset = 0x0;
        } ll_item[31:2];
        field {
            name = "reserved";
            desc = "Reserved. This bit value must be 0 during write operations, and this bit must be masked during read operations.";
            sw = rw; hw = r;
            reset = 0x0;
        } reserved_1_1[1:1];
        field {
            name = "ll_master";
            desc = "Master for loading the next LLI node
- 0: master 1
- 1: master 2";
            sw = rw; hw = r;
            reset = 0x0;
        } ll_master[0:0];
    };
    DMAC_Cn_LLI_t DMAC_C0_LLI @ 0x108;
    DMAC_Cn_LLI_t DMAC_C1_LLI @ 0x128;
    DMAC_Cn_LLI_t DMAC_C2_LLI @ 0x148;
    DMAC_Cn_LLI_t DMAC_C3_LLI @ 0x168;
    reg DMAC_Cn_CONTROL_t {
        name = "DMAC_Cn_CONTROL";
        desc = "DMAC_Cn_CONTROL is a control register of DMA channel n (n = 0-3). Its offset address is 0x10C + n x 0x20. The value of n ranges from 0 to 3. The values 0-3 correspond to DMA channels 0-3. (offset 0x10C, 4 instances at stride 0x20; total reset 0x00000000; PROVEN: Hi3521A/Hi3520D V300 data sheet (Issue 00B07, 2015-12-10), section 3.6.6, PDF page 616).";
        field {
            name = "int_tc_enable";
            desc = "Transfer terminal interrupt enable. This bit determines whether the current LLI node triggers a transfer terminal interrupt.
- 0: do not trigger
- 1: trigger";
            sw = rw; hw = r;
            reset = 0x0;
        } int_tc_enable[31:31];
        field {
            name = "prot_stat";
            desc = "HPROT[2:0] access protection signal transmitted by the master.";
            sw = rw; hw = r;
            reset = 0x0;
        } prot_stat[30:28];
        field {
            name = "dest_incr";
            desc = "Destination address increment
- 0: The destination address is not incremented
- 1: The destination address is incremented once after a data segment is transferred

If the destination device is a peripheral, the destination address is not incremented. If the destination device is a memory, the destination address is incremented.";
            sw = rw; hw = r;
            reset = 0x0;
        } dest_incr[27:27];
        field {
            name = "src_incr";
            desc = "Source address increment
- 0: The source address is not incremented
- 1: The source address is incremented once after a data segment is transferred

If the source device is a peripheral, the source address is not incremented. If the source device is a memory, the source address is incremented.";
            sw = rw; hw = r;
            reset = 0x0;
        } src_incr[26:26];
        field {
            name = "dest_select";
            desc = "Master for accessing the destination device
- 0: master 1
- 1: master 2";
            sw = rw; hw = r;
            reset = 0x0;
        } dest_select[25:25];
        field {
            name = "src_select";
            desc = "Master for accessing the source device
- 0: master 1
- 1: master 2";
            sw = rw; hw = r;
            reset = 0x0;
        } src_select[24:24];
        field {
            name = "dwidth";
            desc = "Transfer bit width of the destination device The transfer bit width is invalid if it is greater than the bit width of the master. The data widths of the destination and source devices can be different. The hardware automatically packs and unpacks the data. For the mapping between the value of dwidth and the bit width, see Table 3-12.";
            sw = rw; hw = r;
            reset = 0x0;
        } dwidth[23:21];
        field {
            name = "swidth";
            desc = "Transfer bit width of the source device The transfer bit width is invalid if it is greater than the bit width of the master. The data widths of the destination and source devices can be different. The hardware automatically packs and unpacks the data. For the mapping between the value of swidth and the bit width, see Table 3-12.";
            sw = rw; hw = r;
            reset = 0x0;
        } swidth[20:18];
        field {
            name = "dbsize";
            desc = "Burst size of the destination device It indicates the number of data segments to be transferred by the destination device in a burst transfer, that is, the number of transferred data segments when DMACCxBREQ is valid. This value must be set to a burst size supported by the destination device. If the destination device is a memory, the value is set to the storage area size beyond the storage address boundary. For the mapping between the value of dbsize and the transfer length, see Table 3-11.";
            sw = rw; hw = r;
            reset = 0x0;
        } dbsize[17:15];
        field {
            name = "sbsize";
            desc = "Burst size of the source device It indicates the amount of data to be transferred by the source device in a burst transfer, that is, the amount of transferred data when DMACCxBREQ is valid. The value must be set to a burst size supported by the source device. If the source device is a memory, the value is set to the storage area size beyond the storage address boundary. For the mapping between the value of sbsize and the transfer length, see Table 3-11.";
            sw = rw; hw = r;
            reset = 0x0;
        } sbsize[14:12];
        field {
            name = "trans_size";
            desc = "The DMA transfer size can be configured by writing to this register only when the DMAC is a flow controller. The field indicates the amount of data to be transferred by the source device. When this register is read, the amount of data transferred through the bus connected to the destination device is obtained. If a channel is active, no valid information is obtained when this register is read. This is because that after software obtains the register value, the value changes during data transfer. Therefore, the register is read after the channel is enabled and data transfer stops.";
            sw = rw; hw = r;
            reset = 0x0;
        } trans_size[11:0];
    };
    DMAC_Cn_CONTROL_t DMAC_C0_CONTROL @ 0x10C;
    DMAC_Cn_CONTROL_t DMAC_C1_CONTROL @ 0x12C;
    DMAC_Cn_CONTROL_t DMAC_C2_CONTROL @ 0x14C;
    DMAC_Cn_CONTROL_t DMAC_C3_CONTROL @ 0x16C;
    reg DMAC_Cn_CONFIG_t {
        name = "DMAC_Cn_CONFIG";
        desc = "DMAC_Cn_CONFIG is a configuration register of channel n (n = 0-3). Its offset address is 0x110 + n x 0x20. The value of n ranges from 0 to 3. The values 0-3 correspond to DMA channels 0-3. This register is not updated when a new LLI node is loaded. (offset 0x110, 4 instances at stride 0x20; total reset 0x00000000; PROVEN: Hi3521A/Hi3520D V300 data sheet (Issue 00B07, 2015-12-10), section 3.6.6, PDF page 618).";
        field {
            name = "reserved";
            desc = "Reserved This bit value must be 0 during write operations, and this bit must be masked during read operations.";
            sw = rw; hw = r;
            reset = 0x0;
        } reserved_31_19[31:19];
        field {
            name = "ch_halt";
            desc = "Halt bit
- 0: The DMA request is allowed.
- 1: The subsequent DMA requests are ignored and the contents in the channel FIFO are completely transmitted.

This bit can disable a DMA channel without data loss by working with the Active bit and the Channel Enable bit.";
            sw = rw; hw = r;
            reset = 0x0;
        } ch_halt[18:18];
        field {
            name = "ch_active";
            desc = "Active bit
- 0: There is no data in the channel FIFO.
- 1: There is data in the channel FIFO.

This bit can disable a DMA channel without data loss by working with the Halt bit and Channel Enable bit.";
            sw = rw; hw = r;
            reset = 0x0;
        } ch_active[17:17];
        field {
            name = "ch_lock";
            desc = "Lock bit
- 0: Lock transfer on the bus is disabled.
- 1: Lock transfer on the bus is enabled.";
            sw = rw; hw = r;
            reset = 0x0;
        } ch_lock[16:16];
        field {
            name = "tc_int_msk";
            desc = "Transfer terminal interrupt mask
- 0: The transfer terminal interrupts of the channel are masked.
- 1: The transfer terminal interrupts of the channel are not masked.";
            sw = rw; hw = r;
            reset = 0x0;
        } tc_int_msk[15:15];
        field {
            name = "err_int_msk";
            desc = "Transfer error interrupt mask
- 0: The error interrupts of the channel are masked.
- 1: The error interrupts of the channel are not masked.";
            sw = rw; hw = r;
            reset = 0x0;
        } err_int_msk[14:14];
        field {
            name = "flow_ctrl";
            desc = "Flow control and transfer type This field specifies the flow controller and transfer type. The flow controller can be the DMAC, source device, or destination device. The transfer type can be memory to peripheral, peripheral to memory, peripheral to peripheral, or memory to memory. For details, see Table 3-13.";
            sw = rw; hw = r;
            reset = 0x0;
        } flow_ctrl[13:11];
        field {
            name = "reserved";
            desc = "Reserved This bit value must be 0 during write operations, and this bit must be masked during read operations.";
            sw = rw; hw = r;
            reset = 0x0;
        } reserved_10_10[10:10];
        field {
            name = "dest_periph";
            desc = "Destination device. The field is used to select a peripheral request signal as the request signal for the DMA destination device of the channel. If the destination device for DMA transfer is a memory, this field is ignored.";
            sw = rw; hw = r;
            reset = 0x0;
        } dest_periph[9:6];
        field {
            name = "reserved";
            desc = "Reserved This bit value must be 0 during write operations, and this bit must be masked during read operations.";
            sw = rw; hw = r;
            reset = 0x0;
        } reserved_5_5[5:5];
        field {
            name = "src_periph";
            desc = "Source device. This field is used to select a peripheral request signal as the request signal for the DMA source device of the channel. If the source device for DMA transfer is a memory, this field is ignored.";
            sw = rw; hw = r;
            reset = 0x0;
        } src_periph[4:1];
        field {
            name = "ch_en";
            desc = "Channel enable. The current status of the channel can be queried by reading this field or DMAC_ENABLED_CHNS.
- 0: disabled
- 1: enabled

Clearing this bit can disable a channel. When this bit is cleared, the current bus transfer continues until the data transfer is complete. Then, the channel is disabled and the remaining data in the FIFO is lost. When the last LLI node is transferred or an error occurs during transfer, the channel is also disabled and this bit is cleared. If you want to disable a channel without data loss, the Halt bit must be set to 1 so the subsequent DMA requests are ignored by the channel. After this, the Active bit must be polled until its value becomes 0, indicating that there is no data in the channel FIFO. At this time, the Enable bit can be cleared. Before enabling a channel by setting this bit to 1, you must reinitialize the channel; otherwise, unexpected results may occur. When a channel is disabled by writing DMAC_Cn_CONFIG [ch_en], DMAC_Cn_CONFIG [ch_en] can be reset again only after the corresponding bit of DMAC_ENABLED_CHNS is 0. This is because the channel is not disabled immediately after the Channel Enable bit is cleared. The running delay during a bus";
            sw = rw; hw = r;
            reset = 0x0;
        } ch_en[0:0];
    };
    DMAC_Cn_CONFIG_t DMAC_C0_CONFIG @ 0x110;
    DMAC_Cn_CONFIG_t DMAC_C1_CONFIG @ 0x130;
    DMAC_Cn_CONFIG_t DMAC_C2_CONFIG @ 0x150;
    DMAC_Cn_CONFIG_t DMAC_C3_CONFIG @ 0x170;
};
`endif
