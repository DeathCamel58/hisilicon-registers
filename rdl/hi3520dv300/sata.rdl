`ifndef HI3520DV300_SATA_PORT_RDL
`define HI3520DV300_SATA_PORT_RDL
regfile eHI3520DV300_SATA_PORT {
    name = "SATA port configuration registers";
    desc = "SATA port configuration registers of the Hi3521A/Hi3520D V300 at base 0x1101_0100. 29 registers extracted programmatically from the Hi3521A/Hi3520D V300 data sheet (Issue 00B07, 2015-12-10) (Table 13-13 Summary of the SATA port configuration registers (base address: 0x1101_0100)): register headings, offsets, total reset values, field bit ranges, access types, names, reset values and descriptions, with PDF page numbers in each register description. Field names, bit ranges, access types and offsets are exact; the free-text descriptions are taken from the cell text of the field table and were checked by sampling only. Hardware not verified.";
    reg SATA_PORT_CLB_t {
        name = "SATA_PORT_CLB";
        desc = "SATA_PORT_CLB is a command list base address register. (offset 0x0, 2 instances at stride 0x80; total reset 0x00000000; PROVEN: Hi3521A/Hi3520D V300 data sheet (Issue 00B07, 2015-12-10), section 13.6.7.2, PDF page 1606).";
        field {
            name = "port_clb";
            desc = "Base address for storing the port command list in the memory Resetting the SATA controller through SATA_GHC_GHC[hab_rst] has no effect on this field.";
            sw = rw; hw = r;
            reset = 0x0;
        } port_clb[31:10];
        field {
            name = "reserved";
            desc = "Reserved";
            sw = r; hw = w;
            reset = 0x0;
        } reserved_9_0[9:0];
    };
    SATA_PORT_CLB_t SATA_PORT_CLB_0 @ 0x0;
    SATA_PORT_CLB_t SATA_PORT_CLB_1 @ 0x80;
    reg SATA_PORT_FB_t {
        name = "SATA_PORT_FB";
        desc = "SATA_PORT_FB is an RX FIS base address register. (offset 0x8, 2 instances at stride 0x80; total reset 0x00000000; PROVEN: Hi3521A/Hi3520D V300 data sheet (Issue 00B07, 2015-12-10), section 13.6.7.2, PDF page 1606).";
        field {
            name = "port_fb";
            desc = "Base address in the memory for storing the frames received through the port Resetting the SATA controller through SATA_GHC_GHC[hab_rst] has no effect on this field.";
            sw = rw; hw = r;
            reset = 0x0;
        } port_fb[31:8];
        field {
            name = "reserved";
            desc = "Reserved";
            sw = r; hw = w;
            reset = 0x0;
        } reserved_7_0[7:0];
    };
    SATA_PORT_FB_t SATA_PORT_FB_0 @ 0x8;
    SATA_PORT_FB_t SATA_PORT_FB_1 @ 0x88;
    reg SATA_PORT_IS_t {
        name = "SATA_PORT_IS";
        desc = "SATA_PORT_IS is a port interrupt status register. (offset 0x10, 2 instances at stride 0x80; total reset 0x00000000; PROVEN: Hi3521A/Hi3520D V300 data sheet (Issue 00B07, 2015-12-10), section 13.6.7.2, PDF page 1607).";
        field {
            name = "reserved";
            desc = "Reserved";
            sw = r; hw = w;
            reset = 0x0;
        } reserved_31_31[31:31];
        field {
            name = "pxis_tfes";
            desc = "Task file data (TFD) error interrupt status
- 0: The value of SATA_PORT_TFD bit[0] is not 1.
- 1: The value of SATA_PORT_TFD bit[0] is 1.

Access type WC in the data sheet: written 1 clears the bit.";
            sw = rw; hw = w; onwrite = woclr;
            reset = 0x0;
        } pxis_tfes[30:30];
        field {
            name = "reserved";
            desc = "Reserved";
            sw = r; hw = w;
            reset = 0x0;
        } reserved_29_29[29:29];
        field {
            name = "pxis_hbds";
            desc = "Internal bus error interrupt
- 0: The DMAC accesses the memory properly.
- 1: An error occurs when the DMAC accesses the memory.

Access type WC in the data sheet: written 1 clears the bit.";
            sw = rw; hw = w; onwrite = woclr;
            reset = 0x0;
        } pxis_hbds[28:28];
        field {
            name = "pxis_ifs";
            desc = "Fatal error interrupt status
- 0: No error occurs during the data frame transfer.
- 1: An error occurs during the data frame transfer.

Access type WC in the data sheet: written 1 clears the bit.";
            sw = rw; hw = w; onwrite = woclr;
            reset = 0x0;
        } pxis_ifs[27:27];
        field {
            name = "pxis_infs";
            desc = "Non-fatal error interrupt status
- 0: No error occurs during the non-data frame transfer.
- 1: An error occurs during the non-data frame transfer.

Access type WC in the data sheet: written 1 clears the bit.";
            sw = rw; hw = w; onwrite = woclr;
            reset = 0x0;
        } pxis_infs[26:26];
        field {
            name = "reserved";
            desc = "Reserved";
            sw = r; hw = w;
            reset = 0x0;
        } reserved_25_25[25:25];
        field {
            name = "pxis_ofs";
            desc = "Data transfer overflow interrupt status
- 0: No overflow is detected.
- 1: During the data frame transfer, if the size of the data memory occupied by commands is smaller than the actual data amount, an interrupt is reported at the end of the data transfer.

Access type WC in the data sheet: written 1 clears the bit.";
            sw = rw; hw = w; onwrite = woclr;
            reset = 0x0;
        } pxis_ofs[24:24];
        field {
            name = "pxis_ipms";
            desc = "PM port number error interrupt status
- 0: No PM port number error is detected during data reception.
- 1: A PM port number error is detected during data reception.

Access type WC in the data sheet: written 1 clears the bit.";
            sw = rw; hw = w; onwrite = woclr;
            reset = 0x0;
        } pxis_ipms[23:23];
        field {
            name = "pxis_prcs";
            desc = "PHY status change interrupt status
- 0: No changes of the phyrdy signal are detected.
- 1: Changes of the phyrdy signal are detected.

This bit directly reflects the value of SATA_PORT_SERR[diag_n].";
            sw = r; hw = w;
            reset = 0x0;
        } pxis_prcs[22:22];
        field {
            name = "reserved";
            desc = "Reserved";
            sw = r; hw = w;
            reset = 0x0;
        } reserved_21_7[21:7];
        field {
            name = "pxis_pcs";
            desc = "Port connection change interrupt status
- 0: No COMINIT signal transmitted from the device is detected.
- 1: A COMINIT signal transmitted from the device is detected.

This bit directly reflects the value of SATA_PORT_SERR[diag.x].";
            sw = r; hw = w;
            reset = 0x0;
        } pxis_pcs[6:6];
        field {
            name = "pxis_dps";
            desc = "Linked list transfer completion interrupt status
- 0: The transfer of the linked list data is complete when no I bit in the PRD is 1.
- 1: The transfer of the linked list data is complete when an I bit in the PRD is 1.

Access type WC in the data sheet: written 1 clears the bit.";
            sw = rw; hw = w; onwrite = woclr;
            reset = 0x0;
        } pxis_dps[5:5];
        field {
            name = "pxis_ufs";
            desc = "Unknown FIS interrupt status
- 0: No unknown FIS is received.
- 1: An unknown FIS is received.";
            sw = r; hw = w;
            reset = 0x0;
        } pxis_ufs[4:4];
        field {
            name = "pxis_sdbs";
            desc = "Set device bits FIS interrupt status
- 0: no effect
- 1: A set device bits FIS is received and the I bit is 1.

Access type WC in the data sheet: written 1 clears the bit.";
            sw = rw; hw = w; onwrite = woclr;
            reset = 0x0;
        } pxis_sdbs[3:3];
        field {
            name = "pxis_dss";
            desc = "DMA setup FIS interrupt status
- 0: no effect
- 1: A DMA setup FIS is received and the I bit is 1.

Access type WC in the data sheet: written 1 clears the bit.";
            sw = rw; hw = w; onwrite = woclr;
            reset = 0x0;
        } pxis_dss[2:2];
        field {
            name = "pxis_pss";
            desc = "PIO setup FIS interrupt status
- 0: no effect
- 1: A PIO setup FIS is received and the I bit is 1.

Access type WC in the data sheet: written 1 clears the bit.";
            sw = rw; hw = w; onwrite = woclr;
            reset = 0x0;
        } pxis_pss[1:1];
        field {
            name = "pxis_dhrs";
            desc = "D2H register FIS interrupt status
- 0: no effect
- 1: A D2H register FIS is received and the I bit is 1.

Access type WC in the data sheet: written 1 clears the bit.";
            sw = rw; hw = w; onwrite = woclr;
            reset = 0x0;
        } pxis_dhrs[0:0];
    };
    SATA_PORT_IS_t SATA_PORT_IS_0 @ 0x10;
    SATA_PORT_IS_t SATA_PORT_IS_1 @ 0x90;
    reg SATA_PORT_IE_t {
        name = "SATA_PORT_IE";
        desc = "SATA_PORT_IE is a port interrupt mask register. (offset 0x14, 2 instances at stride 0x80; total reset 0x00000000; PROVEN: Hi3521A/Hi3520D V300 data sheet (Issue 00B07, 2015-12-10), section 13.6.7.2, PDF page 1609).";
        field {
            name = "reserved";
            desc = "Reserved";
            sw = r; hw = w;
            reset = 0x0;
        } reserved_31_31[31:31];
        field {
            name = "pxie_tfee";
            desc = "TFD error interrupt mask
- 0: masked
- 1: not masked";
            sw = rw; hw = r;
            reset = 0x0;
        } pxie_tfee[30:30];
        field {
            name = "reserved";
            desc = "Reserved";
            sw = r; hw = w;
            reset = 0x0;
        } reserved_29_29[29:29];
        field {
            name = "pxie_hbde";
            desc = "Internal bus error interrupt mask
- 0: masked
- 1: not masked";
            sw = rw; hw = r;
            reset = 0x0;
        } pxie_hbde[28:28];
        field {
            name = "pxie_ife";
            desc = "Fatal error interrupt mask
- 0: masked
- 1: not masked";
            sw = rw; hw = r;
            reset = 0x0;
        } pxie_ife[27:27];
        field {
            name = "pxie_infe";
            desc = "Non-fatal error interrupt mask
- 0: masked
- 1: not masked";
            sw = rw; hw = r;
            reset = 0x0;
        } pxie_infe[26:26];
        field {
            name = "reserved";
            desc = "Reserved";
            sw = r; hw = w;
            reset = 0x0;
        } reserved_25_25[25:25];
        field {
            name = "pxie_ofe";
            desc = "Data transfer overflow interrupt mask
- 0: masked
- 1: not masked";
            sw = rw; hw = r;
            reset = 0x0;
        } pxie_ofe[24:24];
        field {
            name = "pxie_ipme";
            desc = "PM port error interrupt mask
- 0: masked
- 1: not masked";
            sw = rw; hw = r;
            reset = 0x0;
        } pxie_ipme[23:23];
        field {
            name = "pxie_prce";
            desc = "PHY status change interrupt mask
- 0: masked
- 1: not masked";
            sw = rw; hw = r;
            reset = 0x0;
        } pxie_prce[22:22];
        field {
            name = "reserved";
            desc = "Reserved";
            sw = r; hw = w;
            reset = 0x0;
        } reserved_21_7[21:7];
        field {
            name = "pxie_pce";
            desc = "Port connection change interrupt mask
- 0: masked
- 1: not masked";
            sw = rw; hw = r;
            reset = 0x0;
        } pxie_pce[6:6];
        field {
            name = "pxie_dpe";
            desc = "Linked list transfer completion interrupt mask
- 0: masked
- 1: not masked";
            sw = rw; hw = r;
            reset = 0x0;
        } pxie_dpe[5:5];
        field {
            name = "pxie_ufe";
            desc = "Unknown FIS interrupt mask
- 0: masked
- 1: not masked";
            sw = rw; hw = r;
            reset = 0x0;
        } pxie_ufe[4:4];
        field {
            name = "pxie_sdbe";
            desc = "Set device bits FIS interrupt mask
- 0: masked
- 1: not masked";
            sw = rw; hw = r;
            reset = 0x0;
        } pxie_sdbe[3:3];
        field {
            name = "pxie_dse";
            desc = "DMA setup FIS interrupt mask
- 0: masked
- 1: not masked";
            sw = rw; hw = r;
            reset = 0x0;
        } pxie_dse[2:2];
        field {
            name = "pxie_pse";
            desc = "PIO setup FIS interrupt mask
- 0: masked
- 1: not masked";
            sw = rw; hw = r;
            reset = 0x0;
        } pxie_pse[1:1];
        field {
            name = "pxie_dhre";
            desc = "D2H register FIS interrupt mask
- 0: masked
- 1: not masked";
            sw = rw; hw = r;
            reset = 0x0;
        } pxie_dhre[0:0];
    };
    SATA_PORT_IE_t SATA_PORT_IE_0 @ 0x14;
    SATA_PORT_IE_t SATA_PORT_IE_1 @ 0x94;
    reg SATA_PORT_CMD_t {
        name = "SATA_PORT_CMD";
        desc = "SATA_PORT_CMD is a port command and status register. (offset 0x18, 2 instances at stride 0x80; total reset 0x00600000; PROVEN: Hi3521A/Hi3520D V300 data sheet (Issue 00B07, 2015-12-10), section 13.6.7.2, PDF page 1610).";
        field {
            name = "cmd_icc";
            desc = "Port communication control signal
- 0x0: No operation. It indicates that the next port status request is allowed.
- 0x1: Request to enable the port to be in the active status.
- 0x2: Request to enable the port to be in the partial status.
- 0x6: Request to enable the port to be in the slumber status.

Other values: reserved When the software writes any of the preceding values rather than the reserved value, the controller clears the cmd_icc bit after performing related operations. When the software requests the current status of the port, the controller clears the cmd_icc bit directly. If the software requests the port status change from a low-power status to another low-power status, such as from the partial status to the slumber status, it needs to request the status change from the partial status to the active status, and then to the slumber status.";
            sw = rw; hw = r;
            reset = 0x0;
        } cmd_icc[31:28];
        field {
            name = "cmd_asp";
            desc = "Slumber or partial status select for power management
- 0: proactively enter the partial status.
- 1: proactively enter the slumber status.";
            sw = rw; hw = r;
            reset = 0x0;
        } cmd_asp[27:27];
        field {
            name = "cmd_alpe";
            desc = "Automatic power management enable
- 0: disabled
- 1: enabled If SATA_PORT_CI and SATA_PORT_SACT are cleared, the controller enters the power-management status automatically. To be specific, if cmd_asp is 1, the controller enters the partial status; if cmd_asp is 0, the controller enters the slumber status.";
            sw = rw; hw = r;
            reset = 0x0;
        } cmd_alpe[26:26];
        field {
            name = "cmd_dlae";
            desc = "LED drive enable in ATAPI mode
- 0: The LED pin can be driven when cmd_atapi is 0 and commands are being executed.
- 1: The LED pin can be driven when commands are being executed.";
            sw = rw; hw = r;
            reset = 0x0;
        } cmd_dlae[25:25];
        field {
            name = "cmd_atapi";
            desc = "ATAPI device indicator
- 0: The current device is not an ATAPI device.
- 1: The current device is an ATAPI device.";
            sw = rw; hw = r;
            reset = 0x0;
        } cmd_atapi[24:24];
        field {
            name = "reserved";
            desc = "Reserved";
            sw = r; hw = w;
            reset = 0x0;
        } reserved_23_23[23:23];
        field {
            name = "fbscp";
            desc = "Whether the port supports FIS-based switching. When SATA_GHC_CAP1[spm] and SATA_GHC_CAP1[FBSS] are set to 1, this bit must be set to 1.
- 0: not supported
- 1: supported";
            sw = r; hw = w;
            reset = 0x1;
        } fbscp[22:22];
        field {
            name = "cmd_esp";
            desc = "Fixed at 1, indicating that the external SATA device is supported";
            sw = r; hw = w;
            reset = 0x1;
        } cmd_esp[21:21];
        field {
            name = "reserved";
            desc = "Reserved";
            sw = r; hw = w;
            reset = 0x0;
        } reserved_20_18[20:18];
        field {
            name = "cmd_pma";
            desc = "Port multiplier detection indicator
- 0: No port multiplier is connected to the port.
- 1: A port multiplier is connected to the port.";
            sw = rw; hw = r;
            reset = 0x0;
        } cmd_pma[17:17];
        field {
            name = "reserved";
            desc = "Reserved";
            sw = r; hw = w;
            reset = 0x0;
        } reserved_16_16[16:16];
        field {
            name = "cmd_cr";
            desc = "Command list processing indicator
- 0: No command is being executed.
- 1: A command is being executed.";
            sw = r; hw = w;
            reset = 0x0;
        } cmd_cr[15:15];
        field {
            name = "cmd_fr";
            desc = "FIS receive processing indicator
- 0: No FIS is being received.
- 1: An FIS is being received.";
            sw = r; hw = w;
            reset = 0x0;
        } cmd_fr[14:14];
        field {
            name = "reserved";
            desc = "Reserved";
            sw = r; hw = w;
            reset = 0x0;
        } reserved_13_13[13:13];
        field {
            name = "cmd_ccs";
            desc = "Slot number of the current command This field is valid when cmd_st is 1 and is cleared when cmd_st is 0.";
            sw = r; hw = w;
            reset = 0x0;
        } cmd_ccs[12:8];
        field {
            name = "reserved";
            desc = "Reserved";
            sw = r; hw = w;
            reset = 0x0;
        } reserved_7_5[7:5];
        field {
            name = "cmd_fre";
            desc = "FIS receive enable control
- 0: forbid to write the received FISs to the system memory
- 1: enable the received FISs and write them to the system memory

The software needs to set the receive FIS base address register SATA_PORT_FB before enabling this bit to receive FISs. When cmd_st is 1, this bit must be set to 1.";
            sw = rw; hw = r;
            reset = 0x0;
        } cmd_fre[4:4];
        field {
            name = "cmd_clo";
            desc = "BSY/DQR clear control. The software can forcibly clear the BSY and DRQ bits through this bit and transmit commands to the device.
- 0: no effect
- 1: Clear the BSY and DRQ bits of SATA_PORT_TFD[tfd_sts].

After the BSY and DRQ bits are 0, the cmd_clo bit is automatically cleared. The cmd_clo bit can be written as 1 only before the value of cmd_st is changed from 0 to 1. In addition, the software must write 1 to cmd_st after the cmd_clo bit is cleared.";
            sw = rw; hw = r;
            reset = 0x0;
        } cmd_clo[3:3];
        field {
            name = "reserved";
            desc = "Reserved";
            sw = r; hw = w;
            reset = 0x0;
        } reserved_2_2[2:2];
        field {
            name = "cmd_sud";
            desc = "Spin-up device control
- 0: When SATA_PORT_SCTL[det] is 0, the controller enters the listen mode.
- 1: After the system is powered on or the HBA is reset, the controller is enabled to transmit a COMRESET sequence to initialize the hardware device.";
            sw = rw; hw = r;
            reset = 0x0;
        } cmd_sud[1:1];
        field {
            name = "cmd_st";
            desc = "Command list processing enable
- 0: The controller enters the idle status.
- 1: The controller processes the commands from slot 0 that are identified as valid slots by SATA_PORT_CI.

The cmd_st bit can be set to 1 only after cmd_fre is 1.";
            sw = rw; hw = r;
            reset = 0x0;
        } cmd_st[0:0];
    };
    SATA_PORT_CMD_t SATA_PORT_CMD_0 @ 0x18;
    SATA_PORT_CMD_t SATA_PORT_CMD_1 @ 0x98;
    reg SATA_PORT_TFD_t {
        name = "SATA_PORT_TFD";
        desc = "SATA_PORT_TFD is a port task file register. (offset 0x20, 2 instances at stride 0x80; total reset 0x0000007F; PROVEN: Hi3521A/Hi3520D V300 data sheet (Issue 00B07, 2015-12-10), section 13.6.7.2, PDF page 1613).";
        field {
            name = "reserved";
            desc = "Reserved";
            sw = r; hw = w;
            reset = 0x0;
        } reserved_31_16[31:16];
        field {
            name = "tfd_err";
            desc = "Task file error The controller updates this field after receiving a D2H register FIS, a PIO setup FIS, or an SDB FIS.";
            sw = r; hw = w;
            reset = 0x0;
        } tfd_err[15:8];
        field {
            name = "tfd_sts";
            desc = "Task file status bit[7]: BSY bit. It indicates that the device is busy. bit[6:4]: The meaning of this field varies according to commands. bit[3]: DRQ bit. It indicates that there is the data to be transferred in the device. bit[2:1]: The meaning of this field varies according to commands. bit[0]: ERR bit. It indicates that an error occurs during the data transfer. The controller updates this field after receiving a D2H register FIS, a PIO setup FIS, or an SDB FIS.";
            sw = r; hw = w;
            reset = 0x7f;
        } tfd_sts[7:0];
    };
    SATA_PORT_TFD_t SATA_PORT_TFD_0 @ 0x20;
    SATA_PORT_TFD_t SATA_PORT_TFD_1 @ 0xA0;
    reg SATA_PORT_SIG_t {
        name = "SATA_PORT_SIG";
        desc = "SATA_PORT_SIG is a port signature register. (offset 0x24, 2 instances at stride 0x80; total reset 0xFFFFFFFF; PROVEN: Hi3521A/Hi3520D V300 data sheet (Issue 00B07, 2015-12-10), section 13.6.7.2, PDF page 1614).";
        field {
            name = "signature";
            desc = "LBA address and sector addressing. The allocated addresses are as follows: bit[31:24]: LBA upper-bit address bit[23:16]: LBA middle-bit address bit[15:8]: LBA lower-bit address bit[7:0]: number of sectors The controller updates this register when receiving the first D2H register FIS after the hardware device is reset.";
            sw = r; hw = w;
            reset = 0xffffffff;
        } signature[31:0];
    };
    SATA_PORT_SIG_t SATA_PORT_SIG_0 @ 0x24;
    SATA_PORT_SIG_t SATA_PORT_SIG_1 @ 0xA4;
    reg SATA_PORT_SSTS_t {
        name = "SATA_PORT_SSTS";
        desc = "SATA_PORT_SSTS is a port status register. (offset 0x28, 2 instances at stride 0x80; total reset 0x00000000; PROVEN: Hi3521A/Hi3520D V300 data sheet (Issue 00B07, 2015-12-10), section 13.6.7.2, PDF page 1614).";
        field {
            name = "reserved";
            desc = "Reserved";
            sw = r; hw = w;
            reset = 0x0;
        } reserved_31_12[31:12];
        field {
            name = "pxssts_ipm";
            desc = "Current port status
- 0x0: No devices exist or no communication is set up.
- 0x1: active
- 0x2: partial
- 0x6: slumber

Other values: reserved";
            sw = r; hw = w;
            reset = 0x0;
        } pxssts_ipm[11:8];
        field {
            name = "pxssts_spd";
            desc = "Port negotiation speed
- 0x0: No devices exist or no communication is set up.
- 0x1: Rate 1 is negotiated for communication.
- 0x2: Rate 2 is negotiated for communication.
- 0x3: Rate 3 is negotiated for communication.

Other values: reserved";
            sw = r; hw = w;
            reset = 0x0;
        } pxssts_spd[7:4];
        field {
            name = "pxssts_det";
            desc = "Device detection and PHY status
- 0x0: No device is detected and no PHY communication is set up.
- 0x1: A device is detected but no PHY communication is set up.
- 0x3: A device is detected but the PHY communication is set up.
- 0x4: The PHY is offline or in the built-in self test (BIST) status.

Other values: reserved";
            sw = r; hw = w;
            reset = 0x0;
        } pxssts_det[3:0];
    };
    SATA_PORT_SSTS_t SATA_PORT_SSTS_0 @ 0x28;
    SATA_PORT_SSTS_t SATA_PORT_SSTS_1 @ 0xA8;
    reg SATA_PORT_SCTL_t {
        name = "SATA_PORT_SCTL";
        desc = "SATA_PORT_SCTL is a port control register. (offset 0x2C, 2 instances at stride 0x80; total reset 0x00000000; PROVEN: Hi3521A/Hi3520D V300 data sheet (Issue 00B07, 2015-12-10), section 13.6.7.2, PDF page 1615).";
        field {
            name = "reserved";
            desc = "Reserved";
            sw = r; hw = w;
            reset = 0x0;
        } reserved_31_12[31:12];
        field {
            name = "pxsctl_ipm";
            desc = "Port power management status control
- 0x0: no requirements
- 0x1: forbid to enter the partial status
- 0x2: forbid to enter the slumber status
- 0x3: forbid to enter the partial or slumber state

Other values: reserved";
            sw = rw; hw = r;
            reset = 0x0;
        } pxsctl_ipm[11:8];
        field {
            name = "pxsctl_spd";
            desc = "Port communication speed control
- 0x0: no requirements
- 0x1: limit the communication speed to rate 1
- 0x2: limit the communication speed to rate 2
- 0x3: limit the communication speed to rate 3

Other values: reserved";
            sw = rw; hw = r;
            reset = 0x0;
        } pxsctl_spd[7:4];
        field {
            name = "pxsctl_det";
            desc = "Device detection and port initialization control
- 0x0: no device detection or initialization request
- 0x1: request the port to reset the initialization sequence

COMRESET
- 0x4: force the port to be offline

Other values: reserved When pxsctl_det is set to 1, the controller transmits the COMRESET sequence to the device. In this case, to ensure that the device receives the COMRESET sequence, the software must retain the value 1 of pxsctl_det for at least 1 ms.";
            sw = rw; hw = r;
            reset = 0x0;
        } pxsctl_det[3:0];
    };
    SATA_PORT_SCTL_t SATA_PORT_SCTL_0 @ 0x2C;
    SATA_PORT_SCTL_t SATA_PORT_SCTL_1 @ 0xAC;
    reg SATA_PORT_SERR_t {
        name = "SATA_PORT_SERR";
        desc = "SATA_PORT_SERR is an error diagnosis status register. (offset 0x30, 2 instances at stride 0x80; total reset 0x00000000; PROVEN: Hi3521A/Hi3520D V300 data sheet (Issue 00B07, 2015-12-10), section 13.6.7.2, PDF page 1616).";
        field {
            name = "reserved";
            desc = "Reserved";
            sw = r; hw = w;
            reset = 0x0;
        } reserved_31_27[31:27];
        field {
            name = "diag_x";
            desc = "Device detection status
- 0: No COMINIT signal transmitted from the device is detected.
- 1: A COMINIT signal transmitted from the device is detected.

Access type WC in the data sheet: written 1 clears the bit.";
            sw = rw; hw = w; onwrite = woclr;
            reset = 0x0;
        } diag_x[26:26];
        field {
            name = "diag_f";
            desc = "Detection status of the unknown FIS
- 0: No unknown FIS is received.
- 1: An unknown FIS is received and this bit is set to 1 when the cyclic redundancy check (CRC) is correct.

Access type WC in the data sheet: written 1 clears the bit.";
            sw = rw; hw = w; onwrite = woclr;
            reset = 0x0;
        } diag_f[25:25];
        field {
            name = "reserved";
            desc = "Reserved";
            sw = r; hw = w;
            reset = 0x0;
        } reserved_24_24[24:24];
        field {
            name = "diag_s";
            desc = "Link layer error status
- 0: No status transition error occurs at the link layer.
- 1: A status transition error occurs at the link layer.

Access type WC in the data sheet: written 1 clears the bit.";
            sw = rw; hw = w; onwrite = woclr;
            reset = 0x0;
        } diag_s[23:23];
        field {
            name = "diag_h";
            desc = "Handshake error status
- 0: No R_ERR primitive transmitted from the device is received.
- 1: One or more R_ERR primitives transmitted from the device are received.

Access type WC in the data sheet: written 1 clears the bit.";
            sw = rw; hw = w; onwrite = woclr;
            reset = 0x0;
        } diag_h[22:22];
        field {
            name = "diag_c";
            desc = "CRC error status
- 0: No CRC error occurs during FIS receiving.
- 1: A CRC error occurs during FIS receiving.

Access type WC in the data sheet: written 1 clears the bit.";
            sw = rw; hw = w; onwrite = woclr;
            reset = 0x0;
        } diag_c[21:21];
        field {
            name = "reserved";
            desc = "Reserved";
            sw = r; hw = w;
            reset = 0x0;
        } reserved_20_20[20:20];
        field {
            name = "diag_b";
            desc = "Decoding error status
- 0: No 8B/10B decoding error is detected.
- 1: An 8B/10B decoding error is detected.

Access type WC in the data sheet: written 1 clears the bit.";
            sw = rw; hw = w; onwrite = woclr;
            reset = 0x0;
        } diag_b[19:19];
        field {
            name = "diag_w";
            desc = "COMWAKE status
- 0: No COMWAKE signal transmitted from the device is detected.
- 1: A COMWAKE signal transmitted from the device is detected.

Access type WC in the data sheet: written 1 clears the bit.";
            sw = rw; hw = w; onwrite = woclr;
            reset = 0x0;
        } diag_w[18:18];
        field {
            name = "diag_i";
            desc = "PHY internal error status
- 0: No PHY internal error is detected.
- 1: A PHY internal error is detected.

Access type WC in the data sheet: written 1 clears the bit.";
            sw = rw; hw = w; onwrite = woclr;
            reset = 0x0;
        } diag_i[17:17];
        field {
            name = "diag_n";
            desc = "PhyRdy signal change status
- 0: The PhyRdy signal is not changed.
- 1: The PhyRdy signal is changed.

This bit is set to 1 when the value of the PhyRdy signal is changed from 1 to 0 or from 0 to 1.

Access type WC in the data sheet: written 1 clears the bit.";
            sw = rw; hw = w; onwrite = woclr;
            reset = 0x0;
        } diag_n[16:16];
        field {
            name = "reserved";
            desc = "Reserved";
            sw = r; hw = w;
            reset = 0x0;
        } reserved_15_11[15:11];
        field {
            name = "err_p";
            desc = "SATA protocol incompliance error status
- 0: All device behaviors comply with the SATA protocol.
- 1: Some device behaviors do not comply with the SATA protocol.

Access type WC in the data sheet: written 1 clears the bit.";
            sw = rw; hw = w; onwrite = woclr;
            reset = 0x0;
        } err_p[10:10];
        field {
            name = "reserved";
            desc = "Reserved";
            sw = r; hw = w;
            reset = 0x0;
        } reserved_9_9[9:9];
        field {
            name = "err_t";
            desc = "Data integrity error status
- 0: No data integrity error is detected.
- 1: A data integrity error is detected.

Access type WC in the data sheet: written 1 clears the bit.";
            sw = rw; hw = w; onwrite = woclr;
            reset = 0x0;
        } err_t[8:8];
        field {
            name = "reserved";
            desc = "Reserved";
            sw = r; hw = w;
            reset = 0x0;
        } reserved_7_0[7:0];
    };
    SATA_PORT_SERR_t SATA_PORT_SERR_0 @ 0x30;
    SATA_PORT_SERR_t SATA_PORT_SERR_1 @ 0xB0;
    reg SATA_PORT_SACT_t {
        name = "SATA_PORT_SACT";
        desc = "SATA_PORT_SACT is an NCQ command identifier control register. (offset 0x34, 2 instances at stride 0x80; total reset 0x00000000; PROVEN: Hi3521A/Hi3520D V300 data sheet (Issue 00B07, 2015-12-10), section 13.6.7.2, PDF page 1617).";
        field {
            name = "port_sact";
            desc = "NCQ command identifier control Each bit of this register maps to a tag ID and an NCQ command in the memory. To be specific, bit[31:0] map to the commands of slot 31-0 and tag 31-0 respectively. The following describes the meaning of each bit by taking bit[3] as an example:
- 0: The slot 3 command is a non-NCQ command.
- 1: The slot 3 command is an NCQ command. Before setting

SATA_PORT_SACT bit[3] to 1, the software must clear SATA_PORT_CI bit[3]. After the command data transfer, the device transmits an SDB FIS. Then, the controller clears SATA_PORT_SACT bit[3] based on the SActive in the FIS. The software can set SATA_PORT_SACT only when cmd_st is 1. When cmd_st is 0, all bits of SATA_PORT_SACT are cleared.";
            sw = rw; hw = r;
            reset = 0x0;
        } port_sact[31:0];
    };
    SATA_PORT_SACT_t SATA_PORT_SACT_0 @ 0x34;
    SATA_PORT_SACT_t SATA_PORT_SACT_1 @ 0xB4;
    reg SATA_PORT_CI_t {
        name = "SATA_PORT_CI";
        desc = "SATA_PORT_CI is a command TX control register. (offset 0x38, 2 instances at stride 0x80; total reset 0x00000000; PROVEN: Hi3521A/Hi3520D V300 data sheet (Issue 00B07, 2015-12-10), section 13.6.7.2, PDF page 1618).";
        field {
            name = "port_ci";
            desc = "Control for the commands to be transmitted Each bit of this register maps to a command in the memory. To be specific, bit[31:0] map to the commands of slot 31-0 respectively. The following describes the meaning of each bit by taking bit[3] as an example:
- 0: There is no slot 3 command to be transmitted and executed.
- 1: A slot 3 command is created in the memory. Then the controller can transmit this command. After running this command and receiving a corresponding FIS, the controller clears

SATA_PORT_CI bit[3] and the BSY, DRQ, and ERR bits of SATA_PORT_TFD. The bits of SATA_PORT_CI can be set to 1 only when cmd_st is 1 and all bits of SATA_PORT_CI are cleared when cmd_st is 0.";
            sw = rw; hw = r;
            reset = 0x0;
        } port_ci[31:0];
    };
    SATA_PORT_CI_t SATA_PORT_CI_0 @ 0x38;
    SATA_PORT_CI_t SATA_PORT_CI_1 @ 0xB8;
    reg SATA_PORT_SNTF_t {
        name = "SATA_PORT_SNTF";
        desc = "SATA_PORT_SNTF is an async notification event indicator register. (offset 0x3C, 2 instances at stride 0x80; total reset 0x00000000; PROVEN: Hi3521A/Hi3520D V300 data sheet (Issue 00B07, 2015-12-10), section 13.6.7.2, PDF page 1619).";
        field {
            name = "reserved";
            desc = "Reserved";
            sw = r; hw = w;
            reset = 0x0;
        } reserved_31_16[31:16];
        field {
            name = "pxsntf_pmn";
            desc = "Async notification event status If the controller receives an SDB FIS from the device on the PM port and the N bit of this FIS is 1, the controller sets the bit of this register corresponding to this port number to 1. The following describes the meaning of each bit by taking bit[3] as an example:
- 0: No async notification event occurs on the device whose PM port number is 3.
- 1: An async notification event occurs on the device whose PM port number is 3.

Access type WC in the data sheet: written 1 clears the bit.";
            sw = rw; hw = w; onwrite = woclr;
            reset = 0x0;
        } pxsntf_pmn[15:0];
    };
    SATA_PORT_SNTF_t SATA_PORT_SNTF_0 @ 0x3C;
    SATA_PORT_SNTF_t SATA_PORT_SNTF_1 @ 0xBC;
    reg SATA_PORT_FBS_t {
        name = "SATA_PORT_FBS";
        desc = "SATA_PORT_FBS is an FIS-based switching control register. (offset 0x40, 2 instances at stride 0x80; total reset 0x0000F000; PROVEN: Hi3521A/Hi3520D V300 data sheet (Issue 00B07, 2015-12-10), section 13.6.7.2, PDF page 1619).";
        field {
            name = "reserved";
            desc = "Reserved";
            sw = r; hw = w;
            reset = 0x0;
        } reserved_31_20[31:20];
        field {
            name = "fbs_dwe";
            desc = "A fatal error occurs on the device corresponding to the current PM port. This field is configured by hardware and is valid only when PxFBS.SDE is 1.";
            sw = r; hw = w;
            reset = 0x0;
        } fbs_dwe[19:16];
        field {
            name = "fbs_ado";
            desc = "Maximum number of external devices mounted over the PM during the current FIS-based switching. This field is configured by hardware. The number of PM domains corresponding to the created command should be less than the value when a command is created for optimal performance.";
            sw = r; hw = w;
            reset = 0xf;
        } fbs_ado[15:12];
        field {
            name = "fbs_dev";
            desc = "ID of the PM port to which the next command is transmitted. This field is configured by software. Software cannot transmit commands to multiple PM ports. Therefore, when a CI is created, commands cannot be transmitted to multiple PM ports. The same PM port must be used for a CI.";
            sw = rw; hw = r;
            reset = 0x0;
        } fbs_dev[11:8];
        field {
            name = "reserved";
            desc = "Reserved";
            sw = r; hw = w;
            reset = 0x0;
        } reserved_7_3[7:3];
        field {
            name = "fbs_sde";
            desc = "When this field is set to 1, a fatal error occurs, and hardware considers that software processes this error first. This field is cleared by setting PxCMD.ST to 0. When PxFBS.DEC is set to 1 or PxCMD.ST is set to 0, the fbs_sde bit needs to be cleared.";
            sw = r; hw = w;
            reset = 0x0;
        } fbs_sde[2:2];
        field {
            name = "fbs_dec";
            desc = "When software sets this bit to 1, the HBA needs to clear the error trigger conditions and clear the commands of the outstanding corresponding to the device including PxCI and PxSACT of the device. After hardware rectifies the error, the hardware must set this bit to 0. Writing 0 to this bit by using software has no effect. Software can set this bit to 1 only when PxFBS.EN and PxFBS.SDE are 1.";
            sw = rw; hw = r;
            reset = 0x0;
        } fbs_dec[1:1];
        field {
            name = "fbs_en";
            desc = "When this bit is set to 1, a PM is connected, and the HBA needs to enable FIB-based switching to communicate with the PM. When this bit is cleared, FIS-based switching is unavailable. Software can modify this bit only when PxCMD.ST is 0.";
            sw = rw; hw = r;
            reset = 0x0;
        } fbs_en[0:0];
    };
    SATA_PORT_FBS_t SATA_PORT_FBS_0 @ 0x40;
    SATA_PORT_FBS_t SATA_PORT_FBS_1 @ 0xC0;
    reg SATA_PORT_FIFOTH_t {
        name = "SATA_PORT_FIFOTH";
        desc = "SATA_PORT_FIFOTH is an RX FIFO threshold register. (offset 0x44, 2 instances at stride 0x80; total reset 0x076D9F24; PROVEN: Hi3521A/Hi3520D V300 data sheet (Issue 00B07, 2015-12-10), section 13.6.7.2, PDF page 1620). The field table prints reserved as [10:9] and hold_seagate_bug_en as [9]; reserved is taken as [10:10] (INFERRED: the printed ranges overlap, bit 9 belongs to hold_seagate_bug_en).";
        field {
            name = "reserved";
            desc = "Reserved";
            sw = rw; hw = r;
            reset = 0x1db;
        } reserved_31_18[31:18];
        field {
            name = "mem_ctrl";
            desc = "Timing parameter for controlling the memory [13:11]: EMAA in the corresponding memory [14]: EMSA in the corresponding memory [17:15]: EMAB in the corresponding memory";
            sw = rw; hw = r;
            reset = 0x33;
        } mem_ctrl[17:11];
        field {
            name = "reserved";
            desc = "Reserved";
            sw = r; hw = w;
            reset = 0x1;
        } reserved_10_10[10:10];
        field {
            name = "hold_seagate_bug_en";
            desc = "The test shows that some Seagate hard disks do not comply with the protocol. To be specific, CONTp is transmitted after primitives are transmitted once. This bug can be avoided by setting this bit to 1.";
            sw = rw; hw = r;
            reset = 0x1;
        } hold_seagate_bug_en[9:9];
        field {
            name = "dmac_rxfifo_th";
            desc = "Flow control threshold of the DMAC RX FIFO. During data reception, if the data amount in the DMAC FIFO is above the threshold, the controller starts to control the data flow.";
            sw = rw; hw = r;
            reset = 0x12;
        } dmac_rxfifo_th[8:4];
        field {
            name = "rxfifo_th_sel";
            desc = "Flow control FIFO select
- 0: The flow control for the link RX FIFO is valid.
- 1: The flow control for the DMAC RX FIFO is valid.";
            sw = rw; hw = r;
            reset = 0x0;
        } rxfifo_th_sel[3:3];
        field {
            name = "link_rxfifo_th";
            desc = "Flow control threshold of the link RX FIFO. During data reception, if the data amount in the DMAC FIFO is above the threshold, the controller starts to control the data flow.";
            sw = rw; hw = r;
            reset = 0x4;
        } link_rxfifo_th[2:0];
    };
    SATA_PORT_FIFOTH_t SATA_PORT_FIFOTH_0 @ 0x44;
    SATA_PORT_FIFOTH_t SATA_PORT_FIFOTH_1 @ 0xC4;
    reg SATA_PORT_PHYCTL1_t {
        name = "SATA_PORT_PHYCTL1";
        desc = "SATA_PORT_PHYCTL1 is PHY control register 1. (offset 0x48, 2 instances at stride 0x80; total reset 0x002E5CB8; PROVEN: Hi3521A/Hi3520D V300 data sheet (Issue 00B07, 2015-12-10), section 13.6.7.2, PDF page 1621).";
        field {
            name = "reserved";
            desc = "Reserved";
            sw = r; hw = w;
            reset = 0x0;
        } reserved_31_28[31:28];
        field {
            name = "px_tx_invert";
            desc = "Whether polarity reverse is allowed in the TX direction
- 0: no
- 1: yes";
            sw = rw; hw = r;
            reset = 0x0;
        } px_tx_invert[27:27];
        field {
            name = "px_nearafelb";
            desc = "Loopback mode for the BIST test";
            sw = rw; hw = r;
            reset = 0x0;
        } px_nearafelb[26:26];
        field {
            name = "px_bpr_reset";
            desc = "Reset in BIST mode";
            sw = rw; hw = r;
            reset = 0x0;
        } px_bpr_reset[25:25];
        field {
            name = "px_rx_eq";
            desc = "Equalization setting in the RX direction";
            sw = rw; hw = r;
            reset = 0x0;
        } px_rx_eq[24:22];
        field {
            name = "px_tx_amplitude_gen3";
            desc = "Amplitude of the TX signal in Gen3 mode";
            sw = rw; hw = r;
            reset = 0x5c;
        } px_tx_amplitude_gen3[21:15];
        field {
            name = "px_tx_amplitude_gen2";
            desc = "Amplitude of the TX signal in Gen2 mode";
            sw = rw; hw = r;
            reset = 0x5c;
        } px_tx_amplitude_gen2[14:8];
        field {
            name = "px_tx_amplitude_gen1";
            desc = "Amplitude of the TX signal in Gen1 mode";
            sw = rw; hw = r;
            reset = 0x5c;
        } px_tx_amplitude_gen1[7:1];
        field {
            name = "px_rx_invert";
            desc = "Whether polarity reverse is allowed in the RX direction
- 0: no
- 1: yes";
            sw = rw; hw = r;
            reset = 0x0;
        } px_rx_invert[0:0];
    };
    SATA_PORT_PHYCTL1_t SATA_PORT_PHYCTL1_0 @ 0x48;
    SATA_PORT_PHYCTL1_t SATA_PORT_PHYCTL1_1 @ 0xC8;
    reg SATA_PORT_PHYCTL2_t {
        name = "SATA_PORT_PHYCTL2";
        desc = "SATA_PORT_PHYCTL2 is PHY control register 2. (offset 0x4C, 2 instances at stride 0x80; total reset 0x00020555; PROVEN: Hi3521A/Hi3520D V300 data sheet (Issue 00B07, 2015-12-10), section 13.6.7.2, PDF page 1622).";
        field {
            name = "reserved";
            desc = "Reserved";
            sw = r; hw = w;
            reset = 0x0;
        } reserved_31_19[31:19];
        field {
            name = "px_reset";
            desc = "Lane reset signal of the SerDes, async reset, active high";
            sw = rw; hw = r;
            reset = 0x0;
        } px_reset[18:18];
        field {
            name = "px_tx_preemph_gen3";
            desc = "TX preemphasis control in Gen3 mode";
            sw = rw; hw = r;
            reset = 0x20;
        } px_tx_preemph_gen3[17:12];
        field {
            name = "px_tx_preemph_gen2";
            desc = "TX preemphasis control in Gen2 mode";
            sw = rw; hw = r;
            reset = 0x15;
        } px_tx_preemph_gen2[11:6];
        field {
            name = "px_tx_preemph_gen1";
            desc = "TX preemphasis control in Gen1 mode";
            sw = rw; hw = r;
            reset = 0x15;
        } px_tx_preemph_gen1[5:0];
    };
    SATA_PORT_PHYCTL2_t SATA_PORT_PHYCTL2_0 @ 0x4C;
    SATA_PORT_PHYCTL2_t SATA_PORT_PHYCTL2_1 @ 0xCC;
    reg SATA_PORT_HBA_t {
        name = "SATA_PORT_HBA";
        desc = "SATA_PORT_HBA is an HBA test status register. (offset 0x50, 2 instances at stride 0x80; total reset 0x01000000; PROVEN: Hi3521A/Hi3520D V300 data sheet (Issue 00B07, 2015-12-10), section 13.6.7.2, PDF page 1623).";
        field {
            name = "reserved";
            desc = "Reserved";
            sw = r; hw = w;
            reset = 0x0;
        } reserved_31_28[31:28];
        field {
            name = "p_curr_st";
            desc = "Current status of the HBA_PINIT_STATE state machine";
            sw = r; hw = w;
            reset = 0x1;
        } p_curr_st[27:24];
        field {
            name = "reserved";
            desc = "Reserved";
            sw = r; hw = w;
            reset = 0x0;
        } reserved_23_21[23:21];
        field {
            name = "ndr_curr_st";
            desc = "Current status of the HBA_NDR_STATE state machine";
            sw = r; hw = w;
            reset = 0x0;
        } ndr_curr_st[20:16];
        field {
            name = "cfis_curr_st";
            desc = "Current status of the HBA_CFIS_STATE state machine";
            sw = r; hw = w;
            reset = 0x0;
        } cfis_curr_st[15:12];
        field {
            name = "reserved";
            desc = "Reserved";
            sw = r; hw = w;
            reset = 0x0;
        } reserved_11_11[11:11];
        field {
            name = "pio_curr_st";
            desc = "Current status of the HBA_PIO_STATE state machine";
            sw = r; hw = w;
            reset = 0x0;
        } pio_curr_st[10:8];
        field {
            name = "reserved";
            desc = "Reserved";
            sw = r; hw = w;
            reset = 0x0;
        } reserved_7_7[7:7];
        field {
            name = "pm_curr_st";
            desc = "Current status of the HBA_PM_STATE state machine";
            sw = r; hw = w;
            reset = 0x0;
        } pm_curr_st[6:4];
        field {
            name = "err_curr_st";
            desc = "Current status of the HBA_ERR_STATE state machine";
            sw = r; hw = w;
            reset = 0x0;
        } err_curr_st[3:0];
    };
    SATA_PORT_HBA_t SATA_PORT_HBA_0 @ 0x50;
    SATA_PORT_HBA_t SATA_PORT_HBA_1 @ 0xD0;
    reg SATA_PORT_LINK_t {
        name = "SATA_PORT_LINK";
        desc = "SATA_PORT_LINK is a link test status register. (offset 0x54, 2 instances at stride 0x80; total reset 0x00202020; PROVEN: Hi3521A/Hi3520D V300 data sheet (Issue 00B07, 2015-12-10), section 13.6.7.2, PDF page 1623).";
        field {
            name = "reserved";
            desc = "Reserved";
            sw = r; hw = w;
            reset = 0x0;
        } reserved_31_29[31:29];
        field {
            name = "link_curr_st";
            desc = "Current status of the LINK_CTL_STATE state machine";
            sw = r; hw = w;
            reset = 0x0;
        } link_curr_st[28:24];
        field {
            name = "reserved";
            desc = "Reserved";
            sw = r; hw = w;
            reset = 0x0;
        } reserved_23_23[23:23];
        field {
            name = "link_df_fifo_full";
            desc = "Full flag of the link frequency difference FIFO
- 0: not full
- 1: full";
            sw = r; hw = w;
            reset = 0x0;
        } link_df_fifo_full[22:22];
        field {
            name = "link_df_fifo_empty";
            desc = "Empty flag of the link frequency difference FIFO
- 0: not empty
- 1: empty";
            sw = r; hw = w;
            reset = 0x1;
        } link_df_fifo_empty[21:21];
        field {
            name = "link_df_fifo_count";
            desc = "Data amount in the link frequency difference FIFO";
            sw = r; hw = w;
            reset = 0x0;
        } link_df_fifo_count[20:16];
        field {
            name = "reserved";
            desc = "Reserved";
            sw = r; hw = w;
            reset = 0x0;
        } reserved_15_15[15:15];
        field {
            name = "link_rx_fifo_full";
            desc = "Full flag of the link RX FIFO
- 0: not full
- 1: full";
            sw = r; hw = w;
            reset = 0x0;
        } link_rx_fifo_full[14:14];
        field {
            name = "link_rx_fifo_empty";
            desc = "Empty flag of the link RX FIFO
- 0: not empty
- 1: empty";
            sw = r; hw = w;
            reset = 0x1;
        } link_rx_fifo_empty[13:13];
        field {
            name = "link_rx_fifo_count";
            desc = "Data amount in the link RX FIFO";
            sw = r; hw = w;
            reset = 0x0;
        } link_rx_fifo_count[12:8];
        field {
            name = "reserved";
            desc = "Reserved";
            sw = r; hw = w;
            reset = 0x0;
        } reserved_7_7[7:7];
        field {
            name = "link_tx_fifo_full";
            desc = "Full flag of the link TX FIFO
- 0: not full
- 1: full";
            sw = r; hw = w;
            reset = 0x0;
        } link_tx_fifo_full[6:6];
        field {
            name = "link_tx_fifo_empty";
            desc = "Empty flag of the link TX FIFO
- 0: not empty
- 1: empty";
            sw = r; hw = w;
            reset = 0x1;
        } link_tx_fifo_empty[5:5];
        field {
            name = "link_tx_fifo_count";
            desc = "Data amount in the link TX FIFO";
            sw = r; hw = w;
            reset = 0x0;
        } link_tx_fifo_count[4:0];
    };
    SATA_PORT_LINK_t SATA_PORT_LINK_0 @ 0x54;
    SATA_PORT_LINK_t SATA_PORT_LINK_1 @ 0xD4;
    reg SATA_PORT_DMA1_t {
        name = "SATA_PORT_DMA1";
        desc = "SATA_PORT_DMA1 is DMAC test status register 1. (offset 0x58, 2 instances at stride 0x80; total reset 0x00000000; PROVEN: Hi3521A/Hi3520D V300 data sheet (Issue 00B07, 2015-12-10), section 13.6.7.2, PDF page 1625).";
        field {
            name = "reserved";
            desc = "Reserved";
            sw = r; hw = w;
            reset = 0x0;
        } reserved_31_28[31:28];
        field {
            name = "txdmac_cur_state";
            desc = "Current status of the SATA_TX_DMAC state machine";
            sw = r; hw = w;
            reset = 0x0;
        } txdmac_cur_state[27:24];
        field {
            name = "txdmac_prd_i";
            desc = "I bit in the entry of the PRD linked list of SATA_TX_DAMC";
            sw = r; hw = w;
            reset = 0x0;
        } txdmac_prd_i[23:23];
        field {
            name = "tx_entry_dbc_cnt";
            desc = "Down counter in SATA_TX_DMAC. It indicates the number of data bytes in the current entry.";
            sw = r; hw = w;
            reset = 0x0;
        } tx_entry_dbc_cnt[22:0];
    };
    SATA_PORT_DMA1_t SATA_PORT_DMA1_0 @ 0x58;
    SATA_PORT_DMA1_t SATA_PORT_DMA1_1 @ 0xD8;
    reg SATA_PORT_DMA2_t {
        name = "SATA_PORT_DMA2";
        desc = "SATA_PORT_DMA2 is DMAC test status register 2. (offset 0x5C, 2 instances at stride 0x80; total reset 0x00200000; PROVEN: Hi3521A/Hi3520D V300 data sheet (Issue 00B07, 2015-12-10), section 13.6.7.2, PDF page 1625).";
        field {
            name = "reserved";
            desc = "Reserved";
            sw = r; hw = w;
            reset = 0x0;
        } reserved_31_24[31:24];
        field {
            name = "tx_data_fis_cnt";
            desc = "Down counter in SATA_TX_DMAC. It indicates the number of data FIS bytes during the operation of PIO, legacy DMA, or first party DMA. For the PIO operation, the initial value is equal to the value of transcount in the PIO setup FIS; for the legacy DMA or first party DMA operation, the initial value is 0x2000 (2048 DWORD).";
            sw = r; hw = w;
            reset = 0x2000;
        } tx_data_fis_cnt[23:8];
        field {
            name = "tx_cmdh_prdtl";
            desc = "Down counter in SATA_TX_DMAC. The parameter in the command header indicates the number of entries in the PRDT.";
            sw = r; hw = w;
            reset = 0x0;
        } tx_cmdh_prdtl[7:0];
    };
    SATA_PORT_DMA2_t SATA_PORT_DMA2_0 @ 0x5C;
    SATA_PORT_DMA2_t SATA_PORT_DMA2_1 @ 0xDC;
    reg SATA_PORT_DMA3_t {
        name = "SATA_PORT_DMA3";
        desc = "SATA_PORT_DMA3 is DMAC test status register 3. (offset 0x60, 2 instances at stride 0x80; total reset 0x00000000; PROVEN: Hi3521A/Hi3520D V300 data sheet (Issue 00B07, 2015-12-10), section 13.6.7.2, PDF page 1626).";
        field {
            name = "tx_fpdma_tran_cnt";
            desc = "Down counter in SATA_TX_DMAC. It indicates the number of data FIS bytes during the first party DMA operation.";
            sw = r; hw = w;
            reset = 0x0;
        } tx_fpdma_tran_cnt[31:0];
    };
    SATA_PORT_DMA3_t SATA_PORT_DMA3_0 @ 0x60;
    SATA_PORT_DMA3_t SATA_PORT_DMA3_1 @ 0xE0;
    reg SATA_PORT_DMA4_t {
        name = "SATA_PORT_DMA4";
        desc = "SATA_PORT_DMA4 is DMAC test status register 4. (offset 0x64, 2 instances at stride 0x80; total reset 0x00000000; PROVEN: Hi3521A/Hi3520D V300 data sheet (Issue 00B07, 2015-12-10), section 13.6.7.2, PDF page 1626).";
        field {
            name = "reserved";
            desc = "Reserved";
            sw = r; hw = w;
            reset = 0x0;
        } reserved_31_28[31:28];
        field {
            name = "rxdmac_cur_state";
            desc = "Current status of the SATA_RX_DMAC state machine";
            sw = r; hw = w;
            reset = 0x0;
        } rxdmac_cur_state[27:24];
        field {
            name = "rxdmac_prd_i";
            desc = "I bit in the entry of the PRD linked list of SATA_RX_DAMC";
            sw = r; hw = w;
            reset = 0x0;
        } rxdmac_prd_i[23:23];
        field {
            name = "rx_entry_dbc_cnt";
            desc = "Down counter in SATA_RX_DMAC. It indicates the number of data bytes in the current entry.";
            sw = r; hw = w;
            reset = 0x0;
        } rx_entry_dbc_cnt[22:0];
    };
    SATA_PORT_DMA4_t SATA_PORT_DMA4_0 @ 0x64;
    SATA_PORT_DMA4_t SATA_PORT_DMA4_1 @ 0xE4;
    reg SATA_PORT_DMA5_t {
        name = "SATA_PORT_DMA5";
        desc = "SATA_PORT_DMA5 is DMAC test status register 5. (offset 0x68, 2 instances at stride 0x80; total reset 0x00200000; PROVEN: Hi3521A/Hi3520D V300 data sheet (Issue 00B07, 2015-12-10), section 13.6.7.2, PDF page 1627).";
        field {
            name = "reserved";
            desc = "Reserved";
            sw = r; hw = w;
            reset = 0x0;
        } reserved_31_24[31:24];
        field {
            name = "rx_data_fis_cnt";
            desc = "Down counter in SATA_RX_DMAC. It indicates the number of data FIS bytes during the operation of PIO, legacy DMA, or first party DMA. For the PIO operation, the initial value is equal to the value of transcount in the PIO setup FIS; for the legacy DMA or first party DMA operation, the initial value is 0x2000 (2048 DWORD).";
            sw = r; hw = w;
            reset = 0x2000;
        } rx_data_fis_cnt[23:8];
        field {
            name = "rx_cmdh_prdtl";
            desc = "Down counter in SATA_RX_DMAC. The parameter in the command header indicates the number of entries in the PRDT.";
            sw = r; hw = w;
            reset = 0x0;
        } rx_cmdh_prdtl[7:0];
    };
    SATA_PORT_DMA5_t SATA_PORT_DMA5_0 @ 0x68;
    SATA_PORT_DMA5_t SATA_PORT_DMA5_1 @ 0xE8;
    reg SATA_PORT_DMA6_t {
        name = "SATA_PORT_DMA6";
        desc = "SATA_PORT_DMA6 is DMAC test status register 6. (offset 0x6C, 2 instances at stride 0x80; total reset 0x00000000; PROVEN: Hi3521A/Hi3520D V300 data sheet (Issue 00B07, 2015-12-10), section 13.6.7.2, PDF page 1627).";
        field {
            name = "rx_fpdma_tran_cnt";
            desc = "Down counter in SATA_RX_DMAC. It indicates the number of data FIS bytes during the first party DMA operation. The initial value is equal to the value of transcount in the DMA setup FIS.";
            sw = r; hw = w;
            reset = 0x0;
        } rx_fpdma_tran_cnt[31:0];
    };
    SATA_PORT_DMA6_t SATA_PORT_DMA6_0 @ 0x6C;
    SATA_PORT_DMA6_t SATA_PORT_DMA6_1 @ 0xEC;
    reg SATA_PORT_DMA7_t {
        name = "SATA_PORT_DMA7";
        desc = "SATA_PORT_DMA7 is DMAC test status register 7. (offset 0x70, 2 instances at stride 0x80; total reset 0x00050000; PROVEN: Hi3521A/Hi3520D V300 data sheet (Issue 00B07, 2015-12-10), section 13.6.7.2, PDF page 1628).";
        field {
            name = "reserved";
            desc = "Reserved";
            sw = r; hw = w;
            reset = 0x0;
        } reserved_31_22[31:22];
        field {
            name = "pio_op";
            desc = "PIO operation indicator
- 0: The current command is not used for the PIO operation.
- 1: The current command is used for the PIO operation.";
            sw = r; hw = w;
            reset = 0x0;
        } pio_op[21:21];
        field {
            name = "fpdma_op";
            desc = "First party DMA operation indicator
- 0: The current command is not used for the first party DMA operation.
- 1: The current command is used for the first party DMA operation.";
            sw = r; hw = w;
            reset = 0x0;
        } fpdma_op[20:20];
        field {
            name = "dmac_rx_fifo_full";
            desc = "Full status of SATA_DMAC_RX_FIFO
- 0: not full
- 1: full";
            sw = r; hw = w;
            reset = 0x0;
        } dmac_rx_fifo_full[19:19];
        field {
            name = "dmac_rx_fifo_empty";
            desc = "Empty status of SATA_DMAC_RX_FIFO
- 0: not empty
- 1: empty";
            sw = r; hw = w;
            reset = 0x1;
        } dmac_rx_fifo_empty[18:18];
        field {
            name = "dmac_tx_fifo_full";
            desc = "Full status of SATA_DMAC_TX_FIFO
- 0: not full
- 1: full";
            sw = r; hw = w;
            reset = 0x0;
        } dmac_tx_fifo_full[17:17];
        field {
            name = "dmac_tx_fifo_empty";
            desc = "Empty status of SATA_DMAC_TX_FIFO
- 0: not empty
- 1: empty";
            sw = r; hw = w;
            reset = 0x1;
        } dmac_tx_fifo_empty[16:16];
        field {
            name = "dmac_rx_fifo_cnt";
            desc = "Number of data segments in SATA_DMAC_RX_FIFO (in DWORD)";
            sw = r; hw = w;
            reset = 0x0;
        } dmac_rx_fifo_cnt[15:8];
        field {
            name = "dmac_tx_fifo_cnt";
            desc = "Number of data segments in SATA_DMAC_TX_FIFO (in DWORD)";
            sw = r; hw = w;
            reset = 0x0;
        } dmac_tx_fifo_cnt[7:0];
    };
    SATA_PORT_DMA7_t SATA_PORT_DMA7_0 @ 0x70;
    SATA_PORT_DMA7_t SATA_PORT_DMA7_1 @ 0xF0;
    reg SATA_PORT_PHYCTL_t {
        name = "SATA_PORT_PHYCTL";
        desc = "SATA_PORT_PHYCTL is a PHY control register. (offset 0x74, 2 instances at stride 0x80; total reset 0x0E240000; PROVEN: Hi3521A/Hi3520D V300 data sheet (Issue 00B07, 2015-12-10), section 13.6.7.2, PDF page 1629).";
        field {
            name = "test_seq_sel";
            desc = "Test mode. Parameters are set to transmit various test sequences to test eye patterns.
- 001: The HFTP sequence is transmitted.
- 010: The MFTP sequence is transmitted.
- 100: The LFTP sequence is transmitted.
- 011: The LBP sequence is transmitted.";
            sw = rw; hw = r;
            reset = 0x0;
        } test_seq_sel[31:29];
        field {
            name = "phy_disable";
            desc = "PHY enable
- 0: enabled
- 1: disabled";
            sw = rw; hw = r;
            reset = 0x0;
        } phy_disable[28:28];
        field {
            name = "phy_calibrated";
            desc = "Whether to calibrate the PHY
- 0: not calibrated
- 1: calibrated";
            sw = rw; hw = r;
            reset = 0x1;
        } phy_calibrated[27:27];
        field {
            name = "spd_change_ack";
            desc = "Whether the rate can be switched
- 0: no
- 1: yes";
            sw = rw; hw = r;
            reset = 0x1;
        } spd_change_ack[26:26];
        field {
            name = "dp_rdy";
            desc = "Whether the PHY is ready to transmit data
- 0: no
- 1: yes";
            sw = rw; hw = r;
            reset = 0x1;
        } dp_rdy[25:25];
        field {
            name = "bist_tx_fspd";
            desc = "Whether the clock frequency is forcibly transmitted in BIST mode
- 0: no
- 1: yes";
            sw = rw; hw = r;
            reset = 0x0;
        } bist_tx_fspd[24:24];
        field {
            name = "neg_mode_b";
            desc = "Negotiation mode B select
- 0: not supported
- 1: supported";
            sw = rw; hw = r;
            reset = 0x0;
        } neg_mode_b[23:23];
        field {
            name = "gen2_en";
            desc = "Maximum interface rate control signal
- 00: 1.5 Gbit/s mode
- 01: 3 Gbit/s mode
- 10: 6 Gbit/s mode
- 11: reserved";
            sw = rw; hw = r;
            reset = 0x1;
        } gen2_en[22:21];
        field {
            name = "reserved";
            desc = "Reserved";
            sw = r; hw = w;
            reset = 0x10000;
        } reserved_20_2[20:2];
        field {
            name = "port_phy_ctrl_1";
            desc = "Rate mode select. This bit is valid only when the rate mode is controlled by software (port_phy_ctrl_0 is 1).
- 1: 1.5 Gbit/s mode
- 0: 3 Gbit/s mode";
            sw = rw; hw = r;
            reset = 0x0;
        } port_phy_ctrl_1[1:1];
        field {
            name = "port_phy_ctrl_0";
            desc = "Rate control mode
- 0: hardware automatic negotiation
- 1: software control";
            sw = rw; hw = r;
            reset = 0x0;
        } port_phy_ctrl_0[0:0];
    };
    SATA_PORT_PHYCTL_t SATA_PORT_PHYCTL_0 @ 0x74;
    SATA_PORT_PHYCTL_t SATA_PORT_PHYCTL_1 @ 0xF4;
    reg SATA_PORT_PHYSTS_t {
        name = "SATA_PORT_PHYSTS";
        desc = "SATA_PORT_PHYSTS is a PHY test status register. (offset 0x78, 2 instances at stride 0x80; total reset 0x00001883; PROVEN: Hi3521A/Hi3520D V300 data sheet (Issue 00B07, 2015-12-10), section 13.6.7.2, PDF page 1630).";
        field {
            name = "reserved";
            desc = "Reserved";
            sw = r; hw = w;
            reset = 0x0;
        } reserved_31_21[31:21];
        field {
            name = "current_state";
            desc = "Current status of the state machine at the PHY layer";
            sw = r; hw = w;
            reset = 0x0;
        } current_state[20:17];
        field {
            name = "spd_change";
            desc = "Rate change request";
            sw = r; hw = w;
            reset = 0x0;
        } spd_change[16:16];
        field {
            name = "link_rdy";
            desc = "Sufficient D10.2 is transmitted when this bit is 1.";
            sw = r; hw = w;
            reset = 0x0;
        } link_rdy[15:15];
        field {
            name = "init_compl";
            desc = "Non-align primitive is received and initialization is complete when this bit is 1.";
            sw = r; hw = w;
            reset = 0x0;
        } init_compl[14:14];
        field {
            name = "pwr_state";
            desc = "Whether the controller is in low-power (slumber or partial) status
- 1: yes
- 0: no";
            sw = r; hw = w;
            reset = 0x0;
        } pwr_state[13:13];
        field {
            name = "rx_pll_pwron";
            desc = "PHY RX PLL power-on indicator";
            sw = r; hw = w;
            reset = 0x1;
        } rx_pll_pwron[12:12];
        field {
            name = "rx_en";
            desc = "RX enable indicator
- 0x0: disabled
- 0x1: enabled";
            sw = r; hw = w;
            reset = 0x1;
        } rx_en[11:11];
        field {
            name = "tx_en";
            desc = "Required status of the PHY TX
- 000: idle status
- 001: low-power slumber status
- 010: low-power partial status
- 011: normal working status";
            sw = r; hw = w;
            reset = 0x0;
        } tx_en[10:8];
        field {
            name = "mpll_pwron";
            desc = "MPLL power-on indicator";
            sw = r; hw = w;
            reset = 0x1;
        } mpll_pwron[7:7];
        field {
            name = "phy_comwake";
            desc = "The PHY detects COMWAKE when this bit is 1.";
            sw = r; hw = w;
            reset = 0x0;
        } phy_comwake[6:6];
        field {
            name = "phy_cominit";
            desc = "The PHY detects COMINIT when this bit is 1.";
            sw = r; hw = w;
            reset = 0x0;
        } phy_cominit[5:5];
        field {
            name = "half_rate";
            desc = "Rate mode of the PHY
- 0: full-speed mode
- 1: half-speed mode";
            sw = r; hw = w;
            reset = 0x0;
        } half_rate[4:3];
        field {
            name = "phyrdy";
            desc = "The OOB phase and rate negotiation are complete at the link layer when this bit 1, and data can be normally transmitted currently.";
            sw = r; hw = w;
            reset = 0x0;
        } phyrdy[2:2];
        field {
            name = "los";
            desc = "Status of the RX differential line
- 0: Data is received on the RX differential line that is in normal operating status.
- 1: The RX differential line is in static idle status.";
            sw = r; hw = w;
            reset = 0x1;
        } los[1:1];
        field {
            name = "op_done";
            desc = "The PHY PLL is powered on when this bit is 1.";
            sw = r; hw = w;
            reset = 0x1;
        } op_done[0:0];
    };
    SATA_PORT_PHYSTS_t SATA_PORT_PHYSTS_0 @ 0x78;
    SATA_PORT_PHYSTS_t SATA_PORT_PHYSTS_1 @ 0xF8;
    reg SATA_PORT_OUTSTANDING_t {
        name = "SATA_PORT_OUTSTANDING";
        desc = "SATA_PORT_OUTSTANDING is an AXI outstanding control register. (offset 0x7C, 2 instances at stride 0x80; total reset 0x00000000; PROVEN: Hi3521A/Hi3520D V300 data sheet (Issue 00B07, 2015-12-10), section 13.6.7.2, PDF page 1632).";
        field {
            name = "reserved";
            desc = "Reserved";
            sw = r; hw = w;
            reset = 0x0;
        } reserved_31_10[31:10];
        field {
            name = "px_wr_otd_ctrl";
            desc = "Maximum outstanding capability during the write operation performed by the AXI master of each port
- 1111: outstanding of 16
- 0111: outstanding of 8
- 0011: outstanding of 4
- 0001: outstanding of 2
- 0000: outstanding of 1

Other values: reserved";
            sw = rw; hw = r;
            reset = 0x0;
        } px_wr_otd_ctrl[9:6];
        field {
            name = "px_rd_otd_ctrl";
            desc = "Maximum outstanding capability during the read operation performed by the AXI master of each port
- 1111: outstanding of 16
- 0111: outstanding of 8
- 0011: outstanding of 4
- 0001: outstanding of 2
- 0000: outstanding of 1

Other values: reserved";
            sw = rw; hw = r;
            reset = 0x0;
        } px_rd_otd_ctrl[5:2];
        field {
            name = "px_wr_otd_en";
            desc = "Whether to control the maximum outstanding capability during the write operation performed by the AXI master of each port
- 0: no
- 1: yes";
            sw = rw; hw = r;
            reset = 0x0;
        } px_wr_otd_en[1:1];
        field {
            name = "px_rd_otd_en";
            desc = "Whether to control the maximum outstanding capability during the read operation performed by the AXI master of each port
- 0: no
- 1: yes";
            sw = rw; hw = r;
            reset = 0x0;
        } px_rd_otd_en[0:0];
    };
    SATA_PORT_OUTSTANDING_t SATA_PORT_OUTSTANDING_0 @ 0x7C;
    SATA_PORT_OUTSTANDING_t SATA_PORT_OUTSTANDING_1 @ 0xFC;
};
`endif
