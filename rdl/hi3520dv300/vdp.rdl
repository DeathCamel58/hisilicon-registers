`ifndef HI3520DV300_VDP_RDL
`define HI3520DV300_VDP_RDL
regfile eHI3520DV300_VDP {
    name = "Video display processor (VDP)";
    desc = "Video display processor (VDP) of the Hi3521A/Hi3520D V300 at base 0x1302_0000. 219 registers extracted programmatically from the Hi3521A/Hi3520D V300 data sheet (Issue 00B07, 2015-12-10) (Table 10-6 Summary of VDP registers (base address: 0x1302_0000)): register headings, offsets, total reset values, field bit ranges, access types, names, reset values and descriptions, with PDF page numbers in each register description. Field names, bit ranges, access types and offsets are exact; the free-text descriptions are taken from the cell text of the field table and were checked by sampling only. Hardware not verified.";
    reg {
        name = "VOCTRL";
        desc = "VOCTRL is a VO control register. It is used to configure the arbitration mode of surface bus requests. (offset 0x0; total reset 0x00000000; PROVEN: Hi3521A/Hi3520D V300 data sheet (Issue 00B07, 2015-12-10), section 10.2.7, PDF page 1262).";
        field {
            name = "vo_ck_gt_en";
            desc = "VDP clock gating enable
- 0: disabled
- 1: enabled";
            sw = rw; hw = r;
            reset = 0x0;
        } vo_ck_gt_en[31:31];
        field {
            name = "chk_sum_en";
            desc = "Checksum enable
- 0: disabled
- 1: enabled";
            sw = rw; hw = r;
            reset = 0x0;
        } chk_sum_en[30:30];
        field {
            name = "reserved";
            desc = "Reserved";
            sw = r; hw = w;
            reset = 0x0;
        } reserved_29_4[29:4];
        field {
            name = "m0_arb_mode";
            desc = "Arbitration mode of internal surface bus data requests of VO MAC0
- 0000: The polling mode is used.
- 0001: The graphics layer takes priority.

Other values: reserved";
            sw = rw; hw = r;
            reset = 0x0;
        } m0_arb_mode[3:0];
    } VOCTRL @ 0x0;
    reg {
        name = "VOINTSTA";
        desc = "VOINTSTA is a VO interrupt status register (read-only). (offset 0x4; total reset 0x00000044; PROVEN: Hi3521A/Hi3520D V300 data sheet (Issue 00B07, 2015-12-10), section 10.2.7, PDF page 1263). INFERRED: the field table prints bit 20 as v4rr_int and bit 19 as v3rr_int while the descriptions say V3 and V1; the names follow the descriptions and the bit diagram (v4rr, v3rr, v1rr).";
        field {
            name = "reserved";
            desc = "Reserved";
            sw = r; hw = w;
            reset = 0x0;
        } reserved_31_31[31:31];
        field {
            name = "m0_be_int";
            desc = "AXI master 0 bus error interrupt
- 0: No interrupt is generated.
- 1: An interrupt is generated.";
            sw = r; hw = w;
            reset = 0x0;
        } m0_be_int[30:30];
        field {
            name = "reserved";
            desc = "Reserved";
            sw = r; hw = w;
            reset = 0x0;
        } reserved_29_27[29:27];
        field {
            name = "g4rr_int";
            desc = "G4 register update interrupt
- 0: No interrupt is generated.
- 1: An interrupt is generated.";
            sw = r; hw = w;
            reset = 0x0;
        } g4rr_int[26:26];
        field {
            name = "reserved";
            desc = "Reserved";
            sw = r; hw = w;
            reset = 0x0;
        } reserved_25_25[25:25];
        field {
            name = "g2rr_int";
            desc = "G2 register update interrupt
- 0: No interrupt is generated.
- 1: An interrupt is generated.";
            sw = r; hw = w;
            reset = 0x0;
        } g2rr_int[24:24];
        field {
            name = "g1rr_int";
            desc = "G1 register update interrupt
- 0: No interrupt is generated.
- 1: An interrupt is generated.";
            sw = r; hw = w;
            reset = 0x0;
        } g1rr_int[23:23];
        field {
            name = "reserved";
            desc = "Reserved";
            sw = r; hw = w;
            reset = 0x0;
        } reserved_22_22[22:22];
        field {
            name = "v4rr_int";
            desc = "V4 register update interrupt
- 0: No interrupt is generated.
- 1: An interrupt is generated.";
            sw = r; hw = w;
            reset = 0x0;
        } v4rr_int[21:21];
        field {
            name = "v3rr_int";
            desc = "V3 register update interrupt
- 0: No interrupt is generated.
- 1: An interrupt is generated.";
            sw = r; hw = w;
            reset = 0x0;
        } v3rr_int[20:20];
        field {
            name = "v1rr_int";
            desc = "V1 register update interrupt
- 0: No interrupt is generated.
- 1: An interrupt is generated.";
            sw = r; hw = w;
            reset = 0x0;
        } v1rr_int[19:19];
        field {
            name = "reserved";
            desc = "Reserved";
            sw = r; hw = w;
            reset = 0x0;
        } reserved_18_18[18:18];
        field {
            name = "dsd0uf_int";
            desc = "SD low-bandwidth alarm interrupt
- 0: No interrupt is generated.
- 1: An interrupt is generated.";
            sw = r; hw = w;
            reset = 0x0;
        } dsd0uf_int[17:17];
        field {
            name = "dsd0vtthd1_int";
            desc = "SD vertical timing interrupt 1
- 0: No interrupt is generated.
- 1: An interrupt is generated.";
            sw = r; hw = w;
            reset = 0x0;
        } dsd0vtthd1_int[16:16];
        field {
            name = "vdac3_unload_int";
            desc = "VDAC3 offload interrupt
- 0: No interrupt is generated.
- 1: An interrupt is generated.";
            sw = r; hw = w;
            reset = 0x0;
        } vdac3_unload_int[15:15];
        field {
            name = "vdac2_unload_int";
            desc = "VDAC2 offload interrupt
- 0: No interrupt is generated.
- 1: An interrupt is generated.";
            sw = r; hw = w;
            reset = 0x0;
        } vdac2_unload_int[14:14];
        field {
            name = "vdac1_unload_int";
            desc = "VDAC1 offload interrupt
- 0: No interrupt is generated.
- 1: An interrupt is generated.";
            sw = r; hw = w;
            reset = 0x0;
        } vdac1_unload_int[13:13];
        field {
            name = "vdac0_unload_int";
            desc = "VDAC0 offload interrupt
- 0: No interrupt is generated.
- 1: An interrupt is generated.";
            sw = r; hw = w;
            reset = 0x0;
        } vdac0_unload_int[12:12];
        field {
            name = "reserved";
            desc = "Reserved";
            sw = r; hw = w;
            reset = 0x0;
        } reserved_11_10[11:10];
        field {
            name = "dwbc0_vte_int";
            desc = "DWBC0 task completion interrupt
- 0: No interrupt is generated.
- 1: An interrupt is generated.";
            sw = r; hw = w;
            reset = 0x0;
        } dwbc0_vte_int[9:9];
        field {
            name = "reserved";
            desc = "Reserved";
            sw = r; hw = w;
            reset = 0x0;
        } reserved_8_8[8:8];
        field {
            name = "dhd1uf_int";
            desc = "HD1 low-bandwidth alarm interrupt
- 0: No interrupt is generated.
- 1: An interrupt is generated.";
            sw = r; hw = w;
            reset = 0x0;
        } dhd1uf_int[7:7];
        field {
            name = "dhd1vtthd3_int";
            desc = "HD1 vertical timing interrupt 3
- 0: No interrupt is generated.
- 1: An interrupt is generated.";
            sw = r; hw = w;
            reset = 0x1;
        } dhd1vtthd3_int[6:6];
        field {
            name = "dhd1vtthd2_int";
            desc = "HD1 vertical timing interrupt 2
- 0: No interrupt is generated.
- 1: An interrupt is generated.";
            sw = r; hw = w;
            reset = 0x0;
        } dhd1vtthd2_int[5:5];
        field {
            name = "dhd1vtthd1_int";
            desc = "HD1 vertical timing interrupt 1
- 0: No interrupt is generated.
- 1: An interrupt is generated.";
            sw = r; hw = w;
            reset = 0x0;
        } dhd1vtthd1_int[4:4];
        field {
            name = "reserved";
            desc = "Reserved";
            sw = r; hw = w;
            reset = 0x4;
        } reserved_3_0[3:0];
    } VOINTSTA @ 0x4;
    reg {
        name = "VOMSKINTSTA";
        desc = "VOMSKINTSTA is a VO masked interrupt status register. Writing 1 clears this register. (offset 0x8; total reset 0x00000000; PROVEN: Hi3521A/Hi3520D V300 data sheet (Issue 00B07, 2015-12-10), section 10.2.7, PDF page 1265). INFERRED: the field table prints bit 20 as v4rr_clr and bit 19 as v3rr_clr while the descriptions say V3 and V1; the names follow the descriptions and the bit diagram (v4rr, v3rr, v1rr).";
        field {
            name = "reserved";
            desc = "Reserved";
            sw = r; hw = w;
            reset = 0x0;
        } reserved_31_31[31:31];
        field {
            name = "m0_be_clr";
            desc = "AXI master 0 bus error interrupt
- 0: The interrupt is not cleared.
- 1: The interrupt is cleared.

Access type WC in the data sheet: written 1 clears the bit.";
            sw = rw; hw = w; onwrite = woclr;
            reset = 0x0;
        } m0_be_clr[30:30];
        field {
            name = "reserved";
            desc = "Reserved";
            sw = r; hw = w;
            reset = 0x0;
        } reserved_29_27[29:27];
        field {
            name = "g4rr_clr";
            desc = "G4 register update interrupt
- 0: The interrupt is not cleared.
- 1: The interrupt is cleared.

Access type WC in the data sheet: written 1 clears the bit.";
            sw = rw; hw = w; onwrite = woclr;
            reset = 0x0;
        } g4rr_clr[26:26];
        field {
            name = "reserved";
            desc = "Reserved";
            sw = r; hw = w;
            reset = 0x0;
        } reserved_25_25[25:25];
        field {
            name = "g2rr_clr";
            desc = "G2 register update interrupt
- 0: The interrupt is not cleared.
- 1: The interrupt is cleared.

Access type WC in the data sheet: written 1 clears the bit.";
            sw = rw; hw = w; onwrite = woclr;
            reset = 0x0;
        } g2rr_clr[24:24];
        field {
            name = "g1rr_clr";
            desc = "G1 register update interrupt
- 0: The interrupt is not cleared.
- 1: The interrupt is cleared.

Access type WC in the data sheet: written 1 clears the bit.";
            sw = rw; hw = w; onwrite = woclr;
            reset = 0x0;
        } g1rr_clr[23:23];
        field {
            name = "reserved";
            desc = "Reserved";
            sw = r; hw = w;
            reset = 0x0;
        } reserved_22_22[22:22];
        field {
            name = "v4rr_clr";
            desc = "V4 register update interrupt
- 0: The interrupt is not cleared.
- 1: The interrupt is cleared.

Access type WC in the data sheet: written 1 clears the bit.";
            sw = rw; hw = w; onwrite = woclr;
            reset = 0x0;
        } v4rr_clr[21:21];
        field {
            name = "v3rr_clr";
            desc = "V3 register update interrupt
- 0: The interrupt is not cleared.
- 1: The interrupt is cleared.

Access type WC in the data sheet: written 1 clears the bit.";
            sw = rw; hw = w; onwrite = woclr;
            reset = 0x0;
        } v3rr_clr[20:20];
        field {
            name = "v1rr_clr";
            desc = "V1 register update interrupt
- 0: The interrupt is not cleared.
- 1: The interrupt is cleared.

Access type WC in the data sheet: written 1 clears the bit.";
            sw = rw; hw = w; onwrite = woclr;
            reset = 0x0;
        } v1rr_clr[19:19];
        field {
            name = "reserved";
            desc = "Reserved";
            sw = r; hw = w;
            reset = 0x0;
        } reserved_18_18[18:18];
        field {
            name = "dsd0uf_clr";
            desc = "SD low-bandwidth alarm interrupt
- 0: The interrupt is not cleared.
- 1: The interrupt is cleared.";
            sw = r; hw = w;
            reset = 0x0;
        } dsd0uf_clr[17:17];
        field {
            name = "dsd0vtthd1_clr";
            desc = "SD vertical timing interrupt 1
- 0: The interrupt is not cleared.
- 1: The interrupt is cleared.";
            sw = r; hw = w;
            reset = 0x0;
        } dsd0vtthd1_clr[16:16];
        field {
            name = "vdac3_unload_int";
            desc = "VDAC3 offload interrupt
- 0: The interrupt is not cleared.
- 1: The interrupt is cleared.";
            sw = r; hw = w;
            reset = 0x0;
        } vdac3_unload_int[15:15];
        field {
            name = "vdac2_unload_int";
            desc = "VDAC2 offload interrupt
- 0: The interrupt is not cleared.
- 1: The interrupt is cleared.";
            sw = r; hw = w;
            reset = 0x0;
        } vdac2_unload_int[14:14];
        field {
            name = "vdac1_unload_int";
            desc = "VDAC1 offload interrupt
- 0: The interrupt is not cleared.
- 1: The interrupt is cleared.";
            sw = r; hw = w;
            reset = 0x0;
        } vdac1_unload_int[13:13];
        field {
            name = "vdac0_unload_int";
            desc = "VDAC0 offload interrupt
- 0: The interrupt is not cleared.
- 1: The interrupt is cleared.";
            sw = r; hw = w;
            reset = 0x0;
        } vdac0_unload_int[12:12];
        field {
            name = "g4wbc_vte_clr";
            desc = "G4 WBC task completion interrupt
- 0: The interrupt is not cleared.
- 1: The interrupt is cleared.";
            sw = r; hw = w;
            reset = 0x0;
        } g4wbc_vte_clr[11:11];
        field {
            name = "g0wbc_vte_clr";
            desc = "G0 WBC task completion interrupt
- 0: The interrupt is not cleared.
- 1: The interrupt is cleared.";
            sw = r; hw = w;
            reset = 0x0;
        } g0wbc_vte_clr[10:10];
        field {
            name = "dwbc0_vte_clr";
            desc = "DWBC0 task completion interrupt
- 0: The interrupt is not cleared.
- 1: The interrupt is cleared.

Access type WC in the data sheet: written 1 clears the bit.";
            sw = rw; hw = w; onwrite = woclr;
            reset = 0x0;
        } dwbc0_vte_clr[9:9];
        field {
            name = "reserved";
            desc = "Reserved";
            sw = r; hw = w;
            reset = 0x0;
        } reserved_8_8[8:8];
        field {
            name = "dhd1uf_clr";
            desc = "HD1 low-bandwidth alarm interrupt
- 0: The interrupt is not cleared.
- 1: The interrupt is cleared.

Access type WC in the data sheet: written 1 clears the bit.";
            sw = rw; hw = w; onwrite = woclr;
            reset = 0x0;
        } dhd1uf_clr[7:7];
        field {
            name = "dhd1vtthd3_clr";
            desc = "HD1 vertical timing interrupt 3
- 0: The interrupt is not cleared.
- 1: The interrupt is cleared.

Access type WC in the data sheet: written 1 clears the bit.";
            sw = rw; hw = w; onwrite = woclr;
            reset = 0x0;
        } dhd1vtthd3_clr[6:6];
        field {
            name = "dhd1vtthd2_clr";
            desc = "HD1 vertical timing interrupt 2
- 0: The interrupt is not cleared.
- 1: The interrupt is cleared.

Access type WC in the data sheet: written 1 clears the bit.";
            sw = rw; hw = w; onwrite = woclr;
            reset = 0x0;
        } dhd1vtthd2_clr[5:5];
        field {
            name = "dhd1vtthd1_clr";
            desc = "HD1 vertical timing interrupt 1
- 0: The interrupt is not cleared.
- 1: The interrupt is cleared.

Access type WC in the data sheet: written 1 clears the bit.";
            sw = rw; hw = w; onwrite = woclr;
            reset = 0x0;
        } dhd1vtthd1_clr[4:4];
        field {
            name = "reserved";
            desc = "Reserved";
            sw = r; hw = w;
            reset = 0x0;
        } reserved_3_0[3:0];
    } VOMSKINTSTA @ 0x8;
    reg {
        name = "VOINTMSK";
        desc = "VOINTMSK is a VDP interrupt mask register. It corresponds to VOINTSTA. When the corresponding bit is set to 1, the interrupt is enabled; when the corresponding bit is set to 0, the interrupt is masked. (offset 0xC; total reset 0x00000000; PROVEN: Hi3521A/Hi3520D V300 data sheet (Issue 00B07, 2015-12-10), section 10.2.7, PDF page 1267).";
        field {
            name = "reserved";
            desc = "Reserved";
            sw = r; hw = w;
            reset = 0x0;
        } reserved_31_31[31:31];
        field {
            name = "m0_be_intmsk";
            desc = "AXI master 0 bus error interrupt
- 0: masked
- 1: enabled";
            sw = rw; hw = r;
            reset = 0x0;
        } m0_be_intmsk[30:30];
        field {
            name = "reserved";
            desc = "Reserved";
            sw = r; hw = w;
            reset = 0x0;
        } reserved_29_27[29:27];
        field {
            name = "g4rr_intmsk";
            desc = "G4 register update interrupt
- 0: masked
- 1: enabled";
            sw = rw; hw = r;
            reset = 0x0;
        } g4rr_intmsk[26:26];
        field {
            name = "reserved";
            desc = "Reserved";
            sw = r; hw = w;
            reset = 0x0;
        } reserved_25_25[25:25];
        field {
            name = "g2rr_intmsk";
            desc = "G2 register update interrupt
- 0: masked
- 1: enabled";
            sw = rw; hw = r;
            reset = 0x0;
        } g2rr_intmsk[24:24];
        field {
            name = "g1rr_intmsk";
            desc = "G1 register update interrupt
- 0: masked
- 1: enabled";
            sw = rw; hw = r;
            reset = 0x0;
        } g1rr_intmsk[23:23];
        field {
            name = "reserved";
            desc = "Reserved";
            sw = r; hw = w;
            reset = 0x0;
        } reserved_22_22[22:22];
        field {
            name = "v4rr_intmsk";
            desc = "V4 register update interrupt
- 0: masked
- 1: enabled";
            sw = rw; hw = r;
            reset = 0x0;
        } v4rr_intmsk[21:21];
        field {
            name = "v3rr_intmsk";
            desc = "V3 register update interrupt
- 0: masked
- 1: enabled";
            sw = rw; hw = r;
            reset = 0x0;
        } v3rr_intmsk[20:20];
        field {
            name = "v1rr_intmsk";
            desc = "V1 register update interrupt
- 0: masked
- 1: enabled";
            sw = rw; hw = r;
            reset = 0x0;
        } v1rr_intmsk[19:19];
        field {
            name = "reserved";
            desc = "Reserved";
            sw = r; hw = w;
            reset = 0x0;
        } reserved_18_18[18:18];
        field {
            name = "dsd0uf_intmsk";
            desc = "SD low-bandwidth alarm interrupt
- 0: masked
- 1: enabled";
            sw = r; hw = w;
            reset = 0x0;
        } dsd0uf_intmsk[17:17];
        field {
            name = "dsd0vtthd1_intmsk";
            desc = "SD vertical timing interrupt 1
- 0: masked
- 1: enabled";
            sw = r; hw = w;
            reset = 0x0;
        } dsd0vtthd1_intmsk[16:16];
        field {
            name = "vdac3_unload_intmsk";
            desc = "VDAC3 offload interrupt
- 0: masked
- 1: enabled";
            sw = rw; hw = r;
            reset = 0x0;
        } vdac3_unload_intmsk[15:15];
        field {
            name = "vdac2_unload_intmsk";
            desc = "VDAC2 offload interrupt
- 0: masked
- 1: enabled";
            sw = rw; hw = r;
            reset = 0x0;
        } vdac2_unload_intmsk[14:14];
        field {
            name = "vdac1_unload_intmsk";
            desc = "VDAC1 offload interrupt
- 0: masked
- 1: enabled";
            sw = rw; hw = r;
            reset = 0x0;
        } vdac1_unload_intmsk[13:13];
        field {
            name = "vdac0_unload_intmsk";
            desc = "VDAC0 offload interrupt
- 0: masked
- 1: enabled";
            sw = rw; hw = r;
            reset = 0x0;
        } vdac0_unload_intmsk[12:12];
        field {
            name = "g4wbc_vte_intmsk";
            desc = "G4 WBC task completion interrupt
- 0: No interrupt is generated.
- 1: An interrupt is generated.";
            sw = rw; hw = r;
            reset = 0x0;
        } g4wbc_vte_intmsk[11:11];
        field {
            name = "g0wbc_vte_intmsk";
            desc = "G0 WBC task completion interrupt
- 0: No interrupt is generated.
- 1: An interrupt is generated.";
            sw = rw; hw = r;
            reset = 0x0;
        } g0wbc_vte_intmsk[10:10];
        field {
            name = "dwbc0_vte_intmsk";
            desc = "DWBC task completion interrupt
- 0: masked
- 1: enabled";
            sw = rw; hw = r;
            reset = 0x0;
        } dwbc0_vte_intmsk[9:9];
        field {
            name = "reserved";
            desc = "Reserved";
            sw = r; hw = w;
            reset = 0x0;
        } reserved_8_8[8:8];
        field {
            name = "dhd1uf_intmsk";
            desc = "HD1 low-bandwidth alarm interrupt
- 0: masked
- 1: enabled";
            sw = rw; hw = r;
            reset = 0x0;
        } dhd1uf_intmsk[7:7];
        field {
            name = "dhd1vtthd3_intmsk";
            desc = "HD1 vertical timing interrupt 3
- 0: masked
- 1: enabled";
            sw = rw; hw = r;
            reset = 0x0;
        } dhd1vtthd3_intmsk[6:6];
        field {
            name = "dhd1vtthd2_intmsk";
            desc = "HD1 vertical timing interrupt 2
- 0: masked
- 1: enabled";
            sw = rw; hw = r;
            reset = 0x0;
        } dhd1vtthd2_intmsk[5:5];
        field {
            name = "dhd1vtthd1_intmsk";
            desc = "HD1 vertical timing interrupt 1
- 0: masked
- 1: enabled";
            sw = rw; hw = r;
            reset = 0x0;
        } dhd1vtthd1_intmsk[4:4];
        field {
            name = "reserved";
            desc = "Reserved";
            sw = r; hw = w;
            reset = 0x0;
        } reserved_3_0[3:0];
    } VOINTMSK @ 0xC;
    reg {
        name = "VDPVERSION1";
        desc = "VDPVERSION1 is VDP version register 1. (offset 0x10; total reset 0x76756F76; PROVEN: Hi3521A/Hi3520D V300 data sheet (Issue 00B07, 2015-12-10), section 10.2.7, PDF page 1269).";
        field {
            name = "vdpversion1";
            desc = "VDP version register 1";
            sw = r; hw = w;
            reset = 0x76756f76;
        } vdpversion1[31:0];
    } VDPVERSION1 @ 0x10;
    reg {
        name = "VDPVERSION2";
        desc = "VDPVERSION2 is VDP version register 2. (offset 0x14; total reset 0x30313134; PROVEN: Hi3521A/Hi3520D V300 data sheet (Issue 00B07, 2015-12-10), section 10.2.7, PDF page 1270).";
        field {
            name = "vdpversion2";
            desc = "VDP version register 2";
            sw = r; hw = w;
            reset = 0x30313134;
        } vdpversion2[31:0];
    } VDPVERSION2 @ 0x14;
    reg {
        name = "VOAXICTRL";
        desc = "VOAXICTRL is a VO AXI bus configuration register. (offset 0x34; total reset 0x01110111; PROVEN: Hi3521A/Hi3520D V300 data sheet (Issue 00B07, 2015-12-10), section 10.2.7, PDF page 1270).";
        field {
            name = "reserved";
            desc = "Reserved";
            sw = r; hw = w;
            reset = 0x111;
        } reserved_31_16[31:16];
        field {
            name = "m0_id_sel";
            desc = "AXI master 0 multi-ID enable
- 0: disabled
- 1: enabled";
            sw = rw; hw = r;
            reset = 0x0;
        } m0_id_sel[15:15];
        field {
            name = "reserved";
            desc = "Reserved";
            sw = r; hw = w;
            reset = 0x0;
        } reserved_14_12[14:12];
        field {
            name = "m0_wr_ostd";
            desc = "Write ID outstanding of AXI master 0. The value ranges from 1 to 15.";
            sw = rw; hw = r;
            reset = 0x1;
        } m0_wr_ostd[11:8];
        field {
            name = "m0_outstd_rid1";
            desc = "Read ID 1 outstanding of AXI master 0. The value ranges from 1 to 15.";
            sw = rw; hw = r;
            reset = 0x1;
        } m0_outstd_rid1[7:4];
        field {
            name = "m0_outstd_rid0";
            desc = "Read ID 0 outstanding of AXI master 0. The value ranges from 1 to 15.";
            sw = rw; hw = r;
            reset = 0x1;
        } m0_outstd_rid0[3:0];
    } VOAXICTRL @ 0x34;
    reg {
        name = "VO_MUX";
        desc = "VO_MUX is a VO interface multiplexing register. (offset 0x100; total reset 0x00000100; PROVEN: Hi3521A/Hi3520D V300 data sheet (Issue 00B07, 2015-12-10), section 10.2.7, PDF page 1271).";
        field {
            name = "reserved";
            desc = "Reserved";
            sw = r; hw = w;
            reset = 0x0;
        } reserved_31_16[31:16];
        field {
            name = "hdmi_sel";
            desc = "HDMI data select
- 0: reserved
- 1: DHD1 HDMI";
            sw = rw; hw = r;
            reset = 0x0;
        } hdmi_sel[15:12];
        field {
            name = "vga_sel";
            desc = "VGA data select
- 0: reserved
- 1: DHD1 VGA";
            sw = rw; hw = r;
            reset = 0x1;
        } vga_sel[11:8];
        field {
            name = "reserved";
            desc = "Reserved";
            sw = r; hw = w;
            reset = 0x0;
        } reserved_7_4[7:4];
        field {
            name = "sddate_sel";
            desc = "SDDATE data select. The default value is 4.
- 4: DSD0 SDDATE

Other values: reserved";
            sw = rw; hw = r;
            reset = 0x0;
        } sddate_sel[3:0];
    } VO_MUX @ 0x100;
    reg {
        name = "VO_MUX_DAC";
        desc = "VO_MUX_DAC is a VO DAC interface multiplexing register. (offset 0x104; total reset 0x00000987; PROVEN: Hi3521A/Hi3520D V300 data sheet (Issue 00B07, 2015-12-10), section 10.2.7, PDF page 1271).";
        field {
            name = "reserved";
            desc = "Reserved";
            sw = r; hw = w;
            reset = 0x0;
        } reserved_31_16[31:16];
        field {
            name = "dac3_sel";
            desc = "DAC3 output select. The default value is 0x0.
- 0x0: CVBS video (SDATE)
- 0x1: SD analog video Y/R component (SDATE)
- 0x2: SD analog video Cb/G component (SDATE)
- 0x3: SD analog video Cr/B component (SDATE)
- 0x4: HD analog video Y/R component (HDATE)
- 0x5: HD analog video Cb/G component (HDATE)
- 0x6: HD analog video Cr/B component (HDATE)
- 0x7: VGA video R component
- 0x8: VGA video G component
- 0x9: VGA video B component

Other values: reserved";
            sw = rw; hw = r;
            reset = 0x0;
        } dac3_sel[15:12];
        field {
            name = "dac2_sel";
            desc = "DAC2 output select. The default value is 0x0.
- 0x0: CVBS video (SDATE)
- 0x1: SD analog video Y/R component (SDATE)
- 0x2: SD analog video Cb/G component (SDATE)
- 0x3: SD analog video Cr/B component (SDATE)
- 0x4: HD analog video Y/R component (HDATE)
- 0x5: HD analog video Cb/G component (HDATE)
- 0x6: HD analog video Cr/B component (HDATE)
- 0x7: VGA video R component
- 0x8: VGA video G component
- 0x9: VGA video B component

Other values: reserved";
            sw = rw; hw = r;
            reset = 0x9;
        } dac2_sel[11:8];
        field {
            name = "dac1_sel";
            desc = "DAC1 output select. The default value is 0x0.
- 0x0: CVBS video (SDATE)
- 0x1: SD analog video Y/R component (SDATE)
- 0x2: SD analog video Cb/G component (SDATE)
- 0x3: SD analog video Cr/B component (SDATE)
- 0x4: HD analog video Y/R component (HDATE)
- 0x5: HD analog video Cb/G component (HDATE)
- 0x6: HD analog video Cr/B component (HDATE)
- 0x7: VGA video R component
- 0x8: VGA video G component
- 0x9: VGA video B component";
            sw = rw; hw = r;
            reset = 0x8;
        } dac1_sel[7:4];
        field {
            name = "dac0_sel";
            desc = "DAC0 output select. The default value is 0x0.
- 0x0: CVBS video (SDATE)
- 0x1: SD analog video Y/R component (SDATE)
- 0x2: SD analog video Cb/G component (SDATE)
- 0x3: SD analog video Cr/B component (SDATE)
- 0x4: HD analog video Y/R component (HDATE)
- 0x5: HD analog video Cb/G component (HDATE)
- 0x6: HD analog video Cr/B component (HDATE)
- 0x7: VGA video R component
- 0x8: VGA video G component
- 0x9: VGA video B component";
            sw = rw; hw = r;
            reset = 0x7;
        } dac0_sel[3:0];
    } VO_MUX_DAC @ 0x104;
    reg {
        name = "VO_MUX_TESTSYNC";
        desc = "VO_MUX_TESTSYNC is a VO interface test register. (offset 0x108; total reset 0x00000000; PROVEN: Hi3521A/Hi3520D V300 data sheet (Issue 00B07, 2015-12-10), section 10.2.7, PDF page 1273).";
        field {
            name = "vo_test_en";
            desc = "VDP output interface test mode enable
- 0: disabled
- 1: enabled";
            sw = rw; hw = r;
            reset = 0x0;
        } vo_test_en[31:31];
        field {
            name = "reserved";
            desc = "Reserved";
            sw = r; hw = w;
            reset = 0x0;
        } reserved_30_4[30:4];
        field {
            name = "test_field";
            desc = "Test value of the field signal";
            sw = rw; hw = r;
            reset = 0x0;
        } test_field[3:3];
        field {
            name = "test_vsync";
            desc = "Test value of the vsync signal";
            sw = rw; hw = r;
            reset = 0x0;
        } test_vsync[2:2];
        field {
            name = "test_hsync";
            desc = "Test value of the hsync signal";
            sw = rw; hw = r;
            reset = 0x0;
        } test_hsync[1:1];
        field {
            name = "test_dv";
            desc = "Test value of the dv signal";
            sw = rw; hw = r;
            reset = 0x0;
        } test_dv[0:0];
    } VO_MUX_TESTSYNC @ 0x108;
    reg {
        name = "VO_MUX_TESTDATA";
        desc = "VO_MUX_TESTDATA is a VO interface test data register. (offset 0x10C; total reset 0x00000000; PROVEN: Hi3521A/Hi3520D V300 data sheet (Issue 00B07, 2015-12-10), section 10.2.7, PDF page 1274).";
        field {
            name = "reserved";
            desc = "Reserved";
            sw = r; hw = w;
            reset = 0x0;
        } reserved_31_30[31:30];
        field {
            name = "test_data";
            desc = "Output data in test mode The output of DAC0-3 channels is the lower 10 bits of the register value, the output of the BT.1120 channel is the lower 16 bits of the register value, the output of the LCD channel is bits 29-22, 19-12, and 9-2 of the register, and the output of other channels is the register value. The output is in the RGB or YUV format from upper bits to lower bits.";
            sw = rw; hw = r;
            reset = 0x0;
        } test_data[29:0];
    } VO_MUX_TESTDATA @ 0x10C;
    reg {
        name = "VO_DAC_CTRL";
        desc = "VO_DAC_CTRL is a VO DAC control register. (offset 0x120; total reset 0x00000000; PROVEN: Hi3521A/Hi3520D V300 data sheet (Issue 00B07, 2015-12-10), section 10.2.7, PDF page 1274).";
        field {
            name = "reserved";
            desc = "Reserved";
            sw = r; hw = w;
            reset = 0x0;
        } reserved_31_23[31:23];
        field {
            name = "envbg";
            desc = "VBG reference voltage enable
- 0: disabled
- 1: enabled";
            sw = rw; hw = r;
            reset = 0x0;
        } envbg[22:22];
        field {
            name = "pdchopper";
            desc = "VBG chopper enable
- 0: enabled
- 1: disabled";
            sw = rw; hw = r;
            reset = 0x0;
        } pdchopper[21:21];
        field {
            name = "enextref";
            desc = "VBG output test enable
- 0: The internal VBG is used. The VBG is not output to the test pin.
- 1: The VBG is output for external tests.";
            sw = rw; hw = r;
            reset = 0x0;
        } enextref[20:20];
        field {
            name = "reserved";
            desc = "Reserved";
            sw = r; hw = w;
            reset = 0x0;
        } reserved_19_16[19:16];
        field {
            name = "dac_reg_rev";
            desc = "The test is reserved.";
            sw = rw; hw = r;
            reset = 0x0;
        } dac_reg_rev[15:0];
    } VO_DAC_CTRL @ 0x120;
    reg {
        name = "VO_DAC_C_CTRL";
        desc = "VO_DAC_C_CTRL is a VO DAC C channel control register. (offset 0x130; total reset 0x00000000; PROVEN: Hi3521A/Hi3520D V300 data sheet (Issue 00B07, 2015-12-10), section 10.2.7, PDF page 1275).";
        field {
            name = "endac";
            desc = "DAC enable
- 0: disabled
- 1: enabled";
            sw = rw; hw = r;
            reset = 0x0;
        } endac[31:31];
        field {
            name = "reserved";
            desc = "Reserved";
            sw = r; hw = w;
            reset = 0x0;
        } reserved_30_10[30:10];
        field {
            name = "dacgc";
            desc = "DAC output amplitude control The output voltage of the DAC at full scale ranges from 0.52 V to 1.37 V. The output amplitude is adjusted in 64 phases and the adjustment precision is 1%. The formula is as follows: Ifs = 13.9 + Gain x 0.358 (mA)
- 000000: 0.52 V …
- 111111: 1.37 V";
            sw = rw; hw = r;
            reset = 0x0;
        } dacgc[9:4];
        field {
            name = "reserved";
            desc = "Reserved";
            sw = r; hw = w;
            reset = 0x0;
        } reserved_3_2[3:2];
        field {
            name = "cablectr";
            desc = "DAC VREF_CABLE reference voltage adjustment
- 00: normal by default
- 01: -10%
- 10: -20%
- 11: +10%";
            sw = rw; hw = r;
            reset = 0x0;
        } cablectr[1:0];
    } VO_DAC_C_CTRL @ 0x130;
    reg {
        name = "VO_DAC_R_CTRL";
        desc = "VO_DAC_R_CTRL is a VO DAC R channel control register. (offset 0x134; total reset 0x00000000; PROVEN: Hi3521A/Hi3520D V300 data sheet (Issue 00B07, 2015-12-10), section 1.37, PDF page 1276).";
        field {
            name = "endac";
            desc = "DAC enable
- 0: disabled
- 1: enabled";
            sw = rw; hw = r;
            reset = 0x0;
        } endac[31:31];
        field {
            name = "reserved";
            desc = "Reserved";
            sw = r; hw = w;
            reset = 0x0;
        } reserved_30_10[30:10];
        field {
            name = "dacgc";
            desc = "DAC output amplitude control The output voltage of the DAC at full scale ranges from 0.52 V to 1.37 V. The output amplitude is adjusted in 64 phases and the adjustment precision is 1%. The formula is as follows: Ifs = 13.9 + Gain x 0.358 (mA)
- 000000: 0.52 V …
- 111111: 1.37 V";
            sw = rw; hw = r;
            reset = 0x0;
        } dacgc[9:4];
        field {
            name = "reserved";
            desc = "Reserved";
            sw = r; hw = w;
            reset = 0x0;
        } reserved_3_2[3:2];
        field {
            name = "cablectr";
            desc = "DAC VREF_CABLE reference voltage adjustment
- 00: normal by default
- 01: -10%
- 10: -20%
- 11: +10%";
            sw = rw; hw = r;
            reset = 0x0;
        } cablectr[1:0];
    } VO_DAC_R_CTRL @ 0x134;
    reg {
        name = "VO_DAC_G_CTRL";
        desc = "VO_DAC_G_CTRL is a VO DAC G channel control register. (offset 0x138; total reset 0x00000000; PROVEN: Hi3521A/Hi3520D V300 data sheet (Issue 00B07, 2015-12-10), section 1.37, PDF page 1277).";
        field {
            name = "dac_en";
            desc = "DAC enable
- 0: disabled
- 1: enabled";
            sw = rw; hw = r;
            reset = 0x0;
        } dac_en[31:31];
        field {
            name = "reserved";
            desc = "Reserved";
            sw = r; hw = w;
            reset = 0x0;
        } reserved_30_10[30:10];
        field {
            name = "dacgc";
            desc = "DAC output amplitude control The output voltage of the DAC at full scale ranges from 0.52 V to 1.37 V. The output amplitude is adjusted in 64 phases and the adjustment precision is 1%. The formula is as follows: Ifs = 13.9 + Gain x 0.358 (mA)
- 000000: 0.52 V …
- 111111: 1.37 V";
            sw = rw; hw = r;
            reset = 0x0;
        } dacgc[9:4];
        field {
            name = "reserved";
            desc = "Reserved";
            sw = r; hw = w;
            reset = 0x0;
        } reserved_3_2[3:2];
        field {
            name = "cablectr";
            desc = "DAC VREF_CABLE reference voltage adjustment
- 00: normal by default
- 01: -10%
- 10: -20%
- 11: +10%";
            sw = rw; hw = r;
            reset = 0x0;
        } cablectr[1:0];
    } VO_DAC_G_CTRL @ 0x138;
    reg {
        name = "VO_DAC_B_CTRL";
        desc = "VO_DAC_B_CTRL is a VO DAC B channel control register. (offset 0x13C; total reset 0x00000000; PROVEN: Hi3521A/Hi3520D V300 data sheet (Issue 00B07, 2015-12-10), section 1.37, PDF page 1278).";
        field {
            name = "dac_en";
            desc = "DAC enable
- 0: disabled
- 1: enabled";
            sw = rw; hw = r;
            reset = 0x0;
        } dac_en[31:31];
        field {
            name = "reserved";
            desc = "Reserved";
            sw = r; hw = w;
            reset = 0x0;
        } reserved_30_10[30:10];
        field {
            name = "dacgc";
            desc = "DAC output amplitude control The output voltage of the DAC at full scale ranges from 0.52 V to 1.37 V. The output amplitude is adjusted in 64 phases and the adjustment precision is 1%. The formula is as follows: Ifs = 13.9 + Gain x 0.358 (mA)
- 000000: 0.52 V …
- 111111: 1.37 V";
            sw = rw; hw = r;
            reset = 0x0;
        } dacgc[9:4];
        field {
            name = "reserved";
            desc = "Reserved";
            sw = r; hw = w;
            reset = 0x0;
        } reserved_3_2[3:2];
        field {
            name = "cablectr";
            desc = "DAC VREF_CABLE reference voltage adjustment
- 00: normal by default
- 01: -10%
- 10: -20%
- 11: +10%";
            sw = rw; hw = r;
            reset = 0x0;
        } cablectr[1:0];
    } VO_DAC_B_CTRL @ 0x13C;
    reg {
        name = "GDC_CORRESP";
        desc = "GDC_CORRESP is a graphics layer binding relationship register. (offset 0x30C; total reset 0x00011100; PROVEN: Hi3521A/Hi3520D V300 data sheet (Issue 00B07, 2015-12-10), section 1.37, PDF page 1278).";
        field {
            name = "reserved";
            desc = "Reserved";
            sw = r; hw = w;
            reset = 0x11;
        } reserved_31_12[31:12];
        field {
            name = "g2_corresp";
            desc = "G2 binding relationship
- 0010: G2 is bound to CBM 1 or CBM2.
- 0100: G2 is bound to MIXSD, and pictures are displayed through the DSD.

Other values: reserved";
            sw = rw; hw = r;
            reset = 0x1;
        } g2_corresp[11:8];
        field {
            name = "reserved";
            desc = "Reserved";
            sw = r; hw = w;
            reset = 0x0;
        } reserved_7_0[7:0];
    } GDC_CORRESP @ 0x30C;
    reg {
        name = "WBC_CORRESP";
        desc = "WBC_CORRESP is a WBC point binding relationship register. (offset 0x310; total reset 0x00000001; PROVEN: Hi3521A/Hi3520D V300 data sheet (Issue 00B07, 2015-12-10), section 1.37, PDF page 1279).";
        field {
            name = "reserved";
            desc = "Reserved";
            sw = r; hw = w;
            reset = 0x0;
        } reserved_31_6[31:6];
        field {
            name = "wbc_corresp";
            desc = "WBC point binding relationship of WBC_DHD
- 0x1: WBC_DHD is bound to the output end of CBM mixer 1.
- 0x2: WBC_DHD is bound to the output end of CBM mixer 2.
- 0x10: WBC_DHD is bound to the output end of V3.

Other values: reserved";
            sw = rw; hw = r;
            reset = 0x1;
        } wbc_corresp[5:0];
    } WBC_CORRESP @ 0x310;
    reg {
        name = "COEF_DATA";
        desc = "COEF_DATA is a virtual coefficient register. All VDP coefficients are read from this register. The coefficients are distinguished from each other by using the PARARD read enable registers. (offset 0x400; total reset 0x00000000; PROVEN: Hi3521A/Hi3520D V300 data sheet (Issue 00B07, 2015-12-10), section 1.37, PDF page 1279).";
        field {
            name = "coef_data";
            desc = "Coefficient";
            sw = r; hw = w;
            reset = 0x0;
        } coef_data[31:0];
    } COEF_DATA @ 0x400;
    reg {
        name = "V1_PARARD";
        desc = "V1_PARARD is a V1 coefficient read flag register. (offset 0x414; total reset 0x00000000; PROVEN: Hi3521A/Hi3520D V300 data sheet (Issue 00B07, 2015-12-10), section 1.37, PDF page 1280).";
        field {
            name = "reserved";
            desc = "Reserved";
            sw = r; hw = w;
            reset = 0x0;
        } reserved_31_4[31:4];
        field {
            name = "v1_vccoef_rd";
            desc = "Read enable for the V1 vertical chrominance filtering coefficient
- 0: disabled
- 1: enabled";
            sw = rw; hw = r;
            reset = 0x0;
        } v1_vccoef_rd[3:3];
        field {
            name = "v1_vlcoef_rd";
            desc = "Read enable for the V1 vertical luminance filtering coefficient
- 0: disabled
- 1: enabled";
            sw = rw; hw = r;
            reset = 0x0;
        } v1_vlcoef_rd[2:2];
        field {
            name = "v1_hccoef_rd";
            desc = "Read enable for the V1 horizontal chrominance filtering coefficient
- 0: disabled
- 1: enabled";
            sw = rw; hw = r;
            reset = 0x0;
        } v1_hccoef_rd[1:1];
        field {
            name = "v1_hlcoef_rd";
            desc = "Read enable for the V1 horizontal luminance filtering coefficient
- 0: disabled
- 1: enabled";
            sw = rw; hw = r;
            reset = 0x0;
        } v1_hlcoef_rd[0:0];
    } V1_PARARD @ 0x414;
    reg {
        name = "V3_PARARD";
        desc = "V3_PARARD is a V3 coefficient read flag register. (offset 0x41C; total reset 0x00000000; PROVEN: Hi3521A/Hi3520D V300 data sheet (Issue 00B07, 2015-12-10), section 1.37, PDF page 1281).";
        field {
            name = "reserved";
            desc = "Reserved";
            sw = r; hw = w;
            reset = 0x0;
        } reserved_31_4[31:4];
        field {
            name = "v3_vccoef_rd";
            desc = "Read enable for the V3 vertical chrominance filtering coefficient
- 0: disabled
- 1: enabled";
            sw = rw; hw = r;
            reset = 0x0;
        } v3_vccoef_rd[3:3];
        field {
            name = "v3_vlcoef_rd";
            desc = "Read enable for the V3 vertical luminance filtering coefficient
- 0: disabled
- 1: enabled";
            sw = rw; hw = r;
            reset = 0x0;
        } v3_vlcoef_rd[2:2];
        field {
            name = "v3_hccoef_rd";
            desc = "Read enable for the V3 horizontal chrominance filtering coefficient
- 0: disabled
- 1: enabled";
            sw = rw; hw = r;
            reset = 0x0;
        } v3_hccoef_rd[1:1];
        field {
            name = "v3_hlcoef_rd";
            desc = "Read enable for the V3 horizontal luminance filtering coefficient
- 0: disabled
- 1: enabled";
            sw = rw; hw = r;
            reset = 0x0;
        } v3_hlcoef_rd[0:0];
    } V3_PARARD @ 0x41C;
    reg {
        name = "WBCDHD_PARARD";
        desc = "WBCDHD_PARARD is a WBC_DHD coefficient read flag register. (offset 0x4C0; total reset 0x00000000; PROVEN: Hi3521A/Hi3520D V300 data sheet (Issue 00B07, 2015-12-10), section 1.37, PDF page 1282).";
        field {
            name = "reserved";
            desc = "Reserved";
            sw = r; hw = w;
            reset = 0x0;
        } reserved_31_4[31:4];
        field {
            name = "wbcdhd_vccoef_rd";
            desc = "Read enable for the WBC_DHD vertical chrominance filtering coefficient
- 0: disabled
- 1: enabled";
            sw = rw; hw = r;
            reset = 0x0;
        } wbcdhd_vccoef_rd[3:3];
        field {
            name = "wbcdhd_vlcoef_rd";
            desc = "Read enable for the WBC_DHD vertical luminance filtering coefficient
- 0: disabled
- 1: enabled";
            sw = rw; hw = r;
            reset = 0x0;
        } wbcdhd_vlcoef_rd[2:2];
        field {
            name = "wbcdhd_hccoef_rd";
            desc = "Read enable for the WBC_DHD horizontal chrominance filtering coefficient
- 0: disabled
- 1: enabled";
            sw = rw; hw = r;
            reset = 0x0;
        } wbcdhd_hccoef_rd[1:1];
        field {
            name = "wbcdhd_hlcoef_rd";
            desc = "Read enable for the WBC_DHD horizontal luminance filtering coefficient
- 0: disabled
- 1: enabled";
            sw = rw; hw = r;
            reset = 0x0;
        } wbcdhd_hlcoef_rd[0:0];
    } WBCDHD_PARARD @ 0x4C0;
    reg {
        name = "V3_CTRL";
        desc = "V3_CTRL is a V3 configuration register (non-instant register). (offset 0x3800; total reset 0x00000400; PROVEN: Hi3521A/Hi3520D V300 data sheet (Issue 00B07, 2015-12-10), section 1.37, PDF page 1283).";
        field {
            name = "surface_en";
            desc = "Surface enable (non-instant register)
- 0: disabled
- 1: enabled";
            sw = rw; hw = r;
            reset = 0x0;
        } surface_en[31:31];
        field {
            name = "reserved";
            desc = "Reserved";
            sw = r; hw = w;
            reset = 0x0;
        } reserved_30_28[30:28];
        field {
            name = "mute_en";
            desc = "V3 mute enable (non-instant register)
- 0: disabled
- 1: enabled";
            sw = rw; hw = r;
            reset = 0x0;
        } mute_en[27:27];
        field {
            name = "reserved";
            desc = "Reserved";
            sw = r; hw = w;
            reset = 0x0;
        } reserved_26_20[26:20];
        field {
            name = "ifir_mode";
            desc = "Horizontal chrominance IFIR mode
- 00: reserved
- 01: chrominance IFIR replication mode
- 10: bilinear interpolation
- 11: 6-tap FIR";
            sw = rw; hw = r;
            reset = 0x0;
        } ifir_mode[19:18];
        field {
            name = "reserved";
            desc = "Reserved";
            sw = r; hw = w;
            reset = 0x0;
        } reserved_17_17[17:17];
        field {
            name = "reserved";
            desc = "Reserved";
            sw = r; hw = w;
            reset = 0x0;
        } reserved_16_16[16:16];
        field {
            name = "lm_rmode";
            desc = "Luminance read mode
- 00: The read mode is bound to the interface.
- 01: The frame buffer data is read in progressive mode.
- 10: The top field is read in interlaced mode.
- 11: The bottom field is read in interlaced mode.";
            sw = rw; hw = r;
            reset = 0x0;
        } lm_rmode[15:14];
        field {
            name = "chm_rmode";
            desc = "Chrominance read mode
- 00: The read mode is bound to the interface.
- 01: The frame buffer data is read in progressive mode.
- 10: The top field is read in interlaced mode.
- 11: The bottom field is read in interlaced mode.";
            sw = rw; hw = r;
            reset = 0x0;
        } chm_rmode[13:12];
        field {
            name = "reserved";
            desc = "Reserved";
            sw = r; hw = w;
            reset = 0x4;
        } reserved_11_8[11:8];
        field {
            name = "req_ctrl";
            desc = "Register for controlling the number of 16-burst requested consecutively at a time
- 0x0: One 16-burst is requested consecutively at a time.
- 0x1: Two 16-burst are requested consecutively at a time.

Other values: reserved";
            sw = rw; hw = r;
            reset = 0x0;
        } req_ctrl[7:5];
        field {
            name = "reserved";
            desc = "Reserved";
            sw = r; hw = w;
            reset = 0x0;
        } reserved_4_4[4:4];
        field {
            name = "ifmt";
            desc = "Format of the input data
- 0x3: SPYCbCr420
- 0x4: SPYCbCr422

Other values: reserved";
            sw = rw; hw = r;
            reset = 0x0;
        } ifmt[3:0];
    } V3_CTRL @ 0x3800;
    reg {
        name = "V3_UPD";
        desc = "V3_UPD is a V3 channel update enable register. (offset 0x3804; total reset 0x00000000; PROVEN: Hi3521A/Hi3520D V300 data sheet (Issue 00B07, 2015-12-10), section 1.37, PDF page 1284).";
        field {
            name = "reserved";
            desc = "Reserved";
            sw = r; hw = w;
            reset = 0x0;
        } reserved_31_1[31:1];
        field {
            name = "regup";
            desc = "Surface register update. After the registers at this layer are configured, the registers are updated when the value 1 is written to this bit. After updates, this bit is automatically cleared by the hardware.

Access type WC in the data sheet: written 1 clears the bit.";
            sw = rw; hw = w; onwrite = woclr;
            reset = 0x0;
        } regup[0:0];
    } V3_UPD @ 0x3804;
    reg {
        name = "V3_PRERD";
        desc = "V3_PRERD is a V3 prefetch enable register. (offset 0x3820; total reset 0x80000000; PROVEN: Hi3521A/Hi3520D V300 data sheet (Issue 00B07, 2015-12-10), section 1.37, PDF page 1285).";
        field {
            name = "pre_rd_en";
            desc = "V3 prefetch enable
- 0: disabled
- 1: enabled";
            sw = rw; hw = r;
            reset = 0x1;
        } pre_rd_en[31:31];
        field {
            name = "reserved";
            desc = "Reserved";
            sw = r; hw = w;
            reset = 0x0;
        } reserved_30_0[30:0];
    } V3_PRERD @ 0x3820;
    reg {
        name = "V3_IRESO";
        desc = "V3_IRESO is a V3 input resolution register (non-instant register). (offset 0x3828; total reset 0x00000000; PROVEN: Hi3521A/Hi3520D V300 data sheet (Issue 00B07, 2015-12-10), section 1.37, PDF page 1285).";
        field {
            name = "reserved";
            desc = "Reserved";
            sw = r; hw = w;
            reset = 0x0;
        } reserved_31_24[31:24];
        field {
            name = "ih";
            desc = "Height (in line). The value is the actual height minus 1. The frame height is referenced and the unit is line.";
            sw = rw; hw = r;
            reset = 0x0;
        } ih[23:12];
        field {
            name = "iw";
            desc = "Width (in pixel). The value is the actual width minus 1.";
            sw = rw; hw = r;
            reset = 0x0;
        } iw[11:0];
    } V3_IRESO @ 0x3828;
    reg {
        name = "V3_ORESO";
        desc = "V3_ORESO is a V3 output resolution register (non-instant register). (offset 0x382C; total reset 0x00000000; PROVEN: Hi3521A/Hi3520D V300 data sheet (Issue 00B07, 2015-12-10), section 1.37, PDF page 1286).";
        field {
            name = "reserved";
            desc = "Reserved";
            sw = r; hw = w;
            reset = 0x0;
        } reserved_31_24[31:24];
        field {
            name = "oh";
            desc = "Height (in line). The value is the actual height minus 1. The frame height is referenced and the unit is line.";
            sw = rw; hw = r;
            reset = 0x0;
        } oh[23:12];
        field {
            name = "ow";
            desc = "Width (in pixel). The value is the actual width minus 1.";
            sw = rw; hw = r;
            reset = 0x0;
        } ow[11:0];
    } V3_ORESO @ 0x382C;
    reg {
        name = "V3_CBMPARA";
        desc = "V3_CBMPARA is a V3 overlay parameter register (non-instant register). (offset 0x3838; total reset 0x00000000; PROVEN: Hi3521A/Hi3520D V300 data sheet (Issue 00B07, 2015-12-10), section 1.37, PDF page 1286).";
        field {
            name = "reserved";
            desc = "Reserved";
            sw = r; hw = w;
            reset = 0x0;
        } reserved_31_8[31:8];
        field {
            name = "galpha";
            desc = "Overlay global alpha value. The value ranges from 0 to 128. The value 128 indicates opaque, and the value 0 indicates full transparent.";
            sw = rw; hw = r;
            reset = 0x0;
        } galpha[7:0];
    } V3_CBMPARA @ 0x3838;
    reg {
        name = "V3_PARAUP";
        desc = "V3_PARAUP is a V3 coefficient-related register update enable register. The VDP scaling coefficients are configured by using the AXI master. Software configures the start addresses and parameter update flags by using the slave. (offset 0x3840; total reset 0x00000000; PROVEN: Hi3521A/Hi3520D V300 data sheet (Issue 00B07, 2015-12-10), section 1.37, PDF page 1287).";
        field {
            name = "reserved";
            desc = "Reserved";
            sw = r; hw = w;
            reset = 0x0;
        } reserved_31_4[31:4];
        field {
            name = "v3_vccoef_upd";
            desc = "Whether the V3 vertical chrominance filtering coefficients need to be updated. This bit is automatically cleared after the hardware updates the coefficients.
- 0: not updated
- 1: updated";
            sw = w; hw = r;
            reset = 0x0;
        } v3_vccoef_upd[3:3];
        field {
            name = "v3_vlcoef_upd";
            desc = "Whether the V3 vertical luminance filtering coefficients need to be updated. This bit is automatically cleared after the hardware updates the coefficients.
- 0: not updated
- 1: updated";
            sw = w; hw = r;
            reset = 0x0;
        } v3_vlcoef_upd[2:2];
        field {
            name = "v3_hccoef_upd";
            desc = "Whether the V3 horizontal chrominance filtering coefficients need to be updated. This bit is automatically cleared after the hardware updates the coefficients.
- 0: not updated
- 1: updated";
            sw = w; hw = r;
            reset = 0x0;
        } v3_hccoef_upd[1:1];
        field {
            name = "v3_hlcoef_upd";
            desc = "Whether the V3 horizontal luminance filtering coefficients need to be updated. This bit is automatically cleared after the hardware updates the coefficients.
- 0: not updated
- 1: updated";
            sw = w; hw = r;
            reset = 0x0;
        } v3_hlcoef_upd[0:0];
    } V3_PARAUP @ 0x3840;
    reg {
        name = "V3_HLCOEFAD";
        desc = "V3_HLCOEFAD is a V3 horizontal luminance filtering coefficient address register. (offset 0x3850; total reset 0x00000000; PROVEN: Hi3521A/Hi3520D V300 data sheet (Issue 00B07, 2015-12-10), section 1.37, PDF page 1288).";
        field {
            name = "coef_addr";
            desc = "Start address for storing coefficients in the local memory";
            sw = rw; hw = r;
            reset = 0x0;
        } coef_addr[31:0];
    } V3_HLCOEFAD @ 0x3850;
    reg {
        name = "V3_HCCOEFAD";
        desc = "V3_HCCOEFAD is a V3 horizontal chrominance filtering coefficient address register. (offset 0x3854; total reset 0x00000000; PROVEN: Hi3521A/Hi3520D V300 data sheet (Issue 00B07, 2015-12-10), section 1.37, PDF page 1288).";
        field {
            name = "coef_addr";
            desc = "Start address for storing coefficients in the local memory";
            sw = rw; hw = r;
            reset = 0x0;
        } coef_addr[31:0];
    } V3_HCCOEFAD @ 0x3854;
    reg {
        name = "V3_VLCOEFAD";
        desc = "V3_VLCOEFAD is a V3 vertical luminance filtering coefficient address register. (offset 0x3858; total reset 0x00000000; PROVEN: Hi3521A/Hi3520D V300 data sheet (Issue 00B07, 2015-12-10), section 1.37, PDF page 1288).";
        field {
            name = "coef_addr";
            desc = "Start address for storing coefficients in the local memory";
            sw = rw; hw = r;
            reset = 0x0;
        } coef_addr[31:0];
    } V3_VLCOEFAD @ 0x3858;
    reg {
        name = "V3_VCCOEFAD";
        desc = "V3_VCCOEFAD is a V3 vertical chrominance filtering coefficient address register. (offset 0x385C; total reset 0x00000000; PROVEN: Hi3521A/Hi3520D V300 data sheet (Issue 00B07, 2015-12-10), section 1.37, PDF page 1289).";
        field {
            name = "coef_addr";
            desc = "Start address for storing coefficients in the local memory";
            sw = rw; hw = r;
            reset = 0x0;
        } coef_addr[31:0];
    } V3_VCCOEFAD @ 0x385C;
    reg {
        name = "V3_CSC_IDC";
        desc = "V3_CSC_IDC is a V3 CSC input DC component register (instant register). (offset 0x3880; total reset 0x00000000; PROVEN: Hi3521A/Hi3520D V300 data sheet (Issue 00B07, 2015-12-10), section 1.37, PDF page 1289).";
        field {
            name = "reserved";
            desc = "Reserved";
            sw = r; hw = w;
            reset = 0x0;
        } reserved_31_23[31:23];
        field {
            name = "csc_en";
            desc = "CSC enable
- 0: disabled
- 1: enabled";
            sw = rw; hw = r;
            reset = 0x0;
        } csc_en[22:22];
        field {
            name = "cscidc1";
            desc = "DC parameter of input component 1. The MSB is the signed bit. The value is expressed as a complement.";
            sw = rw; hw = r;
            reset = 0x0;
        } cscidc1[21:11];
        field {
            name = "cscidc0";
            desc = "DC parameter of input component 0. The MSB is the signed bit. The value is expressed as a complement.";
            sw = rw; hw = r;
            reset = 0x0;
        } cscidc0[10:0];
    } V3_CSC_IDC @ 0x3880;
    reg {
        name = "V3_CSC_ODC";
        desc = "V3_CSC_ODC is a V3 CSC output DC component register (instant register). (offset 0x3884; total reset 0x00000000; PROVEN: Hi3521A/Hi3520D V300 data sheet (Issue 00B07, 2015-12-10), section 1.37, PDF page 1290).";
        field {
            name = "reserved";
            desc = "Reserved";
            sw = r; hw = w;
            reset = 0x0;
        } reserved_31_23[31:23];
        field {
            name = "csc_sign_mode";
            desc = "CSC output mode
- 0: The CSC output is a 10-bit unsigned number.
- 1: The CSC output is a 12-bit signed number.";
            sw = rw; hw = r;
            reset = 0x0;
        } csc_sign_mode[22:22];
        field {
            name = "cscodc1";
            desc = "DC parameter of output component 1. The MSB is the signed bit. The value is expressed as a complement.";
            sw = rw; hw = r;
            reset = 0x0;
        } cscodc1[21:11];
        field {
            name = "cscodc0";
            desc = "DC parameter of output component 0. The MSB is the signed bit. The value is expressed as a complement.";
            sw = rw; hw = r;
            reset = 0x0;
        } cscodc0[10:0];
    } V3_CSC_ODC @ 0x3884;
    reg {
        name = "V3_CSC_IODC";
        desc = "V3_CSC_IODC is a CSC input/output DC component register (instant register). (offset 0x3888; total reset 0x00000000; PROVEN: Hi3521A/Hi3520D V300 data sheet (Issue 00B07, 2015-12-10), section 1.37, PDF page 1290).";
        field {
            name = "reserved";
            desc = "Reserved";
            sw = r; hw = w;
            reset = 0x0;
        } reserved_31_22[31:22];
        field {
            name = "cscodc2";
            desc = "DC parameter of output component 2. The MSB is the signed bit. The value is expressed as a complement.";
            sw = rw; hw = r;
            reset = 0x0;
        } cscodc2[21:11];
        field {
            name = "cscidc2";
            desc = "DC parameter of input component 2. The MSB is the signed bit. The value is expressed as a complement.";
            sw = rw; hw = r;
            reset = 0x0;
        } cscidc2[10:0];
    } V3_CSC_IODC @ 0x3888;
    reg {
        name = "V3_CSC_P0";
        desc = "V3_CSC_P0 is a CSC parameter 0 register (instant register). (offset 0x388C; total reset 0x00000000; PROVEN: Hi3521A/Hi3520D V300 data sheet (Issue 00B07, 2015-12-10), section 1.37, PDF page 1291).";
        field {
            name = "reserved";
            desc = "Reserved";
            sw = r; hw = w;
            reset = 0x0;
        } reserved_31_31[31:31];
        field {
            name = "cscp01";
            desc = "5.10 data format indicating one sign bit, four integer bits, and 10 decimal bits. The value is represented by a complement.";
            sw = rw; hw = r;
            reset = 0x0;
        } cscp01[30:16];
        field {
            name = "reserved";
            desc = "Reserved";
            sw = r; hw = w;
            reset = 0x0;
        } reserved_15_15[15:15];
        field {
            name = "cscp00";
            desc = "5.10 data format indicating one sign bit, four integer bits, and 10 decimal bits. The value is represented by a complement.";
            sw = rw; hw = r;
            reset = 0x0;
        } cscp00[14:0];
    } V3_CSC_P0 @ 0x388C;
    reg {
        name = "V3_CSC_P1";
        desc = "V3_CSC_P1 is a CSC parameter 1 register (instant register). (offset 0x3890; total reset 0x00000000; PROVEN: Hi3521A/Hi3520D V300 data sheet (Issue 00B07, 2015-12-10), section 5.10, PDF page 1291).";
        field {
            name = "reserved";
            desc = "Reserved";
            sw = r; hw = w;
            reset = 0x0;
        } reserved_31_31[31:31];
        field {
            name = "cscp10";
            desc = "5.10 data format indicating one sign bit, four integer bits, and 10 decimal bits. The value is represented by a complement.";
            sw = rw; hw = r;
            reset = 0x0;
        } cscp10[30:16];
        field {
            name = "reserved";
            desc = "Reserved";
            sw = r; hw = w;
            reset = 0x0;
        } reserved_15_15[15:15];
        field {
            name = "cscp02";
            desc = "5.10 data format indicating one sign bit, four integer bits, and 10 decimal bits. The value is represented by a complement.";
            sw = rw; hw = r;
            reset = 0x0;
        } cscp02[14:0];
    } V3_CSC_P1 @ 0x3890;
    reg {
        name = "V3_CSC_P2";
        desc = "V3_CSC_P2 is a CSC parameter 2 register (instant register). (offset 0x3894; total reset 0x00000000; PROVEN: Hi3521A/Hi3520D V300 data sheet (Issue 00B07, 2015-12-10), section 5.10, PDF page 1292).";
        field {
            name = "reserved";
            desc = "Reserved";
            sw = r; hw = w;
            reset = 0x0;
        } reserved_31_31[31:31];
        field {
            name = "cscp12";
            desc = "5.10 data format indicating one sign bit, four integer bits, and 10 decimal bits. The value is represented by a complement.";
            sw = rw; hw = r;
            reset = 0x0;
        } cscp12[30:16];
        field {
            name = "reserved";
            desc = "Reserved";
            sw = r; hw = w;
            reset = 0x0;
        } reserved_15_15[15:15];
        field {
            name = "cscp11";
            desc = "5.10 data format indicating one sign bit, four integer bits, and 10 decimal bits. The value is represented by a complement.";
            sw = rw; hw = r;
            reset = 0x0;
        } cscp11[14:0];
    } V3_CSC_P2 @ 0x3894;
    reg {
        name = "V3_CSC_P3";
        desc = "V3_CSC_P3 is a CSC parameter 3 register (instant register). (offset 0x3898; total reset 0x00000000; PROVEN: Hi3521A/Hi3520D V300 data sheet (Issue 00B07, 2015-12-10), section 5.10, PDF page 1292).";
        field {
            name = "reserved";
            desc = "Reserved";
            sw = r; hw = w;
            reset = 0x0;
        } reserved_31_31[31:31];
        field {
            name = "cscp21";
            desc = "5.10 data format indicating one sign bit, four integer bits, and 10 decimal bits. The value is represented by a complement.";
            sw = rw; hw = r;
            reset = 0x0;
        } cscp21[30:16];
        field {
            name = "reserved";
            desc = "Reserved";
            sw = r; hw = w;
            reset = 0x0;
        } reserved_15_15[15:15];
        field {
            name = "cscp20";
            desc = "5.10 data format indicating one sign bit, four integer bits, and 10 decimal bits. The value is represented by a complement.";
            sw = rw; hw = r;
            reset = 0x0;
        } cscp20[14:0];
    } V3_CSC_P3 @ 0x3898;
    reg {
        name = "V3_CSC_P4";
        desc = "V3_CSC_P4 is a CSC parameter 4 register (instant register). (offset 0x389C; total reset 0x00000000; PROVEN: Hi3521A/Hi3520D V300 data sheet (Issue 00B07, 2015-12-10), section 5.10, PDF page 1293).";
        field {
            name = "reserved";
            desc = "Reserved";
            sw = r; hw = w;
            reset = 0x0;
        } reserved_31_15[31:15];
        field {
            name = "cscp22";
            desc = "5.10 data format indicating one sign bit, four integer bits, and 10 decimal bits. The value is represented by a complement.";
            sw = rw; hw = r;
            reset = 0x0;
        } cscp22[14:0];
    } V3_CSC_P4 @ 0x389C;
    reg {
        name = "V3_HSP";
        desc = "V3_HSP is a V3 horizontal scaling parameter register (non-instant register). Scaling ratio = Input width/Output width (offset 0x38C0; total reset 0x00100000; PROVEN: Hi3521A/Hi3520D V300 data sheet (Issue 00B07, 2015-12-10), section 5.10, PDF page 1293).";
        field {
            name = "hlmsc_en";
            desc = "Horizontal luminance scaling enable
- 0: disabled
- 1: enabled";
            sw = rw; hw = r;
            reset = 0x0;
        } hlmsc_en[31:31];
        field {
            name = "hchmsc_en";
            desc = "Horizontal chrominance scaling enable
- 0: disabled
- 1: enabled";
            sw = rw; hw = r;
            reset = 0x0;
        } hchmsc_en[30:30];
        field {
            name = "hlmid_en";
            desc = "Median filtering enable for horizontal luminance scaling. This bit is invalid when hlfir_en is invalid.
- 0: disabled
- 1: enabled";
            sw = rw; hw = r;
            reset = 0x0;
        } hlmid_en[29:29];
        field {
            name = "hchmid_en";
            desc = "Median filtering enable for horizontal chrominance scaling. This bit is invalid when hchfir_en is invalid.
- 0: disabled
- 1: enabled";
            sw = rw; hw = r;
            reset = 0x0;
        } hchmid_en[28:28];
        field {
            name = "non_lnr_en";
            desc = "Non-linear scaling enable
- 0: disabled
- 1: enabled";
            sw = rw; hw = r;
            reset = 0x0;
        } non_lnr_en[27:27];
        field {
            name = "hlfir_en";
            desc = "Horizontal luminance scaling mode
- 0: replication mode (filtering disabled)
- 1: filtering mode (filtering enabled)";
            sw = rw; hw = r;
            reset = 0x0;
        } hlfir_en[26:26];
        field {
            name = "hchfir_en";
            desc = "Horizontal chrominance scaling mode
- 0: replication mode (filtering disabled)
- 1: filtering mode (filtering enabled)";
            sw = rw; hw = r;
            reset = 0x0;
        } hchfir_en[25:25];
        field {
            name = "hfir_order";
            desc = "Horizontal scaling sequence
- 0: Horizontal scaling is performed before vertical scaling.
- 1: Horizontal scaling is performed after vertical scaling.";
            sw = rw; hw = r;
            reset = 0x0;
        } hfir_order[24:24];
        field {
            name = "hratio";
            desc = "Horizontal scaling ratio, in (u, 4, 20) format";
            sw = rw; hw = r;
            reset = 0x100000;
        } hratio[23:0];
    } V3_HSP @ 0x38C0;
    reg {
        name = "V3_HLOFFSET";
        desc = "V3_HLOFFSET is a V3 horizontal luminance offset register (non-instant register). It is used for pan-scan. (offset 0x38C4; total reset 0x00000000; PROVEN: Hi3521A/Hi3520D V300 data sheet (Issue 00B07, 2015-12-10), section 5.10, PDF page 1294).";
        field {
            name = "reserved";
            desc = "Reserved";
            sw = r; hw = w;
            reset = 0x0;
        } reserved_31_28[31:28];
        field {
            name = "hor_loffset";
            desc = "Horizontal luminance offset, in (s, 8, 20) format. The value is expressed as a complement.";
            sw = rw; hw = r;
            reset = 0x0;
        } hor_loffset[27:0];
    } V3_HLOFFSET @ 0x38C4;
    reg {
        name = "V3_HCOFFSET";
        desc = "V3_HCOFFSET is a V3 horizontal chrominance offset register (non-instant register). It is used for pan-scan. (offset 0x38C8; total reset 0x00000000; PROVEN: Hi3521A/Hi3520D V300 data sheet (Issue 00B07, 2015-12-10), section 5.10, PDF page 1295).";
        field {
            name = "reserved";
            desc = "Reserved";
            sw = r; hw = w;
            reset = 0x0;
        } reserved_31_28[31:28];
        field {
            name = "hor_coffset";
            desc = "Horizontal chrominance offset, in (s, 8, 20) format. The value is expressed as a complement.";
            sw = rw; hw = r;
            reset = 0x0;
        } hor_coffset[27:0];
    } V3_HCOFFSET @ 0x38C8;
    reg {
        name = "V3_VSP";
        desc = "V3_VSP is a V3 vertical scaling parameter register. (offset 0x38D8; total reset 0x00000000; PROVEN: Hi3521A/Hi3520D V300 data sheet (Issue 00B07, 2015-12-10), section 5.10, PDF page 1295).";
        field {
            name = "vlmsc_en";
            desc = "Vertical luminance scaling enable
- 0: disabled
- 1: enabled";
            sw = rw; hw = r;
            reset = 0x0;
        } vlmsc_en[31:31];
        field {
            name = "vchmsc_en";
            desc = "Vertical chrominance scaling enable
- 0: disabled
- 1: enabled";
            sw = rw; hw = r;
            reset = 0x0;
        } vchmsc_en[30:30];
        field {
            name = "vlmid_en";
            desc = "Median filtering enable for vertical luminance scaling. This bit is invalid when vlfir_en is invalid.
- 0: disabled
- 1: enabled";
            sw = rw; hw = r;
            reset = 0x0;
        } vlmid_en[29:29];
        field {
            name = "vchmid_en";
            desc = "Median filtering enable for vertical chrominance scaling. This bit is invalid when vchfir_en is invalid.
- 0: disabled
- 1: enabled";
            sw = rw; hw = r;
            reset = 0x0;
        } vchmid_en[28:28];
        field {
            name = "reserved";
            desc = "Reserved";
            sw = r; hw = w;
            reset = 0x0;
        } reserved_27_27[27:27];
        field {
            name = "vsc_chroma_tap";
            desc = "Vertical chrominance scaling tap
- 0: 4-tap FIR
- 1: 2-tap FIR";
            sw = rw; hw = r;
            reset = 0x0;
        } vsc_chroma_tap[26:26];
        field {
            name = "reserved";
            desc = "Reserved";
            sw = r; hw = w;
            reset = 0x0;
        } reserved_25_25[25:25];
        field {
            name = "vlfir_en";
            desc = "Vertical luminance scaling mode
- 0: replication mode (filtering disabled)
- 1: filtering mode (filtering enabled)";
            sw = rw; hw = r;
            reset = 0x0;
        } vlfir_en[24:24];
        field {
            name = "vchfir_en";
            desc = "Vertical chrominance scaling mode
- 0: replication mode (filtering disabled)
- 1: filtering mode (filtering enabled)";
            sw = rw; hw = r;
            reset = 0x0;
        } vchfir_en[23:23];
        field {
            name = "zme_out_fmt";
            desc = "Output data format for scaling
- 0: 422
- 1: 420";
            sw = rw; hw = r;
            reset = 0x0;
        } zme_out_fmt[22:21];
        field {
            name = "zme_in_fmt";
            desc = "Input data format for scaling
- 0: 422
- 1: 420";
            sw = rw; hw = r;
            reset = 0x0;
        } zme_in_fmt[20:19];
        field {
            name = "reserved";
            desc = "Reserved";
            sw = r; hw = w;
            reset = 0x0;
        } reserved_18_0[18:0];
    } V3_VSP @ 0x38D8;
    reg {
        name = "V3_VSR";
        desc = "V3_VSR is a vertical luminance scaling ratio register (non-instant register). Scaling ratio = Input height/Output height (offset 0x38DC; total reset 0x00001000; PROVEN: Hi3521A/Hi3520D V300 data sheet (Issue 00B07, 2015-12-10), section 5.10, PDF page 1297).";
        field {
            name = "reserved";
            desc = "Reserved";
            sw = r; hw = w;
            reset = 0x0;
        } reserved_31_16[31:16];
        field {
            name = "vratio";
            desc = "Vertical scaling ratio, in (u, 4, 12) format";
            sw = rw; hw = r;
            reset = 0x1000;
        } vratio[15:0];
    } V3_VSR @ 0x38DC;
    reg {
        name = "V3_VOFFSET";
        desc = "V3_VOFFSET is a V3 vertical luminance scaling offset register. The vertical scaling offset is affected by the field offset during pan-scan and the field offset when repeated frames occur. If no field offset occurs, vluma_offset is the lowest integral part plus the decimal part of offset_pan-scan. In YCbCr422 format, vchroma_offset is equal to vluma_offset; in YCbCr420 format, vchroma_offset is calculated as follows: vchroma_offset = scaling_chroma/2 - 0.25. If the field offset is required (such as static frames or repeated frames) and the bottom field is repeated, the values of vluma_offset and vchroma_offset configured for the top field are the same as those in the case of no field offset. The field offset must be considered when coefficients are configured for the bottom field. (offset 0x38E0; total reset 0x00000000; PROVEN: Hi3521A/Hi3520D V300 data sheet (Issue 00B07, 2015-12-10), section 5.10, PDF page 1297).";
        field {
            name = "vluma_offset";
            desc = "Vertical luminance offset, in (s, 4, 12) format. The value is expressed as a complement.";
            sw = rw; hw = r;
            reset = 0x0;
        } vluma_offset[31:16];
        field {
            name = "vchroma_offset";
            desc = "Vertical chrominance offset, in (s, 4, 12) format. The value is expressed as a complement.";
            sw = rw; hw = r;
            reset = 0x0;
        } vchroma_offset[15:0];
    } V3_VOFFSET @ 0x38E0;
    reg {
        name = "V3_VBOFFSET";
        desc = "V3_VBOFFSET is a V3 vertical luminance scaling offset register for the bottom field. The vertical scaling offset is affected by the field offset during pan-scan and the field offset when repeated frames occur. If no field offset occurs, vluma_offset is the lowest integral part plus the decimal part of offset_pan-scan. In YCbCr422 format, vchroma_offset is equal to vluma_offset; in YCbCr420 format, vchroma_offset is calculated as follows: vchroma_offset = scaling_chroma/2 - 0.25. If the field offset is required (such as static frames or repeated frames) and the bottom field is repeated, the values of vluma_offset and vchroma_offset configured for the top field are the same as those in the case of no field offset. The field offset must be considered when coefficients are configured for the bottom field. (offset 0x38E4; total reset 0x00000000; PROVEN: Hi3521A/Hi3520D V300 data sheet (Issue 00B07, 2015-12-10), section 5.10, PDF page 1298).";
        field {
            name = "vbluma_offset";
            desc = "Vertical luminance offset, in (s, 4, 12) format. The value is expressed as a complement.";
            sw = rw; hw = r;
            reset = 0x0;
        } vbluma_offset[31:16];
        field {
            name = "vbchroma_offset";
            desc = "Vertical chrominance offset, in (s, 4, 12) format. The value is expressed as a complement.";
            sw = rw; hw = r;
            reset = 0x0;
        } vbchroma_offset[15:0];
    } V3_VBOFFSET @ 0x38E4;
    reg {
        name = "V3_DFPOS";
        desc = "V3_DFPOS is a V3 surface start position (in the display window) register (non-instant register). The position unit is pixel. (offset 0x3900; total reset 0x00000000; PROVEN: Hi3521A/Hi3520D V300 data sheet (Issue 00B07, 2015-12-10), section 5.10, PDF page 1298).";
        field {
            name = "reserved";
            desc = "Reserved";
            sw = r; hw = w;
            reset = 0x0;
        } reserved_31_24[31:24];
        field {
            name = "disp_yfpos";
            desc = "Start coordinates of the display column The frame height is referenced and the unit is line.";
            sw = rw; hw = r;
            reset = 0x0;
        } disp_yfpos[23:12];
        field {
            name = "disp_xfpos";
            desc = "Start coordinates of the display row";
            sw = rw; hw = r;
            reset = 0x0;
        } disp_xfpos[11:0];
    } V3_DFPOS @ 0x3900;
    reg {
        name = "V3_DLPOS";
        desc = "V3_DLPOS is a V3 surface end position (in the display window) register (non-instant register). The position unit is pixel. (offset 0x3904; total reset 0x00000000; PROVEN: Hi3521A/Hi3520D V300 data sheet (Issue 00B07, 2015-12-10), section 5.10, PDF page 1299).";
        field {
            name = "reserved";
            desc = "Reserved";
            sw = r; hw = w;
            reset = 0x0;
        } reserved_31_24[31:24];
        field {
            name = "disp_ylpos";
            desc = "End coordinates of the display column The frame height is referenced and the unit is line.";
            sw = rw; hw = r;
            reset = 0x0;
        } disp_ylpos[23:12];
        field {
            name = "disp_xlpos";
            desc = "End coordinates of the display row";
            sw = rw; hw = r;
            reset = 0x0;
        } disp_xlpos[11:0];
    } V3_DLPOS @ 0x3904;
    reg {
        name = "V3_VFPOS";
        desc = "V3_VFPOS is a V3 surface content start position (in the display window) register (non-instant register). The position unit is pixel. (offset 0x3908; total reset 0x00000000; PROVEN: Hi3521A/Hi3520D V300 data sheet (Issue 00B07, 2015-12-10), section 5.10, PDF page 1299).";
        field {
            name = "reserved";
            desc = "Reserved";
            sw = r; hw = w;
            reset = 0x0;
        } reserved_31_24[31:24];
        field {
            name = "video_yfpos";
            desc = "Start coordinates of the video column The frame height is referenced and the unit is line.";
            sw = rw; hw = r;
            reset = 0x0;
        } video_yfpos[23:12];
        field {
            name = "video_xfpos";
            desc = "Start coordinates of the video row";
            sw = rw; hw = r;
            reset = 0x0;
        } video_xfpos[11:0];
    } V3_VFPOS @ 0x3908;
    reg {
        name = "V3_VLPOS";
        desc = "V3_VLPOS is a V3 surface content end position (in the display window) register (non-instant register). The position unit is pixel. (offset 0x390C; total reset 0x00000000; PROVEN: Hi3521A/Hi3520D V300 data sheet (Issue 00B07, 2015-12-10), section 5.10, PDF page 1300).";
        field {
            name = "reserved";
            desc = "Reserved";
            sw = r; hw = w;
            reset = 0x0;
        } reserved_31_24[31:24];
        field {
            name = "video_ylpos";
            desc = "End coordinates of the video column The frame height is referenced and the unit is line.";
            sw = rw; hw = r;
            reset = 0x0;
        } video_ylpos[23:12];
        field {
            name = "video_xlpos";
            desc = "End coordinates of the video row";
            sw = rw; hw = r;
            reset = 0x0;
        } video_xlpos[11:0];
    } V3_VLPOS @ 0x390C;
    reg {
        name = "V3_BK";
        desc = "V3_BK is a V3 background color register. (offset 0x3910; total reset 0x00000000; PROVEN: Hi3521A/Hi3520D V300 data sheet (Issue 00B07, 2015-12-10), section 5.10, PDF page 1300).";
        field {
            name = "reserved";
            desc = "Reserved";
            sw = r; hw = w;
            reset = 0x0;
        } reserved_31_30[31:30];
        field {
            name = "vbk_y";
            desc = "Y component";
            sw = rw; hw = r;
            reset = 0x0;
        } vbk_y[29:20];
        field {
            name = "vbk_cb";
            desc = "Cb component";
            sw = rw; hw = r;
            reset = 0x0;
        } vbk_cb[19:10];
        field {
            name = "vbk_cr";
            desc = "Cr component";
            sw = rw; hw = r;
            reset = 0x0;
        } vbk_cr[9:0];
    } V3_BK @ 0x3910;
    reg {
        name = "V3_ALPHA";
        desc = "V3_ALPHA is a V3 background filling color alpha register. (offset 0x3914; total reset 0x00000000; PROVEN: Hi3521A/Hi3520D V300 data sheet (Issue 00B07, 2015-12-10), section 5.10, PDF page 1301).";
        field {
            name = "reserved";
            desc = "Reserved";
            sw = r; hw = w;
            reset = 0x0;
        } reserved_31_8[31:8];
        field {
            name = "vbk_alpha";
            desc = "Levels 0-255 of the background filling color for the video layer";
            sw = rw; hw = r;
            reset = 0x0;
        } vbk_alpha[7:0];
    } V3_ALPHA @ 0x3914;
    reg {
        name = "V3_RIMWIDTH";
        desc = "V3_RIMWIDTH is a V3 RIM width register (non-instant register). (offset 0x3918; total reset 0x00000000; PROVEN: Hi3521A/Hi3520D V300 data sheet (Issue 00B07, 2015-12-10), section 5.10, PDF page 1301).";
        field {
            name = "reserved";
            desc = "Reserved";
            sw = rw; hw = r;
            reset = 0x0;
        } reserved_31_3[31:3];
        field {
            name = "v0_rim_width";
            desc = "Thickness of all the region borders
- 00: The border width is 0.
- 01: The border width is 1.
- 10: The border width is 2.
- 11: The border width is 4.";
            sw = rw; hw = r;
            reset = 0x0;
        } v0_rim_width[2:0];
    } V3_RIMWIDTH @ 0x3918;
    reg {
        name = "V3_RIMCOL0";
        desc = "V3_RIMCOL0 is a RIM color 0 register (non-instant register) for the upper 32 regions at the V3 video layer. (offset 0x391C; total reset 0x00000000; PROVEN: Hi3521A/Hi3520D V300 data sheet (Issue 00B07, 2015-12-10), section 5.10, PDF page 1302).";
        field {
            name = "reserved";
            desc = "Reserved";
            sw = rw; hw = r;
            reset = 0x0;
        } reserved_31_30[31:30];
        field {
            name = "v0_rim_y0";
            desc = "RIM color 0, R component";
            sw = rw; hw = r;
            reset = 0x0;
        } v0_rim_y0[29:20];
        field {
            name = "v0_rim_u0";
            desc = "RIM color 0, G component";
            sw = rw; hw = r;
            reset = 0x0;
        } v0_rim_u0[19:10];
        field {
            name = "v0_rim_v0";
            desc = "RIM color 0, B component";
            sw = rw; hw = r;
            reset = 0x0;
        } v0_rim_v0[9:0];
    } V3_RIMCOL0 @ 0x391C;
    reg {
        name = "V3_RIMCOL1";
        desc = "V3_RIMCOL1 is a RIM color 1 register (non-instant register) for the upper 32 regions at the V3 video layer. (offset 0x3920; total reset 0x00000000; PROVEN: Hi3521A/Hi3520D V300 data sheet (Issue 00B07, 2015-12-10), section 5.10, PDF page 1302).";
        field {
            name = "reserved";
            desc = "Reserved";
            sw = rw; hw = r;
            reset = 0x0;
        } reserved_31_30[31:30];
        field {
            name = "v0_rim_y1";
            desc = "RIM color 1, R component";
            sw = rw; hw = r;
            reset = 0x0;
        } v0_rim_y1[29:20];
        field {
            name = "v0_rim_u1";
            desc = "RIM color 1, G component";
            sw = rw; hw = r;
            reset = 0x0;
        } v0_rim_u1[19:10];
        field {
            name = "v0_rim_v1";
            desc = "RIM color 1, B component";
            sw = rw; hw = r;
            reset = 0x0;
        } v0_rim_v1[9:0];
    } V3_RIMCOL1 @ 0x3920;
    reg {
        name = "V3_IFIRCOEF01";
        desc = "V3_IFIRCOEF01 is an IFIR filtering coefficient 0/1 register. (offset 0x3980; total reset 0x000F03F5; PROVEN: Hi3521A/Hi3520D V300 data sheet (Issue 00B07, 2015-12-10), section 5.10, PDF page 1303).";
        field {
            name = "reserved";
            desc = "Reserved";
            sw = r; hw = w;
            reset = 0x0;
        } reserved_31_26[31:26];
        field {
            name = "coef1";
            desc = "IFIR filtering coefficient 1";
            sw = rw; hw = r;
            reset = 0xf;
        } coef1[25:16];
        field {
            name = "reserved";
            desc = "Reserved";
            sw = r; hw = w;
            reset = 0x0;
        } reserved_15_10[15:10];
        field {
            name = "coef0";
            desc = "IFIR filtering coefficient 0";
            sw = rw; hw = r;
            reset = 0x3f5;
        } coef0[9:0];
    } V3_IFIRCOEF01 @ 0x3980;
    reg {
        name = "V3_IFIRCOEF23";
        desc = "V3_IFIRCOEF23 is an IFIR filtering coefficient 2/3 register. (offset 0x3984; total reset 0x001C03EC; PROVEN: Hi3521A/Hi3520D V300 data sheet (Issue 00B07, 2015-12-10), section 5.10, PDF page 1303).";
        field {
            name = "reserved";
            desc = "Reserved";
            sw = r; hw = w;
            reset = 0x0;
        } reserved_31_26[31:26];
        field {
            name = "coef3";
            desc = "IFIR filtering coefficient 3";
            sw = rw; hw = r;
            reset = 0x1c;
        } coef3[25:16];
        field {
            name = "reserved";
            desc = "Reserved";
            sw = r; hw = w;
            reset = 0x0;
        } reserved_15_10[15:10];
        field {
            name = "coef2";
            desc = "IFIR filtering coefficient 2";
            sw = rw; hw = r;
            reset = 0x3ec;
        } coef2[9:0];
    } V3_IFIRCOEF23 @ 0x3984;
    reg {
        name = "V3_IFIRCOEF45";
        desc = "V3_IFIRCOEF45 is an IFIR filtering coefficient 4/5 register. (offset 0x3988; total reset 0x003D03D8; PROVEN: Hi3521A/Hi3520D V300 data sheet (Issue 00B07, 2015-12-10), section 5.10, PDF page 1304).";
        field {
            name = "reserved";
            desc = "Reserved";
            sw = r; hw = w;
            reset = 0x0;
        } reserved_31_26[31:26];
        field {
            name = "coef5";
            desc = "IFIR filtering coefficient 5";
            sw = rw; hw = r;
            reset = 0x3d;
        } coef5[25:16];
        field {
            name = "reserved";
            desc = "Reserved";
            sw = r; hw = w;
            reset = 0x0;
        } reserved_15_10[15:10];
        field {
            name = "coef4";
            desc = "IFIR filtering coefficient 4";
            sw = rw; hw = r;
            reset = 0x3d8;
        } coef4[9:0];
    } V3_IFIRCOEF45 @ 0x3988;
    reg {
        name = "V3_IFIRCOEF67";
        desc = "V3_IFIRCOEF67 is an IFIR filtering coefficient 6/7 register. (offset 0x398C; total reset 0x014A0395; PROVEN: Hi3521A/Hi3520D V300 data sheet (Issue 00B07, 2015-12-10), section 5.10, PDF page 1304).";
        field {
            name = "reserved";
            desc = "Reserved";
            sw = r; hw = w;
            reset = 0x0;
        } reserved_31_26[31:26];
        field {
            name = "coef7";
            desc = "IFIR filtering coefficient 7";
            sw = rw; hw = r;
            reset = 0x14a;
        } coef7[25:16];
        field {
            name = "reserved";
            desc = "Reserved";
            sw = r; hw = w;
            reset = 0x0;
        } reserved_15_10[15:10];
        field {
            name = "coef6";
            desc = "IFIR filtering coefficient 6";
            sw = rw; hw = r;
            reset = 0x395;
        } coef6[9:0];
    } V3_IFIRCOEF67 @ 0x398C;
    reg {
        name = "V3_P0RESO";
        desc = "V3_P0RESO is V3 region 0 resolution register (non-instant register). (offset 0x3A00; total reset 0x00000000; PROVEN: Hi3521A/Hi3520D V300 data sheet (Issue 00B07, 2015-12-10), section 5.10, PDF page 1305).";
        field {
            name = "reserved";
            desc = "Reserved";
            sw = rw; hw = r;
            reset = 0x0;
        } reserved_31_12[31:12];
        field {
            name = "w";
            desc = "Width (in pixel). The value is the actual width minus 1. Note: The actual width must be an even number.";
            sw = rw; hw = r;
            reset = 0x0;
        } w_f[11:0];
    } V3_P0RESO @ 0x3A00;
    reg {
        name = "V3_P0LADDR";
        desc = "V3_P0LADDR is a V3 region 0 luminance address register. (offset 0x3A04; total reset 0x00000000; PROVEN: Hi3521A/Hi3520D V300 data sheet (Issue 00B07, 2015-12-10), section 5.10, PDF page 1305).";
        field {
            name = "surface_addr";
            desc = "Luminance start address for VHD region 0";
            sw = rw; hw = r;
            reset = 0x0;
        } surface_addr[31:0];
    } V3_P0LADDR @ 0x3A04;
    reg {
        name = "V3_P0CADDR";
        desc = "V3_P0CADDR is a V3 region 0 chrominance address register. (offset 0x3A08; total reset 0x00000000; PROVEN: Hi3521A/Hi3520D V300 data sheet (Issue 00B07, 2015-12-10), section 5.10, PDF page 1305).";
        field {
            name = "surface_addr";
            desc = "Chrominance start address for VHD region 0";
            sw = rw; hw = r;
            reset = 0x0;
        } surface_addr[31:0];
    } V3_P0CADDR @ 0x3A08;
    reg {
        name = "V3_P0STRIDE";
        desc = "V3_P0STRIDE is a V3 region 0 stride register. (offset 0x3A0C; total reset 0x00000000; PROVEN: Hi3521A/Hi3520D V300 data sheet (Issue 00B07, 2015-12-10), section 5.10, PDF page 1306).";
        field {
            name = "surface_cstride";
            desc = "Stride of the chrominance buffer of VHD region 0 (valid in semi- planar format), 128-bit alignment";
            sw = rw; hw = r;
            reset = 0x0;
        } surface_cstride[31:16];
        field {
            name = "surface_stride";
            desc = "Luminance stride of the luminance buffer of VHD region 0 (valid in semi-planar format), 128-bit alignment";
            sw = rw; hw = r;
            reset = 0x0;
        } surface_stride[15:0];
    } V3_P0STRIDE @ 0x3A0C;
    reg {
        name = "V3_P0VFPOS";
        desc = "V3_P0VFPOS is a video content start position (in the display window) register (non-instant) for V3 region 0. The position unit is pixel. (offset 0x3A10; total reset 0x00000000; PROVEN: Hi3521A/Hi3520D V300 data sheet (Issue 00B07, 2015-12-10), section 5.10, PDF page 1306).";
        field {
            name = "reserved";
            desc = "Reserved";
            sw = rw; hw = r;
            reset = 0x0;
        } reserved_31_24[31:24];
        field {
            name = "video_yfpos";
            desc = "Start coordinates of the video column The frame height is referenced and the unit is line.";
            sw = rw; hw = r;
            reset = 0x0;
        } video_yfpos[23:12];
        field {
            name = "video_xfpos";
            desc = "Start coordinates of the video row";
            sw = rw; hw = r;
            reset = 0x0;
        } video_xfpos[11:0];
    } V3_P0VFPOS @ 0x3A10;
    reg {
        name = "V3_P0VLPOS";
        desc = "V3_P0VLPOS is a video content end position (in the display window) register (non-instant) for V3 region 0. The position unit is pixel. (offset 0x3A14; total reset 0x00000000; PROVEN: Hi3521A/Hi3520D V300 data sheet (Issue 00B07, 2015-12-10), section 5.10, PDF page 1307).";
        field {
            name = "reserved";
            desc = "Reserved";
            sw = rw; hw = r;
            reset = 0x0;
        } reserved_31_24[31:24];
        field {
            name = "video_ylpos";
            desc = "End coordinates of the video column The frame height is referenced and the unit is line.";
            sw = rw; hw = r;
            reset = 0x0;
        } video_ylpos[23:12];
        field {
            name = "video_xlpos";
            desc = "End coordinates of the video row";
            sw = rw; hw = r;
            reset = 0x0;
        } video_xlpos[11:0];
    } V3_P0VLPOS @ 0x3A14;
    reg {
        name = "V3_P0CTRL";
        desc = "V3_P0CTRL is a V3 region 0 control register. (offset 0x3A18; total reset 0x00000000; PROVEN: Hi3521A/Hi3520D V300 data sheet (Issue 00B07, 2015-12-10), section 5.10, PDF page 1307).";
        field {
            name = "reserved";
            desc = "Reserved";
            sw = rw; hw = r;
            reset = 0x0;
        } reserved_31_7[31:7];
        field {
            name = "mute_en";
            desc = "Region 0 mute enable
- 0: disabled
- 1: enabled";
            sw = rw; hw = r;
            reset = 0x0;
        } mute_en[6:6];
        field {
            name = "p0_en";
            desc = "Region 0 enable
- 0: disabled
- 1: enabled";
            sw = rw; hw = r;
            reset = 0x0;
        } p0_en[5:5];
        field {
            name = "p0_dcmp_en";
            desc = "Region 0 decompression enable
- 0: disabled
- 1: enabled";
            sw = rw; hw = r;
            reset = 0x0;
        } p0_dcmp_en[4:4];
        field {
            name = "p0_l_loss_en";
            desc = "Region 0 l_loss enable
- 0: disabled
- 1: enabled";
            sw = rw; hw = r;
            reset = 0x0;
        } p0_l_loss_en[3:3];
        field {
            name = "p0_c_loss_en";
            desc = "Region 0 c_loss enable
- 0: disabled
- 1: enabled";
            sw = rw; hw = r;
            reset = 0x0;
        } p0_c_loss_en[2:2];
        field {
            name = "p0_rim_en";
            desc = "Region 0 rim enable
- 0: disabled
- 1: enabled";
            sw = rw; hw = r;
            reset = 0x0;
        } p0_rim_en[1:1];
        field {
            name = "p0_rim_col_mod";
            desc = "Region 0 rim_mod select
- 0: color 0
- 1: color 1";
            sw = rw; hw = r;
            reset = 0x0;
        } p0_rim_col_mod[0:0];
    } V3_P0CTRL @ 0x3A18;
    reg {
        name = "V3_MULTI_MODE";
        desc = "V3_MULTI_MODE is a multi-region mode enable register. This register must be enabled when there are multiple regions. (offset 0x4230; total reset 0x00000001; PROVEN: Hi3521A/Hi3520D V300 data sheet (Issue 00B07, 2015-12-10), section 5.10, PDF page 1308).";
        field {
            name = "reserved";
            desc = "Reserved";
            sw = rw; hw = r;
            reset = 0x0;
        } reserved_31_1[31:1];
        field {
            name = "mrg_mode";
            desc = "Multi-region mode enable (valid only for V1 or V4)
- 0: single-region mode (with LBOX)
- 1: multi-region mode (without LBOX)";
            sw = rw; hw = r;
            reset = 0x1;
        } mrg_mode[0:0];
    } V3_MULTI_MODE @ 0x4230;
    reg {
        name = "V3_FDRFIFOTHD";
        desc = "V3_FDRFIFOTHD is a V3 FDR FIFO threshold register (non-instant register). (offset 0x4250; total reset 0x00000020; PROVEN: Hi3521A/Hi3520D V300 data sheet (Issue 00B07, 2015-12-10), section 5.10, PDF page 1309). INFERRED: the register header of the data sheet prints the name V0_FDRFIFOTHD; the title, the description and the summary table (Table 10-x) say V3_FDRFIFOTHD.";
        field {
            name = "reserved";
            desc = "Reserved";
            sw = r; hw = w;
            reset = 0x0;
        } reserved_31_10[31:10];
        field {
            name = "ff_thd";
            desc = "FDR FIFO threshold. The minimum value is 32. The value must be 2 to the power of n.";
            sw = rw; hw = r;
            reset = 0x20;
        } ff_thd[9:0];
    } V3_FDRFIFOTHD @ 0x4250;
    reg {
        name = "V3_MRGERRCLR";
        desc = "V3_MRGERRCLR is a V3 multi-region register operation error status clear register. Writing 1 clears this register. (offset 0x4350; total reset 0x00000000; PROVEN: Hi3521A/Hi3520D V300 data sheet (Issue 00B07, 2015-12-10), section 5.10, PDF page 1309).";
        field {
            name = "reserved";
            desc = "Reserved";
            sw = r; hw = w;
            reset = 0x0;
        } reserved_31_1[31:1];
        field {
            name = "mrg_errclr";
            desc = "VO multi-region register operation error status clear register
- 0: not cleared
- 1: cleared";
            sw = rw; hw = r;
            reset = 0x0;
        } mrg_errclr[0:0];
    } V3_MRGERRCLR @ 0x4350;
    reg {
        name = "V3_MRG_ERR";
        desc = "V3_MRG_ERR is a V3 multi-region register operation error signal register. (offset 0x4354; total reset 0x00000000; PROVEN: Hi3521A/Hi3520D V300 data sheet (Issue 00B07, 2015-12-10), section 5.10, PDF page 1310).";
        field {
            name = "reserved";
            desc = "Reserved";
            sw = r; hw = w;
            reset = 0x0;
        } reserved_31_1[31:1];
        field {
            name = "mrg_wrong";
            desc = "V3 multi-region register operation error signal register
- 0: The multi-region register operation is correct.
- 1: The multi-region register operation is incorrect.";
            sw = r; hw = w;
            reset = 0x0;
        } mrg_wrong[0:0];
    } V3_MRG_ERR @ 0x4354;
    reg {
        name = "G4_CTRL";
        desc = "G4_CTRL is a G4 configuration register (non-instant register). (offset 0x8000; total reset 0x40000000; PROVEN: Hi3521A/Hi3520D V300 data sheet (Issue 00B07, 2015-12-10), section 5.10, PDF page 1310).";
        field {
            name = "surface_en";
            desc = "Surface enable (non-instant register)
- 0: disabled
- 1: enabled";
            sw = rw; hw = r;
            reset = 0x0;
        } surface_en[31:31];
        field {
            name = "reserved";
            desc = "Reserved";
            sw = r; hw = w;
            reset = 0x1;
        } reserved_30_30[30:30];
        field {
            name = "reserved";
            desc = "Reserved";
            sw = r; hw = w;
            reset = 0x0;
        } reserved_29_29[29:29];
        field {
            name = "reserved";
            desc = "Reserved";
            sw = r; hw = w;
            reset = 0x0;
        } reserved_28_28[28:28];
        field {
            name = "upd_mode";
            desc = "Update mode
- 0: update by frame
- 1: update by field";
            sw = rw; hw = r;
            reset = 0x0;
        } upd_mode[27:27];
        field {
            name = "read_mode";
            desc = "Data read mode
- 0: The read mode is automatically selected based on the interface read mode. That is, the progressive read mode is selected in progressive display mode, and the interlaced read mode is selected in interlaced display mode.
- 1: The progressive read mode is selected forcibly.";
            sw = rw; hw = r;
            reset = 0x0;
        } read_mode[26:26];
        field {
            name = "dcmp_en";
            desc = "Decompression enable
- 0: disabled
- 1: enabled";
            sw = rw; hw = r;
            reset = 0x0;
        } dcmp_en[25:25];
        field {
            name = "reserved";
            desc = "Reserved";
            sw = r; hw = w;
            reset = 0x0;
        } reserved_24_24[24:24];
        field {
            name = "lossless";
            desc = "Compression mode select
- 0: lossy compression
- 1: lossless compression";
            sw = rw; hw = r;
            reset = 0x0;
        } lossless[23:23];
        field {
            name = "lossless_a";
            desc = "Compression mode select for a
- 0: lossy compression of a
- 1: lossless compression of a";
            sw = rw; hw = r;
            reset = 0x0;
        } lossless_a[22:22];
        field {
            name = "cmp_mode";
            desc = "Compressed data type
- 1: RAM mode
- 0: compression mode";
            sw = rw; hw = r;
            reset = 0x0;
        } cmp_mode[21:21];
        field {
            name = "reserved";
            desc = "Reserved";
            sw = r; hw = w;
            reset = 0x0;
        } reserved_20_15[20:15];
        field {
            name = "req_ctrl";
            desc = "Register for controlling the number of 16-burst requested consecutively at a time
- 0x0: One 16-burst is requested consecutively at a time.
- 0x1: Two 16-burst are requested consecutively at a time.
- 0x2: Four 16-burst are requested consecutively at a time.
- 0x3: Eight 16-burst are requested consecutively at a time.

Other values: reserved";
            sw = rw; hw = r;
            reset = 0x0;
        } req_ctrl[14:12];
        field {
            name = "reserved";
            desc = "Reserved";
            sw = r; hw = w;
            reset = 0x0;
        } reserved_11_10[11:10];
        field {
            name = "bitext";
            desc = "Bit extend mode of the input bitmap
- 00: extend 0s to lower bits
- 01: reserved
- 10: extend the value of the MSB to a lower bit
- 11: extend the values of upper bits to lower bits";
            sw = rw; hw = r;
            reset = 0x0;
        } bitext[9:8];
        field {
            name = "ifmt";
            desc = "Format of the input data
- 0x49: ARGB1555
- 0x68: ARGB8888

Other values: reserved";
            sw = rw; hw = r;
            reset = 0x0;
        } ifmt[7:0];
    } G4_CTRL @ 0x8000;
    reg {
        name = "G4_UPD";
        desc = "G4_UPD is a G4 update enable register. (offset 0x8004; total reset 0x00000000; PROVEN: Hi3521A/Hi3520D V300 data sheet (Issue 00B07, 2015-12-10), section 5.10, PDF page 1312).";
        field {
            name = "reserved";
            desc = "Reserved";
            sw = r; hw = w;
            reset = 0x0;
        } reserved_31_1[31:1];
        field {
            name = "regup";
            desc = "Surface register update. After the registers at this layer are configured, the registers are updated when the value 1 is written to this bit. After updates, this bit is automatically cleared by the hardware.";
            sw = w; hw = r;
            reset = 0x0;
        } regup[0:0];
    } G4_UPD @ 0x8004;
    reg {
        name = "G4_ADDR";
        desc = "G4_ADDR is a G4 address register. When the horizontal pixel offsets, you need to calculate the address by following the description of G4_SFPOS. (offset 0x8010; total reset 0x00000000; PROVEN: Hi3521A/Hi3520D V300 data sheet (Issue 00B07, 2015-12-10), section 5.10, PDF page 1312).";
        field {
            name = "surface_addr";
            desc = "Address for the surface frame buffer";
            sw = rw; hw = r;
            reset = 0x0;
        } surface_addr[31:0];
    } G4_ADDR @ 0x8010;
    reg {
        name = "G4_STRIDE";
        desc = "G4_STRIDE is a G4 stride register. (offset 0x801C; total reset 0x00000000; PROVEN: Hi3521A/Hi3520D V300 data sheet (Issue 00B07, 2015-12-10), section 5.10, PDF page 1313).";
        field {
            name = "reserved";
            desc = "Reserved";
            sw = r; hw = w;
            reset = 0x0;
        } reserved_31_16[31:16];
        field {
            name = "surface_stride";
            desc = "Frame buffer stride";
            sw = rw; hw = r;
            reset = 0x0;
        } surface_stride[15:0];
    } G4_STRIDE @ 0x801C;
    reg {
        name = "G4_IRESO";
        desc = "G4_IRESO is a G4 input resolution register (non-instant register). (offset 0x8020; total reset 0x00000000; PROVEN: Hi3521A/Hi3520D V300 data sheet (Issue 00B07, 2015-12-10), section 5.10, PDF page 1313).";
        field {
            name = "reserved";
            desc = "Reserved";
            sw = r; hw = w;
            reset = 0x0;
        } reserved_31_24[31:24];
        field {
            name = "ih";
            desc = "Height (in line). The value is the actual height minus 1. Note: In interlaced output mode, the actual layer height must be an even number. There is no such limitation in progressive output mode.";
            sw = rw; hw = r;
            reset = 0x0;
        } ih[23:12];
        field {
            name = "iw";
            desc = "Width (in pixel). The value is the actual width minus 1. Note: The actual layer width must be an even number.";
            sw = rw; hw = r;
            reset = 0x0;
        } iw[11:0];
    } G4_IRESO @ 0x8020;
    reg {
        name = "G4_SFPOS";
        desc = "G4_SFPOS is a G4 surface read data start position (in the source bitmap) register (non-instant register). If the read position is not 128-bit-word-aligned, this register indicates the number of pixels required for completing a 128-bit word. Note: The start position offset must be less than or equal to a 128-bit word. The exceeded part is expressed by an address. The details are as follows: The following assumes that the start address for the graphics layer of the source picture is addr_ori, the address configured for the logical graphics layer is addr_offset, the graphics layer offset is offsetp (in pixel), and the data format at the graphics layer is bpp (for example, the bpp for ARGB8888 is 32). The formulas are as follows: G4ADDR = addr_offset = addr_ori + int (offset x bpp/128) G4SFPOS = offset%128 where int indicates the rounding operation, and % indicates the modulo operation. (offset 0x8024; total reset 0x00000000; PROVEN: Hi3521A/Hi3520D V300 data sheet (Issue 00B07, 2015-12-10), section 5.10, PDF page 1314).";
        field {
            name = "reserved";
            desc = "Reserved";
            sw = r; hw = w;
            reset = 0x0;
        } reserved_31_7[31:7];
        field {
            name = "src_xfpos";
            desc = "Start horizontal coordinate of the source picture. The value 0 indicates the first pixel of a line.";
            sw = rw; hw = r;
            reset = 0x0;
        } src_xfpos[6:0];
    } G4_SFPOS @ 0x8024;
    reg {
        name = "G4_CBMPARA";
        desc = "G4_CBMPARA is a G4 overlay parameter register (non-instant register). (offset 0x8030; total reset 0x00000000; PROVEN: Hi3521A/Hi3520D V300 data sheet (Issue 00B07, 2015-12-10), section 5.10, PDF page 1314).";
        field {
            name = "reserved";
            desc = "Reserved";
            sw = r; hw = w;
            reset = 0x0;
        } reserved_31_16[31:16];
        field {
            name = "key_mode";
            desc = "Colorkey mode
- 0: The color is regarded as the colorkey when the following condition is met: Keymin ≤ Pixel ≤ Keymax
- 1: The color is regarded as the colorkey when either of the following conditions is met: Pixel ≤ Keymin or Pixel ≥ Keymax";
            sw = rw; hw = r;
            reset = 0x0;
        } key_mode[15:15];
        field {
            name = "key_en";
            desc = "Colorkey enable
- 0: disabled
- 1: enabled";
            sw = rw; hw = r;
            reset = 0x0;
        } key_en[14:14];
        field {
            name = "premult_en";
            desc = "Whether the input bitmap is a premultiplied bitmap
- 0: non-premultiplied bitmap
- 1: premultiplied bitmap";
            sw = rw; hw = r;
            reset = 0x0;
        } premult_en[13:13];
        field {
            name = "palpha_en";
            desc = "Pixel alpha enable
- 0: disabled
- 1: enabled";
            sw = rw; hw = r;
            reset = 0x0;
        } palpha_en[12:12];
        field {
            name = "reserved";
            desc = "Reserved";
            sw = r; hw = w;
            reset = 0x0;
        } reserved_11_11[11:11];
        field {
            name = "reserved";
            desc = "Reserved";
            sw = r; hw = w;
            reset = 0x0;
        } reserved_10_10[10:10];
        field {
            name = "reserved";
            desc = "Reserved";
            sw = r; hw = w;
            reset = 0x0;
        } reserved_9_9[9:9];
        field {
            name = "palpha_range";
            desc = "Pixel alpha range selection
- 0: The pixel alpha range is 0-128.
- 1: The pixel alpha range is 0-255.";
            sw = rw; hw = r;
            reset = 0x0;
        } palpha_range[8:8];
        field {
            name = "galpha";
            desc = "Overlay global alpha value. The value ranges from 0 to 128. The value 128 indicates opaque, and the value 0 indicates full transparent.";
            sw = rw; hw = r;
            reset = 0x0;
        } galpha[7:0];
    } G4_CBMPARA @ 0x8030;
    reg {
        name = "G4_CKEYMAX";
        desc = "G4_CKEYMAX is a G4 maximum colorkey register (non-instant register). (offset 0x8034; total reset 0x00000000; PROVEN: Hi3521A/Hi3520D V300 data sheet (Issue 00B07, 2015-12-10), section 5.10, PDF page 1315).";
        field {
            name = "va0";
            desc = "Alpha0 value. When the data format is alphaRGB1555 and the alpha value is 0, the alpha0 value is used.";
            sw = rw; hw = r;
            reset = 0x0;
        } va0[31:24];
        field {
            name = "keyr_max";
            desc = "Maximum value of the colorkey R component";
            sw = rw; hw = r;
            reset = 0x0;
        } keyr_max[23:16];
        field {
            name = "keyg_max";
            desc = "Maximum value of the colorkey G component";
            sw = rw; hw = r;
            reset = 0x0;
        } keyg_max[15:8];
        field {
            name = "keyb_max";
            desc = "Maximum value of the colorkey B component";
            sw = rw; hw = r;
            reset = 0x0;
        } keyb_max[7:0];
    } G4_CKEYMAX @ 0x8034;
    reg {
        name = "G4_CKEYMIN";
        desc = "G4_CKEYMIN is a G4 minimum colorkey register (non-instant register). (offset 0x8038; total reset 0x00000000; PROVEN: Hi3521A/Hi3520D V300 data sheet (Issue 00B07, 2015-12-10), section 5.10, PDF page 1316).";
        field {
            name = "va1";
            desc = "Alpha1 value. When the data format is alphaRGB1555 and the alpha value is 1, the alpha1 value is used.";
            sw = rw; hw = r;
            reset = 0x0;
        } va1[31:24];
        field {
            name = "keyr_min";
            desc = "Minimum value of the colorkey R component";
            sw = rw; hw = r;
            reset = 0x0;
        } keyr_min[23:16];
        field {
            name = "keyg_min";
            desc = "Minimum value of the colorkey G component";
            sw = rw; hw = r;
            reset = 0x0;
        } keyg_min[15:8];
        field {
            name = "keyb_min";
            desc = "Minimum value of the colorkey B component";
            sw = rw; hw = r;
            reset = 0x0;
        } keyb_min[7:0];
    } G4_CKEYMIN @ 0x8038;
    reg {
        name = "G4_CMASK";
        desc = "G4_CMASK is a G4 masked colorkey register (non-instant register). The value 1 indicates that the bit corresponding to a pixel is retained during colorkey comparison; the value 0 indicates that the bit corresponding to a pixel is forcibly set to 0 during color comparison no matter whether the bit is 0 or 1. (offset 0x803C; total reset 0xFFFFFFFF; PROVEN: Hi3521A/Hi3520D V300 data sheet (Issue 00B07, 2015-12-10), section 5.10, PDF page 1316).";
        field {
            name = "reserved";
            desc = "Reserved";
            sw = r; hw = w;
            reset = 0xff;
        } reserved_31_24[31:24];
        field {
            name = "kmsk_r";
            desc = "R component of the masked colorkey";
            sw = rw; hw = r;
            reset = 0xff;
        } kmsk_r[23:16];
        field {
            name = "kmsk_g";
            desc = "G component of the masked colorkey";
            sw = rw; hw = r;
            reset = 0xff;
        } kmsk_g[15:8];
        field {
            name = "kmsk_b";
            desc = "B component of the masked colorkey";
            sw = rw; hw = r;
            reset = 0xff;
        } kmsk_b[7:0];
    } G4_CMASK @ 0x803C;
    reg {
        name = "G4_FIFOTHD";
        desc = "G4_FIFOTHD is a G4 buffer threshold register. (offset 0x8048; total reset 0x800003C0; PROVEN: Hi3521A/Hi3520D V300 data sheet (Issue 00B07, 2015-12-10), section 5.10, PDF page 1317).";
        field {
            name = "reserved";
            desc = "Reserved";
            sw = r; hw = w;
            reset = 0x200000;
        } reserved_31_10[31:10];
        field {
            name = "buf_wr_thd";
            desc = "Buffer threshold";
            sw = rw; hw = r;
            reset = 0x3c0;
        } buf_wr_thd[9:0];
    } G4_FIFOTHD @ 0x8048;
    reg {
        name = "G4_DCMP_DBG";
        desc = "G4_DCMP_DBG is a debugging signal register for the DCMP module. (offset 0x8060; total reset 0x00000000; PROVEN: Hi3521A/Hi3520D V300 data sheet (Issue 00B07, 2015-12-10), section 5.10, PDF page 1317).";
        field {
            name = "dcmp_dbg";
            desc = "Status information about the DCMP module. The initial value can be changed.";
            sw = r; hw = w;
            reset = 0x0;
        } dcmp_dbg[31:0];
    } G4_DCMP_DBG @ 0x8060;
    reg {
        name = "G4_DCMP_INTER";
        desc = "G0_DCMP_INTER is an error interrupt information register for the DCMP module. (offset 0x8070; total reset 0x00000000; PROVEN: Hi3521A/Hi3520D V300 data sheet (Issue 00B07, 2015-12-10), section 5.10, PDF page 1318).";
        field {
            name = "reserved";
            desc = "Reserved";
            sw = r; hw = w;
            reset = 0x0;
        } reserved_31_1[31:1];
        field {
            name = "gdccerrclr";
            desc = "This interrupt register indicates whether the output of the DCMP module is correct. If an error occurs, the bit is 1. Writing 1 clears the interrupt.

Access type WC in the data sheet: written 1 clears the bit.";
            sw = rw; hw = w; onwrite = woclr;
            reset = 0x0;
        } gdccerrclr[0:0];
    } G4_DCMP_INTER @ 0x8070;
    reg {
        name = "G4_DFPOS";
        desc = "G4_DFPOS is a G4 surface start position (in the display window) register (non-instant register). The position unit is pixel. (offset 0x8080; total reset 0x00000000; PROVEN: Hi3521A/Hi3520D V300 data sheet (Issue 00B07, 2015-12-10), section 5.10, PDF page 1318).";
        field {
            name = "reserved";
            desc = "Reserved";
            sw = r; hw = w;
            reset = 0x0;
        } reserved_31_24[31:24];
        field {
            name = "disp_yfpos";
            desc = "Column start coordinates";
            sw = rw; hw = r;
            reset = 0x0;
        } disp_yfpos[23:12];
        field {
            name = "disp_xfpos";
            desc = "Row start coordinates";
            sw = rw; hw = r;
            reset = 0x0;
        } disp_xfpos[11:0];
    } G4_DFPOS @ 0x8080;
    reg {
        name = "G4_DLPOS";
        desc = "G4_DLPOS is a G4 surface end position (in the display window) register (non-instant register). The position unit is pixel. (offset 0x8084; total reset 0x00000000; PROVEN: Hi3521A/Hi3520D V300 data sheet (Issue 00B07, 2015-12-10), section 5.10, PDF page 1319).";
        field {
            name = "reserved";
            desc = "Reserved";
            sw = r; hw = w;
            reset = 0x0;
        } reserved_31_24[31:24];
        field {
            name = "disp_ylpos";
            desc = "Column end coordinates";
            sw = rw; hw = r;
            reset = 0x0;
        } disp_ylpos[23:12];
        field {
            name = "disp_xlpos";
            desc = "Row end coordinates";
            sw = rw; hw = r;
            reset = 0x0;
        } disp_xlpos[11:0];
    } G4_DLPOS @ 0x8084;
    reg {
        name = "G4_CSC_IDC";
        desc = "G4_CSC_IDC is a G4 CSC input DC component register (instant register). (offset 0x80C0; total reset 0x00000000; PROVEN: Hi3521A/Hi3520D V300 data sheet (Issue 00B07, 2015-12-10), section 5.10, PDF page 1319).";
        field {
            name = "reserved";
            desc = "Reserved";
            sw = r; hw = w;
            reset = 0x0;
        } reserved_31_26[31:26];
        field {
            name = "csc_mode";
            desc = "This field is valid only when the G2 CSC coefficients are fixed.
- 000: reserved
- 001: YUV2YUV
- 010: YUV601_RGB
- 011: YUV709_RGB
- 100: YUV2YUV_709_601
- 101: YUV2YUV_601_709
- 110: RGB2YUV_601
- 111: RGB2YUV_709";
            sw = rw; hw = r;
            reset = 0x0;
        } csc_mode[25:23];
        field {
            name = "csc_en";
            desc = "CSC enable
- 0: disabled
- 1: enabled";
            sw = rw; hw = r;
            reset = 0x0;
        } csc_en[22:22];
        field {
            name = "cscidc1";
            desc = "DC parameter of input component 1. The MSB is the signed bit. The value is expressed as a complement.";
            sw = rw; hw = r;
            reset = 0x0;
        } cscidc1[21:11];
        field {
            name = "cscidc0";
            desc = "DC parameter of input component 0. The MSB is the signed bit. The value is expressed as a complement.";
            sw = rw; hw = r;
            reset = 0x0;
        } cscidc0[10:0];
    } G4_CSC_IDC @ 0x80C0;
    reg {
        name = "G4_CSC_ODC";
        desc = "G4_CSC_ODC is a G4 CSC output DC component register (instant register). (offset 0x80C4; total reset 0x00000000; PROVEN: Hi3521A/Hi3520D V300 data sheet (Issue 00B07, 2015-12-10), section 5.10, PDF page 1320).";
        field {
            name = "reserved";
            desc = "Reserved";
            sw = r; hw = w;
            reset = 0x0;
        } reserved_31_23[31:23];
        field {
            name = "csc_sign_mode";
            desc = "CSC output mode
- 0: The CSC output is a 10-bit unsigned number.
- 1: The CSC output is a 12-bit signed number.";
            sw = rw; hw = r;
            reset = 0x0;
        } csc_sign_mode[22:22];
        field {
            name = "cscodc1";
            desc = "DC parameter of output component 1. The MSB is the signed bit. The value is expressed as a complement.";
            sw = rw; hw = r;
            reset = 0x0;
        } cscodc1[21:11];
        field {
            name = "cscodc0";
            desc = "DC parameter of output component 0. The MSB is the signed bit. The value is expressed as a complement.";
            sw = rw; hw = r;
            reset = 0x0;
        } cscodc0[10:0];
    } G4_CSC_ODC @ 0x80C4;
    reg {
        name = "G4_CSC_IODC";
        desc = "G4_CSC_IODC is a G4 CSC input/output DC component register (instant register). (offset 0x80C8; total reset 0x00000000; PROVEN: Hi3521A/Hi3520D V300 data sheet (Issue 00B07, 2015-12-10), section 5.10, PDF page 1321).";
        field {
            name = "reserved";
            desc = "Reserved";
            sw = r; hw = w;
            reset = 0x0;
        } reserved_31_22[31:22];
        field {
            name = "cscodc2";
            desc = "DC parameter of output component 2. The MSB is the signed bit. The value is expressed as a complement.";
            sw = rw; hw = r;
            reset = 0x0;
        } cscodc2[21:11];
        field {
            name = "cscidc2";
            desc = "DC parameter of input component 2. The MSB is the signed bit. The value is expressed as a complement.";
            sw = rw; hw = r;
            reset = 0x0;
        } cscidc2[10:0];
    } G4_CSC_IODC @ 0x80C8;
    reg {
        name = "G4_CSC_P0";
        desc = "G4_CSC_P0 is a G4 CSC parameter 0 register (instant register). (offset 0x80CC; total reset 0x00000000; PROVEN: Hi3521A/Hi3520D V300 data sheet (Issue 00B07, 2015-12-10), section 5.10, PDF page 1321).";
        field {
            name = "reserved";
            desc = "Reserved";
            sw = r; hw = w;
            reset = 0x0;
        } reserved_31_31[31:31];
        field {
            name = "cscp01";
            desc = "5.10 data format indicating one sign bit, four integer bits, and 10 decimal bits. The value is represented by a complement.";
            sw = rw; hw = r;
            reset = 0x0;
        } cscp01[30:16];
        field {
            name = "reserved";
            desc = "Reserved";
            sw = r; hw = w;
            reset = 0x0;
        } reserved_15_15[15:15];
        field {
            name = "cscp00";
            desc = "5.10 data format indicating one sign bit, four integer bits, and 10 decimal bits. The value is represented by a complement.";
            sw = rw; hw = r;
            reset = 0x0;
        } cscp00[14:0];
    } G4_CSC_P0 @ 0x80CC;
    reg {
        name = "G4_CSC_P1";
        desc = "G4_CSC_P1 is a G4 CSC parameter 1 register (instant register). (offset 0x80D0; total reset 0x00000000; PROVEN: Hi3521A/Hi3520D V300 data sheet (Issue 00B07, 2015-12-10), section 5.10, PDF page 1322).";
        field {
            name = "reserved";
            desc = "Reserved";
            sw = r; hw = w;
            reset = 0x0;
        } reserved_31_31[31:31];
        field {
            name = "cscp10";
            desc = "5.10 data format indicating one sign bit, four integer bits, and 10 decimal bits. The value is represented by a complement.";
            sw = rw; hw = r;
            reset = 0x0;
        } cscp10[30:16];
        field {
            name = "reserved";
            desc = "Reserved";
            sw = r; hw = w;
            reset = 0x0;
        } reserved_15_15[15:15];
        field {
            name = "cscp02";
            desc = "5.10 data format indicating one sign bit, four integer bits, and 10 decimal bits. The value is represented by a complement.";
            sw = rw; hw = r;
            reset = 0x0;
        } cscp02[14:0];
    } G4_CSC_P1 @ 0x80D0;
    reg {
        name = "G4_CSC_P2";
        desc = "G4_CSC_P2 is a G4 CSC parameter 2 register (instant register). (offset 0x80D4; total reset 0x00000000; PROVEN: Hi3521A/Hi3520D V300 data sheet (Issue 00B07, 2015-12-10), section 5.10, PDF page 1322).";
        field {
            name = "reserved";
            desc = "Reserved";
            sw = r; hw = w;
            reset = 0x0;
        } reserved_31_31[31:31];
        field {
            name = "cscp12";
            desc = "5.10 data format indicating one sign bit, four integer bits, and 10 decimal bits. The value is represented by a complement.";
            sw = rw; hw = r;
            reset = 0x0;
        } cscp12[30:16];
        field {
            name = "reserved";
            desc = "Reserved";
            sw = r; hw = w;
            reset = 0x0;
        } reserved_15_15[15:15];
        field {
            name = "cscp11";
            desc = "5.10 data format indicating one sign bit, four integer bits, and 10 decimal bits. The value is represented by a complement.";
            sw = rw; hw = r;
            reset = 0x0;
        } cscp11[14:0];
    } G4_CSC_P2 @ 0x80D4;
    reg {
        name = "G4_CSC_P3";
        desc = "G4_CSC_P3 is a G4 CSC parameter 3 register (instant register). (offset 0x80D8; total reset 0x00000000; PROVEN: Hi3521A/Hi3520D V300 data sheet (Issue 00B07, 2015-12-10), section 5.10, PDF page 1323).";
        field {
            name = "reserved";
            desc = "Reserved";
            sw = r; hw = w;
            reset = 0x0;
        } reserved_31_31[31:31];
        field {
            name = "cscp21";
            desc = "5.10 data format indicating one sign bit, four integer bits, and 10 decimal bits. The value is represented by a complement.";
            sw = rw; hw = r;
            reset = 0x0;
        } cscp21[30:16];
        field {
            name = "reserved";
            desc = "Reserved";
            sw = r; hw = w;
            reset = 0x0;
        } reserved_15_15[15:15];
        field {
            name = "cscp20";
            desc = "5.10 data format indicating one sign bit, four integer bits, and 10 decimal bits. The value is represented by a complement.";
            sw = rw; hw = r;
            reset = 0x0;
        } cscp20[14:0];
    } G4_CSC_P3 @ 0x80D8;
    reg {
        name = "G4_CSC_P4";
        desc = "G4_CSC_P4 is a G4 CSC parameter 4 register (instant register). (offset 0x80DC; total reset 0x00000000; PROVEN: Hi3521A/Hi3520D V300 data sheet (Issue 00B07, 2015-12-10), section 5.10, PDF page 1323).";
        field {
            name = "reserved";
            desc = "Reserved";
            sw = r; hw = w;
            reset = 0x0;
        } reserved_31_15[31:15];
        field {
            name = "cscp22";
            desc = "5.10 data format indicating one sign bit, four integer bits, and 10 decimal bits. The value is represented by a complement.";
            sw = rw; hw = r;
            reset = 0x0;
        } cscp22[14:0];
    } G4_CSC_P4 @ 0x80DC;
    reg {
        name = "WBC_G4_CTRL";
        desc = "WBC_G4_CTRL is a WBC0 control register (non-instant register). (offset 0xA400; total reset 0x00000000; PROVEN: Hi3521A/Hi3520D V300 data sheet (Issue 00B07, 2015-12-10), section 5.10, PDF page 1324).";
        field {
            name = "wbc_en";
            desc = "WBC enable
- 0: disable
- 1: enable";
            sw = rw; hw = r;
            reset = 0x0;
        } wbc_en[31:31];
        field {
            name = "reserved";
            desc = "Reserved";
            sw = r; hw = w;
            reset = 0x0;
        } reserved_30_11[30:11];
        field {
            name = "auto_stop_en";
            desc = "When the bandwidth is low due to the rapid WBC, WBC is automatically disabled.";
            sw = rw; hw = r;
            reset = 0x0;
        } auto_stop_en[10:10];
        field {
            name = "reserved";
            desc = "Reserved";
            sw = r; hw = w;
            reset = 0x0;
        } reserved_9_0[9:0];
    } WBC_G4_CTRL @ 0xA400;
    reg {
        name = "WBC_G4_UPD";
        desc = "WBC_G4_UPD is a WBC0 channel update enable register. (offset 0xA404; total reset 0x00000000; PROVEN: Hi3521A/Hi3520D V300 data sheet (Issue 00B07, 2015-12-10), section 5.10, PDF page 1324).";
        field {
            name = "reserved";
            desc = "Reserved";
            sw = r; hw = w;
            reset = 0x0;
        } reserved_31_1[31:1];
        field {
            name = "regup";
            desc = "Capture register update. After the registers at this layer are configured, the registers are updated when the value 1 is written to this bit. After updates, this bit is automatically cleared by the hardware.

Access type WC in the data sheet: written 1 clears the bit.";
            sw = rw; hw = w; onwrite = woclr;
            reset = 0x0;
        } regup[0:0];
    } WBC_G4_UPD @ 0xA404;
    reg {
        name = "WBC_G4_ADDR";
        desc = "WBC_G4_ADDR is a capture luminance write address register. (offset 0xA410; total reset 0x00000000; PROVEN: Hi3521A/Hi3520D V300 data sheet (Issue 00B07, 2015-12-10), section 5.10, PDF page 1325).";
        field {
            name = "wbcaddr";
            desc = "Start address for compressing the WBC data";
            sw = rw; hw = r;
            reset = 0x0;
        } wbcaddr[31:0];
    } WBC_G4_ADDR @ 0xA410;
    reg {
        name = "WBC_G4_STRIDE";
        desc = "WBC_G4_STRIDE is a capture stride register. (offset 0xA418; total reset 0x00000000; PROVEN: Hi3521A/Hi3520D V300 data sheet (Issue 00B07, 2015-12-10), section 5.10, PDF page 1325).";
        field {
            name = "reserved";
            desc = "Reserved";
            sw = r; hw = w;
            reset = 0x0;
        } reserved_31_16[31:16];
        field {
            name = "wbcstride";
            desc = "Frame buffer stride, 16-byte-aligned";
            sw = rw; hw = r;
            reset = 0x0;
        } wbcstride[15:0];
    } WBC_G4_STRIDE @ 0xA418;
    reg {
        name = "WBC_G4_ORESO";
        desc = "WBC_G4_ORESO is an output resolution register (non-instant register). (offset 0xA420; total reset 0x00000000; PROVEN: Hi3521A/Hi3520D V300 data sheet (Issue 00B07, 2015-12-10), section 5.10, PDF page 1325).";
        field {
            name = "reserved";
            desc = "Reserved";
            sw = r; hw = w;
            reset = 0x0;
        } reserved_31_24[31:24];
        field {
            name = "oh";
            desc = "Height (in line). The value is the actual height minus 1. Note: In interlaced output mode, the actual layer height must be an even number. There is no such limitation in progressive output mode.";
            sw = rw; hw = r;
            reset = 0x0;
        } oh[23:12];
        field {
            name = "ow";
            desc = "Width (in pixel). The value is the actual width minus 1. Note: The actual layer width must be an even number.";
            sw = rw; hw = r;
            reset = 0x0;
        } ow[11:0];
    } WBC_G4_ORESO @ 0xA420;
    reg {
        name = "WBC_G4_YCROP";
        desc = "WBC_G4_YCROP is an input picture crop start/end vertical coordinate register (non-instant register). (offset 0xA424; total reset 0x00000000; PROVEN: Hi3521A/Hi3520D V300 data sheet (Issue 00B07, 2015-12-10), section 5.10, PDF page 1326).";
        field {
            name = "reserved";
            desc = "Reserved";
            sw = r; hw = w;
            reset = 0x0;
        } reserved_31_24[31:24];
        field {
            name = "ylcrop";
            desc = "End vertical coordinate for cropping";
            sw = rw; hw = r;
            reset = 0x0;
        } ylcrop[23:12];
        field {
            name = "yfcrop";
            desc = "Start vertical coordinate for cropping";
            sw = rw; hw = r;
            reset = 0x0;
        } yfcrop[11:0];
    } WBC_G4_YCROP @ 0xA424;
    reg {
        name = "WBC_G4_CSTR_ERR";
        desc = "WBC_G4_CSTR_ERR is a compressed picture stride configuration error status register. This register is read-only. (offset 0xA434; total reset 0x00000000; PROVEN: Hi3521A/Hi3520D V300 data sheet (Issue 00B07, 2015-12-10), section 5.10, PDF page 1327).";
        field {
            name = "reserved";
            desc = "Reserved";
            sw = r; hw = w;
            reset = 0x0;
        } reserved_31_1[31:1];
        field {
            name = "str_err_flag";
            desc = "When the configured stride length is less than the length of the header information, str_err_flag is pulled up.";
            sw = r; hw = w;
            reset = 0x0;
        } str_err_flag[0:0];
    } WBC_G4_CSTR_ERR @ 0xA434;
    reg {
        name = "WBC_G4_CLR_CSTR_ERR";
        desc = "WBC_G4_CLR_CSTR_ERR is a compressed picture stride configuration error status clear register. This register is write-only. (offset 0xA438; total reset 0x00000000; PROVEN: Hi3521A/Hi3520D V300 data sheet (Issue 00B07, 2015-12-10), section 5.10, PDF page 1327).";
        field {
            name = "reserved";
            desc = "Reserved";
            sw = r; hw = w;
            reset = 0x0;
        } reserved_31_1[31:1];
        field {
            name = "clr_err_flag";
            desc = "Compressed picture stride configuration error status clear register Writing 1 clears the compressed picture stride configuration error status register (WBC_G4_CSTR_ERR).";
            sw = w; hw = r;
            reset = 0x0;
        } clr_err_flag[0:0];
    } WBC_G4_CLR_CSTR_ERR @ 0xA438;
    reg {
        name = "WBC_G4_GLB_INFO";
        desc = "WBC_G4_GLB_INFO is a LCMP global control information register. (offset 0xA480; total reset 0x00000040; PROVEN: Hi3521A/Hi3520D V300 data sheet (Issue 00B07, 2015-12-10), section 5.10, PDF page 1328).";
        field {
            name = "reserved";
            desc = "Reserved";
            sw = r; hw = w;
            reset = 0x0;
        } reserved_31_9[31:9];
        field {
            name = "part_num";
            desc = "Number of split partitions";
            sw = rw; hw = r;
            reset = 0x1;
        } part_num[8:6];
        field {
            name = "partition_en";
            desc = "Whether to split compression
- 0: no spit
- 1: split";
            sw = rw; hw = r;
            reset = 0x0;
        } partition_en[5:5];
        field {
            name = "osd_mode";
            desc = "OSD mode
- 0: 8888
- 2: 1555

Other values: reserved";
            sw = rw; hw = r;
            reset = 0x0;
        } osd_mode[4:3];
        field {
            name = "cmp_mode";
            desc = "Compression mode
- 0: compression
- 1: RAW mode";
            sw = rw; hw = r;
            reset = 0x0;
        } cmp_mode[2:2];
        field {
            name = "is_lossless_alpha";
            desc = "Whether the compression mode of alpha is lossless compression
- 0: lossy compression
- 1: lossless compression";
            sw = rw; hw = r;
            reset = 0x0;
        } is_lossless_alpha[1:1];
        field {
            name = "is_lossless";
            desc = "Whether the compression mode is lossless compression mode
- 0: lossy compression mode
- 1: lossless compression mode";
            sw = rw; hw = r;
            reset = 0x0;
        } is_lossless[0:0];
    } WBC_G4_GLB_INFO @ 0xA480;
    reg {
        name = "WBC_G4_FRAME_SIZE";
        desc = "WBC_G4_FRAME_SIZE is a picture size register. (offset 0xA484; total reset 0x0437077F; PROVEN: Hi3521A/Hi3520D V300 data sheet (Issue 00B07, 2015-12-10), section 5.10, PDF page 1329).";
        field {
            name = "reserved";
            desc = "Reserved";
            sw = r; hw = w;
            reset = 0x0;
        } reserved_31_29[31:29];
        field {
            name = "frame_height";
            desc = "Height (in line). The configured value is the actual height minus 1.";
            sw = rw; hw = r;
            reset = 0x437;
        } frame_height[28:16];
        field {
            name = "reserved";
            desc = "Reserved";
            sw = r; hw = w;
            reset = 0x0;
        } reserved_15_13[15:13];
        field {
            name = "frame_width";
            desc = "Width (in pixel). The configured value is the actual width minus 1.";
            sw = rw; hw = r;
            reset = 0x77f;
        } frame_width[12:0];
    } WBC_G4_FRAME_SIZE @ 0xA484;
    reg {
        name = "WBC_G4_RC_CFG0";
        desc = "WBC_G4_RC_CFG0 is an RC parameter 0 register. (offset 0xA488; total reset 0x017701F4; PROVEN: Hi3521A/Hi3520D V300 data sheet (Issue 00B07, 2015-12-10), section 5.10, PDF page 1329).";
        field {
            name = "reserved";
            desc = "Reserved";
            sw = r; hw = w;
            reset = 0x0;
        } reserved_31_26[31:26];
        field {
            name = "min_mb_bits";
            desc = "Minimum number of bits that can be allocated during rate control";
            sw = rw; hw = r;
            reset = 0x177;
        } min_mb_bits[25:16];
        field {
            name = "reserved";
            desc = "Reserved";
            sw = rw; hw = r;
            reset = 0x0;
        } reserved_15_10[15:10];
        field {
            name = "budget_bits_mb";
            desc = "Number of rated bits for an RC unit";
            sw = rw; hw = r;
            reset = 0x1f4;
        } budget_bits_mb[9:0];
    } WBC_G4_RC_CFG0 @ 0xA488;
    reg {
        name = "WBC_G4_RC_CFG1";
        desc = "WBC_G4_RC_CFG1 is an RC parameter 1 register. (offset 0xA48C; total reset 0x00000000; PROVEN: Hi3521A/Hi3520D V300 data sheet (Issue 00B07, 2015-12-10), section 5.10, PDF page 1330).";
        field {
            name = "reserved";
            desc = "Reserved";
            sw = r; hw = w;
            reset = 0x0;
        } reserved_31_10[31:10];
        field {
            name = "budget_bits_mb_cap";
            desc = "Number of rated bits for an RC unit";
            sw = rw; hw = r;
            reset = 0x0;
        } budget_bits_mb_cap[9:0];
    } WBC_G4_RC_CFG1 @ 0xA48C;
    reg {
        name = "WBC_G4_RC_CFG2";
        desc = "WBC_G4_RC_CFG2 is an RC parameter 2 register. (offset 0xA490; total reset 0x04040A25; PROVEN: Hi3521A/Hi3520D V300 data sheet (Issue 00B07, 2015-12-10), section 5.10, PDF page 1330).";
        field {
            name = "reserved";
            desc = "Reserved";
            sw = r; hw = w;
            reset = 0x0;
        } reserved_31_28[31:28];
        field {
            name = "special_bit_gain";
            desc = "Gain coefficient of special bits";
            sw = rw; hw = r;
            reset = 0x4;
        } special_bit_gain[27:24];
        field {
            name = "reserved";
            desc = "Reserved";
            sw = r; hw = w;
            reset = 0x0;
        } reserved_23_19[23:19];
        field {
            name = "rc_smth_ngain";
            desc = "Steady factor of the RC quality and bandwidth";
            sw = rw; hw = r;
            reset = 0x4;
        } rc_smth_ngain[18:16];
        field {
            name = "reserved";
            desc = "Reserved";
            sw = r; hw = w;
            reset = 0x0;
        } reserved_15_12[15:12];
        field {
            name = "sad_bits_ngain";
            desc = "Number of allocated bits corresponding to the complexity";
            sw = rw; hw = r;
            reset = 0xa;
        } sad_bits_ngain[11:8];
        field {
            name = "smth_qp";
            desc = "Reserved";
            sw = rw; hw = r;
            reset = 0x2;
        } smth_qp[7:4];
        field {
            name = "max_qp";
            desc = "Maximum quantization level";
            sw = rw; hw = r;
            reset = 0x5;
        } max_qp[3:0];
    } WBC_G4_RC_CFG2 @ 0xA490;
    reg {
        name = "WBC_G4_RC_CFG3";
        desc = "WBC_G4_RC_CFG3 is an RC parameter 3 register. (offset 0xA494; total reset 0x000C0040; PROVEN: Hi3521A/Hi3520D V300 data sheet (Issue 00B07, 2015-12-10), section 5.10, PDF page 1331).";
        field {
            name = "reserved";
            desc = "Reserved";
            sw = r; hw = w;
            reset = 0x0;
        } reserved_31_23[31:23];
        field {
            name = "min_sad_thr";
            desc = "Minimum SAD threshold";
            sw = rw; hw = r;
            reset = 0xc;
        } min_sad_thr[22:16];
        field {
            name = "reserved";
            desc = "Reserved";
            sw = r; hw = w;
            reset = 0x0;
        } reserved_15_7[15:7];
        field {
            name = "max_sad_thr";
            desc = "Maximum SAD threshold";
            sw = rw; hw = r;
            reset = 0x40;
        } max_sad_thr[6:0];
    } WBC_G4_RC_CFG3 @ 0xA494;
    reg {
        name = "WBC_G4_RC_CFG4";
        desc = "WBC_G4_RC_CFG4 is an RC parameter 4 register. (offset 0xA498; total reset 0x00100103; PROVEN: Hi3521A/Hi3520D V300 data sheet (Issue 00B07, 2015-12-10), section 5.10, PDF page 1331).";
        field {
            name = "reserved";
            desc = "Reserved";
            sw = r; hw = w;
            reset = 0x0;
        } reserved_31_26[31:26];
        field {
            name = "big_grad_thr";
            desc = "Large gradient threshold";
            sw = rw; hw = r;
            reset = 0x10;
        } big_grad_thr[25:16];
        field {
            name = "reserved";
            desc = "Reserved";
            sw = r; hw = w;
            reset = 0x0;
        } reserved_15_15[15:15];
        field {
            name = "still_thr";
            desc = "Static region threshold";
            sw = rw; hw = r;
            reset = 0x1;
        } still_thr[14:8];
        field {
            name = "reserved";
            desc = "Reserved";
            sw = r; hw = w;
            reset = 0x0;
        } reserved_7_7[7:7];
        field {
            name = "smth_thr";
            desc = "Smooth region threshold";
            sw = rw; hw = r;
            reset = 0x3;
        } smth_thr[6:0];
    } WBC_G4_RC_CFG4 @ 0xA498;
    reg {
        name = "WBC_G4_RC_CFG5";
        desc = "WBC_G4_RC_CFG5 is an RC parameter 5 register. (offset 0xA49C; total reset 0x0A180306; PROVEN: Hi3521A/Hi3520D V300 data sheet (Issue 00B07, 2015-12-10), section 5.10, PDF page 1332).";
        field {
            name = "reserved";
            desc = "Reserved";
            sw = r; hw = w;
            reset = 0x0;
        } reserved_31_30[31:30];
        field {
            name = "large_smth_pix_num_thr";
            desc = "Threshold for determining whether a region is a large smooth region";
            sw = rw; hw = r;
            reset = 0xa;
        } large_smth_pix_num_thr[29:24];
        field {
            name = "reserved";
            desc = "Reserved";
            sw = r; hw = w;
            reset = 0x0;
        } reserved_23_22[23:22];
        field {
            name = "noise_pix_num_thr";
            desc = "Threshold for determining whether a region is a noise region";
            sw = rw; hw = r;
            reset = 0x18;
        } noise_pix_num_thr[21:16];
        field {
            name = "reserved";
            desc = "Reserved";
            sw = r; hw = w;
            reset = 0x0;
        } reserved_15_14[15:14];
        field {
            name = "still_pix_num_thr";
            desc = "Threshold for determining whether a region is a static region";
            sw = rw; hw = r;
            reset = 0x3;
        } still_pix_num_thr[13:8];
        field {
            name = "reserved";
            desc = "Reserved";
            sw = r; hw = w;
            reset = 0x0;
        } reserved_7_6[7:6];
        field {
            name = "smth_pix_num_thr";
            desc = "Threshold for determining whether a region is a smooth region";
            sw = rw; hw = r;
            reset = 0x6;
        } smth_pix_num_thr[5:0];
    } WBC_G4_RC_CFG5 @ 0xA49C;
    reg {
        name = "WBC_G4_RC_CFG6";
        desc = "WBC_G4_RC_CFG6 is an RC parameter 6 register. (offset 0xA4A0; total reset 0x00320020; PROVEN: Hi3521A/Hi3520D V300 data sheet (Issue 00B07, 2015-12-10), section 5.10, PDF page 1332).";
        field {
            name = "reserved";
            desc = "Reserved";
            sw = r; hw = w;
            reset = 0x0;
        } reserved_31_25[31:25];
        field {
            name = "pix_diff_thr";
            desc = "Difference threshold";
            sw = rw; hw = r;
            reset = 0x32;
        } pix_diff_thr[24:16];
        field {
            name = "reserved";
            desc = "Reserved";
            sw = r; hw = w;
            reset = 0x0;
        } reserved_15_7[15:7];
        field {
            name = "noise_sad";
            desc = "SAD of the noise region";
            sw = rw; hw = r;
            reset = 0x20;
        } noise_sad[6:0];
    } WBC_G4_RC_CFG6 @ 0xA4A0;
    reg {
        name = "WBC_G4_RC_CFG7";
        desc = "WBC_G4_RC_CFG7 is an RC parameter 7 register. (offset 0xA4A4; total reset 0x00000A1E; PROVEN: Hi3521A/Hi3520D V300 data sheet (Issue 00B07, 2015-12-10), section 5.10, PDF page 1333).";
        field {
            name = "reserved";
            desc = "Reserved";
            sw = r; hw = w;
            reset = 0x0;
        } reserved_31_16[31:16];
        field {
            name = "max_trow_bits";
            desc = "Maximum number of bits in the previous row";
            sw = rw; hw = r;
            reset = 0xa;
        } max_trow_bits[15:8];
        field {
            name = "reserved";
            desc = "Reserved";
            sw = r; hw = w;
            reset = 0x0;
        } reserved_7_7[7:7];
        field {
            name = "adj_sad_bits_thr";
            desc = "Number of adjusted bits for SAD";
            sw = rw; hw = r;
            reset = 0x1e;
        } adj_sad_bits_thr[6:0];
    } WBC_G4_RC_CFG7 @ 0xA4A4;
    reg {
        name = "WBC_G4_RC_CFG8";
        desc = "WBC_G4_RC_CFG8 is an RC parameter 8 register. (offset 0xA4A8; total reset 0x825A2832; PROVEN: Hi3521A/Hi3520D V300 data sheet (Issue 00B07, 2015-12-10), section 5.10, PDF page 1333).";
        field {
            name = "qp_dec3_bits_thr";
            desc = "Threshold 3 for the number of bits adjusted to decrease the QP value";
            sw = rw; hw = r;
            reset = 0x82;
        } qp_dec3_bits_thr[31:24];
        field {
            name = "qp_dec2_bits_thr";
            desc = "Threshold 2 for the number of bits adjusted to decrease the QP value";
            sw = rw; hw = r;
            reset = 0x5a;
        } qp_dec2_bits_thr[23:16];
        field {
            name = "qp_dec1_bits_thr";
            desc = "Threshold 1 for the number of bits adjusted to decrease the QP value";
            sw = rw; hw = r;
            reset = 0x28;
        } qp_dec1_bits_thr[15:8];
        field {
            name = "qp_inc1_bits_thr";
            desc = "Threshold for the number of bits adjusted to increase the QP value";
            sw = rw; hw = r;
            reset = 0x32;
        } qp_inc1_bits_thr[7:0];
    } WBC_G4_RC_CFG8 @ 0xA4A8;
    reg {
        name = "WBC_G4_RC_CFG9";
        desc = "WBC_G4_RC_CFG9 is an RC parameter 9 register. (offset 0xA4AC; total reset 0x00140046; PROVEN: Hi3521A/Hi3520D V300 data sheet (Issue 00B07, 2015-12-10), section 5.10, PDF page 1334).";
        field {
            name = "reserved";
            desc = "Reserved";
            sw = r; hw = w;
            reset = 0x0;
        } reserved_31_26[31:26];
        field {
            name = "force_qp_thr_cap";
            desc = "Threshold for forcible qp_cap variance";
            sw = rw; hw = r;
            reset = 0x14;
        } force_qp_thr_cap[25:16];
        field {
            name = "reserved";
            desc = "Reserved";
            sw = r; hw = w;
            reset = 0x0;
        } reserved_15_10[15:10];
        field {
            name = "force_qp_thr";
            desc = "Threshold for forcible qp variance";
            sw = rw; hw = r;
            reset = 0x46;
        } force_qp_thr[9:0];
    } WBC_G4_RC_CFG9 @ 0xA4AC;
    reg {
        name = "WBC_G4_MAX_ROW_LEN";
        desc = "WBC_G4_MAX_ROW_LEN is a 128-bit unit register for the row with the lowest compression ratio. (offset 0xA4B0; total reset 0x00000000; PROVEN: Hi3521A/Hi3520D V300 data sheet (Issue 00B07, 2015-12-10), section 5.10, PDF page 1334).";
        field {
            name = "reserved";
            desc = "Reserved";
            sw = r; hw = w;
            reset = 0x0;
        } reserved_31_10[31:10];
        field {
            name = "max_row_len";
            desc = "128-bit unit occupied by the row with the lowest compression ratio";
            sw = rw; hw = r;
            reset = 0x0;
        } max_row_len[9:0];
    } WBC_G4_MAX_ROW_LEN @ 0xA4B0;
    reg {
        name = "WBC_DHD1_CTRL";
        desc = "WBC_DHD1_CTRL is a WBC0 control register (non-instant register). (offset 0xAC00; total reset 0x00001000; PROVEN: Hi3521A/Hi3520D V300 data sheet (Issue 00B07, 2015-12-10), section 5.10, PDF page 1335).";
        field {
            name = "wbc_en";
            desc = "WBC enable
- 0: disabled
- 1: enabled";
            sw = rw; hw = r;
            reset = 0x0;
        } wbc_en[31:31];
        field {
            name = "reserved";
            desc = "Reserved";
            sw = r; hw = w;
            reset = 0x0;
        } reserved_30_30[30:30];
        field {
            name = "mode_out";
            desc = "WBC output mode
- 00: The output mode is automatically selected based on the interface read mode. That is, the progressive read mode is selected in progressive display mode, and the interlaced read mode is selected in interlaced display mode.
- 01: The progressive output mode is selected.
- 10: The top field is output.
- 11: The bottom field is output.";
            sw = rw; hw = r;
            reset = 0x0;
        } mode_out[29:28];
        field {
            name = "format_out";
            desc = "WBC output data format semiplanar
- 0100: YUV420
- 0101: YUV422

Other values: reserved";
            sw = rw; hw = r;
            reset = 0x0;
        } format_out[27:24];
        field {
            name = "reserved";
            desc = "Reserved";
            sw = r; hw = w;
            reset = 0x0;
        } reserved_23_13[23:13];
        field {
            name = "wbc_vtthd_mode";
            desc = "WBC interrupt report mode
- 0: report by frame
- 1: report by field";
            sw = rw; hw = r;
            reset = 0x1;
        } wbc_vtthd_mode[12:12];
        field {
            name = "reserved";
            desc = "Reserved";
            sw = r; hw = w;
            reset = 0x0;
        } reserved_11_11[11:11];
        field {
            name = "auto_stop_en";
            desc = "When the bandwidth is low due to the rapid WBC speed, WBC is automatically disabled.";
            sw = rw; hw = r;
            reset = 0x0;
        } auto_stop_en[10:10];
        field {
            name = "reserved";
            desc = "Reserved";
            sw = r; hw = w;
            reset = 0x0;
        } reserved_9_0[9:0];
    } WBC_DHD1_CTRL @ 0xAC00;
    reg {
        name = "WBC_DHD1_UPD";
        desc = "WBC_DHD1_UPD is a WBC0 channel update enable register. (offset 0xAC04; total reset 0x00000000; PROVEN: Hi3521A/Hi3520D V300 data sheet (Issue 00B07, 2015-12-10), section 5.10, PDF page 1336).";
        field {
            name = "reserved";
            desc = "Reserved";
            sw = r; hw = w;
            reset = 0x0;
        } reserved_31_1[31:1];
        field {
            name = "regup";
            desc = "Capture register update. After the registers at this layer are configured, the registers are updated when the value 1 is written to this bit. After updates, this bit is automatically cleared by the hardware.

Access type WC in the data sheet: written 1 clears the bit.";
            sw = rw; hw = w; onwrite = woclr;
            reset = 0x0;
        } regup[0:0];
    } WBC_DHD1_UPD @ 0xAC04;
    reg {
        name = "WBC_DHD1_YADDR";
        desc = "WBC_DHD1_YADDR is a capture luminance write address register. (offset 0xAC10; total reset 0x00000000; PROVEN: Hi3521A/Hi3520D V300 data sheet (Issue 00B07, 2015-12-10), section 5.10, PDF page 1336).";
        field {
            name = "wbcaddr";
            desc = "When the output format is a semi-planar format, this register indicates the start address for the frame buffer luminance component. When the output format is a package or ARGB format, this register is the start address for a picture. In this case, WBC_G0_CADDR is meaningless. The address must be 4-byte-aligned, and the lower two bits are invalid (seamless combination is supported).";
            sw = rw; hw = r;
            reset = 0x0;
        } wbcaddr[31:0];
    } WBC_DHD1_YADDR @ 0xAC10;
    reg {
        name = "WBC_DHD1_CADDR";
        desc = "WBC_DHD1_CADDR is a capture chrominance write address register. (offset 0xAC14; total reset 0x00000000; PROVEN: Hi3521A/Hi3520D V300 data sheet (Issue 00B07, 2015-12-10), section 5.10, PDF page 1337).";
        field {
            name = "wbccaddr";
            desc = "Start address for the frame buffer chrominance component. The address must be 4-byte-aligned, and the lower two bits are invalid (seamless combination is supported).";
            sw = rw; hw = r;
            reset = 0x0;
        } wbccaddr[31:0];
    } WBC_DHD1_CADDR @ 0xAC14;
    reg {
        name = "WBC_DHD1_STRIDE";
        desc = "WBC_DHD1_STRIDE is a capture stride register. (offset 0xAC18; total reset 0x00000000; PROVEN: Hi3521A/Hi3520D V300 data sheet (Issue 00B07, 2015-12-10), section 5.10, PDF page 1337).";
        field {
            name = "wbccstride";
            desc = "Chrominance stride of the frame buffer, 16-byte-aligned";
            sw = rw; hw = r;
            reset = 0x0;
        } wbccstride[31:16];
        field {
            name = "wbclstride";
            desc = "Luminance stride of the frame buffer, 16-byte-aligned";
            sw = rw; hw = r;
            reset = 0x0;
        } wbclstride[15:0];
    } WBC_DHD1_STRIDE @ 0xAC18;
    reg {
        name = "WBC_DHD1_ORESO";
        desc = "WBC_DHD1_ORESO is an output resolution register (non-instant register). (offset 0xAC20; total reset 0x00000000; PROVEN: Hi3521A/Hi3520D V300 data sheet (Issue 00B07, 2015-12-10), section 5.10, PDF page 1337).";
        field {
            name = "reserved";
            desc = "Reserved";
            sw = r; hw = w;
            reset = 0x0;
        } reserved_31_24[31:24];
        field {
            name = "oh";
            desc = "Height (in line). The value is the actual height minus 1. Note: In interlaced output mode, the actual layer height must be an even number. There is no such limitation in progressive output mode.";
            sw = rw; hw = r;
            reset = 0x0;
        } oh[23:12];
        field {
            name = "ow";
            desc = "Width (in pixel). The value is the actual width minus 1. Note: The actual layer width must be an even number.";
            sw = rw; hw = r;
            reset = 0x0;
        } ow[11:0];
    } WBC_DHD1_ORESO @ 0xAC20;
    reg {
        name = "WBC_DHD1_PARAUP";
        desc = "WBC_DHD1_PARAUP is a gp1 coefficient-related register update enable register. The VDP scaling coefficients are configured by using the AXI master. Software configures the start addresses and parameter update flags by using the slave. (offset 0xAC40; total reset 0x00000000; PROVEN: Hi3521A/Hi3520D V300 data sheet (Issue 00B07, 2015-12-10), section 5.10, PDF page 1338).";
        field {
            name = "reserved";
            desc = "Reserved";
            sw = r; hw = w;
            reset = 0x0;
        } reserved_31_4[31:4];
        field {
            name = "wbc_vccoef_upd";
            desc = "Whether vertical chrominance filtering coefficients need to be updated. This bit is automatically cleared after the hardware updates the coefficients.
- 0: not updated
- 1: updated";
            sw = w; hw = r;
            reset = 0x0;
        } wbc_vccoef_upd[3:3];
        field {
            name = "wbc_vlcoef_upd";
            desc = "Whether vertical luminance filtering coefficients need to be updated. This bit is automatically cleared after the hardware updates the coefficients.
- 0: not updated
- 1: updated";
            sw = w; hw = r;
            reset = 0x0;
        } wbc_vlcoef_upd[2:2];
        field {
            name = "wbc_hccoef_upd";
            desc = "Whether horizontal chrominance filtering coefficients need to be updated. This bit is automatically cleared after the hardware updates the coefficients.
- 0: not updated
- 1: updated";
            sw = w; hw = r;
            reset = 0x0;
        } wbc_hccoef_upd[1:1];
        field {
            name = "wbc_hlcoef_upd";
            desc = "Whether horizontal luminance filtering coefficients need to be updated. This bit is automatically cleared after the hardware updates the coefficients.
- 0: not updated
- 1: updated";
            sw = w; hw = r;
            reset = 0x0;
        } wbc_hlcoef_upd[0:0];
    } WBC_DHD1_PARAUP @ 0xAC40;
    reg {
        name = "WBC_DHD1_HLCOEFAD";
        desc = "WBC_DHD1_HLCOEFAD is a WBC horizontal luminance filtering coefficient address register. (offset 0xAC50; total reset 0x00000000; PROVEN: Hi3521A/Hi3520D V300 data sheet (Issue 00B07, 2015-12-10), section 5.10, PDF page 1339).";
        field {
            name = "coef_addr";
            desc = "Start address for storing coefficients in the local memory";
            sw = rw; hw = r;
            reset = 0x0;
        } coef_addr[31:0];
    } WBC_DHD1_HLCOEFAD @ 0xAC50;
    reg {
        name = "WBC_DHD1_HCCOEFAD";
        desc = "WBC_DHD1_HCCOEFAD is a WBC horizontal chrominance filtering coefficient address register. (offset 0xAC54; total reset 0x00000000; PROVEN: Hi3521A/Hi3520D V300 data sheet (Issue 00B07, 2015-12-10), section 5.10, PDF page 1339).";
        field {
            name = "coef_addr";
            desc = "Start address for storing coefficients in the local memory";
            sw = rw; hw = r;
            reset = 0x0;
        } coef_addr[31:0];
    } WBC_DHD1_HCCOEFAD @ 0xAC54;
    reg {
        name = "WBC_DHD1_VLCOEFAD";
        desc = "WBC_DHD1_VLCOEFAD is a WBC vertical luminance filtering coefficient address register (offset 0xAC58; total reset 0x00000000; PROVEN: Hi3521A/Hi3520D V300 data sheet (Issue 00B07, 2015-12-10), section 5.10, PDF page 1340).";
        field {
            name = "coef_addr";
            desc = "Start address for storing coefficients in the local memory";
            sw = rw; hw = r;
            reset = 0x0;
        } coef_addr[31:0];
    } WBC_DHD1_VLCOEFAD @ 0xAC58;
    reg {
        name = "WBC_DHD1_VCCOEFAD";
        desc = "WBC_DHD1_VCCOEFAD is a WBC vertical chrominance filtering coefficient address register. (offset 0xAC5C; total reset 0x00000000; PROVEN: Hi3521A/Hi3520D V300 data sheet (Issue 00B07, 2015-12-10), section 5.10, PDF page 1340).";
        field {
            name = "coef_addr";
            desc = "Start address for storing coefficients in the local memory";
            sw = rw; hw = r;
            reset = 0x0;
        } coef_addr[31:0];
    } WBC_DHD1_VCCOEFAD @ 0xAC5C;
    reg {
        name = "WBC_DHD1_DITHER_CTRL";
        desc = "WBC_DHD1_DITHER_CTRL is a dither control register. (offset 0xAD00; total reset 0x20000000; PROVEN: Hi3521A/Hi3520D V300 data sheet (Issue 00B07, 2015-12-10), section 5.10, PDF page 1341).";
        field {
            name = "dither_md";
            desc = "Dither mode select
- 000: 10-bit inputs, 8-bit outputs, no dithering, and direct bit truncation
- 011: 10-bit inputs, 8-bit outputs, and time-domain and spatial- domain dithering
- 101: 10-bit inputs, 8-bit outputs, and round off

Other values: reserved";
            sw = rw; hw = r;
            reset = 0x1;
        } dither_md[31:29];
        field {
            name = "reserved";
            desc = "Reserved";
            sw = r; hw = w;
            reset = 0x0;
        } reserved_28_0[28:0];
    } WBC_DHD1_DITHER_CTRL @ 0xAD00;
    reg {
        name = "WBC_DHD1_DITHER_COEF0";
        desc = "WBC_DHD1_DITHER_COEF0 is a dither coefficient 0 register. (offset 0xAD04; total reset 0xDD664400; PROVEN: Hi3521A/Hi3520D V300 data sheet (Issue 00B07, 2015-12-10), section 5.10, PDF page 1341).";
        field {
            name = "dither_coef3";
            desc = "Coefficient 3 for time-domain dithering";
            sw = rw; hw = r;
            reset = 0xdd;
        } dither_coef3[31:24];
        field {
            name = "dither_coef2";
            desc = "Coefficient 2 for time-domain dithering";
            sw = rw; hw = r;
            reset = 0x66;
        } dither_coef2[23:16];
        field {
            name = "dither_coef1";
            desc = "Coefficient 1 for time-domain dithering";
            sw = rw; hw = r;
            reset = 0x44;
        } dither_coef1[15:8];
        field {
            name = "dither_coef0";
            desc = "Coefficient 0 for time-domain dithering";
            sw = rw; hw = r;
            reset = 0x0;
        } dither_coef0[7:0];
    } WBC_DHD1_DITHER_COEF0 @ 0xAD04;
    reg {
        name = "WBC_DHD1_DITHER_COEF1";
        desc = "WBC_DHD1_DITHER_COEF1 is a dither coefficient 1 register. (offset 0xAD08; total reset 0xDD664400; PROVEN: Hi3521A/Hi3520D V300 data sheet (Issue 00B07, 2015-12-10), section 5.10, PDF page 1342).";
        field {
            name = "dither_coef7";
            desc = "Coefficient 7 for time-domain dithering";
            sw = rw; hw = r;
            reset = 0xdd;
        } dither_coef7[31:24];
        field {
            name = "dither_coef6";
            desc = "Coefficient 6 for time-domain dithering";
            sw = rw; hw = r;
            reset = 0x66;
        } dither_coef6[23:16];
        field {
            name = "dither_coef5";
            desc = "Coefficient 5 for time-domain dithering";
            sw = rw; hw = r;
            reset = 0x44;
        } dither_coef5[15:8];
        field {
            name = "dither_coef4";
            desc = "Coefficient 4 for time-domain dithering";
            sw = rw; hw = r;
            reset = 0x0;
        } dither_coef4[7:0];
    } WBC_DHD1_DITHER_COEF1 @ 0xAD08;
    reg {
        name = "WBC_DHD1_HCDS";
        desc = "WBC_DHD1_HCDS is a horizontal chrominance down sampling parameter configuration register (non-instant register). (offset 0xAE10; total reset 0x80000000; PROVEN: Hi3521A/Hi3520D V300 data sheet (Issue 00B07, 2015-12-10), section 5.10, PDF page 1342).";
        field {
            name = "hcds_en";
            desc = "Horizontal chrominance down sampling enable
- 0: disabled
- 1: enabled";
            sw = rw; hw = r;
            reset = 0x1;
        } hcds_en[31:31];
        field {
            name = "hchmid_en";
            desc = "Median filtering enable for horizontal chrominance down sampling. This bit is invalid when hchfir_en is invalid.
- 0: disabled
- 1: enabled";
            sw = rw; hw = r;
            reset = 0x0;
        } hchmid_en[30:30];
        field {
            name = "hchfir_en";
            desc = "Horizontal chrominance down sampling mode
- 0: replication mode (filtering disabled)
- 1: filtering mode (filtering enabled)";
            sw = rw; hw = r;
            reset = 0x0;
        } hchfir_en[29:29];
        field {
            name = "reserved";
            desc = "Reserved";
            sw = r; hw = w;
            reset = 0x0;
        } reserved_28_0[28:0];
    } WBC_DHD1_HCDS @ 0xAE10;
    reg {
        name = "WBC_DHD1_HCDS_COEF0";
        desc = "WBC_DHD1_HCDS_COEF0 is down sampling coefficient register 0. (offset 0xAE14; total reset 0x06753C67; PROVEN: Hi3521A/Hi3520D V300 data sheet (Issue 00B07, 2015-12-10), section 5.10, PDF page 1343).";
        field {
            name = "reserved";
            desc = "Reserved";
            sw = r; hw = w;
            reset = 0x0;
        } reserved_31_30[31:30];
        field {
            name = "coef2";
            desc = "Horizontal down sampling coefficient 2 (signed number)";
            sw = r; hw = w;
            reset = 0x67;
        } coef2[29:20];
        field {
            name = "coef1";
            desc = "Horizontal down sampling coefficient 1 (signed number)";
            sw = r; hw = w;
            reset = 0x14f;
        } coef1[19:10];
        field {
            name = "coef0";
            desc = "Horizontal down sampling coefficient 0 (signed number)";
            sw = r; hw = w;
            reset = 0x67;
        } coef0[9:0];
    } WBC_DHD1_HCDS_COEF0 @ 0xAE14;
    reg {
        name = "WBC_DHD1_HCDS_COEF1";
        desc = "WBC_DHD1_HCDS_COEF1 is down sampling coefficient register 1. (offset 0xAE18; total reset 0x000003E3; PROVEN: Hi3521A/Hi3520D V300 data sheet (Issue 00B07, 2015-12-10), section 5.10, PDF page 1343).";
        field {
            name = "reserved";
            desc = "Reserved";
            sw = r; hw = w;
            reset = 0x0;
        } reserved_31_10[31:10];
        field {
            name = "coef3";
            desc = "Horizontal down sampling coefficient 3 (signed number)";
            sw = r; hw = w;
            reset = 0x3e3;
        } coef3[9:0];
    } WBC_DHD1_HCDS_COEF1 @ 0xAE18;
    reg {
        name = "WBC_DHD1_ZME_HSP";
        desc = "WBC_DHD1_ZME_HSP is a horizontal scaling parameter configuration register (non-instant register). Scaling ratio = Input width/Output width (offset 0xAEC0; total reset 0x00100000; PROVEN: Hi3521A/Hi3520D V300 data sheet (Issue 00B07, 2015-12-10), section 5.10, PDF page 1344).";
        field {
            name = "hlmsc_en";
            desc = "Horizontal luminance scaling enable
- 0: disabled
- 1: enabled";
            sw = rw; hw = r;
            reset = 0x0;
        } hlmsc_en[31:31];
        field {
            name = "hchmsc_en";
            desc = "Horizontal chrominance scaling enable
- 0: disabled
- 1: enabled";
            sw = rw; hw = r;
            reset = 0x0;
        } hchmsc_en[30:30];
        field {
            name = "hlmid_en";
            desc = "Median filtering enable for horizontal luminance scaling. This bit is invalid when hlfir_en is invalid.
- 0: disabled
- 1: enabled";
            sw = rw; hw = r;
            reset = 0x0;
        } hlmid_en[29:29];
        field {
            name = "hchmid_en";
            desc = "Median filtering enable for horizontal chrominance scaling. This bit is invalid when hchfir_en is invalid.
- 0: disabled
- 1: enabled";
            sw = rw; hw = r;
            reset = 0x0;
        } hchmid_en[28:28];
        field {
            name = "non_lnr_en";
            desc = "Non-linear scaling enable
- 0: disabled
- 1: enabled";
            sw = rw; hw = r;
            reset = 0x0;
        } non_lnr_en[27:27];
        field {
            name = "hlfir_en";
            desc = "Horizontal luminance scaling mode
- 0: replication mode (filtering disabled)
- 1: filtering mode (filtering enabled)";
            sw = rw; hw = r;
            reset = 0x0;
        } hlfir_en[26:26];
        field {
            name = "hchfir_en";
            desc = "Horizontal chrominance scaling mode
- 0: replication mode (filtering disabled)
- 1: filtering mode (filtering enabled)";
            sw = rw; hw = r;
            reset = 0x0;
        } hchfir_en[25:25];
        field {
            name = "hfir_order";
            desc = "Horizontal scaling sequence
- 0: Horizontal scaling is performed before vertical scaling.
- 1: Horizontal scaling is performed after vertical scaling.";
            sw = rw; hw = r;
            reset = 0x0;
        } hfir_order[24:24];
        field {
            name = "hratio";
            desc = "Horizontal scaling ratio, in (u, 4, 20) format";
            sw = rw; hw = r;
            reset = 0x100000;
        } hratio[23:0];
    } WBC_DHD1_ZME_HSP @ 0xAEC0;
    reg {
        name = "WBC_DHD1_ZME_HLOFFSET";
        desc = "WBC_DHD1_ZME_HLOFFSET is a horizontal luminance offset register (non-instant register). It is used for pan-scan. (offset 0xAEC4; total reset 0x00000000; PROVEN: Hi3521A/Hi3520D V300 data sheet (Issue 00B07, 2015-12-10), section 5.10, PDF page 1345).";
        field {
            name = "reserved";
            desc = "Reserved";
            sw = r; hw = w;
            reset = 0x0;
        } reserved_31_28[31:28];
        field {
            name = "hor_loffset";
            desc = "Horizontal luminance offset, in (s, 8, 20) format. The value is expressed as a complement.";
            sw = rw; hw = r;
            reset = 0x0;
        } hor_loffset[27:0];
    } WBC_DHD1_ZME_HLOFFSET @ 0xAEC4;
    reg {
        name = "WBC_DHD1_ZME_HCOFFSET";
        desc = "WBC_DHD1_ZME_HCOFFSET is a horizontal chrominance offset register (non-instant register). It is used for pan-scan. (offset 0xAEC8; total reset 0x00000000; PROVEN: Hi3521A/Hi3520D V300 data sheet (Issue 00B07, 2015-12-10), section 5.10, PDF page 1345).";
        field {
            name = "reserved";
            desc = "Reserved";
            sw = r; hw = w;
            reset = 0x0;
        } reserved_31_28[31:28];
        field {
            name = "hor_coffset";
            desc = "Horizontal chrominance offset, in (s, 8, 20) format. The value is expressed as a complement.";
            sw = rw; hw = r;
            reset = 0x0;
        } hor_coffset[27:0];
    } WBC_DHD1_ZME_HCOFFSET @ 0xAEC8;
    reg {
        name = "WBC_DHD1_ZME_VSP";
        desc = "WBC_DHD1_ZME_VSP is a vertical scaling parameter register. (offset 0xAED8; total reset 0x00000000; PROVEN: Hi3521A/Hi3520D V300 data sheet (Issue 00B07, 2015-12-10), section 5.10, PDF page 1346).";
        field {
            name = "vlmsc_en";
            desc = "Vertical luminance scaling enable
- 0: disabled
- 1: enabled";
            sw = rw; hw = r;
            reset = 0x0;
        } vlmsc_en[31:31];
        field {
            name = "vchmsc_en";
            desc = "Vertical chrominance scaling enable
- 0: disabled
- 1: enabled";
            sw = rw; hw = r;
            reset = 0x0;
        } vchmsc_en[30:30];
        field {
            name = "vlmid_en";
            desc = "Median filtering enable for vertical luminance scaling. This bit is invalid when vlfir_en is invalid.
- 0: disabled
- 1: enabled";
            sw = rw; hw = r;
            reset = 0x0;
        } vlmid_en[29:29];
        field {
            name = "vchmid_en";
            desc = "Median filtering enable for vertical chrominance scaling. This bit is invalid when vchfir_en is invalid.
- 0: disabled
- 1: enabled";
            sw = rw; hw = r;
            reset = 0x0;
        } vchmid_en[28:28];
        field {
            name = "reserved";
            desc = "Reserved";
            sw = r; hw = w;
            reset = 0x0;
        } reserved_27_27[27:27];
        field {
            name = "vsc_chroma_tap";
            desc = "Vertical chrominance scaling tap
- 0: 4-tap FIR
- 1: 2-tap FIR";
            sw = rw; hw = r;
            reset = 0x0;
        } vsc_chroma_tap[26:26];
        field {
            name = "reserved";
            desc = "Reserved";
            sw = rw; hw = r;
            reset = 0x0;
        } reserved_25_25[25:25];
        field {
            name = "vlfir_en";
            desc = "Vertical luminance scaling mode
- 0: replication mode (filtering disabled)
- 1: filtering mode (filtering enabled)";
            sw = rw; hw = r;
            reset = 0x0;
        } vlfir_en[24:24];
        field {
            name = "vchfir_en";
            desc = "Vertical chrominance scaling mode
- 0: replication mode (filtering disabled)
- 1: filtering mode (filtering enabled)";
            sw = rw; hw = r;
            reset = 0x0;
        } vchfir_en[23:23];
        field {
            name = "zme_out_fmt";
            desc = "Output data format for scaling
- 0: 422
- 1: 420";
            sw = rw; hw = r;
            reset = 0x0;
        } zme_out_fmt[22:21];
        field {
            name = "zme_in_fmt";
            desc = "Input data format for scaling
- 0: 422
- 1: 420";
            sw = rw; hw = r;
            reset = 0x0;
        } zme_in_fmt[20:19];
        field {
            name = "reserved";
            desc = "Reserved";
            sw = r; hw = w;
            reset = 0x0;
        } reserved_18_0[18:0];
    } WBC_DHD1_ZME_VSP @ 0xAED8;
    reg {
        name = "WBC_DHD1_ZME_VSR";
        desc = "WBC_DHD1_ZME_VSR is a vertical luminance scaling ratio register (non-instant register). Scaling ratio = Input height/Output height (offset 0xAEDC; total reset 0x00001000; PROVEN: Hi3521A/Hi3520D V300 data sheet (Issue 00B07, 2015-12-10), section 5.10, PDF page 1347).";
        field {
            name = "reserved";
            desc = "Reserved";
            sw = r; hw = w;
            reset = 0x0;
        } reserved_31_16[31:16];
        field {
            name = "vratio";
            desc = "Vertical scaling ratio, in (u, 4, 12) format";
            sw = rw; hw = r;
            reset = 0x1000;
        } vratio[15:0];
    } WBC_DHD1_ZME_VSR @ 0xAEDC;
    reg {
        name = "WBC_DHD1_ZME_VOFFSET";
        desc = "WBC_DHD1_ZME_VOFFSET is a vertical luminance scaling offset register. The vertical scaling offset is affected by the field offset during pan-scan and the field offset when repeated frames occur. If no field offset occurs, vluma_offset is the lowest integral part plus the decimal part of offset_pan-scan. In YCbCr422 format, vchroma_offset is equal to vluma_offset; in YCbCr420 format, vchroma_offset is calculated as follows: vchroma_offset = scaling_chroma/2 - 0.25. If the field offset is required (such as static frames or repeated frames) and the bottom field is repeated, the values of vluma_offset and vchroma_offset configured for the top field are the same as those in the case of no field offset. The field offset must be considered when coefficients are configured for the bottom field. (offset 0xAEE0; total reset 0x00000000; PROVEN: Hi3521A/Hi3520D V300 data sheet (Issue 00B07, 2015-12-10), section 5.10, PDF page 1348).";
        field {
            name = "vluma_offset";
            desc = "Vertical luminance offset, in (s, 4, 12) format. The value is expressed as a complement.";
            sw = rw; hw = r;
            reset = 0x0;
        } vluma_offset[31:16];
        field {
            name = "vchroma_offset";
            desc = "Vertical chrominance offset, in (s, 4, 12) format. The value is expressed as a complement.";
            sw = rw; hw = r;
            reset = 0x0;
        } vchroma_offset[15:0];
    } WBC_DHD1_ZME_VOFFSET @ 0xAEE0;
    reg {
        name = "WBC_DHD1_ZME_VBOFFSET";
        desc = "WBC_DHD1_ZME_VBOFFSET is a vertical luminance scaling offset register for the bottom field. The vertical scaling offset is affected by the field offset during pan-scan and the field offset when repeated frames occur. If no field offset occurs, vluma_offset is the lowest integral part plus the decimal part of offset_pan-scan. In YCbCr422 format, vchroma_offset is equal to vluma_offset; in YCbCr420 format, vchroma_offset is calculated as follows: vchroma_offset = scaling_chroma/2 - 0.25. If the field offset is required (such as static frames or repeated frames) and the bottom field is repeated, the values of vluma_offset and vchroma_offset configured for the top field are the same as those in the case of no field offset. The field offset must be considered when coefficients are configured for the bottom field. (offset 0xAEE4; total reset 0x00000000; PROVEN: Hi3521A/Hi3520D V300 data sheet (Issue 00B07, 2015-12-10), section 5.10, PDF page 1348).";
        field {
            name = "vbluma_offset";
            desc = "Vertical luminance offset, in (s, 4, 12) format. The value is expressed as a complement.";
            sw = rw; hw = r;
            reset = 0x0;
        } vbluma_offset[31:16];
        field {
            name = "vbchroma_offset";
            desc = "Vertical chrominance offset, in (s, 4, 12) format. The value is expressed as a complement.";
            sw = rw; hw = r;
            reset = 0x0;
        } vbchroma_offset[15:0];
    } WBC_DHD1_ZME_VBOFFSET @ 0xAEE4;
    reg {
        name = "CBM_BKG2";
        desc = "CBM_BKG2 is a CBM mixer 2 overlay background color register. (offset 0xB420; total reset 0x00000000; PROVEN: Hi3521A/Hi3520D V300 data sheet (Issue 00B07, 2015-12-10), section 5.10, PDF page 1349).";
        field {
            name = "reserved";
            desc = "Reserved";
            sw = r; hw = w;
            reset = 0x0;
        } reserved_31_30[31:30];
        field {
            name = "cbm_bkgy2";
            desc = "Overlay background color of CBM mixer 2, Y component";
            sw = rw; hw = r;
            reset = 0x0;
        } cbm_bkgy2[29:20];
        field {
            name = "cbm_bkgcb2";
            desc = "Overlay background color of CBM mixer 2, Cb component";
            sw = rw; hw = r;
            reset = 0x0;
        } cbm_bkgcb2[19:10];
        field {
            name = "cbm_bkgcr2";
            desc = "Overlay background color of CBM mixer 2, Cr component";
            sw = rw; hw = r;
            reset = 0x0;
        } cbm_bkgcr2[9:0];
    } CBM_BKG2 @ 0xB420;
    reg {
        name = "CBM_MIX2";
        desc = "CBM_MIX2 is a CBM mixer 2 priority configuration register (instant register). The register configuration takes effect only when the VSYNC signal is valid. mixer_prio_x is the overlay layer priority x. (offset 0xB428; total reset 0x00000000; PROVEN: Hi3521A/Hi3520D V300 data sheet (Issue 00B07, 2015-12-10), section 5.10, PDF page 1349).";
        field {
            name = "reserved";
            desc = "Reserved";
            sw = r; hw = w;
            reset = 0x0;
        } reserved_31_20[31:20];
        field {
            name = "mixer_prio4";
            desc = "Drive layer of CBM mixer 2 with priority 4
- 0000: no drive layer
- 0011: V3
- 0100: G4
- 1001: V1
- 1010: HC0

Other values: reserved";
            sw = rw; hw = r;
            reset = 0x0;
        } mixer_prio4[19:16];
        field {
            name = "mixer_prio3";
            desc = "Drive layer of CBM mixer 2 with priority 3
- 0000: no drive layer
- 0011: V3
- 0100: G4
- 1001: V1
- 1010: HC0

Other values: reserved";
            sw = rw; hw = r;
            reset = 0x0;
        } mixer_prio3[15:12];
        field {
            name = "mixer_prio2";
            desc = "Drive layer of CBM mixer 2 with priority 2
- 0000: no drive layer
- 0011: V3
- 0100: G4
- 1001: V1
- 1010: HC0

Other values: reserved";
            sw = rw; hw = r;
            reset = 0x0;
        } mixer_prio2[11:8];
        field {
            name = "mixer_prio1";
            desc = "Drive layer of CBM mixer 2 with priority 1
- 0000: no drive layer
- 0011: V3
- 0100: G4
- 1001: V1
- 1010: HC0

Other values: reserved";
            sw = rw; hw = r;
            reset = 0x0;
        } mixer_prio1[7:4];
        field {
            name = "mixer_prio0";
            desc = "Drive layer of CBM mixer 2 with priority 0
- 0000: no drive layer
- 0011: V3
- 0100: G4
- 1001: V1
- 1010: HC0

Other values: reserved";
            sw = rw; hw = r;
            reset = 0x0;
        } mixer_prio0[3:0];
    } CBM_MIX2 @ 0xB428;
    reg {
        name = "MIXDSD_BKG";
        desc = "MIXDSD_BKG is a DSD mixer 1 overlay background color register. (offset 0xB600; total reset 0x00000000; PROVEN: Hi3521A/Hi3520D V300 data sheet (Issue 00B07, 2015-12-10), section 5.10, PDF page 1350).";
        field {
            name = "reserved";
            desc = "Reserved";
            sw = r; hw = w;
            reset = 0x0;
        } reserved_31_30[31:30];
        field {
            name = "mixer_bkgy";
            desc = "Overlay background color of MIXDSD, Y component";
            sw = rw; hw = r;
            reset = 0x0;
        } mixer_bkgy[29:20];
        field {
            name = "mixer_bkgcb";
            desc = "Overlay background color of MIXDSD, Cb component";
            sw = rw; hw = r;
            reset = 0x0;
        } mixer_bkgcb[19:10];
        field {
            name = "mixer_bkgcr";
            desc = "Overlay background color of MIXDSD, Cr component";
            sw = rw; hw = r;
            reset = 0x0;
        } mixer_bkgcr[9:0];
    } MIXDSD_BKG @ 0xB600;
    reg {
        name = "MIXDSD_MIX";
        desc = "MIXDSD_MIX is a DSD mixer 1 priority configuration register (instant register). The register configuration takes effect only when the VSYNC signal is valid. mixer_prio_x is overly layer priority x. (offset 0xB608; total reset 0x00000001; PROVEN: Hi3521A/Hi3520D V300 data sheet (Issue 00B07, 2015-12-10), section 5.10, PDF page 1351).";
        field {
            name = "reserved";
            desc = "Reserved";
            sw = r; hw = w;
            reset = 0x0;
        } reserved_31_16[31:16];
        field {
            name = "mixer_prio3";
            desc = "Drive layer of DSD mixer 1 with priority 3
- 000: no drive layer
- 0001: V4
- 0010: G1
- 1001: HC1
- 1010: HC0

Other values: reserved";
            sw = rw; hw = r;
            reset = 0x0;
        } mixer_prio3[15:12];
        field {
            name = "mixer_prio2";
            desc = "Drive layer of DSD mixer 1 with priority 2
- 000: no drive layer
- 0001: V4
- 0010: G1
- 1010: HC0

Other values: reserved";
            sw = rw; hw = r;
            reset = 0x0;
        } mixer_prio2[11:8];
        field {
            name = "mixer_prio1";
            desc = "Drive layer of DSD mixer 1 with priority 1
- 000: no drive layer
- 0001: V4
- 0010: G1
- 1010: HC0

Other values: reserved";
            sw = rw; hw = r;
            reset = 0x0;
        } mixer_prio1[7:4];
        field {
            name = "mixer_prio0";
            desc = "Drive layer of DSD mixer 1 with priority 0
- 000: no drive layer
- 0001: V4
- 0010: G1
- 1010: HC0

Other values: reserved";
            sw = rw; hw = r;
            reset = 0x1;
        } mixer_prio0[3:0];
    } MIXDSD_MIX @ 0xB608;
    reg {
        name = "DHD1_CTRL";
        desc = "DHD1_CTRL is a display channel global control register. You must configure any bit of this register before configuring DHD1_CTRL[intf_en]. Otherwise, the configuration does not take effect. (offset 0xC400; total reset 0x00000000; PROVEN: Hi3521A/Hi3520D V300 data sheet (Issue 00B07, 2015-12-10), section 5.10, PDF page 1352).";
        field {
            name = "intf_en";
            desc = "Display interface enable (instant register). Data is output over the interface only when this field is enabled.
- 0: disabled
- 1: enabled";
            sw = rw; hw = r;
            reset = 0x0;
        } intf_en[31:31];
        field {
            name = "cbar_en";
            desc = "Color bar enable. The color bar is output over the interface when this field is enabled.
- 0: disabled
- 1: enabled";
            sw = rw; hw = r;
            reset = 0x0;
        } cbar_en[30:30];
        field {
            name = "cbar_sel";
            desc = "Color space select for the output color bar (instant register)
- 0: VGA
- 1: YPbPr";
            sw = rw; hw = r;
            reset = 0x0;
        } cbar_sel[29:29];
        field {
            name = "reserved";
            desc = "Reserved";
            sw = r; hw = w;
            reset = 0x0;
        } reserved_28_28[28:28];
        field {
            name = "fpga_lmt_en";
            desc = "Debug field. As the frequency of the FPGA clock bus is limited, the 1080i picture cannot be displayed. After this bit is enabled, the picture with 1280-pixel width can be displayed over the 1080i interface.
- 0: disabled
- 1: enabled";
            sw = rw; hw = r;
            reset = 0x0;
        } fpga_lmt_en[27:27];
        field {
            name = "fpga_lmt_width";
            desc = "Debug field. When fpga_lmt_en is enabled, the active region width of the VDP interface depends on this field. The actual width of the active region is calculated as follows: Actual width of the active region = fpga_lmt_width x 16";
            sw = rw; hw = r;
            reset = 0x0;
        } fpga_lmt_width[26:20];
        field {
            name = "reserved";
            desc = "Reserved";
            sw = r; hw = w;
            reset = 0x0;
        } reserved_19_5[19:5];
        field {
            name = "iop";
            desc = "Progressive or interlaced display (non-instant register)
- 0: interlaced display
- 1: progressive display";
            sw = rw; hw = r;
            reset = 0x0;
        } iop[4:4];
        field {
            name = "reserved";
            desc = "Reserved";
            sw = r; hw = w;
            reset = 0x0;
        } reserved_3_1[3:1];
        field {
            name = "regup";
            desc = "Surface register update. After the registers at this layer are configured, the registers are updated when the value 1 is written to this bit. After updates, this bit is automatically cleared by the hardware.

Access type WC in the data sheet: written 1 clears the bit.";
            sw = rw; hw = w; onwrite = woclr;
            reset = 0x0;
        } regup[0:0];
    } DHD1_CTRL @ 0xC400;
    reg {
        name = "DHD1_VSYNC";
        desc = "DHD1_VSYNC is a top field vertical sync timing register in interlaced output mode or frame vertical sync timing register in progressive output mode. This register is a non-instant register. (offset 0xC404; total reset 0x0011321B; PROVEN: Hi3521A/Hi3520D V300 data sheet (Issue 00B07, 2015-12-10), section 5.10, PDF page 1353).";
        field {
            name = "reserved";
            desc = "Reserved";
            sw = r; hw = w;
            reset = 0x0;
        } reserved_31_28[31:28];
        field {
            name = "vfb";
            desc = "In interlaced output mode: top vertical front blanking (TVFB) In progressive output mode: vertical front blanking (VFB)";
            sw = rw; hw = r;
            reset = 0x1;
        } vfb[27:20];
        field {
            name = "vbb";
            desc = "In interlaced output mode: top vertical back blanking (TVBB) In progressive output mode: vertical back blanking (VBB)+vertical pulse width (VPW)";
            sw = rw; hw = r;
            reset = 0x13;
        } vbb[19:12];
        field {
            name = "vact";
            desc = "In interlaced output mode: height of active picture on the top field In progressive output mode: height of an active picture in a frame. The register value is the actual value minus 1.";
            sw = rw; hw = r;
            reset = 0x21b;
        } vact[11:0];
    } DHD1_VSYNC @ 0xC404;
    reg {
        name = "DHD1_HSYNC1";
        desc = "DHD1_HSYNC1 is horizontal sync configuration register 1 in interlaced or progressive output mode (non-instant register). (offset 0xC408; total reset 0x00BF077F; PROVEN: Hi3521A/Hi3520D V300 data sheet (Issue 00B07, 2015-12-10), section 5.10, PDF page 1354).";
        field {
            name = "hbb";
            desc = "Horizontal back blanking (HBB), in pixel";
            sw = rw; hw = r;
            reset = 0xbf;
        } hbb[31:16];
        field {
            name = "hact";
            desc = "Number of horizontal pixels in an active region";
            sw = rw; hw = r;
            reset = 0x77f;
        } hact[15:0];
    } DHD1_HSYNC1 @ 0xC408;
    reg {
        name = "DHD1_HSYNC2";
        desc = "DHD1_HSYNC2 is horizontal sync configuration register 2 in interlaced or progressive output mode (non-instant register). (offset 0xC40C; total reset 0x0000020F; PROVEN: Hi3521A/Hi3520D V300 data sheet (Issue 00B07, 2015-12-10), section 5.10, PDF page 1354).";
        field {
            name = "hmid";
            desc = "Bottom vertical sync active pixel (active region)";
            sw = rw; hw = r;
            reset = 0x0;
        } hmid[31:16];
        field {
            name = "hfb";
            desc = "Horizontal front blanking (HFB), in pixel";
            sw = rw; hw = r;
            reset = 0x20f;
        } hfb[15:0];
    } DHD1_HSYNC2 @ 0xC40C;
    reg {
        name = "DHD1_VPLUS";
        desc = "DHD1_VPLUS is a bottom field vertical sync timing in interlaced output mode (non-instant register). (offset 0xC410; total reset 0x0021321B; PROVEN: Hi3521A/Hi3520D V300 data sheet (Issue 00B07, 2015-12-10), section 5.10, PDF page 1355).";
        field {
            name = "reserved";
            desc = "Reserved";
            sw = r; hw = w;
            reset = 0x0;
        } reserved_31_28[31:28];
        field {
            name = "bvfb";
            desc = "Bottom vertical front blanking (BVFB) in interlaced output mode";
            sw = rw; hw = r;
            reset = 0x2;
        } bvfb[27:20];
        field {
            name = "bvbb";
            desc = "Bottom vertical back blanking (BVBB)+VPW in interlaced output mode";
            sw = rw; hw = r;
            reset = 0x13;
        } bvbb[19:12];
        field {
            name = "bvact";
            desc = "Height of an active picture in the bottom field in interlaced output mode The register value is the actual value minus 1.";
            sw = rw; hw = r;
            reset = 0x21b;
        } bvact[11:0];
    } DHD1_VPLUS @ 0xC410;
    reg {
        name = "DHD1_PWR";
        desc = "DHD1_PWR is a sync signal pulse width register (non-instant register). (offset 0xC414; total reset 0x00000000; PROVEN: Hi3521A/Hi3520D V300 data sheet (Issue 00B07, 2015-12-10), section 5.10, PDF page 1355).";
        field {
            name = "reserved";
            desc = "Reserved";
            sw = r; hw = w;
            reset = 0x0;
        } reserved_31_24[31:24];
        field {
            name = "vpw";
            desc = "VPW minus 1.";
            sw = rw; hw = r;
            reset = 0x0;
        } vpw[23:16];
        field {
            name = "hpw";
            desc = "Horizontal pulse width (HPW) minus 1.";
            sw = rw; hw = r;
            reset = 0x0;
        } hpw[15:0];
    } DHD1_PWR @ 0xC414;
    reg {
        name = "DHD1_VTTHD3";
        desc = "DHD1_VTTHD3 is a vertical timing threshold register (instant register). It can be used to set two thresholds for generating two interrupts separately. (offset 0xC418; total reset 0x00000000; PROVEN: Hi3521A/Hi3520D V300 data sheet (Issue 00B07, 2015-12-10), section 5.10, PDF page 1356).";
        field {
            name = "thd4_mode";
            desc = "Mode of generating threshold 4
- 0: frame mode. The threshold count is in the unit of frame.
- 1: field mode. The threshold count is in the unit of field during interlaced displaying.";
            sw = rw; hw = r;
            reset = 0x0;
        } thd4_mode[31:31];
        field {
            name = "reserved";
            desc = "Reserved";
            sw = r; hw = w;
            reset = 0x0;
        } reserved_30_29[30:29];
        field {
            name = "vtmgthd4";
            desc = "Vertical timing threshold 4 for simultaneously triggering DHD and DSD. The start time of the DSD interface timing is later than that of the DHD interface timing and is equal to the number of lines configured in vtmgthd4.";
            sw = rw; hw = r;
            reset = 0x0;
        } vtmgthd4[28:16];
        field {
            name = "thd3_mode";
            desc = "Mode of generating threshold 3
- 0: frame mode. The threshold count is in the unit of frame.
- 1: field mode. The threshold count is in the unit of field during interlaced displaying.";
            sw = rw; hw = r;
            reset = 0x0;
        } thd3_mode[15:15];
        field {
            name = "reserved";
            desc = "Reserved";
            sw = r; hw = w;
            reset = 0x0;
        } reserved_14_13[14:13];
        field {
            name = "vtmgthd3";
            desc = "Vertical timing threshold 3. When the vertical timing counter reaches this threshold, the VOINTSTA[dhdvtthd3_int] interrupt is triggered.";
            sw = rw; hw = r;
            reset = 0x0;
        } vtmgthd3[12:0];
    } DHD1_VTTHD3 @ 0xC418;
    reg {
        name = "DHD1_VTTHD";
        desc = "DHD1_VTTHD is a vertical timing threshold register (instant register). It can be used to set two thresholds for generating two interrupts separately. (offset 0xC11C; total reset 0x00010001; PROVEN: Hi3521A/Hi3520D V300 data sheet (Issue 00B07, 2015-12-10), section 5.10, PDF page 1356).";
        field {
            name = "thd2_mode";
            desc = "Mode of generating threshold 2
- 0: frame mode. The threshold count is in the unit of frame.
- 1: field mode. The threshold count is in the unit of field during interlaced displaying";
            sw = rw; hw = r;
            reset = 0x0;
        } thd2_mode[31:31];
        field {
            name = "reserved";
            desc = "Reserved";
            sw = r; hw = w;
            reset = 0x0;
        } reserved_30_29[30:29];
        field {
            name = "vtmgthd2";
            desc = "Vertical timing threshold 2. When the vertical timing counter reaches this threshold, the VOINTSTA[dhdvtthd2_int] interrupt is triggered.";
            sw = rw; hw = r;
            reset = 0x1;
        } vtmgthd2[28:16];
        field {
            name = "thd1_mode";
            desc = "Mode of generating threshold 1
- 0: frame mode. The threshold count is in the unit of frame.
- 1: field mode. The threshold count is in the unit of field during interlaced displaying";
            sw = rw; hw = r;
            reset = 0x0;
        } thd1_mode[15:15];
        field {
            name = "reserved";
            desc = "Reserved";
            sw = r; hw = w;
            reset = 0x0;
        } reserved_14_13[14:13];
        field {
            name = "vtmgthd1";
            desc = "Vertical timing threshold 1. When the vertical timing counter reaches this threshold, the VOINTSTA[dhdvtthd_int1] interrupt is triggered.";
            sw = rw; hw = r;
            reset = 0x1;
        } vtmgthd1[12:0];
    } DHD1_VTTHD @ 0xC11C;
    reg {
        name = "DHD1_AFFTHD";
        desc = "DHD1_AFFTHD is a DHD buffer FIFO register. (offset 0xC430; total reset 0x00000020; PROVEN: Hi3521A/Hi3520D V300 data sheet (Issue 00B07, 2015-12-10), section 5.10, PDF page 1357).";
        field {
            name = "reserved";
            desc = "Reserved";
            sw = rw; hw = r;
            reset = 0x0;
        } reserved_31_11[31:11];
        field {
            name = "dhd_aff_thd";
            desc = "DHD buffer FIFO register";
            sw = rw; hw = r;
            reset = 0x20;
        } dhd_aff_thd[10:0];
    } DHD1_AFFTHD @ 0xC430;
    reg {
        name = "DHD1_ABUFTHD";
        desc = "DHD1_ABUFTHD is a DHD buffer register. (offset 0xC434; total reset 0x00000073; PROVEN: Hi3521A/Hi3520D V300 data sheet (Issue 00B07, 2015-12-10), section 5.10, PDF page 1358).";
        field {
            name = "reserved";
            desc = "Reserved";
            sw = rw; hw = r;
            reset = 0x0;
        } reserved_31_11[31:11];
        field {
            name = "dhd_buf_thd";
            desc = "DHD buffer register";
            sw = rw; hw = r;
            reset = 0x73;
        } dhd_buf_thd[10:0];
    } DHD1_ABUFTHD @ 0xC434;
    reg {
        name = "DHD1_DACDET1";
        desc = "DHD1_DACDET1 is DAC automatic detection register 1. (offset 0xC438; total reset 0x000D0303; PROVEN: Hi3521A/Hi3520D V300 data sheet (Issue 00B07, 2015-12-10), section 5.10, PDF page 1358). INFERRED: the register header of the data sheet prints the name DHD1_VGA_DACDET1; the title, the description and the summary table say DHD1_DACDET1.";
        field {
            name = "reserved";
            desc = "Reserved";
            sw = r; hw = w;
            reset = 0x0;
        } reserved_31_26[31:26];
        field {
            name = "det_line";
            desc = "Line of the detected level";
            sw = rw; hw = r;
            reset = 0xd;
        } det_line[25:16];
        field {
            name = "reserved";
            desc = "Reserved";
            sw = r; hw = w;
            reset = 0x0;
        } reserved_15_10[15:10];
        field {
            name = "vdac_det_high";
            desc = "Detected level";
            sw = rw; hw = r;
            reset = 0x303;
        } vdac_det_high[9:0];
    } DHD1_DACDET1 @ 0xC438;
    reg {
        name = "DHD1_DACDET2";
        desc = "DHD1_DACDET2 is DAC automatic detection register 2. (offset 0xC43C; total reset 0x00300118; PROVEN: Hi3521A/Hi3520D V300 data sheet (Issue 00B07, 2015-12-10), section 5.10, PDF page 1358). INFERRED: the register header of the data sheet prints the name DHD1_VGA_DACDET2; the summary table says DHD1_DACDET2.";
        field {
            name = "vdac_det_en";
            desc = "DAC automatic detection enable
- 0: disabled
- 1: enabled";
            sw = rw; hw = r;
            reset = 0x0;
        } vdac_det_en[31:31];
        field {
            name = "reserved";
            desc = "Reserved";
            sw = r; hw = w;
            reset = 0x0;
        } reserved_30_27[30:27];
        field {
            name = "det_pixel_wid";
            desc = "Level width";
            sw = rw; hw = r;
            reset = 0x30;
        } det_pixel_wid[26:16];
        field {
            name = "reserved";
            desc = "Reserved";
            sw = r; hw = w;
            reset = 0x0;
        } reserved_15_11[15:11];
        field {
            name = "det_pixel_sta";
            desc = "Start position of a line";
            sw = rw; hw = r;
            reset = 0x118;
        } det_pixel_sta[10:0];
    } DHD1_DACDET2 @ 0xC43C;
    reg {
        name = "DHD1_PARATHD";
        desc = "DHD1_PARATHDis a PARA coefficient update point threshold register. (offset 0xC4B0; total reset 0x00000000; PROVEN: Hi3521A/Hi3520D V300 data sheet (Issue 00B07, 2015-12-10), section 5.10, PDF page 1359).";
        field {
            name = "reserved";
            desc = "Reserved";
            sw = rw; hw = r;
            reset = 0x0;
        } reserved_31_6[31:6];
        field {
            name = "para_thd";
            desc = "PARA coefficient update point threshold. It indicates the line after the vertical back blanking where the update point occurs. This field is valid only after DFS is enabled.";
            sw = rw; hw = r;
            reset = 0x0;
        } para_thd[5:0];
    } DHD1_PARATHD @ 0xC4B0;
    reg {
        name = "DHD1_START_POS";
        desc = "DHD1_START_POS is a DHD start signal start position register. (offset 0xC4B4; total reset 0x00000805; PROVEN: Hi3521A/Hi3520D V300 data sheet (Issue 00B07, 2015-12-10), section 5.10, PDF page 1359).";
        field {
            name = "reserved";
            desc = "Reserved";
            sw = rw; hw = r;
            reset = 0x0;
        } reserved_31_16[31:16];
        field {
            name = "timing_start_pos";
            desc = "Number of lines before the active region where the timing_gen state machine starts to work";
            sw = rw; hw = r;
            reset = 0x8;
        } timing_start_pos[15:8];
        field {
            name = "start_pos";
            desc = "Number of lines before the active region where the start signal is generated in online mode";
            sw = rw; hw = r;
            reset = 0x5;
        } start_pos[7:0];
    } DHD1_START_POS @ 0xC4B4;
    reg {
        name = "DHD1_STATE";
        desc = "DHD1_STATE is a DHD1 status register. (offset 0xC4F0; total reset 0x00000006; PROVEN: Hi3521A/Hi3520D V300 data sheet (Issue 00B07, 2015-12-10), section 5.10, PDF page 1360).";
        field {
            name = "reserved";
            desc = "Reserved";
            sw = r; hw = w;
            reset = 0x0;
        } reserved_31_24[31:24];
        field {
            name = "count_int";
            desc = "DHD1 interrupt count. The interrupt count is increased by 1 each time a vertical timing interrupt is reported.";
            sw = r; hw = w;
            reset = 0x0;
        } count_int[23:16];
        field {
            name = "vcnt";
            desc = "Active display line count of DHD1";
            sw = r; hw = w;
            reset = 0x0;
        } vcnt[15:3];
        field {
            name = "bottom_field";
            desc = "DHD1 top/bottom field display flag
- 0: top field
- 1: bottom field";
            sw = r; hw = w;
            reset = 0x1;
        } bottom_field[2:2];
        field {
            name = "vblank";
            desc = "DHD1 blanking region display flag
- 0: active region
- 1: blanking region";
            sw = r; hw = w;
            reset = 0x1;
        } vblank[1:1];
        field {
            name = "vback_blank";
            desc = "DHD1 back blanking region display flag
- 0: non-back blanking region
- 1: blanking region";
            sw = r; hw = w;
            reset = 0x0;
        } vback_blank[0:0];
    } DHD1_STATE @ 0xC4F0;
    reg {
        name = "INTF_CTRL";
        desc = "INTF_CTRL is an output interface control register. (offset 0xD000; total reset 0x00000000; PROVEN: Hi3521A/Hi3520D V300 data sheet (Issue 00B07, 2015-12-10), section 5.10, PDF page 1361).";
        field {
            name = "hdmi_mode";
            desc = "Color space select for the output HDMI data (non-instant register)
- 0: YUV
- 1: RGB";
            sw = rw; hw = r;
            reset = 0x0;
        } hdmi_mode[31:31];
        field {
            name = "reserved";
            desc = "Reserved";
            sw = r; hw = w;
            reset = 0x0;
        } reserved_30_0[30:0];
    } INTF_CTRL @ 0xD000;
    reg {
        name = "INTF_SYNC_INV";
        desc = "INTF_SYNC_INV is sync signal polarity configuration register in external sync timing output mode. The setting of this register takes effect immediately after configuration. That is, the polarity of the corresponding sync signal is immediately affected. (offset 0xD008; total reset 0x00000000; PROVEN: Hi3521A/Hi3520D V300 data sheet (Issue 00B07, 2015-12-10), section 5.10, PDF page 1361).";
        field {
            name = "reserved";
            desc = "Reserved";
            sw = r; hw = w;
            reset = 0x0;
        } reserved_31_4[31:4];
        field {
            name = "f_inv";
            desc = "Output phase reverse enable for the odd/even field indicator signal (instant register)
- 0: disabled
- 1: enabled";
            sw = rw; hw = r;
            reset = 0x0;
        } f_inv[3:3];
        field {
            name = "vs_inv";
            desc = "Output phase reverse enable for the vertical sync pulse (instant register)
- 0: disabled
- 1: enabled";
            sw = rw; hw = r;
            reset = 0x0;
        } vs_inv[2:2];
        field {
            name = "hs_inv";
            desc = "Output phase reverse enable for the horizontal sync pulse (instant register)
- 0: disabled
- 1: enabled";
            sw = rw; hw = r;
            reset = 0x0;
        } hs_inv[1:1];
        field {
            name = "dv_inv";
            desc = "Output phase reverse enable for the data validity signal (instant register)
- 0: disabled
- 1: enabled";
            sw = rw; hw = r;
            reset = 0x0;
        } dv_inv[0:0];
    } INTF_SYNC_INV @ 0xD008;
    reg {
        name = "INTF_CLIP0_L";
        desc = "INTF_CLIP0_L is a clip lowest threshold register (instant register). (offset 0xD010; total reset 0x01004010; PROVEN: Hi3521A/Hi3520D V300 data sheet (Issue 00B07, 2015-12-10), section 5.10, PDF page 1362).";
        field {
            name = "reserved";
            desc = "Reserved";
            sw = r; hw = w;
            reset = 0x0;
        } reserved_31_30[31:30];
        field {
            name = "clip_cl2";
            desc = "Lowest threshold Y/R of component 2, unsigned integer";
            sw = rw; hw = r;
            reset = 0x10;
        } clip_cl2[29:20];
        field {
            name = "clip_cl1";
            desc = "Lowest threshold Cb/G of component 1, unsigned integer";
            sw = rw; hw = r;
            reset = 0x10;
        } clip_cl1[19:10];
        field {
            name = "clip_cl0";
            desc = "Lowest threshold Cr/B of component 0, unsigned integer";
            sw = rw; hw = r;
            reset = 0x10;
        } clip_cl0[9:0];
    } INTF_CLIP0_L @ 0xD010;
    reg {
        name = "INTF_CLIP0_H";
        desc = "INTF_CLIP0_H is a clip highest threshold register (instant register). For example, the output data needs to be clipped in BT.656 output mode. (offset 0xD014; total reset 0x0EB3C0F0; PROVEN: Hi3521A/Hi3520D V300 data sheet (Issue 00B07, 2015-12-10), section 5.10, PDF page 1363).";
        field {
            name = "reserved";
            desc = "Reserved";
            sw = r; hw = w;
            reset = 0x0;
        } reserved_31_30[31:30];
        field {
            name = "clip_ch2";
            desc = "Highest threshold Y/R of component 2, unsigned integer";
            sw = rw; hw = r;
            reset = 0xeb;
        } clip_ch2[29:20];
        field {
            name = "clip_ch1";
            desc = "Highest threshold Cb/G of component 1, unsigned integer";
            sw = rw; hw = r;
            reset = 0xf0;
        } clip_ch1[19:10];
        field {
            name = "clip_ch0";
            desc = "Highest threshold Cr/B of component 0, unsigned integer";
            sw = rw; hw = r;
            reset = 0xf0;
        } clip_ch0[9:0];
    } INTF_CLIP0_H @ 0xD014;
    reg {
        name = "INTF_CSC_IDC";
        desc = "INTF_CSC_IDC is a CSC input DC component register (instant register). (offset 0xD020; total reset 0x00000000; PROVEN: Hi3521A/Hi3520D V300 data sheet (Issue 00B07, 2015-12-10), section 5.10, PDF page 1363).";
        field {
            name = "reserved";
            desc = "Reserved";
            sw = r; hw = w;
            reset = 0x0;
        } reserved_31_23[31:23];
        field {
            name = "csc_en";
            desc = "CSC enable
- 0: disabled
- 1: enabled";
            sw = rw; hw = r;
            reset = 0x0;
        } csc_en[22:22];
        field {
            name = "cscidc1";
            desc = "DC parameter of the input component 1. The MSB is the signed bit. The value is expressed as a complement.";
            sw = rw; hw = r;
            reset = 0x0;
        } cscidc1[21:11];
        field {
            name = "cscidc0";
            desc = "DC parameter of the input component 0. The MSB is the signed bit. The value is expressed as a complement.";
            sw = rw; hw = r;
            reset = 0x0;
        } cscidc0[10:0];
    } INTF_CSC_IDC @ 0xD020;
    reg {
        name = "INTF_CSC_ODC";
        desc = "INTF_CSC_ODC is a CSC output DC component register (instant register). (offset 0xD024; total reset 0x00000000; PROVEN: Hi3521A/Hi3520D V300 data sheet (Issue 00B07, 2015-12-10), section 5.10, PDF page 1364).";
        field {
            name = "reserved";
            desc = "Reserved";
            sw = r; hw = w;
            reset = 0x0;
        } reserved_31_23[31:23];
        field {
            name = "csc_sign_mode";
            desc = "CSC output mode
- 0: The CSC output is a 10-bit unsigned number.
- 1: The CSC output is a 12-bit signed number.";
            sw = rw; hw = r;
            reset = 0x0;
        } csc_sign_mode[22:22];
        field {
            name = "cscodc1";
            desc = "DC parameter of the output component 1. The MSB is the signed bit. The value is expressed as a complement.";
            sw = rw; hw = r;
            reset = 0x0;
        } cscodc1[21:11];
        field {
            name = "cscodc0";
            desc = "DC parameter of the output component 0. The MSB is the signed bit. The value is expressed as a complement.";
            sw = rw; hw = r;
            reset = 0x0;
        } cscodc0[10:0];
    } INTF_CSC_ODC @ 0xD024;
    reg {
        name = "INTF_CSC_IODC";
        desc = "INTF_CSC_IODC is a CSC input/output DC component register (instant register). (offset 0xD028; total reset 0x00000000; PROVEN: Hi3521A/Hi3520D V300 data sheet (Issue 00B07, 2015-12-10), section 5.10, PDF page 1364).";
        field {
            name = "reserved";
            desc = "Reserved";
            sw = r; hw = w;
            reset = 0x0;
        } reserved_31_22[31:22];
        field {
            name = "cscodc2";
            desc = "DC parameter of the output component 2. The MSB is the signed bit. The value is expressed as a complement.";
            sw = rw; hw = r;
            reset = 0x0;
        } cscodc2[21:11];
        field {
            name = "cscidc2";
            desc = "DC parameter of the input component 2. The MSB is the signed bit. The value is expressed as a complement.";
            sw = rw; hw = r;
            reset = 0x0;
        } cscidc2[10:0];
    } INTF_CSC_IODC @ 0xD028;
    reg {
        name = "INTF_CSC_P0";
        desc = "INTF_CSC_P0 is a CSC parameter 0 register (instant register). (offset 0xD02C; total reset 0x00000000; PROVEN: Hi3521A/Hi3520D V300 data sheet (Issue 00B07, 2015-12-10), section 5.10, PDF page 1365).";
        field {
            name = "reserved";
            desc = "Reserved";
            sw = r; hw = w;
            reset = 0x0;
        } reserved_31_31[31:31];
        field {
            name = "cscp01";
            desc = "5.10 data format indicating one sign bit, four integer bits, and 10 decimal bits. The value is represented by a complement.";
            sw = rw; hw = r;
            reset = 0x0;
        } cscp01[30:16];
        field {
            name = "reserved";
            desc = "Reserved";
            sw = r; hw = w;
            reset = 0x0;
        } reserved_15_15[15:15];
        field {
            name = "cscp00";
            desc = "5.10 data format indicating one sign bit, four integer bits, and 10 decimal bits. The value is represented by a complement.";
            sw = rw; hw = r;
            reset = 0x0;
        } cscp00[14:0];
    } INTF_CSC_P0 @ 0xD02C;
    reg {
        name = "INTF_CSC_P1";
        desc = "INTF_CSC_P1 is a CSC parameter 1 register (instant register). (offset 0xD030; total reset 0x00000000; PROVEN: Hi3521A/Hi3520D V300 data sheet (Issue 00B07, 2015-12-10), section 5.10, PDF page 1365).";
        field {
            name = "reserved";
            desc = "Reserved";
            sw = r; hw = w;
            reset = 0x0;
        } reserved_31_31[31:31];
        field {
            name = "cscp10";
            desc = "5.10 data format indicating one sign bit, four integer bits, and 10 decimal bits. The value is represented by a complement.";
            sw = rw; hw = r;
            reset = 0x0;
        } cscp10[30:16];
        field {
            name = "reserved";
            desc = "Reserved";
            sw = r; hw = w;
            reset = 0x0;
        } reserved_15_15[15:15];
        field {
            name = "cscp02";
            desc = "5.10 data format indicating one sign bit, four integer bits, and 10 decimal bits. The value is represented by a complement.";
            sw = rw; hw = r;
            reset = 0x0;
        } cscp02[14:0];
    } INTF_CSC_P1 @ 0xD030;
    reg {
        name = "INTF_CSC_P2";
        desc = "INTF_CSC_P2 is a CSC parameter 2 register (instant register). (offset 0xD034; total reset 0x00000000; PROVEN: Hi3521A/Hi3520D V300 data sheet (Issue 00B07, 2015-12-10), section 5.10, PDF page 1366).";
        field {
            name = "reserved";
            desc = "Reserved";
            sw = r; hw = w;
            reset = 0x0;
        } reserved_31_31[31:31];
        field {
            name = "cscp12";
            desc = "5.10 data format indicating one sign bit, four integer bits, and 10 decimal bits. The value is represented by a complement.";
            sw = rw; hw = r;
            reset = 0x0;
        } cscp12[30:16];
        field {
            name = "reserved";
            desc = "Reserved";
            sw = r; hw = w;
            reset = 0x0;
        } reserved_15_15[15:15];
        field {
            name = "cscp11";
            desc = "5.10 data format indicating one sign bit, four integer bits, and 10 decimal bits. The value is represented by a complement.";
            sw = rw; hw = r;
            reset = 0x0;
        } cscp11[14:0];
    } INTF_CSC_P2 @ 0xD034;
    reg {
        name = "INTF_CSC_P3";
        desc = "INTF_CSC_P3 is a CSC parameter 3 register (instant register). (offset 0xD038; total reset 0x00000000; PROVEN: Hi3521A/Hi3520D V300 data sheet (Issue 00B07, 2015-12-10), section 5.10, PDF page 1366).";
        field {
            name = "reserved";
            desc = "Reserved";
            sw = r; hw = w;
            reset = 0x0;
        } reserved_31_31[31:31];
        field {
            name = "cscp21";
            desc = "5.10 data format indicating one sign bit, four integer bits, and 10 decimal bits. The value is represented by a complement.";
            sw = rw; hw = r;
            reset = 0x0;
        } cscp21[30:16];
        field {
            name = "reserved";
            desc = "Reserved";
            sw = r; hw = w;
            reset = 0x0;
        } reserved_15_15[15:15];
        field {
            name = "cscp20";
            desc = "5.10 data format indicating one sign bit, four integer bits, and 10 decimal bits. The value is represented by a complement.";
            sw = rw; hw = r;
            reset = 0x0;
        } cscp20[14:0];
    } INTF_CSC_P3 @ 0xD038;
    reg {
        name = "INTF_CSC_P4";
        desc = "INTF_CSC_P4 is a CSC parameter 4 register (instant register). (offset 0xD03C; total reset 0x00000000; PROVEN: Hi3521A/Hi3520D V300 data sheet (Issue 00B07, 2015-12-10), section 5.10, PDF page 1367).";
        field {
            name = "reserved";
            desc = "Reserved";
            sw = r; hw = w;
            reset = 0x0;
        } reserved_31_15[31:15];
        field {
            name = "cscp22";
            desc = "5.10 data format indicating one sign bit, four integer bits, and 10 decimal bits. The value is represented by a complement.";
            sw = rw; hw = r;
            reset = 0x0;
        } cscp22[14:0];
    } INTF_CSC_P4 @ 0xD03C;
    reg {
        name = "INTF_HSPCFG0";
        desc = "INTF_HSPCFG0 is HSP configuration register 0 (instant register). (offset 0xD040; total reset 0x00000000; PROVEN: Hi3521A/Hi3520D V300 data sheet (Issue 00B07, 2015-12-10), section 5.10, PDF page 1367).";
        field {
            name = "hsp_hf0_tmp3";
            desc = "High-frequency filtering coefficient 3, signed number";
            sw = rw; hw = r;
            reset = 0x0;
        } hsp_hf0_tmp3[31:24];
        field {
            name = "hsp_hf0_tmp2";
            desc = "High-frequency filtering coefficient 2, signed number";
            sw = rw; hw = r;
            reset = 0x0;
        } hsp_hf0_tmp2[23:16];
        field {
            name = "hsp_hf0_tmp1";
            desc = "High-frequency filtering coefficient 1, signed number";
            sw = rw; hw = r;
            reset = 0x0;
        } hsp_hf0_tmp1[15:8];
        field {
            name = "hsp_hf0_tmp0";
            desc = "High-frequency filtering coefficient 0, signed number";
            sw = rw; hw = r;
            reset = 0x0;
        } hsp_hf0_tmp0[7:0];
    } INTF_HSPCFG0 @ 0xD040;
    reg {
        name = "INTF_HSPCFG1";
        desc = "INTF_HSPCFG1 is HSP configuration register 1 (instant register). (offset 0xD044; total reset 0x00000000; PROVEN: Hi3521A/Hi3520D V300 data sheet (Issue 00B07, 2015-12-10), section 5.10, PDF page 1368).";
        field {
            name = "hsp_en";
            desc = "HSP enable
- 0: disabled
- 1: enabled";
            sw = rw; hw = r;
            reset = 0x0;
        } hsp_en[31:31];
        field {
            name = "reserved";
            desc = "Reserved";
            sw = r; hw = w;
            reset = 0x0;
        } reserved_30_8[30:8];
        field {
            name = "hsp_hf0_coring";
            desc = "High-frequency coring coefficient, unsigned number";
            sw = rw; hw = r;
            reset = 0x0;
        } hsp_hf0_coring[7:0];
    } INTF_HSPCFG1 @ 0xD044;
    reg {
        name = "INTF_HSPCFG5";
        desc = "INTF_HSPCFG5 is HSP configuration register 5 (instant register). (offset 0xD054; total reset 0x00000000; PROVEN: Hi3521A/Hi3520D V300 data sheet (Issue 00B07, 2015-12-10), section 5.10, PDF page 1368).";
        field {
            name = "reserved";
            desc = "Reserved";
            sw = r; hw = w;
            reset = 0x0;
        } reserved_31_27[31:27];
        field {
            name = "hsp_hf0_gainneg";
            desc = "High-frequency gain negative polarity coefficient, signed number (10.8)";
            sw = rw; hw = r;
            reset = 0x0;
        } hsp_hf0_gainneg[26:16];
        field {
            name = "reserved";
            desc = "Reserved";
            sw = r; hw = w;
            reset = 0x0;
        } reserved_15_11[15:11];
        field {
            name = "hsp_hf0_gainpos";
            desc = "High-frequency gain positive polarity coefficient, signed number (10.8)";
            sw = rw; hw = r;
            reset = 0x0;
        } hsp_hf0_gainpos[10:0];
    } INTF_HSPCFG5 @ 0xD054;
    reg {
        name = "INTF_HSPCFG6";
        desc = "INTF_HSPCFG6 is HSP configuration register 6 (instant register). (offset 0xD058; total reset 0x00000000; PROVEN: Hi3521A/Hi3520D V300 data sheet (Issue 00B07, 2015-12-10), section 5.10, PDF page 1369).";
        field {
            name = "hsp_hf0_adpshoot_en";
            desc = "High-frequency adjustment threshold enable
- 0: disabled
- 1: enabled";
            sw = rw; hw = r;
            reset = 0x0;
        } hsp_hf0_adpshoot_en[31:31];
        field {
            name = "hsp_hf0_winsize";
            desc = "High-frequency window size, unsigned number. The value range is 0-4.";
            sw = rw; hw = r;
            reset = 0x0;
        } hsp_hf0_winsize[30:28];
        field {
            name = "reserved";
            desc = "Reserved";
            sw = r; hw = w;
            reset = 0x0;
        } reserved_27_24[27:24];
        field {
            name = "hsp_hf0_mixratio";
            desc = "High-frequency adjustment threshold ratio, unsigned number (8.7)";
            sw = rw; hw = r;
            reset = 0x0;
        } hsp_hf0_mixratio[23:16];
        field {
            name = "hsp_hf0_underth";
            desc = "High-frequency adjustment lower threshold, unsigned number";
            sw = rw; hw = r;
            reset = 0x0;
        } hsp_hf0_underth[15:8];
        field {
            name = "hsp_hf0_overth";
            desc = "High-frequency adjustment upper threshold, unsigned number";
            sw = rw; hw = r;
            reset = 0x0;
        } hsp_hf0_overth[7:0];
    } INTF_HSPCFG6 @ 0xD058;
    reg {
        name = "INTF_HSPCFG7";
        desc = "INTF_HSPCFG7 is HSP configuration register 7 (instant register). (offset 0xD05C; total reset 0x00000000; PROVEN: Hi3521A/Hi3520D V300 data sheet (Issue 00B07, 2015-12-10), section 5.10, PDF page 1369).";
        field {
            name = "hsp_hf1_tmp3";
            desc = "High-frequency filtering coefficient 3, signed number";
            sw = rw; hw = r;
            reset = 0x0;
        } hsp_hf1_tmp3[31:24];
        field {
            name = "hsp_hf1_tmp2";
            desc = "High-frequency filtering coefficient 2, signed number";
            sw = rw; hw = r;
            reset = 0x0;
        } hsp_hf1_tmp2[23:16];
        field {
            name = "hsp_hf1_tmp1";
            desc = "High-frequency filtering coefficient 1, signed number";
            sw = rw; hw = r;
            reset = 0x0;
        } hsp_hf1_tmp1[15:8];
        field {
            name = "hsp_hf1_tmp0";
            desc = "High-frequency filtering coefficient 0, signed number";
            sw = rw; hw = r;
            reset = 0x0;
        } hsp_hf1_tmp0[7:0];
    } INTF_HSPCFG7 @ 0xD05C;
    reg {
        name = "INTF_HSPCFG8";
        desc = "INTF_HSPCFG8 is HSP configuration register 8 (instant register). (offset 0xD060; total reset 0x00000000; PROVEN: Hi3521A/Hi3520D V300 data sheet (Issue 00B07, 2015-12-10), section 5.10, PDF page 1370).";
        field {
            name = "reserved";
            desc = "Reserved";
            sw = r; hw = w;
            reset = 0x0;
        } reserved_31_8[31:8];
        field {
            name = "hsp_hf1_coring";
            desc = "High-frequency coring coefficient, unsigned number";
            sw = rw; hw = r;
            reset = 0x0;
        } hsp_hf1_coring[7:0];
    } INTF_HSPCFG8 @ 0xD060;
    reg {
        name = "INTF_HSPCFG12";
        desc = "INTF_HSPCFG12 is HSP configuration register 12 (instant register). (offset 0xD070; total reset 0x00000000; PROVEN: Hi3521A/Hi3520D V300 data sheet (Issue 00B07, 2015-12-10), section 5.10, PDF page 1370).";
        field {
            name = "reserved";
            desc = "Reserved";
            sw = r; hw = w;
            reset = 0x0;
        } reserved_31_27[31:27];
        field {
            name = "hsp_hf1_gainneg";
            desc = "High-frequency gain negative polarity coefficient, signed number (10.8)";
            sw = rw; hw = r;
            reset = 0x0;
        } hsp_hf1_gainneg[26:16];
        field {
            name = "reserved";
            desc = "Reserved";
            sw = r; hw = w;
            reset = 0x0;
        } reserved_15_11[15:11];
        field {
            name = "hsp_hf1_gainpos";
            desc = "High-frequency gain positive polarity coefficient, signed number (10.8)";
            sw = rw; hw = r;
            reset = 0x0;
        } hsp_hf1_gainpos[10:0];
    } INTF_HSPCFG12 @ 0xD070;
    reg {
        name = "INTF_HSPCFG13";
        desc = "INTF_HSPCFG13 is HSP configuration register 13 (instant register). (offset 0xD074; total reset 0x00000000; PROVEN: Hi3521A/Hi3520D V300 data sheet (Issue 00B07, 2015-12-10), section 5.10, PDF page 1371).";
        field {
            name = "hsp_hf1_adpshoot_en";
            desc = "High-frequency adjustment threshold enable
- 0: disabled
- 1: enabled";
            sw = rw; hw = r;
            reset = 0x0;
        } hsp_hf1_adpshoot_en[31:31];
        field {
            name = "hsp_hf1_winsize";
            desc = "High-frequency window size, unsigned number. The value range is 0-4.";
            sw = rw; hw = r;
            reset = 0x0;
        } hsp_hf1_winsize[30:28];
        field {
            name = "reserved";
            desc = "Reserved";
            sw = r; hw = w;
            reset = 0x0;
        } reserved_27_24[27:24];
        field {
            name = "hsp_hf1_mixratio";
            desc = "High-frequency adjustment threshold ratio, unsigned number (8.7)";
            sw = rw; hw = r;
            reset = 0x0;
        } hsp_hf1_mixratio[23:16];
        field {
            name = "hsp_hf1_underth";
            desc = "High-frequency adjustment lower threshold, unsigned number";
            sw = rw; hw = r;
            reset = 0x0;
        } hsp_hf1_underth[15:8];
        field {
            name = "hsp_hf1_overth";
            desc = "High-frequency adjustment upper threshold, unsigned number";
            sw = rw; hw = r;
            reset = 0x0;
        } hsp_hf1_overth[7:0];
    } INTF_HSPCFG13 @ 0xD074;
    reg {
        name = "INTF_HSPCFG14";
        desc = "INTF_HSPCFG14 is HSP configuration register 14 (instant register). (offset 0xD078; total reset 0x00000000; PROVEN: Hi3521A/Hi3520D V300 data sheet (Issue 00B07, 2015-12-10), section 5.10, PDF page 1371).";
        field {
            name = "hsp_h0_en";
            desc = "High-frequency filtering 0 enable
- 0: disabled
- 1: enabled";
            sw = rw; hw = r;
            reset = 0x0;
        } hsp_h0_en[31:31];
        field {
            name = "hsp_h1_en";
            desc = "High-frequency filtering 1 enable
- 0: disabled
- 1: enabled";
            sw = rw; hw = r;
            reset = 0x0;
        } hsp_h1_en[30:30];
        field {
            name = "hsp_ltih_en";
            desc = "Horizontal LTI enable
- 0: disabled
- 1: enabled";
            sw = rw; hw = r;
            reset = 0x0;
        } hsp_ltih_en[29:29];
        field {
            name = "hsp_ctih_en";
            desc = "Horizontal CTI enable
- 0: disabled
- 1: enabled";
            sw = rw; hw = r;
            reset = 0x0;
        } hsp_ctih_en[28:28];
        field {
            name = "reserved";
            desc = "Reserved";
            sw = r; hw = w;
            reset = 0x0;
        } reserved_27_27[27:27];
        field {
            name = "hsp_hf_shootdiv";
            desc = "High-frequency adjustment shift coefficient, unsigned number. The value range is 1-7.";
            sw = rw; hw = r;
            reset = 0x0;
        } hsp_hf_shootdiv[26:24];
        field {
            name = "hsp_lti_ratio";
            desc = "Luminance enhancement ratio, unsigned number (8.7)";
            sw = rw; hw = r;
            reset = 0x0;
        } hsp_lti_ratio[23:16];
        field {
            name = "hsp_ldti_gain";
            desc = "Luminance enhancement gain coefficient, unsigned number (8.5)";
            sw = rw; hw = r;
            reset = 0x0;
        } hsp_ldti_gain[15:8];
        field {
            name = "hsp_cdti_gain";
            desc = "Chrominance enhancement gain coefficient, unsigned number (8.5)";
            sw = rw; hw = r;
            reset = 0x0;
        } hsp_cdti_gain[7:0];
    } INTF_HSPCFG14 @ 0xD078;
    reg {
        name = "INTF_HSPCFG15";
        desc = "INTF_HSPCFG15 is HSP configuration register 15 (instant register). (offset 0xD07C; total reset 0x00000000; PROVEN: Hi3521A/Hi3520D V300 data sheet (Issue 00B07, 2015-12-10), section 5.10, PDF page 1372).";
        field {
            name = "reserved";
            desc = "Reserved";
            sw = r; hw = w;
            reset = 0x0;
        } reserved_31_28[31:28];
        field {
            name = "hsp_peak_ratio";
            desc = "Luminance enhancement ratio, unsigned number (8.7)";
            sw = rw; hw = r;
            reset = 0x0;
        } hsp_peak_ratio[27:20];
        field {
            name = "reserved";
            desc = "Reserved";
            sw = r; hw = w;
            reset = 0x0;
        } reserved_19_19[19:19];
        field {
            name = "hsp_glb_overth";
            desc = "Luminance enhancement global upper threshold, unsigned number";
            sw = rw; hw = r;
            reset = 0x0;
        } hsp_glb_overth[18:10];
        field {
            name = "reserved";
            desc = "Reserved";
            sw = r; hw = w;
            reset = 0x0;
        } reserved_9_9[9:9];
        field {
            name = "hsp_glb_underth";
            desc = "Luminance enhancement global lower threshold, unsigned number";
            sw = rw; hw = r;
            reset = 0x0;
        } hsp_glb_underth[8:0];
    } INTF_HSPCFG15 @ 0xD07C;
    reg {
        name = "DATE_COEFF0";
        desc = "DATE_COEFF0 is a standard parameter configuration register. (offset 0xF200; total reset 0x528414FC; PROVEN: Hi3521A/Hi3520D V300 data sheet (Issue 00B07, 2015-12-10), section 5.10, PDF page 1373).";
        field {
            name = "clpf_sel";
            desc = "Bandwidth of the chrominance low-pass filter
- 00: 1.1 MHz (NTSC)
- 01: 1.3 MHz (PAL)
- 10: 1.6 MHz (for test)
- 11: reserved";
            sw = rw; hw = r;
            reset = 0x1;
        } clpf_sel[31:30];
        field {
            name = "dis_ire";
            desc = "For the (M) NTSC and (M, N) PAL standards, the black level is 7.5 IRE higher than the blanking level; for other standards, the black level is equal to the blanking level. This bit controls whether the black level is 7.5 IRE higher than the blanking level.
- 0: The black level is 7.5 IRE higher than the blanking level.
- 1: The black level is equal to the blanking level.";
            sw = rw; hw = r;
            reset = 0x0;
        } dis_ire[29:29];
        field {
            name = "reserved";
            desc = "Reserved";
            sw = r; hw = w;
            reset = 0x1;
        } reserved_28_28[28:28];
        field {
            name = "pal_half_en";
            desc = "PAL half line reduction enable
- 0: disabled
- 1: enabled";
            sw = rw; hw = r;
            reset = 0x0;
        } pal_half_en[27:27];
        field {
            name = "pbpr_lpf_en";
            desc = "Component chrominance low-pass filtering enable
- 0: disabled
- 1: enabled";
            sw = rw; hw = r;
            reset = 0x0;
        } pbpr_lpf_en[26:26];
        field {
            name = "scanline";
            desc = "Number of scanned lines in each frame based on standards. For the (M) NTSC, NTSC-J, and (M) PAL standards, each line contains 525 lines; for the (B, D, J, H, I) PAL, (N) PAL, and (Nc) PAL standards, each frame contains 625 lines.
- 0: 525 lines in a frame
- 1: 625 lines in a frame";
            sw = rw; hw = r;
            reset = 0x1;
        } scanline[25:25];
        field {
            name = "rgb_en";
            desc = "When intf_sel is set to 100, this bit determines whether the component signal is RGB or YPbPr.
- 0: YPbPr
- 1: RGB";
            sw = rw; hw = r;
            reset = 0x0;
        } rgb_en[24:24];
        field {
            name = "vbi_lpf_en";
            desc = "VBI data low-pass filtering enable
- 0: no filtering
- 1: filtering";
            sw = rw; hw = r;
            reset = 0x1;
        } vbi_lpf_en[23:23];
        field {
            name = "fm_sel";
            desc = "FMSECAM frequency modulation select
- 0: SIN mode
- 1: COS mode";
            sw = rw; hw = r;
            reset = 0x0;
        } fm_sel[22:22];
        field {
            name = "style_sel";
            desc = "CVBS/S-Video output signal standard when this bit works with the scanline bit When the scanline bit is 0 (525 scanned lines in a frame), the definition of the style_sel bit is as follows:
- 0001: (M) NTSC standard
- 0010: NTSC-J standard
- 0100: (M) PAL standard

When the scanline bit is 1 (625 scanned lines in a frame), the definition of the style_sel bit is as follows:
- 0001: (B, D, G, H, I) PAL standard
- 0010: (N) PAL standard
- 0100: (Nc) PAL standard
- 1000: SECAM standard";
            sw = rw; hw = r;
            reset = 0x1;
        } style_sel[21:18];
        field {
            name = "sync_mode_sel";
            desc = "bit[17]: specifies whether there are sync signals in three channels during component output. This bit takes effect only when the sync_mode_scart bit is set to 0. bit[17] is valid only when intf_sel is set to 100 (component output enabled). The definition of bit[17] is as follows:
- 0: Only one channel contains sync signals during component output.
- 1: Three channels contain sync signals during component output.

When bit[17] is set to 0, the sync channel must be the Y channel for YPbPr output or G channel for RGB output. bit[16]: specifies whether there are blanking radixes during RGB output. bit[16] is valid only when intf_sel is set to 100 and rgb_en is set to 1. The definition of bit[16] is as follows:
- 0: There are no blanking radixes during RGB output.
- 1: There are blanking radixes during RGB output.";
            sw = rw; hw = r;
            reset = 0x0;
        } sync_mode_sel[17:16];
        field {
            name = "sync_mode_scart";
            desc = "Overlay sync control for the components of three channels
- 0: Component sync output is configured based on sync_mode_sel bit[1].
- 1: The components of the three channels are not overlaid and synchronized. In this case, sync_mode_sel bit[1] must be set to 0.";
            sw = rw; hw = r;
            reset = 0x0;
        } sync_mode_scart[15:15];
        field {
            name = "length_sel";
            desc = "Active width of each video line (in pixel)
- 0: output according to the line active pixel width in BT.601 mode.
- 1: output according to the line active pixel width in BT.470 mode

When this bit is set to 0, the active width of the line is 720 pixels. When this bit is set to 1, the active width of the line is 704 pixels for the 625-line standard or 712 pixels for the 525-line standard. Currently, the BT.601 mode and BT.470 mode cannot be dynamically switched. You can change the mode only after reset. The BT.601 mode is recommended, and this mode is the default mode after power-on reset.";
            sw = rw; hw = r;
            reset = 0x0;
        } length_sel[14:14];
        field {
            name = "agc_amp_sel";
            desc = "AGC pulse select
- 0: The AGC pulse is generated based on the on-chip default value (recommended).
- 1: The AGC pulse is generated based on the off-chip configuration. DATE_COEFF1[amp_outside]";
            sw = rw; hw = r;
            reset = 0x0;
        } agc_amp_sel[13:13];
        field {
            name = "luma_dl";
            desc = "Lead or lag-behind offset of the chrominance signal relative to the luminance signal, in the unit of half a pixel width. bit[12]: offset direction of the chrominance signal relative to the luminance signal.
- 0: The chrominance signal lags behind the luminance signal.
- 1: The chrominance signal leads the luminance signal. bit[11:9]: absolute offset of the chrominance signal relative to the luminance signal. The value is in binary format and ranges from 0 to 7.
- 000: The chrominance signal is aligned with the luminance signal.

No adjustment is required. 001-111: The chrominance signal leads or lags behind the luminance signal by one to seven units.";
            sw = rw; hw = r;
            reset = 0xa;
        } luma_dl[12:9];
        field {
            name = "reserved";
            desc = "Reserved";
            sw = r; hw = w;
            reset = 0x0;
        } reserved_8_8[8:8];
        field {
            name = "oversam_en";
            desc = "Level-1 over-sampling enable. Both luminance over-sampling and chrominance over-sampling are controlled. bit[7]: luminance over-sampling enable
- 0: disabled
- 1: enabled bit[6]: chrominance over-sampling enable
- 0: disabled
- 1: enabled";
            sw = rw; hw = r;
            reset = 0x3;
        } oversam_en[7:6];
        field {
            name = "lunt_en";
            desc = "Luminance notch enable
- 0: disabled
- 1: enabled";
            sw = rw; hw = r;
            reset = 0x1;
        } lunt_en[5:5];
        field {
            name = "oversam2_en";
            desc = "Level-2 over-sampling enable. Both the luminance channel and chrominance channel are controlled.
- 0: disabled
- 1: enabled";
            sw = rw; hw = r;
            reset = 0x1;
        } oversam2_en[4:4];
        field {
            name = "chlp_en";
            desc = "Chrominance low-pass filtering enable
- 0: disabled
- 1: enabled";
            sw = rw; hw = r;
            reset = 0x1;
        } chlp_en[3:3];
        field {
            name = "sylp_en";
            desc = "Sync low-pass filtering enable
- 0: disabled
- 1: enabled";
            sw = rw; hw = r;
            reset = 0x1;
        } sylp_en[2:2];
        field {
            name = "chgain_en";
            desc = "Chrominance gain enable
- 0: disabled
- 1: enabled";
            sw = rw; hw = r;
            reset = 0x0;
        } chgain_en[1:1];
        field {
            name = "tt_seq";
            desc = "Sequence of transmitting the bits of the teletext data
- 0: from upper bits to lower bits
- 1: from lower bits to upper bits";
            sw = rw; hw = r;
            reset = 0x0;
        } tt_seq[0:0];
    } DATE_COEFF0 @ 0xF200;
    reg {
        name = "DATE_COEFF1";
        desc = "DATE_COEFF1 is an amplitude configuration register. (offset 0xF204; total reset 0x00000000; PROVEN: Hi3521A/Hi3520D V300 data sheet (Issue 00B07, 2015-12-10), section 7.5, PDF page 1377).";
        field {
            name = "c_gain";
            desc = "Adjustment of the chrominance sync gain amplitude";
            sw = rw; hw = r;
            reset = 0x0;
        } c_gain[31:29];
        field {
            name = "cvbs_limit_en";
            desc = "CVBS amplitude limit control
- 0: not limited
- 1: limited";
            sw = rw; hw = r;
            reset = 0x0;
        } cvbs_limit_en[28:28];
        field {
            name = "wss_seq";
            desc = "Sequence of transmitting the bits of the WSS data
- 0: from upper bits to lower bits
- 1: from lower bits to upper bits";
            sw = rw; hw = r;
            reset = 0x0;
        } wss_seq[27:27];
        field {
            name = "vps_seq";
            desc = "Sequence of transmitting the bits of the video programming system (VPS) data
- 0: from upper bits to lower bits
- 1: from lower bits to upper bits";
            sw = rw; hw = r;
            reset = 0x0;
        } vps_seq[26:26];
        field {
            name = "cgms_seq";
            desc = "Sequence of transmitting the bits of the copy generation management system (CGMS) data
- 0: from upper bits to lower bits
- 1: from lower bits to upper bits";
            sw = rw; hw = r;
            reset = 0x0;
        } cgms_seq[25:25];
        field {
            name = "cc_seq";
            desc = "Sequence of transmitting the bits of the closed caption data
- 0: from upper bits to lower bits
- 1: from lower bits to upper bits";
            sw = rw; hw = r;
            reset = 0x0;
        } cc_seq[24:24];
        field {
            name = "c_limit_en";
            desc = "Chrominance amplitude limit control
- 0: not limited
- 1: limited";
            sw = rw; hw = r;
            reset = 0x0;
        } c_limit_en[23:23];
        field {
            name = "amp_outside";
            desc = "Pulse amplitude input of the external AGC";
            sw = rw; hw = r;
            reset = 0x0;
        } amp_outside[22:13];
        field {
            name = "date_test_en";
            desc = "Test valid signal";
            sw = rw; hw = r;
            reset = 0x0;
        } date_test_en[12:12];
        field {
            name = "date_test_mode";
            desc = "Test mode signal";
            sw = rw; hw = r;
            reset = 0x0;
        } date_test_mode[11:10];
        field {
            name = "dac_test";
            desc = "DAC test value input";
            sw = rw; hw = r;
            reset = 0x0;
        } dac_test[9:0];
    } DATE_COEFF1 @ 0xF204;
    reg {
        name = "DATE_COEFF2";
        desc = "DATE_COEFF2 is a DATE coefficient 2 register. (offset 0xF208; total reset 0x00000000; PROVEN: Hi3521A/Hi3520D V300 data sheet (Issue 00B07, 2015-12-10), section 7.5, PDF page 1378).";
        field {
            name = "coef02";
            desc = "DATE coefficient 2";
            sw = rw; hw = r;
            reset = 0x0;
        } coef02[31:0];
    } DATE_COEFF2 @ 0xF208;
    reg {
        name = "DATE_COEFF3";
        desc = "DATE_COEFF3 is a DATE coefficient 3 register. (offset 0xF20C; total reset 0x00000000; PROVEN: Hi3521A/Hi3520D V300 data sheet (Issue 00B07, 2015-12-10), section 7.5, PDF page 1378).";
        field {
            name = "reserved";
            desc = "Reserved";
            sw = r; hw = w;
            reset = 0x0;
        } reserved_31_26[31:26];
        field {
            name = "coef03";
            desc = "DATE coefficient 3";
            sw = rw; hw = r;
            reset = 0x0;
        } coef03[25:0];
    } DATE_COEFF3 @ 0xF20C;
    reg {
        name = "DATE_COEFF4";
        desc = "DATE_COEFF4 is a DATE coefficient 4 register. (offset 0xF210; total reset 0x00000000; PROVEN: Hi3521A/Hi3520D V300 data sheet (Issue 00B07, 2015-12-10), section 7.5, PDF page 1379).";
        field {
            name = "reserved";
            desc = "Reserved";
            sw = r; hw = w;
            reset = 0x0;
        } reserved_31_30[31:30];
        field {
            name = "coef04";
            desc = "DATE coefficient 4";
            sw = rw; hw = r;
            reset = 0x0;
        } coef04[29:0];
    } DATE_COEFF4 @ 0xF210;
    reg {
        name = "DATE_COEFF5";
        desc = "DATE_COEFF5 is a DATE coefficient 5 register. (offset 0xF214; total reset 0x00000000; PROVEN: Hi3521A/Hi3520D V300 data sheet (Issue 00B07, 2015-12-10), section 7.5, PDF page 1379).";
        field {
            name = "reserved";
            desc = "Reserved";
            sw = r; hw = w;
            reset = 0x0;
        } reserved_31_29[31:29];
        field {
            name = "coef05";
            desc = "DATE coefficient 5";
            sw = rw; hw = r;
            reset = 0x0;
        } coef05[28:0];
    } DATE_COEFF5 @ 0xF214;
    reg {
        name = "DATE_COEFF6";
        desc = "DATE_COEFF6 is a DATE coefficient 6 register. (offset 0xF218; total reset 0x80000000; PROVEN: Hi3521A/Hi3520D V300 data sheet (Issue 00B07, 2015-12-10), section 7.5, PDF page 1380).";
        field {
            name = "coef06_0";
            desc = "DATE coefficient 6 register 0";
            sw = rw; hw = r;
            reset = 0x1;
        } coef06_0[31:31];
        field {
            name = "reserved";
            desc = "Reserved";
            sw = r; hw = w;
            reset = 0x0;
        } reserved_30_23[30:23];
        field {
            name = "coef06_1";
            desc = "DATE coefficient 6 register 1";
            sw = rw; hw = r;
            reset = 0x0;
        } coef06_1[22:0];
    } DATE_COEFF6 @ 0xF218;
    reg {
        name = "DATE_COEFF21";
        desc = "DATE_COEFF21 is an output matrix control register. (offset 0xF254; total reset 0x00651432; PROVEN: Hi3521A/Hi3520D V300 data sheet (Issue 00B07, 2015-12-10), section 7.5, PDF page 1380).";
        field {
            name = "reserved";
            desc = "Reserved";
            sw = r; hw = w;
            reset = 0x0;
        } reserved_31_23[31:23];
        field {
            name = "dac5_in_sel";
            desc = "DAC5 output mode
- 000: 0
- 001: CVBS
- 010: G/Y
- 011: B/Pb
- 100: R/Pr
- 101: svideo_y
- 110: svideo_c
- 111: 0";
            sw = rw; hw = r;
            reset = 0x6;
        } dac5_in_sel[22:20];
        field {
            name = "reserved";
            desc = "Reserved";
            sw = r; hw = w;
            reset = 0x0;
        } reserved_19_19[19:19];
        field {
            name = "dac4_in_sel";
            desc = "DAC4 output mode
- 000: 0
- 001: CVBS
- 010: G/Y
- 011: B/Pb
- 100: R/Pr
- 101: svideo_y
- 110: svideo_c
- 111: 0";
            sw = rw; hw = r;
            reset = 0x5;
        } dac4_in_sel[18:16];
        field {
            name = "reserved";
            desc = "Reserved";
            sw = r; hw = w;
            reset = 0x0;
        } reserved_15_15[15:15];
        field {
            name = "dac3_in_sel";
            desc = "DAC3 output mode
- 000: 0
- 001: CVBS
- 010: G/Y
- 011: B/Pb
- 100: R/Pr
- 101: svideo_y
- 110: svideo_c
- 111: 0";
            sw = rw; hw = r;
            reset = 0x1;
        } dac3_in_sel[14:12];
        field {
            name = "reserved";
            desc = "Reserved";
            sw = r; hw = w;
            reset = 0x0;
        } reserved_11_11[11:11];
        field {
            name = "dac2_in_sel";
            desc = "DAC2 output mode
- 000: 0
- 001: CVBS
- 010: G/Y
- 011: B/Pb
- 100: R/Pr
- 101: svideo_y
- 110: svideo_c
- 111: 0";
            sw = rw; hw = r;
            reset = 0x4;
        } dac2_in_sel[10:8];
        field {
            name = "reserved";
            desc = "Reserved";
            sw = r; hw = w;
            reset = 0x0;
        } reserved_7_7[7:7];
        field {
            name = "dac1_in_sel";
            desc = "DAC1 output mode
- 000: 0
- 001: CVBS
- 010: G/Y
- 011: B/Pb
- 100: R/Pr
- 101: svideo_y
- 110: svideo_c
- 111: 0";
            sw = rw; hw = r;
            reset = 0x3;
        } dac1_in_sel[6:4];
        field {
            name = "reserved";
            desc = "Reserved";
            sw = r; hw = w;
            reset = 0x0;
        } reserved_3_3[3:3];
        field {
            name = "dac0_in_sel";
            desc = "DAC0 output mode
- 000: 0
- 001: CVBS
- 010: G/Y
- 011: B/Pb
- 100: R/Pr
- 101: svideo_y
- 110: svideo_c
- 111: 0";
            sw = rw; hw = r;
            reset = 0x2;
        } dac0_in_sel[2:0];
    } DATE_COEFF21 @ 0xF254;
    reg {
        name = "DATE_COEFF22";
        desc = "DATE_COEFF22 is a DTO initial phase configuration register. (offset 0xF258; total reset 0x00000000; PROVEN: Hi3521A/Hi3520D V300 data sheet (Issue 00B07, 2015-12-10), section 7.5, PDF page 1382).";
        field {
            name = "reserved";
            desc = "Reserved";
            sw = r; hw = w;
            reset = 0x0;
        } reserved_31_11[31:11];
        field {
            name = "video_phase_delta";
            desc = "DTO initial phase";
            sw = rw; hw = r;
            reset = 0x0;
        } video_phase_delta[10:0];
    } DATE_COEFF22 @ 0xF258;
    reg {
        name = "DATE_COEFF23";
        desc = "DATE_COEFF23 is a video output delay configuration register. (offset 0xF25C; total reset 0x00000000; PROVEN: Hi3521A/Hi3520D V300 data sheet (Issue 00B07, 2015-12-10), section 7.5, PDF page 1383).";
        field {
            name = "reserved";
            desc = "Reserved";
            sw = r; hw = w;
            reset = 0x0;
        } reserved_31_23[31:23];
        field {
            name = "dac5_out_dly";
            desc = "DAC5 output delay cycle The value is measured by a 54 MHz clock cycle, and the value n indicates n delay cycles.";
            sw = rw; hw = r;
            reset = 0x0;
        } dac5_out_dly[22:20];
        field {
            name = "reserved";
            desc = "Reserved";
            sw = r; hw = w;
            reset = 0x0;
        } reserved_19_19[19:19];
        field {
            name = "dac4_out_dly";
            desc = "DAC4 output delay cycle The value is measured by a 54 MHz clock cycle, and the value n indicates n delay cycles.";
            sw = rw; hw = r;
            reset = 0x0;
        } dac4_out_dly[18:16];
        field {
            name = "reserved";
            desc = "Reserved";
            sw = r; hw = w;
            reset = 0x0;
        } reserved_15_15[15:15];
        field {
            name = "dac3_out_dly";
            desc = "DAC3 output delay cycle The value is measured by a 54 MHz clock cycle, and the value n indicates n delay cycles.";
            sw = rw; hw = r;
            reset = 0x0;
        } dac3_out_dly[14:12];
        field {
            name = "reserved";
            desc = "Reserved";
            sw = r; hw = w;
            reset = 0x0;
        } reserved_11_11[11:11];
        field {
            name = "dac2_out_dly";
            desc = "DAC2 output delay cycle The value is measured by a 54 MHz clock cycle, and the value n indicates n delay cycles.";
            sw = rw; hw = r;
            reset = 0x0;
        } dac2_out_dly[10:8];
        field {
            name = "reserved";
            desc = "Reserved";
            sw = r; hw = w;
            reset = 0x0;
        } reserved_7_7[7:7];
        field {
            name = "dac1_out_dly";
            desc = "DAC1 output delay cycle The value is measured by a 54 MHz clock cycle, and the value n indicates n delay cycles.";
            sw = rw; hw = r;
            reset = 0x0;
        } dac1_out_dly[6:4];
        field {
            name = "reserved";
            desc = "Reserved";
            sw = r; hw = w;
            reset = 0x0;
        } reserved_3_3[3:3];
        field {
            name = "dac0_out_dly";
            desc = "DAC0 output delay cycle The value is measured by a 54 MHz clock cycle, and the value n indicates n delay cycles.";
            sw = rw; hw = r;
            reset = 0x0;
        } dac0_out_dly[2:0];
    } DATE_COEFF23 @ 0xF25C;
    reg {
        name = "DATE_COEFF24";
        desc = "DATE_COEFF24 is a ColorBurst start position register. (offset 0xF260; total reset 0x00012C99; PROVEN: Hi3521A/Hi3520D V300 data sheet (Issue 00B07, 2015-12-10), section 7.5, PDF page 1384).";
        field {
            name = "burst_start";
            desc = "ColorBurst start position";
            sw = rw; hw = r;
            reset = 0x12c99;
        } burst_start[31:0];
    } DATE_COEFF24 @ 0xF260;
    reg {
        name = "DATE_COEFF25";
        desc = "DATE_COEFF25 is a SECAM preemphasis curve input coefficient register. (offset 0xF264; total reset 0x15B509C5; PROVEN: Hi3521A/Hi3520D V300 data sheet (Issue 00B07, 2015-12-10), section 7.5, PDF page 1384).";
        field {
            name = "reserved";
            desc = "Reserved";
            sw = r; hw = w;
            reset = 0x0;
        } reserved_31_29[31:29];
        field {
            name = "x_n_1_coef";
            desc = "Input coefficient 2 of the SECAM preemphasis curve";
            sw = rw; hw = r;
            reset = 0x15b5;
        } x_n_1_coef[28:16];
        field {
            name = "reserved";
            desc = "Reserved";
            sw = r; hw = w;
            reset = 0x0;
        } reserved_15_13[15:13];
        field {
            name = "x_n_coef";
            desc = "Input coefficient 1 of the SECAM preemphasis curve";
            sw = rw; hw = r;
            reset = 0x9c5;
        } x_n_coef[12:0];
    } DATE_COEFF25 @ 0xF264;
    reg {
        name = "DATE_COEFF26";
        desc = "DATE_COEFF26 is a preemphasis curve input coefficient register. (offset 0xF268; total reset 0x00000945; PROVEN: Hi3521A/Hi3520D V300 data sheet (Issue 00B07, 2015-12-10), section 7.5, PDF page 1385).";
        field {
            name = "reserved";
            desc = "Reserved";
            sw = r; hw = w;
            reset = 0x0;
        } reserved_31_13[31:13];
        field {
            name = "x_n_1_coef";
            desc = "Input coefficient 3 of the SECAM preemphasis curve";
            sw = rw; hw = r;
            reset = 0x945;
        } x_n_1_coef[12:0];
    } DATE_COEFF26 @ 0xF268;
    reg {
        name = "DATE_COEFF27";
        desc = "DATE_COEFF27 is a SECAM preemphasis curve output coefficient register. (offset 0xF26C; total reset 0x078000D0; PROVEN: Hi3521A/Hi3520D V300 data sheet (Issue 00B07, 2015-12-10), section 7.5, PDF page 1385).";
        field {
            name = "reserved";
            desc = "Reserved";
            sw = r; hw = w;
            reset = 0x0;
        } reserved_31_27[31:27];
        field {
            name = "y_n_1_coef";
            desc = "Output coefficient 2 of the SECAM preemphasis curve";
            sw = rw; hw = r;
            reset = 0x780;
        } y_n_1_coef[26:16];
        field {
            name = "reserved";
            desc = "Reserved";
            sw = r; hw = w;
            reset = 0x0;
        } reserved_15_11[15:11];
        field {
            name = "y_n_coef";
            desc = "Output coefficient 1 of the SECAM preemphasis curve";
            sw = rw; hw = r;
            reset = 0xd0;
        } y_n_coef[10:0];
    } DATE_COEFF27 @ 0xF26C;
    reg {
        name = "DATE_COEFF28";
        desc = "DATE_COEFF28 is a SECAM color burst start coordinate register. (offset 0xF270; total reset 0x06B00000; PROVEN: Hi3521A/Hi3520D V300 data sheet (Issue 00B07, 2015-12-10), section 7.5, PDF page 1385).";
        field {
            name = "reserved";
            desc = "Reserved";
            sw = r; hw = w;
            reset = 0x0;
        } reserved_31_27[31:27];
        field {
            name = "pixel_begin2";
            desc = "Start position 2 for SECAM color burst";
            sw = rw; hw = r;
            reset = 0x6b0;
        } pixel_begin2[26:16];
        field {
            name = "reserved";
            desc = "Reserved";
            sw = r; hw = w;
            reset = 0x0;
        } reserved_15_11[15:11];
        field {
            name = "pixel_begin1";
            desc = "Start position 1 for SECAM color burst";
            sw = rw; hw = r;
            reset = 0x0;
        } pixel_begin1[10:0];
    } DATE_COEFF28 @ 0xF270;
    reg {
        name = "DATE_COEFF29";
        desc = "DATE_COEFF29 is a SECAM color burst end coordinate register. (offset 0xF274; total reset 0x000000A2; PROVEN: Hi3521A/Hi3520D V300 data sheet (Issue 00B07, 2015-12-10), section 7.5, PDF page 1386).";
        field {
            name = "reserved";
            desc = "Reserved";
            sw = r; hw = w;
            reset = 0x0;
        } reserved_31_11[31:11];
        field {
            name = "pixel_end";
            desc = "End position for SECAM color burst";
            sw = rw; hw = r;
            reset = 0xa2;
        } pixel_end[10:0];
    } DATE_COEFF29 @ 0xF274;
    reg {
        name = "DATE_COEFF30";
        desc = "DATE_COEFF30 is a SECAM peak video signal level width coefficient register. (offset 0xF278; total reset 0x0000003F; PROVEN: Hi3521A/Hi3520D V300 data sheet (Issue 00B07, 2015-12-10), section 7.5, PDF page 1386).";
        field {
            name = "reserved";
            desc = "Reserved";
            sw = r; hw = w;
            reset = 0x0;
        } reserved_31_7[31:7];
        field {
            name = "g_secam";
            desc = "SECAM peak video signal level width coefficient";
            sw = rw; hw = r;
            reset = 0x3f;
        } g_secam[6:0];
    } DATE_COEFF30 @ 0xF278;
    reg {
        name = "DATE_ISRMASK";
        desc = "DATE_ISRMASK is an interrupt mask register. (offset 0xF280; total reset 0x00000000; PROVEN: Hi3521A/Hi3520D V300 data sheet (Issue 00B07, 2015-12-10), section 7.5, PDF page 1387).";
        field {
            name = "reserved";
            desc = "Reserved";
            sw = r; hw = w;
            reset = 0x0;
        } reserved_31_1[31:1];
        field {
            name = "tt_mask";
            desc = "Teletext interrupt mask
- 0: enabled
- 1: masked";
            sw = rw; hw = r;
            reset = 0x0;
        } tt_mask[0:0];
    } DATE_ISRMASK @ 0xF280;
    reg {
        name = "DATE_ISRSTATE";
        desc = "DATE_ISRSTATE is an interrupt status register. (offset 0xF284; total reset 0x00000000; PROVEN: Hi3521A/Hi3520D V300 data sheet (Issue 00B07, 2015-12-10), section 7.5, PDF page 1387).";
        field {
            name = "reserved";
            desc = "Reserved";
            sw = r; hw = w;
            reset = 0x0;
        } reserved_31_1[31:1];
        field {
            name = "tt_status";
            desc = "Teletext interrupt status After the DATE module reads all the teletext data, the bit is set to 1. Writing 1 to this bit clears the interrupt.

Access type WC in the data sheet: written 1 clears the bit.";
            sw = rw; hw = w; onwrite = woclr;
            reset = 0x0;
        } tt_status[0:0];
    } DATE_ISRSTATE @ 0xF284;
    reg {
        name = "DATE_ISR";
        desc = "DATE_ISR is an interrupt register. (offset 0xF288; total reset 0x00000000; PROVEN: Hi3521A/Hi3520D V300 data sheet (Issue 00B07, 2015-12-10), section 7.5, PDF page 1388).";
        field {
            name = "reserved";
            desc = "Reserved";
            sw = r; hw = w;
            reset = 0x0;
        } reserved_31_1[31:1];
        field {
            name = "tt_int";
            desc = "Teletext interrupt. This bit indicates the interrupt status after tt_status is masked by tt_mask.";
            sw = r; hw = w;
            reset = 0x0;
        } tt_int[0:0];
    } DATE_ISR @ 0xF288;
    reg {
        name = "DATE_COEFF37";
        desc = "DATE_COEFF37 is an up-sampling filtering coefficient 1 register. (offset 0xF294; total reset 0x19EF0CF9; PROVEN: Hi3521A/Hi3520D V300 data sheet (Issue 00B07, 2015-12-10), section 7.5, PDF page 1388).";
        field {
            name = "fir_y1_coeff3";
            desc = "Coefficient 13 for luminance up-sampling filtering";
            sw = rw; hw = r;
            reset = 0x19;
        } fir_y1_coeff3[31:24];
        field {
            name = "fir_y1_coeff2";
            desc = "Coefficient 12 for luminance up-sampling filtering";
            sw = rw; hw = r;
            reset = 0xef;
        } fir_y1_coeff2[23:16];
        field {
            name = "fir_y1_coeff1";
            desc = "Coefficient 11 for luminance up-sampling filtering";
            sw = rw; hw = r;
            reset = 0xc;
        } fir_y1_coeff1[15:8];
        field {
            name = "fir_y1_coeff0";
            desc = "Coefficient 10 for luminance up-sampling filtering";
            sw = rw; hw = r;
            reset = 0xf9;
        } fir_y1_coeff0[7:0];
    } DATE_COEFF37 @ 0xF294;
    reg {
        name = "DATE_COEFF38";
        desc = "DATE_COEFF38 is an up-sampling filtering coefficient 2 register. (offset 0xF298; total reset 0x003AFFDA; PROVEN: Hi3521A/Hi3520D V300 data sheet (Issue 00B07, 2015-12-10), section 7.5, PDF page 1388).";
        field {
            name = "fir_y2_coeff1";
            desc = "Coefficient 21 for luminance up-sampling filtering";
            sw = rw; hw = r;
            reset = 0x3a;
        } fir_y2_coeff1[31:16];
        field {
            name = "fir_y2_coeff0";
            desc = "Coefficient 20 for luminance up-sampling filtering";
            sw = rw; hw = r;
            reset = 0xffda;
        } fir_y2_coeff0[15:0];
    } DATE_COEFF38 @ 0xF298;
    reg {
        name = "DATE_COEFF39";
        desc = "DATE_COEFF39 is an up-sampling filtering coefficient 3 register. (offset 0xF29C; total reset 0x0148FF97; PROVEN: Hi3521A/Hi3520D V300 data sheet (Issue 00B07, 2015-12-10), section 7.5, PDF page 1389).";
        field {
            name = "fir_y2_coeff3";
            desc = "Coefficient 23 for luminance up-sampling filtering";
            sw = rw; hw = r;
            reset = 0x148;
        } fir_y2_coeff3[31:16];
        field {
            name = "fir_y2_coeff2";
            desc = "Coefficient 22 for luminance up-sampling filtering";
            sw = rw; hw = r;
            reset = 0xff97;
        } fir_y2_coeff2[15:0];
    } DATE_COEFF39 @ 0xF29C;
    reg {
        name = "DATE_COEFF40";
        desc = "DATE_COEFF40 is an up-sampling filtering coefficient 4 register. (offset 0xF2A0; total reset 0x19EF0CF9; PROVEN: Hi3521A/Hi3520D V300 data sheet (Issue 00B07, 2015-12-10), section 7.5, PDF page 1389).";
        field {
            name = "fir_c1_coeff3";
            desc = "Coefficient 13 for chrominance up-sampling filtering";
            sw = rw; hw = r;
            reset = 0x19;
        } fir_c1_coeff3[31:24];
        field {
            name = "fir_c1_coeff2";
            desc = "Coefficient 12 for chrominance up-sampling filtering";
            sw = rw; hw = r;
            reset = 0xef;
        } fir_c1_coeff2[23:16];
        field {
            name = "fir_c1_coeff1";
            desc = "Coefficient 11 for chrominance up-sampling filtering";
            sw = rw; hw = r;
            reset = 0xc;
        } fir_c1_coeff1[15:8];
        field {
            name = "fir_c1_coeff0";
            desc = "Coefficient 10 for chrominance up-sampling filtering";
            sw = rw; hw = r;
            reset = 0xf9;
        } fir_c1_coeff0[7:0];
    } DATE_COEFF40 @ 0xF2A0;
    reg {
        name = "DATE_COEFF41";
        desc = "DATE_COEFF41 is an up-sampling filtering coefficient 5 register. (offset 0xF2A4; total reset 0x003AFFDA; PROVEN: Hi3521A/Hi3520D V300 data sheet (Issue 00B07, 2015-12-10), section 7.5, PDF page 1390).";
        field {
            name = "fir_c2_coeff1";
            desc = "Coefficient 21 for chrominance up-sampling filtering";
            sw = rw; hw = r;
            reset = 0x3a;
        } fir_c2_coeff1[31:16];
        field {
            name = "fir_c2_coeff0";
            desc = "Coefficient 20 for chrominance up-sampling filtering";
            sw = rw; hw = r;
            reset = 0xffda;
        } fir_c2_coeff0[15:0];
    } DATE_COEFF41 @ 0xF2A4;
    reg {
        name = "DATE_COEFF42";
        desc = "DATE_COEFF42 is an up-sampling filtering coefficient 6 register. (offset 0xF2A8; total reset 0x0148FF97; PROVEN: Hi3521A/Hi3520D V300 data sheet (Issue 00B07, 2015-12-10), section 7.5, PDF page 1390).";
        field {
            name = "fir_c2_coeff3";
            desc = "Coefficient 23 for chrominance up-sampling filtering";
            sw = rw; hw = r;
            reset = 0x148;
        } fir_c2_coeff3[31:16];
        field {
            name = "fir_c2_coeff2";
            desc = "Coefficient 22 for chrominance up-sampling filtering";
            sw = rw; hw = r;
            reset = 0xff97;
        } fir_c2_coeff2[15:0];
    } DATE_COEFF42 @ 0xF2A8;
    reg {
        name = "DATE_DACDET1";
        desc = "DATE_DACDET1 is DAC automatic detection register 1. (offset 0xF2C0; total reset 0x000D0303; PROVEN: Hi3521A/Hi3520D V300 data sheet (Issue 00B07, 2015-12-10), section 7.5, PDF page 1390).";
        field {
            name = "reserved";
            desc = "Reserved";
            sw = r; hw = w;
            reset = 0x0;
        } reserved_31_26[31:26];
        field {
            name = "det_line";
            desc = "Line of the detected level";
            sw = rw; hw = r;
            reset = 0xd;
        } det_line[25:16];
        field {
            name = "reserved";
            desc = "Reserved";
            sw = r; hw = w;
            reset = 0x0;
        } reserved_15_10[15:10];
        field {
            name = "vdac_det_high";
            desc = "Detected level";
            sw = rw; hw = r;
            reset = 0x303;
        } vdac_det_high[9:0];
    } DATE_DACDET1 @ 0xF2C0;
    reg {
        name = "DATE_DACDET2";
        desc = "DATE_DACDET2 is DAC automatic detection register 2. (offset 0xF2C4; total reset 0x00300118; PROVEN: Hi3521A/Hi3520D V300 data sheet (Issue 00B07, 2015-12-10), section 7.5, PDF page 1391).";
        field {
            name = "vdac_det_en";
            desc = "DAC automatic detection enable
- 0: disabled
- 1: enabled";
            sw = rw; hw = r;
            reset = 0x0;
        } vdac_det_en[31:31];
        field {
            name = "reserved";
            desc = "Reserved";
            sw = r; hw = w;
            reset = 0x0;
        } reserved_30_27[30:27];
        field {
            name = "det_pixel_wid";
            desc = "Level width";
            sw = rw; hw = r;
            reset = 0x30;
        } det_pixel_wid[26:16];
        field {
            name = "reserved";
            desc = "Reserved";
            sw = r; hw = w;
            reset = 0x0;
        } reserved_15_11[15:11];
        field {
            name = "det_pixel_sta";
            desc = "Start position of a line";
            sw = rw; hw = r;
            reset = 0x118;
        } det_pixel_sta[10:0];
    } DATE_DACDET2 @ 0xF2C4;
    reg {
        name = "DATE_COEFF50";
        desc = "DATE_COEFF50 is an over-sampling filtering coefficient 1 register. (offset 0xF2C8; total reset 0x07FF07FF; PROVEN: Hi3521A/Hi3520D V300 data sheet (Issue 00B07, 2015-12-10), section 7.5, PDF page 1391).";
        field {
            name = "reserved";
            desc = "Reserved";
            sw = r; hw = w;
            reset = 0x0;
        } reserved_31_27[31:27];
        field {
            name = "ovs_coeff1";
            desc = "Coefficient 11 for luminance over-sampling filtering";
            sw = rw; hw = r;
            reset = 0x7ff;
        } ovs_coeff1[26:16];
        field {
            name = "reserved";
            desc = "Reserved";
            sw = r; hw = w;
            reset = 0x0;
        } reserved_15_11[15:11];
        field {
            name = "ovs_coeff0";
            desc = "Coefficient 10 for luminance over-sampling filtering";
            sw = rw; hw = r;
            reset = 0x7ff;
        } ovs_coeff0[10:0];
    } DATE_COEFF50 @ 0xF2C8;
    reg {
        name = "DATE_COEFF51";
        desc = "DATE_COEFF51 is an over-sampling filtering coefficient 2 register. (offset 0xF2CC; total reset 0x07FF0204; PROVEN: Hi3521A/Hi3520D V300 data sheet (Issue 00B07, 2015-12-10), section 7.5, PDF page 1392).";
        field {
            name = "reserved";
            desc = "Reserved";
            sw = r; hw = w;
            reset = 0x0;
        } reserved_31_27[31:27];
        field {
            name = "ovs_coeff1";
            desc = "Coefficient 21 for luminance over-sampling filtering";
            sw = rw; hw = r;
            reset = 0x7ff;
        } ovs_coeff1[26:16];
        field {
            name = "reserved";
            desc = "Reserved.";
            sw = r; hw = w;
            reset = 0x0;
        } reserved_15_11[15:11];
        field {
            name = "ovs_coeff0";
            desc = "Coefficient 20 for luminance over-sampling filtering";
            sw = rw; hw = r;
            reset = 0x204;
        } ovs_coeff0[10:0];
    } DATE_COEFF51 @ 0xF2CC;
    reg {
        name = "DATE_COEFF52";
        desc = "DATE_COEFF52 is an over-sampling filtering coefficient 3 register. (offset 0xF2D0; total reset 0x000007FF; PROVEN: Hi3521A/Hi3520D V300 data sheet (Issue 00B07, 2015-12-10), section 7.5, PDF page 1392).";
        field {
            name = "reserved";
            desc = "Reserved";
            sw = r; hw = w;
            reset = 0x0;
        } reserved_31_27[31:27];
        field {
            name = "ovs_coeff1";
            desc = "Coefficient 31 for luminance over-sampling filtering";
            sw = rw; hw = r;
            reset = 0x0;
        } ovs_coeff1[26:16];
        field {
            name = "reserved";
            desc = "Reserved";
            sw = r; hw = w;
            reset = 0x0;
        } reserved_15_11[15:11];
        field {
            name = "ovs_coeff0";
            desc = "Coefficient 30 for luminance over-sampling filtering";
            sw = rw; hw = r;
            reset = 0x7ff;
        } ovs_coeff0[10:0];
    } DATE_COEFF52 @ 0xF2D0;
    reg {
        name = "DATE_COEFF53";
        desc = "DATE_COEFF53 is an over-sampling filtering coefficient 4 register. (offset 0xF2D4; total reset 0x07BF000C; PROVEN: Hi3521A/Hi3520D V300 data sheet (Issue 00B07, 2015-12-10), section 7.5, PDF page 1393).";
        field {
            name = "reserved";
            desc = "Reserved";
            sw = r; hw = w;
            reset = 0x0;
        } reserved_31_27[31:27];
        field {
            name = "ovs_coeff1";
            desc = "Coefficient 41 for luminance over-sampling filtering";
            sw = rw; hw = r;
            reset = 0x7bf;
        } ovs_coeff1[26:16];
        field {
            name = "reserved";
            desc = "Reserved";
            sw = r; hw = w;
            reset = 0x0;
        } reserved_15_11[15:11];
        field {
            name = "ovs_coeff0";
            desc = "Coefficient 40 for luminance over-sampling filtering";
            sw = rw; hw = r;
            reset = 0xc;
        } ovs_coeff0[10:0];
    } DATE_COEFF53 @ 0xF2D4;
    reg {
        name = "DATE_COEFF54";
        desc = "DATE_COEFF54 is an over-sampling filtering coefficient 5 register. (offset 0xF2D8; total reset 0x01350135; PROVEN: Hi3521A/Hi3520D V300 data sheet (Issue 00B07, 2015-12-10), section 7.5, PDF page 1393).";
        field {
            name = "reserved";
            desc = "Reserved";
            sw = r; hw = w;
            reset = 0x0;
        } reserved_31_27[31:27];
        field {
            name = "ovs_coeff1";
            desc = "Coefficient 51 for luminance over-sampling filtering";
            sw = rw; hw = r;
            reset = 0x135;
        } ovs_coeff1[26:16];
        field {
            name = "reserved";
            desc = "Reserved";
            sw = r; hw = w;
            reset = 0x0;
        } reserved_15_11[15:11];
        field {
            name = "ovs_coeff0";
            desc = "Coefficient 50 for luminance over-sampling filtering";
            sw = rw; hw = r;
            reset = 0x135;
        } ovs_coeff0[10:0];
    } DATE_COEFF54 @ 0xF2D8;
    reg {
        name = "DATE_COEFF55";
        desc = "DATE_COEFF55 is an over-sampling filtering coefficient 6 register. (offset 0xF2DC; total reset 0x000C07BF; PROVEN: Hi3521A/Hi3520D V300 data sheet (Issue 00B07, 2015-12-10), section 7.5, PDF page 1394).";
        field {
            name = "reserved";
            desc = "Reserved";
            sw = r; hw = w;
            reset = 0x0;
        } reserved_31_27[31:27];
        field {
            name = "ovs_coeff1";
            desc = "Coefficient 61 for luminance over-sampling filtering";
            sw = rw; hw = r;
            reset = 0xc;
        } ovs_coeff1[26:16];
        field {
            name = "reserved";
            desc = "Reserved";
            sw = r; hw = w;
            reset = 0x0;
        } reserved_15_11[15:11];
        field {
            name = "ovs_coeff0";
            desc = "Coefficient 60 for luminance over-sampling filtering";
            sw = rw; hw = r;
            reset = 0x7bf;
        } ovs_coeff0[10:0];
    } DATE_COEFF55 @ 0xF2DC;
    reg {
        name = "DATE_COEFF56";
        desc = "DATE_COEFF56 is an over-sampling round-off register. (offset 0xF2E0; total reset 0x00000001; PROVEN: Hi3521A/Hi3520D V300 data sheet (Issue 00B07, 2015-12-10), section 7.5, PDF page 1394).";
        field {
            name = "reserved";
            desc = "Reserved";
            sw = r; hw = w;
            reset = 0x0;
        } reserved_31_1[31:1];
        field {
            name = "oversam2_round_en";
            desc = "Round-off enable during 2x up-sampling
- 0: disabled
- 1: enabled";
            sw = rw; hw = r;
            reset = 0x1;
        } oversam2_round_en[0:0];
    } DATE_COEFF56 @ 0xF2E0;
    reg {
        name = "DATE_COEFF57";
        desc = "DATE_COEFF57 is a CVBS gain control register. (offset 0xF2E4; total reset 0x00808080; PROVEN: Hi3521A/Hi3520D V300 data sheet (Issue 00B07, 2015-12-10), section 7.5, PDF page 1395).";
        field {
            name = "cvbs_gain_en";
            desc = "CVBS gain enable
- 0: disabled
- 1: enabled";
            sw = rw; hw = r;
            reset = 0x0;
        } cvbs_gain_en[31:31];
        field {
            name = "reserved";
            desc = "Reserved";
            sw = r; hw = w;
            reset = 0x0;
        } reserved_30_24[30:24];
        field {
            name = "ycvbs_gain";
            desc = "Gain control of the luminance component Y";
            sw = rw; hw = r;
            reset = 0x80;
        } ycvbs_gain[23:16];
        field {
            name = "u_gain";
            desc = "Gain control of the chrominance component U";
            sw = rw; hw = r;
            reset = 0x80;
        } u_gain[15:8];
        field {
            name = "v_gain";
            desc = "Gain control of the chrominance component V";
            sw = rw; hw = r;
            reset = 0x80;
        } v_gain[7:0];
    } DATE_COEFF57 @ 0xF2E4;
    reg {
        name = "DATE_COEFF58";
        desc = "DATE_COEFF58 is a component gain control register. (offset 0xF2E8; total reset 0x00808080; PROVEN: Hi3521A/Hi3520D V300 data sheet (Issue 00B07, 2015-12-10), section 7.5, PDF page 1395).";
        field {
            name = "comp_gain_en";
            desc = "Component gain enable
- 0: disabled
- 1: enabled";
            sw = rw; hw = r;
            reset = 0x0;
        } comp_gain_en[31:31];
        field {
            name = "reserved";
            desc = "Reserved";
            sw = r; hw = w;
            reset = 0x0;
        } reserved_30_24[30:24];
        field {
            name = "ycomp_gain";
            desc = "Gain control of the luminance component Y";
            sw = rw; hw = r;
            reset = 0x80;
        } ycomp_gain[23:16];
        field {
            name = "pb_gain";
            desc = "Gain control of the chrominance component U";
            sw = rw; hw = r;
            reset = 0x80;
        } pb_gain[15:8];
        field {
            name = "pr_gain";
            desc = "Gain control of the chrominance component V";
            sw = rw; hw = r;
            reset = 0x80;
        } pr_gain[7:0];
    } DATE_COEFF58 @ 0xF2E8;
    reg {
        name = "DATE_COEFF59";
        desc = "DATE_COEFF59 is a clip control register. (offset 0xF2EC; total reset 0x00010000; PROVEN: Hi3521A/Hi3520D V300 data sheet (Issue 00B07, 2015-12-10), section 7.5, PDF page 1396).";
        field {
            name = "reserved";
            desc = "Reserved";
            sw = r; hw = w;
            reset = 0x0;
        } reserved_31_17[31:17];
        field {
            name = "cb_gain_polar";
            desc = "Chrominance subcarrier polarity control
- 0: negative gain
- 1: positive gain";
            sw = rw; hw = r;
            reset = 0x1;
        } cb_gain_polar[16:16];
        field {
            name = "reserved";
            desc = "Reserved";
            sw = r; hw = w;
            reset = 0x0;
        } reserved_15_14[15:14];
        field {
            name = "cr_os_clip_fullrange";
            desc = "Clip enable for the Cr component in the up-sampling module
- 0: disabled
- 1: enabled";
            sw = rw; hw = r;
            reset = 0x0;
        } cr_os_clip_fullrange[13:13];
        field {
            name = "cb_os_clip_fullrange";
            desc = "Clip enable for the Cb component in the up-sampling module
- 0: disabled
- 1: enabled";
            sw = rw; hw = r;
            reset = 0x0;
        } cb_os_clip_fullrange[12:12];
        field {
            name = "reserved";
            desc = "Reserved";
            sw = r; hw = w;
            reset = 0x0;
        } reserved_11_10[11:10];
        field {
            name = "v_os_clip_fullrange";
            desc = "Clip enable for the V component in the up-sampling module
- 0: disabled
- 1: enabled";
            sw = rw; hw = r;
            reset = 0x0;
        } v_os_clip_fullrange[9:9];
        field {
            name = "u_os_clip_fullrange";
            desc = "Clip enable for the U component in the up-sampling module
- 0: disabled
- 1: enabled";
            sw = rw; hw = r;
            reset = 0x0;
        } u_os_clip_fullrange[8:8];
        field {
            name = "reserved";
            desc = "Reserved";
            sw = r; hw = w;
            reset = 0x0;
        } reserved_7_5[7:5];
        field {
            name = "y_os_clip_fullrange";
            desc = "Clip enable for the Y component in the up-sampling module
- 0: disabled
- 1: enabled";
            sw = rw; hw = r;
            reset = 0x0;
        } y_os_clip_fullrange[4:4];
        field {
            name = "reserved";
            desc = "Reserved";
            sw = r; hw = w;
            reset = 0x0;
        } reserved_3_2[3:2];
        field {
            name = "clpf_clip_fullrange";
            desc = "Clip enable for the chrominance low-pass module
- 0: disabled
- 1: enabled";
            sw = rw; hw = r;
            reset = 0x0;
        } clpf_clip_fullrange[1:1];
        field {
            name = "ynotch_clip_fullrange";
            desc = "Clip enable for the luminance notch module
- 0: disabled
- 1: enabled Contents";
            sw = rw; hw = r;
            reset = 0x0;
        } ynotch_clip_fullrange[0:0];
    } DATE_COEFF59 @ 0xF2EC;
};
`endif
