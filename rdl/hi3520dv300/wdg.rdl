`ifndef HI3520DV300_WDG_RDL
`define HI3520DV300_WDG_RDL
regfile eHI3520DV300_WDG {
    name = "Watchdog (SP805)";
    desc = "Watchdog (SP805) of the Hi3521A/Hi3520D V300 at base 0x1207_0000. 7 registers extracted programmatically from the Hi3521A/Hi3520D V300 data sheet (Issue 00B07, 2015-12-10) (Table 3-17 Summary of watchdog registers (base address: 0x1207_0000)): register headings, offsets, total reset values, field bit ranges, access types, names, reset values and descriptions, with PDF page numbers in each register description. Field names, bit ranges, access types and offsets are exact; the free-text descriptions are taken from the cell text of the field table and were checked by sampling only. Hardware not verified.";
    reg {
        name = "WDG_LOAD";
        desc = "WDG_LOAD is an initial count value register. It is used to configure the initial count value of the internal counter of the watchdog. (offset 0x0; total reset 0xFFFFFFFF; PROVEN: Hi3521A/Hi3520D V300 data sheet (Issue 00B07, 2015-12-10), section 3.9.6, PDF page 664).";
        field {
            name = "wdg_load";
            desc = "Initial count value of the watchdog counter";
            sw = rw; hw = r;
            reset = 0xffffffff;
        } wdg_load[31:0];
    } WDG_LOAD @ 0x0;
    reg {
        name = "WDG_VALUE";
        desc = "WDG_VALUE is a current count value register. It is used to read the current count value of the internal counter of the watchdog. (offset 0x4; total reset 0xFFFFFFFF; PROVEN: Hi3521A/Hi3520D V300 data sheet (Issue 00B07, 2015-12-10), section 3.9.6, PDF page 664).";
        field {
            name = "wdogvalue";
            desc = "Current count value of the watchdog counter";
            sw = r; hw = w;
            reset = 0xffffffff;
        } wdogvalue[31:0];
    } WDG_VALUE @ 0x4;
    reg {
        name = "WDG_CONTROL";
        desc = "WDG_CONTROL is a control register. It is used to enable or disable the watchdog and control the interrupt and reset functions of the watchdog. (offset 0x8; total reset 0x00000000; PROVEN: Hi3521A/Hi3520D V300 data sheet (Issue 00B07, 2015-12-10), section 3.9.6, PDF page 664).";
        field {
            name = "reserved";
            desc = "Reserved";
            sw = r; hw = w;
            reset = 0x0;
        } reserved_31_2[31:2];
        field {
            name = "resen";
            desc = "Output enable of the watchdog reset signal
- 0: disabled
- 1: enabled";
            sw = rw; hw = r;
            reset = 0x0;
        } resen[1:1];
        field {
            name = "inten";
            desc = "Output enable of the watchdog interrupt signal
- 0: The counter stops counting, the current count value remains unchanged, and the watchdog is disabled.
- 1: The counter, interrupt, and watchdog are enabled.";
            sw = rw; hw = r;
            reset = 0x0;
        } inten[0:0];
    } WDG_CONTROL @ 0x8;
    reg {
        name = "WDG_INTCLR";
        desc = "WDG_INTCLR is an interrupt clear register. It is used to clear watchdog interrupts so the watchdog can reload an initial value for counting. This register is write-only. When a value is written to this register, the watchdog interrupts are cleared. No written value is recorded in this register and no default reset value is defined. (offset 0xC; total reset 0x00000000; PROVEN: Hi3521A/Hi3520D V300 data sheet (Issue 00B07, 2015-12-10), section 3.9.6, PDF page 665).";
        field {
            name = "wdg_intclr";
            desc = "Writing any value to this register clears the watchdog interrupts and enables the watchdog to reload an initial count value from WDG_LOAD to restart counting.";
            sw = w; hw = r;
            reset = 0x0;
        } wdg_intclr[31:0];
    } WDG_INTCLR @ 0xC;
    reg {
        name = "WDG_RIS";
        desc = "WDG_RIS is a raw interrupt status register. It shows the raw interrupt status of the watchdog. (offset 0x10; total reset 0x00000000; PROVEN: Hi3521A/Hi3520D V300 data sheet (Issue 00B07, 2015-12-10), section 3.9.6, PDF page 665).";
        field {
            name = "reserved";
            desc = "Reserved";
            sw = r; hw = w;
            reset = 0x0;
        } reserved_31_1[31:1];
        field {
            name = "wdogris";
            desc = "Status of the raw interrupts of the watchdog. When the count value reaches 0, this bit is set to 1.
- 0: No interrupt is generated.
- 1: An interrupt is generated.";
            sw = r; hw = w;
            reset = 0x0;
        } wdogris[0:0];
    } WDG_RIS @ 0x10;
    reg {
        name = "WDG_MIS";
        desc = "WDG_MIS is a masked interrupt status register. It shows the masked interrupt status of the watchdog. (offset 0x14; total reset 0x00000000; PROVEN: Hi3521A/Hi3520D V300 data sheet (Issue 00B07, 2015-12-10), section 3.9.6, PDF page 666).";
        field {
            name = "reserved";
            desc = "Reserved";
            sw = r; hw = w;
            reset = 0x0;
        } reserved_31_1[31:1];
        field {
            name = "wdogmis";
            desc = "Status of the masked interrupts of the watchdog
- 0: No interrupt is generated or the interrupt is masked.
- 1: An interrupt is generated.";
            sw = r; hw = w;
            reset = 0x0;
        } wdogmis[0:0];
    } WDG_MIS @ 0x14;
    reg {
        name = "WDG_LOCK";
        desc = "WDG_LOCK is a lock register. It is used to control the write and read permissions for the watchdog registers. (offset 0xC00; total reset 0x00000000; PROVEN: Hi3521A/Hi3520D V300 data sheet (Issue 00B07, 2015-12-10), section 3.9.6, PDF page 666).";
        field {
            name = "wdg_lock";
            desc = "Writing 0x1ACC_E551 to this register enables the write";
            sw = rw; hw = r;
            reset = 0x0;
        } wdg_lock[31:0];
    } WDG_LOCK @ 0xC00;
};
`endif
