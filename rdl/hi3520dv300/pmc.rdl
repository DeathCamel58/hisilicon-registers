`ifndef HI3520DV300_PMC_RDL
`define HI3520DV300_PMC_RDL
regfile eHI3520DV300_PMC {
    name = "Power management controller (PMC)";
    desc = "Power management controller (PMC) of the Hi3521A/Hi3520D V300 at base 0x120E_0000. 25 registers extracted programmatically from the Hi3521A/Hi3520D V300 data sheet (Issue 00B07, 2015-12-10) (Table 3-20 Summary of PMC registers (base address: 0x120E_0000)): register headings, offsets, total reset values, field bit ranges, access types, names, reset values and descriptions, with PDF page numbers in each register description. Field names, bit ranges, access types and offsets are exact; the free-text descriptions are taken from the cell text of the field table and were checked by sampling only. Hardware not verified.";
    reg {
        name = "PERI_PMC0";
        desc = "PERI_PMC0 is PMC register 0. (offset 0x0; total reset 0x00120078; PROVEN: Hi3521A/Hi3520D V300 data sheet (Issue 00B07, 2015-12-10), section 3.11.4, PDF page 692).";
        field {
            name = "core_pwm_duty";
            desc = "Number of pulse-width modulation (PWM) high-level beats for the core AVS output. If the number is greater than or equal to the number of PWM cycles, the output level is always high. The value cannot be 0. If the configured value is 0, the value 1 is used.";
            sw = rw; hw = r;
            reset = 0x12;
        } core_pwm_duty[31:16];
        field {
            name = "core_pwm_period";
            desc = "Number of PWM cycles for the core AVS output";
            sw = rw; hw = r;
            reset = 0x78;
        } core_pwm_period[15:0];
    } PERI_PMC0 @ 0x0;
    reg {
        name = "PERI_PMC1";
        desc = "PERI_PMC1 is PMC register 1. (offset 0x4; total reset 0x00120078; PROVEN: Hi3521A/Hi3520D V300 data sheet (Issue 00B07, 2015-12-10), section 3.11.4, PDF page 692).";
        field {
            name = "cpu_pwm_duty";
            desc = "Number of PWM high-level beats for the CPU AVS output. If the number is greater than or equal to the number of PWM cycles, the output level is always high. The value cannot be 0. If the configured value is 0, the value 1 is used.";
            sw = rw; hw = r;
            reset = 0x12;
        } cpu_pwm_duty[31:16];
        field {
            name = "cpu_pwm_period";
            desc = "Number of PWM cycles for the CPU AVS output";
            sw = rw; hw = r;
            reset = 0x78;
        } cpu_pwm_period[15:0];
    } PERI_PMC1 @ 0x4;
    reg {
        name = "PERI_PMC4";
        desc = "PERI_PMC4 is PMC register 4. (offset 0x10; total reset 0x00000405; PROVEN: Hi3521A/Hi3520D V300 data sheet (Issue 00B07, 2015-12-10), section 3.11.4, PDF page 693).";
        field {
            name = "reserved";
            desc = "Reserved";
            sw = r; hw = w;
            reset = 0x0;
        } reserved_31_11[31:11];
        field {
            name = "pwm1_reuse_cfg";
            desc = "PWM1 source select for the AVS output
- 0: core
- 1: CPU";
            sw = rw; hw = r;
            reset = 0x1;
        } pwm1_reuse_cfg[10:10];
        field {
            name = "reserved";
            desc = "Reserved";
            sw = r; hw = w;
            reset = 0x0;
        } reserved_9_9[9:9];
        field {
            name = "pwm0_reuse_cfg";
            desc = "PWM0 source select for the AVS output
- 0: core
- 1: CPU";
            sw = rw; hw = r;
            reset = 0x0;
        } pwm0_reuse_cfg[8:8];
        field {
            name = "reserved";
            desc = "Reserved";
            sw = r; hw = w;
            reset = 0x0;
        } reserved_7_4[7:4];
        field {
            name = "cpu_pwm_inv";
            desc = "PWM phase control for the CPU AVS output
- 0: normal output
- 1: inverted output";
            sw = rw; hw = r;
            reset = 0x0;
        } cpu_pwm_inv[3:3];
        field {
            name = "cpu_pwm_enable";
            desc = "PWM enable for the CPU AVS output
- 0: disabled
- 1: enabled";
            sw = rw; hw = r;
            reset = 0x1;
        } cpu_pwm_enable[2:2];
        field {
            name = "core_pwm_inv";
            desc = "PWM phase control for the core AVS output
- 0: normal output
- 1: inverted output";
            sw = rw; hw = r;
            reset = 0x0;
        } core_pwm_inv[1:1];
        field {
            name = "core_pwm_enable";
            desc = "PWM enable for the core AVS output
- 0: disabled
- 1: enabled";
            sw = rw; hw = r;
            reset = 0x1;
        } core_pwm_enable[0:0];
    } PERI_PMC4 @ 0x10;
    reg {
        name = "PERI_PMC5";
        desc = "PERI_PMC5 is PMC register 5. (offset 0x14; total reset 0x00000000; PROVEN: Hi3521A/Hi3520D V300 data sheet (Issue 00B07, 2015-12-10), section 3.11.4, PDF page 694).";
        field {
            name = "core_avs_fsm_inc_pwm_step";
            desc = "Automatic increase step of the core AVS FSM PWM";
            sw = rw; hw = r;
            reset = 0x0;
        } core_avs_fsm_inc_pwm_step[31:24];
        field {
            name = "core_avs_fsm_dec_pwm_step";
            desc = "Automatic decrease step of the core AVS FSM PWM";
            sw = rw; hw = r;
            reset = 0x0;
        } core_avs_fsm_dec_pwm_step[23:16];
        field {
            name = "reserved";
            desc = "Reserved";
            sw = r; hw = w;
            reset = 0x0;
        } reserved_15_3[15:3];
        field {
            name = "core_avs_hpm_fsm_calc_mode";
            desc = "Calculation mode of the core AVS HPM FSM
- 00: average value of four samplings
- 01: average value of eight samplings
- 10: average value of 16 samplings
- 11: average value of 32 samplings";
            sw = rw; hw = r;
            reset = 0x0;
        } core_avs_hpm_fsm_calc_mode[2:1];
        field {
            name = "core_hpm_fsm_en";
            desc = "Core AVS HPM FSM enable
- 0: disabled
- 1: enabled";
            sw = rw; hw = r;
            reset = 0x0;
        } core_hpm_fsm_en[0:0];
    } PERI_PMC5 @ 0x14;
    reg {
        name = "PERI_PMC8";
        desc = "PERI_PMC8 is PMC register 8. (offset 0x20; total reset 0x00000000; PROVEN: Hi3521A/Hi3520D V300 data sheet (Issue 00B07, 2015-12-10), section 3.11.4, PDF page 695).";
        field {
            name = "cpu_avs_fsm_inc_pwm_step";
            desc = "Automatic increase step of the CPU AVS FSM PWM";
            sw = rw; hw = r;
            reset = 0x0;
        } cpu_avs_fsm_inc_pwm_step[31:24];
        field {
            name = "cpu_avs_fsm_dec_pwm_step";
            desc = "Automatic decrease step of the CPU AVS FSM PWM";
            sw = rw; hw = r;
            reset = 0x0;
        } cpu_avs_fsm_dec_pwm_step[23:16];
        field {
            name = "reserved";
            desc = "Reserved";
            sw = r; hw = w;
            reset = 0x0;
        } reserved_15_3[15:3];
        field {
            name = "cpu_avs_hpm_fsm_calc_mode";
            desc = "Calculation mode of the CPU AVS HPM FSM
- 00: average value of four samplings
- 01: average value of eight samplings
- 10: average value of 16 samplings
- 11: average value of 32 samplings";
            sw = rw; hw = r;
            reset = 0x0;
        } cpu_avs_hpm_fsm_calc_mode[2:1];
        field {
            name = "cpu_hpm_fsm_en";
            desc = "CPU AVS HPM FSM enable
- 0: disabled
- 1: enabled";
            sw = rw; hw = r;
            reset = 0x0;
        } cpu_hpm_fsm_en[0:0];
    } PERI_PMC8 @ 0x20;
    reg {
        name = "PERI_PMC10";
        desc = "PERI_PMC10 is core HPM control register 1. (offset 0x28; total reset 0x0000000A; PROVEN: Hi3521A/Hi3520D V300 data sheet (Issue 00B07, 2015-12-10), section 3.11.4, PDF page 696).";
        field {
            name = "reserved";
            desc = "Reserved";
            sw = r; hw = w;
            reset = 0x0;
        } reserved_31_28[31:28];
        field {
            name = "core_hpm_srst_req";
            desc = "Core HPM reset request
- 0: deassert reset
- 1: reset";
            sw = rw; hw = r;
            reset = 0x0;
        } core_hpm_srst_req[27:27];
        field {
            name = "core_hpm_monitor_en";
            desc = "Core HPM cyclic monitoring enable
- 0: disabled
- 1: enabled";
            sw = rw; hw = r;
            reset = 0x0;
        } core_hpm_monitor_en[26:26];
        field {
            name = "core_hpm_bypass";
            desc = "Core HPM cyclic monitoring bypass
- 0: not bypassed
- 1: bypassed";
            sw = rw; hw = r;
            reset = 0x0;
        } core_hpm_bypass[25:25];
        field {
            name = "core_hpm_en";
            desc = "Core HPM measurement enable
- 0: The value retains 0 before a process is started.
- 1: A frequency modulation process is started.";
            sw = rw; hw = r;
            reset = 0x0;
        } core_hpm_en[24:24];
        field {
            name = "reserved";
            desc = "Reserved";
            sw = w; hw = r;
            reset = 0x0;
        } reserved_23_22[23:22];
        field {
            name = "core_hpm_offset";
            desc = "Core HPM offset";
            sw = rw; hw = r;
            reset = 0x0;
        } core_hpm_offset[21:12];
        field {
            name = "reserved";
            desc = "Reserved";
            sw = r; hw = w;
            reset = 0x0;
        } reserved_11_10[11:10];
        field {
            name = "core_hpm_shift";
            desc = "Core HPM shift";
            sw = rw; hw = r;
            reset = 0x0;
        } core_hpm_shift[9:8];
        field {
            name = "reserved";
            desc = "Reserved";
            sw = r; hw = w;
            reset = 0x0;
        } reserved_7_6[7:6];
        field {
            name = "core_hpm_div";
            desc = "Core HPM clock divider n: divn";
            sw = rw; hw = r;
            reset = 0xa;
        } core_hpm_div[5:0];
    } PERI_PMC10 @ 0x28;
    reg {
        name = "PERI_PMC11";
        desc = "PERI_PMC11 is core HPM status register 1. (offset 0x2C; total reset 0x00000000; PROVEN: Hi3521A/Hi3520D V300 data sheet (Issue 00B07, 2015-12-10), section 3.11.4, PDF page 697).";
        field {
            name = "reserved";
            desc = "Reserved";
            sw = r; hw = w;
            reset = 0x0;
        } reserved_31_26[31:26];
        field {
            name = "core_hpm_up_warning";
            desc = "Upper limit for the core HPM warning";
            sw = r; hw = w;
            reset = 0x0;
        } core_hpm_up_warning[25:25];
        field {
            name = "core_hpm_low_warning";
            desc = "Lower limit for the core HPM warning";
            sw = r; hw = w;
            reset = 0x0;
        } core_hpm_low_warning[24:24];
        field {
            name = "reserved";
            desc = "Reserved";
            sw = r; hw = w;
            reset = 0x0;
        } reserved_23_22[23:22];
        field {
            name = "core_hpm_pc_record1";
            desc = "Core HPM original code pattern 1";
            sw = r; hw = w;
            reset = 0x0;
        } core_hpm_pc_record1[21:12];
        field {
            name = "reserved";
            desc = "Reserved";
            sw = r; hw = w;
            reset = 0x0;
        } reserved_11_11[11:11];
        field {
            name = "core_hpm_pc_valid";
            desc = "Core HPM output validity indicator
- 0: invalid
- 1: valid";
            sw = r; hw = w;
            reset = 0x0;
        } core_hpm_pc_valid[10:10];
        field {
            name = "core_hpm_pc_record0";
            desc = "Core HPM original code pattern 0";
            sw = r; hw = w;
            reset = 0x0;
        } core_hpm_pc_record0[9:0];
    } PERI_PMC11 @ 0x2C;
    reg {
        name = "PERI_PMC12";
        desc = "PERI_PMC12 is core HPM status register 2. (offset 0x30; total reset 0x00000000; PROVEN: Hi3521A/Hi3520D V300 data sheet (Issue 00B07, 2015-12-10), section 3.11.4, PDF page 698).";
        field {
            name = "reserved";
            desc = "Reserved";
            sw = r; hw = w;
            reset = 0x0;
        } reserved_31_29[31:29];
        field {
            name = "core_hpm_rcc";
            desc = "Core HPM output with the RCC code";
            sw = r; hw = w;
            reset = 0x0;
        } core_hpm_rcc[28:24];
        field {
            name = "reserved";
            desc = "Reserved";
            sw = r; hw = w;
            reset = 0x0;
        } reserved_23_22[23:22];
        field {
            name = "core_hpm_pc_record3";
            desc = "Core HPM original code pattern 3";
            sw = r; hw = w;
            reset = 0x0;
        } core_hpm_pc_record3[21:12];
        field {
            name = "reserved";
            desc = "Reserved";
            sw = r; hw = w;
            reset = 0x0;
        } reserved_11_10[11:10];
        field {
            name = "core_hpm_pc_record2";
            desc = "Core HPM original code pattern 2";
            sw = r; hw = w;
            reset = 0x0;
        } core_hpm_pc_record2[9:0];
    } PERI_PMC12 @ 0x30;
    reg {
        name = "PERI_PMC13";
        desc = "PERI_PMC13 is core HPM control register 2. (offset 0x34; total reset 0x01000000; PROVEN: Hi3521A/Hi3520D V300 data sheet (Issue 00B07, 2015-12-10), section 3.11.4, PDF page 698).";
        field {
            name = "core_hpm_monitor_period";
            desc = "Core HPM cyclic monitoring period If the configured value is N, the monitoring period (T) is as follows: T = N x 2048/1000 ms The maximum monitoring interval is 522 ms, and the minimum interval is 2 ms.";
            sw = rw; hw = r;
            reset = 0x1;
        } core_hpm_monitor_period[31:24];
        field {
            name = "reserved";
            desc = "Reserved";
            sw = r; hw = w;
            reset = 0x0;
        } reserved_23_22[23:22];
        field {
            name = "core_hpm_lowlimit";
            desc = "Core HPM lower limit";
            sw = rw; hw = r;
            reset = 0x0;
        } core_hpm_lowlimit[21:12];
        field {
            name = "reserved";
            desc = "Reserved";
            sw = r; hw = w;
            reset = 0x0;
        } reserved_11_10[11:10];
        field {
            name = "core_hpm_uplimit";
            desc = "Core HPM upper limit";
            sw = rw; hw = r;
            reset = 0x0;
        } core_hpm_uplimit[9:0];
    } PERI_PMC13 @ 0x34;
    reg {
        name = "PERI_PMC22";
        desc = "PERI_PMC22 is CPU HPM control register 1. (offset 0x58; total reset 0x0000000A; PROVEN: Hi3521A/Hi3520D V300 data sheet (Issue 00B07, 2015-12-10), section 3.11.4, PDF page 699).";
        field {
            name = "reserved";
            desc = "Reserved";
            sw = r; hw = w;
            reset = 0x0;
        } reserved_31_28[31:28];
        field {
            name = "cpu_hpm_srst_req";
            desc = "CPU HPM reset request, active high
- 0: deassert reset
- 1: reset";
            sw = rw; hw = r;
            reset = 0x0;
        } cpu_hpm_srst_req[27:27];
        field {
            name = "cpu_hpm_monitor_en";
            desc = "CPU HPM cyclic monitoring enable
- 0: disabled
- 1: enabled";
            sw = rw; hw = r;
            reset = 0x0;
        } cpu_hpm_monitor_en[26:26];
        field {
            name = "cpu_hpm_bypass";
            desc = "CPU HPM cyclic monitoring bypass
- 0: not bypassed
- 1: bypassed";
            sw = rw; hw = r;
            reset = 0x0;
        } cpu_hpm_bypass[25:25];
        field {
            name = "cpu_hpm_en";
            desc = "CPU HPM measurement enable
- 0: The value retains 0 before a process is started.
- 1: A frequency modulation process is started.";
            sw = rw; hw = r;
            reset = 0x0;
        } cpu_hpm_en[24:24];
        field {
            name = "reserved";
            desc = "Reserved";
            sw = r; hw = w;
            reset = 0x0;
        } reserved_23_22[23:22];
        field {
            name = "cpu_hpm_offset";
            desc = "CPU HPM offset";
            sw = rw; hw = r;
            reset = 0x0;
        } cpu_hpm_offset[21:12];
        field {
            name = "reserved";
            desc = "Reserved";
            sw = r; hw = w;
            reset = 0x0;
        } reserved_11_10[11:10];
        field {
            name = "cpu_hpm_shift";
            desc = "CPU HPM shift";
            sw = rw; hw = r;
            reset = 0x0;
        } cpu_hpm_shift[9:8];
        field {
            name = "reserved";
            desc = "Reserved";
            sw = rw; hw = r;
            reset = 0x0;
        } reserved_7_6[7:6];
        field {
            name = "cpu_hpm_div";
            desc = "CPU HPM clock divider n: divn";
            sw = rw; hw = r;
            reset = 0xa;
        } cpu_hpm_div[5:0];
    } PERI_PMC22 @ 0x58;
    reg {
        name = "PERI_PMC23";
        desc = "PERI_PMC23 is CPU HPM status register 1. (offset 0x5C; total reset 0x00000000; PROVEN: Hi3521A/Hi3520D V300 data sheet (Issue 00B07, 2015-12-10), section 3.11.4, PDF page 700).";
        field {
            name = "reserved";
            desc = "Reserved";
            sw = r; hw = w;
            reset = 0x0;
        } reserved_31_26[31:26];
        field {
            name = "cpu_hpm_up_warning";
            desc = "Upper limit for the CPU HPM warning";
            sw = r; hw = w;
            reset = 0x0;
        } cpu_hpm_up_warning[25:25];
        field {
            name = "cpu_hpm_low_warning";
            desc = "Lower limit for the CPU HPM warning";
            sw = r; hw = w;
            reset = 0x0;
        } cpu_hpm_low_warning[24:24];
        field {
            name = "reserved";
            desc = "Reserved";
            sw = r; hw = w;
            reset = 0x0;
        } reserved_23_22[23:22];
        field {
            name = "cpu_hpm_pc_record1";
            desc = "CPU HPM original code pattern 1";
            sw = r; hw = w;
            reset = 0x0;
        } cpu_hpm_pc_record1[21:12];
        field {
            name = "reserved";
            desc = "Reserved";
            sw = r; hw = w;
            reset = 0x0;
        } reserved_11_11[11:11];
        field {
            name = "cpu_hpm_pc_valid";
            desc = "CPU HPM output validity indicator
- 0: invalid
- 1: valid";
            sw = r; hw = w;
            reset = 0x0;
        } cpu_hpm_pc_valid[10:10];
        field {
            name = "cpu_hpm_pc_record0";
            desc = "CPU HPM original code pattern 0";
            sw = r; hw = w;
            reset = 0x0;
        } cpu_hpm_pc_record0[9:0];
    } PERI_PMC23 @ 0x5C;
    reg {
        name = "PERI_PMC24";
        desc = "PERI_PMC24 is CPU HPM status register 2. (offset 0x60; total reset 0x00000000; PROVEN: Hi3521A/Hi3520D V300 data sheet (Issue 00B07, 2015-12-10), section 3.11.4, PDF page 701).";
        field {
            name = "reserved";
            desc = "Reserved";
            sw = r; hw = w;
            reset = 0x0;
        } reserved_31_29[31:29];
        field {
            name = "cpu_hpm_rcc";
            desc = "CPU HPM output with the RCC code";
            sw = r; hw = w;
            reset = 0x0;
        } cpu_hpm_rcc[28:24];
        field {
            name = "reserved";
            desc = "Reserved";
            sw = r; hw = w;
            reset = 0x0;
        } reserved_23_22[23:22];
        field {
            name = "cpu_hpm_pc_record3";
            desc = "CPU HPM original code pattern 3";
            sw = r; hw = w;
            reset = 0x0;
        } cpu_hpm_pc_record3[21:12];
        field {
            name = "reserved";
            desc = "Reserved";
            sw = r; hw = w;
            reset = 0x0;
        } reserved_11_10[11:10];
        field {
            name = "cpu_hpm_pc_record2";
            desc = "CPU HPM original code pattern 2";
            sw = r; hw = w;
            reset = 0x0;
        } cpu_hpm_pc_record2[9:0];
    } PERI_PMC24 @ 0x60;
    reg {
        name = "PERI_PMC25";
        desc = "PERI_PMC25 is CPU HPM control register 2. (offset 0x64; total reset 0x01000000; PROVEN: Hi3521A/Hi3520D V300 data sheet (Issue 00B07, 2015-12-10), section 3.11.4, PDF page 702).";
        field {
            name = "cpu_hpm_monitor_period";
            desc = "CPU HPM cyclic monitoring period If the configured value is N, the monitoring period (T) is as follows: T = N x 2048/1000 ms The maximum monitoring interval is 522 ms, and the minimum interval is 2 ms.";
            sw = rw; hw = r;
            reset = 0x1;
        } cpu_hpm_monitor_period[31:24];
        field {
            name = "reserved";
            desc = "Reserved";
            sw = r; hw = w;
            reset = 0x0;
        } reserved_23_22[23:22];
        field {
            name = "cpu_hpm_lowlimit";
            desc = "CPU HPM lower limit";
            sw = rw; hw = r;
            reset = 0x0;
        } cpu_hpm_lowlimit[21:12];
        field {
            name = "reserved";
            desc = "Reserved";
            sw = r; hw = w;
            reset = 0x0;
        } reserved_11_10[11:10];
        field {
            name = "cpu_hpm_uplimit";
            desc = "CPU HPM upper limit";
            sw = rw; hw = r;
            reset = 0x0;
        } cpu_hpm_uplimit[9:0];
    } PERI_PMC25 @ 0x64;
    reg {
        name = "PERI_PMC45";
        desc = "PERI_PMC45 is core TS status register 0. (offset 0xB4; total reset 0x00000000; PROVEN: Hi3521A/Hi3520D V300 data sheet (Issue 00B07, 2015-12-10), section 3.11.4, PDF page 702).";
        field {
            name = "reserved";
            desc = "Reserved";
            sw = r; hw = w;
            reset = 0x0;
        } reserved_31_27[31:27];
        field {
            name = "core_ts_record1";
            desc = "Core TS record register 1";
            sw = r; hw = w;
            reset = 0x0;
        } core_ts_record1[26:16];
        field {
            name = "reserved";
            desc = "Reserved";
            sw = r; hw = w;
            reset = 0x0;
        } reserved_15_11[15:11];
        field {
            name = "core_ts_record0";
            desc = "Core TS record register 0";
            sw = r; hw = w;
            reset = 0x0;
        } core_ts_record0[10:0];
    } PERI_PMC45 @ 0xB4;
    reg {
        name = "PERI_PMC46";
        desc = "PERI_PMC46 is core TS status register 1. (offset 0xB8; total reset 0x00000000; PROVEN: Hi3521A/Hi3520D V300 data sheet (Issue 00B07, 2015-12-10), section 3.11.4, PDF page 703).";
        field {
            name = "reserved";
            desc = "Reserved";
            sw = r; hw = w;
            reset = 0x0;
        } reserved_31_27[31:27];
        field {
            name = "core_ts_record3";
            desc = "Core TS record register 3";
            sw = r; hw = w;
            reset = 0x0;
        } core_ts_record3[26:16];
        field {
            name = "reserved";
            desc = "Reserved";
            sw = r; hw = w;
            reset = 0x0;
        } reserved_15_11[15:11];
        field {
            name = "core_ts_record2";
            desc = "Core TS record register 2";
            sw = r; hw = w;
            reset = 0x0;
        } core_ts_record2[10:0];
    } PERI_PMC46 @ 0xB8;
    reg {
        name = "PERI_PMC47";
        desc = "PERI_PMC47 is core TS status register 2. (offset 0xBC; total reset 0x00000000; PROVEN: Hi3521A/Hi3520D V300 data sheet (Issue 00B07, 2015-12-10), section 3.11.4, PDF page 703).";
        field {
            name = "reserved";
            desc = "Reserved";
            sw = r; hw = w;
            reset = 0x0;
        } reserved_31_27[31:27];
        field {
            name = "core_ts_record5";
            desc = "Core TS record register 5";
            sw = r; hw = w;
            reset = 0x0;
        } core_ts_record5[26:16];
        field {
            name = "reserved";
            desc = "Reserved";
            sw = r; hw = w;
            reset = 0x0;
        } reserved_15_11[15:11];
        field {
            name = "core_ts_record4";
            desc = "Core TS record register 4";
            sw = r; hw = w;
            reset = 0x0;
        } core_ts_record4[10:0];
    } PERI_PMC47 @ 0xBC;
    reg {
        name = "PERI_PMC48";
        desc = "PERI_PMC48 is core TS status register 3. (offset 0xC0; total reset 0x00000000; PROVEN: Hi3521A/Hi3520D V300 data sheet (Issue 00B07, 2015-12-10), section 3.11.4, PDF page 704).";
        field {
            name = "reserved";
            desc = "Reserved";
            sw = r; hw = w;
            reset = 0x0;
        } reserved_31_27[31:27];
        field {
            name = "core_ts_record7";
            desc = "Core TS record register 7";
            sw = r; hw = w;
            reset = 0x0;
        } core_ts_record7[26:16];
        field {
            name = "reserved";
            desc = "Reserved";
            sw = r; hw = w;
            reset = 0x0;
        } reserved_15_11[15:11];
        field {
            name = "core_ts_record6";
            desc = "Core TS record register 6";
            sw = r; hw = w;
            reset = 0x0;
        } core_ts_record6[10:0];
    } PERI_PMC48 @ 0xC0;
    reg {
        name = "PERI_PMC49";
        desc = "PERI_PMC49 is CPU TS status register 0. (offset 0xC4; total reset 0x00000000; PROVEN: Hi3521A/Hi3520D V300 data sheet (Issue 00B07, 2015-12-10), section 3.11.4, PDF page 704). INFERRED: the data sheet prints the name of the [10:0] field as core_ts_ record0 (copied from PERI_PMC45); cpu_ts_record0 follows the other fields of this register and the description CPU TS record register 0.";
        field {
            name = "reserved";
            desc = "Reserved";
            sw = r; hw = w;
            reset = 0x0;
        } reserved_31_27[31:27];
        field {
            name = "cpu_ts_record1";
            desc = "CPU TS record register 1";
            sw = r; hw = w;
            reset = 0x0;
        } cpu_ts_record1[26:16];
        field {
            name = "reserved";
            desc = "Reserved";
            sw = r; hw = w;
            reset = 0x0;
        } reserved_15_11[15:11];
        field {
            name = "cpu_ts_record0";
            desc = "CPU TS record register 0";
            sw = r; hw = w;
            reset = 0x0;
        } cpu_ts_record0[10:0];
    } PERI_PMC49 @ 0xC4;
    reg {
        name = "PERI_PMC50";
        desc = "PERI_PMC50 is CPU TS status register 1. (offset 0xC8; total reset 0x00000000; PROVEN: Hi3521A/Hi3520D V300 data sheet (Issue 00B07, 2015-12-10), section 3.11.4, PDF page 705).";
        field {
            name = "reserved";
            desc = "Reserved";
            sw = r; hw = w;
            reset = 0x0;
        } reserved_31_27[31:27];
        field {
            name = "cpu_ts_record3";
            desc = "CPU TS record register 3";
            sw = r; hw = w;
            reset = 0x0;
        } cpu_ts_record3[26:16];
        field {
            name = "reserved";
            desc = "Reserved";
            sw = r; hw = w;
            reset = 0x0;
        } reserved_15_11[15:11];
        field {
            name = "cpu_ts_record2";
            desc = "CPU TS record register 2";
            sw = r; hw = w;
            reset = 0x0;
        } cpu_ts_record2[10:0];
    } PERI_PMC50 @ 0xC8;
    reg {
        name = "PERI_PMC51";
        desc = "PERI_PMC51 is CPU TS status register 2. (offset 0xCC; total reset 0x00000000; PROVEN: Hi3521A/Hi3520D V300 data sheet (Issue 00B07, 2015-12-10), section 3.11.4, PDF page 705).";
        field {
            name = "reserved";
            desc = "Reserved";
            sw = r; hw = w;
            reset = 0x0;
        } reserved_31_27[31:27];
        field {
            name = "cpu_ts_record5";
            desc = "CPU TS record register 5";
            sw = r; hw = w;
            reset = 0x0;
        } cpu_ts_record5[26:16];
        field {
            name = "reserved";
            desc = "Reserved";
            sw = r; hw = w;
            reset = 0x0;
        } reserved_15_11[15:11];
        field {
            name = "cpu_ts_record4";
            desc = "CPU TS record register 4";
            sw = r; hw = w;
            reset = 0x0;
        } cpu_ts_record4[10:0];
    } PERI_PMC51 @ 0xCC;
    reg {
        name = "PERI_PMC52";
        desc = "PERI_PMC52 is CPU TS status register 3. (offset 0xD0; total reset 0x00000000; PROVEN: Hi3521A/Hi3520D V300 data sheet (Issue 00B07, 2015-12-10), section 3.11.4, PDF page 706).";
        field {
            name = "reserved";
            desc = "Reserved";
            sw = r; hw = w;
            reset = 0x0;
        } reserved_31_27[31:27];
        field {
            name = "cpu_ts_record7";
            desc = "CPU TS record register 7";
            sw = r; hw = w;
            reset = 0x0;
        } cpu_ts_record7[26:16];
        field {
            name = "reserved";
            desc = "Reserved";
            sw = r; hw = w;
            reset = 0x0;
        } reserved_15_11[15:11];
        field {
            name = "cpu_ts_record6";
            desc = "CPU TS record register 6";
            sw = r; hw = w;
            reset = 0x0;
        } cpu_ts_record6[10:0];
    } PERI_PMC52 @ 0xD0;
    reg {
        name = "PERI_PMC68";
        desc = "PERI_PMC68 is PMC register 68. (offset 0x110; total reset 0x00000000; PROVEN: Hi3521A/Hi3520D V300 data sheet (Issue 00B07, 2015-12-10), section 3.11.4, PDF page 706).";
        field {
            name = "reserved";
            desc = "Reserved";
            sw = r; hw = w;
            reset = 0x0;
        } reserved_31_31[31:31];
        field {
            name = "tsensor_en";
            desc = "Temperature sensor enable
- 0: disabled
- 1: enabled";
            sw = rw; hw = r;
            reset = 0x0;
        } tsensor_en[30:30];
        field {
            name = "tsensor_monitor_en";
            desc = "Cyclic temperature monitoring enable
- 0: disabled
- 1: enabled";
            sw = rw; hw = r;
            reset = 0x0;
        } tsensor_monitor_en[29:29];
        field {
            name = "reserved";
            desc = "Reserved";
            sw = r; hw = w;
            reset = 0x0;
        } reserved_28_24[28:24];
        field {
            name = "tsensor_monitor_period";
            desc = "Cyclic temperature monitoring cycle. The timing reference is 1 ms.";
            sw = rw; hw = r;
            reset = 0x0;
        } tsensor_monitor_period[23:16];
        field {
            name = "tsensor_temp_uplimit";
            desc = "Temperature overflow value";
            sw = rw; hw = r;
            reset = 0x0;
        } tsensor_temp_uplimit[15:8];
        field {
            name = "tsensor_temp_lowlimit";
            desc = "Temperature underflow value";
            sw = rw; hw = r;
            reset = 0x0;
        } tsensor_temp_lowlimit[7:0];
    } PERI_PMC68 @ 0x110;
    reg {
        name = "PERI_PMC69";
        desc = "PERI_PMC69 is PMC register 69. (offset 0x114; total reset 0x00000000; PROVEN: Hi3521A/Hi3520D V300 data sheet (Issue 00B07, 2015-12-10), section 3.11.4, PDF page 707).";
        field {
            name = "tsensor_temp_code3";
            desc = "Temperature record value 3";
            sw = r; hw = w;
            reset = 0x0;
        } tsensor_temp_code3[31:24];
        field {
            name = "tsensor_temp_code2";
            desc = "Temperature record value 2";
            sw = r; hw = w;
            reset = 0x0;
        } tsensor_temp_code2[23:16];
        field {
            name = "tsensor_temp_code1";
            desc = "Temperature record value 1";
            sw = r; hw = w;
            reset = 0x0;
        } tsensor_temp_code1[15:8];
        field {
            name = "tsensor_temp_code0";
            desc = "Temperature record value 0";
            sw = r; hw = w;
            reset = 0x0;
        } tsensor_temp_code0[7:0];
    } PERI_PMC69 @ 0x114;
    reg {
        name = "PERI_PMC70";
        desc = "PERI_PMC70 is PMC register 70. (offset 0x118; total reset 0x00000000; PROVEN: Hi3521A/Hi3520D V300 data sheet (Issue 00B07, 2015-12-10), section 3.11.4, PDF page 707). The bit diagram prints the name of [7:0] as tsensor_temp_code2; the field table and the description say record value 4, so tsensor_temp_code4 is used (INFERRED).";
        field {
            name = "tsensor_temp_code7";
            desc = "Temperature record value 7";
            sw = r; hw = w;
            reset = 0x0;
        } tsensor_temp_code7[31:24];
        field {
            name = "tsensor_temp_code6";
            desc = "Temperature record value 6";
            sw = r; hw = w;
            reset = 0x0;
        } tsensor_temp_code6[23:16];
        field {
            name = "tsensor_temp_code5";
            desc = "Temperature record value 5";
            sw = r; hw = w;
            reset = 0x0;
        } tsensor_temp_code5[15:8];
        field {
            name = "tsensor_temp_code4";
            desc = "Temperature record value 4";
            sw = r; hw = w;
            reset = 0x0;
        } tsensor_temp_code4[7:0];
    } PERI_PMC70 @ 0x118;
    reg {
        name = "PERI_PMC71";
        desc = "PERI_PMC71 is PMC register 71. (offset 0x11C; total reset 0x00000000; PROVEN: Hi3521A/Hi3520D V300 data sheet (Issue 00B07, 2015-12-10), section 3.11.4, PDF page 708).";
        field {
            name = "reserved";
            desc = "Reserved";
            sw = r; hw = w;
            reset = 0x0;
        } reserved_31_2[31:2];
        field {
            name = "tsensor_low_warning";
            desc = "Temperature underflow alarm
- 0: no alarm
- 1: underflow alarm";
            sw = r; hw = w;
            reset = 0x0;
        } tsensor_low_warning[1:1];
        field {
            name = "tsensor_up_warning";
            desc = "Temperature overflow alarm
- 0: no alarm
- 1: overflow alarm";
            sw = r; hw = w;
            reset = 0x0;
        } tsensor_up_warning[0:0];
    } PERI_PMC71 @ 0x11C;
};
`endif
