`ifndef HI3520DV300_MISC_CTRL_RDL
`define HI3520DV300_MISC_CTRL_RDL
regfile eHI3520DV300_MISC_CTRL {
    name = "Peripheral control registers (MISC_CTRL)";
    desc = "Peripheral control registers (MISC_CTRL) of the Hi3521A/Hi3520D V300 at base 0x1212_0000. 34 registers extracted programmatically from the Hi3521A/Hi3520D V300 data sheet (Issue 00B07, 2015-12-10) (Table 3-9 Summary of peripheral control registers (base address: 0x1212_0000)): register headings, offsets, total reset values, field bit ranges, access types, names, reset values and descriptions, with PDF page numbers in each register description. Field names, bit ranges, access types and offsets are exact; the free-text descriptions are taken from the cell text of the field table and were checked by sampling only. Hardware not verified.";
    reg {
        name = "MISC_CTRL0";
        desc = "MISC_CTRL0 is A7 CPU control register 0. (offset 0x0; total reset 0x00004000; PROVEN: Hi3521A/Hi3520D V300 data sheet (Issue 00B07, 2015-12-10), section 3.5.5.2, PDF page 567).";
        field {
            name = "reserved";
            desc = "Reserved";
            sw = r; hw = w;
            reset = 0x0;
        } reserved_31_15[31:15];
        field {
            name = "a7_l2_cache_present";
            desc = "L2 cache enable
- 0: disabled
- 1: enabled";
            sw = rw; hw = r;
            reset = 0x1;
        } a7_l2_cache_present[14:14];
        field {
            name = "reserved";
            desc = "Reserved";
            sw = r; hw = w;
            reset = 0x0;
        } reserved_13_1[13:1];
        field {
            name = "a7_cp15sdisable";
            desc = "Disable write access to internal secure register of the processor
- 0: The write access is disabled.
- 1: The write access is enabled.";
            sw = rw; hw = r;
            reset = 0x0;
        } a7_cp15sdisable[0:0];
    } MISC_CTRL0 @ 0x0;
    reg {
        name = "MISC_CTRL1";
        desc = "MISC_CTRL1 is A7 CPU control register 1. (offset 0x4; total reset 0x00025101; PROVEN: Hi3521A/Hi3520D V300 data sheet (Issue 00B07, 2015-12-10), section 3.5.5.2, PDF page 567).";
        field {
            name = "reserved";
            desc = "Reserved";
            sw = r; hw = w;
            reset = 0x0;
        } reserved_31_28[31:28];
        field {
            name = "a7_hs_mem_adjust";
            desc = "A7 CPU high-speed memory speed adjustment control";
            sw = rw; hw = r;
            reset = 0x25101;
        } a7_hs_mem_adjust[27:0];
    } MISC_CTRL1 @ 0x4;
    reg {
        name = "MISC_CTRL2";
        desc = "MISC_CTRL2 is an A7 CPU status register. (offset 0x8; total reset 0x00000000; PROVEN: Hi3521A/Hi3520D V300 data sheet (Issue 00B07, 2015-12-10), section 3.5.5.2, PDF page 568).";
        field {
            name = "reserved";
            desc = "Reserved";
            sw = r; hw = w;
            reset = 0x0;
        } reserved_31_3[31:3];
        field {
            name = "a7_standbywfi_l2";
            desc = "Whether the A7 L2 buffer is in wait for interrupt (WFI) status
- 0: no
- 1: yes";
            sw = r; hw = w;
            reset = 0x0;
        } a7_standbywfi_l2[2:2];
        field {
            name = "a7_standbywfi";
            desc = "Whether the A7 CPU is in WFI status
- 0: no
- 1: yes";
            sw = r; hw = w;
            reset = 0x0;
        } a7_standbywfi[1:1];
        field {
            name = "a7_standbywfe";
            desc = "Whether the A7 CPU is in wait for event (WFE) status
- 0: no
- 1: yes";
            sw = r; hw = w;
            reset = 0x0;
        } a7_standbywfe[0:0];
    } MISC_CTRL2 @ 0x8;
    reg {
        name = "MISC_CTRL4";
        desc = "MISC_CTRL4 is peripheral function selection register 1. (offset 0x10; total reset 0x00000000; PROVEN: Hi3521A/Hi3520D V300 data sheet (Issue 00B07, 2015-12-10), section 3.5.5.2, PDF page 569).";
        field {
            name = "reserved";
            desc = "Reserved";
            sw = r; hw = w;
            reset = 0x0;
        } reserved_31_21[31:21];
        field {
            name = "phy_test_reg_access";
            desc = "Access mode of the USB 2.0 PHY/SATA 3.0 PHY register
- 0: This register is accessed through the configuration of other registers.
- 1: This register is accessed through the bus.";
            sw = rw; hw = r;
            reset = 0x0;
        } phy_test_reg_access[20:20];
        field {
            name = "jtag_sel";
            desc = "JTAG function select
- 00: CPU
- 01: SATA PHY 0
- 10: SATA PHY 1";
            sw = rw; hw = r;
            reset = 0x0;
        } jtag_sel[19:18];
        field {
            name = "reserved";
            desc = "Reserved";
            sw = r; hw = w;
            reset = 0x0;
        } reserved_17_16[17:16];
        field {
            name = "test_clk_sel";
            desc = "TSET_CLK_OUT test clock select
- 0: pll_test_out0
- 1: pll_test_out1
- 2: pll_test_out2
- 3: pll_test_out3
- 4: pll_test_out4
- 5: clk_test_out0
- 6: clk_test_out1
- 7: clk_test_out2
- 8: clk_24m
- 9: clk_rtc_out

Other values: reserved";
            sw = rw; hw = r;
            reset = 0x0;
        } test_clk_sel[15:12];
        field {
            name = "rom_pgen";
            desc = "SYSROM power supply enable
- 0: The internal ROM supplies power.
- 1: The internal ROM does not supply power.";
            sw = rw; hw = r;
            reset = 0x0;
        } rom_pgen[11:11];
        field {
            name = "reserved";
            desc = "Reserved";
            sw = r; hw = w;
            reset = 0x0;
        } reserved_10_1[10:1];
        field {
            name = "ram0_ck_gt_en";
            desc = "SYSRAM slice 0 clock gating enable
- 0: disabled. The internal SYSRAM slice 0 clock is always enabled.
- 1: enabled. The internal SYSRAM slice 0 clock is dynamically gated.";
            sw = rw; hw = r;
            reset = 0x0;
        } ram0_ck_gt_en[0:0];
    } MISC_CTRL4 @ 0x10;
    reg {
        name = "MISC_CTRL5";
        desc = "MISC_CTRL5 is an SSP control register. (offset 0x14; total reset 0x00000000; PROVEN: Hi3521A/Hi3520D V300 data sheet (Issue 00B07, 2015-12-10), section 3.5.5.2, PDF page 570).";
        field {
            name = "reserved";
            desc = "Reserved";
            sw = r; hw = w;
            reset = 0x0;
        } reserved_31_2[31:2];
        field {
            name = "ssp_cs_pol_ctrl";
            desc = "Polarity control of the SPI CS
- 0: The SPI CS is active low.
- 1: The SPI CS is active high.";
            sw = rw; hw = r;
            reset = 0x0;
        } ssp_cs_pol_ctrl[1:1];
        field {
            name = "ssp_cs_sel";
            desc = "SPI CS select
- 0: SPI_CSN0
- 1: SPI_CSN1";
            sw = rw; hw = r;
            reset = 0x0;
        } ssp_cs_sel[0:0];
    } MISC_CTRL5 @ 0x14;
    reg {
        name = "MISC_CTRL6";
        desc = "MISC_CTRL6 is system bus arbitration control register 0. (offset 0x18; total reset 0x00000000; PROVEN: Hi3521A/Hi3520D V300 data sheet (Issue 00B07, 2015-12-10), section 3.5.5.2, PDF page 571).";
        field {
            name = "sys_timeout_en_m2";
            desc = "Timeout count enable for the system bus M2 port
- 0: disabled
- 1: enabled";
            sw = rw; hw = r;
            reset = 0x0;
        } sys_timeout_en_m2[31:31];
        field {
            name = "sys_timeout_value_m2";
            desc = "Timeout count value of the system bus M2 port (AHB_SUBSYS) Count value = sys_timeout_value_m2 x 2";
            sw = rw; hw = r;
            reset = 0x0;
        } sys_timeout_value_m2[30:16];
        field {
            name = "sys_timeout_en_m1";
            desc = "Timeout count enable for the system bus M1 port (CPU)
- 0: disabled
- 1: enabled";
            sw = rw; hw = r;
            reset = 0x0;
        } sys_timeout_en_m1[15:15];
        field {
            name = "sys_timeout_value_m1";
            desc = "Timeout count value of the system bus M1 port (CPU) Count value = sys_timeout_value_m1 x 2";
            sw = rw; hw = r;
            reset = 0x0;
        } sys_timeout_value_m1[14:0];
    } MISC_CTRL6 @ 0x18;
    reg {
        name = "MISC_CTRL8";
        desc = "MISC_CTRL8 is system bus port priority register 0. (offset 0x20; total reset 0x00000001; PROVEN: Hi3521A/Hi3520D V300 data sheet (Issue 00B07, 2015-12-10), section 3.5.5.2, PDF page 572).";
        field {
            name = "reserved";
            desc = "Reserved";
            sw = r; hw = w;
            reset = 0x0;
        } reserved_31_7[31:7];
        field {
            name = "sysaxi_port1_pri_in";
            desc = "Bus access priority of the system bus M2 port The value 1 indicates the highest priority.";
            sw = rw; hw = r;
            reset = 0x0;
        } sysaxi_port1_pri_in[6:4];
        field {
            name = "reserved";
            desc = "Reserved";
            sw = r; hw = w;
            reset = 0x0;
        } reserved_3_3[3:3];
        field {
            name = "sysaxi_port0_pri_in";
            desc = "Bus access priority of the system bus M1 port The value 1 indicates the highest priority.";
            sw = rw; hw = r;
            reset = 0x1;
        } sysaxi_port0_pri_in[2:0];
    } MISC_CTRL8 @ 0x20;
    reg {
        name = "MISC_CTRL9";
        desc = "MISC_CTRL9 is system bus port priority register 1. (offset 0x24; total reset 0x00001234; PROVEN: Hi3521A/Hi3520D V300 data sheet (Issue 00B07, 2015-12-10), section 3.5.5.2, PDF page 572).";
        field {
            name = "reserved";
            desc = "Reserved";
            sw = r; hw = w;
            reset = 0x0;
        } reserved_31_19[31:19];
        field {
            name = "sysaxi_priority_s5";
            desc = "Bus access priority of the system bus S5 port The value 7 indicates the highest priority.";
            sw = rw; hw = r;
            reset = 0x0;
        } sysaxi_priority_s5[18:16];
        field {
            name = "reserved";
            desc = "Reserved";
            sw = r; hw = w;
            reset = 0x0;
        } reserved_15_15[15:15];
        field {
            name = "sysaxi_priority_s4";
            desc = "Bus access priority of the system bus S4 port The value 7 indicates the highest priority.";
            sw = rw; hw = r;
            reset = 0x1;
        } sysaxi_priority_s4[14:12];
        field {
            name = "reserved";
            desc = "Reserved";
            sw = r; hw = w;
            reset = 0x0;
        } reserved_11_11[11:11];
        field {
            name = "sysaxi_priority_s3";
            desc = "Bus access priority of the system bus S3 port The value 7 indicates the highest priority.";
            sw = rw; hw = r;
            reset = 0x2;
        } sysaxi_priority_s3[10:8];
        field {
            name = "reserved";
            desc = "Reserved";
            sw = r; hw = w;
            reset = 0x0;
        } reserved_7_7[7:7];
        field {
            name = "sysaxi_priority_s2";
            desc = "Bus access priority of the system bus S2 port The value 7 indicates the highest priority.";
            sw = rw; hw = r;
            reset = 0x3;
        } sysaxi_priority_s2[6:4];
        field {
            name = "reserved";
            desc = "Reserved";
            sw = r; hw = w;
            reset = 0x0;
        } reserved_3_3[3:3];
        field {
            name = "sysaxi_priority_s1";
            desc = "Bus access priority of the system bus S1 port The value 7 indicates the highest priority.";
            sw = rw; hw = r;
            reset = 0x4;
        } sysaxi_priority_s1[2:0];
    } MISC_CTRL9 @ 0x24;
    reg {
        name = "MISC_CTRL10";
        desc = "MISC_CTRL10 is media 0 bus arbitration control register 0. (offset 0x28; total reset 0x00000000; PROVEN: Hi3521A/Hi3520D V300 data sheet (Issue 00B07, 2015-12-10), section 3.5.5.2, PDF page 573).";
        field {
            name = "media0_timeout_en_m2";
            desc = "Timeout count enable for the media 0 bus M2 port
- 0: disabled
- 1: enabled";
            sw = rw; hw = r;
            reset = 0x0;
        } media0_timeout_en_m2[31:31];
        field {
            name = "media0_timeout_value_m2";
            desc = "Timeout count value of the media 0 bus M2 port Count value = media0_timeout_value_m2 x 2";
            sw = rw; hw = r;
            reset = 0x0;
        } media0_timeout_value_m2[30:16];
        field {
            name = "media0_timeout_en_m1";
            desc = "Timeout count enable for the media 0 bus M1 port
- 0: disabled
- 1: enabled";
            sw = rw; hw = r;
            reset = 0x0;
        } media0_timeout_en_m1[15:15];
        field {
            name = "media0_timeout_value_m1";
            desc = "Timeout count value of the media 0 bus M1 port Count value = media0_timeout_value_m1 x 2";
            sw = rw; hw = r;
            reset = 0x0;
        } media0_timeout_value_m1[14:0];
    } MISC_CTRL10 @ 0x28;
    reg {
        name = "MISC_CTRL11";
        desc = "MISC_CTRL11 is media 0 bus arbitration control register 1. (offset 0x2C; total reset 0x00000000; PROVEN: Hi3521A/Hi3520D V300 data sheet (Issue 00B07, 2015-12-10), section 3.5.5.2, PDF page 574).";
        field {
            name = "media0_timeout_en_m4";
            desc = "Timeout count enable for the media 0 bus M4 port
- 0: disabled
- 1: enabled";
            sw = rw; hw = r;
            reset = 0x0;
        } media0_timeout_en_m4[31:31];
        field {
            name = "media0_timeout_value_m4";
            desc = "Timeout count value of the media 0 bus M4 port Count value = media0_timeout_value_m4 x 2";
            sw = rw; hw = r;
            reset = 0x0;
        } media0_timeout_value_m4[30:16];
        field {
            name = "media0_timeout_en_m3";
            desc = "Timeout count enable for the media 0 bus M3 port
- 0: disabled
- 1: enabled";
            sw = rw; hw = r;
            reset = 0x0;
        } media0_timeout_en_m3[15:15];
        field {
            name = "media0_timeout_value_m3";
            desc = "Timeout count value of the media 0 bus M3 port Count value = media0_timeout_value_m3 x 2";
            sw = rw; hw = r;
            reset = 0x0;
        } media0_timeout_value_m3[14:0];
    } MISC_CTRL11 @ 0x2C;
    reg {
        name = "MISC_CTRL12";
        desc = "MISC_CTRL12 is media 0 bus arbitration control register 2. (offset 0x30; total reset 0x00000000; PROVEN: Hi3521A/Hi3520D V300 data sheet (Issue 00B07, 2015-12-10), section 3.5.5.2, PDF page 575).";
        field {
            name = "reserved";
            desc = "Reserved";
            sw = r; hw = w;
            reset = 0x0;
        } reserved_31_16[31:16];
        field {
            name = "media0_timeout_en_m5";
            desc = "Timeout count enable for the media 0 bus M5 port
- 0: disabled
- 1: enabled";
            sw = rw; hw = r;
            reset = 0x0;
        } media0_timeout_en_m5[15:15];
        field {
            name = "media0_timeout_value_m5";
            desc = "Timeout count value of the media 0 bus M5 port Count value = media0_timeout_value_m5 x 2";
            sw = rw; hw = r;
            reset = 0x0;
        } media0_timeout_value_m5[14:0];
    } MISC_CTRL12 @ 0x30;
    reg {
        name = "MISC_CTRL13";
        desc = "MISC_CTRL13 is a media 0 bus priority register. (offset 0x34; total reset 0x00001234; PROVEN: Hi3521A/Hi3520D V300 data sheet (Issue 00B07, 2015-12-10), section 3.5.5.2, PDF page 575).";
        field {
            name = "reserved";
            desc = "Reserved";
            sw = r; hw = w;
            reset = 0x0;
        } reserved_31_19[31:19];
        field {
            name = "media0_port4_pri_in";
            desc = "Bus access priority of the media 0 bus M5 port. The value 7 indicates the highest priority.";
            sw = rw; hw = r;
            reset = 0x0;
        } media0_port4_pri_in[18:16];
        field {
            name = "reserved";
            desc = "Reserved";
            sw = r; hw = w;
            reset = 0x0;
        } reserved_15_15[15:15];
        field {
            name = "media0_port3_pri_in";
            desc = "Bus access priority of the media 0 bus M4 port. The value 7 indicates the highest priority.";
            sw = rw; hw = r;
            reset = 0x1;
        } media0_port3_pri_in[14:12];
        field {
            name = "reserved";
            desc = "Reserved";
            sw = r; hw = w;
            reset = 0x0;
        } reserved_11_11[11:11];
        field {
            name = "media0_port2_pri_in";
            desc = "Bus access priority of the media 0 bus M3 port. The value 7 indicates the highest priority.";
            sw = rw; hw = r;
            reset = 0x2;
        } media0_port2_pri_in[10:8];
        field {
            name = "reserved";
            desc = "Reserved";
            sw = r; hw = w;
            reset = 0x0;
        } reserved_7_7[7:7];
        field {
            name = "media0_port1_pri_in";
            desc = "Bus access priority of the media 0 bus M2 port. The value 7 indicates the highest priority.";
            sw = rw; hw = r;
            reset = 0x3;
        } media0_port1_pri_in[6:4];
        field {
            name = "reserved";
            desc = "Reserved";
            sw = r; hw = w;
            reset = 0x0;
        } reserved_3_3[3:3];
        field {
            name = "media0_port0_pri_in";
            desc = "Bus access priority of the media 0 bus M1 port. The value 7 indicates the highest priority.";
            sw = rw; hw = r;
            reset = 0x4;
        } media0_port0_pri_in[2:0];
    } MISC_CTRL13 @ 0x34;
    reg {
        name = "MISC_CTRL14";
        desc = "MISC_CTRL14 is media 1 bus arbitration control register 0. (offset 0x38; total reset 0x00000000; PROVEN: Hi3521A/Hi3520D V300 data sheet (Issue 00B07, 2015-12-10), section 3.5.5.2, PDF page 576).";
        field {
            name = "media1_timeout_en_m2";
            desc = "Timeout count enable for the media 1 bus M2 port
- 0: disabled
- 1: enabled";
            sw = rw; hw = r;
            reset = 0x0;
        } media1_timeout_en_m2[31:31];
        field {
            name = "media1_timeout_value_m2";
            desc = "Timeout count value of the media 1 bus M2 port Count value = media1_timeout_value_m2 x 2";
            sw = rw; hw = r;
            reset = 0x0;
        } media1_timeout_value_m2[30:16];
        field {
            name = "media1_timeout_en_m1";
            desc = "Timeout count enable for the media 1 bus M1 port
- 0: disabled
- 1: enabled";
            sw = rw; hw = r;
            reset = 0x0;
        } media1_timeout_en_m1[15:15];
        field {
            name = "media1_timeout_value_m1";
            desc = "Timeout count value of the media 1 bus M1 port Count value = media1_timeout_value_m1 x 2";
            sw = rw; hw = r;
            reset = 0x0;
        } media1_timeout_value_m1[14:0];
    } MISC_CTRL14 @ 0x38;
    reg {
        name = "MISC_CTRL15";
        desc = "MISC_CTRL15 is media 1 bus arbitration control register 1. (offset 0x3C; total reset 0x00000000; PROVEN: Hi3521A/Hi3520D V300 data sheet (Issue 00B07, 2015-12-10), section 3.5.5.2, PDF page 577).";
        field {
            name = "media1_timeout_en_m4";
            desc = "Timeout count enable for the media 1 bus M4 port
- 0: disabled
- 1: enabled";
            sw = rw; hw = r;
            reset = 0x0;
        } media1_timeout_en_m4[31:31];
        field {
            name = "media1_timeout_value_m4";
            desc = "Timeout count value of the media 1 bus M4 port Count value = media1_timeout_value_m4 x 2";
            sw = rw; hw = r;
            reset = 0x0;
        } media1_timeout_value_m4[30:16];
        field {
            name = "media1_timeout_en_m3";
            desc = "Timeout count enable for the media 1 bus M3 port
- 0: disabled
- 1: enabled";
            sw = rw; hw = r;
            reset = 0x0;
        } media1_timeout_en_m3[15:15];
        field {
            name = "media1_timeout_value_m3";
            desc = "Timeout count value of the media 1 bus M3 port Count value = media1_timeout_value_m3 x 2";
            sw = rw; hw = r;
            reset = 0x0;
        } media1_timeout_value_m3[14:0];
    } MISC_CTRL15 @ 0x3C;
    reg {
        name = "MISC_CTRL16";
        desc = "MISC_CTRL16 is media 1 bus arbitration control register 2. (offset 0x40; total reset 0x00000000; PROVEN: Hi3521A/Hi3520D V300 data sheet (Issue 00B07, 2015-12-10), section 3.5.5.2, PDF page 578).";
        field {
            name = "media1_timeout_en_m6";
            desc = "Timeout count enable for the media 1 bus M6 port
- 0: disabled
- 1: enabled";
            sw = rw; hw = r;
            reset = 0x0;
        } media1_timeout_en_m6[31:31];
        field {
            name = "media1_timeout_value_m6";
            desc = "Timeout count value of the media 1 bus M6 port Count value = media1_timeout_value_m6 x 2";
            sw = rw; hw = r;
            reset = 0x0;
        } media1_timeout_value_m6[30:16];
        field {
            name = "media1_timeout_en_m5";
            desc = "Timeout count enable for the media 1 bus M5 port
- 0: disabled
- 1: enabled";
            sw = rw; hw = r;
            reset = 0x0;
        } media1_timeout_en_m5[15:15];
        field {
            name = "media1_timeout_value_m5";
            desc = "Timeout count value of the media 1 bus M5 port Count value = media1_timeout_value_m5 x 2";
            sw = rw; hw = r;
            reset = 0x0;
        } media1_timeout_value_m5[14:0];
    } MISC_CTRL16 @ 0x40;
    reg {
        name = "MISC_CTRL17";
        desc = "MISC_CTRL17 is a media 1 bus priority register. (offset 0x44; total reset 0x00012345; PROVEN: Hi3521A/Hi3520D V300 data sheet (Issue 00B07, 2015-12-10), section 3.5.5.2, PDF page 579).";
        field {
            name = "reserved";
            desc = "Reserved";
            sw = r; hw = w;
            reset = 0x0;
        } reserved_31_23[31:23];
        field {
            name = "media1_port5_pri_in";
            desc = "Bus access priority of the media 1 bus M6 port (MDU) The value 7 indicates the highest priority.";
            sw = rw; hw = r;
            reset = 0x0;
        } media1_port5_pri_in[22:20];
        field {
            name = "reserved";
            desc = "Reserved";
            sw = r; hw = w;
            reset = 0x0;
        } reserved_19_19[19:19];
        field {
            name = "media1_port4_pri_in";
            desc = "Bus access priority of the media 1 bus M5 port (AIAO) The value 7 indicates the highest priority.";
            sw = rw; hw = r;
            reset = 0x1;
        } media1_port4_pri_in[18:16];
        field {
            name = "reserved";
            desc = "Reserved";
            sw = r; hw = w;
            reset = 0x0;
        } reserved_15_15[15:15];
        field {
            name = "media1_port3_pri_in";
            desc = "Bus access priority of the media 1 bus M4 port (JPGE) The value 7 indicates the highest priority.";
            sw = rw; hw = r;
            reset = 0x2;
        } media1_port3_pri_in[14:12];
        field {
            name = "reserved";
            desc = "Reserved";
            sw = r; hw = w;
            reset = 0x0;
        } reserved_11_11[11:11];
        field {
            name = "media1_port2_pri_in";
            desc = "Bus access priority of the media 1 bus M3 port (VOIE) The value 7 indicates the highest priority.";
            sw = rw; hw = r;
            reset = 0x3;
        } media1_port2_pri_in[10:8];
        field {
            name = "reserved";
            desc = "Reserved";
            sw = r; hw = w;
            reset = 0x0;
        } reserved_7_7[7:7];
        field {
            name = "media1_port1_pri_in";
            desc = "Bus access priority of the media 1 bus M2 port (VPSS) The value 7 indicates the highest priority.";
            sw = rw; hw = r;
            reset = 0x4;
        } media1_port1_pri_in[6:4];
        field {
            name = "reserved";
            desc = "Reserved";
            sw = r; hw = w;
            reset = 0x0;
        } reserved_3_3[3:3];
        field {
            name = "media1_port0_pri_in";
            desc = "Bus access priority of the media 1 bus M1 port (ACV1) The value 7 indicates the highest priority.";
            sw = rw; hw = r;
            reset = 0x5;
        } media1_port0_pri_in[2:0];
    } MISC_CTRL17 @ 0x44;
    reg {
        name = "MISC_CTRL18";
        desc = "MISC_CTRL18 is HP_PERI bus arbitration control register 0. (offset 0x48; total reset 0x00000000; PROVEN: Hi3521A/Hi3520D V300 data sheet (Issue 00B07, 2015-12-10), section 3.5.5.2, PDF page 580).";
        field {
            name = "hp_peri_timeout_en_m2";
            desc = "Timeout count enable for the HP_PERI bus M2 port
- 0: disabled
- 1: enabled";
            sw = rw; hw = r;
            reset = 0x0;
        } hp_peri_timeout_en_m2[31:31];
        field {
            name = "hp_peri_timeout_value_m2";
            desc = "Timeout count value of the HP_PERI bus M2 port Count value = hp_peri_timeout_value_m2 x 2";
            sw = rw; hw = r;
            reset = 0x0;
        } hp_peri_timeout_value_m2[30:16];
        field {
            name = "hp_peri_timeout_en_m1";
            desc = "Timeout count enable for the HP_PERI bus M1 port
- 0: disabled
- 1: enabled";
            sw = rw; hw = r;
            reset = 0x0;
        } hp_peri_timeout_en_m1[15:15];
        field {
            name = "hp_peri_timeout_value_m1";
            desc = "Timeout count value of the HP_PERI bus M1 port Count value = hp_peri_timeout_value_m1 x 2";
            sw = rw; hw = r;
            reset = 0x0;
        } hp_peri_timeout_value_m1[14:0];
    } MISC_CTRL18 @ 0x48;
    reg {
        name = "MISC_CTRL19";
        desc = "MISC_CTRL19 is HP_PERI bus arbitration control register 1. (offset 0x4C; total reset 0x00000001; PROVEN: Hi3521A/Hi3520D V300 data sheet (Issue 00B07, 2015-12-10), section 3.5.5.2, PDF page 581).";
        field {
            name = "reserved";
            desc = "Reserved";
            sw = r; hw = w;
            reset = 0x0;
        } reserved_31_7[31:7];
        field {
            name = "hp_peri_port1_pri_in";
            desc = "Bus access priority of the HP_PERI bus M2 port (SATA) The value 1 indicates the highest priority.";
            sw = rw; hw = r;
            reset = 0x0;
        } hp_peri_port1_pri_in[6:4];
        field {
            name = "reserved";
            desc = "Reserved";
            sw = r; hw = w;
            reset = 0x0;
        } reserved_3_3[3:3];
        field {
            name = "hp_peri_port0_pri_in";
            desc = "Bus access priority of the HP_PERI bus M1 port (GSF) The value 1 indicates the highest priority.";
            sw = rw; hw = r;
            reset = 0x1;
        } hp_peri_port0_pri_in[2:0];
    } MISC_CTRL19 @ 0x4C;
    reg {
        name = "MISC_CTRL20";
        desc = "MISC_CTRL20 is USB 2.0 control register 0. (offset 0x50; total reset 0x000C33E0; PROVEN: Hi3521A/Hi3520D V300 data sheet (Issue 00B07, 2015-12-10), section 3.5.5.2, PDF page 582).";
        field {
            name = "reserved";
            desc = "Reserved";
            sw = r; hw = w;
            reset = 0x0;
        } reserved_31_22[31:22];
        field {
            name = "usb2_host_ovrcur_merge";
            desc = "One overcurrent enable for two USB 2.0 ports
- 0: disabled
- 1: enabled";
            sw = rw; hw = r;
            reset = 0x0;
        } usb2_host_ovrcur_merge[21:21];
        field {
            name = "usb2_host_pwr_merge";
            desc = "One power supply enable for two USB 2.0 ports
- 0: disabled
- 1: enabled";
            sw = rw; hw = r;
            reset = 0x0;
        } usb2_host_pwr_merge[20:20];
        field {
            name = "usb2_host_ovrcur_pol";
            desc = "Overcurrent protection polarity control for the USB 2.0 port
- 0: active low
- 1: active high";
            sw = rw; hw = r;
            reset = 0x1;
        } usb2_host_ovrcur_pol[19:19];
        field {
            name = "usb2_host_pwren_pol";
            desc = "Power enable polarity control for the USB 2.0 port
- 0: active low
- 1: active high";
            sw = rw; hw = r;
            reset = 0x1;
        } usb2_host_pwren_pol[18:18];
        field {
            name = "reserved";
            desc = "Reserved";
            sw = r; hw = w;
            reset = 0x0;
        } reserved_17_17[17:17];
        field {
            name = "usb2_host_p1_ovrcur_en";
            desc = "Overcurrent protection enable for USB 2.0 port 1
- 0: Overcurrent protection is disabled.
- 1: Overcurrent protection is enabled.";
            sw = rw; hw = r;
            reset = 0x0;
        } usb2_host_p1_ovrcur_en[16:16];
        field {
            name = "usb2_host_p0_ovrcur_en";
            desc = "Overcurrent protection enable for USB 2.0 port 0
- 0: Overcurrent protection is disabled.
- 1: Overcurrent protection is enabled.";
            sw = rw; hw = r;
            reset = 0x0;
        } usb2_host_p0_ovrcur_en[15:15];
        field {
            name = "reserved";
            desc = "Reserved";
            sw = r; hw = w;
            reset = 0x0;
        } reserved_14_14[14:14];
        field {
            name = "usb2_host_p1_pwr_en";
            desc = "Power shutdown control for USB 2.0 port 1
- 0: The power is shut down.
- 1: The output power of the USB 2.0 controller is enabled.";
            sw = rw; hw = r;
            reset = 0x1;
        } usb2_host_p1_pwr_en[13:13];
        field {
            name = "usb2_host_p0_pwr_en";
            desc = "Power shutdown control for USB 2.0 port 0
- 0: The power is shut down.
- 1: The output power of the USB 2.0 controller is enabled.";
            sw = rw; hw = r;
            reset = 0x1;
        } usb2_host_p0_pwr_en[12:12];
        field {
            name = "reserved";
            desc = "Reserved";
            sw = r; hw = w;
            reset = 0x0;
        } reserved_11_11[11:11];
        field {
            name = "reserved";
            desc = "Reserved";
            sw = r; hw = w;
            reset = 0x0;
        } reserved_10_10[10:10];
        field {
            name = "usb2_host_ena_incr16";
            desc = "USB 2.0 burst16 enable
- 0: disabled
- 1: enabled";
            sw = rw; hw = r;
            reset = 0x1;
        } usb2_host_ena_incr16[9:9];
        field {
            name = "usb2_host_ena_incr8";
            desc = "USB2.0 controller burst8 enable
- 0: disabled
- 1: enabled";
            sw = rw; hw = r;
            reset = 0x1;
        } usb2_host_ena_incr8[8:8];
        field {
            name = "usb2_host_ena_incr4";
            desc = "USB2.0 controller burst4 enable
- 0: disabled
- 1: enabled";
            sw = rw; hw = r;
            reset = 0x1;
        } usb2_host_ena_incr4[7:7];
        field {
            name = "usb2_host_ena_incrx_align";
            desc = "USB2.0 controller burst alignment enable
- 0: disabled
- 1: enabled";
            sw = rw; hw = r;
            reset = 0x1;
        } usb2_host_ena_incrx_align[6:6];
        field {
            name = "usb2_host_autoppd_on_overcur";
            desc = "Automatic port power shutdown enable during USB 2.0 controller overcurrent
- 0: disabled
- 1: enabled";
            sw = rw; hw = r;
            reset = 0x1;
        } usb2_host_autoppd_on_overcur[5:5];
        field {
            name = "reserved";
            desc = "Reserved";
            sw = r; hw = w;
            reset = 0x0;
        } reserved_4_4[4:4];
        field {
            name = "reserved";
            desc = "Reserved";
            sw = r; hw = w;
            reset = 0x0;
        } reserved_3_3[3:3];
        field {
            name = "usb2_host_app_start_clk";
            desc = "USB 2.0 OHCI clock control signal 0 (default): The OHCI works properly.
- 1: The OHCI clock is enabled in suspend mode.";
            sw = rw; hw = r;
            reset = 0x0;
        } usb2_host_app_start_clk[2:2];
        field {
            name = "usb2_host_ohci_susp_lgcy";
            desc = "Strap input signal when the USB 2.0 OHCI is suspended";
            sw = rw; hw = r;
            reset = 0x0;
        } usb2_host_ohci_susp_lgcy[1:1];
        field {
            name = "usb2_host_word_if";
            desc = "Data bit width select of the USB 2.0 host UTMI interface
- 0: 8 bits
- 1: 16 bits";
            sw = rw; hw = r;
            reset = 0x0;
        } usb2_host_word_if[0:0];
    } MISC_CTRL20 @ 0x50;
    reg {
        name = "MISC_CTRL21";
        desc = "MISC_CTRL21 is USB 2.0 control register 1. (offset 0x54; total reset 0x00000000; PROVEN: Hi3521A/Hi3520D V300 data sheet (Issue 00B07, 2015-12-10), section 3.5.5.2, PDF page 584).";
        field {
            name = "reserved";
            desc = "Reserved";
            sw = r; hw = w;
            reset = 0x0;
        } reserved_31_24[31:24];
        field {
            name = "usb2_phy_test_rddata";
            desc = "Read data of the USB 2.0 PHY test register";
            sw = r; hw = w;
            reset = 0x0;
        } usb2_phy_test_rddata[23:16];
        field {
            name = "usb2_phy_test_wrdata";
            desc = "Write data of the USB 2.0 PHY test register";
            sw = rw; hw = r;
            reset = 0x0;
        } usb2_phy_test_wrdata[15:8];
        field {
            name = "reserved";
            desc = "Reserved";
            sw = r; hw = w;
            reset = 0x0;
        } reserved_7_6[7:6];
        field {
            name = "usb2_phy_test_wren";
            desc = "Read/Write control for the USB 2.0 PHY test register
- 0: read enable
- 1: write enable";
            sw = rw; hw = r;
            reset = 0x0;
        } usb2_phy_test_wren[5:5];
        field {
            name = "usb2_phy_test_addr";
            desc = "Address of the USB 2.0 PHY test register";
            sw = rw; hw = r;
            reset = 0x0;
        } usb2_phy_test_addr[4:0];
    } MISC_CTRL21 @ 0x54;
    reg {
        name = "MISC_CTRL22";
        desc = "MISC_CTRL22 is SATA PHY 0 control register 0. (offset 0x58; total reset 0x00000000; PROVEN: Hi3521A/Hi3520D V300 data sheet (Issue 00B07, 2015-12-10), section 3.5.5.2, PDF page 585).";
        field {
            name = "sata_phy0_crdatain";
            desc = "Address and write data input for the SATA PHY 0 control register";
            sw = rw; hw = r;
            reset = 0x0;
        } sata_phy0_crdatain[31:16];
        field {
            name = "reserved";
            desc = "Reserved";
            sw = r; hw = w;
            reset = 0x0;
        } reserved_15_4[15:4];
        field {
            name = "sata_phy0_crwrite";
            desc = "Write enable for the SATA PHY 0 control register, active high";
            sw = rw; hw = r;
            reset = 0x0;
        } sata_phy0_crwrite[3:3];
        field {
            name = "sata_phy0_crread";
            desc = "Read enable for the SATA PHY 0 control register, active high";
            sw = rw; hw = r;
            reset = 0x0;
        } sata_phy0_crread[2:2];
        field {
            name = "sata_phy0_crcapdata";
            desc = "Data capture enable for the SATA PHY 0 control register, active high";
            sw = rw; hw = r;
            reset = 0x0;
        } sata_phy0_crcapdata[1:1];
        field {
            name = "sata_phy0_crcapaddr";
            desc = "Address capture enable for the SATA PHY 0 control register, active high";
            sw = rw; hw = r;
            reset = 0x0;
        } sata_phy0_crcapaddr[0:0];
    } MISC_CTRL22 @ 0x58;
    reg {
        name = "MISC_CTRL23";
        desc = "MISC_CTRL23 is SATA PHY 0 control register 1. (offset 0x5C; total reset 0x00000000; PROVEN: Hi3521A/Hi3520D V300 data sheet (Issue 00B07, 2015-12-10), section 3.5.5.2, PDF page 585).";
        field {
            name = "reserved";
            desc = "Reserved";
            sw = r; hw = w;
            reset = 0x0;
        } reserved_31_16[31:16];
        field {
            name = "sata_phy0_crdataout";
            desc = "Data output for the SATA PHY 0 control register";
            sw = r; hw = w;
            reset = 0x0;
        } sata_phy0_crdataout[15:0];
    } MISC_CTRL23 @ 0x5C;
    reg {
        name = "MISC_CTRL24";
        desc = "MISC_CTRL24 is SATA PHY 0 control register 2. (offset 0x60; total reset 0x00000000; PROVEN: Hi3521A/Hi3520D V300 data sheet (Issue 00B07, 2015-12-10), section 3.5.5.2, PDF page 586).";
        field {
            name = "reserved";
            desc = "Reserved";
            sw = r; hw = w;
            reset = 0x0;
        } reserved_31_5[31:5];
        field {
            name = "sata_phy0_acjt_level";
            desc = "RX sensitivity level of the SATA PHY 0 JTAG interface";
            sw = rw; hw = r;
            reset = 0x0;
        } sata_phy0_acjt_level[4:0];
    } MISC_CTRL24 @ 0x60;
    reg {
        name = "MISC_CTRL25";
        desc = "MISC_CTRL25 is SATA PHY 1 control register 0. (offset 0x64; total reset 0x00000000; PROVEN: Hi3521A/Hi3520D V300 data sheet (Issue 00B07, 2015-12-10), section 3.5.5.2, PDF page 586).";
        field {
            name = "sata_phy1_crdatain";
            desc = "Address and write data input for the SATA PHY 1 control register";
            sw = rw; hw = r;
            reset = 0x0;
        } sata_phy1_crdatain[31:16];
        field {
            name = "reserved";
            desc = "Reserved";
            sw = r; hw = w;
            reset = 0x0;
        } reserved_15_4[15:4];
        field {
            name = "sata_phy1_crwrite";
            desc = "Write enable for the SATA PHY 1 control register, active high";
            sw = rw; hw = r;
            reset = 0x0;
        } sata_phy1_crwrite[3:3];
        field {
            name = "sata_phy1_crread";
            desc = "Read enable for the SATA PHY 1 control register, active high";
            sw = rw; hw = r;
            reset = 0x0;
        } sata_phy1_crread[2:2];
        field {
            name = "sata_phy1_crcapdata";
            desc = "Data capture enable for the SATA PHY 1 control register, active high";
            sw = rw; hw = r;
            reset = 0x0;
        } sata_phy1_crcapdata[1:1];
        field {
            name = "sata_phy1_crcapaddr";
            desc = "Address capture enable for the SATA PHY 1 control register, active high";
            sw = rw; hw = r;
            reset = 0x0;
        } sata_phy1_crcapaddr[0:0];
    } MISC_CTRL25 @ 0x64;
    reg {
        name = "MISC_CTRL26";
        desc = "MISC_CTRL26 is SATA PHY 1 control register 1. (offset 0x68; total reset 0x00000000; PROVEN: Hi3521A/Hi3520D V300 data sheet (Issue 00B07, 2015-12-10), section 3.5.5.2, PDF page 587).";
        field {
            name = "reserved";
            desc = "Reserved";
            sw = r; hw = w;
            reset = 0x0;
        } reserved_31_16[31:16];
        field {
            name = "sata_phy1_crdataout";
            desc = "Data output for the SATA PHY 1 control register";
            sw = r; hw = w;
            reset = 0x0;
        } sata_phy1_crdataout[15:0];
    } MISC_CTRL26 @ 0x68;
    reg {
        name = "MISC_CTRL27";
        desc = "MISC_CTRL27 is SATA PHY 1 control register 2. (offset 0x6C; total reset 0x00000000; PROVEN: Hi3521A/Hi3520D V300 data sheet (Issue 00B07, 2015-12-10), section 3.5.5.2, PDF page 587).";
        field {
            name = "reserved";
            desc = "Reserved";
            sw = r; hw = w;
            reset = 0x0;
        } reserved_31_5[31:5];
        field {
            name = "sata_phy1_acjt_level";
            desc = "RX sensitivity level of the SATA PHY 1 JTAG interface";
            sw = rw; hw = r;
            reset = 0x0;
        } sata_phy1_acjt_level[4:0];
    } MISC_CTRL27 @ 0x6C;
    reg {
        name = "MISC_CTRL28";
        desc = "MISC_CTRL28 is an SATA loopback control register. (offset 0x70; total reset 0x00000000; PROVEN: Hi3521A/Hi3520D V300 data sheet (Issue 00B07, 2015-12-10), section 3.5.5.2, PDF page 588).";
        field {
            name = "reserved";
            desc = "Reserved";
            sw = r; hw = w;
            reset = 0x0;
        } reserved_31_6[31:6];
        field {
            name = "sata_lpbk_mode_sel1";
            desc = "Loopback mode select for SATA port 1
- 0: forcible loopback
- 1: data matching loopback";
            sw = rw; hw = r;
            reset = 0x0;
        } sata_lpbk_mode_sel1[5:5];
        field {
            name = "sata_lpbk_mode_sel0";
            desc = "Loopback mode select for SATA port 0
- 0: forcible loopback
- 1: data matching loopback";
            sw = rw; hw = r;
            reset = 0x0;
        } sata_lpbk_mode_sel0[4:4];
        field {
            name = "reserved";
            desc = "Reserved";
            sw = r; hw = w;
            reset = 0x0;
        } reserved_3_2[3:2];
        field {
            name = "sata_lpbk_ctrl_en1";
            desc = "Loopback enable for SATA port 1
- 0: disabled
- 1: enabled";
            sw = rw; hw = r;
            reset = 0x0;
        } sata_lpbk_ctrl_en1[1:1];
        field {
            name = "sata_lpbk_ctrl_en0";
            desc = "Loopback enable for SATA port 0
- 0: disabled
- 1: enabled";
            sw = rw; hw = r;
            reset = 0x0;
        } sata_lpbk_ctrl_en0[0:0];
    } MISC_CTRL28 @ 0x70;
    reg {
        name = "MISC_CTRL29";
        desc = "MISC_CTRL29 is an SATA port 0 loopback configuration register. (offset 0x74; total reset 0x00000000; PROVEN: Hi3521A/Hi3520D V300 data sheet (Issue 00B07, 2015-12-10), section 3.5.5.2, PDF page 589).";
        field {
            name = "sata_lpbk_match_cfg0";
            desc = "Loopback configuration for SATA port 0";
            sw = rw; hw = r;
            reset = 0x0;
        } sata_lpbk_match_cfg0[31:0];
    } MISC_CTRL29 @ 0x74;
    reg {
        name = "MISC_CTRL30";
        desc = "MISC_CTRL30 is an SATA port 1 loopback configuration register. (offset 0x78; total reset 0x00000000; PROVEN: Hi3521A/Hi3520D V300 data sheet (Issue 00B07, 2015-12-10), section 3.5.5.2, PDF page 589).";
        field {
            name = "sata_lpbk_match_cfg1";
            desc = "Loopback configuration for SATA port 1";
            sw = rw; hw = r;
            reset = 0x0;
        } sata_lpbk_match_cfg1[31:0];
    } MISC_CTRL30 @ 0x78;
    reg {
        name = "MISC_CTRL31";
        desc = "MISC_CTRL31 is DDQ QoS control register 0. (offset 0x7C; total reset 0x00000000; PROVEN: Hi3521A/Hi3520D V300 data sheet (Issue 00B07, 2015-12-10), section 3.5.5.2, PDF page 589).";
        field {
            name = "vgs_qos";
            desc = "QoS mapping value of the VGS in the MDDRC";
            sw = rw; hw = r;
            reset = 0x0;
        } vgs_qos[31:28];
        field {
            name = "jpgd_qos";
            desc = "QoS mapping value of the JPGD in the MDDRC";
            sw = rw; hw = r;
            reset = 0x0;
        } jpgd_qos[27:24];
        field {
            name = "ive_qos";
            desc = "QoS mapping value of the IVE in the MDDRC";
            sw = rw; hw = r;
            reset = 0x0;
        } ive_qos[23:20];
        field {
            name = "tde_qos";
            desc = "QoS mapping value of the TDE in the MDDRC";
            sw = rw; hw = r;
            reset = 0x0;
        } tde_qos[19:16];
        field {
            name = "avc0_qos";
            desc = "QoS mapping value of the AVC0 in the MDDRC";
            sw = rw; hw = r;
            reset = 0x0;
        } avc0_qos[15:12];
        field {
            name = "a7_qos";
            desc = "QoS mapping value of the A7 in the MDDRC";
            sw = rw; hw = r;
            reset = 0x0;
        } a7_qos[11:8];
        field {
            name = "vdp_qos";
            desc = "QoS mapping value of the VDP in the MDDRC";
            sw = rw; hw = r;
            reset = 0x0;
        } vdp_qos[7:4];
        field {
            name = "vicap_qos";
            desc = "QoS mapping value of the VICAP in the MDDRC";
            sw = rw; hw = r;
            reset = 0x0;
        } vicap_qos[3:0];
    } MISC_CTRL31 @ 0x7C;
    reg {
        name = "MISC_CTRL32";
        desc = "MISC_CTRL32 is DDQ QoS control register 1. (offset 0x80; total reset 0x00000000; PROVEN: Hi3521A/Hi3520D V300 data sheet (Issue 00B07, 2015-12-10), section 3.5.5.2, PDF page 590).";
        field {
            name = "gsf_qos";
            desc = "QoS mapping value of the GSF in the MDDRC";
            sw = rw; hw = r;
            reset = 0x0;
        } gsf_qos[31:28];
        field {
            name = "ddrt_qos";
            desc = "QoS mapping value of the DDRT in the MDDRC";
            sw = rw; hw = r;
            reset = 0x0;
        } ddrt_qos[27:24];
        field {
            name = "avc1_qos";
            desc = "QoS mapping value of the AVC1 in the MDDRC";
            sw = rw; hw = r;
            reset = 0x0;
        } avc1_qos[23:20];
        field {
            name = "vpss_qos";
            desc = "QoS mapping value of the VPSS in the MDDRC";
            sw = rw; hw = r;
            reset = 0x0;
        } vpss_qos[19:16];
        field {
            name = "voie_qos";
            desc = "QoS mapping value of the VOIE in the MDDRC";
            sw = rw; hw = r;
            reset = 0x0;
        } voie_qos[15:12];
        field {
            name = "jpge_qos";
            desc = "QoS mapping value of the JPGE in the MDDRC";
            sw = rw; hw = r;
            reset = 0x0;
        } jpge_qos[11:8];
        field {
            name = "aio_qos";
            desc = "QoS mapping value of the AIAO in the MDDRC";
            sw = rw; hw = r;
            reset = 0x0;
        } aio_qos[7:4];
        field {
            name = "mdu_qos";
            desc = "QoS mapping value of the MDU in the MDDRC";
            sw = rw; hw = r;
            reset = 0x0;
        } mdu_qos[3:0];
    } MISC_CTRL32 @ 0x80;
    reg {
        name = "MISC_CTRL33";
        desc = "MISC_CTRL33 is DDQ QoS control register 2. (offset 0x84; total reset 0x00000000; PROVEN: Hi3521A/Hi3520D V300 data sheet (Issue 00B07, 2015-12-10), section 3.5.5.2, PDF page 590).";
        field {
            name = "reserved";
            desc = "Reserved";
            sw = r; hw = w;
            reset = 0x0;
        } reserved_31_28[31:28];
        field {
            name = "dma_m1_qos";
            desc = "QoS mapping value of DMA master 1 in the MDDRC";
            sw = rw; hw = r;
            reset = 0x0;
        } dma_m1_qos[27:24];
        field {
            name = "dma_m0_qos";
            desc = "QoS mapping value of DMA master 0 in the MDDRC";
            sw = rw; hw = r;
            reset = 0x0;
        } dma_m0_qos[23:20];
        field {
            name = "fmc_qos";
            desc = "QoS mapping value of the FMC in the MDDRC";
            sw = rw; hw = r;
            reset = 0x0;
        } fmc_qos[19:16];
        field {
            name = "usb2_qos";
            desc = "QoS mapping value of USB 2.0 in the MDDRC";
            sw = rw; hw = r;
            reset = 0x0;
        } usb2_qos[15:12];
        field {
            name = "cipher_qos";
            desc = "QoS mapping value of the cipher in the MDDRC";
            sw = rw; hw = r;
            reset = 0x0;
        } cipher_qos[11:8];
        field {
            name = "scd_qos";
            desc = "QoS mapping value of the SCD in the MDDRC";
            sw = rw; hw = r;
            reset = 0x0;
        } scd_qos[7:4];
        field {
            name = "sata_qos";
            desc = "QoS mapping value of the SATA in the MDDRC";
            sw = rw; hw = r;
            reset = 0x0;
        } sata_qos[3:0];
    } MISC_CTRL33 @ 0x84;
    reg {
        name = "MISC_CTRL36";
        desc = "MISC_CTRL36 is VIVO bus arbitration control register 0. (offset 0x90; total reset 0x00000000; PROVEN: Hi3521A/Hi3520D V300 data sheet (Issue 00B07, 2015-12-10), section 3.5.5.2, PDF page 591).";
        field {
            name = "vivo_timeout_en_m2";
            desc = "Timeout count enable for the VIVO bus M2 port
- 0: disabled
- 1: enabled";
            sw = rw; hw = r;
            reset = 0x0;
        } vivo_timeout_en_m2[31:31];
        field {
            name = "vivo_timeout_value_m2";
            desc = "Timeout count value of the VIVO bus M2 port Count value = media0_timeout_value_m2 x 2";
            sw = rw; hw = r;
            reset = 0x0;
        } vivo_timeout_value_m2[30:16];
        field {
            name = "vivo_timeout_en_m1";
            desc = "Timeout count enable for the VIVO bus M1 port
- 0: disabled
- 1: enabled";
            sw = rw; hw = r;
            reset = 0x0;
        } vivo_timeout_en_m1[15:15];
        field {
            name = "vivo_timeout_value_m1";
            desc = "Timeout count value of the VIVO bus M1 port Count value = media0_timeout_value_m1 x 2";
            sw = rw; hw = r;
            reset = 0x0;
        } vivo_timeout_value_m1[14:0];
    } MISC_CTRL36 @ 0x90;
    reg {
        name = "MISC_CTRL37";
        desc = "MISC_CTRL37 is a VIVO bus priority register. (offset 0x94; total reset 0x00000001; PROVEN: Hi3521A/Hi3520D V300 data sheet (Issue 00B07, 2015-12-10), section 3.5.5.2, PDF page 592).";
        field {
            name = "reserved";
            desc = "Reserved";
            sw = r; hw = w;
            reset = 0x0;
        } reserved_31_7[31:7];
        field {
            name = "vivo_port1_pri_in";
            desc = "Bus access priority of the VIVO bus M2 port (VO) The value 1 indicates the highest priority.";
            sw = rw; hw = r;
            reset = 0x0;
        } vivo_port1_pri_in[6:4];
        field {
            name = "reserved";
            desc = "Reserved";
            sw = r; hw = w;
            reset = 0x0;
        } reserved_3_3[3:3];
        field {
            name = "vivo_port0_pri_in";
            desc = "Bus access priority of the VIVO bus M1 port (VI) The value 1 indicates the highest priority.";
            sw = rw; hw = r;
            reset = 0x1;
        } vivo_port0_pri_in[2:0];
    } MISC_CTRL37 @ 0x94;
};
`endif
