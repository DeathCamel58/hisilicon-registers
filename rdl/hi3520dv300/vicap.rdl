`ifndef HI3520DV300_VICAP_RDL
`define HI3520DV300_VICAP_RDL
regfile eHI3520DV300_VICAP {
    name = "Video capture (VICAP)";
    desc = "Video capture (VICAP) of the Hi3521A/Hi3520D V300 at base 0x130C_0000. 83 registers extracted programmatically from the Hi3521A/Hi3520D V300 data sheet (Issue 00B07, 2015-12-10) (Table 10-5 Summary of the VICAP registers (base address: 0x130C_0000)): register headings, offsets, total reset values, field bit ranges, access types, names, reset values and descriptions, with PDF page numbers in each register description. Field names, bit ranges, access types and offsets are exact; the free-text descriptions are taken from the cell text of the field table and were checked by sampling only. Hardware not verified.";
    reg {
        name = "WK_MODE";
        desc = "WK_MODE is a global working configuration register. (offset 0x0; total reset 0x00000000; PROVEN: Hi3521A/Hi3520D V300 data sheet (Issue 00B07, 2015-12-10), section 10.1.6, PDF page 1180).";
        field {
            name = "reserved";
            desc = "Reserved";
            sw = r; hw = w;
            reset = 0x0;
        } reserved_31_1[31:1];
        field {
            name = "power_mode";
            desc = "Clock mode
- 0: The low-power mode is disabled.
- 1: The low-power mode is enabled.";
            sw = rw; hw = r;
            reset = 0x0;
        } power_mode[0:0];
    } WK_MODE @ 0x0;
    reg {
        name = "AXI_CFG";
        desc = "AXI_CFG is a bus configuration register. (offset 0x10; total reset 0x00101000; PROVEN: Hi3521A/Hi3520D V300 data sheet (Issue 00B07, 2015-12-10), section 10.1.6, PDF page 1181).";
        field {
            name = "reserved";
            desc = "Reserved";
            sw = r; hw = w;
            reset = 0x1010;
        } reserved_31_8[31:8];
        field {
            name = "w_outstanding";
            desc = "Number of write request outstandings Value range: [1,8]";
            sw = rw; hw = r;
            reset = 0x0;
        } w_outstanding[7:4];
        field {
            name = "reserved";
            desc = "Reserved";
            sw = r; hw = w;
            reset = 0x0;
        } reserved_3_0[3:0];
    } AXI_CFG @ 0x10;
    reg {
        name = "MAC_CFG";
        desc = "MAC_CFG is a MAC priority configuration register. (offset 0x14; total reset 0x00000000; PROVEN: Hi3521A/Hi3520D V300 data sheet (Issue 00B07, 2015-12-10), section 10.1.6, PDF page 1181).";
        field {
            name = "ch15_c_pro";
            desc = "Chrominance priority of channel 15. The value 0 indicates the highest priority.";
            sw = rw; hw = r;
            reset = 0x0;
        } ch15_c_pro[31:31];
        field {
            name = "ch15_y_pro";
            desc = "Luminance priority of channel 15. The value 0 indicates the highest priority.";
            sw = rw; hw = r;
            reset = 0x0;
        } ch15_y_pro[30:30];
        field {
            name = "ch14_c_pro";
            desc = "Chrominance priority of channel 14. The value 0 indicates the highest priority.";
            sw = rw; hw = r;
            reset = 0x0;
        } ch14_c_pro[29:29];
        field {
            name = "ch14_y_pro";
            desc = "Luminance priority of channel 14. The value 0 indicates the highest priority.";
            sw = rw; hw = r;
            reset = 0x0;
        } ch14_y_pro[28:28];
        field {
            name = "ch13_c_pro";
            desc = "Chrominance priority of channel 13. The value 0 indicates the highest priority.";
            sw = rw; hw = r;
            reset = 0x0;
        } ch13_c_pro[27:27];
        field {
            name = "ch13_y_pro";
            desc = "Luminance priority of channel 13. The value 0 indicates the highest priority.";
            sw = rw; hw = r;
            reset = 0x0;
        } ch13_y_pro[26:26];
        field {
            name = "ch12_c_pro";
            desc = "Chrominance priority of channel 12. The value 0 indicates the highest priority.";
            sw = rw; hw = r;
            reset = 0x0;
        } ch12_c_pro[25:25];
        field {
            name = "ch12_y_pro";
            desc = "Luminance priority of channel 12. The value 0 indicates the highest priority.";
            sw = rw; hw = r;
            reset = 0x0;
        } ch12_y_pro[24:24];
        field {
            name = "ch11_c_pro";
            desc = "Chrominance priority of channel 11. The value 0 indicates the highest priority.";
            sw = rw; hw = r;
            reset = 0x0;
        } ch11_c_pro[23:23];
        field {
            name = "ch11_y_pro";
            desc = "Luminance priority of channel 11. The value 0 indicates the highest priority.";
            sw = rw; hw = r;
            reset = 0x0;
        } ch11_y_pro[22:22];
        field {
            name = "ch10_c_pro";
            desc = "Chrominance priority of channel 10. The value 0 indicates the highest priority.";
            sw = rw; hw = r;
            reset = 0x0;
        } ch10_c_pro[21:21];
        field {
            name = "ch10_y_pro";
            desc = "Luminance priority of channel 10. The value 0 indicates the highest priority.";
            sw = rw; hw = r;
            reset = 0x0;
        } ch10_y_pro[20:20];
        field {
            name = "ch9_c_pro";
            desc = "Chrominance priority of channel 9. The value 0 indicates the highest priority.";
            sw = rw; hw = r;
            reset = 0x0;
        } ch9_c_pro[19:19];
        field {
            name = "ch9_y_pro";
            desc = "Luminance priority of channel 9. The value 0 indicates the highest priority.";
            sw = rw; hw = r;
            reset = 0x0;
        } ch9_y_pro[18:18];
        field {
            name = "ch8_c_pro";
            desc = "Chrominance priority of channel 8. The value 0 indicates the highest priority.";
            sw = rw; hw = r;
            reset = 0x0;
        } ch8_c_pro[17:17];
        field {
            name = "ch8_y_pro";
            desc = "Luminance priority of channel 8. The value 0 indicates the highest priority.";
            sw = rw; hw = r;
            reset = 0x0;
        } ch8_y_pro[16:16];
        field {
            name = "ch7_c_pro";
            desc = "Chrominance priority of channel 7. The value 0 indicates the highest priority.";
            sw = rw; hw = r;
            reset = 0x0;
        } ch7_c_pro[15:15];
        field {
            name = "ch7_y_pro";
            desc = "Luminance priority of channel 7. The value 0 indicates the highest priority.";
            sw = rw; hw = r;
            reset = 0x0;
        } ch7_y_pro[14:14];
        field {
            name = "ch6_c_pro";
            desc = "Chrominance priority of channel 6. The value 0 indicates the highest priority.";
            sw = rw; hw = r;
            reset = 0x0;
        } ch6_c_pro[13:13];
        field {
            name = "ch6_y_pro";
            desc = "Luminance priority of channel 6. The value 0 indicates the highest priority.";
            sw = rw; hw = r;
            reset = 0x0;
        } ch6_y_pro[12:12];
        field {
            name = "ch5_c_pro";
            desc = "Chrominance priority of channel 5. The value 0 indicates the highest priority.";
            sw = rw; hw = r;
            reset = 0x0;
        } ch5_c_pro[11:11];
        field {
            name = "ch5_y_pro";
            desc = "Luminance priority of channel 5. The value 0 indicates the highest priority.";
            sw = rw; hw = r;
            reset = 0x0;
        } ch5_y_pro[10:10];
        field {
            name = "ch4_c_pro";
            desc = "Chrominance priority of channel 4. The value 0 indicates the highest priority.";
            sw = rw; hw = r;
            reset = 0x0;
        } ch4_c_pro[9:9];
        field {
            name = "ch4_y_pro";
            desc = "Luminance priority of channel 4. The value 0 indicates the highest priority.";
            sw = rw; hw = r;
            reset = 0x0;
        } ch4_y_pro[8:8];
        field {
            name = "ch3_c_pro";
            desc = "Chrominance priority of channel 3. The value 0 indicates the highest priority.";
            sw = rw; hw = r;
            reset = 0x0;
        } ch3_c_pro[7:7];
        field {
            name = "ch3_y_pro";
            desc = "Luminance priority of channel 3. The value 0 indicates the highest priority.";
            sw = rw; hw = r;
            reset = 0x0;
        } ch3_y_pro[6:6];
        field {
            name = "ch2_c_pro";
            desc = "Chrominance priority of channel 2. The value 0 indicates the highest priority.";
            sw = rw; hw = r;
            reset = 0x0;
        } ch2_c_pro[5:5];
        field {
            name = "ch2_y_pro";
            desc = "Luminance priority of channel 2. The value 0 indicates the highest priority.";
            sw = rw; hw = r;
            reset = 0x0;
        } ch2_y_pro[4:4];
        field {
            name = "ch1_c_pro";
            desc = "Chrominance priority of channel 1. The value 0 indicates the highest priority.";
            sw = rw; hw = r;
            reset = 0x0;
        } ch1_c_pro[3:3];
        field {
            name = "ch1_y_pro";
            desc = "Luminance priority of channel 1. The value 0 indicates the highest priority.";
            sw = rw; hw = r;
            reset = 0x0;
        } ch1_y_pro[2:2];
        field {
            name = "ch0_c_pro";
            desc = "Chrominance priority of channel 0. The value 0 indicates the highest priority.";
            sw = rw; hw = r;
            reset = 0x0;
        } ch0_c_pro[1:1];
        field {
            name = "ch0_y_pro";
            desc = "Luminance priority of channel 0. The value 0 indicates the highest priority.";
            sw = rw; hw = r;
            reset = 0x0;
        } ch0_y_pro[0:0];
    } MAC_CFG @ 0x14;
    reg {
        name = "CPC_SEL0";
        desc = "CPC_SEL0 is channel port select register 0. (offset 0x20; total reset 0x00000000; PROVEN: Hi3521A/Hi3520D V300 data sheet (Issue 00B07, 2015-12-10), section 10.1.6, PDF page 1183).";
        field {
            name = "reserved";
            desc = "Reserved";
            sw = r; hw = w;
            reset = 0x0;
        } reserved_31_31[31:31];
        field {
            name = "ch7_sel";
            desc = "Channel 7 port select
- 000: port 0 data with the ID of 0
- 001: port 0 data with the ID of 1
- 010: port 0 data with the ID of 2
- 011: port 0 data with the ID of 3
- 100: port 1 data with the ID of 0
- 101: port 1 data with the ID of 1
- 110: port 1 data with the ID of 2
- 111: port 1 data with the ID of 3";
            sw = rw; hw = r;
            reset = 0x0;
        } ch7_sel[30:28];
        field {
            name = "reserved";
            desc = "Reserved";
            sw = r; hw = w;
            reset = 0x0;
        } reserved_27_27[27:27];
        field {
            name = "ch6_sel";
            desc = "Channel 6 port select
- 000: port 0 data with the ID of 0
- 001: port 0 data with the ID of 1
- 010: port 0 data with the ID of 2
- 011: port 0 data with the ID of 3
- 100: port 1 data with the ID of 0
- 101: port 1 data with the ID of 1
- 110: port 1 data with the ID of 2
- 111: port 1 data with the ID of 3";
            sw = rw; hw = r;
            reset = 0x0;
        } ch6_sel[26:24];
        field {
            name = "reserved";
            desc = "Reserved";
            sw = r; hw = w;
            reset = 0x0;
        } reserved_23_23[23:23];
        field {
            name = "ch5_sel";
            desc = "Channel 5 port select
- 000: port 0 data with the ID of 0
- 001: port 0 data with the ID of 1
- 010: port 0 data with the ID of 2
- 011: port 0 data with the ID of 3
- 100: port 1 data with the ID of 0
- 101: port 1 data with the ID of 1
- 110: port 1 data with the ID of 2
- 111: port 1 data with the ID of 3";
            sw = rw; hw = r;
            reset = 0x0;
        } ch5_sel[22:20];
        field {
            name = "reserved";
            desc = "Reserved";
            sw = r; hw = w;
            reset = 0x0;
        } reserved_19_19[19:19];
        field {
            name = "ch4_sel";
            desc = "Channel 4 port select
- 000: port 0 data with the ID of 0
- 001: port 0 data with the ID of 1
- 010: port 0 data with the ID of 2
- 011: port 0 data with the ID of 3
- 100: port 1 data with the ID of 0
- 101: port 1 data with the ID of 1
- 110: port 1 data with the ID of 2
- 111: port 1 data with the ID of 3";
            sw = rw; hw = r;
            reset = 0x0;
        } ch4_sel[18:16];
        field {
            name = "reserved";
            desc = "Reserved";
            sw = r; hw = w;
            reset = 0x0;
        } reserved_15_15[15:15];
        field {
            name = "ch3_sel";
            desc = "Channel 3 port select
- 000: port 0 data with the ID of 0
- 001: port 0 data with the ID of 1
- 010: port 0 data with the ID of 2
- 011: port 0 data with the ID of 3
- 100: port 1 data with the ID of 0
- 101: port 1 data with the ID of 1
- 110: port 1 data with the ID of 2
- 111: port 1 data with the ID of 3";
            sw = rw; hw = r;
            reset = 0x0;
        } ch3_sel[14:12];
        field {
            name = "reserved";
            desc = "Reserved";
            sw = r; hw = w;
            reset = 0x0;
        } reserved_11_11[11:11];
        field {
            name = "ch2_sel";
            desc = "Channel 2 port select
- 000: port 0 data with the ID of 0
- 001: port 0 data with the ID of 1
- 010: port 0 data with the ID of 2
- 011: port 0 data with the ID of 3
- 100: port 1 data with the ID of 0
- 101: port 1 data with the ID of 1
- 110: port 1 data with the ID of 2
- 111: port 1 data with the ID of 3";
            sw = rw; hw = r;
            reset = 0x0;
        } ch2_sel[10:8];
        field {
            name = "reserved";
            desc = "Reserved";
            sw = r; hw = w;
            reset = 0x0;
        } reserved_7_7[7:7];
        field {
            name = "ch1_sel";
            desc = "Channel 1 port select
- 000: port 0 data with the ID of 0
- 001: port 0 data with the ID of 1
- 010: port 0 data with the ID of 2
- 011: port 0 data with the ID of 3
- 100: port 1 data with the ID of 0
- 101: port 1 data with the ID of 1
- 110: port 1 data with the ID of 2
- 111: port 1 data with the ID of 3";
            sw = rw; hw = r;
            reset = 0x0;
        } ch1_sel[6:4];
        field {
            name = "reserved";
            desc = "Reserved";
            sw = r; hw = w;
            reset = 0x0;
        } reserved_3_3[3:3];
        field {
            name = "ch0_sel";
            desc = "Channel 0 port select
- 000: port 0 data with the ID of 0
- 001: port 0 data with the ID of 1
- 010: port 0 data with the ID of 2
- 011: port 0 data with the ID of 3
- 100: port 1 data with the ID of 0
- 101: port 1 data with the ID of 1
- 110: port 1 data with the ID of 2
- 111: port 1 data with the ID of 3";
            sw = rw; hw = r;
            reset = 0x0;
        } ch0_sel[2:0];
    } CPC_SEL0 @ 0x20;
    reg {
        name = "CPC_SEL1";
        desc = "CPC_SEL1 is channel port select register 1. (offset 0x24; total reset 0x00000000; PROVEN: Hi3521A/Hi3520D V300 data sheet (Issue 00B07, 2015-12-10), section 10.1.6, PDF page 1186).";
        field {
            name = "reserved";
            desc = "Reserved";
            sw = r; hw = w;
            reset = 0x0;
        } reserved_31_31[31:31];
        field {
            name = "ch15_sel";
            desc = "Channel 15 port select
- 000: port 2 data with the ID of 0
- 001: port 2 data with the ID of 1
- 010: port 2 data with the ID of 2
- 011: port 2 data with the ID of 3
- 100: port 3 data with the ID of 0
- 101: port 3 data with the ID of 1
- 110: port 3 data with the ID of 2
- 111: port 3 data with the ID of 3";
            sw = rw; hw = r;
            reset = 0x0;
        } ch15_sel[30:28];
        field {
            name = "reserved";
            desc = "Reserved";
            sw = r; hw = w;
            reset = 0x0;
        } reserved_27_27[27:27];
        field {
            name = "ch14_sel";
            desc = "Channel 14 port select
- 000: port 2 data with the ID of 0
- 001: port 2 data with the ID of 1
- 010: port 2 data with the ID of 2
- 011: port 2 data with the ID of 3
- 100: port 3 data with the ID of 0
- 101: port 3 data with the ID of 1
- 110: port 3 data with the ID of 2
- 111: port 3 data with the ID of 3";
            sw = rw; hw = r;
            reset = 0x0;
        } ch14_sel[26:24];
        field {
            name = "reserved";
            desc = "Reserved";
            sw = r; hw = w;
            reset = 0x0;
        } reserved_23_23[23:23];
        field {
            name = "ch13_sel";
            desc = "Channel 13 port select
- 000: port 2 data with the ID of 0
- 001: port 2 data with the ID of 1
- 010: port 2 data with the ID of 2
- 011: port 2 data with the ID of 3
- 100: port 3 data with the ID of 0
- 101: port 3 data with the ID of 1
- 110: port 3 data with the ID of 2
- 111: port 3 data with the ID of 3";
            sw = rw; hw = r;
            reset = 0x0;
        } ch13_sel[22:20];
        field {
            name = "reserved";
            desc = "Reserved";
            sw = r; hw = w;
            reset = 0x0;
        } reserved_19_19[19:19];
        field {
            name = "ch12_sel";
            desc = "Channel 12 port select
- 000: port 2 data with the ID of 0
- 001: port 2 data with the ID of 1
- 010: port 2 data with the ID of 2
- 011: port 2 data with the ID of 3
- 100: port 3 data with the ID of 0
- 101: port 3 data with the ID of 1
- 110: port 3 data with the ID of 2
- 111: port 3 data with the ID of 3";
            sw = rw; hw = r;
            reset = 0x0;
        } ch12_sel[18:16];
        field {
            name = "reserved";
            desc = "Reserved";
            sw = r; hw = w;
            reset = 0x0;
        } reserved_15_15[15:15];
        field {
            name = "ch11_sel";
            desc = "Channel 11 port select
- 000: port 2 data with the ID of 0
- 001: port 2 data with the ID of 1
- 010: port 2 data with the ID of 2
- 011: port 2 data with the ID of 3
- 100: port 3 data with the ID of 0
- 101: port 3 data with the ID of 1
- 110: port 3 data with the ID of 2
- 111: port 3 data with the ID of 3";
            sw = rw; hw = r;
            reset = 0x0;
        } ch11_sel[14:12];
        field {
            name = "reserved";
            desc = "Reserved";
            sw = r; hw = w;
            reset = 0x0;
        } reserved_11_11[11:11];
        field {
            name = "ch10_sel";
            desc = "Channel 10 port select
- 000: port 2 data with the ID of 0
- 001: port 2 data with the ID of 1
- 010: port 2 data with the ID of 2
- 011: port 2 data with the ID of 3
- 100: port 3 data with the ID of 0
- 101: port 3 data with the ID of 1
- 110: port 3 data with the ID of 2
- 111: port 3 data with the ID of 3";
            sw = rw; hw = r;
            reset = 0x0;
        } ch10_sel[10:8];
        field {
            name = "reserved";
            desc = "Reserved";
            sw = r; hw = w;
            reset = 0x0;
        } reserved_7_7[7:7];
        field {
            name = "ch9_sel";
            desc = "Channel 9 port select
- 000: port 2 data with the ID of 0
- 001: port 2 data with the ID of 1
- 010: port 2 data with the ID of 2
- 011: port 2 data with the ID of 3
- 100: port 3 data with the ID of 0
- 101: port 3 data with the ID of 1
- 110: port 3 data with the ID of 2
- 111: port 3 data with the ID of 3";
            sw = rw; hw = r;
            reset = 0x0;
        } ch9_sel[6:4];
        field {
            name = "reserved";
            desc = "Reserved";
            sw = r; hw = w;
            reset = 0x0;
        } reserved_3_3[3:3];
        field {
            name = "ch8_sel";
            desc = "Channel 8 port select
- 000: port 2 data with the ID of 0
- 001: port 2 data with the ID of 1
- 010: port 2 data with the ID of 2
- 011: port 2 data with the ID of 3
- 100: port 3 data with the ID of 0
- 101: port 3 data with the ID of 1
- 110: port 3 data with the ID of 2
- 111: port 3 data with the ID of 3";
            sw = rw; hw = r;
            reset = 0x0;
        } ch8_sel[2:0];
    } CPC_SEL1 @ 0x24;
    reg {
        name = "CH_RST_REQ";
        desc = "CH_RST_REQ is a channel soft reset request register. (offset 0x60; total reset 0x00000000; PROVEN: Hi3521A/Hi3520D V300 data sheet (Issue 00B07, 2015-12-10), section 10.1.6, PDF page 1188).";
        field {
            name = "reserved";
            desc = "Reserved";
            sw = r; hw = w;
            reset = 0x0;
        } reserved_31_16[31:16];
        field {
            name = "ch15_srst_req";
            desc = "Soft reset request of channel 15
- 0: deassert soft reset
- 1: enable soft reset";
            sw = rw; hw = r;
            reset = 0x0;
        } ch15_srst_req[15:15];
        field {
            name = "ch14_srst_req";
            desc = "Soft reset request of channel 14
- 0: deassert soft reset
- 1: enable soft reset";
            sw = rw; hw = r;
            reset = 0x0;
        } ch14_srst_req[14:14];
        field {
            name = "ch13_srst_req";
            desc = "Soft reset request of channel 13
- 0: deassert soft reset
- 1: enable soft reset";
            sw = rw; hw = r;
            reset = 0x0;
        } ch13_srst_req[13:13];
        field {
            name = "ch12_srst_req";
            desc = "Soft reset request of channel 12
- 0: deassert soft reset
- 1: enable soft reset";
            sw = rw; hw = r;
            reset = 0x0;
        } ch12_srst_req[12:12];
        field {
            name = "ch11_srst_req";
            desc = "Soft reset request of channel 11
- 0: deassert soft reset
- 1: enable soft reset";
            sw = rw; hw = r;
            reset = 0x0;
        } ch11_srst_req[11:11];
        field {
            name = "ch10_srst_req";
            desc = "Soft reset request of channel 10
- 0: deassert soft reset
- 1: enable soft reset";
            sw = rw; hw = r;
            reset = 0x0;
        } ch10_srst_req[10:10];
        field {
            name = "ch8_srst_req";
            desc = "Soft reset request of channel 9
- 0: deassert soft reset
- 1: enable soft reset";
            sw = rw; hw = r;
            reset = 0x0;
        } ch8_srst_req[9:9];
        field {
            name = "ch8_srst_req";
            desc = "Soft reset request of channel 8
- 0: deassert soft reset
- 1: enable soft reset";
            sw = rw; hw = r;
            reset = 0x0;
        } ch8_srst_req_8_8[8:8];
        field {
            name = "ch7_srst_req";
            desc = "Soft reset request of channel 7
- 0: deassert soft reset
- 1: enable soft reset";
            sw = rw; hw = r;
            reset = 0x0;
        } ch7_srst_req[7:7];
        field {
            name = "ch6_srst_req";
            desc = "Soft reset request of channel 6
- 0: deassert soft reset
- 1: enable soft reset";
            sw = rw; hw = r;
            reset = 0x0;
        } ch6_srst_req[6:6];
        field {
            name = "ch5_srst_req";
            desc = "Soft reset request of channel 5
- 0: deassert soft reset
- 1: enable soft reset";
            sw = rw; hw = r;
            reset = 0x0;
        } ch5_srst_req[5:5];
        field {
            name = "ch4_srst_req";
            desc = "Soft reset request of channel 4
- 0: deassert soft reset
- 1: enable soft reset";
            sw = rw; hw = r;
            reset = 0x0;
        } ch4_srst_req[4:4];
        field {
            name = "ch3_srst_req";
            desc = "Soft reset request of channel 3
- 0: deassert soft reset
- 1: enable soft reset";
            sw = rw; hw = r;
            reset = 0x0;
        } ch3_srst_req[3:3];
        field {
            name = "ch2_srst_req";
            desc = "Soft reset request of channel 2
- 0: deassert soft reset
- 1: enable soft reset";
            sw = rw; hw = r;
            reset = 0x0;
        } ch2_srst_req[2:2];
        field {
            name = "ch1_srst_req";
            desc = "Soft reset request of channel 1
- 0: deassert soft reset
- 1: enable soft reset";
            sw = rw; hw = r;
            reset = 0x0;
        } ch1_srst_req[1:1];
        field {
            name = "ch0_srst_req";
            desc = "Soft reset request of channel 0
- 0: deassert soft reset
- 1: enable soft reset";
            sw = rw; hw = r;
            reset = 0x0;
        } ch0_srst_req[0:0];
    } CH_RST_REQ @ 0x60;
    reg {
        name = "APB_TIMEOUT";
        desc = "APB_TIMEOUT is an APB timeout register. (offset 0xE0; total reset 0x80000100; PROVEN: Hi3521A/Hi3520D V300 data sheet (Issue 00B07, 2015-12-10), section 10.1.6, PDF page 1190).";
        field {
            name = "enable";
            desc = "Timeout enable
- 0: disabled
- 1: enabled";
            sw = rw; hw = r;
            reset = 0x1;
        } enable[31:31];
        field {
            name = "reserved";
            desc = "Reserved";
            sw = r; hw = w;
            reset = 0x0;
        } reserved_30_16[30:16];
        field {
            name = "timeout";
            desc = "Timeout threshold (in APB clock)";
            sw = rw; hw = r;
            reset = 0x100;
        } timeout[15:0];
    } APB_TIMEOUT @ 0xE0;
    reg {
        name = "VICAP_INT";
        desc = "VICAP_INT is an interrupt indicator register. (offset 0xF0; total reset 0x00000000; PROVEN: Hi3521A/Hi3520D V300 data sheet (Issue 00B07, 2015-12-10), section 10.1.6, PDF page 1191).";
        field {
            name = "reserved";
            desc = "Reserved";
            sw = r; hw = w;
            reset = 0x0;
        } reserved_31_16[31:16];
        field {
            name = "int_ch15";
            desc = "Interrupt indicator of channel 15
- 0: No interrupt is generated.
- 1: An interrupt is generated.";
            sw = r; hw = w;
            reset = 0x0;
        } int_ch15[15:15];
        field {
            name = "int_ch14";
            desc = "Interrupt indicator of channel 14
- 0: No interrupt is generated.
- 1: An interrupt is generated.";
            sw = r; hw = w;
            reset = 0x0;
        } int_ch14[14:14];
        field {
            name = "int_ch13";
            desc = "Interrupt indicator of channel 13
- 0: No interrupt is generated.
- 1: An interrupt is generated.";
            sw = r; hw = w;
            reset = 0x0;
        } int_ch13[13:13];
        field {
            name = "int_ch12";
            desc = "Interrupt indicator of channel 12
- 0: No interrupt is generated.
- 1: An interrupt is generated.";
            sw = r; hw = w;
            reset = 0x0;
        } int_ch12[12:12];
        field {
            name = "int_ch11";
            desc = "Interrupt indicator of channel 11
- 0: No interrupt is generated.
- 1: An interrupt is generated.";
            sw = r; hw = w;
            reset = 0x0;
        } int_ch11[11:11];
        field {
            name = "int_ch10";
            desc = "Interrupt indicator of channel 10
- 0: No interrupt is generated.
- 1: An interrupt is generated.";
            sw = r; hw = w;
            reset = 0x0;
        } int_ch10[10:10];
        field {
            name = "int_ch9";
            desc = "Interrupt indicator of channel 9
- 0: No interrupt is generated.
- 1: An interrupt is generated.";
            sw = r; hw = w;
            reset = 0x0;
        } int_ch9[9:9];
        field {
            name = "int_ch8";
            desc = "Interrupt indicator of channel 8
- 0: No interrupt is generated.
- 1: An interrupt is generated.";
            sw = r; hw = w;
            reset = 0x0;
        } int_ch8[8:8];
        field {
            name = "int_ch7";
            desc = "Interrupt indicator of channel 7
- 0: No interrupt is generated.
- 1: An interrupt is generated.";
            sw = r; hw = w;
            reset = 0x0;
        } int_ch7[7:7];
        field {
            name = "int_ch6";
            desc = "Interrupt indicator of channel 6
- 0: No interrupt is generated.
- 1: An interrupt is generated.";
            sw = r; hw = w;
            reset = 0x0;
        } int_ch6[6:6];
        field {
            name = "int_ch5";
            desc = "Interrupt indicator of channel 5
- 0: No interrupt is generated.
- 1: An interrupt is generated.";
            sw = r; hw = w;
            reset = 0x0;
        } int_ch5[5:5];
        field {
            name = "int_ch4";
            desc = "Interrupt indicator of channel 4
- 0: No interrupt is generated.
- 1: An interrupt is generated.";
            sw = r; hw = w;
            reset = 0x0;
        } int_ch4[4:4];
        field {
            name = "int_ch3";
            desc = "Interrupt indicator of channel 3
- 0: No interrupt is generated.
- 1: An interrupt is generated.";
            sw = r; hw = w;
            reset = 0x0;
        } int_ch3[3:3];
        field {
            name = "int_ch2";
            desc = "Interrupt indicator of channel 2
- 0: No interrupt is generated.
- 1: An interrupt is generated.";
            sw = r; hw = w;
            reset = 0x0;
        } int_ch2[2:2];
        field {
            name = "int_ch1";
            desc = "Interrupt indicator of channel 1
- 0: No interrupt is generated.
- 1: An interrupt is generated.";
            sw = r; hw = w;
            reset = 0x0;
        } int_ch1[1:1];
        field {
            name = "int_ch0";
            desc = "Interrupt indicator of channel 0
- 0: No interrupt is generated.
- 1: An interrupt is generated.";
            sw = r; hw = w;
            reset = 0x0;
        } int_ch0[0:0];
    } VICAP_INT @ 0xF0;
    reg {
        name = "VICAP_INT_MASK";
        desc = "VICAP_INT_MASK is an interrupt enable register. (offset 0xF8; total reset 0x00000000; PROVEN: Hi3521A/Hi3520D V300 data sheet (Issue 00B07, 2015-12-10), section 10.1.6, PDF page 1192).";
        field {
            name = "reserved";
            desc = "Reserved";
            sw = r; hw = w;
            reset = 0x0;
        } reserved_31_16[31:16];
        field {
            name = "int_ch15";
            desc = "Channel 15 interrupt enable
- 0: masked
- 1: enabled";
            sw = rw; hw = r;
            reset = 0x0;
        } int_ch15[15:15];
        field {
            name = "int_ch14";
            desc = "Channel 14 interrupt enable
- 0: masked
- 1: enabled";
            sw = rw; hw = r;
            reset = 0x0;
        } int_ch14[14:14];
        field {
            name = "int_ch13";
            desc = "Channel 13 interrupt enable
- 0: masked
- 1: enabled";
            sw = rw; hw = r;
            reset = 0x0;
        } int_ch13[13:13];
        field {
            name = "int_ch12";
            desc = "Channel 12 interrupt enable
- 0: masked
- 1: enabled";
            sw = rw; hw = r;
            reset = 0x0;
        } int_ch12[12:12];
        field {
            name = "int_ch11";
            desc = "Channel 11 interrupt enable
- 0: masked
- 1: enabled";
            sw = rw; hw = r;
            reset = 0x0;
        } int_ch11[11:11];
        field {
            name = "int_ch10";
            desc = "Channel 10 interrupt enable
- 0: masked
- 1: enabled";
            sw = rw; hw = r;
            reset = 0x0;
        } int_ch10[10:10];
        field {
            name = "int_ch9";
            desc = "Channel 9 interrupt enable
- 0: masked
- 1: enabled";
            sw = rw; hw = r;
            reset = 0x0;
        } int_ch9[9:9];
        field {
            name = "int_ch8";
            desc = "Channel 8 interrupt enable
- 0: masked
- 1: enabled";
            sw = rw; hw = r;
            reset = 0x0;
        } int_ch8[8:8];
        field {
            name = "int_ch7";
            desc = "Channel 7 interrupt enable
- 0: masked
- 1: enabled";
            sw = rw; hw = r;
            reset = 0x0;
        } int_ch7[7:7];
        field {
            name = "int_ch6";
            desc = "Channel 6 interrupt enable
- 0: masked
- 1: enabled";
            sw = rw; hw = r;
            reset = 0x0;
        } int_ch6[6:6];
        field {
            name = "int_ch5";
            desc = "Channel 5 interrupt enable
- 0: masked
- 1: enabled";
            sw = rw; hw = r;
            reset = 0x0;
        } int_ch5[5:5];
        field {
            name = "int_ch4";
            desc = "Channel 4 interrupt enable
- 0: masked
- 1: enabled";
            sw = rw; hw = r;
            reset = 0x0;
        } int_ch4[4:4];
        field {
            name = "int_ch3";
            desc = "Channel 3 interrupt enable
- 0: masked
- 1: enabled";
            sw = rw; hw = r;
            reset = 0x0;
        } int_ch3[3:3];
        field {
            name = "int_ch2";
            desc = "Channel 2 interrupt enable
- 0: masked
- 1: enabled";
            sw = rw; hw = r;
            reset = 0x0;
        } int_ch2[2:2];
        field {
            name = "int_ch1";
            desc = "Channel 1 interrupt enable
- 0: masked
- 1: enabled";
            sw = rw; hw = r;
            reset = 0x0;
        } int_ch1[1:1];
        field {
            name = "int_ch0";
            desc = "Channel 0 interrupt enable
- 0: masked
- 1: enabled";
            sw = rw; hw = r;
            reset = 0x0;
        } int_ch0[0:0];
    } VICAP_INT_MASK @ 0xF8;
    reg {
        name = "PT_INTF_MOD";
        desc = "PT_INTF_MOD is an interface mode register. (offset 0x10000; total reset 0x00000000; PROVEN: Hi3521A/Hi3520D V300 data sheet (Issue 00B07, 2015-12-10), section 10.1.6, PDF page 1194).";
        field {
            name = "enable";
            desc = "Port register. Four ports are supported. 0x10000-0x100FF: offset addresses of port 0 0x18000-0x180FF: offset addresses of port 1 0x20000-0x200FF: offset addresses of port 2 0x28000-0x280FF: offset addresses of port 3 In the following register description, only the offset addresses of port 0 are provided. The register descriptions of other ports are similar. Port enable
- 0: disabled
- 1: enabled";
            sw = rw; hw = r;
            reset = 0x0;
        } enable[31:31];
        field {
            name = "reserved";
            desc = "Reserved";
            sw = r; hw = w;
            reset = 0x0;
        } reserved_30_25[30:25];
        field {
            name = "interleave_seq";
            desc = "Y/C sequence during interleaving
- 0: The C component is before the Y component.
- 1: The Y component is before the C component.";
            sw = rw; hw = r;
            reset = 0x0;
        } interleave_seq[24:24];
        field {
            name = "ch3_id_en";
            desc = "Channel 3 ID enable
- 0: The channel ID is not checked.
- 1: The data channel is selected based on the channel ID.";
            sw = rw; hw = r;
            reset = 0x0;
        } ch3_id_en[23:23];
        field {
            name = "ch2_id_en";
            desc = "Channel 2 ID enable
- 0: The channel ID is not checked.
- 1: The data channel is selected based on the channel ID.";
            sw = rw; hw = r;
            reset = 0x0;
        } ch2_id_en[22:22];
        field {
            name = "ch1_id_en";
            desc = "Channel 1 ID enable
- 0: The channel ID is not checked.
- 1: The data channel is selected based on the channel ID.";
            sw = rw; hw = r;
            reset = 0x0;
        } ch1_id_en[21:21];
        field {
            name = "ch0_id_en";
            desc = "Channel 0 ID enable
- 0: The channel ID is not checked.
- 1: The data channel is selected based on the channel ID.";
            sw = rw; hw = r;
            reset = 0x0;
        } ch0_id_en[20:20];
        field {
            name = "reserved";
            desc = "Reserved";
            sw = rw; hw = r;
            reset = 0x0;
        } reserved_19_10[19:10];
        field {
            name = "port_mux_mode";
            desc = "Multiplexed timing mode
- 0: non-multiplexed mode
- 1: 2-channel BT.656 multiplexed mode
- 2: 4-channel BT.656 multiplexed mode
- 3: BT.1120 Y/C interleaved mode";
            sw = rw; hw = r;
            reset = 0x0;
        } port_mux_mode[9:8];
        field {
            name = "reserved";
            desc = "Reserved";
            sw = r; hw = w;
            reset = 0x0;
        } reserved_7_0[7:0];
    } PT_INTF_MOD @ 0x10000;
    reg {
        name = "PT_INTF_OFFSET";
        desc = "PT_INTF_OFFSET is an interface offset register. (offset 0x10010; total reset 0xFFFF0000; PROVEN: Hi3521A/Hi3520D V300 data sheet (Issue 00B07, 2015-12-10), section 10.1.6, PDF page 1195).";
        field {
            name = "mask";
            desc = "Component 0 mask";
            sw = rw; hw = r;
            reset = 0xffff;
        } mask[31:16];
        field {
            name = "rev";
            desc = "Whether the data line is reversed
- 0: The data line is not reversed.
- 1: The data line is reversed.";
            sw = rw; hw = r;
            reset = 0x0;
        } rev[15:15];
        field {
            name = "reserved";
            desc = "Reserved";
            sw = r; hw = w;
            reset = 0x0;
        } reserved_14_6[14:6];
        field {
            name = "offset";
            desc = "Component 0 offset";
            sw = rw; hw = r;
            reset = 0x0;
        } offset[5:0];
    } PT_INTF_OFFSET @ 0x10010;
    reg {
        name = "PT_ID_STATUS";
        desc = "PT_ID_STATUS is an interface ID status register. (offset 0x10050; total reset 0x00000000; PROVEN: Hi3521A/Hi3520D V300 data sheet (Issue 00B07, 2015-12-10), section 10.1.6, PDF page 1196).";
        field {
            name = "reserved";
            desc = "Reserved";
            sw = r; hw = w;
            reset = 0x0;
        } reserved_31_4[31:4];
        field {
            name = "id3";
            desc = "Data with the ID of 3 is detected in channel 3.";
            sw = r; hw = w;
            reset = 0x0;
        } id3[3:3];
        field {
            name = "id2";
            desc = "Data with the ID of 2 is detected in channel 2.";
            sw = r; hw = w;
            reset = 0x0;
        } id2[2:2];
        field {
            name = "id1";
            desc = "Data with the ID of 1 is detected in channel 1.";
            sw = r; hw = w;
            reset = 0x0;
        } id1[1:1];
        field {
            name = "id0";
            desc = "Data with the ID of 0 is detected in channel 0.";
            sw = r; hw = w;
            reset = 0x0;
        } id0[0:0];
    } PT_ID_STATUS @ 0x10050;
    reg {
        name = "CH_IPI_INTF_MOD";
        desc = "CH_IPI_INTF_MOD is an interface mode register. (offset 0x10300; total reset 0x00000000; PROVEN: Hi3521A/Hi3520D V300 data sheet (Issue 00B07, 2015-12-10), section 10.1.6, PDF page 1197).";
        field {
            name = "enable";
            desc = "Channel. A maximum of 16 channels are supported. 0x10300-0x113FF: offset addresses of channel 0 0x12300-0x133FF: offset addresses of channel 1 0x14300-0x153FF: offset addresses of channel 2 0x16300-0x173FF: offset addresses of channel 3 0x18300-0x193FF: offset addresses of channel 4 0x1A300-0x1B3FF: offset addresses of channel 5 0x1C300-0x1D3FF: offset addresses of channel 6 0x1E300-0x1F3FF: offset addresses of channel 7 0x20300-0x213FF: offset addresses of channel 8 0x22300-0x233FF: offset addresses of channel 9 0x24300-0x253FF: offset addresses of channel 10 0x26300-0x273FF: offset addresses of channel 11 0x28300-0x293FF: offset addresses of channel 12 0x2a300-0x2b3FF: offset addresses of channel 13 0x2c300-0x2d3FF: offset addresses of channel 14 0x2e300-0x2f3FF: offset addresses of channel 15 Port enable
- 0: disabled
- 1: enabled";
            sw = rw; hw = r;
            reset = 0x0;
        } enable[31:31];
        field {
            name = "reserved";
            desc = "Reserved";
            sw = r; hw = w;
            reset = 0x0;
        } reserved_30_1[30:1];
        field {
            name = "mode";
            desc = "Timing mode
- 0: external synchronous mode
- 1: BT656 timing mode";
            sw = rw; hw = r;
            reset = 0x0;
        } mode[0:0];
    } CH_IPI_INTF_MOD @ 0x10300;
    reg {
        name = "CH_IPI_OFFSET0";
        desc = "CH_IPI_OFFSET0 is a component 0 offset register. (offset 0x10310; total reset 0xFF000000; PROVEN: Hi3521A/Hi3520D V300 data sheet (Issue 00B07, 2015-12-10), section 10.1.6, PDF page 1198).";
        field {
            name = "mask";
            desc = "Component 0 mask";
            sw = rw; hw = r;
            reset = 0xff00;
        } mask[31:16];
        field {
            name = "rev";
            desc = "Whether the data line is reversed
- 0: The data line is not reversed.
- 1: The data line is reversed.";
            sw = rw; hw = r;
            reset = 0x0;
        } rev[15:15];
        field {
            name = "reserved";
            desc = "Reserved";
            sw = r; hw = w;
            reset = 0x0;
        } reserved_14_6[14:6];
        field {
            name = "offset";
            desc = "Component 0 offset";
            sw = rw; hw = r;
            reset = 0x0;
        } offset[5:0];
    } CH_IPI_OFFSET0 @ 0x10310;
    reg {
        name = "CH_IPI_OFFSET1";
        desc = "CH_IPI_OFFSET1 is a component 1 offset register. (offset 0x10314; total reset 0xFF000008; PROVEN: Hi3521A/Hi3520D V300 data sheet (Issue 00B07, 2015-12-10), section 10.1.6, PDF page 1198).";
        field {
            name = "mask";
            desc = "Component 1 mask";
            sw = rw; hw = r;
            reset = 0xff00;
        } mask[31:16];
        field {
            name = "rev";
            desc = "Whether the data line is reversed
- 0: The data line is not reversed.
- 1: The data line is reversed.";
            sw = rw; hw = r;
            reset = 0x0;
        } rev[15:15];
        field {
            name = "reserved";
            desc = "Reserved";
            sw = r; hw = w;
            reset = 0x0;
        } reserved_14_6[14:6];
        field {
            name = "offset";
            desc = "Component 1 offset";
            sw = rw; hw = r;
            reset = 0x8;
        } offset[5:0];
    } CH_IPI_OFFSET1 @ 0x10314;
    reg {
        name = "CH_IPI_OFFSET2";
        desc = "CH_IPI_OFFSET2 is a component 2 offset register. (offset 0x10318; total reset 0xFF000010; PROVEN: Hi3521A/Hi3520D V300 data sheet (Issue 00B07, 2015-12-10), section 10.1.6, PDF page 1199).";
        field {
            name = "mask";
            desc = "Component 2 mask";
            sw = rw; hw = r;
            reset = 0xff00;
        } mask[31:16];
        field {
            name = "rev";
            desc = "Whether the data line is reversed
- 0: The data line is not reversed.
- 1: The data line is reversed.";
            sw = rw; hw = r;
            reset = 0x0;
        } rev[15:15];
        field {
            name = "reserved";
            desc = "Reserved";
            sw = r; hw = w;
            reset = 0x0;
        } reserved_14_6[14:6];
        field {
            name = "offset";
            desc = "Component 2 offset";
            sw = rw; hw = r;
            reset = 0x10;
        } offset[5:0];
    } CH_IPI_OFFSET2 @ 0x10318;
    reg {
        name = "CH_IPI_BT656_CFG";
        desc = "CH_IPI_BT656_CFG is a BT.656 configuration register. (offset 0x10320; total reset 0x00000303; PROVEN: Hi3521A/Hi3520D V300 data sheet (Issue 00B07, 2015-12-10), section 10.1.6, PDF page 1199).";
        field {
            name = "enable";
            desc = "BT.656 enable
- 0: disabled
- 1: enabled";
            sw = rw; hw = r;
            reset = 0x0;
        } enable[31:31];
        field {
            name = "reserved";
            desc = "Reserved";
            sw = r; hw = w;
            reset = 0x0;
        } reserved_30_11[30:11];
        field {
            name = "field_inv";
            desc = "Reverse control
- 0: not reversed
- 1: reversed";
            sw = rw; hw = r;
            reset = 0x0;
        } field_inv[10:10];
        field {
            name = "vsync_inv";
            desc = "vsync reverse control
- 0: not reversed
- 1: reversed";
            sw = rw; hw = r;
            reset = 0x1;
        } vsync_inv[9:9];
        field {
            name = "hsync_inv";
            desc = "hsync reverse control
- 0: not reversed
- 1: reversed";
            sw = rw; hw = r;
            reset = 0x1;
        } hsync_inv[8:8];
        field {
            name = "reserved";
            desc = "Reserved";
            sw = r; hw = w;
            reset = 0x0;
        } reserved_7_4[7:4];
        field {
            name = "mode";
            desc = "Mode select mode[0]
- 0: hsync is not an active signal.
- 1: hsync is an active signal. mode[1]
- 0: The hsync output is active low.
- 1: The hsync output is active high. mode[3:2]
- 00: Component 0 is parsed.
- 01: Component 1 is parsed.
- 10: Component 2 is parsed.
- 11: reserved";
            sw = rw; hw = r;
            reset = 0x3;
        } mode[3:0];
    } CH_IPI_BT656_CFG @ 0x10320;
    reg {
        name = "CH_IPI_UNIFY_TIMING_CFG";
        desc = "CH_IPI_UNIFY_TIMING_CFG is a timing configuration register. (offset 0x10330; total reset 0x00000000; PROVEN: Hi3521A/Hi3520D V300 data sheet (Issue 00B07, 2015-12-10), section 10.1.6, PDF page 1200).";
        field {
            name = "reserved";
            desc = "Reserved";
            sw = r; hw = w;
            reset = 0x0;
        } reserved_31_27[31:27];
        field {
            name = "field_inv";
            desc = "Field reverse (level-1 field processing)
- 0: not reversed
- 1: reversed";
            sw = rw; hw = r;
            reset = 0x0;
        } field_inv[26:26];
        field {
            name = "field_sel";
            desc = "Field source select (level-0 field processing)
- 00: input field
- 01: input vsync
- 10: detected based on the relationship between vsync and hsync
- 11: fixed at 0";
            sw = rw; hw = r;
            reset = 0x0;
        } field_sel[25:24];
        field {
            name = "reserved";
            desc = "Reserved";
            sw = r; hw = w;
            reset = 0x0;
        } reserved_23_21[23:21];
        field {
            name = "vsync_mode";
            desc = "Vsync processing mode (level-2 vsync processing)
- 00: not processed
- 01: detect the rising edge
- 10: detect the rising edge and falling edge
- 11: reserved";
            sw = rw; hw = r;
            reset = 0x0;
        } vsync_mode[20:19];
        field {
            name = "vsync_inv";
            desc = "vsync reverse (level-1 vsync processing)
- 0: not reversed
- 1: reversed";
            sw = rw; hw = r;
            reset = 0x0;
        } vsync_inv[18:18];
        field {
            name = "vsync_sel";
            desc = "vsync source select (level-0 vsync processing)
- 00: input vsync
- 01: input field
- 10: fixed at 0
- 11: reserved";
            sw = rw; hw = r;
            reset = 0x0;
        } vsync_sel[17:16];
        field {
            name = "reserved";
            desc = "Reserved";
            sw = r; hw = w;
            reset = 0x0;
        } reserved_15_15[15:15];
        field {
            name = "hsync_mode";
            desc = "hsync processing mode (level-3 hsync processing)
- 0: not processed
- 1: detect the rising edge";
            sw = rw; hw = r;
            reset = 0x0;
        } hsync_mode[14:13];
        field {
            name = "hsync_and";
            desc = "Whether hsync is operated with the result of level-1 vsync processing (level-2 hsync processing)
- 00: not processed
- 01: ANDed
- 10: exclusive ORed
- 11: reserved";
            sw = rw; hw = r;
            reset = 0x0;
        } hsync_and[12:11];
        field {
            name = "hsync_inv";
            desc = "hsync reverse (level-1 hsync processing)
- 0: not reversed
- 1: reversed";
            sw = rw; hw = r;
            reset = 0x0;
        } hsync_inv[10:10];
        field {
            name = "hsync_sel";
            desc = "hsync source select (level-1 hsync processing)
- 00: input hsync
- 01: input de
- 10: fixed at 0
- 11: reserved";
            sw = rw; hw = r;
            reset = 0x0;
        } hsync_sel[9:8];
        field {
            name = "reserved";
            desc = "Reserved";
            sw = r; hw = w;
            reset = 0x0;
        } reserved_7_3[7:3];
        field {
            name = "de_inv";
            desc = "de reverse (level-1 de processing)
- 0: not reversed
- 1: reversed";
            sw = rw; hw = r;
            reset = 0x0;
        } de_inv[2:2];
        field {
            name = "de_sel";
            desc = "de source select (level-0 de processing)
- 00: input de
- 01: result of level-2 hsync processing
- 10: fixed at 1
- 11: fixed at 0";
            sw = rw; hw = r;
            reset = 0x0;
        } de_sel[1:0];
    } CH_IPI_UNIFY_TIMING_CFG @ 0x10330;
    reg {
        name = "CH_IPI_GEN_TIMING_CFG";
        desc = "CH_IPI_GEN_TIMING_CFG is a timing recovery module configuration register. (offset 0x10334; total reset 0x00000000; PROVEN: Hi3521A/Hi3520D V300 data sheet (Issue 00B07, 2015-12-10), section 10.1.6, PDF page 1202).";
        field {
            name = "enable";
            desc = "Timing recovery enable (timings are recovered based on timing parameters)
- 0: disabled
- 1: enabled";
            sw = rw; hw = r;
            reset = 0x0;
        } enable[31:31];
        field {
            name = "mode";
            desc = "Timing recovery mode (timings are recovered based on timing parameters)
- 0: Timings are generated based on the input valid signal of PT.
- 1: Timings are automatically calculated and generated internally.";
            sw = rw; hw = r;
            reset = 0x0;
        } mode[30:30];
        field {
            name = "reserved";
            desc = "Reserved";
            sw = r; hw = w;
            reset = 0x0;
        } reserved_29_3[29:3];
        field {
            name = "vsync_mode";
            desc = "vsync recovery
- 0: not recovered
- 1: recovered";
            sw = rw; hw = r;
            reset = 0x0;
        } vsync_mode[2:2];
        field {
            name = "hsync_mode";
            desc = "hsync recovery
- 0: not recovered
- 1: recovered";
            sw = rw; hw = r;
            reset = 0x0;
        } hsync_mode[1:1];
        field {
            name = "reserved";
            desc = "Reserved";
            sw = r; hw = w;
            reset = 0x0;
        } reserved_0_0[0:0];
    } CH_IPI_GEN_TIMING_CFG @ 0x10334;
    reg {
        name = "CH_IPI_UNIFY_DATA_CFG";
        desc = "CH_IPI_UNIFY_DATA_CFG is a data configuration register. (offset 0x10340; total reset 0x00000000; PROVEN: Hi3521A/Hi3520D V300 data sheet (Issue 00B07, 2015-12-10), section 10.1.6, PDF page 1203).";
        field {
            name = "enable";
            desc = "Data separation enable
- 0: disabled
- 1: enabled";
            sw = rw; hw = r;
            reset = 0x0;
        } enable[31:31];
        field {
            name = "reserved";
            desc = "Reserved";
            sw = r; hw = w;
            reset = 0x0;
        } reserved_30_4[30:4];
        field {
            name = "uv_seq";
            desc = "Cb/Cr sequence
- 0: CbCr
- 1: CrCb";
            sw = rw; hw = r;
            reset = 0x0;
        } uv_seq[3:3];
        field {
            name = "yc_seq";
            desc = "Y/C sequence
- 0: CY
- 1: YC";
            sw = rw; hw = r;
            reset = 0x0;
        } yc_seq[2:2];
        field {
            name = "comp_num";
            desc = "Data component select
- 00: component 1
- 01: component 2
- 10: component 3
- 11: reserved";
            sw = rw; hw = r;
            reset = 0x0;
        } comp_num[1:0];
    } CH_IPI_UNIFY_DATA_CFG @ 0x10340;
    reg {
        name = "CH_IPI_YUV444_CFG";
        desc = "CH_IPI_YUV444_CFG is a YUV444 configuration register. (offset 0x10350; total reset 0x00000000; PROVEN: Hi3521A/Hi3520D V300 data sheet (Issue 00B07, 2015-12-10), section 10.1.6, PDF page 1204).";
        field {
            name = "enable";
            desc = "YUV enable for converting YUV422 signals into YUV444 signals
- 0: disabled
- 1: enabled";
            sw = rw; hw = r;
            reset = 0x0;
        } enable[31:31];
        field {
            name = "reserved";
            desc = "Reserved";
            sw = r; hw = w;
            reset = 0x0;
        } reserved_30_0[30:0];
    } CH_IPI_YUV444_CFG @ 0x10350;
    reg {
        name = "CH_IPI_INTF_HFB";
        desc = "CH_IPI_INTF_HFB is a horizontal front blanking region width register. (offset 0x10380; total reset 0x00000010; PROVEN: Hi3521A/Hi3520D V300 data sheet (Issue 00B07, 2015-12-10), section 10.1.6, PDF page 1204).";
        field {
            name = "reserved";
            desc = "Reserved";
            sw = r; hw = w;
            reset = 0x0;
        } reserved_31_16[31:16];
        field {
            name = "hfb";
            desc = "Horizontal front blanking region width";
            sw = rw; hw = r;
            reset = 0x10;
        } hfb[15:0];
    } CH_IPI_INTF_HFB @ 0x10380;
    reg {
        name = "CH_IPI_INTF_HACT";
        desc = "CH_IPI_INTF_HACT is a horizontal valid region width register. (offset 0x10384; total reset 0x00000010; PROVEN: Hi3521A/Hi3520D V300 data sheet (Issue 00B07, 2015-12-10), section 10.1.6, PDF page 1205).";
        field {
            name = "hact";
            desc = "Horizontal valid region width (in clock cycle)";
            sw = rw; hw = r;
            reset = 0x10;
        } hact[31:0];
    } CH_IPI_INTF_HACT @ 0x10384;
    reg {
        name = "CH_IPI_INTF_HBB";
        desc = "CH_IPI_INTF_HBB is a horizontal back blanking region width register. (offset 0x10388; total reset 0x00000010; PROVEN: Hi3521A/Hi3520D V300 data sheet (Issue 00B07, 2015-12-10), section 10.1.6, PDF page 1205).";
        field {
            name = "reserved";
            desc = "Reserved";
            sw = r; hw = w;
            reset = 0x0;
        } reserved_31_16[31:16];
        field {
            name = "hbb";
            desc = "Horizontal back blanking region width";
            sw = rw; hw = r;
            reset = 0x10;
        } hbb[15:0];
    } CH_IPI_INTF_HBB @ 0x10388;
    reg {
        name = "CH_IPI_INTF_VFB";
        desc = "CH_IPI_INTF_VFB is a vertical front blanking region width register. (offset 0x1038C; total reset 0x00000010; PROVEN: Hi3521A/Hi3520D V300 data sheet (Issue 00B07, 2015-12-10), section 10.1.6, PDF page 1205).";
        field {
            name = "reserved";
            desc = "Reserved";
            sw = r; hw = w;
            reset = 0x0;
        } reserved_31_16[31:16];
        field {
            name = "vfb";
            desc = "Vertical front blanking region width";
            sw = rw; hw = r;
            reset = 0x10;
        } vfb[15:0];
    } CH_IPI_INTF_VFB @ 0x1038C;
    reg {
        name = "CH_IPI_INTF_VACT";
        desc = "CH_IPI_INTF_VACT is a vertical valid region width register. (offset 0x10390; total reset 0x00000010; PROVEN: Hi3521A/Hi3520D V300 data sheet (Issue 00B07, 2015-12-10), section 10.1.6, PDF page 1206).";
        field {
            name = "reserved";
            desc = "Reserved";
            sw = r; hw = w;
            reset = 0x0;
        } reserved_31_16[31:16];
        field {
            name = "vact";
            desc = "Vertical valid region width";
            sw = rw; hw = r;
            reset = 0x10;
        } vact[15:0];
    } CH_IPI_INTF_VACT @ 0x10390;
    reg {
        name = "CH_IPI_INTF_VBB";
        desc = "CH_IPI_INTF_VBB is a vertical back blanking region width register. (offset 0x10394; total reset 0x00000010; PROVEN: Hi3521A/Hi3520D V300 data sheet (Issue 00B07, 2015-12-10), section 10.1.6, PDF page 1206).";
        field {
            name = "reserved";
            desc = "Reserved";
            sw = r; hw = w;
            reset = 0x0;
        } reserved_31_16[31:16];
        field {
            name = "vbb";
            desc = "Vertical back blanking region width";
            sw = rw; hw = r;
            reset = 0x10;
        } vbb[15:0];
    } CH_IPI_INTF_VBB @ 0x10394;
    reg {
        name = "CH_IPI_INTF_VBFB";
        desc = "CH_IPI_INTF_VBFB is a vertical bottom field front blanking region width register. (offset 0x10398; total reset 0x00000010; PROVEN: Hi3521A/Hi3520D V300 data sheet (Issue 00B07, 2015-12-10), section 10.1.6, PDF page 1206).";
        field {
            name = "reserved";
            desc = "Reserved";
            sw = r; hw = w;
            reset = 0x0;
        } reserved_31_16[31:16];
        field {
            name = "vbfb";
            desc = "Vertical bottom field front blanking region width";
            sw = rw; hw = r;
            reset = 0x10;
        } vbfb[15:0];
    } CH_IPI_INTF_VBFB @ 0x10398;
    reg {
        name = "CH_IPI_INTF_VBACT";
        desc = "CH_IPI_INTF_VBACT is a vertical bottom field valid region width register. (offset 0x1039C; total reset 0x00000010; PROVEN: Hi3521A/Hi3520D V300 data sheet (Issue 00B07, 2015-12-10), section 10.1.6, PDF page 1207).";
        field {
            name = "reserved";
            desc = "Reserved";
            sw = r; hw = w;
            reset = 0x0;
        } reserved_31_16[31:16];
        field {
            name = "vbact";
            desc = "Vertical bottom field valid region width";
            sw = rw; hw = r;
            reset = 0x10;
        } vbact[15:0];
    } CH_IPI_INTF_VBACT @ 0x1039C;
    reg {
        name = "CH_IPI_INTF_VBBB";
        desc = "CH_IPI_INTF_VBBB is a vertical bottom field back blanking region width register. (offset 0x103A0; total reset 0x00000010; PROVEN: Hi3521A/Hi3520D V300 data sheet (Issue 00B07, 2015-12-10), section 10.1.6, PDF page 1207).";
        field {
            name = "reserved";
            desc = "Reserved";
            sw = r; hw = w;
            reset = 0x0;
        } reserved_31_16[31:16];
        field {
            name = "vbbb";
            desc = "Vertical bottom field back blanking region width";
            sw = rw; hw = r;
            reset = 0x10;
        } vbbb[15:0];
    } CH_IPI_INTF_VBBB @ 0x103A0;
    reg {
        name = "CH_IPI_STATUS";
        desc = "CH_IPI_STATUS is an interface status register. (offset 0x103E0; total reset 0x00000000; PROVEN: Hi3521A/Hi3520D V300 data sheet (Issue 00B07, 2015-12-10), section 10.1.6, PDF page 1208).";
        field {
            name = "reserved";
            desc = "Reserved";
            sw = r; hw = w;
            reset = 0x0;
        } reserved_31_6[31:6];
        field {
            name = "id";
            desc = "Port output ID";
            sw = r; hw = w;
            reset = 0x0;
        } id[5:4];
        field {
            name = "field";
            desc = "Field output over the port";
            sw = r; hw = w;
            reset = 0x0;
        } field_f[3:3];
        field {
            name = "vysnc";
            desc = "vysnc signal output over the port";
            sw = r; hw = w;
            reset = 0x0;
        } vysnc[2:2];
        field {
            name = "hsync";
            desc = "hsync signal output over the port";
            sw = r; hw = w;
            reset = 0x0;
        } hsync[1:1];
        field {
            name = "de";
            desc = "de signal output over the port";
            sw = r; hw = w;
            reset = 0x0;
        } de[0:0];
    } CH_IPI_STATUS @ 0x103E0;
    reg {
        name = "CH_IPI_BT656_STATUS";
        desc = "CH_IPI_BT656_STATUS is a BT.656 status register. (offset 0x103E4; total reset 0x00000000; PROVEN: Hi3521A/Hi3520D V300 data sheet (Issue 00B07, 2015-12-10), section 10.1.6, PDF page 1208).";
        field {
            name = "reserved";
            desc = "Reserved";
            sw = r; hw = w;
            reset = 0x0;
        } reserved_31_16[31:16];
        field {
            name = "seav";
            desc = "Synchronization code";
            sw = r; hw = w;
            reset = 0x0;
        } seav[15:8];
        field {
            name = "reserved";
            desc = "Reserved";
            sw = r; hw = w;
            reset = 0x0;
        } reserved_7_0[7:0];
    } CH_IPI_BT656_STATUS @ 0x103E4;
    reg {
        name = "CH_IPI_SIZE";
        desc = "CH_IPI_SIZE is an input picture size register. (offset 0x103EC; total reset 0x00000000; PROVEN: Hi3521A/Hi3520D V300 data sheet (Issue 00B07, 2015-12-10), section 10.1.6, PDF page 1209).";
        field {
            name = "height";
            desc = "Picture height";
            sw = r; hw = w;
            reset = 0x0;
        } height[31:16];
        field {
            name = "width";
            desc = "Picture width";
            sw = r; hw = w;
            reset = 0x0;
        } width[15:0];
    } CH_IPI_SIZE @ 0x103EC;
    reg {
        name = "CH_CTRL";
        desc = "CH_CTRL is a channel control register. (offset 0x10500; total reset 0x00000000; PROVEN: Hi3521A/Hi3520D V300 data sheet (Issue 00B07, 2015-12-10), section 10.1.6, PDF page 1209).";
        field {
            name = "enable";
            desc = "Channel enable
- 0: disabled
- 1: enabled";
            sw = rw; hw = r;
            reset = 0x0;
        } enable[31:31];
        field {
            name = "reserved";
            desc = "Reserved";
            sw = r; hw = w;
            reset = 0x0;
        } reserved_30_0[30:0];
    } CH_CTRL @ 0x10500;
    reg {
        name = "CH_REG_NEWER";
        desc = "CH_REG_NEWER is a capture control register. (offset 0x10504; total reset 0x00000000; PROVEN: Hi3521A/Hi3520D V300 data sheet (Issue 00B07, 2015-12-10), section 10.1.6, PDF page 1210).";
        field {
            name = "reserved";
            desc = "Reserved";
            sw = r; hw = w;
            reset = 0x0;
        } reserved_31_1[31:1];
        field {
            name = "reg_newer";
            desc = "Channel update. This bit is automatically cleared for each frame.";
            sw = rw; hw = r;
            reset = 0x0;
        } reg_newer[0:0];
    } CH_REG_NEWER @ 0x10504;
    reg {
        name = "CH_SUM_Y";
        desc = "CH_SUM_Y is an input picture luminance statistics register. (offset 0x10520; total reset 0x00000000; PROVEN: Hi3521A/Hi3520D V300 data sheet (Issue 00B07, 2015-12-10), section 10.1.6, PDF page 1210).";
        field {
            name = "sum_y";
            desc = "Luminance statistics";
            sw = r; hw = w;
            reset = 0x0;
        } sum_y[31:0];
    } CH_SUM_Y @ 0x10520;
    reg {
        name = "CH_COUNT";
        desc = "CH_COUNT is a channel input picture counter register. (offset 0x10530; total reset 0x00000000; PROVEN: Hi3521A/Hi3520D V300 data sheet (Issue 00B07, 2015-12-10), section 10.1.6, PDF page 1210).";
        field {
            name = "v_count";
            desc = "Counter for the number of vertical lines.This bit is automatically cleared for each frame.";
            sw = r; hw = w;
            reset = 0x0;
        } v_count[31:16];
        field {
            name = "reserved";
            desc = "Reserved";
            sw = r; hw = w;
            reset = 0x0;
        } reserved_15_0[15:0];
    } CH_COUNT @ 0x10530;
    reg {
        name = "CH_DLY_CFG";
        desc = "CH_DLY_CFG is a channel input picture start interrupt delay configuration register. (offset 0x10534; total reset 0x00000000; PROVEN: Hi3521A/Hi3520D V300 data sheet (Issue 00B07, 2015-12-10), section 10.1.6, PDF page 1211).";
        field {
            name = "v_dly_cfg";
            desc = "Vertical line number delay";
            sw = rw; hw = r;
            reset = 0x0;
        } v_dly_cfg[31:16];
        field {
            name = "reserved";
            desc = "Reserved";
            sw = r; hw = w;
            reset = 0x0;
        } reserved_15_0[15:0];
    } CH_DLY_CFG @ 0x10534;
    reg {
        name = "CH_WCH_Y_CFG";
        desc = "CH_WCH_Y_CFG is a Y component configuration register for the WCH module. (offset 0x10580; total reset 0x00000000; PROVEN: Hi3521A/Hi3520D V300 data sheet (Issue 00B07, 2015-12-10), section 10.1.6, PDF page 1211).";
        field {
            name = "enable";
            desc = "CH write channel enable
- 0: disabled
- 1: enabled";
            sw = rw; hw = r;
            reset = 0x0;
        } enable[31:31];
        field {
            name = "reserved";
            desc = "Reserved";
            sw = r; hw = w;
            reset = 0x0;
        } reserved_30_20[30:20];
        field {
            name = "interleave";
            desc = "Progressive/Interlaced flag
- 0: The output data is progressive or interlaced and does not need to be interleaved as frames for storage.
- 1: The output data is interlaced and needs to be interleaved as frames for storage.";
            sw = rw; hw = r;
            reset = 0x0;
        } interleave[19:19];
        field {
            name = "bfield";
            desc = "Top/Bottom field flag. This field is used when the output data is interlaced and needs to be interleaved as frames for storage.
- 0: top field
- 1: bottom field";
            sw = rw; hw = r;
            reset = 0x0;
        } bfield[18:18];
        field {
            name = "reserved";
            desc = "Reserved";
            sw = r; hw = w;
            reset = 0x0;
        } reserved_17_16[17:16];
        field {
            name = "reserved";
            desc = "Reserved";
            sw = r; hw = w;
            reset = 0x0;
        } reserved_15_5[15:5];
        field {
            name = "flip";
            desc = "Channel flip enable
- 0: disabled
- 1: enabled";
            sw = rw; hw = r;
            reset = 0x0;
        } flip[4:4];
        field {
            name = "mirror";
            desc = "Channel mirror enable
- 0: disabled
- 1: enabled";
            sw = rw; hw = r;
            reset = 0x0;
        } mirror[3:3];
        field {
            name = "reserved";
            desc = "Reserved";
            sw = rw; hw = r;
            reset = 0x0;
        } reserved_2_0[2:0];
    } CH_WCH_Y_CFG @ 0x10580;
    reg {
        name = "CH_WCH_Y_SIZE";
        desc = "CH_WCH_Y_SIZE is a Y component storage size register for the WCH module. (offset 0x10584; total reset 0x00000000; PROVEN: Hi3521A/Hi3520D V300 data sheet (Issue 00B07, 2015-12-10), section 10.1.6, PDF page 1212).";
        field {
            name = "reserved";
            desc = "Reserved";
            sw = r; hw = w;
            reset = 0x0;
        } reserved_31_29[31:29];
        field {
            name = "height";
            desc = "Height (in line) of the stored picture. The configured value is the actual value minus 1.";
            sw = rw; hw = r;
            reset = 0x0;
        } height[28:16];
        field {
            name = "reserved";
            desc = "Reserved";
            sw = r; hw = w;
            reset = 0x0;
        } reserved_15_13[15:13];
        field {
            name = "width";
            desc = "Width (in pixel) of the stored picture. The configured value is the actual value minus 1.";
            sw = rw; hw = r;
            reset = 0x0;
        } width[12:0];
    } CH_WCH_Y_SIZE @ 0x10584;
    reg {
        name = "CH_WCH_Y_FADDR";
        desc = "CH_WCH_Y_FADDR is a Y component storage base address register for the WCH module. (offset 0x10590; total reset 0x00000000; PROVEN: Hi3521A/Hi3520D V300 data sheet (Issue 00B07, 2015-12-10), section 10.1.6, PDF page 1213).";
        field {
            name = "faddr";
            desc = "Base address for storing the Y component";
            sw = rw; hw = r;
            reset = 0x0;
        } faddr[31:0];
    } CH_WCH_Y_FADDR @ 0x10590;
    reg {
        name = "CH_WCH_Y_STRIDE";
        desc = "CH_WCH_Y_STRIDE is a Y component line offset register for the WCH module. (offset 0x10598; total reset 0x00000000; PROVEN: Hi3521A/Hi3520D V300 data sheet (Issue 00B07, 2015-12-10), section 10.1.6, PDF page 1213).";
        field {
            name = "reserved";
            desc = "Reserved";
            sw = r; hw = w;
            reset = 0x0;
        } reserved_31_16[31:16];
        field {
            name = "stride";
            desc = "Stride (in byte) for storing the Y component";
            sw = rw; hw = r;
            reset = 0x0;
        } stride[15:0];
    } CH_WCH_Y_STRIDE @ 0x10598;
    reg {
        name = "CH_WCH_C_CFG";
        desc = "CH_WCH_C_CFG is a C component configuration register for the WCH module. (offset 0x105A0; total reset 0x00000000; PROVEN: Hi3521A/Hi3520D V300 data sheet (Issue 00B07, 2015-12-10), section 10.1.6, PDF page 1214).";
        field {
            name = "enable";
            desc = "CH write channel enable
- 0: disabled
- 1: enabled";
            sw = rw; hw = r;
            reset = 0x0;
        } enable[31:31];
        field {
            name = "reserved";
            desc = "Reserved";
            sw = r; hw = w;
            reset = 0x0;
        } reserved_30_20[30:20];
        field {
            name = "interleave";
            desc = "Progressive/Interlaced flag
- 0: The output data is progressive or interlaced and does not need to be interleaved as frames for storage.
- 1: The output data is interlaced and needs to be interleaved as frames for storage.";
            sw = rw; hw = r;
            reset = 0x0;
        } interleave[19:19];
        field {
            name = "bfield";
            desc = "Top/Bottom field flag. This field is used when the output data is interlaced and needs to be interleaved as frames for storage.
- 0: top field
- 1: bottom field";
            sw = rw; hw = r;
            reset = 0x0;
        } bfield[18:18];
        field {
            name = "reserved";
            desc = "Reserved";
            sw = r; hw = w;
            reset = 0x0;
        } reserved_17_16[17:16];
        field {
            name = "reserved";
            desc = "Reserved";
            sw = r; hw = w;
            reset = 0x0;
        } reserved_15_5[15:5];
        field {
            name = "flip";
            desc = "Channel flip enable
- 0: disabled
- 1: enabled";
            sw = rw; hw = r;
            reset = 0x0;
        } flip[4:4];
        field {
            name = "mirror";
            desc = "Channel mirror enable
- 0: disabled
- 1: enabled";
            sw = rw; hw = r;
            reset = 0x0;
        } mirror[3:3];
        field {
            name = "reserved";
            desc = "Reserved";
            sw = rw; hw = r;
            reset = 0x0;
        } reserved_2_0[2:0];
    } CH_WCH_C_CFG @ 0x105A0;
    reg {
        name = "CH_WCH_C_SIZE";
        desc = "CH_WCH_C_SIZE is a C component storage size register for the WCH module. (offset 0x105A4; total reset 0x00000000; PROVEN: Hi3521A/Hi3520D V300 data sheet (Issue 00B07, 2015-12-10), section 10.1.6, PDF page 1215).";
        field {
            name = "reserved";
            desc = "Reserved";
            sw = r; hw = w;
            reset = 0x0;
        } reserved_31_29[31:29];
        field {
            name = "height";
            desc = "Height (in line) of the stored picture. The configured value is the actual value minus 1.";
            sw = rw; hw = r;
            reset = 0x0;
        } height[28:16];
        field {
            name = "reserved";
            desc = "Reserved";
            sw = r; hw = w;
            reset = 0x0;
        } reserved_15_13[15:13];
        field {
            name = "width";
            desc = "Width (in pixel) of the stored picture. The configured value is the actual value minus 1.";
            sw = rw; hw = r;
            reset = 0x0;
        } width[12:0];
    } CH_WCH_C_SIZE @ 0x105A4;
    reg {
        name = "CH_WCH_C_FADDR";
        desc = "CH_WCH_C_FADDR is a C component storage base address register for the WCH module. (offset 0x105B0; total reset 0x00000000; PROVEN: Hi3521A/Hi3520D V300 data sheet (Issue 00B07, 2015-12-10), section 10.1.6, PDF page 1215).";
        field {
            name = "faddr";
            desc = "Base address for storing the C component";
            sw = rw; hw = r;
            reset = 0x0;
        } faddr[31:0];
    } CH_WCH_C_FADDR @ 0x105B0;
    reg {
        name = "CH_WCH_C_STRIDE";
        desc = "CH_WCH_C_STRIDE is a C component line offset register for the WCH module. (offset 0x105B8; total reset 0x00000000; PROVEN: Hi3521A/Hi3520D V300 data sheet (Issue 00B07, 2015-12-10), section 10.1.6, PDF page 1216).";
        field {
            name = "reserved";
            desc = "Reserved";
            sw = r; hw = w;
            reset = 0x0;
        } reserved_31_16[31:16];
        field {
            name = "stride";
            desc = "Stride (in byte) for storing the C component";
            sw = rw; hw = r;
            reset = 0x0;
        } stride[15:0];
    } CH_WCH_C_STRIDE @ 0x105B8;
    reg {
        name = "CH_INT";
        desc = "CH_INT is a channel raw interrupt register. (offset 0x105F0; total reset 0x00000000; PROVEN: Hi3521A/Hi3520D V300 data sheet (Issue 00B07, 2015-12-10), section 10.1.6, PDF page 1216).";
        field {
            name = "reserved";
            desc = "Reserved";
            sw = r; hw = w;
            reset = 0x0;
        } reserved_31_16[31:16];
        field {
            name = "fstart_dly";
            desc = "Status of the delayed field/frame start interrupt. Writing 1 clears the interrupt.
- 0: No interrupt is generated.
- 1: An interrupt is generated.

Access type WC in the data sheet: written 1 clears the bit.";
            sw = rw; hw = w; onwrite = woclr;
            reset = 0x0;
        } fstart_dly[15:15];
        field {
            name = "reserved";
            desc = "Reserved";
            sw = r; hw = w;
            reset = 0x0;
        } reserved_14_8[14:8];
        field {
            name = "timer_out";
            desc = "Status of the timing loss interrupt. Writing 1 clears the interrupt.
- 0: No interrupt is generated.
- 1: An interrupt is generated.

Access type WC in the data sheet: written 1 clears the bit.";
            sw = rw; hw = w; onwrite = woclr;
            reset = 0x0;
        } timer_out[7:7];
        field {
            name = "height_err";
            desc = "Status of the picture height change interrupt. Writing 1 clears the interrupt.
- 0: No interrupt is generated.
- 1: An interrupt is generated.

Access type WC in the data sheet: written 1 clears the bit.";
            sw = rw; hw = w; onwrite = woclr;
            reset = 0x0;
        } height_err[6:6];
        field {
            name = "width_err";
            desc = "Status of the picture width change interrupt. Writing 1 clears the interrupt.
- 0: No interrupt is generated.
- 1: An interrupt is generated.

Access type WC in the data sheet: written 1 clears the bit.";
            sw = rw; hw = w; onwrite = woclr;
            reset = 0x0;
        } width_err[5:5];
        field {
            name = "update_cfg";
            desc = "Status of the register updated interrupt. Writing 1 clears the interrupt.
- 0: No interrupt is generated.
- 1: An interrupt is generated.

Access type WC in the data sheet: written 1 clears the bit.";
            sw = rw; hw = w; onwrite = woclr;
            reset = 0x0;
        } update_cfg[4:4];
        field {
            name = "field_throw";
            desc = "Status of the field/frame loss interrupt. Writing 1 clears the interrupt.
- 0: No interrupt is generated.
- 1: An interrupt is generated.

Access type WC in the data sheet: written 1 clears the bit.";
            sw = rw; hw = w; onwrite = woclr;
            reset = 0x0;
        } field_throw[3:3];
        field {
            name = "buf_ovf";
            desc = "Status of the internal FIFO overflow error interrupt. Writing 1 clears the interrupt.
- 0: No interrupt is generated.
- 1: An interrupt is generated.

Access type WC in the data sheet: written 1 clears the bit.";
            sw = rw; hw = w; onwrite = woclr;
            reset = 0x0;
        } buf_ovf[2:2];
        field {
            name = "cc_int";
            desc = "Status of the capture completion interrupt. Writing 1 clears the interrupt.
- 0: No interrupt is generated.
- 1: An interrupt is generated.

Access type WC in the data sheet: written 1 clears the bit.";
            sw = rw; hw = w; onwrite = woclr;
            reset = 0x0;
        } cc_int[1:1];
        field {
            name = "fstart";
            desc = "Status of the field/frame start interrupt. Writing 1 clears the interrupt.
- 0: No interrupt is generated.
- 1: An interrupt is generated.

Access type WC in the data sheet: written 1 clears the bit.";
            sw = rw; hw = w; onwrite = woclr;
            reset = 0x0;
        } fstart[0:0];
    } CH_INT @ 0x105F0;
    reg {
        name = "CH_INT_MASK";
        desc = "CH_INT_MASK is a channel interrupt mask register. (offset 0x105F8; total reset 0x00000000; PROVEN: Hi3521A/Hi3520D V300 data sheet (Issue 00B07, 2015-12-10), section 10.1.6, PDF page 1218).";
        field {
            name = "reserved";
            desc = "Reserved";
            sw = r; hw = w;
            reset = 0x0;
        } reserved_31_16[31:16];
        field {
            name = "fstart_dly";
            desc = "Delayed field/frame start interrupt enable
- 0: masked
- 1: enabled";
            sw = rw; hw = r;
            reset = 0x0;
        } fstart_dly[15:15];
        field {
            name = "reserved";
            desc = "Reserved";
            sw = r; hw = w;
            reset = 0x0;
        } reserved_14_8[14:8];
        field {
            name = "timer_out";
            desc = "Timing loss interrupt status enable
- 0: masked
- 1: enabled

Access type WC in the data sheet: written 1 clears the bit.";
            sw = rw; hw = w; onwrite = woclr;
            reset = 0x0;
        } timer_out[7:7];
        field {
            name = "height_err";
            desc = "Picture height change interrupt status enable
- 0: masked
- 1: enabled";
            sw = rw; hw = r;
            reset = 0x0;
        } height_err[6:6];
        field {
            name = "width_err";
            desc = "Picture width change interrupt status enable
- 0: masked
- 1: enabled";
            sw = rw; hw = r;
            reset = 0x0;
        } width_err[5:5];
        field {
            name = "update_cfg";
            desc = "Register update interrupt enable
- 0: masked
- 1: enabled";
            sw = rw; hw = r;
            reset = 0x0;
        } update_cfg[4:4];
        field {
            name = "field_throw";
            desc = "Field/Frame loss interrupt enable
- 0: masked
- 1: enabled";
            sw = rw; hw = r;
            reset = 0x0;
        } field_throw[3:3];
        field {
            name = "buf_ovf";
            desc = "Internal FIFO overflow error interrupt enable
- 0: masked
- 1: enabled";
            sw = rw; hw = r;
            reset = 0x0;
        } buf_ovf[2:2];
        field {
            name = "cc_int";
            desc = "Capture completion interrupt enable
- 0: masked
- 1: enabled";
            sw = rw; hw = r;
            reset = 0x0;
        } cc_int[1:1];
        field {
            name = "fstart";
            desc = "Field/Frame start interrupt enable
- 0: masked
- 1: enabled";
            sw = rw; hw = r;
            reset = 0x0;
        } fstart[0:0];
    } CH_INT_MASK @ 0x105F8;
    reg {
        name = "CH_MSC_CFG";
        desc = "CH_MSC_CFG is a block mask configuration register. (offset 0x10700; total reset 0x00000000; PROVEN: Hi3521A/Hi3520D V300 data sheet (Issue 00B07, 2015-12-10), section 10.1.6, PDF page 1219).";
        field {
            name = "reserved";
            desc = "Reserved";
            sw = r; hw = w;
            reset = 0x0;
        } reserved_31_4[31:4];
        field {
            name = "msc3_en";
            desc = "Block 3 enable
- 0: disabled
- 1: enabled";
            sw = rw; hw = r;
            reset = 0x0;
        } msc3_en[3:3];
        field {
            name = "msc2_en";
            desc = "Block 2 enable
- 0: disabled
- 1: enabled";
            sw = rw; hw = r;
            reset = 0x0;
        } msc2_en[2:2];
        field {
            name = "msc1_en";
            desc = "Block 1 enable
- 0: disabled
- 1: enabled";
            sw = rw; hw = r;
            reset = 0x0;
        } msc1_en[1:1];
        field {
            name = "msc0_en";
            desc = "Block 0 enable
- 0: disabled
- 1: enabled";
            sw = rw; hw = r;
            reset = 0x0;
        } msc0_en[0:0];
    } CH_MSC_CFG @ 0x10700;
    reg {
        name = "CH_BLOCK0_START";
        desc = "CH_BLOCK0_START is a mask start position register for block 0. (offset 0x10710; total reset 0x00000000; PROVEN: Hi3521A/Hi3520D V300 data sheet (Issue 00B07, 2015-12-10), section 10.1.6, PDF page 1220).";
        field {
            name = "reserved";
            desc = "Reserved";
            sw = r; hw = w;
            reset = 0x0;
        } reserved_31_28[31:28];
        field {
            name = "y_start";
            desc = "Vertical start point of block 0";
            sw = rw; hw = r;
            reset = 0x0;
        } y_start[27:16];
        field {
            name = "reserved";
            desc = "Reserved";
            sw = r; hw = w;
            reset = 0x0;
        } reserved_15_12[15:12];
        field {
            name = "x_start";
            desc = "Horizontal start point of block 0";
            sw = rw; hw = r;
            reset = 0x0;
        } x_start[11:0];
    } CH_BLOCK0_START @ 0x10710;
    reg {
        name = "CH_BLOCK1_START";
        desc = "CH_BLOCK1_START is a mask start position register for block 1. (offset 0x10714; total reset 0x00000000; PROVEN: Hi3521A/Hi3520D V300 data sheet (Issue 00B07, 2015-12-10), section 10.1.6, PDF page 1220).";
        field {
            name = "reserved";
            desc = "Reserved";
            sw = r; hw = w;
            reset = 0x0;
        } reserved_31_28[31:28];
        field {
            name = "y_start";
            desc = "Vertical start point of block 1";
            sw = rw; hw = r;
            reset = 0x0;
        } y_start[27:16];
        field {
            name = "reserved";
            desc = "Reserved";
            sw = r; hw = w;
            reset = 0x0;
        } reserved_15_12[15:12];
        field {
            name = "x_start";
            desc = "Horizontal start point of block 1";
            sw = rw; hw = r;
            reset = 0x0;
        } x_start[11:0];
    } CH_BLOCK1_START @ 0x10714;
    reg {
        name = "CH_BLOCK2_START";
        desc = "CH_BLOCK2_START is a mask start position register for block 2. (offset 0x10718; total reset 0x00000000; PROVEN: Hi3521A/Hi3520D V300 data sheet (Issue 00B07, 2015-12-10), section 10.1.6, PDF page 1221).";
        field {
            name = "reserved";
            desc = "Reserved";
            sw = r; hw = w;
            reset = 0x0;
        } reserved_31_28[31:28];
        field {
            name = "y_start";
            desc = "Vertical start point of block 2";
            sw = rw; hw = r;
            reset = 0x0;
        } y_start[27:16];
        field {
            name = "reserved";
            desc = "Reserved";
            sw = r; hw = w;
            reset = 0x0;
        } reserved_15_12[15:12];
        field {
            name = "x_start";
            desc = "Horizontal start point of block 2";
            sw = rw; hw = r;
            reset = 0x0;
        } x_start[11:0];
    } CH_BLOCK2_START @ 0x10718;
    reg {
        name = "CH_BLOCK3_START";
        desc = "CH_BLOCK3_START is a mask start position register for block 3. (offset 0x1071C; total reset 0x00000000; PROVEN: Hi3521A/Hi3520D V300 data sheet (Issue 00B07, 2015-12-10), section 10.1.6, PDF page 1221).";
        field {
            name = "reserved";
            desc = "Reserved";
            sw = r; hw = w;
            reset = 0x0;
        } reserved_31_28[31:28];
        field {
            name = "y_start";
            desc = "Vertical start point of block 3";
            sw = rw; hw = r;
            reset = 0x0;
        } y_start[27:16];
        field {
            name = "reserved";
            desc = "Reserved";
            sw = r; hw = w;
            reset = 0x0;
        } reserved_15_12[15:12];
        field {
            name = "x_start";
            desc = "Horizontal start point of block 3";
            sw = rw; hw = r;
            reset = 0x0;
        } x_start[11:0];
    } CH_BLOCK3_START @ 0x1071C;
    reg {
        name = "CH_BLOCK0_SIZE";
        desc = "CH_BLOCK0_SIZE is a mask size register for block 0. (offset 0x10720; total reset 0x00000000; PROVEN: Hi3521A/Hi3520D V300 data sheet (Issue 00B07, 2015-12-10), section 10.1.6, PDF page 1222).";
        field {
            name = "reserved";
            desc = "Reserved";
            sw = r; hw = w;
            reset = 0x0;
        } reserved_31_28[31:28];
        field {
            name = "blk_height";
            desc = "Vertical height of block 0 minus 1";
            sw = rw; hw = r;
            reset = 0x0;
        } blk_height[27:16];
        field {
            name = "reserved";
            desc = "Reserved";
            sw = r; hw = w;
            reset = 0x0;
        } reserved_15_12[15:12];
        field {
            name = "blk_width";
            desc = "Horizontal width of block 0 minus 1";
            sw = rw; hw = r;
            reset = 0x0;
        } blk_width[11:0];
    } CH_BLOCK0_SIZE @ 0x10720;
    reg {
        name = "CH_BLOCK1_SIZE";
        desc = "CH_BLOCK1_SIZE is a mask size register for block 1. (offset 0x10724; total reset 0x00000000; PROVEN: Hi3521A/Hi3520D V300 data sheet (Issue 00B07, 2015-12-10), section 10.1.6, PDF page 1222).";
        field {
            name = "reserved";
            desc = "Reserved";
            sw = r; hw = w;
            reset = 0x0;
        } reserved_31_28[31:28];
        field {
            name = "blk_height";
            desc = "Vertical height of block 1 minus 1";
            sw = rw; hw = r;
            reset = 0x0;
        } blk_height[27:16];
        field {
            name = "reserved";
            desc = "Reserved";
            sw = r; hw = w;
            reset = 0x0;
        } reserved_15_12[15:12];
        field {
            name = "blk_width";
            desc = "Horizontal width of block 1 minus 1";
            sw = rw; hw = r;
            reset = 0x0;
        } blk_width[11:0];
    } CH_BLOCK1_SIZE @ 0x10724;
    reg {
        name = "CH_BLOCK2_SIZE";
        desc = "CH_BLOCK2_SIZE is a mask size register for block 2. (offset 0x10728; total reset 0x00000000; PROVEN: Hi3521A/Hi3520D V300 data sheet (Issue 00B07, 2015-12-10), section 10.1.6, PDF page 1223).";
        field {
            name = "reserved";
            desc = "Reserved";
            sw = r; hw = w;
            reset = 0x0;
        } reserved_31_28[31:28];
        field {
            name = "blk_height";
            desc = "Vertical height of block 2 minus 1";
            sw = rw; hw = r;
            reset = 0x0;
        } blk_height[27:16];
        field {
            name = "reserved";
            desc = "Reserved";
            sw = r; hw = w;
            reset = 0x0;
        } reserved_15_12[15:12];
        field {
            name = "blk_width";
            desc = "Horizontal width of block 2 minus 1";
            sw = rw; hw = r;
            reset = 0x0;
        } blk_width[11:0];
    } CH_BLOCK2_SIZE @ 0x10728;
    reg {
        name = "CH_BLOCK3_SIZE";
        desc = "CH_BLOCK3_SIZE is a mask size register for block 3. (offset 0x1072C; total reset 0x00000000; PROVEN: Hi3521A/Hi3520D V300 data sheet (Issue 00B07, 2015-12-10), section 10.1.6, PDF page 1223).";
        field {
            name = "reserved";
            desc = "Reserved";
            sw = r; hw = w;
            reset = 0x0;
        } reserved_31_28[31:28];
        field {
            name = "blk_height";
            desc = "Vertical height of block 3 minus 1";
            sw = rw; hw = r;
            reset = 0x0;
        } blk_height[27:16];
        field {
            name = "reserved";
            desc = "Reserved";
            sw = r; hw = w;
            reset = 0x0;
        } reserved_15_12[15:12];
        field {
            name = "blk_width";
            desc = "Horizontal width of block 3 minus 1";
            sw = rw; hw = r;
            reset = 0x0;
        } blk_width[11:0];
    } CH_BLOCK3_SIZE @ 0x1072C;
    reg {
        name = "CH_BLOCK0_COLOR";
        desc = "CH_BLOCK0_COLOR is a mask color register for block 0. (offset 0x10730; total reset 0x00000000; PROVEN: Hi3521A/Hi3520D V300 data sheet (Issue 00B07, 2015-12-10), section 10.1.6, PDF page 1224).";
        field {
            name = "reserved";
            desc = "Reserved";
            sw = r; hw = w;
            reset = 0x0;
        } reserved_31_24[31:24];
        field {
            name = "blk_cr";
            desc = "Cr component of the filling color for block 0";
            sw = rw; hw = r;
            reset = 0x0;
        } blk_cr[23:16];
        field {
            name = "blk_cb";
            desc = "Cb component of the filling color for block 0";
            sw = rw; hw = r;
            reset = 0x0;
        } blk_cb[15:8];
        field {
            name = "blk_y";
            desc = "Y component of the filling color for block 0";
            sw = rw; hw = r;
            reset = 0x0;
        } blk_y[7:0];
    } CH_BLOCK0_COLOR @ 0x10730;
    reg {
        name = "CH_BLOCK1_COLOR";
        desc = "CH_BLOCK1_COLOR is a mask color register for block 1. (offset 0x10734; total reset 0x00000000; PROVEN: Hi3521A/Hi3520D V300 data sheet (Issue 00B07, 2015-12-10), section 10.1.6, PDF page 1224).";
        field {
            name = "reserved";
            desc = "Reserved";
            sw = r; hw = w;
            reset = 0x0;
        } reserved_31_24[31:24];
        field {
            name = "blk_cr";
            desc = "Cr component of the filling color for block 1";
            sw = rw; hw = r;
            reset = 0x0;
        } blk_cr[23:16];
        field {
            name = "blk_cb";
            desc = "Cb component of the filling color for block 1";
            sw = rw; hw = r;
            reset = 0x0;
        } blk_cb[15:8];
        field {
            name = "blk_y";
            desc = "Y component of the filling color for block 1";
            sw = rw; hw = r;
            reset = 0x0;
        } blk_y[7:0];
    } CH_BLOCK1_COLOR @ 0x10734;
    reg {
        name = "CH_BLOCK2_COLOR";
        desc = "CH_BLOCK2_COLOR is a mask color register for block 2. (offset 0x10738; total reset 0x00000000; PROVEN: Hi3521A/Hi3520D V300 data sheet (Issue 00B07, 2015-12-10), section 10.1.6, PDF page 1225).";
        field {
            name = "reserved";
            desc = "Reserved";
            sw = r; hw = w;
            reset = 0x0;
        } reserved_31_24[31:24];
        field {
            name = "blk_cr";
            desc = "Cr component of the filling color for block 2";
            sw = rw; hw = r;
            reset = 0x0;
        } blk_cr[23:16];
        field {
            name = "blk_cb";
            desc = "Cb component of the filling color for block 2";
            sw = rw; hw = r;
            reset = 0x0;
        } blk_cb[15:8];
        field {
            name = "blk_y";
            desc = "Y component of the filling color for block 2";
            sw = rw; hw = r;
            reset = 0x0;
        } blk_y[7:0];
    } CH_BLOCK2_COLOR @ 0x10738;
    reg {
        name = "CH_BLOCK3_COLOR";
        desc = "CH_BLOCK3_COLOR is a mask color register for block 3. (offset 0x1073C; total reset 0x00000000; PROVEN: Hi3521A/Hi3520D V300 data sheet (Issue 00B07, 2015-12-10), section 10.1.6, PDF page 1225).";
        field {
            name = "reserved";
            desc = "Reserved";
            sw = r; hw = w;
            reset = 0x0;
        } reserved_31_24[31:24];
        field {
            name = "blk_cr";
            desc = "Cr component of the filling color for block 3";
            sw = rw; hw = r;
            reset = 0x0;
        } blk_cr[23:16];
        field {
            name = "blk_cb";
            desc = "Cb component of the filling color for block 3";
            sw = rw; hw = r;
            reset = 0x0;
        } blk_cb[15:8];
        field {
            name = "blk_y";
            desc = "Y component of the filling color for block 3";
            sw = rw; hw = r;
            reset = 0x0;
        } blk_y[7:0];
    } CH_BLOCK3_COLOR @ 0x1073C;
    reg {
        name = "CH_CROP_CFG";
        desc = "CH_CROP_CFG is a crop enable register. (offset 0x10800; total reset 0x00000000; PROVEN: Hi3521A/Hi3520D V300 data sheet (Issue 00B07, 2015-12-10), section 10.1.6, PDF page 1226).";
        field {
            name = "reserved";
            desc = "Reserved";
            sw = r; hw = w;
            reset = 0x0;
        } reserved_31_1[31:1];
        field {
            name = "n0_en";
            desc = "Enable for crop region 0
- 0: disabled
- 1: enabled";
            sw = rw; hw = r;
            reset = 0x0;
        } n0_en[0:0];
    } CH_CROP_CFG @ 0x10800;
    reg {
        name = "CH_CROP0_START";
        desc = "CH_CROP0_START is a crop start position register for region 0. (offset 0x10810; total reset 0x00000000; PROVEN: Hi3521A/Hi3520D V300 data sheet (Issue 00B07, 2015-12-10), section 10.1.6, PDF page 1226).";
        field {
            name = "reserved";
            desc = "Reserved";
            sw = r; hw = w;
            reset = 0x0;
        } reserved_31_29[31:29];
        field {
            name = "y_start";
            desc = "ID of the line from which the picture starts to be captured";
            sw = rw; hw = r;
            reset = 0x0;
        } y_start[28:16];
        field {
            name = "reserved";
            desc = "Reserved";
            sw = r; hw = w;
            reset = 0x0;
        } reserved_15_13[15:13];
        field {
            name = "x_start";
            desc = "ID of the pixel from which the picture starts to be captured";
            sw = rw; hw = r;
            reset = 0x0;
        } x_start[12:0];
    } CH_CROP0_START @ 0x10810;
    reg {
        name = "CH_CROP0_SIZE";
        desc = "CH_CROP0_SIZE is a crop size configuration register for region 0. (offset 0x10814; total reset 0x00000000; PROVEN: Hi3521A/Hi3520D V300 data sheet (Issue 00B07, 2015-12-10), section 10.1.6, PDF page 1227).";
        field {
            name = "reserved";
            desc = "Reserved";
            sw = r; hw = w;
            reset = 0x0;
        } reserved_31_29[31:29];
        field {
            name = "height";
            desc = "Height (in line) of the obtained picture. The configured value is the actual value minus 1.";
            sw = rw; hw = r;
            reset = 0x0;
        } height[28:16];
        field {
            name = "reserved";
            desc = "Reserved";
            sw = r; hw = w;
            reset = 0x0;
        } reserved_15_13[15:13];
        field {
            name = "width";
            desc = "Width (in pixel) of the obtained picture. The configured value is the actual value minus 1.";
            sw = rw; hw = r;
            reset = 0x0;
        } width[12:0];
    } CH_CROP0_SIZE @ 0x10814;
    reg {
        name = "CH_SKIP_Y_CFG";
        desc = "CH_SKIP_Y_CFG is a Y component skip configuration register. (offset 0x10900; total reset 0xFFFFFFFF; PROVEN: Hi3521A/Hi3520D V300 data sheet (Issue 00B07, 2015-12-10), section 10.1.6, PDF page 1227).";
        field {
            name = "skip_cfg";
            desc = "Skip configuration of the Y component";
            sw = rw; hw = r;
            reset = 0xffffffff;
        } skip_cfg[31:0];
    } CH_SKIP_Y_CFG @ 0x10900;
    reg {
        name = "CH_SKIP_C_CFG";
        desc = "CH_SKIP_C_CFG is a C component skip configuration register. (offset 0x10910; total reset 0xFFFFFFFF; PROVEN: Hi3521A/Hi3520D V300 data sheet (Issue 00B07, 2015-12-10), section 10.1.6, PDF page 1228).";
        field {
            name = "skip_cfg";
            desc = "Skip configuration of the C component";
            sw = rw; hw = r;
            reset = 0xffffffff;
        } skip_cfg[31:0];
    } CH_SKIP_C_CFG @ 0x10910;
    reg {
        name = "CH_LHFIR_SPH";
        desc = "CH_LHFIR_SPH is a horizontal luminance scaling parameter configuration register. (offset 0x10A00; total reset 0x00000000; PROVEN: Hi3521A/Hi3520D V300 data sheet (Issue 00B07, 2015-12-10), section 10.1.6, PDF page 1228).";
        field {
            name = "hlmsc_en";
            desc = "Horizontal luminance scaling enable
- 0: disabled
- 1: enabled";
            sw = rw; hw = r;
            reset = 0x0;
        } hlmsc_en[31:31];
        field {
            name = "reserved";
            desc = "Reserved";
            sw = r; hw = w;
            reset = 0x0;
        } reserved_30_0[30:0];
    } CH_LHFIR_SPH @ 0x10A00;
    reg {
        name = "CH_CHFIR_SPH";
        desc = "CH_CHFIR_SPH is a horizontal chrominance scaling parameter configuration register. (offset 0x10A04; total reset 0x00000000; PROVEN: Hi3521A/Hi3520D V300 data sheet (Issue 00B07, 2015-12-10), section 10.1.6, PDF page 1229).";
        field {
            name = "hchmsc_en";
            desc = "Horizontal chrominance scaling enable
- 0: disabled
- 1: enabled";
            sw = rw; hw = r;
            reset = 0x0;
        } hchmsc_en[31:31];
        field {
            name = "reserved";
            desc = "Reserved";
            sw = r; hw = w;
            reset = 0x0;
        } reserved_30_0[30:0];
    } CH_CHFIR_SPH @ 0x10A04;
    reg {
        name = "CH_LHFIR_IN_SIZE";
        desc = "CH_LHFIR_IN_SIZE is a horizontal luminance scaling input size configuration register. (offset 0x10A10; total reset 0x00000000; PROVEN: Hi3521A/Hi3520D V300 data sheet (Issue 00B07, 2015-12-10), section 10.1.6, PDF page 1229).";
        field {
            name = "reserved";
            desc = "Reserved";
            sw = r; hw = w;
            reset = 0x0;
        } reserved_31_13[31:13];
        field {
            name = "width";
            desc = "Picture width (in pixel). The configured value is the actual value minus 1.";
            sw = rw; hw = r;
            reset = 0x0;
        } width[12:0];
    } CH_LHFIR_IN_SIZE @ 0x10A10;
    reg {
        name = "CH_CHFIR_IN_SIZE";
        desc = "CH_CHFIR_IN_SIZE is a horizontal chrominance scaling input size configuration register. (offset 0x10A14; total reset 0x00000000; PROVEN: Hi3521A/Hi3520D V300 data sheet (Issue 00B07, 2015-12-10), section 10.1.6, PDF page 1230).";
        field {
            name = "reserved";
            desc = "Reserved";
            sw = r; hw = w;
            reset = 0x0;
        } reserved_31_13[31:13];
        field {
            name = "width";
            desc = "Picture width (in pixel). The configured value is the actual value minus 1. The picture width is set to the sum of the widths of the Cb and Cr chrominance components.";
            sw = rw; hw = r;
            reset = 0x0;
        } width[12:0];
    } CH_CHFIR_IN_SIZE @ 0x10A14;
    reg {
        name = "CH_LHFIR_OUT_SIZE";
        desc = "CH_LHFIR_OUT_SIZE is a horizontal luminance scaling output size configuration register. (offset 0x10A18; total reset 0x00000000; PROVEN: Hi3521A/Hi3520D V300 data sheet (Issue 00B07, 2015-12-10), section 10.1.6, PDF page 1230).";
        field {
            name = "reserved";
            desc = "Reserved";
            sw = r; hw = w;
            reset = 0x0;
        } reserved_31_13[31:13];
        field {
            name = "width";
            desc = "Picture width (in pixel). The configured value is the actual value minus 1.";
            sw = rw; hw = r;
            reset = 0x0;
        } width[12:0];
    } CH_LHFIR_OUT_SIZE @ 0x10A18;
    reg {
        name = "CH_CHFIR_OUT_SIZE";
        desc = "CH_CHFIR_OUT_SIZE is a horizontal chrominance scaling output size configuration register. (offset 0x10A1C; total reset 0x00000000; PROVEN: Hi3521A/Hi3520D V300 data sheet (Issue 00B07, 2015-12-10), section 10.1.6, PDF page 1231).";
        field {
            name = "reserved";
            desc = "Reserved";
            sw = r; hw = w;
            reset = 0x0;
        } reserved_31_13[31:13];
        field {
            name = "width";
            desc = "Picture width (in pixel). The configured value is the actual value minus 1. The picture width is set to the sum of the widths of the Cb and Cr chrominance components.";
            sw = rw; hw = r;
            reset = 0x0;
        } width[12:0];
    } CH_CHFIR_OUT_SIZE @ 0x10A1C;
    reg {
        name = "CH_LHFIR_COEF0";
        desc = "CH_LHFIR_COEF0 is horizontal luminance scaling coefficient register 0. (offset 0x10A30; total reset 0x00000000; PROVEN: Hi3521A/Hi3520D V300 data sheet (Issue 00B07, 2015-12-10), section 10.1.6, PDF page 1231).";
        field {
            name = "reserved";
            desc = "Reserved";
            sw = r; hw = w;
            reset = 0x0;
        } reserved_31_30[31:30];
        field {
            name = "coef2";
            desc = "Horizontal luminance scaling and filtering coefficient 2";
            sw = rw; hw = r;
            reset = 0x0;
        } coef2[29:20];
        field {
            name = "coef1";
            desc = "Horizontal luminance scaling and filtering coefficient 1";
            sw = rw; hw = r;
            reset = 0x0;
        } coef1[19:10];
        field {
            name = "coef0";
            desc = "Horizontal luminance scaling and filtering coefficient 0 Only 8-tap horizontal scaling at an integral ratio is supported.";
            sw = rw; hw = r;
            reset = 0x0;
        } coef0[9:0];
    } CH_LHFIR_COEF0 @ 0x10A30;
    reg {
        name = "CH_LHFIR_COEF1";
        desc = "CH_LHFIR_COEF1 is horizontal luminance scaling coefficient register 1. (offset 0x10A34; total reset 0x000001FF; PROVEN: Hi3521A/Hi3520D V300 data sheet (Issue 00B07, 2015-12-10), section 10.1.6, PDF page 1232).";
        field {
            name = "reserved";
            desc = "Reserved";
            sw = r; hw = w;
            reset = 0x0;
        } reserved_31_30[31:30];
        field {
            name = "coef5";
            desc = "Horizontal luminance scaling and filtering coefficient 5";
            sw = rw; hw = r;
            reset = 0x0;
        } coef5[29:20];
        field {
            name = "coef4";
            desc = "Horizontal luminance scaling and filtering coefficient 4";
            sw = rw; hw = r;
            reset = 0x0;
        } coef4[19:10];
        field {
            name = "coef3";
            desc = "Horizontal luminance scaling and filtering coefficient 3";
            sw = rw; hw = r;
            reset = 0x1ff;
        } coef3[9:0];
    } CH_LHFIR_COEF1 @ 0x10A34;
    reg {
        name = "CH_LHFIR_COEF2";
        desc = "CH_LHFIR_COEF2 is horizontal luminance scaling coefficient register 2. (offset 0x10A38; total reset 0x00000000; PROVEN: Hi3521A/Hi3520D V300 data sheet (Issue 00B07, 2015-12-10), section 10.1.6, PDF page 1232).";
        field {
            name = "reserved";
            desc = "Reserved";
            sw = r; hw = w;
            reset = 0x0;
        } reserved_31_20[31:20];
        field {
            name = "coef7";
            desc = "Horizontal luminance scaling and filtering coefficient 7";
            sw = rw; hw = r;
            reset = 0x0;
        } coef7[19:10];
        field {
            name = "coef6";
            desc = "Horizontal luminance scaling and filtering coefficient 6";
            sw = rw; hw = r;
            reset = 0x0;
        } coef6[9:0];
    } CH_LHFIR_COEF2 @ 0x10A38;
    reg {
        name = "CH_CHFIR_COEF0";
        desc = "CH_CHFIR_COEF0 is chrominance horizontal scaling coefficient register 0. (offset 0x10A40; total reset 0x00000000; PROVEN: Hi3521A/Hi3520D V300 data sheet (Issue 00B07, 2015-12-10), section 10.1.6, PDF page 1233).";
        field {
            name = "reserved";
            desc = "Reserved";
            sw = r; hw = w;
            reset = 0x0;
        } reserved_31_30[31:30];
        field {
            name = "coef2";
            desc = "Horizontal chrominance scaling and filtering coefficient 2";
            sw = rw; hw = r;
            reset = 0x0;
        } coef2[29:20];
        field {
            name = "coef1";
            desc = "Horizontal chrominance scaling and filtering coefficient 1";
            sw = rw; hw = r;
            reset = 0x0;
        } coef1[19:10];
        field {
            name = "coef0";
            desc = "Horizontal chrominance scaling and filtering coefficient 0 Only 8-tap horizontal scaling at an integral ratio is supported.";
            sw = rw; hw = r;
            reset = 0x0;
        } coef0[9:0];
    } CH_CHFIR_COEF0 @ 0x10A40;
    reg {
        name = "CH_CHFIR_COEF1";
        desc = "CH_CHFIR_COEF1 is chrominance horizontal scaling coefficient register 1. (offset 0x10A44; total reset 0x000001FF; PROVEN: Hi3521A/Hi3520D V300 data sheet (Issue 00B07, 2015-12-10), section 10.1.6, PDF page 1233).";
        field {
            name = "reserved";
            desc = "Reserved";
            sw = r; hw = w;
            reset = 0x0;
        } reserved_31_30[31:30];
        field {
            name = "coef5";
            desc = "Horizontal chrominance scaling and filtering coefficient 5";
            sw = rw; hw = r;
            reset = 0x0;
        } coef5[29:20];
        field {
            name = "coef4";
            desc = "Horizontal chrominance scaling and filtering coefficient 4";
            sw = rw; hw = r;
            reset = 0x0;
        } coef4[19:10];
        field {
            name = "coef3";
            desc = "Horizontal chrominance scaling and filtering coefficient 3";
            sw = rw; hw = r;
            reset = 0x1ff;
        } coef3[9:0];
    } CH_CHFIR_COEF1 @ 0x10A44;
    reg {
        name = "CH_CHFIR_COEF2";
        desc = "CH_CHFIR_COEF2 is chrominance horizontal scaling coefficient register 2. (offset 0x10A48; total reset 0x00000000; PROVEN: Hi3521A/Hi3520D V300 data sheet (Issue 00B07, 2015-12-10), section 10.1.6, PDF page 1234).";
        field {
            name = "reserved";
            desc = "Reserved";
            sw = r; hw = w;
            reset = 0x0;
        } reserved_31_20[31:20];
        field {
            name = "coef7";
            desc = "Horizontal chrominance scaling and filtering coefficient 7";
            sw = rw; hw = r;
            reset = 0x0;
        } coef7[19:10];
        field {
            name = "coef6";
            desc = "Horizontal chrominance scaling and filtering coefficient 6";
            sw = rw; hw = r;
            reset = 0x0;
        } coef6[9:0];
    } CH_CHFIR_COEF2 @ 0x10A48;
    reg {
        name = "CH_VCDS_CFG";
        desc = "CH_VCDS_CFG is a vertical chrominance down sampling configuration register for large streams. (offset 0x10B00; total reset 0x00000000; PROVEN: Hi3521A/Hi3520D V300 data sheet (Issue 00B07, 2015-12-10), section 10.1.6, PDF page 1234).";
        field {
            name = "enable";
            desc = "Down sampling enable
- 0: disabled
- 1: enabled";
            sw = rw; hw = r;
            reset = 0x0;
        } enable[31:31];
        field {
            name = "reserved";
            desc = "Reserved";
            sw = r; hw = w;
            reset = 0x0;
        } reserved_30_0[30:0];
    } CH_VCDS_CFG @ 0x10B00;
    reg {
        name = "CH_VCDS_COEF";
        desc = "CH_VCDS_COEF is a vertical chrominance down sampling coefficient register for large streams. (offset 0x10B04; total reset 0x0000001F; PROVEN: Hi3521A/Hi3520D V300 data sheet (Issue 00B07, 2015-12-10), section 10.1.6, PDF page 1235).";
        field {
            name = "reserved";
            desc = "Reserved";
            sw = r; hw = w;
            reset = 0x0;
        } reserved_31_21[31:21];
        field {
            name = "coef1";
            desc = "Down sampling coefficient 1";
            sw = rw; hw = r;
            reset = 0x0;
        } coef1[20:16];
        field {
            name = "reserved";
            desc = "Reserved";
            sw = r; hw = w;
            reset = 0x0;
        } reserved_15_5[15:5];
        field {
            name = "coef0";
            desc = "Down sampling coefficient 0";
            sw = rw; hw = r;
            reset = 0x1f;
        } coef0[4:0];
    } CH_VCDS_COEF @ 0x10B04;
    reg {
        name = "CH_VCDS_IN_SIZE";
        desc = "CH_VCDS_IN_SIZE is a vertical chrominance down sampling input size configuration register. (offset 0x10B08; total reset 0x00000000; PROVEN: Hi3521A/Hi3520D V300 data sheet (Issue 00B07, 2015-12-10), section 10.1.6, PDF page 1235).";
        field {
            name = "reserved";
            desc = "Reserved";
            sw = r; hw = w;
            reset = 0x0;
        } reserved_31_29[31:29];
        field {
            name = "height";
            desc = "Height (in line) of the obtained picture. The configured value is the actual value minus 1.";
            sw = rw; hw = r;
            reset = 0x0;
        } height[28:16];
        field {
            name = "reserved";
            desc = "Reserved";
            sw = r; hw = w;
            reset = 0x0;
        } reserved_15_13[15:13];
        field {
            name = "width";
            desc = "Width (in pixel) of the obtained picture. The configured value is the actual value minus 1. The picture width is set to the width of the Cb/Cr component.";
            sw = rw; hw = r;
            reset = 0x0;
        } width[12:0];
    } CH_VCDS_IN_SIZE @ 0x10B08;
    reg {
        name = "CH_CLIP_Y_CFG";
        desc = "CH_CLIP_Y_CFG is a luminance clamp configuration register. (offset 0x10C00; total reset 0xFFFF0000; PROVEN: Hi3521A/Hi3520D V300 data sheet (Issue 00B07, 2015-12-10), section 10.1.6, PDF page 1236).";
        field {
            name = "max";
            desc = "Maximum luminance value. When the data bit width is less than 16 bits, the upper bits are valid.";
            sw = rw; hw = r;
            reset = 0xffff;
        } max[31:16];
        field {
            name = "min";
            desc = "Minimum luminance value. When the data bit width is less than 16 bits, the upper bits are valid.";
            sw = rw; hw = r;
            reset = 0x0;
        } min[15:0];
    } CH_CLIP_Y_CFG @ 0x10C00;
    reg {
        name = "CH_CLIP_C_CFG";
        desc = "CH_CLIP_C_CFG is a chrominance clamp configuration register. (offset 0x10C04; total reset 0xFFFF0000; PROVEN: Hi3521A/Hi3520D V300 data sheet (Issue 00B07, 2015-12-10), section 10.1.6, PDF page 1236).";
        field {
            name = "max";
            desc = "Maximum chrominance value. When the data bit width is less than 16 bits, the upper bits are valid.";
            sw = rw; hw = r;
            reset = 0xffff;
        } max[31:16];
        field {
            name = "min";
            desc = "Minimum chrominance value. When the data bit width is less than 16 bits, the upper bits are valid.";
            sw = rw; hw = r;
            reset = 0x0;
        } min[15:0];
    } CH_CLIP_C_CFG @ 0x10C04;
};
`endif
