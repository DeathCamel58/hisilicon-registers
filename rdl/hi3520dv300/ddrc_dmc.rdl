`ifndef HI3520DV300_DDRC_DMC_RDL
`define HI3520DV300_DDRC_DMC_RDL
regfile eHI3520DV300_DDRC_DMC {
    name = "DDRC DMC";
    desc = "DDRC DMC of the Hi3521A/Hi3520D V300 at base 0x1211_8000. 75 registers extracted programmatically from the Hi3521A/Hi3520D V300 data sheet (Issue 00B07, 2015-12-10) (Table 4-11 Summary of DMC registers (Base address: 0x1211_8000)): register headings, offsets, total reset values, field bit ranges, access types, names, reset values and descriptions, with PDF page numbers in each register description. Field names, bit ranges, access types and offsets are exact; the free-text descriptions are taken from the cell text of the field table and were checked by sampling only. Hardware not verified.";
    reg {
        name = "DDRC_CTRL_SREF";
        desc = "DDRC_CTRL_SREF is a DDRC self-refresh control register. (offset 0x0; total reset 0x00000001; PROVEN: Hi3521A/Hi3520D V300 data sheet (Issue 00B07, 2015-12-10), section 4.1.8.2, PDF page 794).";
        field {
            name = "reserved";
            desc = "Reserved";
            sw = r; hw = w;
            reset = 0x0;
        } reserved_31_2[31:2];
        field {
            name = "sref_done";
            desc = "DDR PHY self-refresh done
- 0: normal operating mode
- 1: The transition from 0 to 1 indicates that the DDR PHY completes all required operations after exiting the self-refresh status and the DMC can accept new requests.";
            sw = rw; hw = r;
            reset = 0x0;
        } sref_done[1:1];
        field {
            name = "sref_req";
            desc = "SDRAM self-refresh request
- 0: exit the self-refresh status
- 1: enter the self-refresh status";
            sw = rw; hw = r;
            reset = 0x1;
        } sref_req[0:0];
    } DDRC_CTRL_SREF @ 0x0;
    reg {
        name = "DDRC_CTRL_SFC";
        desc = "DDRC_CTRL_SFC is a DDRC software configuration command start register. (offset 0xC; total reset 0x00000000; PROVEN: Hi3521A/Hi3520D V300 data sheet (Issue 00B07, 2015-12-10), section 4.1.8.2, PDF page 794).";
        field {
            name = "reserved";
            desc = "Reserved";
            sw = r; hw = w;
            reset = 0x0;
        } reserved_31_1[31:1];
        field {
            name = "cmd_req";
            desc = "Request of executing the configuration command of the DDRC
- 0: The command is not executed or the parameter is automatically cleared after the command is executed.
- 1: The command is requested to be executed.";
            sw = rw; hw = r;
            reset = 0x0;
        } cmd_req[0:0];
    } DDRC_CTRL_SFC @ 0xC;
    reg {
        name = "DDRC_CTRL_PERF";
        desc = "DDRC_CTRL_PERF is a DDRC performance statistics enable register. (offset 0x10; total reset 0x0014F000; PROVEN: Hi3521A/Hi3520D V300 data sheet (Issue 00B07, 2015-12-10), section 4.1.8.2, PDF page 795).";
        field {
            name = "reserved";
            desc = "Reserved";
            sw = r; hw = w;
            reset = 0xa7800;
        } reserved_31_1[31:1];
        field {
            name = "perf_en";
            desc = "Performance statistics mode
- 0: disabled
- 1: enabled

When perf_mode is 0 and this bit is enabled, the performance statistics register starts cyclic counting. When perf_mode is 1, this bit is automatically cleared after counting is complete.";
            sw = rw; hw = r;
            reset = 0x0;
        } perf_en[0:0];
    } DDRC_CTRL_PERF @ 0x10;
    reg {
        name = "DDRC_CFG_SREF";
        desc = "DDRC_CFG_SREF is a DDRC self-refresh configuration register. (offset 0x20; total reset 0x00000000; PROVEN: Hi3521A/Hi3520D V300 data sheet (Issue 00B07, 2015-12-10), section 4.1.8.2, PDF page 796).";
        field {
            name = "asref_en";
            desc = "SDRAM automatic self-refresh enable
- 1: enabled
- 0: disabled

Each rank corresponds to one control bit. The rank automatically enters the self-refresh status only when DDRC_CFG_PD[PD_EN] and the asref_en corresponding to the rank are valid. This function is not supported in this version.";
            sw = r; hw = w;
            reset = 0x0;
        } asref_en[31:16];
        field {
            name = "sref_arefnum";
            desc = "Number of self-refresh operations initiated after DDR3 SDRAM exits the self-refresh status during the DFS process
- 0x0: No self-refresh operation is initiated. 0x1-0xF: n";
            sw = rw; hw = r;
            reset = 0x0;
        } sref_arefnum[15:12];
        field {
            name = "reserved";
            desc = "Reserved";
            sw = r; hw = w;
            reset = 0x0;
        } reserved_11_9[11:9];
        field {
            name = "clk_switch";
            desc = "DDRC low-power clock switch. Whether to back press AXI interface command when the DDRC enters the low-power status (DDR self-refresh)
- 0: The interface commands are not back pressed, and an error is returned directly.
- 1: The interface commands are back pressed, and the original command is executed after the clock is switched.";
            sw = rw; hw = r;
            reset = 0x0;
        } clk_switch[8:8];
        field {
            name = "reserved";
            desc = "Reserved";
            sw = r; hw = w;
            reset = 0x0;
        } reserved_7_5[7:5];
        field {
            name = "sref_odis";
            desc = "Output disable for the DDR command and data I/O in self-refresh mode
- 0: enabled
- 1: disabled

The configuration is a static configuration. It is recommended that this bit be set to 1 to disable the output of the DDR command and data I/O after the DDR enters the self-refresh status. It is recommended that this bit be set to 0 to enable the output of the DDR command and data I/O before the DDR exits the self-refresh status.";
            sw = rw; hw = r;
            reset = 0x0;
        } sref_odis[4:4];
        field {
            name = "reserved";
            desc = "Reserved";
            sw = r; hw = w;
            reset = 0x0;
        } reserved_3_1[3:1];
        field {
            name = "sref_cc";
            desc = "SDRAM clock control in self-refresh mode
- 0: The SDRAM clock is enabled.
- 1: The SDRAM clock is disabled.";
            sw = rw; hw = r;
            reset = 0x0;
        } sref_cc[0:0];
    } DDRC_CFG_SREF @ 0x20;
    reg {
        name = "DDRC_CFG_INIT";
        desc = "DDRC_CFG_INIT is a DDR initialization configuration register. (offset 0x24; total reset 0x00000000; PROVEN: Hi3521A/Hi3520D V300 data sheet (Issue 00B07, 2015-12-10), section 4.1.8.2, PDF page 797).";
        field {
            name = "reserved";
            desc = "Reserved";
            sw = r; hw = w;
            reset = 0x0;
        } reserved_31_8[31:8];
        field {
            name = "init_arefnum";
            desc = "Number of auto-refresh operations when the DDR3 SDRAM is being initialized 0x0-0x2: two 0x3-0xF: n";
            sw = rw; hw = r;
            reset = 0x0;
        } init_arefnum[7:0];
    } DDRC_CFG_INIT @ 0x24;
    reg {
        name = "DDRC_CFG_PD";
        desc = "DDRC_CFG_PD is a DDR power-down status register. (offset 0x28; total reset 0x00000000; PROVEN: Hi3521A/Hi3520D V300 data sheet (Issue 00B07, 2015-12-10), section 4.1.8.2, PDF page 798).";
        field {
            name = "asref_prd";
            desc = "SDRAM self-refresh cycle. When the DDRC does not receive any command in consecutive asref_prd cycles, it forces the SDRAM to enter the self-refresh status. When a command is received, the DDRC forces the SDRAM to exit the self-refresh status. 0x0-0xFFF: (n x 16) clock cycles This field is valid only when asref_en is 1.";
            sw = r; hw = w;
            reset = 0x0;
        } asref_prd[31:20];
        field {
            name = "t_clk_cke";
            desc = "Relationship between CLK and CKE 0x0-0x7: Delay relative to CKE when the DDR PHY disables the DDR3 clock. The delay is related to the DDR PHY. This field can be set to 0 when the clock is disabled.";
            sw = rw; hw = r;
            reset = 0x0;
        } t_clk_cke[19:16];
        field {
            name = "pd_prd";
            desc = "SDRAM power-down cycle. When the DDRC does not receive any command in consecutive pd_prd cycles, it forces the SDRAM to enter the power-down status. When a command is received, the DDRC forces the SDRAM to exit the power-down status.
- 0x00: not enter the power-down status 0x01-0xFFF: n clock cycles

This field is valid only when pd_en is 1.";
            sw = rw; hw = r;
            reset = 0x0;
        } pd_prd[15:4];
        field {
            name = "reserved";
            desc = "Reserved";
            sw = r; hw = w;
            reset = 0x0;
        } reserved_3_2[3:2];
        field {
            name = "pd_ac";
            desc = "SDRAM address command dynamic disable in power-down mode
- 1: disable the pin output
- 0: enable the pin output

This field is valid when pd_en is enabled. The control pins do not include CKE, ODT, CSN, and RESET_N.";
            sw = rw; hw = r;
            reset = 0x0;
        } pd_ac[1:1];
        field {
            name = "pd_en";
            desc = "Automatic power-down enable for the SDRAM
- 1: enabled
- 0: disabled";
            sw = rw; hw = r;
            reset = 0x0;
        } pd_en[0:0];
    } DDRC_CFG_PD @ 0x28;
    reg {
        name = "DDRC_CFG_AREF";
        desc = "DDRC_CFG_AREF is a DDRC auto-refresh mode register. (offset 0x2C; total reset 0x00000000; PROVEN: Hi3521A/Hi3520D V300 data sheet (Issue 00B07, 2015-12-10), section 4.1.8.2, PDF page 799).";
        field {
            name = "reserved";
            desc = "Reserved";
            sw = r; hw = w;
            reset = 0x0;
        } reserved_31_16[31:16];
        field {
            name = "aref_alarm_num";
            desc = "The auto-refresh command is forced to be transmitted if a specific number of auto-refresh commands cannot be transmitted. 0x0-0xFF: lack of (n + 1) auto-refresh commands Only one auto-refresh command is considered when n is 255 because the upper bits are lost after the bits of the 8-bit counter are carried. In optimization mode (when aref_opt is 1), an alarm is generated when the number of postponed commands is greater than or equal to 15.";
            sw = rw; hw = r;
            reset = 0x0;
        } aref_alarm_num[15:8];
        field {
            name = "reserved";
            desc = "Reserved";
            sw = r; hw = w;
            reset = 0x0;
        } reserved_7_5[7:5];
        field {
            name = "aref_alarm_en";
            desc = "Auto-refresh loss alarm enable (AREF function)
- 0: disabled
- 1: enabled";
            sw = rw; hw = r;
            reset = 0x0;
        } aref_alarm_en[4:4];
        field {
            name = "aref_dual_rank";
            desc = "REF command transmit mode select
- 0: The REF commands are transmitted to only one rank each time.
- 1: The REF commands are transmitted to two ranks each time.";
            sw = rw; hw = r;
            reset = 0x0;
        } aref_dual_rank[3:3];
        field {
            name = "aref_opt";
            desc = "Auto-refresh optimization enable
- 1: enabled
- 0: disabled

When this function is enabled, it is recommended that aref_mode be set to 00. The DMC dynamically detects whether the DDR is idle during each auto-refresh. If the DDR is idle, the AREF commands are transmitted; otherwise, the DMC waits until nine AREF cycles are reached. Then the DMC forcibly terminates the DDR access and inserts AREF commands.";
            sw = rw; hw = r;
            reset = 0x0;
        } aref_opt[2:2];
        field {
            name = "aref_mode";
            desc = "Auto-refresh mode
- 00: An auto-refresh operation is performed every one tREFI cycle.
- 01: Three auto-refresh operations are performed every three tREFI cycles.
- 10: Four auto-refresh operations are performed every five tREFI cycles.
- 11: Eight auto-refresh operations are performed every nine tREFI cycles.

Optimized auto-refresh mode
- 11: The maximum number of postponed commands is 8.
- 10: The maximum number of postponed commands is 4.
- 01: The maximum number of postponed commands is 2.
- 00: The maximum number of postponed commands is 1.";
            sw = rw; hw = r;
            reset = 0x0;
        } aref_mode[1:0];
    } DDRC_CFG_AREF @ 0x2C;
    reg {
        name = "DDRC_CFG_WORKMODE";
        desc = "DDRC_CFG_WORKMODE is a DDRC operating mode register. (offset 0x40; total reset 0x00000000; PROVEN: Hi3521A/Hi3520D V300 data sheet (Issue 00B07, 2015-12-10), section 4.1.8.2, PDF page 800).";
        field {
            name = "reserved";
            desc = "Reserved";
            sw = r; hw = w;
            reset = 0x0;
        } reserved_31_14[31:14];
        field {
            name = "hdr_mode";
            desc = "DFI interface mode select
- 0: SDR mode
- 1: HDR mode

The Hi3521A supports only the HDR mode.";
            sw = rw; hw = r;
            reset = 0x0;
        } hdr_mode[13:13];
        field {
            name = "read_mode";
            desc = "DDRC read mode
- 0: associated read mode
- 1: delay read mode

The associated read mode is a mode in which the DDRC samples data based on the data valid signal from the PHY. The delay read mode is a mode in which the DDRC samples the data from the PHY after the internal delay of the DDRC.";
            sw = rw; hw = r;
            reset = 0x0;
        } read_mode[12:12];
        field {
            name = "addr_mode";
            desc = "DDR address line reverse mode select
- 00: The address is set to all 1s when the DDR is idle.
- 01: The status of the previous command is retained when the DDR is idle.
- 10: The status opposite to the previous status is restored when the DDR is idle.
- 11: reserved";
            sw = rw; hw = r;
            reset = 0x0;
        } addr_mode[11:10];
        field {
            name = "intlv_en";
            desc = "DMC burst interleave enable
- 0: disabled
- 1: enabled";
            sw = rw; hw = r;
            reset = 0x0;
        } intlv_en[9:9];
        field {
            name = "wrap_en";
            desc = "Wrap command optimization enable
- 0: disabled
- 1: enabled";
            sw = rw; hw = r;
            reset = 0x0;
        } wrap_en[8:8];
        field {
            name = "reserved";
            desc = "Reserved";
            sw = r; hw = w;
            reset = 0x0;
        } reserved_7_5[7:5];
        field {
            name = "apre_en";
            desc = "Auto-precharge enable
- 0: disabled
- 1: enabled";
            sw = rw; hw = r;
            reset = 0x0;
        } apre_en[4:4];
        field {
            name = "func_clkon";
            desc = "Functional module clock enable
- 0: The clock is internally controlled.
- 1: The clock is forcibly enabled.";
            sw = rw; hw = r;
            reset = 0x0;
        } func_clkon[3:3];
        field {
            name = "data_clkon";
            desc = "Data channel clock enable
- 0: The clock is internally controlled.
- 1: The clock is forcibly enabled.";
            sw = rw; hw = r;
            reset = 0x0;
        } data_clkon[2:2];
        field {
            name = "cmd_clkon";
            desc = "Command channel clock enable
- 0: The clock is internally controlled.
- 1: The clock is forcibly enabled.";
            sw = rw; hw = r;
            reset = 0x0;
        } cmd_clkon[1:1];
        field {
            name = "clk_ratio";
            desc = "Operating mode of the DDRC
- 0: The ratio of the DDRC frequency to the PHY frequency is 1:1.
- 1: The ratio of the frequency of the DDRC to the frequency of the

PHY is 1:2. This field is fixed at 1 in this version.";
            sw = rw; hw = r;
            reset = 0x0;
        } clk_ratio[0:0];
    } DDRC_CFG_WORKMODE @ 0x40;
    reg {
        name = "DDRC_CFG_WORKMODE2";
        desc = "DDRC_CFG_WORKMODE2 is a DDRC operating mode register. (offset 0x44; total reset 0x00000000; PROVEN: Hi3521A/Hi3520D V300 data sheet (Issue 00B07, 2015-12-10), section 4.1.8.2, PDF page 802).";
        field {
            name = "reserved";
            desc = "Reserved";
            sw = r; hw = w;
            reset = 0x0;
        } reserved_31_30[31:30];
        field {
            name = "openpage_time";
            desc = "Open page delay control 0x0-0x1: The open page function is disabled. 0x2-0x3fff: open page delay The open page function is disabled when DDRC_CFG_WORKMODE[apre_en] is enabled.";
            sw = rw; hw = r;
            reset = 0x0;
        } openpage_time[29:16];
        field {
            name = "rank_disable";
            desc = "Rank disable
- 0: normal operating mode
- 1: The auto-refresh/power-down/self-refresh function of a rank is disabled.";
            sw = rw; hw = r;
            reset = 0x0;
        } rank_disable[15:0];
    } DDRC_CFG_WORKMODE2 @ 0x44;
    reg {
        name = "DDRC_CFG_DDRMODE";
        desc = "DDRC_CFG_DDRMODE is a DDR operating mode register. (offset 0x50; total reset 0x00000000; PROVEN: Hi3521A/Hi3520D V300 data sheet (Issue 00B07, 2015-12-10), section 4.1.8.2, PDF page 802).";
        field {
            name = "reserved";
            desc = "Reserved";
            sw = r; hw = w;
            reset = 0x0;
        } reserved_31_31[31:31];
        field {
            name = "bank_mode";
            desc = "Bank interleaving mode For 8-bit bus width:
- 000: 8-byte banks are interleaved.
- 001: 16-byte banks are interleaved. …
- 111: 1 KB banks are interleaved.

For 16-bit bus width:
- 000: 16-byte banks are interleaved.
- 001: 32-byte banks are interleaved. …
- 111: 2 KB banks are interleaved.

For 32-bit bus width:
- 000: 32-byte banks are interleaved.
- 001: 64-byte banks are interleaved. …
- 111: 4 KB banks are interleaved.

For 64-bit bus width:
- 000: 64-byte banks are interleaved.
- 001: 128-byte banks are interleaved. …
- 111: 8 KB banks are interleaved.

When the AXI is set to a non-zero value, this field must be set to 000 and the AXI configuration mode is used. When the AXI is set to 000, the DMC configuration mode is used.";
            sw = rw; hw = r;
            reset = 0x0;
        } bank_mode[30:28];
        field {
            name = "reserved";
            desc = "Reserved";
            sw = r; hw = w;
            reset = 0x0;
        } reserved_27_26[27:26];
        field {
            name = "bank_xor";
            desc = "Scrambling enable for the bank address and row address
- 00: disabled
- 01: The bank address and offset address 0 are scrambled.
- 10: The bank address and offset address 1 are scrambled.
- 11: The bank address and offset address 2 are scrambled.";
            sw = rw; hw = r;
            reset = 0x0;
        } bank_xor[25:24];
        field {
            name = "asref_zqc_en";
            desc = "SDRAM ZQ enable when the ASREF exits.
- 0: disabled
- 1: enabled";
            sw = rw; hw = r;
            reset = 0x0;
        } asref_zqc_en[23:23];
        field {
            name = "sref_zqc_en";
            desc = "SDRAM ZQ enable when the SREF exits.
- 0: disabled
- 1: enabled

This field is valid only for the DDR3 SDRAM and is set to 0 by default. In addition, the value of this field cannot be dynamically changed during the self-refresh exit process.";
            sw = rw; hw = r;
            reset = 0x0;
        } sref_zqc_en[22:22];
        field {
            name = "rank";
            desc = "Number of DDRC ranks
- 00: 1
- 01: 2
- 10: 3
- 11: 4

When the number of external DDR ranks is greater than 4, this field is used to control four groups of ranks (0-3, 4-7, 8-11, and 12-16).";
            sw = rw; hw = r;
            reset = 0x0;
        } rank[21:20];
        field {
            name = "rank_mode";
            desc = "Rank interleaving mode
- 00: single rank mode
- 01: single rank mode
- 10: Two ranks are interleaved.
- 11: Four ranks are interleaved.

Multiple ranks can be interleaved only when the configuration of these ranks is the same; otherwise, unpredictable errors may occur.";
            sw = rw; hw = r;
            reset = 0x0;
        } rank_mode[19:18];
        field {
            name = "odt_on";
            desc = "Whether the ODT signal output to the SDRAM is fixed
- 0: The signal is automatically controlled by the DDRC.
- 1: The output is fixed at the wodt configuration of rank 0.";
            sw = rw; hw = r;
            reset = 0x0;
        } odt_on[17:17];
        field {
            name = "zqc_en";
            desc = "AREF ZQ command enable
- 0: disabled
- 1: enabled";
            sw = rw; hw = r;
            reset = 0x0;
        } zqc_en[16:16];
        field {
            name = "reserved";
            desc = "Reserved";
            sw = r; hw = w;
            reset = 0x0;
        } reserved_15_15[15:15];
        field {
            name = "scramb_en";
            desc = "Data scrambling enable (The scrambling code is generated by using the address, and exclusive ORed with the data to reduce synchronous inversion).
- 0: disabled
- 1: enabled";
            sw = rw; hw = r;
            reset = 0x0;
        } scramb_en[14:14];
        field {
            name = "reserved";
            desc = "Reserved";
            sw = r; hw = w;
            reset = 0x0;
        } reserved_13_13[13:13];
        field {
            name = "bc_en";
            desc = "DDR3 burst chop mode
- 0: disabled
- 1: enabled";
            sw = rw; hw = r;
            reset = 0x0;
        } bc_en[12:12];
        field {
            name = "reserved";
            desc = "Reserved. This bit must be fixed at 1'b0.";
            sw = r; hw = w;
            reset = 0x0;
        } reserved_11_11[11:11];
        field {
            name = "reserved";
            desc = "Reserved";
            sw = r; hw = w;
            reset = 0x0;
        } reserved_10_9[10:9];
        field {
            name = "brstlen";
            desc = "Burst length of the DDRC When brstlen2 is set to 0:
- 1: BL8
- 0: BL4

When brstlen2 is set to 1:
- 1: BL32
- 0: BL16

The burst length of the DDR3 SDRAM can be set to only burst 8. The burst length is related to the clock ratio of the DMC to the PHY. The burst length is BLx/n (x indicates the burst type, that is, 4, 8, 16, or 32. n indicates that the clock ratio of the DMC to the PHY is 1:n). For example, when the clock ratio is 1:2, to set the DDRC burst length to BL32, set brstlen to 0 and brstlen2 to 1.";
            sw = rw; hw = r;
            reset = 0x0;
        } brstlen[8:8];
        field {
            name = "brstlen2";
            desc = "Burst length 2 of the DDRC
- 1: extended mode
- 0: basic mode

This field works with brstlen.";
            sw = rw; hw = r;
            reset = 0x0;
        } brstlen2[7:7];
        field {
            name = "reserved";
            desc = "Reserved";
            sw = r; hw = w;
            reset = 0x0;
        } reserved_6_6[6:6];
        field {
            name = "mem_width";
            desc = "Bit width of the storage data bus
- 00: 8 bits
- 01: 16 bits
- 10: 32 bits
- 11: 64 bits";
            sw = rw; hw = r;
            reset = 0x0;
        } mem_width[5:4];
        field {
            name = "dram_type";
            desc = "External memory type
- 110: DDR3

Other values: reserved";
            sw = rw; hw = r;
            reset = 0x0;
        } dram_type[3:0];
    } DDRC_CFG_DDRMODE @ 0x50;
    reg {
        name = "DDRC_CFG_SCRAMB";
        desc = "DDRC_CFG_SCRAMB is a DDR data scrambling configuration register. (offset 0x58; total reset 0x00000000; PROVEN: Hi3521A/Hi3520D V300 data sheet (Issue 00B07, 2015-12-10), section 4.1.8.2, PDF page 806).";
        field {
            name = "reserved";
            desc = "Reserved";
            sw = r; hw = w;
            reset = 0x0;
        } reserved_31_19[31:19];
        field {
            name = "dbi_low_act";
            desc = "DBI active level
- 0: active high
- 1: active low";
            sw = rw; hw = r;
            reset = 0x0;
        } dbi_low_act[18:18];
        field {
            name = "rd_dbi_en";
            desc = "Read DBI enable
- 0: disabled
- 1: enabled";
            sw = rw; hw = r;
            reset = 0x0;
        } rd_dbi_en[17:17];
        field {
            name = "wr_dbi_en";
            desc = "Read DBI enable
- 0: disabled
- 1: enabled";
            sw = rw; hw = r;
            reset = 0x0;
        } wr_dbi_en[16:16];
        field {
            name = "reserved";
            desc = "Reserved";
            sw = r; hw = w;
            reset = 0x0;
        } reserved_15_5[15:5];
        field {
            name = "scramb_seed_type";
            desc = "Address mode for scrambling
- 0: Use the CS and BA for scrambling.
- 1: Use the CS, BA, and low bits of the row address for scrambling.";
            sw = rw; hw = r;
            reset = 0x0;
        } scramb_seed_type[4:4];
        field {
            name = "reserved";
            desc = "Reserved";
            sw = r; hw = w;
            reset = 0x0;
        } reserved_3_3[3:3];
        field {
            name = "scramb_seed_sort";
            desc = "Address arrangement mode for scrambling
- 000: CS_BA_COL arrangement
- 001: CS_COL_BA arrangement
- 010: COL_CS_BA arrangement
- 011: COL_BA_CS arrangement
- 100: BA_CS_COL arrangement
- 101: BA_COL_CS arrangement

Other values: reserved";
            sw = rw; hw = r;
            reset = 0x0;
        } scramb_seed_sort[2:0];
    } DDRC_CFG_SCRAMB @ 0x58;
    reg {
        name = "DDRC_CFG_RNKVOL";
        desc = "DDRC_CFG_RNKVOL is a DDRC-controlled DDR capacity configuration register. (offset 0x60; total reset 0x00000022; PROVEN: Hi3521A/Hi3520D V300 data sheet (Issue 00B07, 2015-12-10), section 4.1.8.2, PDF page 807).";
        field {
            name = "reserved";
            desc = "Reserved";
            sw = r; hw = w;
            reset = 0x0;
        } reserved_31_17[31:17];
        field {
            name = "mem_x4";
            desc = "4-bit external component combination mode
- 0: 8-/16-/32-bit external components are combined.
- 1: 4-bit external components are combined.";
            sw = rw; hw = r;
            reset = 0x0;
        } mem_x4[16:16];
        field {
            name = "reserved";
            desc = "Reserved";
            sw = r; hw = w;
            reset = 0x0;
        } reserved_15_14[15:14];
        field {
            name = "mem_map";
            desc = "Address translation mode of the SDRAM
- 00: {Rank, Row, Ba, Col, DW} = AXI_Address
- 01: {Rank, Ba, Row, Col, DW}= AXI_Address
- 10: {Rank, Row, Ba, Col, cs, Col, DW}= AXI_Address
- 11: {Rank, Ba, Row, Col, cs, Col, DW}= AXI_Address

This parameter can be set to 10 or 11 only when DDRC_CONFIG1[dual_ch] is valid. When there are multiple ranks, the configuration must be the same for each rank. This field must be set to 00 in the current version.";
            sw = rw; hw = r;
            reset = 0x0;
        } mem_map[13:12];
        field {
            name = "reserved";
            desc = "Reserved";
            sw = r; hw = w;
            reset = 0x0;
        } reserved_11_10[11:10];
        field {
            name = "mem_bank";
            desc = "Number of banks of a single SDRAM
- 00: 4 banks
- 01: 8 banks
- 10:16 banks
- 11: reserved";
            sw = rw; hw = r;
            reset = 0x0;
        } mem_bank[9:8];
        field {
            name = "reserved";
            desc = "Reserved";
            sw = r; hw = w;
            reset = 0x0;
        } reserved_7_7[7:7];
        field {
            name = "mem_row";
            desc = "Bit width of the row address of a single SDRAM
- 000: 11 bits
- 001: 12 bits
- 010: 13 bits
- 011: 14 bits
- 100: 15 bits
- 101: 16 bits

Other values: reserved";
            sw = rw; hw = r;
            reset = 0x2;
        } mem_row[6:4];
        field {
            name = "reserved";
            desc = "Reserved";
            sw = r; hw = w;
            reset = 0x0;
        } reserved_3_3[3:3];
        field {
            name = "mem_col";
            desc = "Bit width of the column address of a single SDRAM
- 000: 8 bits
- 001: 9 bits
- 010: 10 bits
- 011: 11 bits
- 100: 12 bits

Other values: reserved";
            sw = rw; hw = r;
            reset = 0x2;
        } mem_col[2:0];
    } DDRC_CFG_RNKVOL @ 0x60;
    reg {
        name = "DDRC_CFG_ODT";
        desc = "DDRC_CFG_ODT is a DDR ODT configuration register. (offset 0xA0; total reset 0x00000000; PROVEN: Hi3521A/Hi3520D V300 data sheet (Issue 00B07, 2015-12-10), section 4.1.8.2, PDF page 808).";
        field {
            name = "rodt";
            desc = "ODT read enable for other RANKs when the current RANK transmits the read command
- 1: enabled
- 0: disabled";
            sw = rw; hw = r;
            reset = 0x0;
        } rodt[31:16];
        field {
            name = "wodt";
            desc = "ODT write enable for other RANKs when the current RANK transmits the write command
- 1: enabled
- 0: disabled";
            sw = rw; hw = r;
            reset = 0x0;
        } wodt[15:0];
    } DDRC_CFG_ODT @ 0xA0;
    reg {
        name = "DDRC_CFG_EMRS01";
        desc = "DDRC_CFG_EMRS01 is a configuration register for DDR mode register 0 and mode register 1. (offset 0xF0; total reset 0x00000000; PROVEN: Hi3521A/Hi3520D V300 data sheet (Issue 00B07, 2015-12-10), section 4.1.8.2, PDF page 809).";
        field {
            name = "emrs1";
            desc = "DDR3 SDRAM extended mode register 1 This field corresponds to valid bits 13-0 of mode register 1 (MR1) in the DDR3 SDRAM user manual. MR1[15:14] of most DDRs are not used. DDRC_CFG_EMRS01[31:30] are reserved and set to 2'b00. For details about MR1, see the DDR3 SDRAM user manual.";
            sw = rw; hw = r;
            reset = 0x0;
        } emrs1[31:16];
        field {
            name = "mrs";
            desc = "DDR3 SDRAM mode register This field corresponds to valid bits 13-0 of mode register 0 (MR0) in the DDR3 SDRAM user manual. MR0[15:14] of most DDRs are not used. DDRC_CFG_EMRS01[15:14] are reserved and set to 2'b00. For details about MR0, see the DDR3 SDRAM user manual.";
            sw = rw; hw = r;
            reset = 0x0;
        } mrs[15:0];
    } DDRC_CFG_EMRS01 @ 0xF0;
    reg {
        name = "DDRC_CFG_EMRS23";
        desc = "DDRC_CFG_EMRS23 is a configuration register for DDR mode register 2 and mode register 3. (offset 0xF4; total reset 0x00000000; PROVEN: Hi3521A/Hi3520D V300 data sheet (Issue 00B07, 2015-12-10), section 4.1.8.2, PDF page 809).";
        field {
            name = "emrs3";
            desc = "DDR3 SDRAM extended mode register 3 This field corresponds to valid bits 13-0 of mode register 3 (MR3) in the DDR3 SDRAM user manual. MR3[15:14] of most DDRs are not used. DDRC_CFG_EMRS23[31:30] are reserved and set to 2'b00. For details about MR3, see the DDR3 SDRAM user manual.";
            sw = rw; hw = r;
            reset = 0x0;
        } emrs3[31:16];
        field {
            name = "emrs2";
            desc = "DDR3 SDRAM extended mode register 2 This field corresponds to valid bits 13-0 of mode register 2 (MR2) in the DDR3 SDRAM user manual. MR2[15:14] of most DDRs are not used. DDRC_CFG_EMRS23[15:14] are reserved and set to 2'b00. For details about MR2, see the DDR3 SDRAM user manual.";
            sw = rw; hw = r;
            reset = 0x0;
        } emrs2[15:0];
    } DDRC_CFG_EMRS23 @ 0xF4;
    reg {
        name = "DDRC_CFG_TIMING0";
        desc = "DDRC_CFG_TIMING0 is DDRC timing parameter register 0. (offset 0x100; total reset 0xFFFFFF3F; PROVEN: Hi3521A/Hi3520D V300 data sheet (Issue 00B07, 2015-12-10), section 4.1.8.2, PDF page 810).";
        field {
            name = "tmrd";
            desc = "Number of wait cycles for the load mode register (LMR) command. The value is tMRD for the DDR3. 0x0-0x1: 1 clock cycle 0x2-0xF: n clock cycles";
            sw = rw; hw = r;
            reset = 0xf;
        } tmrd[31:28];
        field {
            name = "trrd";
            desc = "Number of wait cycles from ACT bank A to ACT bank B 0x0-0x1: 1 clock cycle 0x2-0xF: n clock cycles";
            sw = rw; hw = r;
            reset = 0xf;
        } trrd[27:24];
        field {
            name = "trp";
            desc = "Number of wait cycles for the disable command (PRE period) 0x0-0x1: 1 clock cycle 0x2-0xF: n clock cycles";
            sw = rw; hw = r;
            reset = 0x1f;
        } trp[23:19];
        field {
            name = "trcd";
            desc = "Number of wait cycles from the ACT bank command to the read or write command 0x0-0x3: 3 clock cycles 0x4-0xF: n clock cycles";
            sw = rw; hw = r;
            reset = 0x1f;
        } trcd[18:14];
        field {
            name = "trc";
            desc = "Number of wait cycles from an ACT bank command to the next ACT bank command 0x00-0x01: 1 clock cycle 0x02-0x3F: n clock cycles";
            sw = rw; hw = r;
            reset = 0x3f;
        } trc[13:8];
        field {
            name = "reserved";
            desc = "Reserved";
            sw = r; hw = w;
            reset = 0x0;
        } reserved_7_6[7:6];
        field {
            name = "tras";
            desc = "Number of wait cycles from the ACT bank command to the disable command (PRE) 0x0-0x1: 1 clock cycle 0x2-0xF: n clock cycles Others: Reserved.";
            sw = rw; hw = r;
            reset = 0x3f;
        } tras[5:0];
    } DDRC_CFG_TIMING0 @ 0x100;
    reg {
        name = "DDRC_CFG_TIMING1";
        desc = "DDRC_CFG_TIMING1 is DDRC timing parameter register 1. (offset 0x84; total reset 0xFF2215FF; PROVEN: Hi3521A/Hi3520D V300 data sheet (Issue 00B07, 2015-12-10), section 4.1.8.2, PDF page 811).";
        field {
            name = "tsre";
            desc = "Number of wait cycles from the self-refresh exit command to the read command
- 0x0: reserved 0x01-0xFF: (n x 4) clock cycles

This field is set to the larger value between tXSDLL and tXS for the DDR3 SDRAM.";
            sw = rw; hw = r;
            reset = 0xff;
        } tsre[31:24];
        field {
            name = "trtw";
            desc = "Delay from the last read data command to the first write data command 0x0-0x1: 1 clock cycle 0x2-0xF: (n + 1) clock cycles In DDR3 mode, the field value depends on the latency of the board, package, and I/O.";
            sw = rw; hw = r;
            reset = 0x2;
        } trtw[23:20];
        field {
            name = "twl";
            desc = "Number of wait cycles from the write command to the write data command 0x0-0x1: 1 clock cycle 0x2-0xF: n clock cycles For example, 0x3 indicates three clock cycles. The clock cycle is the DDR3 clock cycle.";
            sw = rw; hw = r;
            reset = 0x4;
        } twl[19:15];
        field {
            name = "tcl";
            desc = "Column address strobe (CAS) latency from the read command to the read data operation 0x0-0x1: 1 clock cycle 0x2-0xF: n clock cycles The clock cycle is the DDR3 clock cycle.";
            sw = rw; hw = r;
            reset = 0x5;
        } tcl[14:10];
        field {
            name = "reserved";
            desc = "Reserved";
            sw = r; hw = w;
            reset = 0x0;
        } reserved_9_9[9:9];
        field {
            name = "trfc";
            desc = "Number of wait cycles for the AREF period or AREF to the ACT command. The field value is set to the maximum value of max{trfc, tzqcs}.
- 0x00: reserved 0x01-0x1FF: n clock cycles";
            sw = rw; hw = r;
            reset = 0x1ff;
        } trfc[8:0];
    } DDRC_CFG_TIMING1 @ 0x84;
    reg {
        name = "DDRC_CFG_TIMING2";
        desc = "DDRC_CFG_TIMING2 is DDRC timing parameter register 2. (offset 0x108; total reset 0xF303F000; PROVEN: Hi3521A/Hi3520D V300 data sheet (Issue 00B07, 2015-12-10), section 4.1.8.2, PDF page 812).";
        field {
            name = "tcke";
            desc = "Minimum cycle of retaining the self-refresh mode
- 0x0: reserved 0x1-0xF: n clock cycles

The field value must be the maximum value among tCKESR, tCKSRE, tCKSRX, and tCKE.";
            sw = rw; hw = r;
            reset = 0xf;
        } tcke[31:28];
        field {
            name = "twtr";
            desc = "Number of wait cycles for the last write data to the write-to-read command 0x0-0x1: 1 clock cycle 0x2-0xF: n clock cycles For example, 0x3 indicates three clock cycles.";
            sw = rw; hw = r;
            reset = 0x3;
        } twtr[27:24];
        field {
            name = "reserved";
            desc = "Reserved";
            sw = r; hw = w;
            reset = 0x0;
        } reserved_23_18[23:18];
        field {
            name = "tfaw";
            desc = "Number of clock cycles for four consecutive activation commands 0x00-0x3F: n clock cycles For example, 0x14 indicates 20 clock cycles.";
            sw = rw; hw = r;
            reset = 0x3f;
        } tfaw[17:12];
        field {
            name = "reserved";
            desc = "Reserved";
            sw = r; hw = w;
            reset = 0x0;
        } reserved_11_11[11:11];
        field {
            name = "taref";
            desc = "Number of auto-refresh cycles
- 0x000: forbidden 0x001-0x7FF: The auto-refresh cycle of the SDRAM is (16 x n) clock cycles.

For example, 0x008 indicates 128 (16 x 8) clock cycles. The interval tREFI is 7800/16/tclk. Tclk is twice the running cycle of the SDRAM.";
            sw = rw; hw = r;
            reset = 0x0;
        } taref[10:0];
    } DDRC_CFG_TIMING2 @ 0x108;
    reg {
        name = "DDRC_CFG_TIMING3";
        desc = "DDRC_CFG_TIMING3 is DDRC timing parameter register 3. (offset 0x10C; total reset 0xFFFFE0F2; PROVEN: Hi3521A/Hi3520D V300 data sheet (Issue 00B07, 2015-12-10), section 4.1.8.2, PDF page 813).";
        field {
            name = "tzq_prd";
            desc = "Number of ZQCS command cycles
- 0x000: The ZQCS command is forbidden. 0x001-0x3FF: (n x 128) AREF cycles

The number of ZQCS command cycles is equal to (n x 128) taref clock cycles.";
            sw = rw; hw = r;
            reset = 0x3ff;
        } tzq_prd[31:22];
        field {
            name = "tzqinit";
            desc = "Number of ZQ initialization delay cycles 0x0-0x1FF: (n x 4) clock cycles The value needs to be set to the larger value between tZQINIT and tDLLK.";
            sw = rw; hw = r;
            reset = 0x1ff;
        } tzqinit[21:13];
        field {
            name = "taond";
            desc = "Number of ODT enable/disable cycles In DDR3 mode, this value is set to tWL - 2 (tWL is DDRC_CFG_TIMING1[twl]).";
            sw = rw; hw = r;
            reset = 0x0;
        } taond[12:8];
        field {
            name = "txard";
            desc = "Number of wait cycles of exiting the DDR low-power mode 0x0-0xF: n clock cycles (in decimal) For example, 0x7 indicates seven clock cycles. The field value is the maximum value among tXP, tXARD, tXARDS, and tXS. In DDR3 mode, the field value is the larger value between tXP and tCKE.";
            sw = rw; hw = r;
            reset = 0xf;
        } txard[7:4];
        field {
            name = "trtp";
            desc = "Wait delay from the read command to the disable command 000-010: 2 clock cycles";
            sw = rw; hw = r;
            reset = 0x2;
        } trtp[3:0];
    } DDRC_CFG_TIMING3 @ 0x10C;
    reg {
        name = "DDRC_CFG_TIMING4";
        desc = "DDRC_CFG_TIMING4 is DDRC timing parameter register 4. (offset 0x110; total reset 0x01FF2000; PROVEN: Hi3521A/Hi3520D V300 data sheet (Issue 00B07, 2015-12-10), section 4.1.8.2, PDF page 814).";
        field {
            name = "reserved";
            desc = "Reserved";
            sw = r; hw = w;
            reset = 0x0;
        } reserved_31_25[31:25];
        field {
            name = "tmod";
            desc = "Delay from the MRS command to ODT and ZQCL validity 0x0-0x1: 1 clock cycle 0x2-0x1F: n clock cycles";
            sw = rw; hw = r;
            reset = 0x1f;
        } tmod[24:20];
        field {
            name = "reserved";
            desc = "Reserved";
            sw = r; hw = w;
            reset = 0xf2000;
        } reserved_19_0[19:0];
    } DDRC_CFG_TIMING4 @ 0x110;
    reg {
        name = "DDRC_CFG_TIMING5";
        desc = "DDRC_CFG_TIMING5 is DDRC timing parameter register 5. (offset 0x114; total reset 0x1113FF1F; PROVEN: Hi3521A/Hi3520D V300 data sheet (Issue 00B07, 2015-12-10), section 4.1.8.2, PDF page 814).";
        field {
            name = "reserved";
            desc = "Reserved";
            sw = r; hw = w;
            reset = 0x1113;
        } reserved_31_16[31:16];
        field {
            name = "tzqcs";
            desc = "ZQCS calibration delay cycle 0x0-0xFF: (n x 2) clock cycles The field value must be greater than or equal to 10 because of the DMC design.";
            sw = rw; hw = r;
            reset = 0xff;
        } tzqcs[15:8];
        field {
            name = "reserved";
            desc = "Reserved";
            sw = r; hw = w;
            reset = 0x0;
        } reserved_7_5[7:5];
        field {
            name = "twr";
            desc = "Number of wait cycles of write recovery 0x0-0x1: one clock cycle 0x2-0x1F: n clock cycles When the DFS is required, tWR must be set based on the highest chip frequency that may be used. tWR cannot be changed when the DDR frequency changes.";
            sw = rw; hw = r;
            reset = 0x1f;
        } twr[4:0];
    } DDRC_CFG_TIMING5 @ 0x114;
    reg {
        name = "DDRC_CFG_TIMING6";
        desc = "DDRC_CFG_TIMING6 is DDRC timing parameter register 6. (offset 0x118; total reset 0x000000FF; PROVEN: Hi3521A/Hi3520D V300 data sheet (Issue 00B07, 2015-12-10), section 4.1.8.2, PDF page 815).";
        field {
            name = "reserved";
            desc = "Reserved";
            sw = r; hw = w;
            reset = 0x0;
        } reserved_31_24[31:24];
        field {
            name = "trrd_l";
            desc = "Number of trrd wait cycles between bank groups 0x0-0x1: one clock cycle 0x2-0xF: n clock cycles";
            sw = rw; hw = r;
            reset = 0x0;
        } trrd_l[23:20];
        field {
            name = "twtr_l";
            desc = "Number of twtr wait cycles between bank groups 0x0-0x1: one clock cycle 0x2-0xF: n clock cycles";
            sw = rw; hw = r;
            reset = 0x0;
        } twtr_l[19:16];
        field {
            name = "tccd_l";
            desc = "Number of tccd wait cycles between bank groups 0x0-0x1: one clock cycle 0x2-0xF: n clock cycles";
            sw = rw; hw = r;
            reset = 0x0;
        } tccd_l[15:12];
        field {
            name = "reserved";
            desc = "Reserved";
            sw = r; hw = w;
            reset = 0x0;
        } reserved_11_8[11:8];
        field {
            name = "tcksrx";
            desc = "tCKSRX for the DDR3. Number of advanced valid beats before the DDR exits the self-refresh status. 0x0-0x1: one clock cycle 0x2-0xF: n clock cycles";
            sw = rw; hw = r;
            reset = 0xf;
        } tcksrx[7:4];
        field {
            name = "tcksre";
            desc = "tCKSRE for the DDR3. Number of beats to be retained after the DDR enters the self-refresh status. 0x0-0x1: one clock cycle 0x2-0xF: n clock cycles";
            sw = rw; hw = r;
            reset = 0xf;
        } tcksre[3:0];
    } DDRC_CFG_TIMING6 @ 0x118;
    reg {
        name = "DDRC_CFG_NXT_TIMING0";
        desc = "DDRC_CFG_NXT_TIMING0 is DDRC timing parameter register 0 for switching the frequency. (offset 0x120; total reset 0xFFFFFF3F; PROVEN: Hi3521A/Hi3520D V300 data sheet (Issue 00B07, 2015-12-10), section 4.1.8.2, PDF page 816).";
        field {
            name = "tmrd";
            desc = "Number of wait cycles for the loading command of the LMR 0x0 and 0x1: one clock cycle 0x2-0xF: n clock cycles";
            sw = rw; hw = r;
            reset = 0xf;
        } tmrd[31:28];
        field {
            name = "trrd";
            desc = "Number of wait cycles from ACT bank A to ACT bank B 0x0 and 0x1: one clock cycle 0x2-0xF: n clock cycles";
            sw = rw; hw = r;
            reset = 0xf;
        } trrd[27:24];
        field {
            name = "trp";
            desc = "Number of wait cycles for the disable command (PRE period) 0x0 and 0x1: one clock cycle 0x2-0xF: n clock cycles";
            sw = rw; hw = r;
            reset = 0x1f;
        } trp[23:19];
        field {
            name = "trcd";
            desc = "Number of wait cycles from the ACT bank command to the read or write command 0x0-0x3: three clock cycles 0x4-0xF: n clock cycles";
            sw = rw; hw = r;
            reset = 0x1f;
        } trcd[18:14];
        field {
            name = "trc";
            desc = "Number of wait cycles from an ACT bank command to the next ACT bank command 0x00-0x01: one clock cycle 0x02-0x3F: n clock cycles";
            sw = rw; hw = r;
            reset = 0x3f;
        } trc[13:8];
        field {
            name = "reserved";
            desc = "Reserved";
            sw = r; hw = w;
            reset = 0x0;
        } reserved_7_6[7:6];
        field {
            name = "tras";
            desc = "Number of wait cycles from the ACT bank command to the disable command (PRE) 0x00-0x01: one clock cycle 0x02-0x3F: n clock cycles tras is obtained from DDR user manuals. If DDRC_CFG_WORKMODE[clk_ration] is 1, convert the time specified in the DDR user manuals into the DDR clock cycle and then divide it by 2. If the value has a remainder, add 1 to the value. If DDRC_CFG_WORKMODE[clk_ration] is 0, convert the time specified in the DDR user manuals into the DDR clock cycle and then use it directly.";
            sw = rw; hw = r;
            reset = 0x3f;
        } tras[5:0];
    } DDRC_CFG_NXT_TIMING0 @ 0x120;
    reg {
        name = "DDRC_CFG_NXT_TIMING1";
        desc = "DDRC_CFG_NXT_TIMING1 is DDRC timing parameter register 1 for switching the frequency. (offset 0x124; total reset 0xFF2215FF; PROVEN: Hi3521A/Hi3520D V300 data sheet (Issue 00B07, 2015-12-10), section 4.1.8.2, PDF page 817).";
        field {
            name = "tsre";
            desc = "Number of wait cycles from the self-refresh exit command to the read command
- 0x0: one clock cycle 0x01-0xFF: (n x 4) clock cycles

When the DDR3 SDRAM is used, the value is set to tXSDLL.";
            sw = rw; hw = r;
            reset = 0xff;
        } tsre[31:24];
        field {
            name = "trtw";
            desc = "Delay from the last read data command to the first write data command 0x0 and 0x1: one clock cycle 0x2-0xF: (n + 1) clock cycles";
            sw = rw; hw = r;
            reset = 0x2;
        } trtw[23:20];
        field {
            name = "twl";
            desc = "Number of wait cycles from the write command to the data write operation 0x0 and 0x1: one clock cycle 0x2-0xF: n clock cycles For example, 0x3 indicates three clock cycles. The clock cycle is the DDR3 clock cycle.";
            sw = rw; hw = r;
            reset = 0x4;
        } twl[19:15];
        field {
            name = "tcl";
            desc = "Column address strobe latency (CL) from the read command to the data read operation 0x0 and 0x1: one clock cycle 0x2-0xF: n clock cycles The clock cycle is the DDR3 clock cycle.";
            sw = rw; hw = r;
            reset = 0x5;
        } tcl[14:10];
        field {
            name = "reserved";
            desc = "Reserved";
            sw = r; hw = w;
            reset = 0x0;
        } reserved_9_9[9:9];
        field {
            name = "trfc";
            desc = "Number of wait cycles for the AREF period or AREF to the ACT command. The field value is set to the maximum value of max{trfc, tzqcs}. 0x00-0x01: one clock cycle 0x02-0xFF: n clock cycles";
            sw = rw; hw = r;
            reset = 0x1ff;
        } trfc[8:0];
    } DDRC_CFG_NXT_TIMING1 @ 0x124;
    reg {
        name = "DDRC_CFG_NXT_TIMING2";
        desc = "DDRC_CFG_NXT_TIMING2 is DDRC timing parameter register 2 for switching the frequency. (offset 0x128; total reset 0xF303F000; PROVEN: Hi3521A/Hi3520D V300 data sheet (Issue 00B07, 2015-12-10), section 4.1.8.2, PDF page 818).";
        field {
            name = "tcke";
            desc = "Minimum cycle of retaining the low-power mode 0x0 and 0x1: one clock cycle 0x2-0xF: n clock cycles The field value must be the maximum value among tCKESR, tCKSRE, tCKSRX, and tCKE.";
            sw = rw; hw = r;
            reset = 0xf;
        } tcke[31:28];
        field {
            name = "twtr";
            desc = "Number of wait cycles for the last data write operation to the write-to-read command 0x0 and 0x1: one clock cycle 0x2-0xF: n clock cycles For example, 0x3 indicates three clock cycles.";
            sw = rw; hw = r;
            reset = 0x3;
        } twtr[27:24];
        field {
            name = "reserved";
            desc = "Reserved";
            sw = r; hw = w;
            reset = 0x0;
        } reserved_23_18[23:18];
        field {
            name = "tfaw";
            desc = "Number of clock cycles for four consecutive activation commands 0x00-0x3F: n clock cycles For example, 0x14 indicates 20 clock cycles.";
            sw = rw; hw = r;
            reset = 0x3f;
        } tfaw[17:12];
        field {
            name = "reserved";
            desc = "Reserved";
            sw = r; hw = w;
            reset = 0x0;
        } reserved_11_11[11:11];
        field {
            name = "taref";
            desc = "Number of auto-refresh cycles
- 0x000: auto-refresh disabled 0x001-0x7FF: The auto-refresh cycle of the SDRAM is (16 x n) clock cycles.

For example, 0x008 indicates 128 (16 x 8) clock cycles. The interval tREF is 7800/16/tclk. Tclk is the running cycle of the SDRAM.";
            sw = rw; hw = r;
            reset = 0x0;
        } taref[10:0];
    } DDRC_CFG_NXT_TIMING2 @ 0x128;
    reg {
        name = "DDRC_CFG_NXT_TIMING3";
        desc = "DDRC_CFG_NXT_TIMING3 is DDRC timing parameter register 3 for switching the frequency. (offset 0x12C; total reset 0xFFDFF0F2; PROVEN: Hi3521A/Hi3520D V300 data sheet (Issue 00B07, 2015-12-10), section 4.1.8.2, PDF page 819).";
        field {
            name = "tzq_prd";
            desc = "Number of ZQCS command cycles
- 0x000: The ZQCS command is disabled. 0x001-0x3FF: (n x 128) AREF cycles

The time of ZQCS command cycles is equal to (n x 128) taref clock cycles.";
            sw = rw; hw = r;
            reset = 0x3ff;
        } tzq_prd[31:22];
        field {
            name = "tzqinit";
            desc = "Number of ZQ initialization delay cycles 0x0-0x1ff: (n x 4) clock cycles The value needs to be set to the larger value between tZQINIT and tDLLK.";
            sw = rw; hw = r;
            reset = 0xff;
        } tzqinit[21:13];
        field {
            name = "taond";
            desc = "Number of ODT enable/disable cycles In DDR3 mode, the value is set to tWL - 2 (tWL is DDRC_CFG_TIMING1[twl]).";
            sw = rw; hw = r;
            reset = 0x10;
        } taond[12:8];
        field {
            name = "txard";
            desc = "Number of wait cycles of exiting the DDR low-power mode 0x0-0xF: (n x 2) clock cycles. n indicates a decimal value. For example, 0x7 indicates 14 clock cycles. The field value is the maximum value among tXP, tXARD, tXARDS, and tXS.";
            sw = rw; hw = r;
            reset = 0xf;
        } txard[7:4];
        field {
            name = "trtp";
            desc = "Wait delay from the read command to the disable command 0000-0010: two clock cycles 0011-1111: n clock cycles Trtp = AL + BL/2 + Max (trtp, 2) - 2";
            sw = rw; hw = r;
            reset = 0x2;
        } trtp[3:0];
    } DDRC_CFG_NXT_TIMING3 @ 0x12C;
    reg {
        name = "DDRC_CFG_NXT_TIMING4";
        desc = "DDRC_CFG_NXT_TIMING4 is DDRC timing parameter register 4 for switching the frequency. (offset 0x130; total reset 0x01FF2000; PROVEN: Hi3521A/Hi3520D V300 data sheet (Issue 00B07, 2015-12-10), section 4.1.8.2, PDF page 820).";
        field {
            name = "reserved";
            desc = "Reserved";
            sw = rw; hw = r;
            reset = 0x0;
        } reserved_31_25[31:25];
        field {
            name = "tmod";
            desc = "Delay from the MRS command to ODT valid 0x0 and 0x1: one clock cycle 0x02-0x1F: n clock cycles";
            sw = rw; hw = r;
            reset = 0x1f;
        } tmod[24:20];
        field {
            name = "twlo";
            desc = "DDR3 write level status delay parameter 0x0 and 0x1: one clock cycle 0x2-0xF: n clock cycles The parameter is equal to twlo + twloe.";
            sw = rw; hw = r;
            reset = 0xf;
        } twlo[19:16];
        field {
            name = "reserved";
            desc = "Reserved";
            sw = r; hw = w;
            reset = 0x0;
        } reserved_15_14[15:14];
        field {
            name = "twldqsen";
            desc = "DDR3 write level start delay 0x0 and 0x1: one clock cycle 0x2-0x3F: n clock cycles";
            sw = rw; hw = r;
            reset = 0x20;
        } twldqsen[13:8];
        field {
            name = "reserved";
            desc = "Reserved";
            sw = r; hw = w;
            reset = 0x0;
        } reserved_7_6[7:6];
        field {
            name = "twlmrd";
            desc = "Delay of the initial valid DDR3 write level DQS 0x0 and 0x1: one clock cycle 0x2-0x3F: n clock cycles";
            sw = rw; hw = r;
            reset = 0x0;
        } twlmrd[5:0];
    } DDRC_CFG_NXT_TIMING4 @ 0x130;
    reg {
        name = "DDRC_CFG_NXT_TIMING5";
        desc = "DDRC_CFG_NXT_TIMING5 is DDRC timing parameter register 5 for switching the frequency. (offset 0x134; total reset 0x1113FF1F; PROVEN: Hi3521A/Hi3520D V300 data sheet (Issue 00B07, 2015-12-10), section 4.1.8.2, PDF page 821).";
        field {
            name = "reserved";
            desc = "Reserved";
            sw = rw; hw = r;
            reset = 0x1113;
        } reserved_31_16[31:16];
        field {
            name = "tzqcs";
            desc = "ZQCS calibration delay period 0x0-0xFF: (n + 1) clock cycles";
            sw = rw; hw = r;
            reset = 0xff;
        } tzqcs[15:8];
        field {
            name = "reserved";
            desc = "Reserved";
            sw = rw; hw = r;
            reset = 0x0;
        } reserved_7_5[7:5];
        field {
            name = "twr";
            desc = "Number of wait cycles of write recovery 0x0 and 0x1: one clock cycle 0x2-0x1F: n clock cycles When DFS is required, tWR must be set based on the maximum chip frequency that may be used. tWR cannot be changed when the DDR frequency changes.";
            sw = rw; hw = r;
            reset = 0x1f;
        } twr[4:0];
    } DDRC_CFG_NXT_TIMING5 @ 0x134;
    reg {
        name = "DDRC_CFG_NXT_TIMING6";
        desc = "DDRC_CFG_NXT_TIMING6 is DDRC timing parameter register 6 for switching the frequency. (offset 0x138; total reset 0x000000FF; PROVEN: Hi3521A/Hi3520D V300 data sheet (Issue 00B07, 2015-12-10), section 4.1.8.2, PDF page 821).";
        field {
            name = "reserved";
            desc = "Reserved";
            sw = r; hw = w;
            reset = 0x0;
        } reserved_31_24[31:24];
        field {
            name = "trrd_l";
            desc = "Number of trrd wait cycles between bank groups 0x0-0x1: one clock cycle 0x2-0xF: n clock cycles";
            sw = rw; hw = r;
            reset = 0x0;
        } trrd_l[23:20];
        field {
            name = "twtr_l";
            desc = "Number of twtr wait cycles between bank groups 0x0-0x1: one clock cycle 0x2-0xF: n clock cycles";
            sw = rw; hw = r;
            reset = 0x0;
        } twtr_l[19:16];
        field {
            name = "tccd_l";
            desc = "Number of tccd wait cycles between bank groups 0x0-0x1: one clock cycle 0x2-0xF: n clock cycles This field is used to configure the cycle of the DDR clock domain.";
            sw = rw; hw = r;
            reset = 0x0;
        } tccd_l[15:12];
        field {
            name = "reserved";
            desc = "Reserved";
            sw = r; hw = w;
            reset = 0x0;
        } reserved_11_8[11:8];
        field {
            name = "tcksrx";
            desc = "tCKSRX for the DDR3. Number of advanced valid beats before the DDR exits the self-refresh status. 0x0-0x1: one clock cycle 0x2-0xF: n clock cycles";
            sw = rw; hw = r;
            reset = 0xf;
        } tcksrx[7:4];
        field {
            name = "tcksre";
            desc = "tCKSRE for the DDR3. Number of beats to be retained after the DDR enters the self-refresh status. 0x0-0x1: one clock cycle 0x2-0xF: n clock cycles";
            sw = rw; hw = r;
            reset = 0xf;
        } tcksre[3:0];
    } DDRC_CFG_NXT_TIMING6 @ 0x138;
    reg {
        name = "DDRC_CFG_BLDATA";
        desc = "DDRC_CFG_BLDATA is a DDRC pre-received write data configuration register. (offset 0x140; total reset 0x00000002; PROVEN: Hi3521A/Hi3520D V300 data sheet (Issue 00B07, 2015-12-10), section 4.1.8.2, PDF page 822).";
        field {
            name = "reserved";
            desc = "Reserved";
            sw = r; hw = w;
            reset = 0x0;
        } reserved_31_4[31:4];
        field {
            name = "bl_data";
            desc = "Number of DMC data segments corresponding to each DDR command in the current mode 0x0-0xF: n data segments";
            sw = rw; hw = r;
            reset = 0x2;
        } bl_data[3:0];
    } DDRC_CFG_BLDATA @ 0x140;
    reg {
        name = "DDRC_CFG_DMCLVL";
        desc = "DDRC_CFG_DMCLVL is a DDRC command queue depth threshold configuration register. (offset 0x144; total reset 0x00000008; PROVEN: Hi3521A/Hi3520D V300 data sheet (Issue 00B07, 2015-12-10), section 4.1.8.2, PDF page 823).";
        field {
            name = "reserved";
            desc = "Reserved";
            sw = r; hw = w;
            reset = 0x0;
        } reserved_31_13[31:13];
        field {
            name = "mbist_que_level";
            desc = "Number of command buffers started by the DMC when the MTEST or MCLR function is used
- 0x0: 1 0x1-0x10: 1-16. The maximum value is related to the code.";
            sw = rw; hw = r;
            reset = 0x0;
        } mbist_que_level[12:8];
        field {
            name = "reserved";
            desc = "Reserved";
            sw = r; hw = w;
            reset = 0x0;
        } reserved_7_5[7:5];
        field {
            name = "que_level";
            desc = "Depth of the command register FIFO in the DMC 0x1-0x10: depth of n commands Other values: reserved";
            sw = rw; hw = r;
            reset = 0x8;
        } que_level[4:0];
    } DDRC_CFG_DMCLVL @ 0x144;
    reg {
        name = "DDRC_CFG_DDRPHY";
        desc = "DDRC_CFG_DDRPHY is a DDR I/O configuration register. (offset 0x200; total reset 0x001F1000; PROVEN: Hi3521A/Hi3520D V300 data sheet (Issue 00B07, 2015-12-10), section 4.1.8.2, PDF page 823).";
        field {
            name = "reserved";
            desc = "Reserved";
            sw = r; hw = w;
            reset = 0x0;
        } reserved_31_21[31:21];
        field {
            name = "wr_busy_dly";
            desc = "Gating enable for the data beat in the PHY The value of this field must be greater than (WL + 2). This field can be set to 0x1F in scenarios that do not have high requirements on power consumption.";
            sw = rw; hw = r;
            reset = 0x1f;
        } wr_busy_dly[20:16];
        field {
            name = "reserved";
            desc = "Reserved";
            sw = r; hw = w;
            reset = 0x0;
        } reserved_15_13[15:13];
        field {
            name = "phy_upden";
            desc = "Enable of the DDRC response to dfi_phyupd_en of the DDR PHY
- 0: disabled
- 1: enabled";
            sw = rw; hw = r;
            reset = 0x1;
        } phy_upden[12:12];
        field {
            name = "trdlat";
            desc = "Inherent delay of the DDR PHY 0x0-0xF: (n + 1) clock cycles This field needs to be set to 8 when synopsys3/2phy is used.";
            sw = rw; hw = r;
            reset = 0x0;
        } trdlat[11:8];
        field {
            name = "reserved";
            desc = "Reserved";
            sw = r; hw = w;
            reset = 0x0;
        } reserved_7_0[7:0];
    } DDRC_CFG_DDRPHY @ 0x200;
    reg {
        name = "DDRC_CFG_SFC_TIM";
        desc = "DDRC_CFG_SFC_TIM is a DDRC software DDR configuration command timing register. (offset 0x20C; total reset 0x00000000; PROVEN: Hi3521A/Hi3520D V300 data sheet (Issue 00B07, 2015-12-10), section 4.1.8.2, PDF page 824).";
        field {
            name = "reserved";
            desc = "Reserved";
            sw = r; hw = w;
            reset = 0x0;
        } reserved_31_16[31:16];
        field {
            name = "wait_time";
            desc = "Wait period after the DDR command configured by the SFC is executed. This field is valid only when DDRC_CFG_SFC[wait_en] is 1.";
            sw = rw; hw = r;
            reset = 0x0;
        } wait_time[15:0];
    } DDRC_CFG_SFC_TIM @ 0x20C;
    reg {
        name = "DDRC_CFG_SFC";
        desc = "DDRC_CFG_SFC is a DDRC software DDR command attribute register. (offset 0x210; total reset 0x00000000; PROVEN: Hi3521A/Hi3520D V300 data sheet (Issue 00B07, 2015-12-10), section 4.1.8.2, PDF page 825).";
        field {
            name = "wait_en";
            desc = "Enable for exiting a period after the command execution is complete
- 0: disabled
- 1: enabled

The wait period is configured in DDRC_CFG_SFC_TIM.";
            sw = rw; hw = r;
            reset = 0x0;
        } wait_en[31:31];
        field {
            name = "pre_dis";
            desc = "Precharge command transmit disable
- 0: The precharge command is transmitted before the SFC command.
- 1: The precharge command is not transmitted before the SFC command, and the corresponding command is transmitted directly.";
            sw = rw; hw = r;
            reset = 0x0;
        } pre_dis[30:30];
        field {
            name = "reserved";
            desc = "Reserved";
            sw = r; hw = w;
            reset = 0x0;
        } reserved_29_4[29:4];
        field {
            name = "cmd_type";
            desc = "DDR command configuration
- 0000: enter the deep power-down status
- 0001: exit the deep power down mode
- 0010: LMR command
- 0011: ZQCL command. In LPDDRX mode, the ZQ type is controlled by setting cmd_mrs. When cmd_mrs is 0xFF, 0x56, and 0xC3, the ZQ type is ZQINIT, ZQCS, and ZQRESET respectively. When cmd_mrs is set to other values, the ZQ type is

ZQCL.
- 0100: write command
- 0101: read command
- 0110: precharge all command
- 0111: read MRS command
- 1000: AREF command
- 1001: enter the self-refresh status
- 1010: exit the self-refresh status
- 1011: reserved
- 1111: DFI_CTRL_UPD_REQ/DFI_CTRL_UPD_ACK handshake for requesting the PHY to enter the refresh mode (this operation is not supported in this version)";
            sw = rw; hw = r;
            reset = 0x0;
        } cmd_type[3:0];
    } DDRC_CFG_SFC @ 0x210;
    reg {
        name = "DDRC_CFG_SFC_ADDR0";
        desc = "DDRC_CFG_SFC_ADDR0 is read/write memory address register 0 for the software configuration module. (offset 0x214; total reset 0x00000000; PROVEN: Hi3521A/Hi3520D V300 data sheet (Issue 00B07, 2015-12-10), section 4.1.8.2, PDF page 826).";
        field {
            name = "sfc_row";
            desc = "Row address for the memory that is read or written by the software configuration module The maximum address bit width is related to the specifications of the connected component.";
            sw = rw; hw = r;
            reset = 0x0;
        } sfc_row[31:12];
        field {
            name = "sfc_col";
            desc = "Column address for the memory that is read or written by the software configuration module The DDRC access address must be aligned based on the current DMC bit width. For example, if the current DMC bit width is 128 bits: When the 64-/72-bit external DDR is connected, the DMC addresses are accessed based on {sfc_col[15:1], 1'b0}. When the 32-/36-bit external DDR is connected, the DMC addresses are accessed based on {sfc_col[15:2]0.2'b0}.";
            sw = rw; hw = r;
            reset = 0x0;
        } sfc_col[11:0];
    } DDRC_CFG_SFC_ADDR0 @ 0x214;
    reg {
        name = "DDRC_CFG_SFC_WDATA0";
        desc = "DDRC_CFG_SFC_WDATA0 is write data configuration register 0 for the software configuration module. (offset 0x21C; total reset 0x00000000; PROVEN: Hi3521A/Hi3520D V300 data sheet (Issue 00B07, 2015-12-10), section 4.1.8.2, PDF page 826).";
        field {
            name = "wdata0";
            desc = "Bits 31-0 of the written data of the software configuration module";
            sw = rw; hw = r;
            reset = 0x0;
        } wdata0[31:0];
    } DDRC_CFG_SFC_WDATA0 @ 0x21C;
    reg {
        name = "DDRC_CFG_SFC_WDATA1";
        desc = "DDRC_CFG_SFC_WDATA1 is write data configuration register 1 for the software configuration module. (offset 0x220; total reset 0x00000000; PROVEN: Hi3521A/Hi3520D V300 data sheet (Issue 00B07, 2015-12-10), section 4.1.8.2, PDF page 827).";
        field {
            name = "wdata1";
            desc = "Bits 63-32 of the written data of the software configuration module";
            sw = rw; hw = r;
            reset = 0x0;
        } wdata1[31:0];
    } DDRC_CFG_SFC_WDATA1 @ 0x220;
    reg {
        name = "DDRC_CFG_SFC_WDATA2";
        desc = "DDRC_CFG_SFC_WDATA2 is write data configuration register 2 for the software configuration module. (offset 0x224; total reset 0x00000000; PROVEN: Hi3521A/Hi3520D V300 data sheet (Issue 00B07, 2015-12-10), section 4.1.8.2, PDF page 827).";
        field {
            name = "wdata2";
            desc = "Bits 95-64 of the written data of the software configuration module";
            sw = rw; hw = r;
            reset = 0x0;
        } wdata2[31:0];
    } DDRC_CFG_SFC_WDATA2 @ 0x224;
    reg {
        name = "DDRC_CFG_SFC_WDATA3";
        desc = "DDRC_CFG_SFC_WDATA3 is write data configuration register 3 for the software configuration module. (offset 0x228; total reset 0x00000000; PROVEN: Hi3521A/Hi3520D V300 data sheet (Issue 00B07, 2015-12-10), section 4.1.8.2, PDF page 827).";
        field {
            name = "wdata3";
            desc = "Bits 127-96 of the written data of the software configuration module";
            sw = rw; hw = r;
            reset = 0x0;
        } wdata3[31:0];
    } DDRC_CFG_SFC_WDATA3 @ 0x228;
    reg {
        name = "DDRC_CFG_STADAT";
        desc = "DDRC_CFG_STADAT is a DDRC data statistics control register. (offset 0x254; total reset 0x00000000; PROVEN: Hi3521A/Hi3520D V300 data sheet (Issue 00B07, 2015-12-10), section 4.1.8.2, PDF page 828).";
        field {
            name = "reserved";
            desc = "Reserved";
            sw = r; hw = w;
            reset = 0x0;
        } reserved_31_31[31:31];
        field {
            name = "dat_stat_en";
            desc = "DDR data statistics enable
- 0: disabled
- 1: enabled

When dat_stat _mode is 0 and this bit is enabled, the performance statistics register starts cyclic counting. When dat_stat _mode is 1, this bit is automatically cleared after the counting is complete.";
            sw = rw; hw = r;
            reset = 0x0;
        } dat_stat_en[30:30];
        field {
            name = "dat_stat_mode";
            desc = "Data statistical mode 2'b00: continuous trigger mode. Counters related to performance statistics keep counting to ensure that no data overflows within 1s. 2'b01: single trigger mode. When the performance statistical period reaches the value of perf_prd, the statistical result retains and the counting stops. When the statistical period is reached, an interrupt is reported. 2'b10: threshold-based trigger mode. When the statistical period is reached, if the counting value is within the threshold, no interrupt is reported. In this case, a counting is started again until the counting value exceeds the threshold. Then an interrupt is reported and the counting stops. When dat_stat_mode is set to 2'b01 or 2'b10, the statistical result retains after an overflow occurs. When dat_stat_mode is set to 2'b00, the statistical value is wrapped after an overflow occurs.";
            sw = rw; hw = r;
            reset = 0x0;
        } dat_stat_mode[29:28];
        field {
            name = "dat_stat_prd";
            desc = "Data statistical period 0x0-0x1: invalid 0x2-0xFFFFFFF: statistical period The actual statistical period is (load_stat_prd x 16 x tclk). tclk is the bus clock cycle of the DDRC. This configuration is valid only when load_stat_mode is 2'b01 or 2'b10. When load_stat_mode is 0, counters related to performance statistics keep counting.";
            sw = rw; hw = r;
            reset = 0x0;
        } dat_stat_prd[27:0];
    } DDRC_CFG_STADAT @ 0x254;
    reg {
        name = "DDRC_CFG_DATMIN";
        desc = "DDRC_CFG_DATMIN is a DMC data counting minimum threshold register. (offset 0x258; total reset 0x00000000; PROVEN: Hi3521A/Hi3520D V300 data sheet (Issue 00B07, 2015-12-10), section 4.1.8.2, PDF page 829).";
        field {
            name = "reserved";
            desc = "Reserved";
            sw = r; hw = w;
            reset = 0x0;
        } reserved_31_28[31:28];
        field {
            name = "dmc_dat_min";
            desc = "Minimum threshold for data statistics. When the data statistical value is less than or equal to this threshold, an interrupt is reported. The threshold is a multiple of 32. That is, if this field is set to n, the actual threshold is n x 32.";
            sw = rw; hw = r;
            reset = 0x0;
        } dmc_dat_min[27:0];
    } DDRC_CFG_DATMIN @ 0x258;
    reg {
        name = "DDRC_CFG_DATMAX";
        desc = "DDRC_CFG_DATMAX is a DMC data counting maximum threshold register. (offset 0x25C; total reset 0x00000000; PROVEN: Hi3521A/Hi3520D V300 data sheet (Issue 00B07, 2015-12-10), section 4.1.8.2, PDF page 829).";
        field {
            name = "reserved";
            desc = "Reserved";
            sw = r; hw = w;
            reset = 0x0;
        } reserved_31_28[31:28];
        field {
            name = "dmc_dat_max";
            desc = "Maximum threshold for data statistics. When the data statistical value is greater than or equal to this threshold, an interrupt is reported. The threshold is a multiple of 32. That is, if this field is set to n, the actual threshold is n x 32.";
            sw = rw; hw = r;
            reset = 0x0;
        } dmc_dat_max[27:0];
    } DDRC_CFG_DATMAX @ 0x25C;
    reg {
        name = "DDRC_CFG_STACMD";
        desc = "DDRC_CFG_STACMD is a DDR performance statistics mode register. (offset 0x260; total reset 0x00000000; PROVEN: Hi3521A/Hi3520D V300 data sheet (Issue 00B07, 2015-12-10), section 4.1.8.2, PDF page 830).";
        field {
            name = "reserved";
            desc = "Reserved";
            sw = r; hw = w;
            reset = 0x0;
        } reserved_31_31[31:31];
        field {
            name = "load_stat_en";
            desc = "DDR load statistics enable
- 0: disabled
- 1: enabled

When dat_stat_mode is 0 and this bit is enabled, the performance statistics register starts cyclic counting. When load_stat_mode is 1, this bit is automatically cleared after the counting is complete.";
            sw = rw; hw = r;
            reset = 0x0;
        } load_stat_en[30:30];
        field {
            name = "load_stat";
            desc = "Load statistical mode 2'b00: continuous trigger mode. Counters related to performance statistics keep counting to ensure that no data overflows within 1s. 2'b01: single trigger mode. When the performance statistical period reaches the value of perf_prd, the statistical result retains and the counting stops. When the statistical period is reached, an interrupt is reported. _mode 2'b10: threshold-based trigger mode. When the statistical period is reached, if the counting value is within the threshold, no interrupt is reported. In this case, a counting is started again until the counting value exceeds the threshold. Then an interrupt is reported and the counting stops. If the load statistical result exceeds the maximum counting value, the statistical result is wrapped after an overflow occurs.";
            sw = rw; hw = r;
            reset = 0x0;
        } load_stat[29:28];
        field {
            name = "load_stat_prd";
            desc = "Load statistical period 0x0-0x1: invalid 0x2-0xFFFFFFF: statistical period The actual statistical cycle is (perf_prd x 16 x tclk). tclk is the bus clock cycle of the DDRC. This configuration is valid only when perf_mode is 1. When perf_mode is 0, counters related to performance statistics keep counting.";
            sw = rw; hw = r;
            reset = 0x0;
        } load_stat_prd[27:0];
    } DDRC_CFG_STACMD @ 0x260;
    reg {
        name = "DDRC_CFG_CMDMIN";
        desc = "DDRC_CFG_CMDMIN is a DMC command counting minimum threshold register. (offset 0x264; total reset 0x00000000; PROVEN: Hi3521A/Hi3520D V300 data sheet (Issue 00B07, 2015-12-10), section 4.1.8.2, PDF page 831).";
        field {
            name = "reserved";
            desc = "Reserved";
            sw = r; hw = w;
            reset = 0x0;
        } reserved_31_28[31:28];
        field {
            name = "dmc_cmd_min";
            desc = "Minimum threshold for command statistics. When the command statistical value is less than or equal to this threshold, an interrupt is reported. The threshold is a multiple of 32. That is, if this field is set to n, the actual threshold is n x 32.";
            sw = rw; hw = r;
            reset = 0x0;
        } dmc_cmd_min[27:0];
    } DDRC_CFG_CMDMIN @ 0x264;
    reg {
        name = "DDRC_CFG_CMDMAX";
        desc = "DDRC_CFG_CMDMAX is a DMC command counting maximum threshold register. (offset 0x268; total reset 0x00000000; PROVEN: Hi3521A/Hi3520D V300 data sheet (Issue 00B07, 2015-12-10), section 4.1.8.2, PDF page 831).";
        field {
            name = "reserved";
            desc = "Reserved";
            sw = r; hw = w;
            reset = 0x0;
        } reserved_31_28[31:28];
        field {
            name = "dmc_cmd_max";
            desc = "Maximum threshold for command statistics. When the command statistical value is greater than or equal to this threshold, an interrupt is reported. The threshold is a multiple of 32. That is, if this field is set to n, the actual threshold is n x 32.";
            sw = rw; hw = r;
            reset = 0x0;
        } dmc_cmd_max[27:0];
    } DDRC_CFG_CMDMAX @ 0x268;
    reg {
        name = "DDRC_CFG_PERF";
        desc = "DDRC_CFG_PERF is a DDRC performance statistics mode register. (offset 0x270; total reset 0x00000000; PROVEN: Hi3521A/Hi3520D V300 data sheet (Issue 00B07, 2015-12-10), section 4.1.8.2, PDF page 832).";
        field {
            name = "reserved";
            desc = "Reserved";
            sw = r; hw = w;
            reset = 0x0;
        } reserved_31_30[31:30];
        field {
            name = "flux_en";
            desc = "DMC traffic monitoring enable
- 0: disabled
- 1: enabled

When traffic monitoring is enabled, the statistics module provides the number of cycles occupied by the DDR interface by ID to each request port. The traffic can be controlled by using this field and the port traffic setting function.";
            sw = rw; hw = r;
            reset = 0x0;
        } flux_en[29:29];
        field {
            name = "perf_mode";
            desc = "Performance statistical mode
- 0: continuous trigger mode. The performance counter continues to count. This ensures no overflow within 1s in continuous count mode.
- 1: single trigger mode. When the performance statistics time reaches perf_prd, the count value is retained and counting stops.

The maximum statistical result retains after an overflow occurs.";
            sw = rw; hw = r;
            reset = 0x0;
        } perf_mode[28:28];
        field {
            name = "perf_prd";
            desc = "Performance statistics cycle 0x0-0x1: invalid 0x2-0xFFFFFFF: statistical cycles The actual statistics cycle is (perf_prd x 16 x tclk). tclk is the bus clock cycle of the DDRC. This field is valid only when perf_mode is 1. When perf_mode is 0, the performance counter keeps on counting.";
            sw = rw; hw = r;
            reset = 0x0;
        } perf_prd[27:0];
    } DDRC_CFG_PERF @ 0x270;
    reg {
        name = "DDRC_CFG_STAID";
        desc = "DDRC_CFG_STAID is a DDRC performance statistics command ID register. (offset 0x274; total reset 0x00000000; PROVEN: Hi3521A/Hi3520D V300 data sheet (Issue 00B07, 2015-12-10), section 4.1.8.2, PDF page 833).";
        field {
            name = "reserved";
            desc = "Reserved";
            sw = r; hw = w;
            reset = 0x0;
        } reserved_31_16[31:16];
        field {
            name = "sta_id";
            desc = "Performance statistics by a specified ID. This field works with sta_idmask.";
            sw = rw; hw = r;
            reset = 0x0;
        } sta_id[15:0];
    } DDRC_CFG_STAID @ 0x274;
    reg {
        name = "DDRC_CFG_STAIDMSK";
        desc = "DDRC_CFG_STAIDMSK is a DDR performance statistics command ID mask register. (offset 0x278; total reset 0x00001FFF; PROVEN: Hi3521A/Hi3520D V300 data sheet (Issue 00B07, 2015-12-10), section 4.1.8.2, PDF page 833).";
        field {
            name = "reserved";
            desc = "Reserved";
            sw = r; hw = w;
            reset = 0x0;
        } reserved_31_16[31:16];
        field {
            name = "sta_idmask";
            desc = "Specified ID mask The DDRC performance statistics register collects statistics only for specified ID commands. Cmd_id (ID of the command in the DDRC) & sta_idmask = sta_id";
            sw = rw; hw = r;
            reset = 0x1fff;
        } sta_idmask[15:0];
    } DDRC_CFG_STAIDMSK @ 0x278;
    reg {
        name = "DDRC_INTMSK";
        desc = "DDRC_INTMSK is a DDRC interrupt mask register. (offset 0x280; total reset 0x00000000; PROVEN: Hi3521A/Hi3520D V300 data sheet (Issue 00B07, 2015-12-10), section 4.1.8.2, PDF page 834).";
        field {
            name = "reserved";
            desc = "Reserved";
            sw = r; hw = w;
            reset = 0x0;
        } reserved_31_13[31:13];
        field {
            name = "rdtimeout_int_mask";
            desc = "DDR PHY read data timeout interrupt mask enable
- 0: not masked
- 1: masked";
            sw = rw; hw = r;
            reset = 0x0;
        } rdtimeout_int_mask[12:12];
        field {
            name = "reserved";
            desc = "Reserved";
            sw = r; hw = w;
            reset = 0x0;
        } reserved_11_10[11:10];
        field {
            name = "load_int_mask";
            desc = "DDR load statistical period reach interrupt mask enable
- 0: not masked
- 1: masked";
            sw = rw; hw = r;
            reset = 0x0;
        } load_int_mask[9:9];
        field {
            name = "reserved";
            desc = "Reserved";
            sw = r; hw = w;
            reset = 0x0;
        } reserved_8_6[8:6];
        field {
            name = "sref_err_int_mask";
            desc = "Command interface access error interrupt mask enable in DDR self-refresh mode
- 0: not masked
- 1: masked";
            sw = rw; hw = r;
            reset = 0x0;
        } sref_err_int_mask[5:5];
        field {
            name = "reserved";
            desc = "Reserved";
            sw = r; hw = w;
            reset = 0x0;
        } reserved_4_2[4:2];
        field {
            name = "flux_int_mask";
            desc = "DDR FLUX statistical period reach interrupt mask enable
- 0: not masked
- 1: masked";
            sw = rw; hw = r;
            reset = 0x0;
        } flux_int_mask[1:1];
        field {
            name = "reserved";
            desc = "Reserved";
            sw = r; hw = w;
            reset = 0x0;
        } reserved_0_0[0:0];
    } DDRC_INTMSK @ 0x280;
    reg {
        name = "DDRC_RINT";
        desc = "DDRC_RINT is a DDRC raw interrupt register. (offset 0x284; total reset 0x00000000; PROVEN: Hi3521A/Hi3520D V300 data sheet (Issue 00B07, 2015-12-10), section 4.1.8.2, PDF page 835).";
        field {
            name = "reserved";
            desc = "Reserved";
            sw = r; hw = w;
            reset = 0x0;
        } reserved_31_17[31:17];
        field {
            name = "aref_alarm_rint";
            desc = "DDR AREF command error raw interrupt. Writing 1 clears the interrupt.

Access type INT_WC in the data sheet: written 1 clears the bit.";
            sw = rw; hw = w; onwrite = woclr;
            reset = 0x0;
        } aref_alarm_rint[16:16];
        field {
            name = "reserved";
            desc = "Reserved";
            sw = r; hw = w;
            reset = 0x0;
        } reserved_15_13[15:13];
        field {
            name = "rdtimeout_rint";
            desc = "DDR PHY read data timeout raw interrupt. Writing 1 clears the interrupt.

Access type INT_WC in the data sheet: written 1 clears the bit.";
            sw = rw; hw = w; onwrite = woclr;
            reset = 0x0;
        } rdtimeout_rint[12:12];
        field {
            name = "reserved";
            desc = "Reserved";
            sw = r; hw = w;
            reset = 0x0;
        } reserved_11_10[11:10];
        field {
            name = "load_rint";
            desc = "DDR load statistical period reach interrupt. Writing 1 clears the interrupt.

Access type INT_WC in the data sheet: written 1 clears the bit.";
            sw = rw; hw = w; onwrite = woclr;
            reset = 0x0;
        } load_rint[9:9];
        field {
            name = "reserved";
            desc = "Reserved";
            sw = r; hw = w;
            reset = 0x0;
        } reserved_8_6[8:6];
        field {
            name = "sref_err_rint";
            desc = "Self-refresh interface command access interrupt. Writing 1 clears the interrupt.

Access type INT_WC in the data sheet: written 1 clears the bit.";
            sw = rw; hw = w; onwrite = woclr;
            reset = 0x0;
        } sref_err_rint[5:5];
        field {
            name = "reserved";
            desc = "Reserved";
            sw = r; hw = w;
            reset = 0x0;
        } reserved_4_2[4:2];
        field {
            name = "flux_rint";
            desc = "DDR FLUX statistics period reach interrupt. Writing 1 clears the interrupt.

Access type RW in the data sheet; the description says the bit is cleared by writing 1, modeled as write-one-to-clear (INFERRED).";
            sw = rw; hw = w; onwrite = woclr;
            reset = 0x0;
        } flux_rint[1:1];
        field {
            name = "reserved";
            desc = "Reserved";
            sw = r; hw = w;
            reset = 0x0;
        } reserved_0_0[0:0];
    } DDRC_RINT @ 0x284;
    reg {
        name = "DDRC_INTSTS";
        desc = "DDRC_INTSTS is a DDRC interrupt status register. (offset 0x288; total reset 0x00000000; PROVEN: Hi3521A/Hi3520D V300 data sheet (Issue 00B07, 2015-12-10), section 4.1.8.2, PDF page 836).";
        field {
            name = "reserved";
            desc = "Reserved";
            sw = r; hw = w;
            reset = 0x0;
        } reserved_31_17[31:17];
        field {
            name = "aref_alarm_intsts";
            desc = "DDR AREF command error interrupt

Access type INT (interrupt status) in the data sheet.";
            sw = r; hw = w;
            reset = 0x0;
        } aref_alarm_intsts[16:16];
        field {
            name = "reserved";
            desc = "Reserved";
            sw = r; hw = w;
            reset = 0x0;
        } reserved_15_13[15:13];
        field {
            name = "rdtimeout_intsts";
            desc = "DDR PHY read data timeout interrupt

Access type INT (interrupt status) in the data sheet.";
            sw = r; hw = w;
            reset = 0x0;
        } rdtimeout_intsts[12:12];
        field {
            name = "reserved";
            desc = "Reserved";
            sw = r; hw = w;
            reset = 0x0;
        } reserved_11_10[11:10];
        field {
            name = "load_intsts";
            desc = "DDR load statistical period reach interrupt

Access type INT (interrupt status) in the data sheet.";
            sw = r; hw = w;
            reset = 0x0;
        } load_intsts[9:9];
        field {
            name = "reserved";
            desc = "Reserved";
            sw = r; hw = w;
            reset = 0x0;
        } reserved_8_6[8:6];
        field {
            name = "sref_err_intsts";
            desc = "Self-refresh interface command access interrupt

Access type INT (interrupt status) in the data sheet.";
            sw = r; hw = w;
            reset = 0x0;
        } sref_err_intsts[5:5];
        field {
            name = "reserved";
            desc = "Reserved";
            sw = r; hw = w;
            reset = 0x0;
        } reserved_4_2[4:2];
        field {
            name = "flux_intsts";
            desc = "DDR FLUX statistics period reach interrupt";
            sw = rw; hw = r;
            reset = 0x0;
        } flux_intsts[1:1];
        field {
            name = "reserved";
            desc = "Reserved";
            sw = r; hw = w;
            reset = 0x0;
        } reserved_0_0[0:0];
    } DDRC_INTSTS @ 0x288;
    reg {
        name = "DDRC_CURR_STATUS";
        desc = "DDRC_CURR_STATUS is a DDRC status register. (offset 0x290; total reset 0x00000101; PROVEN: Hi3521A/Hi3520D V300 data sheet (Issue 00B07, 2015-12-10), section 4.1.8.2, PDF page 836).";
        field {
            name = "reserved";
            desc = "Reserved";
            sw = r; hw = w;
            reset = 0x0;
        } reserved_31_9[31:9];
        field {
            name = "busy_func";
            desc = "Status of the DDRC FUNC module. This field is in the SREF status during reset.
- 0: idle
- 1: A command is being processed.";
            sw = r; hw = w;
            reset = 0x1;
        } busy_func[8:8];
        field {
            name = "reserved";
            desc = "Reserved";
            sw = r; hw = w;
            reset = 0x0;
        } reserved_7_5[7:5];
        field {
            name = "busy_dmc";
            desc = "Status of the DDRC DMC
- 0: idle
- 1: A command is being processed.";
            sw = r; hw = w;
            reset = 0x0;
        } busy_dmc[4:4];
        field {
            name = "reserved";
            desc = "Reserved";
            sw = r; hw = w;
            reset = 0x0;
        } reserved_3_1[3:1];
        field {
            name = "busy";
            desc = "Overall status of the DDRC
- 0: idle
- 1: A command is being processed.";
            sw = r; hw = w;
            reset = 0x1;
        } busy[0:0];
    } DDRC_CURR_STATUS @ 0x290;
    reg {
        name = "DDRC_CURR_FUNC";
        desc = "DDRC_CURR_FUNC is a DDRC FUNC module status register. (offset 0x294; total reset 0x00000001; PROVEN: Hi3521A/Hi3520D V300 data sheet (Issue 00B07, 2015-12-10), section 4.1.8.2, PDF page 837).";
        field {
            name = "reserved";
            desc = "Reserved";
            sw = r; hw = w;
            reset = 0x0;
        } reserved_31_13[31:13];
        field {
            name = "in_sfc";
            desc = "DDRC SFC status
- 0: idle
- 1: An SFC command is being processed.";
            sw = r; hw = w;
            reset = 0x0;
        } in_sfc[12:12];
        field {
            name = "reserved";
            desc = "Reserved";
            sw = r; hw = w;
            reset = 0x0;
        } reserved_11_9[11:9];
        field {
            name = "aref_opt_stat";
            desc = "Auto-refresh optimization mode status
- 1: The DDR is in optimization mode.
- 0: The DDR exits the optimization mode

Before the DDR SDRAM enters the self-refresh status through configuration or requests over the csysreq interface, ensure that the DDR SDRAM exits the auto-refresh optimization mode. This is because some postponed commands may not be transmitted in self-refresh optimization mode.";
            sw = r; hw = w;
            reset = 0x0;
        } aref_opt_stat[8:8];
        field {
            name = "reserved";
            desc = "Reserved";
            sw = r; hw = w;
            reset = 0x0;
        } reserved_7_1[7:1];
        field {
            name = "in_sref";
            desc = "DDR self-refresh status
- 0: normal
- 1: self-refresh.";
            sw = r; hw = w;
            reset = 0x1;
        } in_sref[0:0];
    } DDRC_CURR_FUNC @ 0x294;
    reg {
        name = "DDRC_CURR_FUNC2";
        desc = "DDRC_CURR_FUNC2 is a DDRC FUNC2 module status register. (offset 0x298; total reset 0x00000000; PROVEN: Hi3521A/Hi3520D V300 data sheet (Issue 00B07, 2015-12-10), section 4.1.8.2, PDF page 838). The data sheet prints in_asref as [31:15], which overlaps in_pd [15:0]; in_asref is taken as [31:16] (16 bits, one per rank, like in_pd). INFERRED: the [31:16] range of in_asref.";
        field {
            name = "in_asref";
            desc = "DDRC automatic self-refresh status
- 1: automatic self-refresh status
- 0: normal status

Each bit represents a rank. (INFERRED range: the data sheet prints [31:15], which overlaps in_pd.)";
            sw = r; hw = w;
            reset = 0x0;
        } in_asref[31:16];
        field {
            name = "in_pd";
            desc = "DDRC power-down status
- 1: power-down status
- 0: normal status

Each bit represents a rank.";
            sw = r; hw = w;
            reset = 0x0;
        } in_pd[15:0];
    } DDRC_CURR_FUNC2 @ 0x298;
    reg {
        name = "DDRC_CURR_EXECST";
        desc = "DDRC_CURR_EXECST is a DDRC command state machine status register. (offset 0x2A0; total reset 0x00000000; PROVEN: Hi3521A/Hi3520D V300 data sheet (Issue 00B07, 2015-12-10), section 4.1.8.2, PDF page 839).";
        field {
            name = "dmc_ct";
            desc = "Controller command type
- 0: read command
- 1: write command";
            sw = r; hw = w;
            reset = 0x0;
        } dmc_ct[31:16];
        field {
            name = "dmc_cv";
            desc = "Controller command validity flag
- 0: invalid
- 1: valid";
            sw = r; hw = w;
            reset = 0x0;
        } dmc_cv[15:0];
    } DDRC_CURR_EXECST @ 0x2A0;
    reg {
        name = "DDRC_CURR_WGFIFOST";
        desc = "DDRC_CURR_WGFIFOST is a DDRC write data FIFO status register. (offset 0x2A4; total reset 0x00000001; PROVEN: Hi3521A/Hi3520D V300 data sheet (Issue 00B07, 2015-12-10), section 4.1.8.2, PDF page 839).";
        field {
            name = "reserved";
            desc = "Reserved";
            sw = r; hw = w;
            reset = 0x0;
        } reserved_31_1[31:1];
        field {
            name = "wgntfifo_e";
            desc = "WGNT_FIFO empty or full status. The empty status indicates that all written data is received, and the non-empty status indicates that the written data is not completely received.
- 0: not empty
- 1: empty";
            sw = r; hw = w;
            reset = 0x1;
        } wgntfifo_e[0:0];
    } DDRC_CURR_WGFIFOST @ 0x2A4;
    reg {
        name = "DDRC_HIS_FLUX_WR";
        desc = "DDRC_HIS_FLUX_WR is a DDRC all write command traffic statistics register. (offset 0x380; total reset 0x00000000; PROVEN: Hi3521A/Hi3520D V300 data sheet (Issue 00B07, 2015-12-10), section 4.1.8.2, PDF page 840).";
        field {
            name = "flux_wr";
            desc = "Write traffic statistics of all masters with the IDs of the DDRC. The counting is performed in the valid statistics cycle. The unit is the DMC bit width. When perf_mode is 0, the value is wrapped when an overflow occurs. When perf_mode is 1, the value is retained when an overflow occurs. This field is cleared when the next statistics start.";
            sw = r; hw = w;
            reset = 0x0;
        } flux_wr[31:0];
    } DDRC_HIS_FLUX_WR @ 0x380;
    reg {
        name = "DDRC_HIS_FLUX_RD";
        desc = "DDRC_HIS_FLUX_RD is a DDRC all read command traffic statistics register. (offset 0x384; total reset 0x00000000; PROVEN: Hi3521A/Hi3520D V300 data sheet (Issue 00B07, 2015-12-10), section 4.1.8.2, PDF page 840).";
        field {
            name = "flux_rd";
            desc = "Read traffic statistics of all masters with the IDs of the DDRC. The counting is performed in the valid statistics cycle. The unit is the DMC bit width. When perf_mode is 0, the value is wrapped when an overflow occurs. When perf_mode is 1, the value is retained when an overflow occurs. This field is cleared when the next statistics start.";
            sw = r; hw = w;
            reset = 0x0;
        } flux_rd[31:0];
    } DDRC_HIS_FLUX_RD @ 0x384;
    reg {
        name = "DDRC_HIS_FLUX_WCMD";
        desc = "DDRC_HIS_FLUX_WCMD is a DDRC all write command count register. (offset 0x388; total reset 0x00000000; PROVEN: Hi3521A/Hi3520D V300 data sheet (Issue 00B07, 2015-12-10), section 4.1.8.2, PDF page 841).";
        field {
            name = "flux_wr_cmd";
            desc = "Write command count of the masters with all IDs of the DDRC. The counting is performed in the valid statistics cycle. When perf_mode is 0, the value is wrapped when an overflow occurs. When perf_mode is 1, the value is retained when an overflow occurs. This field is cleared when the next statistics start.";
            sw = r; hw = w;
            reset = 0x0;
        } flux_wr_cmd[31:0];
    } DDRC_HIS_FLUX_WCMD @ 0x388;
    reg {
        name = "DDRC_HIS_FLUX_RCMD";
        desc = "DDRC_HIS_FLUX_RCMD is a DDRC all read command count register. (offset 0x38C; total reset 0x00000000; PROVEN: Hi3521A/Hi3520D V300 data sheet (Issue 00B07, 2015-12-10), section 4.1.8.2, PDF page 841).";
        field {
            name = "flux_rd_cmd";
            desc = "Read command count of the masters with all IDs of the DDRC. The counting is performed in the valid statistics cycle. When perf_mode is 0, the value is wrapped when an overflow occurs. When perf_mode is 1, the value is retained when an overflow occurs. This field is cleared when the next statistics start.";
            sw = r; hw = w;
            reset = 0x0;
        } flux_rd_cmd[31:0];
    } DDRC_HIS_FLUX_RCMD @ 0x38C;
    reg {
        name = "DDRC_HIS_FLUXID_WR";
        desc = "DDRC_HIS_FLUXID_WR is a DDRC specified ID write traffic statistics registers. (offset 0x390; total reset 0x00000000; PROVEN: Hi3521A/Hi3520D V300 data sheet (Issue 00B07, 2015-12-10), section 4.1.8.2, PDF page 842).";
        field {
            name = "fluxid_wr";
            desc = "Write traffic statistics of the master with the specified ID of the DDRC. The counting is performed in the valid statistics cycle. When perf_mode is 0, the value is wrapped when an overflow occurs. When perf_mode is 1, the value is retained when an overflow occurs. This field is cleared when the next statistics start. The unit is the DMC data bit width (128 bits).";
            sw = r; hw = w;
            reset = 0x0;
        } fluxid_wr[31:0];
    } DDRC_HIS_FLUXID_WR @ 0x390;
    reg {
        name = "DDRC_HIS_FLUXID_RD";
        desc = "DDRC_HIS_FLUXID_RD is a DDRC specified ID read traffic statistics registers. (offset 0x394; total reset 0x00000000; PROVEN: Hi3521A/Hi3520D V300 data sheet (Issue 00B07, 2015-12-10), section 4.1.8.2, PDF page 842).";
        field {
            name = "fluxid_rd";
            desc = "Read traffic statistics of the master with the specified ID of the DDRC. The counting is performed in the valid statistics cycle. When perf_mode is 0, the value is wrapped when an overflow occurs. When perf_mode is 1, the value is retained when an overflow occurs. This field is cleared when the next statistics start. The unit is the DMC data bit width (128 bits).";
            sw = r; hw = w;
            reset = 0x0;
        } fluxid_rd[31:0];
    } DDRC_HIS_FLUXID_RD @ 0x394;
    reg {
        name = "DDRC_HIS_FLUXID_WCMD";
        desc = "DDRC_HIS_FLUXID_WCMD is a DDRC all ID write command count register. (offset 0x398; total reset 0x00000000; PROVEN: Hi3521A/Hi3520D V300 data sheet (Issue 00B07, 2015-12-10), section 4.1.8.2, PDF page 843).";
        field {
            name = "fluxid_wr_cmd";
            desc = "Read traffic statistics of the master based on specified IDs. The counting is performed in the valid statistics cycle. When perf_mode is 0, the value is wrapped when an overflow occurs. When perf_mode is 1, the value is retained when an overflow occurs. This field is cleared when the next statistics start.";
            sw = r; hw = w;
            reset = 0x0;
        } fluxid_wr_cmd[31:0];
    } DDRC_HIS_FLUXID_WCMD @ 0x398;
    reg {
        name = "DDRC_HIS_FLUXID_RCMD";
        desc = "DDRC_HIS_FLUXID_RCMD is a DDRC all ID read command count register. (offset 0x39C; total reset 0x00000000; PROVEN: Hi3521A/Hi3520D V300 data sheet (Issue 00B07, 2015-12-10), section 4.1.8.2, PDF page 843).";
        field {
            name = "fluxid_rd_cmd";
            desc = "Read command count of the master based on specified IDs. The counting is performed in the valid statistics cycle. When perf_mode is 0, the value is wrapped when an overflow occurs. When perf_mode is 1, the value is retained when an overflow occurs. This field is cleared when the next statistics start.";
            sw = r; hw = w;
            reset = 0x0;
        } fluxid_rd_cmd[31:0];
    } DDRC_HIS_FLUXID_RCMD @ 0x39C;
    reg {
        name = "DDRC_HIS_WLATCNT0";
        desc = "DDRC_HIS_WLATCNT0 is DDRC specified ID write command latency statistics register 0. (offset 0x3A0; total reset 0x0000FFFF; PROVEN: Hi3521A/Hi3520D V300 data sheet (Issue 00B07, 2015-12-10), section 4.1.8.2, PDF page 844).";
        field {
            name = "wlatcnt_max";
            desc = "Maximum latency of the write command with the specified ID of the DDRC This field is cleared when the next statistics start.";
            sw = r; hw = w;
            reset = 0x0;
        } wlatcnt_max[31:16];
        field {
            name = "wlatcnt_min";
            desc = "Minimum latency of the write command with the specified ID of the DDRC. The maximum value is retained if an overflow occurs. This field is cleared when the next statistics start.";
            sw = r; hw = w;
            reset = 0xffff;
        } wlatcnt_min[15:0];
    } DDRC_HIS_WLATCNT0 @ 0x3A0;
    reg {
        name = "DDRC_HIS_WLATCNT1";
        desc = "DDRC_HIS_WLATCNT1 is DDRC specified ID write command latency statistics register 1. (offset 0x3A4; total reset 0x00000000; PROVEN: Hi3521A/Hi3520D V300 data sheet (Issue 00B07, 2015-12-10), section 4.1.8.2, PDF page 844).";
        field {
            name = "wlatcnt_all";
            desc = "Accumulated latency of the write command with the specified ID in the statistics cycle (the results of the lower four bits are ignored) When perf_mode is 0, the value is wrapped when an overflow occurs. When perf_mode is 1, the value is retained when an overflow occurs. This field is cleared when the next statistics start. Software can obtain the average latency of the write command with the specified ID by dividing wlatcnt_all by fluxid_wr_cmd.";
            sw = r; hw = w;
            reset = 0x0;
        } wlatcnt_all[31:0];
    } DDRC_HIS_WLATCNT1 @ 0x3A4;
    reg {
        name = "DDRC_HIS_RLATCNT0";
        desc = "DDRC_HIS_RLATCNT0 is a DDRC specified ID read command latency statistics register 0. (offset 0x3A8; total reset 0x0000FFFF; PROVEN: Hi3521A/Hi3520D V300 data sheet (Issue 00B07, 2015-12-10), section 4.1.8.2, PDF page 845).";
        field {
            name = "rlatcnt_max";
            desc = "Maximum latency of the read command with the specified ID of the DDRC The actual maximum read latency is rlatcnt_max plus inhere_rlatcnt. The maximum value is retained if an overflow occurs. This field is cleared when the next statistics start.";
            sw = r; hw = w;
            reset = 0x0;
        } rlatcnt_max[31:16];
        field {
            name = "rlatcnt_min";
            desc = "Minimum latency of the read command with the specified ID of the DDRC Note that the actual minimum read latency is rlatcnt_min plus inhere_rlatcnt. The maximum value is retained if an overflow occurs. This field is cleared when the next statistics start.";
            sw = r; hw = w;
            reset = 0xffff;
        } rlatcnt_min[15:0];
    } DDRC_HIS_RLATCNT0 @ 0x3A8;
    reg {
        name = "DDRC_HIS_RLATCNT1";
        desc = "DDRC_HIS_RLATCNT1 is DDRC specified ID read command latency statistics register 1. (offset 0x3AC; total reset 0x00000000; PROVEN: Hi3521A/Hi3520D V300 data sheet (Issue 00B07, 2015-12-10), section 4.1.8.2, PDF page 845).";
        field {
            name = "rlatcnt_all";
            desc = "Accumulated latency of the read command with the specified ID in the statistics cycle (the results of the lower four bits are ignored) When perf_mode is 0, the value is wrapped when an overflow occurs. When perf_mode is 1, the value is retained when an overflow occurs. This field is cleared when the next statistics start. Software can obtain the average latency of the read command with the specified ID by using rlatcnt_all/fluxid_rd_cmd+inhere_rlatcnt.";
            sw = r; hw = w;
            reset = 0x0;
        } rlatcnt_all[31:0];
    } DDRC_HIS_RLATCNT1 @ 0x3AC;
    reg {
        name = "DDRC_HIS_INHERE_RLAT_CNT";
        desc = "DDRC_HIS_INHERE_RLAT_CNT is a read channel inherent latency register. (offset 0x3B0; total reset 0x00000000; PROVEN: Hi3521A/Hi3520D V300 data sheet (Issue 00B07, 2015-12-10), section 4.1.8.2, PDF page 846).";
        field {
            name = "reserved";
            desc = "Reserved";
            sw = r; hw = w;
            reset = 0x0;
        } reserved_31_16[31:16];
        field {
            name = "inhere_rlatcnt";
            desc = "Inherent latency of the read data channel for the DDRC and PHY. The actual latency can be obtained only by using this register and rlatcnt_min, rlatcnt_max, rlatcnt_all, and fluxid_rd_cmd.";
            sw = r; hw = w;
            reset = 0x0;
        } inhere_rlatcnt[15:0];
    } DDRC_HIS_INHERE_RLAT_CNT @ 0x3B0;
    reg {
        name = "DDRC_STACMD_RPT";
        desc = "DDRC_STACMD_RPT is the read pointer to the DMC accumulated command count register. (offset 0x3B8; total reset 0x00000000; PROVEN: Hi3521A/Hi3520D V300 data sheet (Issue 00B07, 2015-12-10), section 4.1.8.2, PDF page 846).";
        field {
            name = "reserved";
            desc = "Reserved";
            sw = r; hw = w;
            reset = 0x0;
        } reserved_31_3[31:3];
        field {
            name = "stacmd_rpt";
            desc = "In threshold-based statistical mode, the latest eight load statistical results are stored. This pointer is used to indicate the statistical result that the read DDRC_HIS_CMD_SUM value points to.
- 000: latest statistical result
- 001: second to the latest statistical result …
- 111: latest seventh statistical result";
            sw = rw; hw = r;
            reset = 0x0;
        } stacmd_rpt[2:0];
    } DDRC_STACMD_RPT @ 0x3B8;
    reg {
        name = "DDRC_HIS_CMD_SUM";
        desc = "DDRC_HIS_CMD_SUM is a DDRC accumulated command count register. (offset 0x3BC; total reset 0x00000000; PROVEN: Hi3521A/Hi3520D V300 data sheet (Issue 00B07, 2015-12-10), section 4.1.8.2, PDF page 847).";
        field {
            name = "dmc_cmd_sum";
            desc = "Accumulated value of the commands that are temporarily stored in the DMC in the cycle. The value is wrapped if an overflow occurs.";
            sw = r; hw = w;
            reset = 0x0;
        } dmc_cmd_sum[31:0];
    } DDRC_HIS_CMD_SUM @ 0x3BC;
    reg {
        name = "DDRC_HIS_SFC_RDATA0";
        desc = "DDRC_HIS_SFC_RDATA0 is SFC read data register 0. (offset 0x4A8; total reset 0x00000000; PROVEN: Hi3521A/Hi3520D V300 data sheet (Issue 00B07, 2015-12-10), section 4.1.8.2, PDF page 847).";
        field {
            name = "rdata0";
            desc = "Bits 31-0 of the data read by the SFC";
            sw = r; hw = w;
            reset = 0x0;
        } rdata0[31:0];
    } DDRC_HIS_SFC_RDATA0 @ 0x4A8;
    reg {
        name = "DDRC_HIS_SFC_RDATA1";
        desc = "DDRC_HIS_SFC_RDATA1 is an SFC read data register. (offset 0x4AC; total reset 0x00000000; PROVEN: Hi3521A/Hi3520D V300 data sheet (Issue 00B07, 2015-12-10), section 4.1.8.2, PDF page 847).";
        field {
            name = "rdata1";
            desc = "Bits 63-32 of the data read by the SFC";
            sw = r; hw = w;
            reset = 0x0;
        } rdata1[31:0];
    } DDRC_HIS_SFC_RDATA1 @ 0x4AC;
    reg {
        name = "DDRC_HIS_SFC_RDATA2";
        desc = "DDRC_HIS_SFC_RDATA2 is an SFC read data register. (offset 0x4B0; total reset 0x00000000; PROVEN: Hi3521A/Hi3520D V300 data sheet (Issue 00B07, 2015-12-10), section 4.1.8.2, PDF page 848).";
        field {
            name = "rdata2";
            desc = "Bits 95-64 of the data read by the SFC";
            sw = r; hw = w;
            reset = 0x0;
        } rdata2[31:0];
    } DDRC_HIS_SFC_RDATA2 @ 0x4B0;
    reg {
        name = "DDRC_HIS_SFC_RDATA3";
        desc = "DDRC_HIS_SFC_RDATA3 is software configuration read data register 3. (offset 0x4B4; total reset 0x00000000; PROVEN: Hi3521A/Hi3520D V300 data sheet (Issue 00B07, 2015-12-10), section 4.1.8.2, PDF page 848).";
        field {
            name = "rdata3";
            desc = "Bits 127-96 of the data read by the SFC";
            sw = rw; hw = r;
            reset = 0x0;
        } rdata3[31:0];
    } DDRC_HIS_SFC_RDATA3 @ 0x4B4;
};
`endif
