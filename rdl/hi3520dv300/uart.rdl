`ifndef HI3520DV300_UART_RDL
`define HI3520DV300_UART_RDL
regfile eHI3520DV300_UART {
    name = "UART (PL011)";
    desc = "UART (PL011) of the Hi3521A/Hi3520D V300 at base 0x12080000. 13 registers extracted programmatically from the Hi3521A/Hi3520D V300 data sheet (Issue 00B07, 2015-12-10) (Table 13-2 Summary of UART registers Offset Address Register Description Page 0x000 UART_DR Data register 13-32): register headings, offsets, total reset values, field bit ranges, access types, names, reset values and descriptions, with PDF page numbers in each register description. Field names, bit ranges, access types and offsets are exact; the free-text descriptions are taken from the cell text of the field table and were checked by sampling only. Hardware not verified.";
    reg {
        name = "UART_DR";
        desc = "UART_DR is a UART data register that stores the received data and the data to be transmitted. The receive status can be queried by reading this register. (offset 0x0; total reset 0x00000000; PROVEN: Hi3521A/Hi3520D V300 data sheet (Issue 00B07, 2015-12-10), section 13.2.6, PDF page 1513).";
        field {
            name = "reserved";
            desc = "Reserved";
            sw = r; hw = w;
            reset = 0x0;
        } reserved_15_12[15:12];
        field {
            name = "oe";
            desc = "Overflow error
- 0: No overflow error occurs.
- 1: An overflow error occurs. That is, a data segment is received when the RX FIFO is full.";
            sw = r; hw = w;
            reset = 0x0;
        } oe[11:11];
        field {
            name = "be";
            desc = "Break error
- 0: No break error occurs.
- 1: A break error occurs. That is, the time of RX data input signal keeping low is longer than a full word transfer. A full word consists of a start bit, a data bit, a parity bit, and a stop bit.";
            sw = r; hw = w;
            reset = 0x0;
        } be[10:10];
        field {
            name = "pe";
            desc = "Parity error
- 0: No parity error occurs.
- 1: A parity error occurs.";
            sw = r; hw = w;
            reset = 0x0;
        } pe[9:9];
        field {
            name = "fe";
            desc = "Frame error
- 0: No frame error occurs.
- 1: A frame error (namely, stop bit error) occurs.";
            sw = r; hw = w;
            reset = 0x0;
        } fe[8:8];
        field {
            name = "data";
            desc = "Data received and to be transmitted";
            sw = rw; hw = r;
            reset = 0x0;
        } data[7:0];
    } UART_DR @ 0x0;
    reg {
        name = "UART_RSR";
        desc = "UART_RSR is a receive status register or error clear register. It acts as the receive status register when being read. It acts as the error clear register when being written. You can query the receive status by reading UART_DR. The status information about the break, frame, and parity read from UART_DR has priority over that read from UART_RSR. That is, the status read from UART_DR changes faster than that read from UART_RSR. UART_RSR is reset when any value is written to it. (offset 0x4; total reset 0x00000000; PROVEN: Hi3521A/Hi3520D V300 data sheet (Issue 00B07, 2015-12-10), section 13.2.6, PDF page 1514).";
        field {
            name = "reserved";
            desc = "Reserved";
            sw = r; hw = w;
            reset = 0x0;
        } reserved_7_4[7:4];
        field {
            name = "oe";
            desc = "Overflow error
- 0: No overflow error occurs.
- 1: An overflow error occurs.

When the FIFO is full, the next data segment cannot be written to the FIFO and overflow occurs in the shift register. Therefore, the contents in the FIFO are valid. In this case, the CPU must read the data immediately to spare the FIFO.";
            sw = rw; hw = r;
            reset = 0x0;
        } oe[3:3];
        field {
            name = "be";
            desc = "Break error
- 0: No break error occurs.
- 1: A break error occurs.

A break error occurs when the time period during which the RX data signal keeps low is longer than a full word transfer. A full word consists of a start bit, a data bit, a parity bit, and a stop bit.";
            sw = rw; hw = r;
            reset = 0x0;
        } be[2:2];
        field {
            name = "pe";
            desc = "Parity error
- 0: No parity error occurs.
- 1: A parity error occurs when the received data is checked.

In FIFO mode, the error is associated with the data at the top of the FIFO.";
            sw = rw; hw = r;
            reset = 0x0;
        } pe[1:1];
        field {
            name = "fe";
            desc = "Frame error
- 0: No frame error occurs.
- 1: The stop bit of the received data is incorrect. The valid stop bit is 1.";
            sw = rw; hw = r;
            reset = 0x0;
        } fe[0:0];
    } UART_RSR @ 0x4;
    reg {
        name = "UART_FR";
        desc = "UART_FR is a UART flag register. (offset 0x18; total reset 0x00000012; PROVEN: Hi3521A/Hi3520D V300 data sheet (Issue 00B07, 2015-12-10), section 13.2.6, PDF page 1515).";
        field {
            name = "reserved";
            desc = "Reserved";
            sw = r; hw = w;
            reset = 0x0;
        } reserved_15_8[15:8];
        field {
            name = "txfe";
            desc = "The definition of the bit is determined by the status of UART_LCR_H[fen]. If UART_LCR_H[fen] is 0, this bit is set to 1 when the TX holding register is empty. If UART_LCR_H[fen] is 1, this bit is set to 1 when the TX FIFO is empty.";
            sw = r; hw = w;
            reset = 0x0;
        } txfe[7:7];
        field {
            name = "rxff";
            desc = "The definition of the bit is determined by the status of UART_LCR_H[fen]. If UART_LCR_H[fen] is 0, this bit is set to 1 when the RX holding register is full. If UART_LCR_H[fen] is 1, this bit is set to 1 when the RX FIFO is full.";
            sw = r; hw = w;
            reset = 0x0;
        } rxff[6:6];
        field {
            name = "txff";
            desc = "The definition of the bit is determined by the status of UART_LCR_H[fen]. If UART_LCR_H[fen] is 0, this bit is set to 1 when the TX holding register is full. If UART_LCR_H[fen] is 1, this bit is set to 1 when the TX FIFO is full.";
            sw = r; hw = w;
            reset = 0x0;
        } txff[5:5];
        field {
            name = "rxfe";
            desc = "The definition of the bit is determined by the status of UART_LCR_H[fen]. If UART_LCR_H[fen] is 0, this bit is set to 1 when the RX holding register is empty. If UART_LCR_H[fen] is 1, this bit is set to 1 when the RX FIFO is empty.";
            sw = r; hw = w;
            reset = 0x1;
        } rxfe[4:4];
        field {
            name = "busy";
            desc = "UART busy/idle status
- 0: The UART is idle or data transmission is complete.
- 1: The UART is busy in transmitting data.

If the bit is set to 1, the status is kept until the entire byte (including all stop bits) is transmitted from the shift register. Regardless of whether the UART is enabled, this bit is set to 1 when the TX FIFO is not empty.";
            sw = r; hw = w;
            reset = 0x0;
        } busy[3:3];
        field {
            name = "reserved";
            desc = "Reserved";
            sw = r; hw = w;
            reset = 0x2;
        } reserved_2_0[2:0];
    } UART_FR @ 0x18;
    reg {
        name = "UART_IBRD";
        desc = "UART_IBRD is an integral baud rate register. (offset 0x24; total reset 0x00000000; PROVEN: Hi3521A/Hi3520D V300 data sheet (Issue 00B07, 2015-12-10), section 13.2.6, PDF page 1516).";
        field {
            name = "baud";
            desc = "Clock frequency divider corresponding to the integral part divint of the baud rate. All bits are cleared after reset.";
            sw = rw; hw = r;
            reset = 0x0;
        } baud[15:0];
    } UART_IBRD @ 0x24;
    reg {
        name = "UART_FBRD";
        desc = "UART_FBRD is a fractional baud rate register. The values of UART_IBRD and UART_FBRD can be updated only after the current data is transmitted and received completely. The minimum clock frequency divider is 1 and the maximum divider is 65,535 (216 - 1). That is, UART_IBRD cannot be 0 and UART_FBRD is ignored if UART_IBRD is 0. Similarly, if UART_IBRD is equal to 65,535 (0xFFFF), UART_IBRD must be 0. If UART_FBRD is greater than 0, the data fails to be transmitted or received. (offset 0x28; total reset 0x00000000; PROVEN: Hi3521A/Hi3520D V300 data sheet (Issue 00B07, 2015-12-10), section 13.2.6, PDF page 1516).";
        field {
            name = "reserved";
            desc = "Reserved";
            sw = r; hw = w;
            reset = 0x0;
        } reserved_7_6[7:6];
        field {
            name = "band";
            desc = "Clock frequency divider corresponding to the fractional divfrac part of the baud rate. All bits are cleared after reset.";
            sw = rw; hw = r;
            reset = 0x0;
        } band[5:0];
    } UART_FBRD @ 0x28;
    reg {
        name = "UART_LCR_H";
        desc = "UART_LCR_H is a line control register. The registers UART_LCR_H, UART_IBRD, and UART_FBRD are combined to form a 30-bit register. If UART_IBRD and UART_FBRD are updated, UART_LCR_H must be updated at the same time. (offset 0x2C; total reset 0x00000000; PROVEN: Hi3521A/Hi3520D V300 data sheet (Issue 00B07, 2015-12-10), section 13.2.6, PDF page 1517).";
        field {
            name = "reserved";
            desc = "Reserved";
            sw = r; hw = w;
            reset = 0x0;
        } reserved_15_8[15:8];
        field {
            name = "sps";
            desc = "Parity select When bit 1, bit 2, and bit 7 of this register are set to 1, the parity bit is 0 during transmission and detection. When bit 1 and bit 7 of this register are set to 1 and bit 2 is set to 0, the parity bit is 1 during transmission and detection. When bit 1, bit 2, and bit 7 are cleared, the stick parity bit is disabled.";
            sw = rw; hw = r;
            reset = 0x0;
        } sps[7:7];
        field {
            name = "wlen";
            desc = "Count of bits in a transmitted or received frame
- 00: 5 bits
- 01: 6 bits
- 10: 7 bits
- 11: 8 bits";
            sw = rw; hw = r;
            reset = 0x0;
        } wlen[6:5];
        field {
            name = "fen";
            desc = "TX/RX FIFO enable
- 0: disabled
- 1: enabled";
            sw = rw; hw = r;
            reset = 0x0;
        } fen[4:4];
        field {
            name = "stp2";
            desc = "2-bit stop bit at the end of a transmitted frame
- 0: There is no 2-bit stop bit at the end of the transmitted frame.
- 1: There is a 2-bit stop bit at the end of the transmitted frame.

The RX logic does not check for the 2-bit stop bit during data reception.";
            sw = rw; hw = r;
            reset = 0x0;
        } stp2[3:3];
        field {
            name = "eps";
            desc = "Parity select during data transmission and reception
- 0: The odd parity is generated or checked during data transmission and reception.
- 1: The even parity is generated or checked during data transmission and reception.

When UART_LCR_H[fen] is 0, this bit becomes invalid.";
            sw = rw; hw = r;
            reset = 0x0;
        } eps[2:2];
        field {
            name = "pen";
            desc = "Parity enable
- 0: The parity is disabled.
- 1: The parity is generated on the TX side and checked on the RX side.";
            sw = rw; hw = r;
            reset = 0x0;
        } pen[1:1];
        field {
            name = "brk";
            desc = "Break transmit
- 0: invalid
- 1: After the current data transmission is complete, UTXD outputs low level continuously.

This bit must retain 1 during the period of at least two full frames to ensure the break command is executed properly. In general, the bit must be set to 0.";
            sw = rw; hw = r;
            reset = 0x0;
        } brk[0:0];
    } UART_LCR_H @ 0x2C;
    reg {
        name = "UART_CR";
        desc = "UART_CR is a UART control register. To configure UART_CR, perform the following steps: Step 1 Write 0 to UART_CR[uarten] to disable the UART. Step 2 Wait until the current data transmission or reception is complete. Step 3 Clear Step 4 UART_LCR_H[fen]. Step 5 Configure UART_CR. Step 6 Write 1 to UART_CR[uarten] to enable the UART. ----End (offset 0x30; total reset 0x00000300; PROVEN: Hi3521A/Hi3520D V300 data sheet (Issue 00B07, 2015-12-10), section 13.2.6, PDF page 1518).";
        field {
            name = "ctsen";
            desc = "CTS hardware flow control enable
- 0: disabled
- 1: enabled. Data is transmitted only when the nUARTCTS signal is valid.";
            sw = rw; hw = r;
            reset = 0x0;
        } ctsen[15:15];
        field {
            name = "rtsen";
            desc = "RTS hardware flow control enable
- 0: disabled
- 1: enabled. The data reception request is raised only when";
            sw = rw; hw = r;
            reset = 0x0;
        } rtsen[14:14];
        field {
            name = "reserved";
            desc = "Reserved";
            sw = r; hw = w;
            reset = 0x0;
        } reserved_13_12[13:12];
        field {
            name = "rts";
            desc = "Request transmit This bit is the inversion of the status output signal nUARTRTS of the UART modem.
- 0: The output signal retains.
- 1: When this bit is set to 1, the output signal is 0.";
            sw = rw; hw = r;
            reset = 0x0;
        } rts[11:11];
        field {
            name = "dtr";
            desc = "Data transmit ready This bit is the inversion of the status output signal nUARTDTR of the UART modem.
- 0: The output signal retains.
- 1: When this bit is set to 1, the output signal is 0.";
            sw = rw; hw = r;
            reset = 0x0;
        } dtr[10:10];
        field {
            name = "rxe";
            desc = "UART receive enable
- 0: disabled
- 1: enabled

If the UART is disabled during data reception, the current data reception is stopped abnormally.";
            sw = rw; hw = r;
            reset = 0x1;
        } rxe[9:9];
        field {
            name = "txe";
            desc = "UART transmit enable
- 0: disabled
- 1: enabled

If the UART is disabled during data transmission, the current data transmission is stopped abnormally.";
            sw = rw; hw = r;
            reset = 0x1;
        } txe[8:8];
        field {
            name = "lbe";
            desc = "Loopback enable
- 0: disabled
- 1: UARTTXD is looped back to UARTRXD.";
            sw = rw; hw = r;
            reset = 0x0;
        } lbe[7:7];
        field {
            name = "reserved";
            desc = "Reserved";
            sw = r; hw = w;
            reset = 0x0;
        } reserved_6_1[6:1];
        field {
            name = "uarten";
            desc = "UART enable
- 0: disabled
- 1: enabled

If the UART is disabled during data reception and transmission, the data transfer is stopped abnormally.";
            sw = rw; hw = r;
            reset = 0x0;
        } uarten[0:0];
    } UART_CR @ 0x30;
    reg {
        name = "UART_IFLS";
        desc = "UART_IFLS is an interrupt FIFO threshold select register. It is used to set a threshold for triggering a FIFO interrupt (UART_TXINTR or UART_RXINTR). (offset 0x34; total reset 0x00000012; PROVEN: Hi3521A/Hi3520D V300 data sheet (Issue 00B07, 2015-12-10), section 13.2.6, PDF page 1520).";
        field {
            name = "reserved";
            desc = "Reserved";
            sw = r; hw = w;
            reset = 0x0;
        } reserved_15_6[15:6];
        field {
            name = "rxiflsel";
            desc = "RX interrupt FIFO threshold select. An RX interrupt is triggered when any of the following conditions is met:
- 000: RX FIFO ≥ 1/8 full
- 001: RX FIFO ≥ 1/4 full
- 010: RX FIFO ≥ 1/2 full
- 011: RX FIFO ≥ 3/4 full
- 100: RX FIFO ≥ 7/8 full 101-111: reserved";
            sw = rw; hw = r;
            reset = 0x2;
        } rxiflsel[5:3];
        field {
            name = "txiflsel";
            desc = "TX interrupt FIFO threshold select. A TX interrupt is triggered when any of the following conditions is met:
- 000: TX FIFO ≤ 1/8 full
- 001: TX FIFO ≤ 1/4 full
- 011: TX FIFO ≤ 3/4 full
- 010: TX FIFO ≤ 1/2 full
- 100: TX FIFO ≤ 7/8 full 101-111: reserved";
            sw = rw; hw = r;
            reset = 0x2;
        } txiflsel[2:0];
    } UART_IFLS @ 0x34;
    reg {
        name = "UART_IMSC";
        desc = "UART_IMSC is an interrupt mask register. It is used to mask interrupts. (offset 0x38; total reset 0x00000000; PROVEN: Hi3521A/Hi3520D V300 data sheet (Issue 00B07, 2015-12-10), section 13.2.6, PDF page 1521).";
        field {
            name = "reserved";
            desc = "Reserved";
            sw = r; hw = w;
            reset = 0x0;
        } reserved_15_11[15:11];
        field {
            name = "oeim";
            desc = "Mask status of the overflow error interrupt
- 0: masked
- 1: not masked";
            sw = rw; hw = r;
            reset = 0x0;
        } oeim[10:10];
        field {
            name = "beim";
            desc = "Mask status of the break error interrupt
- 0: masked
- 1: not masked";
            sw = rw; hw = r;
            reset = 0x0;
        } beim[9:9];
        field {
            name = "peim";
            desc = "Mask status of the parity interrupt
- 0: masked
- 1: not masked";
            sw = rw; hw = r;
            reset = 0x0;
        } peim[8:8];
        field {
            name = "feim";
            desc = "Mask status of the frame error interrupt
- 0: masked
- 1: not masked";
            sw = rw; hw = r;
            reset = 0x0;
        } feim[7:7];
        field {
            name = "rtim";
            desc = "Mask status of the RX timeout interrupt
- 0: masked
- 1: not masked";
            sw = rw; hw = r;
            reset = 0x0;
        } rtim[6:6];
        field {
            name = "txim";
            desc = "Mask status of the TX interrupt
- 0: masked
- 1: not masked";
            sw = rw; hw = r;
            reset = 0x0;
        } txim[5:5];
        field {
            name = "rxim";
            desc = "Mask status of the RX interrupt
- 0: masked
- 1: not masked";
            sw = rw; hw = r;
            reset = 0x0;
        } rxim[4:4];
        field {
            name = "reserved";
            desc = "Reserved";
            sw = r; hw = w;
            reset = 0x0;
        } reserved_3_0[3:0];
    } UART_IMSC @ 0x38;
    reg {
        name = "UART_RIS";
        desc = "UART_RIS is a raw interrupt status register. The contents of this register are not affected by the UART_IMSC register. (offset 0x3C; total reset 0x00000000; PROVEN: Hi3521A/Hi3520D V300 data sheet (Issue 00B07, 2015-12-10), section 13.2.6, PDF page 1522).";
        field {
            name = "reserved";
            desc = "Reserved";
            sw = r; hw = w;
            reset = 0x0;
        } reserved_15_11[15:11];
        field {
            name = "oeris";
            desc = "Status of the raw overflow error interrupt
- 0: No interrupt is generated.
- 1: An interrupt is generated.";
            sw = r; hw = w;
            reset = 0x0;
        } oeris[10:10];
        field {
            name = "beris";
            desc = "Status of the raw break error interrupt
- 0: No interrupt is generated.
- 1: An interrupt is generated.";
            sw = r; hw = w;
            reset = 0x0;
        } beris[9:9];
        field {
            name = "peris";
            desc = "Status of the raw parity interrupt
- 0: No interrupt is generated.
- 1: An interrupt is generated.";
            sw = r; hw = w;
            reset = 0x0;
        } peris[8:8];
        field {
            name = "feris";
            desc = "Status of the raw error interrupt
- 0: No interrupt is generated.
- 1: An interrupt is generated.";
            sw = r; hw = w;
            reset = 0x0;
        } feris[7:7];
        field {
            name = "rtris";
            desc = "Status of the raw RX timeout interrupt
- 0: No interrupt is generated.
- 1: An interrupt is generated.";
            sw = r; hw = w;
            reset = 0x0;
        } rtris[6:6];
        field {
            name = "txris";
            desc = "Status of the raw TX interrupt
- 0: No interrupt is generated.
- 1: An interrupt is generated.";
            sw = r; hw = w;
            reset = 0x0;
        } txris[5:5];
        field {
            name = "rxris";
            desc = "Status of the raw RX interrupt
- 0: No interrupt is generated.
- 1: An interrupt is generated.";
            sw = r; hw = w;
            reset = 0x0;
        } rxris[4:4];
        field {
            name = "reserved";
            desc = "Reserved";
            sw = r; hw = w;
            reset = 0x0;
        } reserved_3_0[3:0];
    } UART_RIS @ 0x3C;
    reg {
        name = "UART_MIS";
        desc = "UART_MIS is a masked interrupt status register. The contents of this register are the results obtained after the raw interrupt status is ANDed with the interrupt mask status. (offset 0x40; total reset 0x00000000; PROVEN: Hi3521A/Hi3520D V300 data sheet (Issue 00B07, 2015-12-10), section 13.2.6, PDF page 1523).";
        field {
            name = "reserved";
            desc = "Reserved";
            sw = r; hw = w;
            reset = 0x0;
        } reserved_15_11[15:11];
        field {
            name = "oemis";
            desc = "Status of the masked overflow error interrupt
- 0: No interrupt is generated.
- 1: An interrupt is generated.";
            sw = r; hw = w;
            reset = 0x0;
        } oemis[10:10];
        field {
            name = "bemis";
            desc = "Status of the masked break error interrupt
- 0: No interrupt is generated.
- 1: An interrupt is generated.";
            sw = r; hw = w;
            reset = 0x0;
        } bemis[9:9];
        field {
            name = "pemis";
            desc = "Status of the masked parity interrupt
- 0: No interrupt is generated.
- 1: An interrupt is generated.";
            sw = r; hw = w;
            reset = 0x0;
        } pemis[8:8];
        field {
            name = "femis";
            desc = "Status of the masked error interrupt
- 0: No interrupt is generated.
- 1: An interrupt is generated.";
            sw = r; hw = w;
            reset = 0x0;
        } femis[7:7];
        field {
            name = "rtmis";
            desc = "Status of the masked RX timeout interrupt
- 0: No interrupt is generated.
- 1: An interrupt is generated.";
            sw = r; hw = w;
            reset = 0x0;
        } rtmis[6:6];
        field {
            name = "txmis";
            desc = "Status of the masked TX interrupt
- 0: No interrupt is generated.
- 1: An interrupt is generated.";
            sw = r; hw = w;
            reset = 0x0;
        } txmis[5:5];
        field {
            name = "rxmis";
            desc = "Status of the masked RX interrupt
- 0: No interrupt is generated.
- 1: An interrupt is generated.";
            sw = r; hw = w;
            reset = 0x0;
        } rxmis[4:4];
        field {
            name = "reserved";
            desc = "Reserved";
            sw = r; hw = w;
            reset = 0x0;
        } reserved_3_0[3:0];
    } UART_MIS @ 0x40;
    reg {
        name = "UART_ICR";
        desc = "UART_ICR is an interrupt clear register. When 1 is written to it, the corresponding interrupt is cleared. Writing 0 has no effect. (offset 0x44; total reset 0x00000000; PROVEN: Hi3521A/Hi3520D V300 data sheet (Issue 00B07, 2015-12-10), section 13.2.6, PDF page 1524).";
        field {
            name = "reserved";
            desc = "Reserved";
            sw = r; hw = w;
            reset = 0x0;
        } reserved_15_11[15:11];
        field {
            name = "oeic";
            desc = "Overflow error interrupt clear
- 0: invalid
- 1: cleared";
            sw = w; hw = r;
            reset = 0x0;
        } oeic[10:10];
        field {
            name = "beic";
            desc = "Break error interrupt clear
- 0: invalid
- 1: cleared";
            sw = w; hw = r;
            reset = 0x0;
        } beic[9:9];
        field {
            name = "peic";
            desc = "Parity interrupt clear
- 0: invalid
- 1: cleared";
            sw = w; hw = r;
            reset = 0x0;
        } peic[8:8];
        field {
            name = "feic";
            desc = "Error interrupt clear
- 0: invalid
- 1: cleared";
            sw = w; hw = r;
            reset = 0x0;
        } feic[7:7];
        field {
            name = "rtic";
            desc = "RX timeout interrupt clear
- 0: invalid
- 1: cleared";
            sw = w; hw = r;
            reset = 0x0;
        } rtic[6:6];
        field {
            name = "txic";
            desc = "TX interrupt clear
- 0: invalid
- 1: cleared";
            sw = w; hw = r;
            reset = 0x0;
        } txic[5:5];
        field {
            name = "rxic";
            desc = "RX interrupt clear
- 0: invalid
- 1: cleared";
            sw = w; hw = r;
            reset = 0x0;
        } rxic[4:4];
        field {
            name = "reserved";
            desc = "Reserved";
            sw = r; hw = w;
            reset = 0x0;
        } reserved_3_0[3:0];
    } UART_ICR @ 0x44;
    reg {
        name = "UART_DMACR";
        desc = "UART_DMACR is a DMA control register. It is used to enable or disable the DMAs of the TX and RX FIFOs. (offset 0x48; total reset 0x00000000; PROVEN: Hi3521A/Hi3520D V300 data sheet (Issue 00B07, 2015-12-10), section 13.2.6, PDF page 1525).";
        field {
            name = "reserved";
            desc = "Reserved";
            sw = r; hw = w;
            reset = 0x0;
        } reserved_15_3[15:3];
        field {
            name = "dmaonerr";
            desc = "DMA enable for the RX channel when the UART error interrupt (UARTEINTR) occurs.
- 0: When UARTEINTR is valid, the DMA output request (UARTRXDMASREQ or UARRTXDMABREQ) of the RX channel is valid.
- 1: When UARTEINTR is valid, the DMA output request (UARTRXDMASREQ or UARRTXDMABREQ) of the RX channel is invalid.";
            sw = rw; hw = r;
            reset = 0x0;
        } dmaonerr[2:2];
        field {
            name = "txdmae";
            desc = "TX FIFO DMA enable
- 0: disabled
- 1: enable";
            sw = rw; hw = r;
            reset = 0x0;
        } txdmae[1:1];
        field {
            name = "rxdmae";
            desc = "RX FIFO DMA enable
- 0: disabled
- 1: enable";
            sw = rw; hw = r;
            reset = 0x0;
        } rxdmae[0:0];
    } UART_DMACR @ 0x48;
};
`endif
