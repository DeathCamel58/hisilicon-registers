`ifndef HI3520DV300_PADCTRL_RDL
`define HI3520DV300_PADCTRL_RDL
regfile eHI3520DV300_PADCTRL {
    name = "Pad (pin drive capability) control registers";
    desc = "Pad (pin drive capability) control registers of the Hi3521A/Hi3520D V300 at base 0x120F_0800. 122 registers extracted programmatically from the Hi3521A/Hi3520D V300 data sheet (Issue 00B07, 2015-12-10) (Table 2-29 Summary of pad_ctrl registers (base address: 0x120F_0800)): register headings, offsets, total reset values, field bit ranges, access types, names, reset values and descriptions, with PDF page numbers in each register description. Field names, bit ranges, access types and offsets are exact; the free-text descriptions are taken from the cell text of the field table and were checked by sampling only. Hardware not verified.";
    reg {
        name = "PADCTRL_REG0";
        desc = "PADCTRL_REG0 is a drive capability register for the VI0_CLK pin. (offset 0x0; total reset 0x00000078; PROVEN: Hi3521A/Hi3520D V300 data sheet (Issue 00B07, 2015-12-10), section 2.5.2, PDF page 130).";
        field {
            name = "reserved";
            desc = "Reserved";
            sw = r; hw = w;
            reset = 0x0;
        } reserved_31_7[31:7];
        field {
            name = "ds";
            desc = "Drive current of the VI0_CLK pin
- 000: 12 mA
- 001: 11 mA
- 010: 9 mA
- 011: 8 mA
- 100: 5 mA
- 101: 4 mA
- 110: 2 mA
- 111: 1 mA";
            sw = rw; hw = r;
            reset = 0x7;
        } ds[6:4];
        field {
            name = "sl";
            desc = "Level conversion rate of the VI0_CLK pin
- 0: fast edge
- 1: slow edge";
            sw = rw; hw = r;
            reset = 0x1;
        } sl[3:3];
        field {
            name = "reserved";
            desc = "Reserved";
            sw = r; hw = w;
            reset = 0x0;
        } reserved_2_0[2:0];
    } PADCTRL_REG0 @ 0x0;
    reg {
        name = "PADCTRL_REG1";
        desc = "PADCTRL_REG1 is a drive capability register for the VI0_DAT7 pin. (offset 0x4; total reset 0x00000038; PROVEN: Hi3521A/Hi3520D V300 data sheet (Issue 00B07, 2015-12-10), section 2.5.2, PDF page 131).";
        field {
            name = "reserved";
            desc = "Reserved";
            sw = r; hw = w;
            reset = 0x0;
        } reserved_31_6[31:6];
        field {
            name = "ds";
            desc = "Drive current of the VI0_DAT7 pin
- 00: 4 mA
- 01: 3 mA
- 10: 2 mA
- 11: 1 mA";
            sw = rw; hw = r;
            reset = 0x3;
        } ds[5:4];
        field {
            name = "sl";
            desc = "Level conversion rate of the VI0_DAT7 pin
- 0: fast edge
- 1: slow edge";
            sw = rw; hw = r;
            reset = 0x1;
        } sl[3:3];
        field {
            name = "reserved";
            desc = "Reserved";
            sw = r; hw = w;
            reset = 0x0;
        } reserved_2_0[2:0];
    } PADCTRL_REG1 @ 0x4;
    reg {
        name = "PADCTRL_REG2";
        desc = "PADCTRL_REG2 is a drive capability register for the VI0_DAT6 pin. (offset 0x8; total reset 0x00000038; PROVEN: Hi3521A/Hi3520D V300 data sheet (Issue 00B07, 2015-12-10), section 2.5.2, PDF page 132).";
        field {
            name = "reserved";
            desc = "Reserved";
            sw = r; hw = w;
            reset = 0x0;
        } reserved_31_6[31:6];
        field {
            name = "ds";
            desc = "Drive current of the VI0_DAT6 pin
- 00: 4 mA
- 01: 3 mA
- 10: 2 mA
- 11: 1 mA";
            sw = rw; hw = r;
            reset = 0x3;
        } ds[5:4];
        field {
            name = "sl";
            desc = "Level conversion rate of the VI0_DAT6 pin
- 0: fast edge
- 1: slow edge";
            sw = rw; hw = r;
            reset = 0x1;
        } sl[3:3];
        field {
            name = "reserved";
            desc = "Reserved";
            sw = r; hw = w;
            reset = 0x0;
        } reserved_2_0[2:0];
    } PADCTRL_REG2 @ 0x8;
    reg {
        name = "PADCTRL_REG3";
        desc = "PADCTRL_REG3 is a drive capability register for the VI0_DAT5 pin. (offset 0xC; total reset 0x00000038; PROVEN: Hi3521A/Hi3520D V300 data sheet (Issue 00B07, 2015-12-10), section 2.5.2, PDF page 132).";
        field {
            name = "reserved";
            desc = "Reserved";
            sw = r; hw = w;
            reset = 0x0;
        } reserved_31_6[31:6];
        field {
            name = "ds";
            desc = "Drive current of the VI0_DAT5 pin
- 00: 4 mA
- 01: 3 mA
- 10: 2 mA
- 11: 1 mA";
            sw = rw; hw = r;
            reset = 0x3;
        } ds[5:4];
        field {
            name = "sl";
            desc = "Level conversion rate of the VI0_DAT5 pin
- 0: fast edge
- 1: slow edge";
            sw = rw; hw = r;
            reset = 0x1;
        } sl[3:3];
        field {
            name = "reserved";
            desc = "Reserved";
            sw = r; hw = w;
            reset = 0x0;
        } reserved_2_0[2:0];
    } PADCTRL_REG3 @ 0xC;
    reg {
        name = "PADCTRL_REG4";
        desc = "PADCTRL_REG4 is a drive capability register for the VI0_DAT4 pin. (offset 0x10; total reset 0x00000038; PROVEN: Hi3521A/Hi3520D V300 data sheet (Issue 00B07, 2015-12-10), section 2.5.2, PDF page 133).";
        field {
            name = "reserved";
            desc = "Reserved";
            sw = r; hw = w;
            reset = 0x0;
        } reserved_31_6[31:6];
        field {
            name = "ds";
            desc = "Drive current of the VI0_DAT4 pin
- 00: 4 mA
- 01: 3 mA
- 10: 2 mA
- 11: 1 mA";
            sw = rw; hw = r;
            reset = 0x3;
        } ds[5:4];
        field {
            name = "sl";
            desc = "Level conversion rate of the VI0_DAT4 pin
- 0: fast edge
- 1: slow edge";
            sw = rw; hw = r;
            reset = 0x1;
        } sl[3:3];
        field {
            name = "reserved";
            desc = "Reserved";
            sw = r; hw = w;
            reset = 0x0;
        } reserved_2_0[2:0];
    } PADCTRL_REG4 @ 0x10;
    reg {
        name = "PADCTRL_REG5";
        desc = "PADCTRL_REG5 is a drive capability register for the VI0_DAT3 pin. (offset 0x14; total reset 0x00000038; PROVEN: Hi3521A/Hi3520D V300 data sheet (Issue 00B07, 2015-12-10), section 2.5.2, PDF page 134).";
        field {
            name = "reserved";
            desc = "Reserved";
            sw = r; hw = w;
            reset = 0x0;
        } reserved_31_6[31:6];
        field {
            name = "ds";
            desc = "Drive current of the VI0_DAT3 pin
- 00: 4 mA
- 01: 3 mA
- 10: 2 mA
- 11: 1 mA";
            sw = rw; hw = r;
            reset = 0x3;
        } ds[5:4];
        field {
            name = "sl";
            desc = "Level conversion rate of the VI0_DAT3 pin
- 0: fast edge
- 1: slow edge";
            sw = rw; hw = r;
            reset = 0x1;
        } sl[3:3];
        field {
            name = "reserved";
            desc = "Reserved";
            sw = r; hw = w;
            reset = 0x0;
        } reserved_2_0[2:0];
    } PADCTRL_REG5 @ 0x14;
    reg {
        name = "PADCTRL_REG6";
        desc = "PADCTRL_REG6 is a drive capability register for the VI0_DAT2 pin. (offset 0x18; total reset 0x00000038; PROVEN: Hi3521A/Hi3520D V300 data sheet (Issue 00B07, 2015-12-10), section 2.5.2, PDF page 134).";
        field {
            name = "reserved";
            desc = "Reserved";
            sw = r; hw = w;
            reset = 0x0;
        } reserved_31_6[31:6];
        field {
            name = "ds";
            desc = "Drive current of the VI0_DAT2 pin
- 00: 4 mA
- 01: 3 mA
- 10: 2 mA
- 11: 1 mA";
            sw = rw; hw = r;
            reset = 0x3;
        } ds[5:4];
        field {
            name = "sl";
            desc = "Level conversion rate of the VI0_DAT2 pin
- 0: fast edge
- 1: slow edge";
            sw = rw; hw = r;
            reset = 0x1;
        } sl[3:3];
        field {
            name = "reserved";
            desc = "Reserved";
            sw = r; hw = w;
            reset = 0x0;
        } reserved_2_0[2:0];
    } PADCTRL_REG6 @ 0x18;
    reg {
        name = "PADCTRL_REG7";
        desc = "PADCTRL_REG7 is a drive capability register for the VI0_DAT1 pin. (offset 0x1C; total reset 0x00000038; PROVEN: Hi3521A/Hi3520D V300 data sheet (Issue 00B07, 2015-12-10), section 2.5.2, PDF page 135).";
        field {
            name = "reserved";
            desc = "Reserved";
            sw = r; hw = w;
            reset = 0x0;
        } reserved_31_6[31:6];
        field {
            name = "ds";
            desc = "Drive current of the VI0_DAT1 pin
- 00: 4 mA
- 01: 3 mA
- 10: 2 mA
- 11: 1 mA";
            sw = rw; hw = r;
            reset = 0x3;
        } ds[5:4];
        field {
            name = "sl";
            desc = "Level conversion rate of the VI0_DAT1 pin
- 0: fast edge
- 1: slow edge";
            sw = rw; hw = r;
            reset = 0x1;
        } sl[3:3];
        field {
            name = "reserved";
            desc = "Reserved";
            sw = r; hw = w;
            reset = 0x0;
        } reserved_2_0[2:0];
    } PADCTRL_REG7 @ 0x1C;
    reg {
        name = "PADCTRL_REG8";
        desc = "PADCTRL_REG8 is a drive capability register for the VI0_DAT0 pin. (offset 0x20; total reset 0x00000038; PROVEN: Hi3521A/Hi3520D V300 data sheet (Issue 00B07, 2015-12-10), section 2.5.2, PDF page 136).";
        field {
            name = "reserved";
            desc = "Reserved";
            sw = r; hw = w;
            reset = 0x0;
        } reserved_31_6[31:6];
        field {
            name = "ds";
            desc = "Drive current of the VI0_DAT0 pin
- 00: 4 mA
- 01: 3 mA
- 10: 2 mA
- 11: 1 mA";
            sw = rw; hw = r;
            reset = 0x3;
        } ds[5:4];
        field {
            name = "sl";
            desc = "Level conversion rate of the VI0_DAT0 pin
- 0: fast edge
- 1: slow edge";
            sw = rw; hw = r;
            reset = 0x1;
        } sl[3:3];
        field {
            name = "reserved";
            desc = "Reserved";
            sw = r; hw = w;
            reset = 0x0;
        } reserved_2_0[2:0];
    } PADCTRL_REG8 @ 0x20;
    reg {
        name = "PADCTRL_REG9";
        desc = "PADCTRL_REG9 is a drive capability register for the VI1_CLK pin. (offset 0x24; total reset 0x00000038; PROVEN: Hi3521A/Hi3520D V300 data sheet (Issue 00B07, 2015-12-10), section 2.5.2, PDF page 136).";
        field {
            name = "reserved";
            desc = "Reserved";
            sw = r; hw = w;
            reset = 0x0;
        } reserved_31_6[31:6];
        field {
            name = "ds";
            desc = "Drive current of the VI1_CLK pin
- 00: 4 mA
- 01: 3 mA
- 10: 2 mA
- 11: 1 mA";
            sw = rw; hw = r;
            reset = 0x3;
        } ds[5:4];
        field {
            name = "sl";
            desc = "Level conversion rate of the VI1_CLK pin
- 0: fast edge
- 1: slow edge";
            sw = rw; hw = r;
            reset = 0x1;
        } sl[3:3];
        field {
            name = "reserved";
            desc = "Reserved";
            sw = r; hw = w;
            reset = 0x0;
        } reserved_2_0[2:0];
    } PADCTRL_REG9 @ 0x24;
    reg {
        name = "PADCTRL_REG10";
        desc = "PADCTRL_REG10 is a drive capability register for the VI1_DAT7 pin. (offset 0x28; total reset 0x00000038; PROVEN: Hi3521A/Hi3520D V300 data sheet (Issue 00B07, 2015-12-10), section 2.5.2, PDF page 137).";
        field {
            name = "reserved";
            desc = "Reserved";
            sw = r; hw = w;
            reset = 0x0;
        } reserved_31_6[31:6];
        field {
            name = "ds";
            desc = "Drive current of the VI1_DAT7 pin
- 00: 4 mA
- 01: 3 mA
- 10: 2 mA
- 11: 1 mA";
            sw = rw; hw = r;
            reset = 0x3;
        } ds[5:4];
        field {
            name = "sl";
            desc = "Level conversion rate of the VI1_DAT7 pin
- 0: fast edge
- 1: slow edge";
            sw = rw; hw = r;
            reset = 0x1;
        } sl[3:3];
        field {
            name = "reserved";
            desc = "Reserved";
            sw = r; hw = w;
            reset = 0x0;
        } reserved_2_0[2:0];
    } PADCTRL_REG10 @ 0x28;
    reg {
        name = "PADCTRL_REG11";
        desc = "PADCTRL_REG11 is a drive capability register for the VI1_DAT6 pin. (offset 0x2C; total reset 0x00000038; PROVEN: Hi3521A/Hi3520D V300 data sheet (Issue 00B07, 2015-12-10), section 2.5.2, PDF page 138).";
        field {
            name = "reserved";
            desc = "Reserved";
            sw = r; hw = w;
            reset = 0x0;
        } reserved_31_6[31:6];
        field {
            name = "ds";
            desc = "Drive current of the VI1_DAT6 pin
- 00: 4 mA
- 01: 3 mA
- 10: 2 mA
- 11: 1 mA";
            sw = rw; hw = r;
            reset = 0x3;
        } ds[5:4];
        field {
            name = "sl";
            desc = "Level conversion rate of the VI1_DAT6 pin
- 0: fast edge
- 1: slow edge";
            sw = rw; hw = r;
            reset = 0x1;
        } sl[3:3];
        field {
            name = "reserved";
            desc = "Reserved";
            sw = r; hw = w;
            reset = 0x0;
        } reserved_2_0[2:0];
    } PADCTRL_REG11 @ 0x2C;
    reg {
        name = "PADCTRL_REG12";
        desc = "PADCTRL_REG12 is a drive capability register for the VI1_DAT5 pin. (offset 0x30; total reset 0x00000038; PROVEN: Hi3521A/Hi3520D V300 data sheet (Issue 00B07, 2015-12-10), section 2.5.2, PDF page 138).";
        field {
            name = "reserved";
            desc = "Reserved";
            sw = r; hw = w;
            reset = 0x0;
        } reserved_31_6[31:6];
        field {
            name = "ds";
            desc = "Drive current of the VI1_DAT5 pin
- 00: 4 mA
- 01: 3 mA
- 10: 2 mA
- 11: 1 mA";
            sw = rw; hw = r;
            reset = 0x3;
        } ds[5:4];
        field {
            name = "sl";
            desc = "Level conversion rate of the VI1_DAT5 pin
- 0: fast edge
- 1: slow edge";
            sw = rw; hw = r;
            reset = 0x1;
        } sl[3:3];
        field {
            name = "reserved";
            desc = "Reserved";
            sw = r; hw = w;
            reset = 0x0;
        } reserved_2_0[2:0];
    } PADCTRL_REG12 @ 0x30;
    reg {
        name = "PADCTRL_REG13";
        desc = "PADCTRL_REG13 is a drive capability register for the VI1_DAT4 pin. (offset 0x34; total reset 0x00000038; PROVEN: Hi3521A/Hi3520D V300 data sheet (Issue 00B07, 2015-12-10), section 2.5.2, PDF page 139).";
        field {
            name = "reserved";
            desc = "Reserved";
            sw = r; hw = w;
            reset = 0x0;
        } reserved_31_6[31:6];
        field {
            name = "ds";
            desc = "Drive current of the VI1_DAT4 pin
- 00: 4 mA
- 01: 3 mA
- 10: 2 mA
- 11: 1 mA";
            sw = rw; hw = r;
            reset = 0x3;
        } ds[5:4];
        field {
            name = "sl";
            desc = "Level conversion rate of the VI1_DAT4 pin
- 0: fast edge
- 1: slow edge";
            sw = rw; hw = r;
            reset = 0x1;
        } sl[3:3];
        field {
            name = "reserved";
            desc = "Reserved";
            sw = r; hw = w;
            reset = 0x0;
        } reserved_2_0[2:0];
    } PADCTRL_REG13 @ 0x34;
    reg {
        name = "PADCTRL_REG14";
        desc = "PADCTRL_REG14 is a drive capability register for the VI1_DAT3 pin. (offset 0x38; total reset 0x00000038; PROVEN: Hi3521A/Hi3520D V300 data sheet (Issue 00B07, 2015-12-10), section 2.5.2, PDF page 140).";
        field {
            name = "reserved";
            desc = "Reserved";
            sw = r; hw = w;
            reset = 0x0;
        } reserved_31_6[31:6];
        field {
            name = "ds";
            desc = "Drive current of the VI1_DAT3 pin
- 00: 4 mA
- 01: 3 mA
- 10: 2 mA
- 11: 1 mA";
            sw = rw; hw = r;
            reset = 0x3;
        } ds[5:4];
        field {
            name = "sl";
            desc = "Level conversion rate of the VI1_DAT3 pin
- 0: fast edge
- 1: slow edge";
            sw = rw; hw = r;
            reset = 0x1;
        } sl[3:3];
        field {
            name = "reserved";
            desc = "Reserved";
            sw = r; hw = w;
            reset = 0x0;
        } reserved_2_0[2:0];
    } PADCTRL_REG14 @ 0x38;
    reg {
        name = "PADCTRL_REG15";
        desc = "PADCTRL_REG15 is a drive capability register for the VI1_DAT2 pin. (offset 0x3C; total reset 0x00000038; PROVEN: Hi3521A/Hi3520D V300 data sheet (Issue 00B07, 2015-12-10), section 2.5.2, PDF page 140).";
        field {
            name = "reserved";
            desc = "Reserved";
            sw = r; hw = w;
            reset = 0x0;
        } reserved_31_6[31:6];
        field {
            name = "ds";
            desc = "Drive current of the VI1_DAT2 pin
- 00: 4 mA
- 01: 3 mA
- 10: 2 mA
- 11: 1 mA";
            sw = rw; hw = r;
            reset = 0x3;
        } ds[5:4];
        field {
            name = "sl";
            desc = "Level conversion rate of the VI1_DAT2 pin
- 0: fast edge
- 1: slow edge";
            sw = rw; hw = r;
            reset = 0x1;
        } sl[3:3];
        field {
            name = "reserved";
            desc = "Reserved";
            sw = r; hw = w;
            reset = 0x0;
        } reserved_2_0[2:0];
    } PADCTRL_REG15 @ 0x3C;
    reg {
        name = "PADCTRL_REG16";
        desc = "PADCTRL_REG16 is a drive capability register for the VI1_DAT1 pin. (offset 0x40; total reset 0x00000038; PROVEN: Hi3521A/Hi3520D V300 data sheet (Issue 00B07, 2015-12-10), section 2.5.2, PDF page 141).";
        field {
            name = "reserved";
            desc = "Reserved";
            sw = r; hw = w;
            reset = 0x0;
        } reserved_31_6[31:6];
        field {
            name = "ds";
            desc = "Drive current of the VI1_DAT1 pin
- 00: 4 mA
- 01: 3 mA
- 10: 2 mA
- 11: 1 mA";
            sw = rw; hw = r;
            reset = 0x3;
        } ds[5:4];
        field {
            name = "sl";
            desc = "Level conversion rate of the VI1_DAT1 pin
- 0: fast edge
- 1: slow edge";
            sw = rw; hw = r;
            reset = 0x1;
        } sl[3:3];
        field {
            name = "reserved";
            desc = "Reserved";
            sw = r; hw = w;
            reset = 0x0;
        } reserved_2_0[2:0];
    } PADCTRL_REG16 @ 0x40;
    reg {
        name = "PADCTRL_REG17";
        desc = "PADCTRL_REG17 is a drive capability register for the VI1_DAT0 pin. (offset 0x44; total reset 0x00000038; PROVEN: Hi3521A/Hi3520D V300 data sheet (Issue 00B07, 2015-12-10), section 2.5.2, PDF page 142).";
        field {
            name = "reserved";
            desc = "Reserved";
            sw = r; hw = w;
            reset = 0x0;
        } reserved_31_6[31:6];
        field {
            name = "ds";
            desc = "Drive current of the VI1_DAT0 pin
- 00: 4 mA
- 01: 3 mA
- 10: 2 mA
- 11: 1 mA";
            sw = rw; hw = r;
            reset = 0x3;
        } ds[5:4];
        field {
            name = "sl";
            desc = "Level conversion rate of the VI1_DAT0 pin
- 0: fast edge
- 1: slow edge";
            sw = rw; hw = r;
            reset = 0x1;
        } sl[3:3];
        field {
            name = "reserved";
            desc = "Reserved";
            sw = r; hw = w;
            reset = 0x0;
        } reserved_2_0[2:0];
    } PADCTRL_REG17 @ 0x44;
    reg {
        name = "PADCTRL_REG18";
        desc = "PADCTRL_REG18 is a drive capability register for the VI_ADC_REFCLK0 pin. (offset 0x48; total reset 0x00000078; PROVEN: Hi3521A/Hi3520D V300 data sheet (Issue 00B07, 2015-12-10), section 2.5.2, PDF page 142).";
        field {
            name = "reserved";
            desc = "Reserved";
            sw = r; hw = w;
            reset = 0x0;
        } reserved_31_7[31:7];
        field {
            name = "ds";
            desc = "Drive current of the VI_ADC_REFCLK0 pin
- 000: 12 mA
- 001: 11 mA
- 010: 9 mA
- 011: 8 mA
- 100: 5 mA
- 101: 4 mA
- 110: 2 mA
- 111: 1 mA";
            sw = rw; hw = r;
            reset = 0x7;
        } ds[6:4];
        field {
            name = "sl";
            desc = "Level conversion rate of the VI_ADC_REFCLK0 pin
- 0: fast edge
- 1: slow edge";
            sw = rw; hw = r;
            reset = 0x1;
        } sl[3:3];
        field {
            name = "reserved";
            desc = "Reserved";
            sw = r; hw = w;
            reset = 0x0;
        } reserved_2_0[2:0];
    } PADCTRL_REG18 @ 0x48;
    reg {
        name = "PADCTRL_REG19";
        desc = "PADCTRL_REG19 is a drive capability register for the VI2_CLK pin. (offset 0x4C; total reset 0x00000078; PROVEN: Hi3521A/Hi3520D V300 data sheet (Issue 00B07, 2015-12-10), section 2.5.2, PDF page 143).";
        field {
            name = "reserved";
            desc = "Reserved";
            sw = r; hw = w;
            reset = 0x0;
        } reserved_31_7[31:7];
        field {
            name = "ds";
            desc = "Drive current of the VI2_CLK pin
- 000: 12 mA
- 001: 11 mA
- 010: 9 mA
- 011: 8 mA
- 100: 5 mA
- 101: 4 mA
- 110: 2 mA
- 111: 1 mA";
            sw = rw; hw = r;
            reset = 0x7;
        } ds[6:4];
        field {
            name = "sl";
            desc = "Level conversion rate of the VI2_CLK pin
- 0: fast edge
- 1: slow edge";
            sw = rw; hw = r;
            reset = 0x1;
        } sl[3:3];
        field {
            name = "reserved";
            desc = "Reserved";
            sw = r; hw = w;
            reset = 0x0;
        } reserved_2_0[2:0];
    } PADCTRL_REG19 @ 0x4C;
    reg {
        name = "PADCTRL_REG20";
        desc = "PADCTRL_REG20 is a drive capability register for the VI2_DAT7 pin. (offset 0x50; total reset 0x00000038; PROVEN: Hi3521A/Hi3520D V300 data sheet (Issue 00B07, 2015-12-10), section 2.5.2, PDF page 144).";
        field {
            name = "reserved";
            desc = "Reserved";
            sw = r; hw = w;
            reset = 0x0;
        } reserved_31_6[31:6];
        field {
            name = "ds";
            desc = "Drive current of the VI2_DAT7 pin
- 00: 4 mA
- 01: 3 mA
- 10: 2 mA
- 11: 1 mA";
            sw = rw; hw = r;
            reset = 0x3;
        } ds[5:4];
        field {
            name = "sl";
            desc = "Level conversion rate of the VI2_DAT7 pin
- 0: fast edge
- 1: slow edge";
            sw = rw; hw = r;
            reset = 0x1;
        } sl[3:3];
        field {
            name = "reserved";
            desc = "Reserved";
            sw = r; hw = w;
            reset = 0x0;
        } reserved_2_0[2:0];
    } PADCTRL_REG20 @ 0x50;
    reg {
        name = "PADCTRL_REG21";
        desc = "PADCTRL_REG21 is a drive capability register for the VI2_DAT6 pin. (offset 0x54; total reset 0x00000038; PROVEN: Hi3521A/Hi3520D V300 data sheet (Issue 00B07, 2015-12-10), section 2.5.2, PDF page 145).";
        field {
            name = "reserved";
            desc = "Reserved";
            sw = r; hw = w;
            reset = 0x0;
        } reserved_31_6[31:6];
        field {
            name = "ds";
            desc = "Drive current of the VI2_DAT6 pin
- 00: 4 mA
- 01: 3 mA
- 10: 2 mA
- 11: 1 mA";
            sw = rw; hw = r;
            reset = 0x3;
        } ds[5:4];
        field {
            name = "sl";
            desc = "Level conversion rate of the VI2_DAT6 pin
- 0: fast edge
- 1: slow edge";
            sw = rw; hw = r;
            reset = 0x1;
        } sl[3:3];
        field {
            name = "reserved";
            desc = "Reserved";
            sw = r; hw = w;
            reset = 0x0;
        } reserved_2_0[2:0];
    } PADCTRL_REG21 @ 0x54;
    reg {
        name = "PADCTRL_REG22";
        desc = "PADCTRL_REG22 is a drive capability register for the VI2_DAT5 pin. (offset 0x58; total reset 0x00000038; PROVEN: Hi3521A/Hi3520D V300 data sheet (Issue 00B07, 2015-12-10), section 2.5.2, PDF page 145).";
        field {
            name = "reserved";
            desc = "Reserved";
            sw = r; hw = w;
            reset = 0x0;
        } reserved_31_6[31:6];
        field {
            name = "ds";
            desc = "Drive current of the VI2_DAT5 pin
- 00: 4 mA
- 01: 3 mA
- 10: 2 mA
- 11: 1 mA";
            sw = rw; hw = r;
            reset = 0x3;
        } ds[5:4];
        field {
            name = "sl";
            desc = "Level conversion rate of the VI2_DAT5 pin
- 0: fast edge
- 1: slow edge";
            sw = rw; hw = r;
            reset = 0x1;
        } sl[3:3];
        field {
            name = "reserved";
            desc = "Reserved";
            sw = r; hw = w;
            reset = 0x0;
        } reserved_2_0[2:0];
    } PADCTRL_REG22 @ 0x58;
    reg {
        name = "PADCTRL_REG23";
        desc = "PADCTRL_REG23 is a drive capability register for the VI2_DAT4 pin. (offset 0x5C; total reset 0x00000038; PROVEN: Hi3521A/Hi3520D V300 data sheet (Issue 00B07, 2015-12-10), section 2.5.2, PDF page 146).";
        field {
            name = "reserved";
            desc = "Reserved";
            sw = r; hw = w;
            reset = 0x0;
        } reserved_31_6[31:6];
        field {
            name = "ds";
            desc = "Drive current of the VI2_DAT4 pin
- 00: 4 mA
- 01: 3 mA
- 10: 2 mA
- 11: 1 mA";
            sw = rw; hw = r;
            reset = 0x3;
        } ds[5:4];
        field {
            name = "sl";
            desc = "Level conversion rate of the VI2_DAT4 pin
- 0: fast edge
- 1: slow edge";
            sw = rw; hw = r;
            reset = 0x1;
        } sl[3:3];
        field {
            name = "reserved";
            desc = "Reserved";
            sw = r; hw = w;
            reset = 0x0;
        } reserved_2_0[2:0];
    } PADCTRL_REG23 @ 0x5C;
    reg {
        name = "PADCTRL_REG24";
        desc = "PADCTRL_REG24 is a drive capability register for the VI2_DAT3 pin. (offset 0x60; total reset 0x00000038; PROVEN: Hi3521A/Hi3520D V300 data sheet (Issue 00B07, 2015-12-10), section 2.5.2, PDF page 147).";
        field {
            name = "reserved";
            desc = "Reserved";
            sw = r; hw = w;
            reset = 0x0;
        } reserved_31_6[31:6];
        field {
            name = "ds";
            desc = "Drive current of the VI2_DAT3 pin
- 00: 4 mA
- 01: 3 mA
- 10: 2 mA
- 11: 1 mA";
            sw = rw; hw = r;
            reset = 0x3;
        } ds[5:4];
        field {
            name = "sl";
            desc = "Level conversion rate of the VI2_DAT3 pin
- 0: fast edge
- 1: slow edge";
            sw = rw; hw = r;
            reset = 0x1;
        } sl[3:3];
        field {
            name = "reserved";
            desc = "Reserved";
            sw = r; hw = w;
            reset = 0x0;
        } reserved_2_0[2:0];
    } PADCTRL_REG24 @ 0x60;
    reg {
        name = "PADCTRL_REG25";
        desc = "PADCTRL_REG25 is a drive capability register for the VI2_DAT2 pin. (offset 0x64; total reset 0x00000038; PROVEN: Hi3521A/Hi3520D V300 data sheet (Issue 00B07, 2015-12-10), section 2.5.2, PDF page 147).";
        field {
            name = "reserved";
            desc = "Reserved";
            sw = r; hw = w;
            reset = 0x0;
        } reserved_31_6[31:6];
        field {
            name = "ds";
            desc = "Drive current of the VI2_DAT2 pin
- 00: 4 mA
- 01: 3 mA
- 10: 2 mA
- 11: 1 mA";
            sw = rw; hw = r;
            reset = 0x3;
        } ds[5:4];
        field {
            name = "sl";
            desc = "Level conversion rate of the VI2_DAT2 pin
- 0: fast edge
- 1: slow edge";
            sw = rw; hw = r;
            reset = 0x1;
        } sl[3:3];
        field {
            name = "reserved";
            desc = "Reserved";
            sw = r; hw = w;
            reset = 0x0;
        } reserved_2_0[2:0];
    } PADCTRL_REG25 @ 0x64;
    reg {
        name = "PADCTRL_REG26";
        desc = "PADCTRL_REG26 is a drive capability register for the VI2_DAT1 pin. (offset 0x68; total reset 0x00000038; PROVEN: Hi3521A/Hi3520D V300 data sheet (Issue 00B07, 2015-12-10), section 2.5.2, PDF page 148).";
        field {
            name = "reserved";
            desc = "Reserved";
            sw = r; hw = w;
            reset = 0x0;
        } reserved_31_6[31:6];
        field {
            name = "ds";
            desc = "Drive current of the VI2_DAT1 pin
- 00: 4 mA
- 01: 3 mA
- 10: 2 mA
- 11: 1 mA";
            sw = rw; hw = r;
            reset = 0x3;
        } ds[5:4];
        field {
            name = "sl";
            desc = "Level conversion rate of the VI2_DAT1 pin
- 0: fast edge
- 1: slow edge";
            sw = rw; hw = r;
            reset = 0x1;
        } sl[3:3];
        field {
            name = "reserved";
            desc = "Reserved";
            sw = r; hw = w;
            reset = 0x0;
        } reserved_2_0[2:0];
    } PADCTRL_REG26 @ 0x68;
    reg {
        name = "PADCTRL_REG27";
        desc = "PADCTRL_REG27 is a drive capability register for the VI2_DAT0 pin. (offset 0x6C; total reset 0x00000038; PROVEN: Hi3521A/Hi3520D V300 data sheet (Issue 00B07, 2015-12-10), section 2.5.2, PDF page 149).";
        field {
            name = "reserved";
            desc = "Reserved";
            sw = r; hw = w;
            reset = 0x0;
        } reserved_31_6[31:6];
        field {
            name = "ds";
            desc = "Drive current of the VI2_DAT0 pin
- 00: 4 mA
- 01: 3 mA
- 10: 2 mA
- 11: 1 mA";
            sw = rw; hw = r;
            reset = 0x3;
        } ds[5:4];
        field {
            name = "sl";
            desc = "Level conversion rate of the VI2_DAT0 pin
- 0: fast edge
- 1: slow edge";
            sw = rw; hw = r;
            reset = 0x1;
        } sl[3:3];
        field {
            name = "reserved";
            desc = "Reserved";
            sw = r; hw = w;
            reset = 0x0;
        } reserved_2_0[2:0];
    } PADCTRL_REG27 @ 0x6C;
    reg {
        name = "PADCTRL_REG28";
        desc = "PADCTRL_REG28 is a drive capability register for the VI3_CLK pin. (offset 0x70; total reset 0x00000038; PROVEN: Hi3521A/Hi3520D V300 data sheet (Issue 00B07, 2015-12-10), section 2.5.2, PDF page 149).";
        field {
            name = "reserved";
            desc = "Reserved";
            sw = r; hw = w;
            reset = 0x0;
        } reserved_31_6[31:6];
        field {
            name = "ds";
            desc = "Drive current of the VI3_CLK pin
- 00: 4 mA
- 01: 3 mA
- 10: 2 mA
- 11: 1 mA";
            sw = rw; hw = r;
            reset = 0x3;
        } ds[5:4];
        field {
            name = "sl";
            desc = "Level conversion rate of the VI3_CLK pin
- 0: fast edge
- 1: slow edge";
            sw = rw; hw = r;
            reset = 0x1;
        } sl[3:3];
        field {
            name = "reserved";
            desc = "Reserved";
            sw = r; hw = w;
            reset = 0x0;
        } reserved_2_0[2:0];
    } PADCTRL_REG28 @ 0x70;
    reg {
        name = "PADCTRL_REG29";
        desc = "PADCTRL_REG29 is a drive capability register for the VI3_DAT7 pin. (offset 0x74; total reset 0x00000038; PROVEN: Hi3521A/Hi3520D V300 data sheet (Issue 00B07, 2015-12-10), section 2.5.2, PDF page 150).";
        field {
            name = "reserved";
            desc = "Reserved";
            sw = r; hw = w;
            reset = 0x0;
        } reserved_31_6[31:6];
        field {
            name = "ds";
            desc = "Drive current of the VI3_DAT7 pin
- 00: 4 mA
- 01: 3 mA
- 10: 2 mA
- 11: 1 mA";
            sw = rw; hw = r;
            reset = 0x3;
        } ds[5:4];
        field {
            name = "sl";
            desc = "Level conversion rate of the VI3_DAT7 pin
- 0: fast edge
- 1: slow edge";
            sw = rw; hw = r;
            reset = 0x1;
        } sl[3:3];
        field {
            name = "reserved";
            desc = "Reserved";
            sw = r; hw = w;
            reset = 0x0;
        } reserved_2_0[2:0];
    } PADCTRL_REG29 @ 0x74;
    reg {
        name = "PADCTRL_REG30";
        desc = "PADCTRL_REG30 is a drive capability register for the VI3_DAT6 pin. (offset 0x78; total reset 0x00000038; PROVEN: Hi3521A/Hi3520D V300 data sheet (Issue 00B07, 2015-12-10), section 2.5.2, PDF page 151).";
        field {
            name = "reserved";
            desc = "Reserved";
            sw = r; hw = w;
            reset = 0x0;
        } reserved_31_6[31:6];
        field {
            name = "ds";
            desc = "Drive current of the VI3_DAT6 pin
- 00: 4 mA
- 01: 3 mA
- 10: 2 mA
- 11: 1 mA";
            sw = rw; hw = r;
            reset = 0x3;
        } ds[5:4];
        field {
            name = "sl";
            desc = "Level conversion rate of the VI3_DAT6 pin
- 0: fast edge
- 1: slow edge";
            sw = rw; hw = r;
            reset = 0x1;
        } sl[3:3];
        field {
            name = "reserved";
            desc = "Reserved";
            sw = r; hw = w;
            reset = 0x0;
        } reserved_2_0[2:0];
    } PADCTRL_REG30 @ 0x78;
    reg {
        name = "PADCTRL_REG31";
        desc = "PADCTRL_REG31 is a drive capability register for the VI3_DAT5 pin. (offset 0x7C; total reset 0x00000038; PROVEN: Hi3521A/Hi3520D V300 data sheet (Issue 00B07, 2015-12-10), section 2.5.2, PDF page 151).";
        field {
            name = "reserved";
            desc = "Reserved";
            sw = r; hw = w;
            reset = 0x0;
        } reserved_31_6[31:6];
        field {
            name = "ds";
            desc = "Drive current of the VI3_DAT5 pin
- 00: 4 mA
- 01: 3 mA
- 10: 2 mA
- 11: 1 mA";
            sw = rw; hw = r;
            reset = 0x3;
        } ds[5:4];
        field {
            name = "sl";
            desc = "Level conversion rate of the VI3_DAT5 pin
- 0: fast edge
- 1: slow edge";
            sw = rw; hw = r;
            reset = 0x1;
        } sl[3:3];
        field {
            name = "reserved";
            desc = "Reserved";
            sw = r; hw = w;
            reset = 0x0;
        } reserved_2_0[2:0];
    } PADCTRL_REG31 @ 0x7C;
    reg {
        name = "PADCTRL_REG32";
        desc = "PADCTRL_REG32 is a drive capability register for the VI3_DAT4 pin. (offset 0x80; total reset 0x00000038; PROVEN: Hi3521A/Hi3520D V300 data sheet (Issue 00B07, 2015-12-10), section 2.5.2, PDF page 152).";
        field {
            name = "reserved";
            desc = "Reserved";
            sw = r; hw = w;
            reset = 0x0;
        } reserved_31_6[31:6];
        field {
            name = "ds";
            desc = "Drive current of the VI3_DAT4 pin
- 00: 4 mA
- 01: 3 mA
- 10: 2 mA
- 11: 1 mA";
            sw = rw; hw = r;
            reset = 0x3;
        } ds[5:4];
        field {
            name = "sl";
            desc = "Level conversion rate of the VI3_DAT4 pin
- 0: fast edge
- 1: slow edge";
            sw = rw; hw = r;
            reset = 0x1;
        } sl[3:3];
        field {
            name = "reserved";
            desc = "Reserved";
            sw = r; hw = w;
            reset = 0x0;
        } reserved_2_0[2:0];
    } PADCTRL_REG32 @ 0x80;
    reg {
        name = "PADCTRL_REG33";
        desc = "PADCTRL_REG33 is a drive capability register for the VI3_DAT3 pin. (offset 0x84; total reset 0x00000038; PROVEN: Hi3521A/Hi3520D V300 data sheet (Issue 00B07, 2015-12-10), section 2.5.2, PDF page 153).";
        field {
            name = "reserved";
            desc = "Reserved";
            sw = r; hw = w;
            reset = 0x0;
        } reserved_31_6[31:6];
        field {
            name = "ds";
            desc = "Drive current of the VI3_DAT3 pin
- 00: 4 mA
- 01: 3 mA
- 10: 2 mA
- 11: 1 mA";
            sw = rw; hw = r;
            reset = 0x3;
        } ds[5:4];
        field {
            name = "sl";
            desc = "Level conversion rate of the VI3_DAT3 pin
- 0: fast edge
- 1: slow edge";
            sw = rw; hw = r;
            reset = 0x1;
        } sl[3:3];
        field {
            name = "reserved";
            desc = "Reserved";
            sw = r; hw = w;
            reset = 0x0;
        } reserved_2_0[2:0];
    } PADCTRL_REG33 @ 0x84;
    reg {
        name = "PADCTRL_REG34";
        desc = "PADCTRL_REG34 is a drive capability register for the VI3_DAT2 pin. (offset 0x88; total reset 0x00000038; PROVEN: Hi3521A/Hi3520D V300 data sheet (Issue 00B07, 2015-12-10), section 2.5.2, PDF page 153).";
        field {
            name = "reserved";
            desc = "Reserved";
            sw = r; hw = w;
            reset = 0x0;
        } reserved_31_6[31:6];
        field {
            name = "ds";
            desc = "Drive current of the VI3_DAT2 pin
- 00: 4 mA
- 01: 3 mA
- 10: 2 mA
- 11: 1 mA";
            sw = rw; hw = r;
            reset = 0x3;
        } ds[5:4];
        field {
            name = "sl";
            desc = "Level conversion rate of the VI3_DAT2 pin
- 0: fast edge
- 1: slow edge";
            sw = rw; hw = r;
            reset = 0x1;
        } sl[3:3];
        field {
            name = "reserved";
            desc = "Reserved";
            sw = r; hw = w;
            reset = 0x0;
        } reserved_2_0[2:0];
    } PADCTRL_REG34 @ 0x88;
    reg {
        name = "PADCTRL_REG35";
        desc = "PADCTRL_REG35 is a drive capability register for the VI3_DAT1 pin. (offset 0x8C; total reset 0x00000038; PROVEN: Hi3521A/Hi3520D V300 data sheet (Issue 00B07, 2015-12-10), section 2.5.2, PDF page 154).";
        field {
            name = "reserved";
            desc = "Reserved";
            sw = r; hw = w;
            reset = 0x0;
        } reserved_31_6[31:6];
        field {
            name = "ds";
            desc = "Drive current of the VI3_DAT1 pin
- 00: 4 mA
- 01: 3 mA
- 10: 2 mA
- 11: 1 mA";
            sw = rw; hw = r;
            reset = 0x3;
        } ds[5:4];
        field {
            name = "sl";
            desc = "Level conversion rate of the VI3_DAT1 pin
- 0: fast edge
- 1: slow edge";
            sw = rw; hw = r;
            reset = 0x1;
        } sl[3:3];
        field {
            name = "reserved";
            desc = "Reserved";
            sw = r; hw = w;
            reset = 0x0;
        } reserved_2_0[2:0];
    } PADCTRL_REG35 @ 0x8C;
    reg {
        name = "PADCTRL_REG36";
        desc = "PADCTRL_REG36 is a drive capability register for the VI3_DAT0 pin. (offset 0x90; total reset 0x00000038; PROVEN: Hi3521A/Hi3520D V300 data sheet (Issue 00B07, 2015-12-10), section 2.5.2, PDF page 155).";
        field {
            name = "reserved";
            desc = "Reserved";
            sw = r; hw = w;
            reset = 0x0;
        } reserved_31_6[31:6];
        field {
            name = "ds";
            desc = "Drive current of the VI3_DAT0 pin
- 00: 4 mA
- 01: 3 mA
- 10: 2 mA
- 11: 1 mA";
            sw = rw; hw = r;
            reset = 0x3;
        } ds[5:4];
        field {
            name = "sl";
            desc = "Level conversion rate of the VI3_DAT0 pin
- 0: fast edge
- 1: slow edge";
            sw = rw; hw = r;
            reset = 0x1;
        } sl[3:3];
        field {
            name = "reserved";
            desc = "Reserved";
            sw = r; hw = w;
            reset = 0x0;
        } reserved_2_0[2:0];
    } PADCTRL_REG36 @ 0x90;
    reg {
        name = "PADCTRL_REG37";
        desc = "PADCTRL_REG37 is a drive capability register for the VI_ADC_REFCLK1 pin. (offset 0x94; total reset 0x00000078; PROVEN: Hi3521A/Hi3520D V300 data sheet (Issue 00B07, 2015-12-10), section 2.5.2, PDF page 155).";
        field {
            name = "reserved";
            desc = "Reserved";
            sw = r; hw = w;
            reset = 0x0;
        } reserved_31_7[31:7];
        field {
            name = "ds";
            desc = "Drive current of the VI_ADC_REFCLK1 pin
- 000: 12 mA
- 001: 11 mA
- 010: 9 mA
- 011: 8 mA
- 100: 5 mA
- 101: 4 mA
- 110: 2 mA
- 111: 1 mA";
            sw = rw; hw = r;
            reset = 0x7;
        } ds[6:4];
        field {
            name = "sl";
            desc = "Level conversion rate of the VI_ADC_REFCLK1 pin
- 0: fast edge
- 1: slow edge";
            sw = rw; hw = r;
            reset = 0x1;
        } sl[3:3];
        field {
            name = "reserved";
            desc = "Reserved";
            sw = r; hw = w;
            reset = 0x0;
        } reserved_2_0[2:0];
    } PADCTRL_REG37 @ 0x94;
    reg {
        name = "PADCTRL_REG38";
        desc = "PADCTRL_REG38 is a drive capability register for the VGA_HS pin. (offset 0x98; total reset 0x00000078; PROVEN: Hi3521A/Hi3520D V300 data sheet (Issue 00B07, 2015-12-10), section 2.5.2, PDF page 156).";
        field {
            name = "reserved";
            desc = "Reserved";
            sw = r; hw = w;
            reset = 0x0;
        } reserved_31_7[31:7];
        field {
            name = "ds";
            desc = "Drive current of the VGA_HS pin
- 000: 12 mA
- 001: 11 mA
- 010: 9 mA
- 011: 8 mA
- 100: 5 mA
- 101: 4 mA
- 110: 2 mA
- 111: 1 mA";
            sw = rw; hw = r;
            reset = 0x7;
        } ds[6:4];
        field {
            name = "sl";
            desc = "Level conversion rate of the VGA_HS pin
- 0: fast edge
- 1: slow edge";
            sw = rw; hw = r;
            reset = 0x1;
        } sl[3:3];
        field {
            name = "reserved";
            desc = "Reserved";
            sw = r; hw = w;
            reset = 0x0;
        } reserved_2_0[2:0];
    } PADCTRL_REG38 @ 0x98;
    reg {
        name = "PADCTRL_REG39";
        desc = "PADCTRL_REG39 is a drive capability register for the VGA_VS pin. (offset 0x9C; total reset 0x00000078; PROVEN: Hi3521A/Hi3520D V300 data sheet (Issue 00B07, 2015-12-10), section 2.5.2, PDF page 157).";
        field {
            name = "reserved";
            desc = "Reserved";
            sw = r; hw = w;
            reset = 0x0;
        } reserved_31_7[31:7];
        field {
            name = "ds";
            desc = "Drive current of the VGA_VS pin
- 000: 12 mA
- 001: 11 mA
- 010: 9 mA
- 011: 8 mA
- 100: 5 mA
- 101: 4 mA
- 110: 2 mA
- 111: 1 mA";
            sw = rw; hw = r;
            reset = 0x7;
        } ds[6:4];
        field {
            name = "sl";
            desc = "Level conversion rate of the VGA_VS pin
- 0: fast edge
- 1: slow edge";
            sw = rw; hw = r;
            reset = 0x1;
        } sl[3:3];
        field {
            name = "reserved";
            desc = "Reserved";
            sw = r; hw = w;
            reset = 0x0;
        } reserved_2_0[2:0];
    } PADCTRL_REG39 @ 0x9C;
    reg {
        name = "PADCTRL_REG40";
        desc = "PADCTRL_REG40 is a drive capability register for the I2S0_BCLK_RX pin. (offset 0xA0; total reset 0x00000038; PROVEN: Hi3521A/Hi3520D V300 data sheet (Issue 00B07, 2015-12-10), section 2.5.2, PDF page 158).";
        field {
            name = "reserved";
            desc = "Reserved";
            sw = r; hw = w;
            reset = 0x0;
        } reserved_31_6[31:6];
        field {
            name = "ds";
            desc = "Drive current of the I2S0_BCLK_RX pin
- 00: 4 mA
- 01: 3 mA
- 10: 2 mA
- 11: 1 mA";
            sw = rw; hw = r;
            reset = 0x3;
        } ds[5:4];
        field {
            name = "sl";
            desc = "Level conversion rate of the I2S0_BCLK_RX pin
- 0: fast edge
- 1: slow edge";
            sw = rw; hw = r;
            reset = 0x1;
        } sl[3:3];
        field {
            name = "reserved";
            desc = "Reserved";
            sw = r; hw = w;
            reset = 0x0;
        } reserved_2_0[2:0];
    } PADCTRL_REG40 @ 0xA0;
    reg {
        name = "PADCTRL_REG41";
        desc = "PADCTRL_REG41 is a drive capability register for the I2S0_WS_RX pin. (offset 0xA4; total reset 0x00000038; PROVEN: Hi3521A/Hi3520D V300 data sheet (Issue 00B07, 2015-12-10), section 2.5.2, PDF page 158).";
        field {
            name = "reserved";
            desc = "Reserved";
            sw = r; hw = w;
            reset = 0x0;
        } reserved_31_6[31:6];
        field {
            name = "ds";
            desc = "Drive current of the I2S0_WS_RX pin
- 00: 4 mA
- 01: 3 mA
- 10: 2 mA
- 11: 1 mA";
            sw = rw; hw = r;
            reset = 0x3;
        } ds[5:4];
        field {
            name = "sl";
            desc = "Level conversion rate of the I2S0_WS_RX pin
- 0: fast edge
- 1: slow edge";
            sw = rw; hw = r;
            reset = 0x1;
        } sl[3:3];
        field {
            name = "reserved";
            desc = "Reserved";
            sw = r; hw = w;
            reset = 0x0;
        } reserved_2_0[2:0];
    } PADCTRL_REG41 @ 0xA4;
    reg {
        name = "PADCTRL_REG42";
        desc = "PADCTRL_REG42 is a drive capability register for the I2S0_SD_RX pin. (offset 0xA8; total reset 0x00000038; PROVEN: Hi3521A/Hi3520D V300 data sheet (Issue 00B07, 2015-12-10), section 2.5.2, PDF page 159).";
        field {
            name = "reserved";
            desc = "Reserved";
            sw = r; hw = w;
            reset = 0x0;
        } reserved_31_6[31:6];
        field {
            name = "ds";
            desc = "Drive current of the I2S0_SD_RX pin
- 00: 4 mA
- 01: 3 mA
- 10: 2 mA
- 11: 1 mA";
            sw = rw; hw = r;
            reset = 0x3;
        } ds[5:4];
        field {
            name = "sl";
            desc = "Level conversion rate of the I2S0_SD_RX pin
- 0: fast edge
- 1: slow edge";
            sw = rw; hw = r;
            reset = 0x1;
        } sl[3:3];
        field {
            name = "reserved";
            desc = "Reserved";
            sw = r; hw = w;
            reset = 0x0;
        } reserved_2_0[2:0];
    } PADCTRL_REG42 @ 0xA8;
    reg {
        name = "PADCTRL_REG43";
        desc = "PADCTRL_REG43 is a drive capability register for the I2S1_BCLK_RX pin. (offset 0xAC; total reset 0x00000038; PROVEN: Hi3521A/Hi3520D V300 data sheet (Issue 00B07, 2015-12-10), section 2.5.2, PDF page 160).";
        field {
            name = "reserved";
            desc = "Reserved";
            sw = r; hw = w;
            reset = 0x0;
        } reserved_31_6[31:6];
        field {
            name = "ds";
            desc = "Drive current of the I2S1_BCLK_RX pin
- 00: 4 mA
- 01: 3 mA
- 10: 2 mA
- 11: 1 mA";
            sw = rw; hw = r;
            reset = 0x3;
        } ds[5:4];
        field {
            name = "sl";
            desc = "Level conversion rate of the I2S1_BCLK_RX pin
- 0: fast edge
- 1: slow edge";
            sw = rw; hw = r;
            reset = 0x1;
        } sl[3:3];
        field {
            name = "reserved";
            desc = "Reserved";
            sw = r; hw = w;
            reset = 0x0;
        } reserved_2_0[2:0];
    } PADCTRL_REG43 @ 0xAC;
    reg {
        name = "PADCTRL_REG44";
        desc = "PADCTRL_REG44 is a drive capability register for the I2S1_WS_RX pin. (offset 0xB0; total reset 0x00000038; PROVEN: Hi3521A/Hi3520D V300 data sheet (Issue 00B07, 2015-12-10), section 2.5.2, PDF page 160).";
        field {
            name = "reserved";
            desc = "Reserved";
            sw = r; hw = w;
            reset = 0x0;
        } reserved_31_6[31:6];
        field {
            name = "ds";
            desc = "Drive current of the I2S1_WS_RX pin
- 00: 4 mA
- 01: 3 mA
- 10: 2 mA
- 11: 1 mA";
            sw = rw; hw = r;
            reset = 0x3;
        } ds[5:4];
        field {
            name = "sl";
            desc = "Level conversion rate of the I2S1_WS_RX pin
- 0: fast edge
- 1: slow edge";
            sw = rw; hw = r;
            reset = 0x1;
        } sl[3:3];
        field {
            name = "reserved";
            desc = "Reserved";
            sw = r; hw = w;
            reset = 0x0;
        } reserved_2_0[2:0];
    } PADCTRL_REG44 @ 0xB0;
    reg {
        name = "PADCTRL_REG45";
        desc = "PADCTRL_REG45 is a drive capability register for the I2S1_SD_RX pin. (offset 0xB4; total reset 0x00000038; PROVEN: Hi3521A/Hi3520D V300 data sheet (Issue 00B07, 2015-12-10), section 2.5.2, PDF page 161).";
        field {
            name = "reserved";
            desc = "Reserved";
            sw = r; hw = w;
            reset = 0x0;
        } reserved_31_6[31:6];
        field {
            name = "ds";
            desc = "Drive current of the I2S1_SD_RX pin
- 00: 4 mA
- 01: 3 mA
- 10: 2 mA
- 11: 1 mA";
            sw = rw; hw = r;
            reset = 0x3;
        } ds[5:4];
        field {
            name = "sl";
            desc = "Level conversion rate of the I2S1_SD_RX pin
- 0: fast edge
- 1: slow edge";
            sw = rw; hw = r;
            reset = 0x1;
        } sl[3:3];
        field {
            name = "reserved";
            desc = "Reserved";
            sw = r; hw = w;
            reset = 0x0;
        } reserved_2_0[2:0];
    } PADCTRL_REG45 @ 0xB4;
    reg {
        name = "PADCTRL_REG46";
        desc = "PADCTRL_REG46 is a drive capability register for the I2S2_BCLK_TX pin. (offset 0xB8; total reset 0x00000038; PROVEN: Hi3521A/Hi3520D V300 data sheet (Issue 00B07, 2015-12-10), section 2.5.2, PDF page 162).";
        field {
            name = "reserved";
            desc = "Reserved";
            sw = r; hw = w;
            reset = 0x0;
        } reserved_31_6[31:6];
        field {
            name = "ds";
            desc = "Drive current of the I2S2_BCLK_TX pin
- 00: 4 mA
- 01: 3 mA
- 10: 2 mA
- 11: 1 mA";
            sw = rw; hw = r;
            reset = 0x3;
        } ds[5:4];
        field {
            name = "sl";
            desc = "Level conversion rate of the I2S2_BCLK_TX pin
- 0: fast edge
- 1: slow edge";
            sw = rw; hw = r;
            reset = 0x1;
        } sl[3:3];
        field {
            name = "reserved";
            desc = "Reserved";
            sw = r; hw = w;
            reset = 0x0;
        } reserved_2_0[2:0];
    } PADCTRL_REG46 @ 0xB8;
    reg {
        name = "PADCTRL_REG47";
        desc = "PADCTRL_REG47 is a drive capability register for the I2S2_WS_TX pin. (offset 0xBC; total reset 0x00000038; PROVEN: Hi3521A/Hi3520D V300 data sheet (Issue 00B07, 2015-12-10), section 2.5.2, PDF page 162).";
        field {
            name = "reserved";
            desc = "Reserved";
            sw = r; hw = w;
            reset = 0x0;
        } reserved_31_6[31:6];
        field {
            name = "ds";
            desc = "Drive current of the I2S2_WS_TX pin
- 00: 4 mA
- 01: 3 mA
- 10: 2 mA
- 11: 1 mA";
            sw = rw; hw = r;
            reset = 0x3;
        } ds[5:4];
        field {
            name = "sl";
            desc = "Level conversion rate of the I2S2_WS_TX pin
- 0: fast edge
- 1: slow edge";
            sw = rw; hw = r;
            reset = 0x1;
        } sl[3:3];
        field {
            name = "reserved";
            desc = "Reserved";
            sw = r; hw = w;
            reset = 0x0;
        } reserved_2_0[2:0];
    } PADCTRL_REG47 @ 0xBC;
    reg {
        name = "PADCTRL_REG48";
        desc = "PADCTRL_REG48 is a drive capability register for the I2S2_SD_TX pin. (offset 0xC0; total reset 0x00000038; PROVEN: Hi3521A/Hi3520D V300 data sheet (Issue 00B07, 2015-12-10), section 2.5.2, PDF page 163).";
        field {
            name = "reserved";
            desc = "Reserved";
            sw = r; hw = w;
            reset = 0x0;
        } reserved_31_6[31:6];
        field {
            name = "ds";
            desc = "Drive current of the I2S2_SD_TX pin
- 00: 4 mA
- 01: 3 mA
- 10: 2 mA
- 11: 1 mA";
            sw = rw; hw = r;
            reset = 0x3;
        } ds[5:4];
        field {
            name = "sl";
            desc = "Level conversion rate of the I2S2_SD_TX pin
- 0: fast edge
- 1: slow edge";
            sw = rw; hw = r;
            reset = 0x1;
        } sl[3:3];
        field {
            name = "reserved";
            desc = "Reserved";
            sw = r; hw = w;
            reset = 0x0;
        } reserved_2_0[2:0];
    } PADCTRL_REG48 @ 0xC0;
    reg {
        name = "PADCTRL_REG49";
        desc = "PADCTRL_REG49 is a drive capability register for the SPI_SCLK pin. (offset 0xC4; total reset 0x00000078; PROVEN: Hi3521A/Hi3520D V300 data sheet (Issue 00B07, 2015-12-10), section 2.5.2, PDF page 164).";
        field {
            name = "reserved";
            desc = "Reserved";
            sw = r; hw = w;
            reset = 0x0;
        } reserved_31_7[31:7];
        field {
            name = "ds";
            desc = "Drive current of the SPI_SCLK pin
- 000: 12 mA
- 001: 11 mA
- 010: 9 mA
- 011: 8 mA
- 100: 5 mA
- 101: 4 mA
- 110: 2 mA
- 111: 1 mA";
            sw = rw; hw = r;
            reset = 0x7;
        } ds[6:4];
        field {
            name = "sl";
            desc = "Level conversion rate of the SPI_SCLK pin
- 0: fast edge
- 1: slow edge";
            sw = rw; hw = r;
            reset = 0x1;
        } sl[3:3];
        field {
            name = "reserved";
            desc = "Reserved";
            sw = r; hw = w;
            reset = 0x0;
        } reserved_2_0[2:0];
    } PADCTRL_REG49 @ 0xC4;
    reg {
        name = "PADCTRL_REG50";
        desc = "PADCTRL_REG50 is a drive capability register for the SPI_SDO pin. (offset 0xC8; total reset 0x00000038; PROVEN: Hi3521A/Hi3520D V300 data sheet (Issue 00B07, 2015-12-10), section 2.5.2, PDF page 164).";
        field {
            name = "reserved";
            desc = "Reserved";
            sw = r; hw = w;
            reset = 0x0;
        } reserved_31_6[31:6];
        field {
            name = "ds";
            desc = "Drive current of the SPI_SDO pin
- 00: 4 mA
- 01: 3 mA
- 10: 2 mA
- 11: 1 mA";
            sw = rw; hw = r;
            reset = 0x3;
        } ds[5:4];
        field {
            name = "sl";
            desc = "Level conversion rate of the SPI_SDO pin
- 0: fast edge
- 1: slow edge";
            sw = rw; hw = r;
            reset = 0x1;
        } sl[3:3];
        field {
            name = "reserved";
            desc = "Reserved";
            sw = r; hw = w;
            reset = 0x0;
        } reserved_2_0[2:0];
    } PADCTRL_REG50 @ 0xC8;
    reg {
        name = "PADCTRL_REG51";
        desc = "PADCTRL_REG51 is a drive capability register for the SPI_SDI pin. (offset 0xCC; total reset 0x00000038; PROVEN: Hi3521A/Hi3520D V300 data sheet (Issue 00B07, 2015-12-10), section 2.5.2, PDF page 165).";
        field {
            name = "reserved";
            desc = "Reserved";
            sw = r; hw = w;
            reset = 0x0;
        } reserved_31_6[31:6];
        field {
            name = "ds";
            desc = "Drive current of the SPI_SDI pin
- 00: 4 mA
- 01: 3 mA
- 10: 2 mA
- 11: 1 mA";
            sw = rw; hw = r;
            reset = 0x3;
        } ds[5:4];
        field {
            name = "sl";
            desc = "Level conversion rate of the SPI_SDI pin
- 0: fast edge
- 1: slow edge";
            sw = rw; hw = r;
            reset = 0x1;
        } sl[3:3];
        field {
            name = "reserved";
            desc = "Reserved";
            sw = r; hw = w;
            reset = 0x0;
        } reserved_2_0[2:0];
    } PADCTRL_REG51 @ 0xCC;
    reg {
        name = "PADCTRL_REG52";
        desc = "PADCTRL_REG52 is a drive capability register for the SPI_CSN0 pin. (offset 0xD0; total reset 0x00000038; PROVEN: Hi3521A/Hi3520D V300 data sheet (Issue 00B07, 2015-12-10), section 2.5.2, PDF page 166).";
        field {
            name = "reserved";
            desc = "Reserved";
            sw = r; hw = w;
            reset = 0x0;
        } reserved_31_6[31:6];
        field {
            name = "ds";
            desc = "Drive current of the SPI_CSN0 pin
- 00: 4 mA
- 01: 3 mA
- 10: 2 mA
- 11: 1 mA";
            sw = rw; hw = r;
            reset = 0x3;
        } ds[5:4];
        field {
            name = "sl";
            desc = "Level conversion rate of the SPI_CSN0 pin
- 0: fast edge
- 1: slow edge";
            sw = rw; hw = r;
            reset = 0x1;
        } sl[3:3];
        field {
            name = "reserved";
            desc = "Reserved";
            sw = r; hw = w;
            reset = 0x0;
        } reserved_2_0[2:0];
    } PADCTRL_REG52 @ 0xD0;
    reg {
        name = "PADCTRL_REG54";
        desc = "PADCTRL_REG54 is a drive capability register for the PWM_OUT0 pin. (offset 0xD8; total reset 0x00000038; PROVEN: Hi3521A/Hi3520D V300 data sheet (Issue 00B07, 2015-12-10), section 2.5.2, PDF page 166).";
        field {
            name = "reserved";
            desc = "Reserved";
            sw = r; hw = w;
            reset = 0x0;
        } reserved_31_6[31:6];
        field {
            name = "ds";
            desc = "Drive current of the PWM_OUT0 pin
- 00: 4 mA
- 01: 3 mA
- 10: 2 mA
- 11: 1 mA";
            sw = rw; hw = r;
            reset = 0x3;
        } ds[5:4];
        field {
            name = "sl";
            desc = "Level conversion rate of the PWM_OUT0 pin
- 0: fast edge
- 1: slow edge";
            sw = rw; hw = r;
            reset = 0x1;
        } sl[3:3];
        field {
            name = "reserved";
            desc = "Reserved";
            sw = r; hw = w;
            reset = 0x0;
        } reserved_2_0[2:0];
    } PADCTRL_REG54 @ 0xD8;
    reg {
        name = "PADCTRL_REG56";
        desc = "PADCTRL_REG56 is a drive capability register for the I2C_SDA pin. (offset 0xE0; total reset 0x00000038; PROVEN: Hi3521A/Hi3520D V300 data sheet (Issue 00B07, 2015-12-10), section 2.5.2, PDF page 167).";
        field {
            name = "reserved";
            desc = "Reserved";
            sw = r; hw = w;
            reset = 0x0;
        } reserved_31_6[31:6];
        field {
            name = "ds";
            desc = "Drive current of the I2C_SDA pin
- 00: 4 mA
- 01: 3 mA
- 10: 2 mA
- 11: 1 mA";
            sw = rw; hw = r;
            reset = 0x3;
        } ds[5:4];
        field {
            name = "sl";
            desc = "Level conversion rate of the I2C_SDA pin
- 0: fast edge
- 1: slow edge";
            sw = rw; hw = r;
            reset = 0x1;
        } sl[3:3];
        field {
            name = "reserved";
            desc = "Reserved";
            sw = r; hw = w;
            reset = 0x0;
        } reserved_2_0[2:0];
    } PADCTRL_REG56 @ 0xE0;
    reg {
        name = "PADCTRL_REG57";
        desc = "PADCTRL_REG57 is a drive capability register for the I2C_SCL pin. (offset 0xE4; total reset 0x00000038; PROVEN: Hi3521A/Hi3520D V300 data sheet (Issue 00B07, 2015-12-10), section 2.5.2, PDF page 168).";
        field {
            name = "reserved";
            desc = "Reserved";
            sw = r; hw = w;
            reset = 0x0;
        } reserved_31_6[31:6];
        field {
            name = "ds";
            desc = "Drive current of the I2C_SCL pin
- 00: 4 mA
- 01: 3 mA
- 10: 2 mA
- 11: 1 mA";
            sw = rw; hw = r;
            reset = 0x3;
        } ds[5:4];
        field {
            name = "sl";
            desc = "Level conversion rate of the I2C_SCL pin
- 0: fast edge
- 1: slow edge";
            sw = rw; hw = r;
            reset = 0x1;
        } sl[3:3];
        field {
            name = "reserved";
            desc = "Reserved";
            sw = r; hw = w;
            reset = 0x0;
        } reserved_2_0[2:0];
    } PADCTRL_REG57 @ 0xE4;
    reg {
        name = "PADCTRL_REG58";
        desc = "PADCTRL_REG58 is a drive capability register for the UART0_RXD pin. (offset 0xE8; total reset 0x00000038; PROVEN: Hi3521A/Hi3520D V300 data sheet (Issue 00B07, 2015-12-10), section 2.5.2, PDF page 168).";
        field {
            name = "reserved";
            desc = "Reserved";
            sw = r; hw = w;
            reset = 0x0;
        } reserved_31_6[31:6];
        field {
            name = "ds";
            desc = "Drive current of the UART0_RXD pin
- 00: 4 mA
- 01: 3 mA
- 10: 2 mA
- 11: 1 mA";
            sw = rw; hw = r;
            reset = 0x3;
        } ds[5:4];
        field {
            name = "sl";
            desc = "Level conversion rate of the UART0_RXD pin
- 0: fast edge
- 1: slow edge";
            sw = rw; hw = r;
            reset = 0x1;
        } sl[3:3];
        field {
            name = "reserved";
            desc = "Reserved";
            sw = r; hw = w;
            reset = 0x0;
        } reserved_2_0[2:0];
    } PADCTRL_REG58 @ 0xE8;
    reg {
        name = "PADCTRL_REG59";
        desc = "PADCTRL_REG59 is a drive capability register for the UART0_TXD pin. (offset 0xEC; total reset 0x00000038; PROVEN: Hi3521A/Hi3520D V300 data sheet (Issue 00B07, 2015-12-10), section 2.5.2, PDF page 169).";
        field {
            name = "reserved";
            desc = "Reserved";
            sw = r; hw = w;
            reset = 0x0;
        } reserved_31_6[31:6];
        field {
            name = "ds";
            desc = "Drive current of the UART0_TXD pin
- 00: 4 mA
- 01: 3 mA
- 10: 2 mA
- 11: 1 mA";
            sw = rw; hw = r;
            reset = 0x3;
        } ds[5:4];
        field {
            name = "sl";
            desc = "Level conversion rate of the UART0_TXD pin
- 0: fast edge
- 1: slow edge";
            sw = rw; hw = r;
            reset = 0x1;
        } sl[3:3];
        field {
            name = "reserved";
            desc = "Reserved";
            sw = r; hw = w;
            reset = 0x0;
        } reserved_2_0[2:0];
    } PADCTRL_REG59 @ 0xEC;
    reg {
        name = "PADCTRL_REG60";
        desc = "PADCTRL_REG60 is a drive capability register for the UART0_CTSN pin. (offset 0xF0; total reset 0x00000038; PROVEN: Hi3521A/Hi3520D V300 data sheet (Issue 00B07, 2015-12-10), section 2.5.2, PDF page 170).";
        field {
            name = "reserved";
            desc = "Reserved";
            sw = r; hw = w;
            reset = 0x0;
        } reserved_31_6[31:6];
        field {
            name = "ds";
            desc = "Drive current of the UART0_CTSN pin
- 00: 4 mA
- 01: 3 mA
- 10: 2 mA
- 11: 1 mA";
            sw = rw; hw = r;
            reset = 0x3;
        } ds[5:4];
        field {
            name = "sl";
            desc = "Level conversion rate of the UART0_CTSN pin
- 0: fast edge
- 1: slow edge";
            sw = rw; hw = r;
            reset = 0x1;
        } sl[3:3];
        field {
            name = "reserved";
            desc = "Reserved";
            sw = r; hw = w;
            reset = 0x0;
        } reserved_2_0[2:0];
    } PADCTRL_REG60 @ 0xF0;
    reg {
        name = "PADCTRL_REG61";
        desc = "PADCTRL_REG61 is a drive capability register for the UART0_RTSN pin. (offset 0xF4; total reset 0x00000038; PROVEN: Hi3521A/Hi3520D V300 data sheet (Issue 00B07, 2015-12-10), section 2.5.2, PDF page 170).";
        field {
            name = "reserved";
            desc = "Reserved";
            sw = r; hw = w;
            reset = 0x0;
        } reserved_31_6[31:6];
        field {
            name = "ds";
            desc = "Drive current of the UART0_RTSN pin
- 00: 4 mA
- 01: 3 mA
- 10: 2 mA
- 11: 1 mA";
            sw = rw; hw = r;
            reset = 0x3;
        } ds[5:4];
        field {
            name = "sl";
            desc = "Level conversion rate of the UART0_RTSN pin
- 0: fast edge
- 1: slow edge";
            sw = rw; hw = r;
            reset = 0x1;
        } sl[3:3];
        field {
            name = "reserved";
            desc = "Reserved";
            sw = r; hw = w;
            reset = 0x0;
        } reserved_2_0[2:0];
    } PADCTRL_REG61 @ 0xF4;
    reg {
        name = "PADCTRL_REG62";
        desc = "PADCTRL_REG62 is a drive capability register for the UART1_RXD pin. (offset 0xF8; total reset 0x00000038; PROVEN: Hi3521A/Hi3520D V300 data sheet (Issue 00B07, 2015-12-10), section 2.5.2, PDF page 171).";
        field {
            name = "reserved";
            desc = "Reserved";
            sw = r; hw = w;
            reset = 0x0;
        } reserved_31_6[31:6];
        field {
            name = "ds";
            desc = "Drive current of the UART1_RXD pin
- 00: 4 mA
- 01: 3 mA
- 10: 2 mA
- 11: 1 mA";
            sw = rw; hw = r;
            reset = 0x3;
        } ds[5:4];
        field {
            name = "sl";
            desc = "Level conversion rate of the UART1_RXD pin
- 0: fast edge
- 1: slow edge";
            sw = rw; hw = r;
            reset = 0x1;
        } sl[3:3];
        field {
            name = "reserved";
            desc = "Reserved";
            sw = r; hw = w;
            reset = 0x0;
        } reserved_2_0[2:0];
    } PADCTRL_REG62 @ 0xF8;
    reg {
        name = "PADCTRL_REG63";
        desc = "PADCTRL_REG63 is a drive capability register for the UART1_TXD pin. (offset 0xFC; total reset 0x00000038; PROVEN: Hi3521A/Hi3520D V300 data sheet (Issue 00B07, 2015-12-10), section 2.5.2, PDF page 172).";
        field {
            name = "reserved";
            desc = "Reserved";
            sw = r; hw = w;
            reset = 0x0;
        } reserved_31_6[31:6];
        field {
            name = "ds";
            desc = "Drive current of the UART1_TXD pin
- 00: 4 mA
- 01: 3 mA
- 10: 2 mA
- 11: 1 mA";
            sw = rw; hw = r;
            reset = 0x3;
        } ds[5:4];
        field {
            name = "sl";
            desc = "Level conversion rate of the UART1_TXD pin
- 0: fast edge
- 1: slow edge";
            sw = rw; hw = r;
            reset = 0x1;
        } sl[3:3];
        field {
            name = "reserved";
            desc = "Reserved";
            sw = r; hw = w;
            reset = 0x0;
        } reserved_2_0[2:0];
    } PADCTRL_REG63 @ 0xFC;
    reg {
        name = "PADCTRL_REG64";
        desc = "PADCTRL_REG64 is a drive capability register for the UART2_RXD pin. (offset 0x100; total reset 0x00000038; PROVEN: Hi3521A/Hi3520D V300 data sheet (Issue 00B07, 2015-12-10), section 2.5.2, PDF page 172).";
        field {
            name = "reserved";
            desc = "Reserved";
            sw = r; hw = w;
            reset = 0x0;
        } reserved_31_6[31:6];
        field {
            name = "ds";
            desc = "Drive current of the UART2_RXD pin
- 00: 4 mA
- 01: 3 mA
- 10: 2 mA
- 11: 1 mA";
            sw = rw; hw = r;
            reset = 0x3;
        } ds[5:4];
        field {
            name = "sl";
            desc = "Level conversion rate of the UART2_RXD pin
- 0: fast edge
- 1: slow edge";
            sw = rw; hw = r;
            reset = 0x1;
        } sl[3:3];
        field {
            name = "reserved";
            desc = "Reserved";
            sw = r; hw = w;
            reset = 0x0;
        } reserved_2_0[2:0];
    } PADCTRL_REG64 @ 0x100;
    reg {
        name = "PADCTRL_REG65";
        desc = "PADCTRL_REG65 is a drive capability register for the UART2_TXD pin. (offset 0x104; total reset 0x00000038; PROVEN: Hi3521A/Hi3520D V300 data sheet (Issue 00B07, 2015-12-10), section 2.5.2, PDF page 173).";
        field {
            name = "reserved";
            desc = "Reserved";
            sw = r; hw = w;
            reset = 0x0;
        } reserved_31_6[31:6];
        field {
            name = "ds";
            desc = "Drive current of the UART2_TXD pin
- 00: 4 mA
- 01: 3 mA
- 10: 2 mA
- 11: 1 mA";
            sw = rw; hw = r;
            reset = 0x3;
        } ds[5:4];
        field {
            name = "sl";
            desc = "Level conversion rate of the UART2_TXD pin
- 0: fast edge
- 1: slow edge";
            sw = rw; hw = r;
            reset = 0x1;
        } sl[3:3];
        field {
            name = "reserved";
            desc = "Reserved";
            sw = r; hw = w;
            reset = 0x0;
        } reserved_2_0[2:0];
    } PADCTRL_REG65 @ 0x104;
    reg {
        name = "PADCTRL_REG66";
        desc = "PADCTRL_REG66 is a drive capability register for the RGMII_RXDV pin. (offset 0x108; total reset 0x00000038; PROVEN: Hi3521A/Hi3520D V300 data sheet (Issue 00B07, 2015-12-10), section 2.5.2, PDF page 174).";
        field {
            name = "reserved";
            desc = "Reserved";
            sw = r; hw = w;
            reset = 0x0;
        } reserved_31_6[31:6];
        field {
            name = "ds";
            desc = "Drive current of the RGMII_RXDV pin
- 00: 4 mA
- 01: 3 mA
- 10: 2 mA
- 11: 1 mA";
            sw = rw; hw = r;
            reset = 0x3;
        } ds[5:4];
        field {
            name = "sl";
            desc = "Level conversion rate of the RGMII_RXDV pin
- 0: fast edge
- 1: slow edge";
            sw = rw; hw = r;
            reset = 0x1;
        } sl[3:3];
        field {
            name = "reserved";
            desc = "Reserved";
            sw = r; hw = w;
            reset = 0x0;
        } reserved_2_0[2:0];
    } PADCTRL_REG66 @ 0x108;
    reg {
        name = "PADCTRL_REG67";
        desc = "PADCTRL_REG67 is a drive capability register for the RGMII_RXD3 pin. (offset 0x10C; total reset 0x00000038; PROVEN: Hi3521A/Hi3520D V300 data sheet (Issue 00B07, 2015-12-10), section 2.5.2, PDF page 174).";
        field {
            name = "reserved";
            desc = "Reserved";
            sw = r; hw = w;
            reset = 0x0;
        } reserved_31_6[31:6];
        field {
            name = "ds";
            desc = "Drive current of the RGMII_RXD3 pin
- 00: 4 mA
- 01: 3 mA
- 10: 2 mA
- 11: 1 mA";
            sw = rw; hw = r;
            reset = 0x3;
        } ds[5:4];
        field {
            name = "sl";
            desc = "Level conversion rate of the RGMII_RXD3 pin
- 0: fast edge
- 1: slow edge";
            sw = rw; hw = r;
            reset = 0x1;
        } sl[3:3];
        field {
            name = "reserved";
            desc = "Reserved";
            sw = r; hw = w;
            reset = 0x0;
        } reserved_2_0[2:0];
    } PADCTRL_REG67 @ 0x10C;
    reg {
        name = "PADCTRL_REG68";
        desc = "PADCTRL_REG68 is a drive capability register for the RGMII_RXD2 pin. (offset 0x110; total reset 0x00000038; PROVEN: Hi3521A/Hi3520D V300 data sheet (Issue 00B07, 2015-12-10), section 2.5.2, PDF page 175).";
        field {
            name = "reserved";
            desc = "Reserved";
            sw = r; hw = w;
            reset = 0x0;
        } reserved_31_6[31:6];
        field {
            name = "ds";
            desc = "Drive current of the RGMII_RXD2 pin
- 00: 4 mA
- 01: 3 mA
- 10: 2 mA
- 11: 1 mA";
            sw = rw; hw = r;
            reset = 0x3;
        } ds[5:4];
        field {
            name = "sl";
            desc = "Level conversion rate of the RGMII_RXD2 pin
- 0: fast edge
- 1: slow edge";
            sw = rw; hw = r;
            reset = 0x1;
        } sl[3:3];
        field {
            name = "reserved";
            desc = "Reserved";
            sw = r; hw = w;
            reset = 0x0;
        } reserved_2_0[2:0];
    } PADCTRL_REG68 @ 0x110;
    reg {
        name = "PADCTRL_REG69";
        desc = "PADCTRL_REG69 is a drive capability register for the RGMII_RXD1 pin. (offset 0x114; total reset 0x00000038; PROVEN: Hi3521A/Hi3520D V300 data sheet (Issue 00B07, 2015-12-10), section 2.5.2, PDF page 176).";
        field {
            name = "reserved";
            desc = "Reserved";
            sw = r; hw = w;
            reset = 0x0;
        } reserved_31_6[31:6];
        field {
            name = "ds";
            desc = "Drive current of the RGMII_RXD1 pin
- 00: 4 mA
- 01: 3 mA
- 10: 2 mA
- 11: 1 mA";
            sw = rw; hw = r;
            reset = 0x3;
        } ds[5:4];
        field {
            name = "sl";
            desc = "Level conversion rate of the RGMII_RXD1 pin
- 0: fast edge
- 1: slow edge";
            sw = rw; hw = r;
            reset = 0x1;
        } sl[3:3];
        field {
            name = "reserved";
            desc = "Reserved";
            sw = r; hw = w;
            reset = 0x0;
        } reserved_2_0[2:0];
    } PADCTRL_REG69 @ 0x114;
    reg {
        name = "PADCTRL_REG70";
        desc = "PADCTRL_REG70 is a drive capability register for the RGMII_RXD0 pin. (offset 0x118; total reset 0x00000038; PROVEN: Hi3521A/Hi3520D V300 data sheet (Issue 00B07, 2015-12-10), section 2.5.2, PDF page 176).";
        field {
            name = "reserved";
            desc = "Reserved";
            sw = r; hw = w;
            reset = 0x0;
        } reserved_31_6[31:6];
        field {
            name = "ds";
            desc = "Drive current of the RGMII_RXD0 pin
- 00: 4 mA
- 01: 3 mA
- 10: 2 mA
- 11: 1 mA";
            sw = rw; hw = r;
            reset = 0x3;
        } ds[5:4];
        field {
            name = "sl";
            desc = "Level conversion rate of the RGMII_RXD0 pin
- 0: fast edge
- 1: slow edge";
            sw = rw; hw = r;
            reset = 0x1;
        } sl[3:3];
        field {
            name = "reserved";
            desc = "Reserved";
            sw = r; hw = w;
            reset = 0x0;
        } reserved_2_0[2:0];
    } PADCTRL_REG70 @ 0x118;
    reg {
        name = "PADCTRL_REG71";
        desc = "PADCTRL_REG71 is a drive capability register for the RGMII_RXCK pin. (offset 0x11C; total reset 0x00000038; PROVEN: Hi3521A/Hi3520D V300 data sheet (Issue 00B07, 2015-12-10), section 2.5.2, PDF page 177).";
        field {
            name = "reserved";
            desc = "Reserved";
            sw = r; hw = w;
            reset = 0x0;
        } reserved_31_6[31:6];
        field {
            name = "ds";
            desc = "Drive current of the RGMII_RXCK pin
- 00: 4 mA
- 01: 3 mA
- 10: 2 mA
- 11: 1 mA";
            sw = rw; hw = r;
            reset = 0x3;
        } ds[5:4];
        field {
            name = "sl";
            desc = "Level conversion rate of the RGMII_RXCK pin
- 0: fast edge
- 1: slow edge";
            sw = rw; hw = r;
            reset = 0x1;
        } sl[3:3];
        field {
            name = "reserved";
            desc = "Reserved";
            sw = r; hw = w;
            reset = 0x0;
        } reserved_2_0[2:0];
    } PADCTRL_REG71 @ 0x11C;
    reg {
        name = "PADCTRL_REG72";
        desc = "PADCTRL_REG72 is a drive capability register for the RGMII_TXEN pin. (offset 0x120; total reset 0x00000078; PROVEN: Hi3521A/Hi3520D V300 data sheet (Issue 00B07, 2015-12-10), section 2.5.2, PDF page 178).";
        field {
            name = "reserved";
            desc = "Reserved";
            sw = r; hw = w;
            reset = 0x0;
        } reserved_31_7[31:7];
        field {
            name = "ds";
            desc = "Drive current of the RGMII_TXEN pin
- 000: 18 mA
- 001: 16 mA
- 010: 14 mA
- 011: 12 mA
- 100: 5 mA
- 101: 4 mA
- 110: 2 mA
- 111: 1 mA";
            sw = rw; hw = r;
            reset = 0x7;
        } ds[6:4];
        field {
            name = "sl";
            desc = "Level conversion rate of the RGMII_TXEN pin
- 0: fast edge
- 1: slow edge";
            sw = rw; hw = r;
            reset = 0x1;
        } sl[3:3];
        field {
            name = "reserved";
            desc = "Reserved";
            sw = r; hw = w;
            reset = 0x0;
        } reserved_2_0[2:0];
    } PADCTRL_REG72 @ 0x120;
    reg {
        name = "PADCTRL_REG73";
        desc = "PADCTRL_REG73 is a drive capability register for the RGMII_TXD3 pin. (offset 0x124; total reset 0x00000078; PROVEN: Hi3521A/Hi3520D V300 data sheet (Issue 00B07, 2015-12-10), section 2.5.2, PDF page 178).";
        field {
            name = "reserved";
            desc = "Reserved";
            sw = r; hw = w;
            reset = 0x0;
        } reserved_31_7[31:7];
        field {
            name = "ds";
            desc = "Drive current of the RGMII_TXD3 pin
- 000: 18 mA
- 001: 16 mA
- 010: 14 mA
- 011: 12 mA
- 100: 5 mA
- 101: 4 mA
- 110: 2 mA
- 111: 1 mA";
            sw = rw; hw = r;
            reset = 0x7;
        } ds[6:4];
        field {
            name = "sl";
            desc = "Level conversion rate of the RGMII_TXD3 pin
- 0: fast edge
- 1: slow edge";
            sw = rw; hw = r;
            reset = 0x1;
        } sl[3:3];
        field {
            name = "reserved";
            desc = "Reserved";
            sw = r; hw = w;
            reset = 0x0;
        } reserved_2_0[2:0];
    } PADCTRL_REG73 @ 0x124;
    reg {
        name = "PADCTRL_REG74";
        desc = "PADCTRL_REG74 is a drive capability register for the RGMII_TXD2 pin. (offset 0x128; total reset 0x00000078; PROVEN: Hi3521A/Hi3520D V300 data sheet (Issue 00B07, 2015-12-10), section 2.5.2, PDF page 179).";
        field {
            name = "reserved";
            desc = "Reserved";
            sw = r; hw = w;
            reset = 0x0;
        } reserved_31_7[31:7];
        field {
            name = "ds";
            desc = "Drive current of the RGMII_TXD2 pin
- 000: 18 mA
- 001: 16 mA
- 010: 14 mA
- 011: 12 mA
- 100: 5 mA
- 101: 4 mA
- 110: 2 mA
- 111: 1 mA";
            sw = rw; hw = r;
            reset = 0x7;
        } ds[6:4];
        field {
            name = "sl";
            desc = "Level conversion rate of the RGMII_TXD2 pin
- 0: fast edge
- 1: slow edge";
            sw = rw; hw = r;
            reset = 0x1;
        } sl[3:3];
        field {
            name = "reserved";
            desc = "Reserved";
            sw = r; hw = w;
            reset = 0x0;
        } reserved_2_0[2:0];
    } PADCTRL_REG74 @ 0x128;
    reg {
        name = "PADCTRL_REG75";
        desc = "PADCTRL_REG75 is a drive capability register for the RGMII_TXD1 pin. (offset 0x12C; total reset 0x00000078; PROVEN: Hi3521A/Hi3520D V300 data sheet (Issue 00B07, 2015-12-10), section 2.5.2, PDF page 180).";
        field {
            name = "reserved";
            desc = "Reserved";
            sw = r; hw = w;
            reset = 0x0;
        } reserved_31_7[31:7];
        field {
            name = "ds";
            desc = "Drive current of the RGMII_TXD1 pin
- 000: 18 mA
- 001: 16 mA
- 010: 14 mA
- 011: 12 mA
- 100: 5 mA
- 101: 4 mA
- 110: 2 mA
- 111: 1 mA";
            sw = rw; hw = r;
            reset = 0x7;
        } ds[6:4];
        field {
            name = "sl";
            desc = "Level conversion rate of the RGMII_TXD1 pin
- 0: fast edge
- 1: slow edge";
            sw = rw; hw = r;
            reset = 0x1;
        } sl[3:3];
        field {
            name = "reserved";
            desc = "Reserved";
            sw = r; hw = w;
            reset = 0x0;
        } reserved_2_0[2:0];
    } PADCTRL_REG75 @ 0x12C;
    reg {
        name = "PADCTRL_REG76";
        desc = "PADCTRL_REG76 is a drive capability register for the RGMII_TXD0 pin. (offset 0x130; total reset 0x00000078; PROVEN: Hi3521A/Hi3520D V300 data sheet (Issue 00B07, 2015-12-10), section 2.5.2, PDF page 181).";
        field {
            name = "reserved";
            desc = "Reserved";
            sw = r; hw = w;
            reset = 0x0;
        } reserved_31_7[31:7];
        field {
            name = "ds";
            desc = "Drive current of the RGMII_TXD0 pin
- 000: 18 mA
- 001: 16 mA
- 010: 14 mA
- 011: 12 mA
- 100: 5 mA
- 101: 4 mA
- 110: 2 mA
- 111: 1 mA";
            sw = rw; hw = r;
            reset = 0x7;
        } ds[6:4];
        field {
            name = "sl";
            desc = "Level conversion rate of the RGMII_TXD0 pin
- 0: fast edge
- 1: slow edge";
            sw = rw; hw = r;
            reset = 0x1;
        } sl[3:3];
        field {
            name = "reserved";
            desc = "Reserved";
            sw = r; hw = w;
            reset = 0x0;
        } reserved_2_0[2:0];
    } PADCTRL_REG76 @ 0x130;
    reg {
        name = "PADCTRL_REG77";
        desc = "PADCTRL_REG77 is a drive capability register for the RGMII_TXCKOUT pin. (offset 0x134; total reset 0x00000078; PROVEN: Hi3521A/Hi3520D V300 data sheet (Issue 00B07, 2015-12-10), section 2.5.2, PDF page 181).";
        field {
            name = "reserved";
            desc = "Reserved";
            sw = r; hw = w;
            reset = 0x0;
        } reserved_31_7[31:7];
        field {
            name = "ds";
            desc = "Drive current of the RGMII_TXCKOUT pin
- 000: 18 mA
- 001: 16 mA
- 010: 14 mA
- 011: 12 mA
- 100: 5 mA
- 101: 4 mA
- 110: 2 mA
- 111: 1 mA";
            sw = rw; hw = r;
            reset = 0x7;
        } ds[6:4];
        field {
            name = "sl";
            desc = "Level conversion rate of the RGMII_TXCKOUT pin
- 0: fast edge
- 1: slow edge";
            sw = rw; hw = r;
            reset = 0x1;
        } sl[3:3];
        field {
            name = "reserved";
            desc = "Reserved";
            sw = r; hw = w;
            reset = 0x0;
        } reserved_2_0[2:0];
    } PADCTRL_REG77 @ 0x134;
    reg {
        name = "PADCTRL_REG78";
        desc = "PADCTRL_REG78 is a drive capability register for the RGMII_CRS pin. (offset 0x138; total reset 0x00000038; PROVEN: Hi3521A/Hi3520D V300 data sheet (Issue 00B07, 2015-12-10), section 2.5.2, PDF page 182).";
        field {
            name = "reserved";
            desc = "Reserved";
            sw = r; hw = w;
            reset = 0x0;
        } reserved_31_6[31:6];
        field {
            name = "ds";
            desc = "Drive current of the RGMII_CRS pin
- 00: 4 mA
- 01: 3 mA
- 10: 2 mA
- 11: 1 mA";
            sw = rw; hw = r;
            reset = 0x3;
        } ds[5:4];
        field {
            name = "sl";
            desc = "Level conversion rate of the RGMII_CRS pin
- 0: fast edge
- 1: slow edge";
            sw = rw; hw = r;
            reset = 0x1;
        } sl[3:3];
        field {
            name = "reserved";
            desc = "Reserved";
            sw = r; hw = w;
            reset = 0x0;
        } reserved_2_0[2:0];
    } PADCTRL_REG78 @ 0x138;
    reg {
        name = "PADCTRL_REG79";
        desc = "PADCTRL_REG79 is a drive capability register for the RGMII_COL pin. (offset 0x13C; total reset 0x00000038; PROVEN: Hi3521A/Hi3520D V300 data sheet (Issue 00B07, 2015-12-10), section 2.5.2, PDF page 183).";
        field {
            name = "reserved";
            desc = "Reserved";
            sw = r; hw = w;
            reset = 0x0;
        } reserved_31_6[31:6];
        field {
            name = "ds";
            desc = "Drive current of the RGMII_COL pin
- 00: 4 mA
- 01: 3 mA
- 10: 2 mA
- 11: 1 mA";
            sw = rw; hw = r;
            reset = 0x3;
        } ds[5:4];
        field {
            name = "sl";
            desc = "Level conversion rate of the RGMII_COL pin
- 0: fast edge
- 1: slow edge";
            sw = rw; hw = r;
            reset = 0x1;
        } sl[3:3];
        field {
            name = "reserved";
            desc = "Reserved";
            sw = r; hw = w;
            reset = 0x0;
        } reserved_2_0[2:0];
    } PADCTRL_REG79 @ 0x13C;
    reg {
        name = "PADCTRL_REG82";
        desc = "PADCTRL_REG82 is a drive capability register for the EPHY_CLK pin. (offset 0x148; total reset 0x00000078; PROVEN: Hi3521A/Hi3520D V300 data sheet (Issue 00B07, 2015-12-10), section 2.5.2, PDF page 183).";
        field {
            name = "reserved";
            desc = "Reserved";
            sw = r; hw = w;
            reset = 0x0;
        } reserved_31_7[31:7];
        field {
            name = "ds";
            desc = "Drive current of the EPHY_CLK pin
- 000: 12 mA
- 001: 11 mA
- 010: 9 mA
- 011: 8 mA
- 100: 5 mA
- 101: 4 mA
- 110: 2 mA
- 111: 1 mA";
            sw = rw; hw = r;
            reset = 0x7;
        } ds[6:4];
        field {
            name = "sl";
            desc = "Level conversion rate of the EPHY_CLK pin
- 0: fast edge
- 1: slow edge";
            sw = rw; hw = r;
            reset = 0x1;
        } sl[3:3];
        field {
            name = "reserved";
            desc = "Reserved";
            sw = r; hw = w;
            reset = 0x0;
        } reserved_2_0[2:0];
    } PADCTRL_REG82 @ 0x148;
    reg {
        name = "PADCTRL_REG84";
        desc = "PADCTRL_REG84 is a drive capability register for the MDCK pin. (offset 0x150; total reset 0x00000038; PROVEN: Hi3521A/Hi3520D V300 data sheet (Issue 00B07, 2015-12-10), section 2.5.2, PDF page 184).";
        field {
            name = "reserved";
            desc = "Reserved";
            sw = r; hw = w;
            reset = 0x0;
        } reserved_31_6[31:6];
        field {
            name = "ds";
            desc = "Drive current of the MDCK pin
- 00: 4 mA
- 01: 3 mA
- 10: 2 mA
- 11: 1 mA";
            sw = rw; hw = r;
            reset = 0x3;
        } ds[5:4];
        field {
            name = "sl";
            desc = "Level conversion rate of the MDCK pin
- 0: fast edge
- 1: slow edge";
            sw = rw; hw = r;
            reset = 0x1;
        } sl[3:3];
        field {
            name = "reserved";
            desc = "Reserved";
            sw = r; hw = w;
            reset = 0x0;
        } reserved_2_0[2:0];
    } PADCTRL_REG84 @ 0x150;
    reg {
        name = "PADCTRL_REG85";
        desc = "PADCTRL_REG85 is a drive capability register for the MDIO pin. (offset 0x154; total reset 0x00000038; PROVEN: Hi3521A/Hi3520D V300 data sheet (Issue 00B07, 2015-12-10), section 2.5.2, PDF page 185).";
        field {
            name = "reserved";
            desc = "Reserved";
            sw = r; hw = w;
            reset = 0x0;
        } reserved_31_6[31:6];
        field {
            name = "ds";
            desc = "Drive current of the MDIO pin
- 00: 4 mA
- 01: 3 mA
- 10: 2 mA
- 11: 1 mA";
            sw = rw; hw = r;
            reset = 0x3;
        } ds[5:4];
        field {
            name = "sl";
            desc = "Level conversion rate of the MDIO pin
- 0: fast edge
- 1: slow edge";
            sw = rw; hw = r;
            reset = 0x1;
        } sl[3:3];
        field {
            name = "reserved";
            desc = "Reserved";
            sw = r; hw = w;
            reset = 0x0;
        } reserved_2_0[2:0];
    } PADCTRL_REG85 @ 0x154;
    reg {
        name = "PADCTRL_REG86";
        desc = "PADCTRL_REG86 is a drive capability register for the IR_IN pin. (offset 0x158; total reset 0x00000038; PROVEN: Hi3521A/Hi3520D V300 data sheet (Issue 00B07, 2015-12-10), section 2.5.2, PDF page 185).";
        field {
            name = "reserved";
            desc = "Reserved";
            sw = r; hw = w;
            reset = 0x0;
        } reserved_31_6[31:6];
        field {
            name = "ds";
            desc = "Drive current of the IR_IN pin
- 00: 4 mA
- 01: 3 mA
- 10: 2 mA
- 11: 1 mA";
            sw = rw; hw = r;
            reset = 0x3;
        } ds[5:4];
        field {
            name = "sl";
            desc = "Level conversion rate of the IR_IN pin
- 0: fast edge
- 1: slow edge";
            sw = rw; hw = r;
            reset = 0x1;
        } sl[3:3];
        field {
            name = "reserved";
            desc = "Reserved";
            sw = r; hw = w;
            reset = 0x0;
        } reserved_2_0[2:0];
    } PADCTRL_REG86 @ 0x158;
    reg {
        name = "PADCTRL_REG87";
        desc = "PADCTRL_REG87 is a drive capability register for the SFC_CLK pin. (offset 0x15C; total reset 0x00000058; PROVEN: Hi3521A/Hi3520D V300 data sheet (Issue 00B07, 2015-12-10), section 2.5.2, PDF page 186).";
        field {
            name = "reserved";
            desc = "Reserved";
            sw = r; hw = w;
            reset = 0x0;
        } reserved_31_7[31:7];
        field {
            name = "ds";
            desc = "Drive current of the SFC_CLK pin
- 000: 18 mA
- 001: 16 mA
- 010: 14 mA
- 011: 12 mA
- 100: 5 mA
- 101: 4 mA
- 110: 2 mA
- 111: 1 mA";
            sw = rw; hw = r;
            reset = 0x5;
        } ds[6:4];
        field {
            name = "sl";
            desc = "Level conversion rate of the SFC_CLK pin
- 0: fast edge
- 1: slow edge";
            sw = rw; hw = r;
            reset = 0x1;
        } sl[3:3];
        field {
            name = "reserved";
            desc = "Reserved";
            sw = r; hw = w;
            reset = 0x0;
        } reserved_2_0[2:0];
    } PADCTRL_REG87 @ 0x15C;
    reg {
        name = "PADCTRL_REG88";
        desc = "PADCTRL_REG88 is a drive capability register for the SFC_DIO pin. (offset 0x160; total reset 0x00000038; PROVEN: Hi3521A/Hi3520D V300 data sheet (Issue 00B07, 2015-12-10), section 2.5.2, PDF page 187).";
        field {
            name = "reserved";
            desc = "Reserved";
            sw = r; hw = w;
            reset = 0x0;
        } reserved_31_6[31:6];
        field {
            name = "ds";
            desc = "Drive current of the SFC_DIO pin
- 00: 4 mA
- 01: 3 mA
- 10: 2 mA
- 11: 1 mA";
            sw = rw; hw = r;
            reset = 0x3;
        } ds[5:4];
        field {
            name = "sl";
            desc = "Level conversion rate of the SFC_DIO pin
- 0: fast edge
- 1: slow edge";
            sw = rw; hw = r;
            reset = 0x1;
        } sl[3:3];
        field {
            name = "reserved";
            desc = "Reserved";
            sw = r; hw = w;
            reset = 0x0;
        } reserved_2_0[2:0];
    } PADCTRL_REG88 @ 0x160;
    reg {
        name = "PADCTRL_REG89";
        desc = "PADCTRL_REG89 is a drive capability register for the SFC_WP_IO2 pin. (offset 0x164; total reset 0x00000038; PROVEN: Hi3521A/Hi3520D V300 data sheet (Issue 00B07, 2015-12-10), section 2.5.2, PDF page 187).";
        field {
            name = "reserved";
            desc = "Reserved";
            sw = r; hw = w;
            reset = 0x0;
        } reserved_31_6[31:6];
        field {
            name = "ds";
            desc = "Drive current of the SFC_WP_IO2 pin
- 00: 4 mA
- 01: 3 mA
- 10: 2 mA
- 11: 1 mA";
            sw = rw; hw = r;
            reset = 0x3;
        } ds[5:4];
        field {
            name = "sl";
            desc = "Level conversion rate of the SFC_WP_IO2 pin
- 0: fast edge
- 1: slow edge";
            sw = rw; hw = r;
            reset = 0x1;
        } sl[3:3];
        field {
            name = "reserved";
            desc = "Reserved";
            sw = r; hw = w;
            reset = 0x0;
        } reserved_2_0[2:0];
    } PADCTRL_REG89 @ 0x164;
    reg {
        name = "PADCTRL_REG90";
        desc = "PADCTRL_REG90 is a drive capability register for the SFC_DOI pin. (offset 0x168; total reset 0x00000038; PROVEN: Hi3521A/Hi3520D V300 data sheet (Issue 00B07, 2015-12-10), section 2.5.2, PDF page 188).";
        field {
            name = "reserved";
            desc = "Reserved";
            sw = r; hw = w;
            reset = 0x0;
        } reserved_31_6[31:6];
        field {
            name = "ds";
            desc = "Drive current of the SFC_DOI pin
- 00: 4 mA
- 01: 3 mA
- 10: 2 mA
- 11: 1 mA";
            sw = rw; hw = r;
            reset = 0x3;
        } ds[5:4];
        field {
            name = "sl";
            desc = "Level conversion rate of the SFC_DOI pin
- 0: fast edge
- 1: slow edge";
            sw = rw; hw = r;
            reset = 0x1;
        } sl[3:3];
        field {
            name = "reserved";
            desc = "Reserved";
            sw = r; hw = w;
            reset = 0x0;
        } reserved_2_0[2:0];
    } PADCTRL_REG90 @ 0x168;
    reg {
        name = "PADCTRL_REG91";
        desc = "PADCTRL_REG91 is a drive capability register for the SFC_HOLD_IO3 pin. (offset 0x16C; total reset 0x00000038; PROVEN: Hi3521A/Hi3520D V300 data sheet (Issue 00B07, 2015-12-10), section 2.5.2, PDF page 189).";
        field {
            name = "reserved";
            desc = "Reserved";
            sw = r; hw = w;
            reset = 0x0;
        } reserved_31_6[31:6];
        field {
            name = "ds";
            desc = "Drive current of the SFC_HOLD_IO3 pin
- 00: 4 mA
- 01: 3 mA
- 10: 2 mA
- 11: 1 mA";
            sw = rw; hw = r;
            reset = 0x3;
        } ds[5:4];
        field {
            name = "sl";
            desc = "Level conversion rate of the SFC_HOLD_IO3 pin
- 0: fast edge
- 1: slow edge";
            sw = rw; hw = r;
            reset = 0x1;
        } sl[3:3];
        field {
            name = "reserved";
            desc = "Reserved";
            sw = r; hw = w;
            reset = 0x0;
        } reserved_2_0[2:0];
    } PADCTRL_REG91 @ 0x16C;
    reg {
        name = "PADCTRL_REG92";
        desc = "PADCTRL_REG92 is a drive capability register for the SFC_CS0N pin. (offset 0x170; total reset 0x00000038; PROVEN: Hi3521A/Hi3520D V300 data sheet (Issue 00B07, 2015-12-10), section 2.5.2, PDF page 189).";
        field {
            name = "reserved";
            desc = "Reserved";
            sw = r; hw = w;
            reset = 0x0;
        } reserved_31_6[31:6];
        field {
            name = "ds";
            desc = "Drive current of the SFC_CS0N pin
- 00: 4 mA
- 01: 3 mA
- 10: 2 mA
- 11: 1 mA";
            sw = rw; hw = r;
            reset = 0x3;
        } ds[5:4];
        field {
            name = "sl";
            desc = "Level conversion rate of the SFC_CS0N pin
- 0: fast edge
- 1: slow edge";
            sw = rw; hw = r;
            reset = 0x1;
        } sl[3:3];
        field {
            name = "reserved";
            desc = "Reserved";
            sw = r; hw = w;
            reset = 0x0;
        } reserved_2_0[2:0];
    } PADCTRL_REG92 @ 0x170;
    reg {
        name = "PADCTRL_REG93";
        desc = "PADCTRL_REG93 is a drive capability register for the SFC_CS1N pin. (offset 0x174; total reset 0x00000038; PROVEN: Hi3521A/Hi3520D V300 data sheet (Issue 00B07, 2015-12-10), section 2.5.2, PDF page 190).";
        field {
            name = "reserved";
            desc = "Reserved";
            sw = r; hw = w;
            reset = 0x0;
        } reserved_31_6[31:6];
        field {
            name = "ds";
            desc = "Drive current of the SFC_CS1N pin
- 00: 4 mA
- 01: 3 mA
- 10: 2 mA
- 11: 1 mA";
            sw = rw; hw = r;
            reset = 0x3;
        } ds[5:4];
        field {
            name = "sl";
            desc = "Level conversion rate of the SFC_CS1N pin
- 0: fast edge
- 1: slow edge";
            sw = rw; hw = r;
            reset = 0x1;
        } sl[3:3];
        field {
            name = "reserved";
            desc = "Reserved";
            sw = r; hw = w;
            reset = 0x0;
        } reserved_2_0[2:0];
    } PADCTRL_REG93 @ 0x174;
    reg {
        name = "PADCTRL_REG94";
        desc = "PADCTRL_REG94 is a drive capability register for the JTAG_EN pin. (offset 0x178; total reset 0x00000038; PROVEN: Hi3521A/Hi3520D V300 data sheet (Issue 00B07, 2015-12-10), section 2.5.2, PDF page 191).";
        field {
            name = "reserved";
            desc = "Reserved";
            sw = r; hw = w;
            reset = 0x0;
        } reserved_31_6[31:6];
        field {
            name = "ds";
            desc = "Drive current of the JTAG_EN pin
- 00: 4 mA
- 01: 3 mA
- 10: 2 mA
- 11: 1 mA";
            sw = rw; hw = r;
            reset = 0x3;
        } ds[5:4];
        field {
            name = "sl";
            desc = "Level conversion rate of the JTAG_EN pin
- 0: fast edge
- 1: slow edge";
            sw = rw; hw = r;
            reset = 0x1;
        } sl[3:3];
        field {
            name = "reserved";
            desc = "Reserved";
            sw = r; hw = w;
            reset = 0x0;
        } reserved_2_0[2:0];
    } PADCTRL_REG94 @ 0x178;
    reg {
        name = "PADCTRL_REG95";
        desc = "PADCTRL_REG95 is a drive capability register for the JTAG_TRSTN pin. (offset 0x17C; total reset 0x00000038; PROVEN: Hi3521A/Hi3520D V300 data sheet (Issue 00B07, 2015-12-10), section 2.5.2, PDF page 191).";
        field {
            name = "reserved";
            desc = "Reserved";
            sw = r; hw = w;
            reset = 0x0;
        } reserved_31_6[31:6];
        field {
            name = "ds";
            desc = "Drive current of the JTAG_TRSTN pin
- 00: 4 mA
- 01: 3 mA
- 10: 2 mA
- 11: 1 mA";
            sw = rw; hw = r;
            reset = 0x3;
        } ds[5:4];
        field {
            name = "sl";
            desc = "Level conversion rate of the JTAG_TRSTN pin
- 0: fast edge
- 1: slow edge";
            sw = rw; hw = r;
            reset = 0x1;
        } sl[3:3];
        field {
            name = "reserved";
            desc = "Reserved";
            sw = r; hw = w;
            reset = 0x0;
        } reserved_2_0[2:0];
    } PADCTRL_REG95 @ 0x17C;
    reg {
        name = "PADCTRL_REG96";
        desc = "PADCTRL_REG96 is a drive capability register for the JTAG_TCK pin. (offset 0x180; total reset 0x00000038; PROVEN: Hi3521A/Hi3520D V300 data sheet (Issue 00B07, 2015-12-10), section 2.5.2, PDF page 192).";
        field {
            name = "reserved";
            desc = "Reserved";
            sw = r; hw = w;
            reset = 0x0;
        } reserved_31_6[31:6];
        field {
            name = "ds";
            desc = "Drive current of the JTAG_TCK pin
- 00: 4 mA
- 01: 3 mA
- 10: 2 mA
- 11: 1 mA";
            sw = rw; hw = r;
            reset = 0x3;
        } ds[5:4];
        field {
            name = "sl";
            desc = "Level conversion rate of the JTAG_TCK pin
- 0: fast edge
- 1: slow edge";
            sw = rw; hw = r;
            reset = 0x1;
        } sl[3:3];
        field {
            name = "reserved";
            desc = "Reserved";
            sw = r; hw = w;
            reset = 0x0;
        } reserved_2_0[2:0];
    } PADCTRL_REG96 @ 0x180;
    reg {
        name = "PADCTRL_REG97";
        desc = "PADCTRL_REG97 is a drive capability register for the JTAG_TMS pin. (offset 0x184; total reset 0x00000038; PROVEN: Hi3521A/Hi3520D V300 data sheet (Issue 00B07, 2015-12-10), section 2.5.2, PDF page 193).";
        field {
            name = "reserved";
            desc = "Reserved";
            sw = r; hw = w;
            reset = 0x0;
        } reserved_31_6[31:6];
        field {
            name = "ds";
            desc = "Drive current of the JTAG_TMS pin
- 00: 4 mA
- 01: 3 mA
- 10: 2 mA
- 11: 1 mA";
            sw = rw; hw = r;
            reset = 0x3;
        } ds[5:4];
        field {
            name = "sl";
            desc = "Level conversion rate of the JTAG_TMS pin
- 0: fast edge
- 1: slow edge";
            sw = rw; hw = r;
            reset = 0x1;
        } sl[3:3];
        field {
            name = "reserved";
            desc = "Reserved";
            sw = r; hw = w;
            reset = 0x0;
        } reserved_2_0[2:0];
    } PADCTRL_REG97 @ 0x184;
    reg {
        name = "PADCTRL_REG98";
        desc = "PADCTRL_REG98 is a drive capability register for the JTAG_TDO pin. (offset 0x188; total reset 0x00000038; PROVEN: Hi3521A/Hi3520D V300 data sheet (Issue 00B07, 2015-12-10), section 2.5.2, PDF page 193).";
        field {
            name = "reserved";
            desc = "Reserved";
            sw = r; hw = w;
            reset = 0x0;
        } reserved_31_6[31:6];
        field {
            name = "ds";
            desc = "Drive current of the JTAG_TDO pin
- 00: 4 mA
- 01: 3 mA
- 10: 2 mA
- 11: 1 mA";
            sw = rw; hw = r;
            reset = 0x3;
        } ds[5:4];
        field {
            name = "sl";
            desc = "Level conversion rate of the JTAG_TDO pin
- 0: fast edge
- 1: slow edge";
            sw = rw; hw = r;
            reset = 0x1;
        } sl[3:3];
        field {
            name = "reserved";
            desc = "Reserved";
            sw = r; hw = w;
            reset = 0x0;
        } reserved_2_0[2:0];
    } PADCTRL_REG98 @ 0x188;
    reg {
        name = "PADCTRL_REG99";
        desc = "PADCTRL_REG99 is a drive capability register for the JTAG_TDI pin. (offset 0x18C; total reset 0x00000038; PROVEN: Hi3521A/Hi3520D V300 data sheet (Issue 00B07, 2015-12-10), section 2.5.2, PDF page 194).";
        field {
            name = "reserved";
            desc = "Reserved";
            sw = r; hw = w;
            reset = 0x0;
        } reserved_31_6[31:6];
        field {
            name = "ds";
            desc = "Drive current of the JTAG_TDI pin
- 00: 4 mA
- 01: 3 mA
- 10: 2 mA
- 11: 1 mA";
            sw = rw; hw = r;
            reset = 0x3;
        } ds[5:4];
        field {
            name = "sl";
            desc = "Level conversion rate of the JTAG_TDI pin
- 0: fast edge
- 1: slow edge";
            sw = rw; hw = r;
            reset = 0x1;
        } sl[3:3];
        field {
            name = "reserved";
            desc = "Reserved";
            sw = r; hw = w;
            reset = 0x0;
        } reserved_2_0[2:0];
    } PADCTRL_REG99 @ 0x18C;
    reg {
        name = "PADCTRL_REG100";
        desc = "PADCTRL_REG100 is a drive capability register for the POR_ENABLE pin. (offset 0x190; total reset 0x00000038; PROVEN: Hi3521A/Hi3520D V300 data sheet (Issue 00B07, 2015-12-10), section 2.5.2, PDF page 195).";
        field {
            name = "reserved";
            desc = "Reserved";
            sw = r; hw = w;
            reset = 0x0;
        } reserved_31_6[31:6];
        field {
            name = "ds";
            desc = "Drive current of the POR_ENABLE pin
- 00: 4 mA
- 01: 3 mA
- 10: 2 mA
- 11: 1 mA";
            sw = rw; hw = r;
            reset = 0x3;
        } ds[5:4];
        field {
            name = "sl";
            desc = "Level conversion rate of the POR_ENABLE pin
- 0: fast edge
- 1: slow edge";
            sw = rw; hw = r;
            reset = 0x1;
        } sl[3:3];
        field {
            name = "reserved";
            desc = "Reserved";
            sw = r; hw = w;
            reset = 0x0;
        } reserved_2_0[2:0];
    } PADCTRL_REG100 @ 0x190;
    reg {
        name = "PADCTRL_REG101";
        desc = "PADCTRL_REG101 is a drive capability register for the RSTN pin. (offset 0x194; total reset 0x00000038; PROVEN: Hi3521A/Hi3520D V300 data sheet (Issue 00B07, 2015-12-10), section 2.5.2, PDF page 195).";
        field {
            name = "reserved";
            desc = "Reserved";
            sw = r; hw = w;
            reset = 0x0;
        } reserved_31_6[31:6];
        field {
            name = "ds";
            desc = "Drive current of the RSTN pin
- 00: 4 mA
- 01: 3 mA
- 10: 2 mA
- 11: 1 mA";
            sw = rw; hw = r;
            reset = 0x3;
        } ds[5:4];
        field {
            name = "sl";
            desc = "Level conversion rate of the RSTN pin
- 0: fast edge
- 1: slow edge";
            sw = rw; hw = r;
            reset = 0x1;
        } sl[3:3];
        field {
            name = "reserved";
            desc = "Reserved";
            sw = r; hw = w;
            reset = 0x0;
        } reserved_2_0[2:0];
    } PADCTRL_REG101 @ 0x194;
    reg {
        name = "PADCTRL_REG102";
        desc = "PADCTRL_REG102 is a drive capability register for the WDG_RSTN pin. (offset 0x198; total reset 0x00000038; PROVEN: Hi3521A/Hi3520D V300 data sheet (Issue 00B07, 2015-12-10), section 2.5.2, PDF page 196).";
        field {
            name = "reserved";
            desc = "Reserved";
            sw = r; hw = w;
            reset = 0x0;
        } reserved_31_6[31:6];
        field {
            name = "ds";
            desc = "Drive current of the WDG_RSTN pin
- 00: 4 mA
- 01: 3 mA
- 10: 2 mA
- 11: 1 mA";
            sw = rw; hw = r;
            reset = 0x3;
        } ds[5:4];
        field {
            name = "sl";
            desc = "Level conversion rate of the WDG_RSTN pin
- 0: fast edge
- 1: slow edge";
            sw = rw; hw = r;
            reset = 0x1;
        } sl[3:3];
        field {
            name = "reserved";
            desc = "Reserved";
            sw = r; hw = w;
            reset = 0x0;
        } reserved_2_0[2:0];
    } PADCTRL_REG102 @ 0x198;
    reg {
        name = "PADCTRL_REG103";
        desc = "PADCTRL_REG103 is a drive capability register for the TEST_MODE pin. (offset 0x19C; total reset 0x00000038; PROVEN: Hi3521A/Hi3520D V300 data sheet (Issue 00B07, 2015-12-10), section 2.5.2, PDF page 197).";
        field {
            name = "reserved";
            desc = "Reserved";
            sw = r; hw = w;
            reset = 0x0;
        } reserved_31_6[31:6];
        field {
            name = "ds";
            desc = "Drive current of the TEST_MODE pin
- 00: 4 mA
- 01: 3 mA
- 10: 2 mA
- 11: 1 mA";
            sw = rw; hw = r;
            reset = 0x3;
        } ds[5:4];
        field {
            name = "sl";
            desc = "Level conversion rate of the TEST_MODE pin
- 0: fast edge
- 1: slow edge";
            sw = rw; hw = r;
            reset = 0x1;
        } sl[3:3];
        field {
            name = "reserved";
            desc = "Reserved";
            sw = r; hw = w;
            reset = 0x0;
        } reserved_2_0[2:0];
    } PADCTRL_REG103 @ 0x19C;
    reg {
        name = "PADCTRL_REG104";
        desc = "PADCTRL_REG104 is a drive capability register for the USB2_OVRCUR0 pin. (offset 0x1A0; total reset 0x00000038; PROVEN: Hi3521A/Hi3520D V300 data sheet (Issue 00B07, 2015-12-10), section 2.5.2, PDF page 197).";
        field {
            name = "reserved";
            desc = "Reserved";
            sw = r; hw = w;
            reset = 0x0;
        } reserved_31_6[31:6];
        field {
            name = "ds";
            desc = "Drive current of the USB2_OVRCUR0 pin
- 00: 4 mA
- 01: 3 mA
- 10: 2 mA
- 11: 1 mA";
            sw = rw; hw = r;
            reset = 0x3;
        } ds[5:4];
        field {
            name = "sl";
            desc = "Level conversion rate of the USB2_OVRCUR0 pin
- 0: fast edge
- 1: slow edge";
            sw = rw; hw = r;
            reset = 0x1;
        } sl[3:3];
        field {
            name = "reserved";
            desc = "Reserved";
            sw = r; hw = w;
            reset = 0x0;
        } reserved_2_0[2:0];
    } PADCTRL_REG104 @ 0x1A0;
    reg {
        name = "PADCTRL_REG105";
        desc = "PADCTRL_REG105 is a drive capability register for the USB2_PWREN0 pin. (offset 0x1A4; total reset 0x00000038; PROVEN: Hi3521A/Hi3520D V300 data sheet (Issue 00B07, 2015-12-10), section 2.5.2, PDF page 198).";
        field {
            name = "reserved";
            desc = "Reserved";
            sw = r; hw = w;
            reset = 0x0;
        } reserved_31_6[31:6];
        field {
            name = "ds";
            desc = "Drive current of the USB2_PWREN0 pin
- 00: 4 mA
- 01: 3 mA
- 10: 2 mA
- 11: 1 mA";
            sw = rw; hw = r;
            reset = 0x3;
        } ds[5:4];
        field {
            name = "sl";
            desc = "Level conversion rate of the USB2_PWREN0 pin
- 0: fast edge
- 1: slow edge";
            sw = rw; hw = r;
            reset = 0x1;
        } sl[3:3];
        field {
            name = "reserved";
            desc = "Reserved";
            sw = r; hw = w;
            reset = 0x0;
        } reserved_2_0[2:0];
    } PADCTRL_REG105 @ 0x1A4;
    reg {
        name = "PADCTRL_REG106";
        desc = "PADCTRL_REG106 is a drive capability register for the USB2_OVRCUR1 pin. (offset 0x1A8; total reset 0x00000038; PROVEN: Hi3521A/Hi3520D V300 data sheet (Issue 00B07, 2015-12-10), section 2.5.2, PDF page 199).";
        field {
            name = "reserved";
            desc = "Reserved";
            sw = r; hw = w;
            reset = 0x0;
        } reserved_31_6[31:6];
        field {
            name = "ds";
            desc = "Drive current of the USB2_OVRCUR1 pin
- 00: 4 mA
- 01: 3 mA
- 10: 2 mA
- 11: 1 mA";
            sw = rw; hw = r;
            reset = 0x3;
        } ds[5:4];
        field {
            name = "sl";
            desc = "Level conversion rate of the USB2_OVRCUR1 pin
- 0: fast edge
- 1: slow edge";
            sw = rw; hw = r;
            reset = 0x1;
        } sl[3:3];
        field {
            name = "reserved";
            desc = "Reserved";
            sw = r; hw = w;
            reset = 0x0;
        } reserved_2_0[2:0];
    } PADCTRL_REG106 @ 0x1A8;
    reg {
        name = "PADCTRL_REG107";
        desc = "PADCTRL_REG107 is a drive capability register for the USB2_PWREN1 pin. (offset 0x1AC; total reset 0x00000038; PROVEN: Hi3521A/Hi3520D V300 data sheet (Issue 00B07, 2015-12-10), section 2.5.2, PDF page 199).";
        field {
            name = "reserved";
            desc = "Reserved";
            sw = r; hw = w;
            reset = 0x0;
        } reserved_31_6[31:6];
        field {
            name = "ds";
            desc = "Drive current of the USB2_PWREN1 pin
- 00: 4 mA
- 01: 3 mA
- 10: 2 mA
- 11: 1 mA";
            sw = rw; hw = r;
            reset = 0x3;
        } ds[5:4];
        field {
            name = "sl";
            desc = "Level conversion rate of the USB2_PWREN1 pin
- 0: fast edge
- 1: slow edge";
            sw = rw; hw = r;
            reset = 0x1;
        } sl[3:3];
        field {
            name = "reserved";
            desc = "Reserved";
            sw = r; hw = w;
            reset = 0x0;
        } reserved_2_0[2:0];
    } PADCTRL_REG107 @ 0x1AC;
    reg {
        name = "PADCTRL_REG108";
        desc = "PADCTRL_REG108 is a drive capability register for the HDMI_HOTPLUG pin. (offset 0x1B0; total reset 0x00000038; PROVEN: Hi3521A/Hi3520D V300 data sheet (Issue 00B07, 2015-12-10), section 2.5.2, PDF page 200).";
        field {
            name = "reserved";
            desc = "Reserved";
            sw = r; hw = w;
            reset = 0x0;
        } reserved_31_6[31:6];
        field {
            name = "ds";
            desc = "Drive current of the HDMI_HOTPLUG pin
- 00: 4 mA
- 01: 3 mA
- 10: 2 mA
- 11: 1 mA";
            sw = rw; hw = r;
            reset = 0x3;
        } ds[5:4];
        field {
            name = "sl";
            desc = "Level conversion rate of the HDMI_HOTPLUG pin
- 0: fast edge
- 1: slow edge";
            sw = rw; hw = r;
            reset = 0x1;
        } sl[3:3];
        field {
            name = "reserved";
            desc = "Reserved";
            sw = r; hw = w;
            reset = 0x0;
        } reserved_2_0[2:0];
    } PADCTRL_REG108 @ 0x1B0;
    reg {
        name = "PADCTRL_REG109";
        desc = "PADCTRL_REG109 is a drive capability register for the HDMI_CEC pin. (offset 0x1B4; total reset 0x00000038; PROVEN: Hi3521A/Hi3520D V300 data sheet (Issue 00B07, 2015-12-10), section 2.5.2, PDF page 201).";
        field {
            name = "reserved";
            desc = "Reserved";
            sw = r; hw = w;
            reset = 0x0;
        } reserved_31_6[31:6];
        field {
            name = "ds";
            desc = "Drive current of the HDMI_CEC pin
- 00: 4 mA
- 01: 3 mA
- 10: 2 mA
- 11: 1 mA";
            sw = rw; hw = r;
            reset = 0x3;
        } ds[5:4];
        field {
            name = "sl";
            desc = "Level conversion rate of the HDMI_CEC pin
- 0: fast edge
- 1: slow edge";
            sw = rw; hw = r;
            reset = 0x1;
        } sl[3:3];
        field {
            name = "reserved";
            desc = "Reserved";
            sw = r; hw = w;
            reset = 0x0;
        } reserved_2_0[2:0];
    } PADCTRL_REG109 @ 0x1B4;
    reg {
        name = "PADCTRL_REG110";
        desc = "PADCTRL_REG110 is a drive capability register for the HDMI_SDA pin. (offset 0x1B8; total reset 0x00000038; PROVEN: Hi3521A/Hi3520D V300 data sheet (Issue 00B07, 2015-12-10), section 2.5.2, PDF page 201).";
        field {
            name = "reserved";
            desc = "Reserved";
            sw = r; hw = w;
            reset = 0x0;
        } reserved_31_6[31:6];
        field {
            name = "ds";
            desc = "Drive current of the HDMI_SDA pin
- 00: 4 mA
- 01: 3 mA
- 10: 2 mA
- 11: 1 mA";
            sw = rw; hw = r;
            reset = 0x3;
        } ds[5:4];
        field {
            name = "sl";
            desc = "Level conversion rate of the HDMI_SDA pin
- 0: fast edge
- 1: slow edge";
            sw = rw; hw = r;
            reset = 0x1;
        } sl[3:3];
        field {
            name = "reserved";
            desc = "Reserved";
            sw = r; hw = w;
            reset = 0x0;
        } reserved_2_0[2:0];
    } PADCTRL_REG110 @ 0x1B8;
    reg {
        name = "PADCTRL_REG111";
        desc = "PADCTRL_REG111 is a drive capability register for the HDMI_SCL pin. (offset 0x1BC; total reset 0x00000038; PROVEN: Hi3521A/Hi3520D V300 data sheet (Issue 00B07, 2015-12-10), section 2.5.2, PDF page 202).";
        field {
            name = "reserved";
            desc = "Reserved";
            sw = r; hw = w;
            reset = 0x0;
        } reserved_31_6[31:6];
        field {
            name = "ds";
            desc = "Drive current of the HDMI_SCL pin
- 00: 4 mA
- 01: 3 mA
- 10: 2 mA
- 11: 1 mA";
            sw = rw; hw = r;
            reset = 0x3;
        } ds[5:4];
        field {
            name = "sl";
            desc = "Level conversion rate of the HDMI_SCL pin
- 0: fast edge
- 1: slow edge";
            sw = rw; hw = r;
            reset = 0x1;
        } sl[3:3];
        field {
            name = "reserved";
            desc = "Reserved";
            sw = r; hw = w;
            reset = 0x0;
        } reserved_2_0[2:0];
    } PADCTRL_REG111 @ 0x1BC;
    reg {
        name = "PADCTRL_REG112";
        desc = "PADCTRL_REG112 is a drive capability register for the SATA_LED_N0 pin. (offset 0x1C0; total reset 0x00000038; PROVEN: Hi3521A/Hi3520D V300 data sheet (Issue 00B07, 2015-12-10), section 2.5.2, PDF page 203).";
        field {
            name = "reserved";
            desc = "Reserved";
            sw = r; hw = w;
            reset = 0x0;
        } reserved_31_6[31:6];
        field {
            name = "ds";
            desc = "Drive current of the SATA_LED_N0 pin
- 00: 4 mA
- 01: 3 mA
- 10: 2 mA
- 11: 1 mA";
            sw = rw; hw = r;
            reset = 0x3;
        } ds[5:4];
        field {
            name = "sl";
            desc = "Level conversion rate of the SATA_LED_N0 pin
- 0: fast edge
- 1: slow edge";
            sw = rw; hw = r;
            reset = 0x1;
        } sl[3:3];
        field {
            name = "reserved";
            desc = "Reserved";
            sw = r; hw = w;
            reset = 0x0;
        } reserved_2_0[2:0];
    } PADCTRL_REG112 @ 0x1C0;
    reg {
        name = "PADCTRL_REG113";
        desc = "PADCTRL_REG113 is a drive capability register for the SATA_LED_N1 pin. (offset 0x1C4; total reset 0x00000038; PROVEN: Hi3521A/Hi3520D V300 data sheet (Issue 00B07, 2015-12-10), section 2.5.2, PDF page 203).";
        field {
            name = "reserved";
            desc = "Reserved";
            sw = r; hw = w;
            reset = 0x0;
        } reserved_31_6[31:6];
        field {
            name = "ds";
            desc = "Drive current of the SATA_LED_N1 pin
- 00: 4 mA
- 01: 3 mA
- 10: 2 mA
- 11: 1 mA";
            sw = rw; hw = r;
            reset = 0x3;
        } ds[5:4];
        field {
            name = "sl";
            desc = "Level conversion rate of the SATA_LED_N1 pin
- 0: fast edge
- 1: slow edge";
            sw = rw; hw = r;
            reset = 0x1;
        } sl[3:3];
        field {
            name = "reserved";
            desc = "Reserved";
            sw = r; hw = w;
            reset = 0x0;
        } reserved_2_0[2:0];
    } PADCTRL_REG113 @ 0x1C4;
    reg {
        name = "PADCTRL_REG114";
        desc = "PADCTRL_REG114 is a drive capability register for the GPIO0_0 pin. (offset 0x1C8; total reset 0x00000038; PROVEN: Hi3521A/Hi3520D V300 data sheet (Issue 00B07, 2015-12-10), section 2.5.2, PDF page 204).";
        field {
            name = "reserved";
            desc = "Reserved";
            sw = r; hw = w;
            reset = 0x0;
        } reserved_31_6[31:6];
        field {
            name = "ds";
            desc = "Drive current of the GPIO0_0 pin
- 00: 4 mA
- 01: 3 mA
- 10: 2 mA
- 11: 1 mA";
            sw = rw; hw = r;
            reset = 0x3;
        } ds[5:4];
        field {
            name = "sl";
            desc = "Level conversion rate of the GPIO0_0 pin
- 0: fast edge
- 1: slow edge";
            sw = rw; hw = r;
            reset = 0x1;
        } sl[3:3];
        field {
            name = "reserved";
            desc = "Reserved";
            sw = r; hw = w;
            reset = 0x0;
        } reserved_2_0[2:0];
    } PADCTRL_REG114 @ 0x1C8;
    reg {
        name = "PADCTRL_REG115";
        desc = "PADCTRL_REG115 is a drive capability register for the GPIO0_1 pin. (offset 0x1CC; total reset 0x00000038; PROVEN: Hi3521A/Hi3520D V300 data sheet (Issue 00B07, 2015-12-10), section 2.5.2, PDF page 205).";
        field {
            name = "reserved";
            desc = "Reserved";
            sw = r; hw = w;
            reset = 0x0;
        } reserved_31_6[31:6];
        field {
            name = "ds";
            desc = "Drive current of the GPIO0_1 pin
- 00: 4 mA
- 01: 3 mA
- 10: 2 mA
- 11: 1 mA";
            sw = rw; hw = r;
            reset = 0x3;
        } ds[5:4];
        field {
            name = "sl";
            desc = "Level conversion rate of the GPIO0_1 pin
- 0: fast edge
- 1: slow edge";
            sw = rw; hw = r;
            reset = 0x1;
        } sl[3:3];
        field {
            name = "reserved";
            desc = "Reserved";
            sw = r; hw = w;
            reset = 0x0;
        } reserved_2_0[2:0];
    } PADCTRL_REG115 @ 0x1CC;
    reg {
        name = "PADCTRL_REG116";
        desc = "PADCTRL_REG116 is a drive capability register for the GPIO0_2 pin. (offset 0x1D0; total reset 0x00000038; PROVEN: Hi3521A/Hi3520D V300 data sheet (Issue 00B07, 2015-12-10), section 2.5.2, PDF page 205).";
        field {
            name = "reserved";
            desc = "Reserved";
            sw = r; hw = w;
            reset = 0x0;
        } reserved_31_6[31:6];
        field {
            name = "ds";
            desc = "Drive current of the GPIO0_2 pin
- 00: 4 mA
- 01: 3 mA
- 10: 2 mA
- 11: 1 mA";
            sw = rw; hw = r;
            reset = 0x3;
        } ds[5:4];
        field {
            name = "sl";
            desc = "Level conversion rate of the GPIO0_2 pin
- 0: fast edge
- 1: slow edge";
            sw = rw; hw = r;
            reset = 0x1;
        } sl[3:3];
        field {
            name = "reserved";
            desc = "Reserved";
            sw = r; hw = w;
            reset = 0x0;
        } reserved_2_0[2:0];
    } PADCTRL_REG116 @ 0x1D0;
    reg {
        name = "PADCTRL_REG117";
        desc = "PADCTRL_REG117 is a drive capability register for the GPIO0_3 pin. (offset 0x1D4; total reset 0x00000038; PROVEN: Hi3521A/Hi3520D V300 data sheet (Issue 00B07, 2015-12-10), section 2.5.2, PDF page 206).";
        field {
            name = "reserved";
            desc = "Reserved";
            sw = r; hw = w;
            reset = 0x0;
        } reserved_31_6[31:6];
        field {
            name = "ds";
            desc = "Drive current of the GPIO0_3 pin
- 00: 4 mA
- 01: 3 mA
- 10: 2 mA
- 11: 1 mA";
            sw = rw; hw = r;
            reset = 0x3;
        } ds[5:4];
        field {
            name = "sl";
            desc = "Level conversion rate of the GPIO0_3 pin
- 0: fast edge
- 1: slow edge";
            sw = rw; hw = r;
            reset = 0x1;
        } sl[3:3];
        field {
            name = "reserved";
            desc = "Reserved";
            sw = r; hw = w;
            reset = 0x0;
        } reserved_2_0[2:0];
    } PADCTRL_REG117 @ 0x1D4;
    reg {
        name = "PADCTRL_REG53";
        desc = "PADCTRL_REG53 is a drive capability register for the SPI_CSN1 pin. (offset 0xD4; total reset 0x00000038; PROVEN: Hi3521A/Hi3520D V300 data sheet (Issue 00B07, 2015-12-10), section 2.5.2, PDF page 398).";
        field {
            name = "reserved";
            desc = "Reserved";
            sw = r; hw = w;
            reset = 0x0;
        } reserved_31_6[31:6];
        field {
            name = "ds";
            desc = "Drive current of the SPI_CSN1 pin
- 00: 4 mA
- 01: 3 mA
- 10: 2 mA
- 11: 1 mA";
            sw = rw; hw = r;
            reset = 0x3;
        } ds[5:4];
        field {
            name = "sl";
            desc = "Level conversion rate of the SPI_CSN1 pin
- 0: fast edge
- 1: slow edge";
            sw = rw; hw = r;
            reset = 0x1;
        } sl[3:3];
        field {
            name = "reserved";
            desc = "Reserved";
            sw = r; hw = w;
            reset = 0x0;
        } reserved_2_0[2:0];
    } PADCTRL_REG53 @ 0xD4;
    reg {
        name = "PADCTRL_REG55";
        desc = "PADCTRL_REG55 is a drive capability register for the PWM_OUT1 pin. (offset 0xDC; total reset 0x00000038; PROVEN: Hi3521A/Hi3520D V300 data sheet (Issue 00B07, 2015-12-10), section 2.5.2, PDF page 400).";
        field {
            name = "reserved";
            desc = "Reserved";
            sw = r; hw = w;
            reset = 0x0;
        } reserved_31_6[31:6];
        field {
            name = "ds";
            desc = "Drive current of the PWM_OUT1 pin
- 00: 4 mA
- 01: 3 mA
- 10: 2 mA
- 11: 1 mA";
            sw = rw; hw = r;
            reset = 0x3;
        } ds[5:4];
        field {
            name = "sl";
            desc = "Level conversion rate of the PWM_OUT1 pin
- 0: fast edge
- 1: slow edge";
            sw = rw; hw = r;
            reset = 0x1;
        } sl[3:3];
        field {
            name = "reserved";
            desc = "Reserved";
            sw = r; hw = w;
            reset = 0x0;
        } reserved_2_0[2:0];
    } PADCTRL_REG55 @ 0xDC;
    reg {
        name = "PADCTRL_REG80";
        desc = "PADCTRL_REG80 is a drive capability register for the RGMII_RXER pin. (offset 0x140; total reset 0x00000038; PROVEN: Hi3521A/Hi3520D V300 data sheet (Issue 00B07, 2015-12-10), section 2.5.2, PDF page 417).";
        field {
            name = "reserved";
            desc = "Reserved";
            sw = r; hw = w;
            reset = 0x0;
        } reserved_31_6[31:6];
        field {
            name = "ds";
            desc = "Drive current of the RGMII_RXER pin
- 00: 4 mA
- 01: 3 mA
- 10: 2 mA
- 11: 1 mA";
            sw = rw; hw = r;
            reset = 0x3;
        } ds[5:4];
        field {
            name = "sl";
            desc = "Level conversion rate of the RGMII_RXER pin
- 0: fast edge
- 1: slow edge";
            sw = rw; hw = r;
            reset = 0x1;
        } sl[3:3];
        field {
            name = "reserved";
            desc = "Reserved";
            sw = r; hw = w;
            reset = 0x0;
        } reserved_2_0[2:0];
    } PADCTRL_REG80 @ 0x140;
    reg {
        name = "PADCTRL_REG81";
        desc = "PADCTRL_REG81 is a drive capability register for the RGMII_TXER pin. (offset 0x144; total reset 0x00000038; PROVEN: Hi3521A/Hi3520D V300 data sheet (Issue 00B07, 2015-12-10), section 2.5.2, PDF page 418).";
        field {
            name = "reserved";
            desc = "Reserved";
            sw = r; hw = w;
            reset = 0x0;
        } reserved_31_6[31:6];
        field {
            name = "ds";
            desc = "Drive current of the RGMII_TXER pin
- 00: 4 mA
- 01: 3 mA
- 10: 2 mA
- 11: 1 mA";
            sw = rw; hw = r;
            reset = 0x3;
        } ds[5:4];
        field {
            name = "sl";
            desc = "Level conversion rate of the RGMII_TXER pin
- 0: fast edge
- 1: slow edge";
            sw = rw; hw = r;
            reset = 0x1;
        } sl[3:3];
        field {
            name = "reserved";
            desc = "Reserved";
            sw = r; hw = w;
            reset = 0x0;
        } reserved_2_0[2:0];
    } PADCTRL_REG81 @ 0x144;
    reg {
        name = "PADCTRL_REG83";
        desc = "PADCTRL_REG83 is a drive capability register for the EPHY_RSTN pin. (offset 0x14C; total reset 0x00000038; PROVEN: Hi3521A/Hi3520D V300 data sheet (Issue 00B07, 2015-12-10), section 2.5.2, PDF page 419).";
        field {
            name = "reserved";
            desc = "Reserved";
            sw = r; hw = w;
            reset = 0x0;
        } reserved_31_6[31:6];
        field {
            name = "ds";
            desc = "Drive current of the EPHY_RSTN pin
- 00: 4 mA
- 01: 3 mA
- 10: 2 mA
- 11: 1 mA";
            sw = rw; hw = r;
            reset = 0x3;
        } ds[5:4];
        field {
            name = "sl";
            desc = "Level conversion rate of the EPHY_RSTN pin
- 0: fast edge
- 1: slow edge";
            sw = rw; hw = r;
            reset = 0x1;
        } sl[3:3];
        field {
            name = "reserved";
            desc = "Reserved";
            sw = r; hw = w;
            reset = 0x0;
        } reserved_2_0[2:0];
    } PADCTRL_REG83 @ 0x14C;
    reg {
        name = "PADCTRL_REG118";
        desc = "PADCTRL_REG118 is a drive capability register for the GPIO0_4 pin. (offset 0x1D8; total reset 0x00000038; PROVEN: Hi3521A/Hi3520D V300 data sheet (Issue 00B07, 2015-12-10), section 2.5.2, PDF page 442).";
        field {
            name = "reserved";
            desc = "Reserved";
            sw = r; hw = w;
            reset = 0x0;
        } reserved_31_6[31:6];
        field {
            name = "ds";
            desc = "Drive current of the GPIO0_4 pin
- 00: 4 mA
- 01: 3 mA
- 10: 2 mA
- 11: 1 mA";
            sw = rw; hw = r;
            reset = 0x3;
        } ds[5:4];
        field {
            name = "sl";
            desc = "Level conversion rate of the GPIO0_4 pin
- 0: fast edge
- 1: slow edge";
            sw = rw; hw = r;
            reset = 0x1;
        } sl[3:3];
        field {
            name = "reserved";
            desc = "Reserved";
            sw = r; hw = w;
            reset = 0x0;
        } reserved_2_0[2:0];
    } PADCTRL_REG118 @ 0x1D8;
    reg {
        name = "PADCTRL_REG119";
        desc = "PADCTRL_REG119 is a drive capability register for the GPIO0_5 pin. (offset 0x1DC; total reset 0x00000038; PROVEN: Hi3521A/Hi3520D V300 data sheet (Issue 00B07, 2015-12-10), section 2.5.2, PDF page 443).";
        field {
            name = "reserved";
            desc = "Reserved";
            sw = r; hw = w;
            reset = 0x0;
        } reserved_31_6[31:6];
        field {
            name = "ds";
            desc = "Drive current of the GPIO0_5 pin
- 00: 4 mA
- 01: 3 mA
- 10: 2 mA
- 11: 1 mA";
            sw = rw; hw = r;
            reset = 0x3;
        } ds[5:4];
        field {
            name = "sl";
            desc = "Level conversion rate of the GPIO0_5 pin
- 0: fast edge
- 1: slow edge";
            sw = rw; hw = r;
            reset = 0x1;
        } sl[3:3];
        field {
            name = "reserved";
            desc = "Reserved";
            sw = r; hw = w;
            reset = 0x0;
        } reserved_2_0[2:0];
    } PADCTRL_REG119 @ 0x1DC;
    reg {
        name = "PADCTRL_REG120";
        desc = "PADCTRL_REG120 is a drive capability register for the GPIO0_6 pin. (offset 0x1E0; total reset 0x00000038; PROVEN: Hi3521A/Hi3520D V300 data sheet (Issue 00B07, 2015-12-10), section 2.5.2, PDF page 444).";
        field {
            name = "reserved";
            desc = "Reserved";
            sw = r; hw = w;
            reset = 0x0;
        } reserved_31_6[31:6];
        field {
            name = "ds";
            desc = "Drive current of the GPIO0_6 pin
- 00: 4 mA
- 01: 3 mA
- 10: 2 mA
- 11: 1 mA";
            sw = rw; hw = r;
            reset = 0x3;
        } ds[5:4];
        field {
            name = "sl";
            desc = "Level conversion rate of the GPIO0_6 pin
- 0: fast edge
- 1: slow edge";
            sw = rw; hw = r;
            reset = 0x1;
        } sl[3:3];
        field {
            name = "reserved";
            desc = "Reserved";
            sw = r; hw = w;
            reset = 0x0;
        } reserved_2_0[2:0];
    } PADCTRL_REG120 @ 0x1E0;
    reg {
        name = "PADCTRL_REG121";
        desc = "PADCTRL_REG121 is a drive capability register for the GPIO0_7 pin. (offset 0x1E4; total reset 0x00000038; PROVEN: Hi3521A/Hi3520D V300 data sheet (Issue 00B07, 2015-12-10), section 2.5.2, PDF page 444).";
        field {
            name = "reserved";
            desc = "Reserved";
            sw = r; hw = w;
            reset = 0x0;
        } reserved_31_6[31:6];
        field {
            name = "ds";
            desc = "Drive current of the GPIO0_7 pin
- 00: 4 mA
- 01: 3 mA
- 10: 2 mA
- 11: 1 mA";
            sw = rw; hw = r;
            reset = 0x3;
        } ds[5:4];
        field {
            name = "sl";
            desc = "Level conversion rate of the GPIO0_7 pin
- 0: fast edge
- 1: slow edge";
            sw = rw; hw = r;
            reset = 0x1;
        } sl[3:3];
        field {
            name = "reserved";
            desc = "Reserved";
            sw = r; hw = w;
            reset = 0x0;
        } reserved_2_0[2:0];
    } PADCTRL_REG121 @ 0x1E4;
};
`endif
