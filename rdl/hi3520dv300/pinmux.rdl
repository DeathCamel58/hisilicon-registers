`ifndef HI3520DV300_PINMUX_RDL
`define HI3520DV300_PINMUX_RDL
regfile eHI3520DV300_PINMUX {
    name = "Pin multiplexing control registers";
    desc = "Pin multiplexing control registers of the Hi3521A/Hi3520D V300 at base 0x120F_0000. 99 registers extracted programmatically from the Hi3521A/Hi3520D V300 data sheet (Issue 00B07, 2015-12-10) (Table 2-28 Summary of pin multiplexing control registers (base address: 0x120F_0000)): register headings, offsets, total reset values, field bit ranges, access types, names, reset values and descriptions, with PDF page numbers in each register description. Field names, bit ranges, access types and offsets are exact; the free-text descriptions are taken from the cell text of the field table and were checked by sampling only. Hardware not verified.";
    reg {
        name = "muxctrl_reg0";
        desc = "muxctrl_reg0 is a multiplexing control register for the VI0_CLK pin. (offset 0x0; total reset 0x00000000; PROVEN: Hi3521A/Hi3520D V300 data sheet (Issue 00B07, 2015-12-10), section 2.4.2, PDF page 77).";
        field {
            name = "reserved";
            desc = "Reserved";
            sw = r; hw = w;
            reset = 0x0;
        } reserved_31_2[31:2];
        field {
            name = "muxctrl_reg0";
            desc = "Multiplexing control for the VI0_CLK pin
- 00: GPIO5_7
- 01: VI0_CLK
- 10: VI_ADC_REFCLK0

Other values: Reserved";
            sw = rw; hw = r;
            reset = 0x0;
        } muxctrl_reg0[1:0];
    } muxctrl_reg0 @ 0x0;
    reg {
        name = "muxctrl_reg1";
        desc = "muxctrl_reg1 is a multiplexing control register for the VI0_DAT7 pin. (offset 0x4; total reset 0x00000000; PROVEN: Hi3521A/Hi3520D V300 data sheet (Issue 00B07, 2015-12-10), section 2.4.2, PDF page 77).";
        field {
            name = "reserved";
            desc = "Reserved";
            sw = r; hw = w;
            reset = 0x0;
        } reserved_31_1[31:1];
        field {
            name = "muxctrl_reg1";
            desc = "Multiplexing control for the VI0_DAT7 pin
- 0: GPIO1_0
- 1: VI0_DAT7";
            sw = rw; hw = r;
            reset = 0x0;
        } muxctrl_reg1[0:0];
    } muxctrl_reg1 @ 0x4;
    reg {
        name = "muxctrl_reg2";
        desc = "muxctrl_reg2 is a multiplexing control register for the VI0_DAT6 pin. (offset 0x8; total reset 0x00000000; PROVEN: Hi3521A/Hi3520D V300 data sheet (Issue 00B07, 2015-12-10), section 2.4.2, PDF page 78).";
        field {
            name = "reserved";
            desc = "Reserved";
            sw = r; hw = w;
            reset = 0x0;
        } reserved_31_1[31:1];
        field {
            name = "muxctrl_reg2";
            desc = "Multiplexing control for the VI0_DAT6 pin
- 0: GPIO1_1
- 1: VI0_DAT6";
            sw = rw; hw = r;
            reset = 0x0;
        } muxctrl_reg2[0:0];
    } muxctrl_reg2 @ 0x8;
    reg {
        name = "muxctrl_reg3";
        desc = "muxctrl_reg3 is a multiplexing control register for the VI0_DAT5 pin. (offset 0xC; total reset 0x00000000; PROVEN: Hi3521A/Hi3520D V300 data sheet (Issue 00B07, 2015-12-10), section 2.4.2, PDF page 78).";
        field {
            name = "reserved";
            desc = "Reserved";
            sw = r; hw = w;
            reset = 0x0;
        } reserved_31_1[31:1];
        field {
            name = "muxctrl_reg3";
            desc = "Multiplexing control for the VI0_DAT5 pin
- 0: GPIO1_2
- 1: VI0_DAT5";
            sw = rw; hw = r;
            reset = 0x0;
        } muxctrl_reg3[0:0];
    } muxctrl_reg3 @ 0xC;
    reg {
        name = "muxctrl_reg4";
        desc = "muxctrl_reg4 is a multiplexing control register for the VI0_DAT4 pin. (offset 0x10; total reset 0x00000000; PROVEN: Hi3521A/Hi3520D V300 data sheet (Issue 00B07, 2015-12-10), section 2.4.2, PDF page 79).";
        field {
            name = "reserved";
            desc = "Reserved";
            sw = r; hw = w;
            reset = 0x0;
        } reserved_31_1[31:1];
        field {
            name = "muxctrl_reg4";
            desc = "Multiplexing control for the VI0_DAT4 pin
- 0: GPIO1_3
- 1: VI0_DAT4";
            sw = rw; hw = r;
            reset = 0x0;
        } muxctrl_reg4[0:0];
    } muxctrl_reg4 @ 0x10;
    reg {
        name = "muxctrl_reg5";
        desc = "muxctrl_reg5 is a multiplexing control register for the VI0_DAT3 pin. (offset 0x14; total reset 0x00000000; PROVEN: Hi3521A/Hi3520D V300 data sheet (Issue 00B07, 2015-12-10), section 2.4.2, PDF page 79).";
        field {
            name = "reserved";
            desc = "Reserved";
            sw = r; hw = w;
            reset = 0x0;
        } reserved_31_1[31:1];
        field {
            name = "muxctrl_reg5";
            desc = "Multiplexing control for the VI0_DAT3 pin
- 0: GPIO1_4
- 1: VI0_DAT3";
            sw = rw; hw = r;
            reset = 0x0;
        } muxctrl_reg5[0:0];
    } muxctrl_reg5 @ 0x14;
    reg {
        name = "muxctrl_reg6";
        desc = "muxctrl_reg6 is a multiplexing control register for the VI0_DAT2 pin. (offset 0x18; total reset 0x00000000; PROVEN: Hi3521A/Hi3520D V300 data sheet (Issue 00B07, 2015-12-10), section 2.4.2, PDF page 80).";
        field {
            name = "reserved";
            desc = "Reserved";
            sw = r; hw = w;
            reset = 0x0;
        } reserved_31_1[31:1];
        field {
            name = "muxctrl_reg6";
            desc = "Multiplexing control for the VI0_DAT2 pin
- 0: GPIO1_5
- 1: VI0_DAT2";
            sw = rw; hw = r;
            reset = 0x0;
        } muxctrl_reg6[0:0];
    } muxctrl_reg6 @ 0x18;
    reg {
        name = "muxctrl_reg7";
        desc = "muxctrl_reg7 is a multiplexing control register for the VI0_DAT1 pin. (offset 0x1C; total reset 0x00000000; PROVEN: Hi3521A/Hi3520D V300 data sheet (Issue 00B07, 2015-12-10), section 2.4.2, PDF page 80).";
        field {
            name = "reserved";
            desc = "Reserved";
            sw = r; hw = w;
            reset = 0x0;
        } reserved_31_1[31:1];
        field {
            name = "muxctrl_reg7";
            desc = "Multiplexing control for the VI0_DAT1 pin
- 0: GPIO1_6
- 1: VI0_DAT1";
            sw = rw; hw = r;
            reset = 0x0;
        } muxctrl_reg7[0:0];
    } muxctrl_reg7 @ 0x1C;
    reg {
        name = "muxctrl_reg8";
        desc = "muxctrl_reg8 is a multiplexing control register for the VI0_DAT0 pin. (offset 0x20; total reset 0x00000000; PROVEN: Hi3521A/Hi3520D V300 data sheet (Issue 00B07, 2015-12-10), section 2.4.2, PDF page 81).";
        field {
            name = "reserved";
            desc = "Reserved";
            sw = r; hw = w;
            reset = 0x0;
        } reserved_31_1[31:1];
        field {
            name = "muxctrl_reg8";
            desc = "Multiplexing control for the VI0_DAT0 pin
- 0: GPIO1_7
- 1: VI0_DAT0";
            sw = rw; hw = r;
            reset = 0x0;
        } muxctrl_reg8[0:0];
    } muxctrl_reg8 @ 0x20;
    reg {
        name = "muxctrl_reg9";
        desc = "muxctrl_reg9 is a multiplexing control register for the VI1_CLK pin. (offset 0x24; total reset 0x00000000; PROVEN: Hi3521A/Hi3520D V300 data sheet (Issue 00B07, 2015-12-10), section 2.4.2, PDF page 81).";
        field {
            name = "reserved";
            desc = "Reserved";
            sw = r; hw = w;
            reset = 0x0;
        } reserved_31_2[31:2];
        field {
            name = "muxctrl_reg9";
            desc = "Multiplexing control for the VI1_CLK pin
- 00: GPIO10_6
- 01: VI1_CLK
- 10: VI0_CLK

Other values: reserved";
            sw = rw; hw = r;
            reset = 0x0;
        } muxctrl_reg9[1:0];
    } muxctrl_reg9 @ 0x24;
    reg {
        name = "muxctrl_reg10";
        desc = "muxctrl_reg10 is a multiplexing control register for the VI1_DAT7 pin. (offset 0x28; total reset 0x00000000; PROVEN: Hi3521A/Hi3520D V300 data sheet (Issue 00B07, 2015-12-10), section 2.4.2, PDF page 82).";
        field {
            name = "reserved";
            desc = "Reserved";
            sw = r; hw = w;
            reset = 0x0;
        } reserved_31_1[31:1];
        field {
            name = "muxctrl_reg10";
            desc = "Multiplexing control for the VI1_DAT7 pin
- 0: GPIO2_0
- 1: VI1_DAT7";
            sw = rw; hw = r;
            reset = 0x0;
        } muxctrl_reg10[0:0];
    } muxctrl_reg10 @ 0x28;
    reg {
        name = "muxctrl_reg11";
        desc = "muxctrl_reg11 is a multiplexing control register for the VI1_DAT6 pin. (offset 0x2C; total reset 0x00000000; PROVEN: Hi3521A/Hi3520D V300 data sheet (Issue 00B07, 2015-12-10), section 2.4.2, PDF page 82).";
        field {
            name = "reserved";
            desc = "Reserved";
            sw = r; hw = w;
            reset = 0x0;
        } reserved_31_1[31:1];
        field {
            name = "muxctrl_reg11";
            desc = "Multiplexing control for the VI1_DAT6 pin
- 0: GPIO2_1
- 1: VI1_DAT6";
            sw = rw; hw = r;
            reset = 0x0;
        } muxctrl_reg11[0:0];
    } muxctrl_reg11 @ 0x2C;
    reg {
        name = "muxctrl_reg12";
        desc = "muxctrl_reg12 is a multiplexing control register for the VI1_DAT5 pin. (offset 0x30; total reset 0x00000000; PROVEN: Hi3521A/Hi3520D V300 data sheet (Issue 00B07, 2015-12-10), section 2.4.2, PDF page 83).";
        field {
            name = "reserved";
            desc = "Reserved";
            sw = r; hw = w;
            reset = 0x0;
        } reserved_31_1[31:1];
        field {
            name = "muxctrl_reg12";
            desc = "Multiplexing control for the VI1_DAT5 pin
- 0: GPIO2_2
- 1: VI1_DAT5";
            sw = rw; hw = r;
            reset = 0x0;
        } muxctrl_reg12[0:0];
    } muxctrl_reg12 @ 0x30;
    reg {
        name = "muxctrl_reg13";
        desc = "muxctrl_reg13 is a multiplexing control register for the VI1_DAT4 pin. (offset 0x34; total reset 0x00000000; PROVEN: Hi3521A/Hi3520D V300 data sheet (Issue 00B07, 2015-12-10), section 2.4.2, PDF page 83).";
        field {
            name = "reserved";
            desc = "Reserved";
            sw = r; hw = w;
            reset = 0x0;
        } reserved_31_1[31:1];
        field {
            name = "muxctrl_reg13";
            desc = "Multiplexing control for the VI1_DAT4 pin
- 0: GPIO2_3
- 1: VI1_DAT4";
            sw = rw; hw = r;
            reset = 0x0;
        } muxctrl_reg13[0:0];
    } muxctrl_reg13 @ 0x34;
    reg {
        name = "muxctrl_reg14";
        desc = "muxctrl_reg14 is a multiplexing control register for the VI1_DAT3 pin. (offset 0x38; total reset 0x00000000; PROVEN: Hi3521A/Hi3520D V300 data sheet (Issue 00B07, 2015-12-10), section 2.4.2, PDF page 84).";
        field {
            name = "reserved";
            desc = "Reserved";
            sw = r; hw = w;
            reset = 0x0;
        } reserved_31_1[31:1];
        field {
            name = "muxctrl_reg14";
            desc = "Multiplexing control for the VI1_DAT3 pin
- 0: GPIO2_4
- 1: VI1_DAT3";
            sw = rw; hw = r;
            reset = 0x0;
        } muxctrl_reg14[0:0];
    } muxctrl_reg14 @ 0x38;
    reg {
        name = "muxctrl_reg15";
        desc = "muxctrl_reg15 is a multiplexing control register for the VI1_DAT2 pin. (offset 0x3C; total reset 0x00000000; PROVEN: Hi3521A/Hi3520D V300 data sheet (Issue 00B07, 2015-12-10), section 2.4.2, PDF page 84).";
        field {
            name = "reserved";
            desc = "Reserved";
            sw = r; hw = w;
            reset = 0x0;
        } reserved_31_1[31:1];
        field {
            name = "muxctrl_reg15";
            desc = "Multiplexing control for the VI1_DAT2 pin
- 0: GPIO2_5
- 1: VI1_DAT2";
            sw = rw; hw = r;
            reset = 0x0;
        } muxctrl_reg15[0:0];
    } muxctrl_reg15 @ 0x3C;
    reg {
        name = "muxctrl_reg16";
        desc = "muxctrl_reg16 is a multiplexing control register for the VI1_DAT1 pin. (offset 0x40; total reset 0x00000000; PROVEN: Hi3521A/Hi3520D V300 data sheet (Issue 00B07, 2015-12-10), section 2.4.2, PDF page 85).";
        field {
            name = "reserved";
            desc = "Reserved";
            sw = r; hw = w;
            reset = 0x0;
        } reserved_31_1[31:1];
        field {
            name = "muxctrl_reg16";
            desc = "Multiplexing control for the VI1_DAT1 pin
- 0: GPIO2_6
- 1: VI1_DAT1";
            sw = rw; hw = r;
            reset = 0x0;
        } muxctrl_reg16[0:0];
    } muxctrl_reg16 @ 0x40;
    reg {
        name = "muxctrl_reg17";
        desc = "muxctrl_reg17 is a multiplexing control register for the VI1_DAT0 pin. (offset 0x44; total reset 0x00000000; PROVEN: Hi3521A/Hi3520D V300 data sheet (Issue 00B07, 2015-12-10), section 2.4.2, PDF page 85).";
        field {
            name = "reserved";
            desc = "Reserved";
            sw = r; hw = w;
            reset = 0x0;
        } reserved_31_1[31:1];
        field {
            name = "muxctrl_reg17";
            desc = "Multiplexing control for the VI1_DAT0 pin
- 0: GPIO2_7
- 1: VI1_DAT0";
            sw = rw; hw = r;
            reset = 0x0;
        } muxctrl_reg17[0:0];
    } muxctrl_reg17 @ 0x44;
    reg {
        name = "muxctrl_reg18";
        desc = "muxctrl_reg18 is a multiplexing control register for the VI_ADC_REFCLK0 pin. (offset 0x48; total reset 0x00000000; PROVEN: Hi3521A/Hi3520D V300 data sheet (Issue 00B07, 2015-12-10), section 2.4.2, PDF page 86).";
        field {
            name = "reserved";
            desc = "Reserved";
            sw = r; hw = w;
            reset = 0x0;
        } reserved_31_2[31:2];
        field {
            name = "muxctrl_reg18";
            desc = "Multiplexing control for the VI_ADC_REFCLK0 pin
- 00: GPIO6_0
- 01: VI_ADC_REFCLK0
- 10: VI1_CLK

Other values: reserved";
            sw = rw; hw = r;
            reset = 0x0;
        } muxctrl_reg18[1:0];
    } muxctrl_reg18 @ 0x48;
    reg {
        name = "muxctrl_reg19";
        desc = "muxctrl_reg19 is a multiplexing control register for the VI2_CLK pin. (offset 0x4C; total reset 0x00000000; PROVEN: Hi3521A/Hi3520D V300 data sheet (Issue 00B07, 2015-12-10), section 2.4.2, PDF page 86).";
        field {
            name = "reserved";
            desc = "Reserved";
            sw = r; hw = w;
            reset = 0x0;
        } reserved_31_2[31:2];
        field {
            name = "muxctrl_reg19";
            desc = "Multiplexing control for the VI2_CLK pin
- 00: GPIO11_7
- 01: VI2_CLK
- 10: VI_ADC_REFCLK1

Other values: reserved";
            sw = rw; hw = r;
            reset = 0x0;
        } muxctrl_reg19[1:0];
    } muxctrl_reg19 @ 0x4C;
    reg {
        name = "muxctrl_reg20";
        desc = "muxctrl_reg20 is a multiplexing control register for the VI2_DAT7 pin. (offset 0x50; total reset 0x00000000; PROVEN: Hi3521A/Hi3520D V300 data sheet (Issue 00B07, 2015-12-10), section 2.4.2, PDF page 87).";
        field {
            name = "reserved";
            desc = "Reserved";
            sw = r; hw = w;
            reset = 0x0;
        } reserved_31_1[31:1];
        field {
            name = "muxctrl_reg20";
            desc = "Multiplexing control for the VI2_DAT7 pin
- 0: GPIO3_0
- 1: VI2_DAT7";
            sw = rw; hw = r;
            reset = 0x0;
        } muxctrl_reg20[0:0];
    } muxctrl_reg20 @ 0x50;
    reg {
        name = "muxctrl_reg21";
        desc = "muxctrl_reg21 is a multiplexing control register for the VI2_DAT6 pin. (offset 0x54; total reset 0x00000000; PROVEN: Hi3521A/Hi3520D V300 data sheet (Issue 00B07, 2015-12-10), section 2.4.2, PDF page 87).";
        field {
            name = "reserved";
            desc = "Reserved";
            sw = r; hw = w;
            reset = 0x0;
        } reserved_31_1[31:1];
        field {
            name = "muxctrl_reg21";
            desc = "Multiplexing control for the VI2_DAT6 pin
- 0: GPIO3_1
- 1: VI2_DAT6";
            sw = rw; hw = r;
            reset = 0x0;
        } muxctrl_reg21[0:0];
    } muxctrl_reg21 @ 0x54;
    reg {
        name = "muxctrl_reg22";
        desc = "muxctrl_reg22 is a multiplexing control register for the VI2_DAT5 pin. (offset 0x58; total reset 0x00000000; PROVEN: Hi3521A/Hi3520D V300 data sheet (Issue 00B07, 2015-12-10), section 2.4.2, PDF page 88).";
        field {
            name = "reserved";
            desc = "Reserved";
            sw = r; hw = w;
            reset = 0x0;
        } reserved_31_1[31:1];
        field {
            name = "muxctrl_reg22";
            desc = "Multiplexing control for the VI2_DAT5 pin
- 0: GPIO3_2
- 1: VI2_DAT5";
            sw = rw; hw = r;
            reset = 0x0;
        } muxctrl_reg22[0:0];
    } muxctrl_reg22 @ 0x58;
    reg {
        name = "muxctrl_reg23";
        desc = "muxctrl_reg23 is a multiplexing control register for the VI2_DAT4 pin. (offset 0x5C; total reset 0x00000000; PROVEN: Hi3521A/Hi3520D V300 data sheet (Issue 00B07, 2015-12-10), section 2.4.2, PDF page 88).";
        field {
            name = "reserved";
            desc = "Reserved";
            sw = r; hw = w;
            reset = 0x0;
        } reserved_31_1[31:1];
        field {
            name = "muxctrl_reg23";
            desc = "Multiplexing control for the VI2_DAT4 pin
- 0: GPIO3_3
- 1: VI2_DAT4";
            sw = rw; hw = r;
            reset = 0x0;
        } muxctrl_reg23[0:0];
    } muxctrl_reg23 @ 0x5C;
    reg {
        name = "muxctrl_reg24";
        desc = "muxctrl_reg24 is a multiplexing control register for the VI2_DAT3 pin. (offset 0x60; total reset 0x00000000; PROVEN: Hi3521A/Hi3520D V300 data sheet (Issue 00B07, 2015-12-10), section 2.4.2, PDF page 89).";
        field {
            name = "reserved";
            desc = "Reserved";
            sw = r; hw = w;
            reset = 0x0;
        } reserved_31_1[31:1];
        field {
            name = "muxctrl_reg24";
            desc = "Multiplexing control for the VI2_DAT3 pin
- 0: GPIO3_4
- 1: VI2_DAT3";
            sw = rw; hw = r;
            reset = 0x0;
        } muxctrl_reg24[0:0];
    } muxctrl_reg24 @ 0x60;
    reg {
        name = "muxctrl_reg25";
        desc = "muxctrl_reg25 is a multiplexing control register for the VI2_DAT2 pin. (offset 0x64; total reset 0x00000000; PROVEN: Hi3521A/Hi3520D V300 data sheet (Issue 00B07, 2015-12-10), section 2.4.2, PDF page 89).";
        field {
            name = "reserved";
            desc = "Reserved";
            sw = r; hw = w;
            reset = 0x0;
        } reserved_31_1[31:1];
        field {
            name = "muxctrl_reg25";
            desc = "Multiplexing control for the VI2_DAT2 pin
- 0: GPIO3_5
- 1: VI2_DAT2";
            sw = rw; hw = r;
            reset = 0x0;
        } muxctrl_reg25[0:0];
    } muxctrl_reg25 @ 0x64;
    reg {
        name = "muxctrl_reg26";
        desc = "muxctrl_reg26 is a multiplexing control register for the VI2_DAT1 pin. (offset 0x68; total reset 0x00000000; PROVEN: Hi3521A/Hi3520D V300 data sheet (Issue 00B07, 2015-12-10), section 2.4.2, PDF page 90).";
        field {
            name = "reserved";
            desc = "Reserved";
            sw = r; hw = w;
            reset = 0x0;
        } reserved_31_1[31:1];
        field {
            name = "muxctrl_reg26";
            desc = "Multiplexing control for the VI2_DAT1 pin
- 0: GPIO3_6
- 1: VI2_DAT1";
            sw = rw; hw = r;
            reset = 0x0;
        } muxctrl_reg26[0:0];
    } muxctrl_reg26 @ 0x68;
    reg {
        name = "muxctrl_reg27";
        desc = "muxctrl_reg27 is a multiplexing control register for the VI2_DAT0 pin. (offset 0x6C; total reset 0x00000000; PROVEN: Hi3521A/Hi3520D V300 data sheet (Issue 00B07, 2015-12-10), section 2.4.2, PDF page 90).";
        field {
            name = "reserved";
            desc = "Reserved";
            sw = r; hw = w;
            reset = 0x0;
        } reserved_31_1[31:1];
        field {
            name = "muxctrl_reg27";
            desc = "Multiplexing control for the VI2_DAT0 pin
- 0: GPIO3_7
- 1: VI2_DAT0";
            sw = rw; hw = r;
            reset = 0x0;
        } muxctrl_reg27[0:0];
    } muxctrl_reg27 @ 0x6C;
    reg {
        name = "muxctrl_reg28";
        desc = "muxctrl_reg28 is a multiplexing control register for the VI3_CLK pin. (offset 0x70; total reset 0x00000000; PROVEN: Hi3521A/Hi3520D V300 data sheet (Issue 00B07, 2015-12-10), section 2.4.2, PDF page 91).";
        field {
            name = "reserved";
            desc = "Reserved";
            sw = r; hw = w;
            reset = 0x0;
        } reserved_31_2[31:2];
        field {
            name = "muxctrl_reg28";
            desc = "Multiplexing control for the VI3_CLK pin
- 00: GPIO10_5
- 01: VI3_CLK
- 10: VI2_CLK

Other values: reserved";
            sw = rw; hw = r;
            reset = 0x0;
        } muxctrl_reg28[1:0];
    } muxctrl_reg28 @ 0x70;
    reg {
        name = "muxctrl_reg29";
        desc = "muxctrl_reg29 is a multiplexing control register for the VI3_DAT7 pin. (offset 0x74; total reset 0x00000000; PROVEN: Hi3521A/Hi3520D V300 data sheet (Issue 00B07, 2015-12-10), section 2.4.2, PDF page 91).";
        field {
            name = "reserved";
            desc = "Reserved";
            sw = r; hw = w;
            reset = 0x0;
        } reserved_31_1[31:1];
        field {
            name = "muxctrl_reg29";
            desc = "Multiplexing control for the VI3_DAT7 pin
- 0: GPIO4_0
- 1: VI3_DAT7";
            sw = rw; hw = r;
            reset = 0x0;
        } muxctrl_reg29[0:0];
    } muxctrl_reg29 @ 0x74;
    reg {
        name = "muxctrl_reg30";
        desc = "muxctrl_reg30 is a multiplexing control register for the VI3_DAT6 pin. (offset 0x78; total reset 0x00000000; PROVEN: Hi3521A/Hi3520D V300 data sheet (Issue 00B07, 2015-12-10), section 2.4.2, PDF page 92).";
        field {
            name = "reserved";
            desc = "Reserved";
            sw = r; hw = w;
            reset = 0x0;
        } reserved_31_1[31:1];
        field {
            name = "muxctrl_reg30";
            desc = "Multiplexing control for the VI3_DAT6 pin
- 0: GPIO4_1
- 1: VI3_DAT6";
            sw = rw; hw = r;
            reset = 0x0;
        } muxctrl_reg30[0:0];
    } muxctrl_reg30 @ 0x78;
    reg {
        name = "muxctrl_reg31";
        desc = "muxctrl_reg31 is a multiplexing control register for the VI3_DAT5 pin. (offset 0x7C; total reset 0x00000000; PROVEN: Hi3521A/Hi3520D V300 data sheet (Issue 00B07, 2015-12-10), section 2.4.2, PDF page 92).";
        field {
            name = "reserved";
            desc = "Reserved";
            sw = r; hw = w;
            reset = 0x0;
        } reserved_31_1[31:1];
        field {
            name = "muxctrl_reg31";
            desc = "Multiplexing control for the VI3_DAT5 pin
- 0: GPIO4_2
- 1: VI3_DAT5";
            sw = rw; hw = r;
            reset = 0x0;
        } muxctrl_reg31[0:0];
    } muxctrl_reg31 @ 0x7C;
    reg {
        name = "muxctrl_reg32";
        desc = "muxctrl_reg32 is a multiplexing control register for the VI3_DAT4 pin. (offset 0x80; total reset 0x00000000; PROVEN: Hi3521A/Hi3520D V300 data sheet (Issue 00B07, 2015-12-10), section 2.4.2, PDF page 93).";
        field {
            name = "reserved";
            desc = "Reserved";
            sw = r; hw = w;
            reset = 0x0;
        } reserved_31_1[31:1];
        field {
            name = "muxctrl_reg32";
            desc = "Multiplexing control for the VI3_DAT4 pin
- 0: GPIO4_3
- 1: VI3_DAT4";
            sw = rw; hw = r;
            reset = 0x0;
        } muxctrl_reg32[0:0];
    } muxctrl_reg32 @ 0x80;
    reg {
        name = "muxctrl_reg33";
        desc = "muxctrl_reg33 is a multiplexing control register for the VI3_DAT3 pin. (offset 0x84; total reset 0x00000000; PROVEN: Hi3521A/Hi3520D V300 data sheet (Issue 00B07, 2015-12-10), section 2.4.2, PDF page 93).";
        field {
            name = "reserved";
            desc = "Reserved";
            sw = r; hw = w;
            reset = 0x0;
        } reserved_31_1[31:1];
        field {
            name = "muxctrl_reg33";
            desc = "Multiplexing control for the VI3_DAT3 pin
- 0: GPIO4_4
- 1: VI3_DAT3";
            sw = rw; hw = r;
            reset = 0x0;
        } muxctrl_reg33[0:0];
    } muxctrl_reg33 @ 0x84;
    reg {
        name = "muxctrl_reg34";
        desc = "muxctrl_reg34 is a multiplexing control register for the VI3_DAT2 pin. (offset 0x88; total reset 0x00000000; PROVEN: Hi3521A/Hi3520D V300 data sheet (Issue 00B07, 2015-12-10), section 2.4.2, PDF page 94).";
        field {
            name = "reserved";
            desc = "Reserved";
            sw = r; hw = w;
            reset = 0x0;
        } reserved_31_1[31:1];
        field {
            name = "muxctrl_reg34";
            desc = "Multiplexing control for the VI3_DAT2 pin
- 0: GPIO4_5
- 1: VI3_DAT2";
            sw = rw; hw = r;
            reset = 0x0;
        } muxctrl_reg34[0:0];
    } muxctrl_reg34 @ 0x88;
    reg {
        name = "muxctrl_reg35";
        desc = "muxctrl_reg35 is a multiplexing control register for the VI3_DAT1 pin. (offset 0x8C; total reset 0x00000000; PROVEN: Hi3521A/Hi3520D V300 data sheet (Issue 00B07, 2015-12-10), section 2.4.2, PDF page 94).";
        field {
            name = "reserved";
            desc = "Reserved";
            sw = r; hw = w;
            reset = 0x0;
        } reserved_31_1[31:1];
        field {
            name = "muxctrl_reg35";
            desc = "Multiplexing control for the VI3_DAT1 pin
- 0: GPIO4_6
- 1: VI3_DAT1";
            sw = rw; hw = r;
            reset = 0x0;
        } muxctrl_reg35[0:0];
    } muxctrl_reg35 @ 0x8C;
    reg {
        name = "muxctrl_reg36";
        desc = "muxctrl_reg36 is a multiplexing control register for the VI3_DAT0 pin. (offset 0x90; total reset 0x00000000; PROVEN: Hi3521A/Hi3520D V300 data sheet (Issue 00B07, 2015-12-10), section 2.4.2, PDF page 95).";
        field {
            name = "reserved";
            desc = "Reserved";
            sw = r; hw = w;
            reset = 0x0;
        } reserved_31_1[31:1];
        field {
            name = "muxctrl_reg36";
            desc = "Multiplexing control for the VI3_DAT0 pin
- 0: GPIO4_7
- 1: VI3_DAT0";
            sw = rw; hw = r;
            reset = 0x0;
        } muxctrl_reg36[0:0];
    } muxctrl_reg36 @ 0x90;
    reg {
        name = "muxctrl_reg37";
        desc = "muxctrl_reg37 is a multiplexing control register for the VI_ADC_REFCLK1 pin. (offset 0x94; total reset 0x00000000; PROVEN: Hi3521A/Hi3520D V300 data sheet (Issue 00B07, 2015-12-10), section 2.4.2, PDF page 95).";
        field {
            name = "reserved";
            desc = "Reserved";
            sw = r; hw = w;
            reset = 0x0;
        } reserved_31_2[31:2];
        field {
            name = "muxctrl_reg37";
            desc = "Multiplexing control for the VI_ADC_REFCLK1 pin
- 00: GPIO6_1
- 01: VI_ADC_REFCLK1
- 10: VI3_CLK

Other values: reserved";
            sw = rw; hw = r;
            reset = 0x0;
        } muxctrl_reg37[1:0];
    } muxctrl_reg37 @ 0x94;
    reg {
        name = "muxctrl_reg38";
        desc = "muxctrl_reg38 is a multiplexing control register for the VGA_HS pin. (offset 0x98; total reset 0x00000000; PROVEN: Hi3521A/Hi3520D V300 data sheet (Issue 00B07, 2015-12-10), section 2.4.2, PDF page 96).";
        field {
            name = "reserved";
            desc = "Reserved";
            sw = r; hw = w;
            reset = 0x0;
        } reserved_31_1[31:1];
        field {
            name = "muxctrl_reg38";
            desc = "Multiplexing control for the VGA_HS pin
- 0: GPIO11_6
- 1: VGA_HS";
            sw = rw; hw = r;
            reset = 0x0;
        } muxctrl_reg38[0:0];
    } muxctrl_reg38 @ 0x98;
    reg {
        name = "muxctrl_reg39";
        desc = "muxctrl_reg39 is a multiplexing control register for the VGA_VS pin. (offset 0x9C; total reset 0x00000000; PROVEN: Hi3521A/Hi3520D V300 data sheet (Issue 00B07, 2015-12-10), section 2.4.2, PDF page 96).";
        field {
            name = "reserved";
            desc = "Reserved";
            sw = r; hw = w;
            reset = 0x0;
        } reserved_31_1[31:1];
        field {
            name = "muxctrl_reg39";
            desc = "Multiplexing control for the VGA_VS pin
- 0: GPIO11_3
- 1: VGA_VS";
            sw = rw; hw = r;
            reset = 0x0;
        } muxctrl_reg39[0:0];
    } muxctrl_reg39 @ 0x9C;
    reg {
        name = "muxctrl_reg40";
        desc = "muxctrl_reg40 is a multiplexing control register for the I2S0_BCLK_RX pin. (offset 0xA0; total reset 0x00000000; PROVEN: Hi3521A/Hi3520D V300 data sheet (Issue 00B07, 2015-12-10), section 2.4.2, PDF page 97).";
        field {
            name = "reserved";
            desc = "Reserved";
            sw = r; hw = w;
            reset = 0x0;
        } reserved_31_1[31:1];
        field {
            name = "muxctrl_reg40";
            desc = "Multiplexing control for the I2S0_BCLK_RX pin
- 0: GPIO9_0
- 1: I2S0_BCLK_RX";
            sw = rw; hw = r;
            reset = 0x0;
        } muxctrl_reg40[0:0];
    } muxctrl_reg40 @ 0xA0;
    reg {
        name = "muxctrl_reg41";
        desc = "muxctrl_reg41 is a multiplexing control register for the I2S0_WS_RX pin. (offset 0xA4; total reset 0x00000000; PROVEN: Hi3521A/Hi3520D V300 data sheet (Issue 00B07, 2015-12-10), section 2.4.2, PDF page 97).";
        field {
            name = "reserved";
            desc = "Reserved";
            sw = r; hw = w;
            reset = 0x0;
        } reserved_31_1[31:1];
        field {
            name = "muxctrl_reg41";
            desc = "Multiplexing control for the I2S0_WS_RX pin
- 0: GPIO9_1
- 1: I2S0_WS_RX";
            sw = rw; hw = r;
            reset = 0x0;
        } muxctrl_reg41[0:0];
    } muxctrl_reg41 @ 0xA4;
    reg {
        name = "muxctrl_reg42";
        desc = "muxctrl_reg42 is a multiplexing control register for the I2S0_SD_RX pin. (offset 0xA8; total reset 0x00000000; PROVEN: Hi3521A/Hi3520D V300 data sheet (Issue 00B07, 2015-12-10), section 2.4.2, PDF page 98).";
        field {
            name = "reserved";
            desc = "Reserved";
            sw = r; hw = w;
            reset = 0x0;
        } reserved_31_1[31:1];
        field {
            name = "muxctrl_reg42";
            desc = "Multiplexing control for the I2S0_SD_RX pin
- 0: GPIO9_2
- 1: I2S0_SD_RX";
            sw = rw; hw = r;
            reset = 0x0;
        } muxctrl_reg42[0:0];
    } muxctrl_reg42 @ 0xA8;
    reg {
        name = "muxctrl_reg43";
        desc = "muxctrl_reg43 is a multiplexing control register for the I2S1_BCLK_RX pin. (offset 0xAC; total reset 0x00000000; PROVEN: Hi3521A/Hi3520D V300 data sheet (Issue 00B07, 2015-12-10), section 2.4.2, PDF page 98).";
        field {
            name = "reserved";
            desc = "Reserved";
            sw = r; hw = w;
            reset = 0x0;
        } reserved_31_2[31:2];
        field {
            name = "muxctrl_reg43";
            desc = "Multiplexing control for the I2S1_BCLK_RX pin
- 00: GPIO9_3
- 01: I2S1_BCLK_RX
- 10: I2S2_MCLK

Other values: reserved";
            sw = rw; hw = r;
            reset = 0x0;
        } muxctrl_reg43[1:0];
    } muxctrl_reg43 @ 0xAC;
    reg {
        name = "muxctrl_reg44";
        desc = "muxctrl_reg44 is a multiplexing control register for the I2S1_WS_RX pin. (offset 0xB0; total reset 0x00000000; PROVEN: Hi3521A/Hi3520D V300 data sheet (Issue 00B07, 2015-12-10), section 2.4.2, PDF page 99).";
        field {
            name = "reserved";
            desc = "Reserved";
            sw = r; hw = w;
            reset = 0x0;
        } reserved_31_1[31:1];
        field {
            name = "muxctrl_reg44";
            desc = "Multiplexing control for the I2S1_WS_RX pin
- 0: GPIO9_4
- 1: I2S1_WS_RX";
            sw = rw; hw = r;
            reset = 0x0;
        } muxctrl_reg44[0:0];
    } muxctrl_reg44 @ 0xB0;
    reg {
        name = "muxctrl_reg45";
        desc = "muxctrl_reg45 is a multiplexing control register for the I2S1_SD_RX pin. (offset 0xB4; total reset 0x00000000; PROVEN: Hi3521A/Hi3520D V300 data sheet (Issue 00B07, 2015-12-10), section 2.4.2, PDF page 99).";
        field {
            name = "reserved";
            desc = "Reserved";
            sw = r; hw = w;
            reset = 0x0;
        } reserved_31_1[31:1];
        field {
            name = "muxctrl_reg45";
            desc = "Multiplexing control for the I2S1_SD_RX pin
- 0: GPIO9_5
- 1: I2S1_SD_RX";
            sw = rw; hw = r;
            reset = 0x0;
        } muxctrl_reg45[0:0];
    } muxctrl_reg45 @ 0xB4;
    reg {
        name = "muxctrl_reg46";
        desc = "muxctrl_reg46 is a multiplexing control register for the I2S2_BCLK_TX pin. (offset 0xB8; total reset 0x00000000; PROVEN: Hi3521A/Hi3520D V300 data sheet (Issue 00B07, 2015-12-10), section 2.4.2, PDF page 100).";
        field {
            name = "reserved";
            desc = "Reserved";
            sw = r; hw = w;
            reset = 0x0;
        } reserved_31_1[31:1];
        field {
            name = "muxctrl_reg46";
            desc = "Multiplexing control for the I2S2_BCLK_TX pin
- 0: GPIO9_6
- 1: I2S2_BCLK_TX";
            sw = rw; hw = r;
            reset = 0x0;
        } muxctrl_reg46[0:0];
    } muxctrl_reg46 @ 0xB8;
    reg {
        name = "muxctrl_reg47";
        desc = "muxctrl_reg47 is a multiplexing control register for the I2S2_WS_TX pin. (offset 0xBC; total reset 0x00000000; PROVEN: Hi3521A/Hi3520D V300 data sheet (Issue 00B07, 2015-12-10), section 2.4.2, PDF page 100).";
        field {
            name = "reserved";
            desc = "Reserved";
            sw = r; hw = w;
            reset = 0x0;
        } reserved_31_1[31:1];
        field {
            name = "muxctrl_reg47";
            desc = "Multiplexing control for the I2S2_WS_TX pin
- 0: GPIO9_7
- 1: I2S2_WS_TX";
            sw = rw; hw = r;
            reset = 0x0;
        } muxctrl_reg47[0:0];
    } muxctrl_reg47 @ 0xBC;
    reg {
        name = "muxctrl_reg48";
        desc = "muxctrl_reg48 is a multiplexing control register for the I2S2_SD_TX pin. (offset 0xC0; total reset 0x00000000; PROVEN: Hi3521A/Hi3520D V300 data sheet (Issue 00B07, 2015-12-10), section 2.4.2, PDF page 101).";
        field {
            name = "reserved";
            desc = "Reserved";
            sw = r; hw = w;
            reset = 0x0;
        } reserved_31_1[31:1];
        field {
            name = "muxctrl_reg48";
            desc = "Multiplexing control for the I2S2_SD_TX pin
- 0: GPIO5_4
- 1: I2S2_SD_TX";
            sw = rw; hw = r;
            reset = 0x0;
        } muxctrl_reg48[0:0];
    } muxctrl_reg48 @ 0xC0;
    reg {
        name = "muxctrl_reg49";
        desc = "muxctrl_reg49 is a multiplexing control register for the SPI_SCLK pin. (offset 0xC4; total reset 0x00000000; PROVEN: Hi3521A/Hi3520D V300 data sheet (Issue 00B07, 2015-12-10), section 2.4.2, PDF page 101).";
        field {
            name = "reserved";
            desc = "Reserved";
            sw = r; hw = w;
            reset = 0x0;
        } reserved_31_2[31:2];
        field {
            name = "muxctrl_reg49";
            desc = "Multiplexing control for the SPI_SCLK pin
- 00: TEST_CLK
- 01: SPI_SCLK
- 10: GPIO5_0

Other values: reserved";
            sw = rw; hw = r;
            reset = 0x0;
        } muxctrl_reg49[1:0];
    } muxctrl_reg49 @ 0xC4;
    reg {
        name = "muxctrl_reg50";
        desc = "muxctrl_reg50 is a multiplexing control register for the SPI_SDO pin. (offset 0xC8; total reset 0x00000000; PROVEN: Hi3521A/Hi3520D V300 data sheet (Issue 00B07, 2015-12-10), section 2.4.2, PDF page 102).";
        field {
            name = "reserved";
            desc = "Reserved";
            sw = r; hw = w;
            reset = 0x0;
        } reserved_31_1[31:1];
        field {
            name = "muxctrl_reg50";
            desc = "Multiplexing control for the SPI_SDO pin
- 0: GPIO5_1
- 1: SPI_SDO";
            sw = rw; hw = r;
            reset = 0x0;
        } muxctrl_reg50[0:0];
    } muxctrl_reg50 @ 0xC8;
    reg {
        name = "muxctrl_reg51";
        desc = "muxctrl_reg51 is a multiplexing control register for the SPI_SDI pin. (offset 0xCC; total reset 0x00000000; PROVEN: Hi3521A/Hi3520D V300 data sheet (Issue 00B07, 2015-12-10), section 2.4.2, PDF page 102).";
        field {
            name = "reserved";
            desc = "Reserved";
            sw = r; hw = w;
            reset = 0x0;
        } reserved_31_1[31:1];
        field {
            name = "muxctrl_reg51";
            desc = "Multiplexing control for the SPI_SDI pin
- 0: GPIO5_2
- 1: SPI_SDI";
            sw = rw; hw = r;
            reset = 0x0;
        } muxctrl_reg51[0:0];
    } muxctrl_reg51 @ 0xCC;
    reg {
        name = "muxctrl_reg52";
        desc = "muxctrl_reg52 is a multiplexing control register for the SPI_CSN0 pin. (offset 0xD0; total reset 0x00000000; PROVEN: Hi3521A/Hi3520D V300 data sheet (Issue 00B07, 2015-12-10), section 2.4.2, PDF page 103).";
        field {
            name = "reserved";
            desc = "Reserved";
            sw = r; hw = w;
            reset = 0x0;
        } reserved_31_1[31:1];
        field {
            name = "muxctrl_reg52";
            desc = "Multiplexing control for the SPI_CSN0 pin
- 0: GPIO5_3
- 1: SPI_CSN0";
            sw = rw; hw = r;
            reset = 0x0;
        } muxctrl_reg52[0:0];
    } muxctrl_reg52 @ 0xD0;
    reg {
        name = "muxctrl_reg54";
        desc = "muxctrl_reg54 is a multiplexing control register for the PWM_OUT0 pin. (offset 0xD8; total reset 0x00000000; PROVEN: Hi3521A/Hi3520D V300 data sheet (Issue 00B07, 2015-12-10), section 2.4.2, PDF page 103).";
        field {
            name = "reserved";
            desc = "Reserved";
            sw = r; hw = w;
            reset = 0x0;
        } reserved_31_1[31:1];
        field {
            name = "muxctrl_reg54";
            desc = "Multiplexing control for the PWM_OUT0 pin
- 0: PWM_OUT0
- 1: GPIO5_5";
            sw = rw; hw = r;
            reset = 0x0;
        } muxctrl_reg54[0:0];
    } muxctrl_reg54 @ 0xD8;
    reg {
        name = "muxctrl_reg56";
        desc = "muxctrl_reg56 is a multiplexing control register for the I2C_SDA pin. (offset 0xE0; total reset 0x00000000; PROVEN: Hi3521A/Hi3520D V300 data sheet (Issue 00B07, 2015-12-10), section 2.4.2, PDF page 104).";
        field {
            name = "reserved";
            desc = "Reserved";
            sw = r; hw = w;
            reset = 0x0;
        } reserved_31_1[31:1];
        field {
            name = "muxctrl_reg56";
            desc = "Multiplexing control for the I2C_SDA pin
- 0: GPIO12_6
- 1: I2C_SDA";
            sw = rw; hw = r;
            reset = 0x0;
        } muxctrl_reg56[0:0];
    } muxctrl_reg56 @ 0xE0;
    reg {
        name = "muxctrl_reg57";
        desc = "muxctrl_reg57 is a multiplexing control register for the I2C_SCL pin. (offset 0xE4; total reset 0x00000000; PROVEN: Hi3521A/Hi3520D V300 data sheet (Issue 00B07, 2015-12-10), section 2.4.2, PDF page 104).";
        field {
            name = "reserved";
            desc = "Reserved";
            sw = r; hw = w;
            reset = 0x0;
        } reserved_31_1[31:1];
        field {
            name = "muxctrl_reg57";
            desc = "Multiplexing control for the I2C_SCL pin
- 0: GPIO12_7
- 1: I2C_SCL";
            sw = rw; hw = r;
            reset = 0x0;
        } muxctrl_reg57[0:0];
    } muxctrl_reg57 @ 0xE4;
    reg {
        name = "muxctrl_reg58";
        desc = "muxctrl_reg58 is a multiplexing control register for the UART0_RXD pin. (offset 0xE8; total reset 0x00000000; PROVEN: Hi3521A/Hi3520D V300 data sheet (Issue 00B07, 2015-12-10), section 2.4.2, PDF page 105).";
        field {
            name = "reserved";
            desc = "Reserved";
            sw = r; hw = w;
            reset = 0x0;
        } reserved_31_1[31:1];
        field {
            name = "muxctrl_reg58";
            desc = "Multiplexing control for the UART0_RXD pin
- 0: UART0_RXD
- 1: GPIO10_7";
            sw = rw; hw = r;
            reset = 0x0;
        } muxctrl_reg58[0:0];
    } muxctrl_reg58 @ 0xE8;
    reg {
        name = "muxctrl_reg59";
        desc = "muxctrl_reg59 is a multiplexing control register for the UART0_TXD pin. (offset 0xEC; total reset 0x00000000; PROVEN: Hi3521A/Hi3520D V300 data sheet (Issue 00B07, 2015-12-10), section 2.4.2, PDF page 105).";
        field {
            name = "reserved";
            desc = "Reserved";
            sw = r; hw = w;
            reset = 0x0;
        } reserved_31_1[31:1];
        field {
            name = "muxctrl_reg59";
            desc = "Multiplexing control for the UART0_TXD pin
- 0: UART0_TXD
- 1: GPIO12_5";
            sw = rw; hw = r;
            reset = 0x0;
        } muxctrl_reg59[0:0];
    } muxctrl_reg59 @ 0xEC;
    reg {
        name = "muxctrl_reg60";
        desc = "muxctrl_reg60 is a multiplexing control register for the UART0_CTSN pin. (offset 0xF0; total reset 0x00000000; PROVEN: Hi3521A/Hi3520D V300 data sheet (Issue 00B07, 2015-12-10), section 2.4.2, PDF page 106).";
        field {
            name = "reserved";
            desc = "Reserved";
            sw = r; hw = w;
            reset = 0x0;
        } reserved_31_1[31:1];
        field {
            name = "muxctrl_reg60";
            desc = "Multiplexing control for the UART0_CTSN pin
- 0: UART0_CTSN
- 1: GPIO6_2";
            sw = rw; hw = r;
            reset = 0x0;
        } muxctrl_reg60[0:0];
    } muxctrl_reg60 @ 0xF0;
    reg {
        name = "muxctrl_reg61";
        desc = "muxctrl_reg61 is a multiplexing control register for the UART0_RTSN pin. (offset 0xF4; total reset 0x00000000; PROVEN: Hi3521A/Hi3520D V300 data sheet (Issue 00B07, 2015-12-10), section 2.4.2, PDF page 106).";
        field {
            name = "reserved";
            desc = "Reserved";
            sw = r; hw = w;
            reset = 0x0;
        } reserved_31_1[31:1];
        field {
            name = "muxctrl_reg61";
            desc = "Multiplexing control for the UART0_RTSN pin
- 0: UART0_RTSN
- 1: GPIO6_3";
            sw = rw; hw = r;
            reset = 0x0;
        } muxctrl_reg61[0:0];
    } muxctrl_reg61 @ 0xF4;
    reg {
        name = "muxctrl_reg62";
        desc = "muxctrl_reg62 is a multiplexing control register for the UART1_RXD pin. (offset 0xF8; total reset 0x00000000; PROVEN: Hi3521A/Hi3520D V300 data sheet (Issue 00B07, 2015-12-10), section 2.4.2, PDF page 107).";
        field {
            name = "reserved";
            desc = "Reserved";
            sw = r; hw = w;
            reset = 0x0;
        } reserved_31_1[31:1];
        field {
            name = "muxctrl_reg62";
            desc = "Multiplexing control for the UART1_RXD pin
- 0: GPIO6_5
- 1: UART1_RXD";
            sw = rw; hw = r;
            reset = 0x0;
        } muxctrl_reg62[0:0];
    } muxctrl_reg62 @ 0xF8;
    reg {
        name = "muxctrl_reg63";
        desc = "muxctrl_reg63 is a multiplexing control register for the UART1_TXD pin. (offset 0xFC; total reset 0x00000000; PROVEN: Hi3521A/Hi3520D V300 data sheet (Issue 00B07, 2015-12-10), section 2.4.2, PDF page 107).";
        field {
            name = "reserved";
            desc = "Reserved";
            sw = r; hw = w;
            reset = 0x0;
        } reserved_31_1[31:1];
        field {
            name = "muxctrl_reg63";
            desc = "Multiplexing control for the UART1_TXD pin
- 0: GPIO6_7
- 1: UART1_TXD";
            sw = rw; hw = r;
            reset = 0x0;
        } muxctrl_reg63[0:0];
    } muxctrl_reg63 @ 0xFC;
    reg {
        name = "muxctrl_reg64";
        desc = "muxctrl_reg64 is a multiplexing control register for the UART2_RXD pin. (offset 0x100; total reset 0x00000000; PROVEN: Hi3521A/Hi3520D V300 data sheet (Issue 00B07, 2015-12-10), section 2.4.2, PDF page 108).";
        field {
            name = "reserved";
            desc = "Reserved";
            sw = r; hw = w;
            reset = 0x0;
        } reserved_31_1[31:1];
        field {
            name = "muxctrl_reg64";
            desc = "Multiplexing control for the UART2_RXD pin
- 0: GPIO11_4
- 1: UART2_RXD";
            sw = rw; hw = r;
            reset = 0x0;
        } muxctrl_reg64[0:0];
    } muxctrl_reg64 @ 0x100;
    reg {
        name = "muxctrl_reg65";
        desc = "muxctrl_reg65 is a multiplexing control register for the UART2_TXD pin. (offset 0x104; total reset 0x00000000; PROVEN: Hi3521A/Hi3520D V300 data sheet (Issue 00B07, 2015-12-10), section 2.4.2, PDF page 108).";
        field {
            name = "reserved";
            desc = "Reserved";
            sw = r; hw = w;
            reset = 0x0;
        } reserved_31_1[31:1];
        field {
            name = "muxctrl_reg65";
            desc = "Multiplexing control for the UART2_TXD pin
- 0: GPIO11_5
- 1: UART2_TXD";
            sw = rw; hw = r;
            reset = 0x0;
        } muxctrl_reg65[0:0];
    } muxctrl_reg65 @ 0x104;
    reg {
        name = "muxctrl_reg66";
        desc = "muxctrl_reg66 is a multiplexing control register for the RGMII_RXDV pin. (offset 0x108; total reset 0x00000000; PROVEN: Hi3521A/Hi3520D V300 data sheet (Issue 00B07, 2015-12-10), section 2.4.2, PDF page 109).";
        field {
            name = "reserved";
            desc = "Reserved";
            sw = r; hw = w;
            reset = 0x0;
        } reserved_31_1[31:1];
        field {
            name = "muxctrl_reg66";
            desc = "Multiplexing control for the RGMII_RXDV pin
- 0: GPIO7_0
- 1: RGMII_RXDV";
            sw = rw; hw = r;
            reset = 0x0;
        } muxctrl_reg66[0:0];
    } muxctrl_reg66 @ 0x108;
    reg {
        name = "muxctrl_reg67";
        desc = "muxctrl_reg67 is a multiplexing control register for the RGMII_RXD3 pin. (offset 0x10C; total reset 0x00000000; PROVEN: Hi3521A/Hi3520D V300 data sheet (Issue 00B07, 2015-12-10), section 2.4.2, PDF page 109).";
        field {
            name = "reserved";
            desc = "Reserved";
            sw = r; hw = w;
            reset = 0x0;
        } reserved_31_1[31:1];
        field {
            name = "muxctrl_reg67";
            desc = "Multiplexing control for the RGMII_RXD3 pin
- 0: GPIO7_1
- 1: RGMII_RXD3";
            sw = rw; hw = r;
            reset = 0x0;
        } muxctrl_reg67[0:0];
    } muxctrl_reg67 @ 0x10C;
    reg {
        name = "muxctrl_reg68";
        desc = "muxctrl_reg68 is a multiplexing control register for the RGMII_RXD2 pin. (offset 0x110; total reset 0x00000000; PROVEN: Hi3521A/Hi3520D V300 data sheet (Issue 00B07, 2015-12-10), section 2.4.2, PDF page 110).";
        field {
            name = "reserved";
            desc = "Reserved";
            sw = r; hw = w;
            reset = 0x0;
        } reserved_31_1[31:1];
        field {
            name = "muxctrl_reg68";
            desc = "Multiplexing control for the RGMII_RXD2 pin
- 0: GPIO7_2
- 1: RGMII_RXD2";
            sw = rw; hw = r;
            reset = 0x0;
        } muxctrl_reg68[0:0];
    } muxctrl_reg68 @ 0x110;
    reg {
        name = "muxctrl_reg69";
        desc = "muxctrl_reg69 is a multiplexing control register for the RGMII_RXD1 pin. (offset 0x114; total reset 0x00000000; PROVEN: Hi3521A/Hi3520D V300 data sheet (Issue 00B07, 2015-12-10), section 2.4.2, PDF page 110).";
        field {
            name = "reserved";
            desc = "Reserved";
            sw = r; hw = w;
            reset = 0x0;
        } reserved_31_1[31:1];
        field {
            name = "muxctrl_reg69";
            desc = "Multiplexing control for the RGMII_RXD1 pin
- 0: GPIO7_3
- 1: RGMII_RXD1";
            sw = rw; hw = r;
            reset = 0x0;
        } muxctrl_reg69[0:0];
    } muxctrl_reg69 @ 0x114;
    reg {
        name = "muxctrl_reg70";
        desc = "muxctrl_reg70 is a multiplexing control register for the RGMII_RXD0 pin. (offset 0x118; total reset 0x00000000; PROVEN: Hi3521A/Hi3520D V300 data sheet (Issue 00B07, 2015-12-10), section 2.4.2, PDF page 111).";
        field {
            name = "reserved";
            desc = "Reserved";
            sw = r; hw = w;
            reset = 0x0;
        } reserved_31_1[31:1];
        field {
            name = "muxctrl_reg70";
            desc = "Multiplexing control for the RGMII_RXD0 pin
- 0: GPIO7_4
- 1: RGMII_RXD0";
            sw = rw; hw = r;
            reset = 0x0;
        } muxctrl_reg70[0:0];
    } muxctrl_reg70 @ 0x118;
    reg {
        name = "muxctrl_reg71";
        desc = "muxctrl_reg71 is a multiplexing control register for the RGMII_RXCK pin. (offset 0x11C; total reset 0x00000000; PROVEN: Hi3521A/Hi3520D V300 data sheet (Issue 00B07, 2015-12-10), section 2.4.2, PDF page 111).";
        field {
            name = "reserved";
            desc = "Reserved";
            sw = r; hw = w;
            reset = 0x0;
        } reserved_31_1[31:1];
        field {
            name = "muxctrl_reg71";
            desc = "Multiplexing control for the RGMII_RXCK pin
- 0: GPIO7_5
- 1: RGMII_RXCK";
            sw = rw; hw = r;
            reset = 0x0;
        } muxctrl_reg71[0:0];
    } muxctrl_reg71 @ 0x11C;
    reg {
        name = "muxctrl_reg72";
        desc = "muxctrl_reg72 is a multiplexing control register for the RGMII_TXEN pin. (offset 0x120; total reset 0x00000000; PROVEN: Hi3521A/Hi3520D V300 data sheet (Issue 00B07, 2015-12-10), section 2.4.2, PDF page 112).";
        field {
            name = "reserved";
            desc = "Reserved";
            sw = r; hw = w;
            reset = 0x0;
        } reserved_31_1[31:1];
        field {
            name = "muxctrl_reg72";
            desc = "Multiplexing control for the RGMII_TXEN pin
- 0: GPIO7_6
- 1: RGMII_TXEN";
            sw = rw; hw = r;
            reset = 0x0;
        } muxctrl_reg72[0:0];
    } muxctrl_reg72 @ 0x120;
    reg {
        name = "muxctrl_reg73";
        desc = "muxctrl_reg73 is a multiplexing control register for the RGMII_TXD3 pin. (offset 0x124; total reset 0x00000000; PROVEN: Hi3521A/Hi3520D V300 data sheet (Issue 00B07, 2015-12-10), section 2.4.2, PDF page 112).";
        field {
            name = "reserved";
            desc = "Reserved";
            sw = r; hw = w;
            reset = 0x0;
        } reserved_31_1[31:1];
        field {
            name = "muxctrl_reg73";
            desc = "Multiplexing control for the RGMII_TXD3 pin
- 0: GPIO7_7
- 1: RGMII_TXD3";
            sw = rw; hw = r;
            reset = 0x0;
        } muxctrl_reg73[0:0];
    } muxctrl_reg73 @ 0x124;
    reg {
        name = "muxctrl_reg74";
        desc = "muxctrl_reg74 is a multiplexing control register for the RGMII_TXD2 pin. (offset 0x128; total reset 0x00000000; PROVEN: Hi3521A/Hi3520D V300 data sheet (Issue 00B07, 2015-12-10), section 2.4.2, PDF page 113).";
        field {
            name = "reserved";
            desc = "Reserved";
            sw = r; hw = w;
            reset = 0x0;
        } reserved_31_1[31:1];
        field {
            name = "muxctrl_reg74";
            desc = "Multiplexing control for the RGMII_TXD2 pin
- 0: GPIO8_0
- 1: RGMII_TXD2";
            sw = rw; hw = r;
            reset = 0x0;
        } muxctrl_reg74[0:0];
    } muxctrl_reg74 @ 0x128;
    reg {
        name = "muxctrl_reg75";
        desc = "muxctrl_reg75 is a multiplexing control register for the RGMII_TXD1 pin. (offset 0x12C; total reset 0x00000000; PROVEN: Hi3521A/Hi3520D V300 data sheet (Issue 00B07, 2015-12-10), section 2.4.2, PDF page 113).";
        field {
            name = "reserved";
            desc = "Reserved";
            sw = r; hw = w;
            reset = 0x0;
        } reserved_31_1[31:1];
        field {
            name = "muxctrl_reg75";
            desc = "Multiplexing control for the RGMII_TXD1 pin
- 0: GPIO8_1
- 1: RGMII_TXD1";
            sw = rw; hw = r;
            reset = 0x0;
        } muxctrl_reg75[0:0];
    } muxctrl_reg75 @ 0x12C;
    reg {
        name = "muxctrl_reg76";
        desc = "muxctrl_reg76 is a multiplexing control register for the RGMII_TXD0 pin. (offset 0x130; total reset 0x00000000; PROVEN: Hi3521A/Hi3520D V300 data sheet (Issue 00B07, 2015-12-10), section 2.4.2, PDF page 114).";
        field {
            name = "reserved";
            desc = "Reserved";
            sw = r; hw = w;
            reset = 0x0;
        } reserved_31_1[31:1];
        field {
            name = "muxctrl_reg76";
            desc = "Multiplexing control for the RGMII_TXD0 pin
- 0: GPIO8_2
- 1: RGMII_TXD0";
            sw = rw; hw = r;
            reset = 0x0;
        } muxctrl_reg76[0:0];
    } muxctrl_reg76 @ 0x130;
    reg {
        name = "muxctrl_reg77";
        desc = "muxctrl_reg77 is a multiplexing control register for the RGMII_TXCKOUT pin. (offset 0x134; total reset 0x00000000; PROVEN: Hi3521A/Hi3520D V300 data sheet (Issue 00B07, 2015-12-10), section 2.4.2, PDF page 114).";
        field {
            name = "reserved";
            desc = "Reserved";
            sw = r; hw = w;
            reset = 0x0;
        } reserved_31_2[31:2];
        field {
            name = "muxctrl_reg77";
            desc = "Multiplexing control for the RGMII_TXCKOUT pin
- 00: GPIO8_3
- 01: RGMII_TXCKOUT
- 10: MII_TXCK
- 11: RMII_CLK";
            sw = rw; hw = r;
            reset = 0x0;
        } muxctrl_reg77[1:0];
    } muxctrl_reg77 @ 0x134;
    reg {
        name = "muxctrl_reg78";
        desc = "muxctrl_reg78 is a multiplexing control register for the RGMII_CRS pin. (offset 0x138; total reset 0x00000000; PROVEN: Hi3521A/Hi3520D V300 data sheet (Issue 00B07, 2015-12-10), section 2.4.2, PDF page 115).";
        field {
            name = "reserved";
            desc = "Reserved";
            sw = r; hw = w;
            reset = 0x0;
        } reserved_31_1[31:1];
        field {
            name = "muxctrl_reg78";
            desc = "Multiplexing control for the RGMII_CRS pin
- 0: GPIO8_4
- 1: RGMII_CRS";
            sw = rw; hw = r;
            reset = 0x0;
        } muxctrl_reg78[0:0];
    } muxctrl_reg78 @ 0x138;
    reg {
        name = "muxctrl_reg79";
        desc = "muxctrl_reg79 is a multiplexing control register for the RGMII_COL pin. (offset 0x13C; total reset 0x00000000; PROVEN: Hi3521A/Hi3520D V300 data sheet (Issue 00B07, 2015-12-10), section 2.4.2, PDF page 115).";
        field {
            name = "reserved";
            desc = "Reserved";
            sw = r; hw = w;
            reset = 0x0;
        } reserved_31_1[31:1];
        field {
            name = "muxctrl_reg79";
            desc = "Multiplexing control for the RGMII_COL pin
- 0: GPIO8_5
- 1: RGMII_COL";
            sw = rw; hw = r;
            reset = 0x0;
        } muxctrl_reg79[0:0];
    } muxctrl_reg79 @ 0x13C;
    reg {
        name = "muxctrl_reg81";
        desc = "muxctrl_reg81 is a multiplexing control register for the EPHY_CLK pin. (offset 0x144; total reset 0x00000000; PROVEN: Hi3521A/Hi3520D V300 data sheet (Issue 00B07, 2015-12-10), section 2.4.2, PDF page 116).";
        field {
            name = "reserved";
            desc = "Reserved";
            sw = r; hw = w;
            reset = 0x0;
        } reserved_31_1[31:1];
        field {
            name = "muxctrl_reg81";
            desc = "Multiplexing control for the EPHY_CLK pin
- 0: GPIO6_6
- 1: EPHY_CLK";
            sw = rw; hw = r;
            reset = 0x0;
        } muxctrl_reg81[0:0];
    } muxctrl_reg81 @ 0x144;
    reg {
        name = "muxctrl_reg83";
        desc = "muxctrl_reg83 is a multiplexing control register for the MDCK pin. (offset 0x14C; total reset 0x00000000; PROVEN: Hi3521A/Hi3520D V300 data sheet (Issue 00B07, 2015-12-10), section 2.4.2, PDF page 116).";
        field {
            name = "reserved";
            desc = "Reserved";
            sw = r; hw = w;
            reset = 0x0;
        } reserved_31_2[31:2];
        field {
            name = "muxctrl_reg83";
            desc = "Multiplexing control for the MDCK pin
- 00: GPIO10_0
- 01: MDCK
- 10: BOOTROM_SEL

Other values: reserved";
            sw = rw; hw = r;
            reset = 0x0;
        } muxctrl_reg83[1:0];
    } muxctrl_reg83 @ 0x14C;
    reg {
        name = "muxctrl_reg84";
        desc = "muxctrl_reg84 is a multiplexing control register for the MDIO pin. (offset 0x150; total reset 0x00000000; PROVEN: Hi3521A/Hi3520D V300 data sheet (Issue 00B07, 2015-12-10), section 2.4.2, PDF page 117).";
        field {
            name = "reserved";
            desc = "Reserved";
            sw = r; hw = w;
            reset = 0x0;
        } reserved_31_1[31:1];
        field {
            name = "muxctrl_reg84";
            desc = "Multiplexing control for the MDIO pin
- 0: GPIO10_1
- 1: MDIO";
            sw = rw; hw = r;
            reset = 0x0;
        } muxctrl_reg84[0:0];
    } muxctrl_reg84 @ 0x150;
    reg {
        name = "muxctrl_reg85";
        desc = "muxctrl_reg85 is a multiplexing control register for the IR_IN pin. (offset 0x154; total reset 0x00000000; PROVEN: Hi3521A/Hi3520D V300 data sheet (Issue 00B07, 2015-12-10), section 2.4.2, PDF page 117).";
        field {
            name = "reserved";
            desc = "Reserved";
            sw = r; hw = w;
            reset = 0x0;
        } reserved_31_1[31:1];
        field {
            name = "muxctrl_reg85";
            desc = "Multiplexing control for the IR_IN pin
- 0: GPIO10_2
- 1: IR_IN";
            sw = rw; hw = r;
            reset = 0x0;
        } muxctrl_reg85[0:0];
    } muxctrl_reg85 @ 0x154;
    reg {
        name = "muxctrl_reg86";
        desc = "muxctrl_reg86 is a multiplexing control register for the SFC_DIO pin. (offset 0x158; total reset 0x00000000; PROVEN: Hi3521A/Hi3520D V300 data sheet (Issue 00B07, 2015-12-10), section 2.4.2, PDF page 118).";
        field {
            name = "reserved";
            desc = "Reserved";
            sw = r; hw = w;
            reset = 0x0;
        } reserved_31_1[31:1];
        field {
            name = "muxctrl_reg86";
            desc = "Multiplexing control for the SFC_DIO pin
- 0: SFC_DIO
- 1: GPIO11_0";
            sw = rw; hw = r;
            reset = 0x0;
        } muxctrl_reg86[0:0];
    } muxctrl_reg86 @ 0x158;
    reg {
        name = "muxctrl_reg87";
        desc = "muxctrl_reg87 is a multiplexing control register for the SFC_WP_IO2 pin. (offset 0x15C; total reset 0x00000000; PROVEN: Hi3521A/Hi3520D V300 data sheet (Issue 00B07, 2015-12-10), section 2.4.2, PDF page 118).";
        field {
            name = "reserved";
            desc = "Reserved";
            sw = r; hw = w;
            reset = 0x0;
        } reserved_31_1[31:1];
        field {
            name = "muxctrl_reg87";
            desc = "Multiplexing control for the SFC_WP_IO2 pin
- 0: SFC_WP_IO2
- 1: GPIO11_1";
            sw = rw; hw = r;
            reset = 0x0;
        } muxctrl_reg87[0:0];
    } muxctrl_reg87 @ 0x15C;
    reg {
        name = "muxctrl_reg88";
        desc = "muxctrl_reg88 is a multiplexing control register for the SFC_DOI pin. (offset 0x160; total reset 0x00000000; PROVEN: Hi3521A/Hi3520D V300 data sheet (Issue 00B07, 2015-12-10), section 2.4.2, PDF page 119).";
        field {
            name = "reserved";
            desc = "Reserved";
            sw = r; hw = w;
            reset = 0x0;
        } reserved_31_1[31:1];
        field {
            name = "muxctrl_reg88";
            desc = "Multiplexing control for the SFC_DOI pin
- 0: SFC_DOI
- 1: GPIO11_2";
            sw = rw; hw = r;
            reset = 0x0;
        } muxctrl_reg88[0:0];
    } muxctrl_reg88 @ 0x160;
    reg {
        name = "muxctrl_reg89";
        desc = "muxctrl_reg89 is a multiplexing control register for the USB2_OVRCUR0 pin. (offset 0x164; total reset 0x00000000; PROVEN: Hi3521A/Hi3520D V300 data sheet (Issue 00B07, 2015-12-10), section 2.4.2, PDF page 119).";
        field {
            name = "reserved";
            desc = "Reserved";
            sw = r; hw = w;
            reset = 0x0;
        } reserved_31_1[31:1];
        field {
            name = "muxctrl_reg89";
            desc = "Multiplexing control for the USB2_OVRCUR0 pin
- 0: GPIO13_0
- 1: USB2_OVRCUR0";
            sw = rw; hw = r;
            reset = 0x0;
        } muxctrl_reg89[0:0];
    } muxctrl_reg89 @ 0x164;
    reg {
        name = "muxctrl_reg90";
        desc = "muxctrl_reg90 is a multiplexing control register for the USB2_PWREN0 pin. (offset 0x168; total reset 0x00000000; PROVEN: Hi3521A/Hi3520D V300 data sheet (Issue 00B07, 2015-12-10), section 2.4.2, PDF page 120).";
        field {
            name = "reserved";
            desc = "Reserved";
            sw = r; hw = w;
            reset = 0x0;
        } reserved_31_1[31:1];
        field {
            name = "muxctrl_reg90";
            desc = "Multiplexing control for the USB2_PWREN0 pin
- 0: GPIO13_1
- 1: USB2_PWREN0";
            sw = rw; hw = r;
            reset = 0x0;
        } muxctrl_reg90[0:0];
    } muxctrl_reg90 @ 0x168;
    reg {
        name = "muxctrl_reg91";
        desc = "muxctrl_reg91 is a multiplexing control register for the USB2_OVRCUR1 pin. (offset 0x16C; total reset 0x00000000; PROVEN: Hi3521A/Hi3520D V300 data sheet (Issue 00B07, 2015-12-10), section 2.4.2, PDF page 120).";
        field {
            name = "reserved";
            desc = "Reserved";
            sw = r; hw = w;
            reset = 0x0;
        } reserved_31_1[31:1];
        field {
            name = "muxctrl_reg91";
            desc = "Multiplexing control for the USB2_OVRCUR1 pin
- 0: GPIO13_2
- 1: USB2_OVRCUR1";
            sw = rw; hw = r;
            reset = 0x0;
        } muxctrl_reg91[0:0];
    } muxctrl_reg91 @ 0x16C;
    reg {
        name = "muxctrl_reg92";
        desc = "muxctrl_reg92 is a multiplexing control register for the USB2_PWREN1 pin. (offset 0x170; total reset 0x00000000; PROVEN: Hi3521A/Hi3520D V300 data sheet (Issue 00B07, 2015-12-10), section 2.4.2, PDF page 121).";
        field {
            name = "reserved";
            desc = "Reserved";
            sw = r; hw = w;
            reset = 0x0;
        } reserved_31_1[31:1];
        field {
            name = "muxctrl_reg92";
            desc = "Multiplexing control for the USB2_PWREN1 pin
- 0: GPIO13_3
- 1: USB2_PWREN1";
            sw = rw; hw = r;
            reset = 0x0;
        } muxctrl_reg92[0:0];
    } muxctrl_reg92 @ 0x170;
    reg {
        name = "muxctrl_reg93";
        desc = "muxctrl_reg93 is a multiplexing control register for the HDMI_HOTPLUG pin. (offset 0x174; total reset 0x00000000; PROVEN: Hi3521A/Hi3520D V300 data sheet (Issue 00B07, 2015-12-10), section 2.4.2, PDF page 121).";
        field {
            name = "reserved";
            desc = "Reserved";
            sw = r; hw = w;
            reset = 0x0;
        } reserved_31_1[31:1];
        field {
            name = "muxctrl_reg93";
            desc = "Multiplexing control for the HDMI_HOTPLUG pin
- 0: GPIO13_4
- 1: HDMI_HOTPLUG";
            sw = rw; hw = r;
            reset = 0x0;
        } muxctrl_reg93[0:0];
    } muxctrl_reg93 @ 0x174;
    reg {
        name = "muxctrl_reg94";
        desc = "muxctrl_reg94 is a multiplexing control register for the HDMI_CEC pin. (offset 0x178; total reset 0x00000000; PROVEN: Hi3521A/Hi3520D V300 data sheet (Issue 00B07, 2015-12-10), section 2.4.2, PDF page 122).";
        field {
            name = "reserved";
            desc = "Reserved";
            sw = r; hw = w;
            reset = 0x0;
        } reserved_31_1[31:1];
        field {
            name = "muxctrl_reg94";
            desc = "Multiplexing control for the HDMI_CEC pin
- 0: GPIO13_5
- 1: HDMI_CEC";
            sw = rw; hw = r;
            reset = 0x0;
        } muxctrl_reg94[0:0];
    } muxctrl_reg94 @ 0x178;
    reg {
        name = "muxctrl_reg95";
        desc = "muxctrl_reg95 is a multiplexing control register for the HDMI_SDA pin. (offset 0x17C; total reset 0x00000000; PROVEN: Hi3521A/Hi3520D V300 data sheet (Issue 00B07, 2015-12-10), section 2.4.2, PDF page 122).";
        field {
            name = "reserved";
            desc = "Reserved";
            sw = r; hw = w;
            reset = 0x0;
        } reserved_31_1[31:1];
        field {
            name = "muxctrl_reg95";
            desc = "Multiplexing control for the HDMI_SDA pin
- 0: GPIO13_6
- 1: HDMI_SDA";
            sw = rw; hw = r;
            reset = 0x0;
        } muxctrl_reg95[0:0];
    } muxctrl_reg95 @ 0x17C;
    reg {
        name = "muxctrl_reg96";
        desc = "muxctrl_reg96 is a multiplexing control register for the HDMI_SCL pin. (offset 0x180; total reset 0x00000000; PROVEN: Hi3521A/Hi3520D V300 data sheet (Issue 00B07, 2015-12-10), section 2.4.2, PDF page 123).";
        field {
            name = "reserved";
            desc = "Reserved";
            sw = r; hw = w;
            reset = 0x0;
        } reserved_31_1[31:1];
        field {
            name = "muxctrl_reg96";
            desc = "Multiplexing control for the HDMI_SCL pin
- 0: GPIO13_7
- 1: HDMI_SCL";
            sw = rw; hw = r;
            reset = 0x0;
        } muxctrl_reg96[0:0];
    } muxctrl_reg96 @ 0x180;
    reg {
        name = "muxctrl_reg97";
        desc = "muxctrl_reg97 is a multiplexing control register for the SATA_LED_N0 pin. (offset 0x184; total reset 0x00000000; PROVEN: Hi3521A/Hi3520D V300 data sheet (Issue 00B07, 2015-12-10), section 2.4.2, PDF page 123).";
        field {
            name = "reserved";
            desc = "Reserved";
            sw = r; hw = w;
            reset = 0x0;
        } reserved_31_1[31:1];
        field {
            name = "muxctrl_reg97";
            desc = "Multiplexing control for the SATA_LED_N0 pin
- 0: GPIO10_3
- 1: SATA_LED_N0";
            sw = rw; hw = r;
            reset = 0x0;
        } muxctrl_reg97[0:0];
    } muxctrl_reg97 @ 0x184;
    reg {
        name = "muxctrl_reg98";
        desc = "muxctrl_reg98 is a multiplexing control register for the SATA_LED_N1 pin. (offset 0x188; total reset 0x00000000; PROVEN: Hi3521A/Hi3520D V300 data sheet (Issue 00B07, 2015-12-10), section 2.4.2, PDF page 124).";
        field {
            name = "reserved";
            desc = "Reserved";
            sw = r; hw = w;
            reset = 0x0;
        } reserved_31_1[31:1];
        field {
            name = "muxctrl_reg98";
            desc = "Multiplexing control for the SATA_LED_N1 pin
- 0: GPIO10_4
- 1: SATA_LED_N1";
            sw = rw; hw = r;
            reset = 0x0;
        } muxctrl_reg98[0:0];
    } muxctrl_reg98 @ 0x188;
    reg {
        name = "muxctrl_reg53";
        desc = "muxctrl_reg53 is a multiplexing control register for the SPI_CSN1 pin. (offset 0xD4; total reset 0x00000000; PROVEN: Hi3521A/Hi3520D V300 data sheet (Issue 00B07, 2015-12-10), section 2.4.2, PDF page 333).";
        field {
            name = "reserved";
            desc = "Reserved";
            sw = r; hw = w;
            reset = 0x0;
        } reserved_31_1[31:1];
        field {
            name = "muxctrl_reg53";
            desc = "Multiplexing control for the SPI_CSN1 pin
- 0: GPIO8_7
- 1: SPI_CSN1";
            sw = rw; hw = r;
            reset = 0x0;
        } muxctrl_reg53[0:0];
    } muxctrl_reg53 @ 0xD4;
    reg {
        name = "muxctrl_reg55";
        desc = "muxctrl_reg55 is a multiplexing control register for the PWM_OUT1 pin. (offset 0xDC; total reset 0x00000000; PROVEN: Hi3521A/Hi3520D V300 data sheet (Issue 00B07, 2015-12-10), section 2.4.2, PDF page 334).";
        field {
            name = "reserved";
            desc = "Reserved";
            sw = r; hw = w;
            reset = 0x0;
        } reserved_31_1[31:1];
        field {
            name = "muxctrl_reg55";
            desc = "Multiplexing control for the PWM_OUT1 pin
- 0: PWM_OUT1
- 1: GPIO5_6";
            sw = rw; hw = r;
            reset = 0x0;
        } muxctrl_reg55[0:0];
    } muxctrl_reg55 @ 0xDC;
    reg {
        name = "muxctrl_reg80";
        desc = "muxctrl_reg80 is a multiplexing control register for the RGMII_RXER pin. (offset 0x140; total reset 0x00000000; PROVEN: Hi3521A/Hi3520D V300 data sheet (Issue 00B07, 2015-12-10), section 2.4.2, PDF page 346).";
        field {
            name = "reserved";
            desc = "Reserved";
            sw = r; hw = w;
            reset = 0x0;
        } reserved_31_1[31:1];
        field {
            name = "muxctrl_reg80";
            desc = "Multiplexing control for the RGMII_RXER pin
- 0: GPIO8_6
- 1: RGMII_RXER";
            sw = rw; hw = r;
            reset = 0x0;
        } muxctrl_reg80[0:0];
    } muxctrl_reg80 @ 0x140;
    reg {
        name = "muxctrl_reg82";
        desc = "muxctrl_reg82 is a multiplexing control register for the EPHY_RSTN pin. (offset 0x148; total reset 0x00000000; PROVEN: Hi3521A/Hi3520D V300 data sheet (Issue 00B07, 2015-12-10), section 2.4.2, PDF page 347).";
        field {
            name = "reserved";
            desc = "Reserved";
            sw = r; hw = w;
            reset = 0x0;
        } reserved_31_1[31:1];
        field {
            name = "muxctrl_reg82";
            desc = "Multiplexing control for the EPHY_RSTN pin
- 0: GPIO6_4
- 1: EPHY_RSTN";
            sw = rw; hw = r;
            reset = 0x0;
        } muxctrl_reg82[0:0];
    } muxctrl_reg82 @ 0x148;
};
`endif
