`ifndef HI3520DV300_DDRC_AWADDR_RDL
`define HI3520DV300_DDRC_AWADDR_RDL
regfile eHI3520DV300_DDRC_AWADDR {
    name = "DDRC AWADDR surveillance";
    desc = "DDRC AWADDR surveillance of the Hi3521A/Hi3520D V300 at base 0x1211_5000. 4 registers extracted programmatically from the Hi3521A/Hi3520D V300 data sheet (Issue 00B07, 2015-12-10) (Table 4-9 Summary of AWADDR_SRVLNC registers (base address: 0x1211_5000)): register headings, offsets, total reset values, field bit ranges, access types, names, reset values and descriptions, with PDF page numbers in each register description. Field names, bit ranges, access types and offsets are exact; the free-text descriptions are taken from the cell text of the field table and were checked by sampling only. Hardware not verified.";
    reg {
        name = "AWADDR_SRVLNC_CLKCFG";
        desc = "AWADDR_SRVLNC_CLKCFG is a MUX clock gating configuration register. (offset 0x0; total reset 0x00000007; PROVEN: Hi3521A/Hi3520D V300 data sheet (Issue 00B07, 2015-12-10), section 4.1.7.2, PDF page 785).";
        field {
            name = "reserved";
            desc = "Reserved";
            sw = r; hw = w;
            reset = 0x1;
        } reserved_31_2[31:2];
        field {
            name = "detaddr_gt_en";
            desc = "Static clock gating for the address monitoring module
- 0: disabled
- 1: enabled";
            sw = rw; hw = r;
            reset = 0x1;
        } detaddr_gt_en[1:1];
        field {
            name = "apg_gt_en";
            desc = "Static clock gating for the register module in the address monitoring module
- 0: disabled
- 1: enabled";
            sw = rw; hw = r;
            reset = 0x1;
        } apg_gt_en[0:0];
    } AWADDR_SRVLNC_CLKCFG @ 0x0;
    regfile AWADDR_SRVLNC_ZONE_t {
        name = "AWADDR_SRVLNC zone";
        desc = "Start/end register pair of one monitored address segment (Table 4-10: addr_zones = 0-31). The registers of segment n sit at 0x100 + 0x8 x n (AWADDR_SRVLNC_STARTN) and 0x104 + 0x8 x n (AWADDR_SRVLNC_ENDN); SystemRDL cannot express two interleaved register arrays, so the pair is modelled as an array of 32 register files at stride 0x8.";
        reg {
            name = "AWADDR_SRVLNC_STARTN";
            desc = "AWADDR_SRVLNC_STARTN is a start address register for segment n in the monitored address area. (offset 0x100 + 0x8 x n, n = 0-31 (addr_zones, Table 4-10); total reset 0x00000000; PROVEN: Hi3521A/Hi3520D V300 data sheet (Issue 00B07, 2015-12-10), section 4.1.7.2, PDF page 786).";
            field {
                name = "awaddr_srvlnc_start";
                desc = "Start address of segment n in the address area Note: The lower 4-bit addresses can be ignored.";
                sw = rw; hw = r;
                reset = 0x0;
            } awaddr_srvlnc_start[31:0];
        } AWADDR_SRVLNC_STARTN @ 0x0;
        reg {
            name = "AWADDR_SRVLNC_ENDN";
            desc = "AWADDR_SRVLNC_ENDN is an end address register for segment n in the monitored address area. (offset 0x104 + 0x8 x n, n = 0-31 (addr_zones, Table 4-10); total reset 0x00000000; PROVEN: Hi3521A/Hi3520D V300 data sheet (Issue 00B07, 2015-12-10), section 4.1.7.2, PDF page 786).";
            field {
                name = "awaddr_srvlnc_end";
                desc = "End address of segment n in the address area Note: The lower 4-bit addresses can be ignored. The configured value is the actual end address + 1.";
                sw = rw; hw = r;
                reset = 0x0;
            } awaddr_srvlnc_end[31:0];
        } AWADDR_SRVLNC_ENDN @ 0x4;
    } AWADDR_SRVLNC_ZONE[32] @ 0x100 += 0x8;
    reg {
        name = "AWADDR_SRVLNC_STATUS";
        desc = "AWADDR_SRVLNC_STATUS is an address pollution status register for the monitored 32-segment address areas. (offset 0x200; total reset 0x00000000; PROVEN: Hi3521A/Hi3520D V300 data sheet (Issue 00B07, 2015-12-10), section 4.1.7.2, PDF page 787).";
        field {
            name = "addr_infect_st31";
            desc = "Monitoring status of segment 31 in the address area
- 0: There is no write command.
- 1: There is a write command.

Access type WC in the data sheet: written 1 clears the bit.";
            sw = rw; hw = w; onwrite = woclr;
            reset = 0x0;
        } addr_infect_st31[31:31];
        field {
            name = "addr_infect_st30";
            desc = "Monitoring status of segment 30 in the address area
- 0: There is no write command.
- 1: There is a write command.

Access type WC in the data sheet: written 1 clears the bit.";
            sw = rw; hw = w; onwrite = woclr;
            reset = 0x0;
        } addr_infect_st30[30:30];
        field {
            name = "addr_infect_st29";
            desc = "Monitoring status of segment 29 in the address area
- 0: There is no write command.
- 1: There is a write command.

Access type WC in the data sheet: written 1 clears the bit.";
            sw = rw; hw = w; onwrite = woclr;
            reset = 0x0;
        } addr_infect_st29[29:29];
        field {
            name = "addr_infect_st28";
            desc = "Monitoring status of segment 28 in the address area
- 0: There is no write command.
- 1: There is a write command.

Access type WC in the data sheet: written 1 clears the bit.";
            sw = rw; hw = w; onwrite = woclr;
            reset = 0x0;
        } addr_infect_st28[28:28];
        field {
            name = "addr_infect_st27";
            desc = "Monitoring status of segment 27 in the address area
- 0: There is no write command.
- 1: There is a write command.

Access type WC in the data sheet: written 1 clears the bit.";
            sw = rw; hw = w; onwrite = woclr;
            reset = 0x0;
        } addr_infect_st27[27:27];
        field {
            name = "addr_infect_st26";
            desc = "Monitoring status of segment 26 in the address area
- 0: There is no write command.
- 1: There is a write command.

Access type WC in the data sheet: written 1 clears the bit.";
            sw = rw; hw = w; onwrite = woclr;
            reset = 0x0;
        } addr_infect_st26[26:26];
        field {
            name = "addr_infect_st25";
            desc = "Monitoring status of segment 25 in the address area
- 0: There is no write command.
- 1: There is a write command.

Access type WC in the data sheet: written 1 clears the bit.";
            sw = rw; hw = w; onwrite = woclr;
            reset = 0x0;
        } addr_infect_st25[25:25];
        field {
            name = "addr_infect_st24";
            desc = "Monitoring status of segment 24 in the address area
- 0: There is no write command.
- 1: There is a write command.

Access type WC in the data sheet: written 1 clears the bit.";
            sw = rw; hw = w; onwrite = woclr;
            reset = 0x0;
        } addr_infect_st24[24:24];
        field {
            name = "addr_infect_st23";
            desc = "Monitoring status of segment 23 in the address area
- 0: There is no write command.
- 1: There is a write command.

Access type WC in the data sheet: written 1 clears the bit.";
            sw = rw; hw = w; onwrite = woclr;
            reset = 0x0;
        } addr_infect_st23[23:23];
        field {
            name = "addr_infect_st22";
            desc = "Monitoring status of segment 22 in the address area
- 0: There is no write command.
- 1: There is a write command.

Access type WC in the data sheet: written 1 clears the bit.";
            sw = rw; hw = w; onwrite = woclr;
            reset = 0x0;
        } addr_infect_st22[22:22];
        field {
            name = "addr_infect_st21";
            desc = "Monitoring status of segment 21 in the address area
- 0: There is no write command.
- 1: There is a write command.

Access type WC in the data sheet: written 1 clears the bit.";
            sw = rw; hw = w; onwrite = woclr;
            reset = 0x0;
        } addr_infect_st21[21:21];
        field {
            name = "addr_infect_st20";
            desc = "Monitoring status of segment 20 in the address area
- 0: There is no write command.
- 1: There is a write command.

Access type WC in the data sheet: written 1 clears the bit.";
            sw = rw; hw = w; onwrite = woclr;
            reset = 0x0;
        } addr_infect_st20[20:20];
        field {
            name = "addr_infect_st19";
            desc = "Monitoring status of segment 19 in the address area
- 0: There is no write command.
- 1: There is a write command.

Access type WC in the data sheet: written 1 clears the bit.";
            sw = rw; hw = w; onwrite = woclr;
            reset = 0x0;
        } addr_infect_st19[19:19];
        field {
            name = "addr_infect_st18";
            desc = "Monitoring status of segment 18 in the address area
- 0: There is no write command.
- 1: There is a write command.

Access type WC in the data sheet: written 1 clears the bit.";
            sw = rw; hw = w; onwrite = woclr;
            reset = 0x0;
        } addr_infect_st18[18:18];
        field {
            name = "addr_infect_st17";
            desc = "Monitoring status of segment 17 in the address area
- 0: There is no write command.
- 1: There is a write command.

Access type WC in the data sheet: written 1 clears the bit.";
            sw = rw; hw = w; onwrite = woclr;
            reset = 0x0;
        } addr_infect_st17[17:17];
        field {
            name = "addr_infect_st16";
            desc = "Monitoring status of segment 16 in the address area
- 0: There is no write command.
- 1: There is a write command.

Access type WC in the data sheet: written 1 clears the bit.";
            sw = rw; hw = w; onwrite = woclr;
            reset = 0x0;
        } addr_infect_st16[16:16];
        field {
            name = "addr_infect_st15";
            desc = "Monitoring status of segment 15 in the address area
- 0: There is no write command.
- 1: There is a write command.

Access type WC in the data sheet: written 1 clears the bit.";
            sw = rw; hw = w; onwrite = woclr;
            reset = 0x0;
        } addr_infect_st15[15:15];
        field {
            name = "addr_infect_st14";
            desc = "Monitoring status of segment 14 in the address area
- 0: There is no write command.
- 1: There is a write command.

Access type WC in the data sheet: written 1 clears the bit.";
            sw = rw; hw = w; onwrite = woclr;
            reset = 0x0;
        } addr_infect_st14[14:14];
        field {
            name = "addr_infect_st13";
            desc = "Monitoring status of segment 13 in the address area
- 0: There is no write command.
- 1: There is a write command.

Access type WC in the data sheet: written 1 clears the bit.";
            sw = rw; hw = w; onwrite = woclr;
            reset = 0x0;
        } addr_infect_st13[13:13];
        field {
            name = "addr_infect_st12";
            desc = "Monitoring status of segment 12 in the address area
- 0: There is no write command.
- 1: There is a write command.

Access type WC in the data sheet: written 1 clears the bit.";
            sw = rw; hw = w; onwrite = woclr;
            reset = 0x0;
        } addr_infect_st12[12:12];
        field {
            name = "addr_infect_st11";
            desc = "Monitoring status of segment 11 in the address area
- 0: There is no write command.
- 1: There is a write command.

Access type WC in the data sheet: written 1 clears the bit.";
            sw = rw; hw = w; onwrite = woclr;
            reset = 0x0;
        } addr_infect_st11[11:11];
        field {
            name = "addr_infect_st10";
            desc = "Monitoring status of segment 10 in the address area
- 0: There is no write command.
- 1: There is a write command.

Access type WC in the data sheet: written 1 clears the bit.";
            sw = rw; hw = w; onwrite = woclr;
            reset = 0x0;
        } addr_infect_st10[10:10];
        field {
            name = "addr_infect_st9";
            desc = "Monitoring status of segment 9 in the address area
- 0: There is no write command.
- 1: There is a write command.

Access type WC in the data sheet: written 1 clears the bit.";
            sw = rw; hw = w; onwrite = woclr;
            reset = 0x0;
        } addr_infect_st9[9:9];
        field {
            name = "addr_infect_st8";
            desc = "Monitoring status of segment 8 in the address area
- 0: There is no write command.
- 1: There is a write command.

Access type WC in the data sheet: written 1 clears the bit.";
            sw = rw; hw = w; onwrite = woclr;
            reset = 0x0;
        } addr_infect_st8[8:8];
        field {
            name = "addr_infect_st7";
            desc = "Monitoring status of segment 7 in the address area
- 0: There is no write command.
- 1: There is a write command.

Access type WC in the data sheet: written 1 clears the bit.";
            sw = rw; hw = w; onwrite = woclr;
            reset = 0x0;
        } addr_infect_st7[7:7];
        field {
            name = "addr_infect_st6";
            desc = "Monitoring status of segment 6 in the address area
- 0: There is no write command.
- 1: There is a write command.

Access type WC in the data sheet: written 1 clears the bit.";
            sw = rw; hw = w; onwrite = woclr;
            reset = 0x0;
        } addr_infect_st6[6:6];
        field {
            name = "addr_infect_st5";
            desc = "Monitoring status of segment 5 in the address area
- 0: There is no write command.
- 1: There is a write command.

Access type WC in the data sheet: written 1 clears the bit.";
            sw = rw; hw = w; onwrite = woclr;
            reset = 0x0;
        } addr_infect_st5[5:5];
        field {
            name = "addr_infect_st4";
            desc = "Monitoring status of segment 4 in the address area
- 0: There is no write command.
- 1: There is a write command.

Access type WC in the data sheet: written 1 clears the bit.";
            sw = rw; hw = w; onwrite = woclr;
            reset = 0x0;
        } addr_infect_st4[4:4];
        field {
            name = "addr_infect_st3";
            desc = "Monitoring status of segment 3 in the address area
- 0: There is no write command.
- 1: There is a write command.

Access type WC in the data sheet: written 1 clears the bit.";
            sw = rw; hw = w; onwrite = woclr;
            reset = 0x0;
        } addr_infect_st3[3:3];
        field {
            name = "addr_infect_st2";
            desc = "Monitoring status of segment 2 in the address area
- 0: There is no write command.
- 1: There is a write command.

Access type WC in the data sheet: written 1 clears the bit.";
            sw = rw; hw = w; onwrite = woclr;
            reset = 0x0;
        } addr_infect_st2[2:2];
        field {
            name = "addr_infect_st1";
            desc = "Monitoring status of segment 1 in the address area
- 0: There is no write command.
- 1: There is a write command.

Access type WC in the data sheet: written 1 clears the bit.";
            sw = rw; hw = w; onwrite = woclr;
            reset = 0x0;
        } addr_infect_st1[1:1];
        field {
            name = "addr_infect_st0";
            desc = "Monitoring status of segment 0 in the address area
- 0: There is no write command.
- 1: There is a write command.

Access type WC in the data sheet: written 1 clears the bit.";
            sw = rw; hw = w; onwrite = woclr;
            reset = 0x0;
        } addr_infect_st0[0:0];
    } AWADDR_SRVLNC_STATUS @ 0x200;
};
`endif
