`ifndef HI3520DV300_GSF_RDL
`define HI3520DV300_GSF_RDL
regfile eHI3520DV300_GSF {
    name = "Gigabit Ethernet MAC (GSF)";
    desc = "Gigabit Ethernet MAC (GSF) of the Hi3521A/Hi3520D V300 at base 0x100a_0000. 164 registers extracted programmatically from the Hi3521A/Hi3520D V300 data sheet (Issue 00B07, 2015-12-10) (Table 5-3 Summary of GSF registers (base address: 0x100a_0000)): register headings, offsets, total reset values, field bit ranges, access types, names, reset values and descriptions, with PDF page numbers in each register description. Field names, bit ranges, access types and offsets are exact; the free-text descriptions are taken from the cell text of the field table and were checked by sampling only. Hardware not verified.";
    reg {
        name = "STATION_ADDR_LOW";
        desc = "STATION_ADDR_LOW is a local MAC address register. (offset 0x0; total reset 0x00000000; PROVEN: Hi3521A/Hi3520D V300 data sheet (Issue 00B07, 2015-12-10), section 5.7, PDF page 1001).";
        field {
            name = "station_addr_low";
            desc = "Lower 32 bits for the source MAC address of MAC_CORE";
            sw = rw; hw = r;
            reset = 0x0;
        } station_addr_low[31:0];
    } STATION_ADDR_LOW @ 0x0;
    reg {
        name = "STATION_ADDR_HIGH";
        desc = "STATION_ADDR_HIGH is a local MAC address register. (offset 0x4; total reset 0x00000000; PROVEN: Hi3521A/Hi3520D V300 data sheet (Issue 00B07, 2015-12-10), section 5.7, PDF page 1001).";
        field {
            name = "reserved";
            desc = "Reserved";
            sw = r; hw = w;
            reset = 0x0;
        } reserved_31_16[31:16];
        field {
            name = "station_addr_high";
            desc = "Upper 16 bits of the source MAC address of MAC_CORE. The default configurations can be used.";
            sw = rw; hw = r;
            reset = 0x0;
        } station_addr_high[15:0];
    } STATION_ADDR_HIGH @ 0x4;
    reg {
        name = "DUPLEX_SEL_RGMII";
        desc = "DUPLEX_SEL_RGMII is a half-duplex selection register. (offset 0x8; total reset 0x00000001; PROVEN: Hi3521A/Hi3520D V300 data sheet (Issue 00B07, 2015-12-10), section 5.7, PDF page 1002).";
        field {
            name = "reserved";
            desc = "Reserved";
            sw = r; hw = w;
            reset = 0x0;
        } reserved_31_1[31:1];
        field {
            name = "duplex_sel_rgmii";
            desc = "Half-duplex selection signal
- 0: half duplex
- 1: full duplex";
            sw = rw; hw = r;
            reset = 0x1;
        } duplex_sel_rgmii[0:0];
    } DUPLEX_SEL_RGMII @ 0x8;
    reg {
        name = "FD_FC_TYPE";
        desc = "FD_FC_TYPE is a flow control frame type domain register. (offset 0xC; total reset 0x00008808; PROVEN: Hi3521A/Hi3520D V300 data sheet (Issue 00B07, 2015-12-10), section 5.7, PDF page 1002).";
        field {
            name = "reserved";
            desc = "Reserved";
            sw = r; hw = w;
            reset = 0x0;
        } reserved_31_16[31:16];
        field {
            name = "fd_fc_type";
            desc = "Flow control frame type domain in full-duplex mode";
            sw = rw; hw = r;
            reset = 0x8808;
        } fd_fc_type[15:0];
    } FD_FC_TYPE @ 0xC;
    reg {
        name = "COL_DISTANCE";
        desc = "COL_DISTANCE is a single retransmission packet length threshold register. (offset 0x14; total reset 0x00000043; PROVEN: Hi3521A/Hi3520D V300 data sheet (Issue 00B07, 2015-12-10), section 5.7, PDF page 1003).";
        field {
            name = "reserved";
            desc = "Reserved";
            sw = r; hw = w;
            reset = 0x0;
        } reserved_31_10[31:10];
        field {
            name = "col_distance";
            desc = "Single retransmission packet length threshold";
            sw = rw; hw = r;
            reset = 0x43;
        } col_distance[9:0];
    } COL_DISTANCE @ 0x14;
    reg {
        name = "FC_TX_TIMER";
        desc = "FC_TX_TIMER is a flow control time parameter register. (offset 0x1C; total reset 0x000000FF; PROVEN: Hi3521A/Hi3520D V300 data sheet (Issue 00B07, 2015-12-10), section 5.7, PDF page 1003).";
        field {
            name = "reserved";
            desc = "Reserved";
            sw = r; hw = w;
            reset = 0x0;
        } reserved_31_16[31:16];
        field {
            name = "fc_tx_timer";
            desc = "Parameter of the time period during which flow control frames are transmitted. The unit of the time period is measured by how long 512 bits are transmitted. In 100 Mbit/s mode, the unit is equivalent to 128 clock periods. In 1000 Mbit/s mode, the unit is equivalent to 64 clock periods.";
            sw = rw; hw = r;
            reset = 0xff;
        } fc_tx_timer[15:0];
    } FC_TX_TIMER @ 0x1C;
    reg {
        name = "FD_FC_ADDR_LOW";
        desc = "FD_FC_ADDR_LOW is a flow control frame destination address lower 32 bits register. (offset 0x20; total reset 0xC2000001; PROVEN: Hi3521A/Hi3520D V300 data sheet (Issue 00B07, 2015-12-10), section 5.7, PDF page 1003).";
        field {
            name = "fd_fc_addr_low";
            desc = "Lower 32 bits of the destination address of the flow control frame";
            sw = rw; hw = r;
            reset = 0xc2000001;
        } fd_fc_addr_low[31:0];
    } FD_FC_ADDR_LOW @ 0x20;
    reg {
        name = "FD_FC_ADDR_HIGH";
        desc = "FD_FC_ADDR_HIGH is a flow control frame destination address upper 16 bits register. (offset 0x24; total reset 0x00000180; PROVEN: Hi3521A/Hi3520D V300 data sheet (Issue 00B07, 2015-12-10), section 5.7, PDF page 1004).";
        field {
            name = "reserved";
            desc = "Reserved";
            sw = r; hw = w;
            reset = 0x0;
        } reserved_31_16[31:16];
        field {
            name = "fd_fc_addr_high";
            desc = "Upper 16 bits of the destination address of the flow control frame";
            sw = rw; hw = r;
            reset = 0x180;
        } fd_fc_addr_high[15:0];
    } FD_FC_ADDR_HIGH @ 0x24;
    reg {
        name = "IPG_TX_TIMER";
        desc = "IPG_TX_TIMER is a TX frame IPG register. (offset 0x30; total reset 0x00000008; PROVEN: Hi3521A/Hi3520D V300 data sheet (Issue 00B07, 2015-12-10), section 5.7, PDF page 1004).";
        field {
            name = "reserved";
            desc = "Reserved";
            sw = r; hw = w;
            reset = 0x0;
        } reserved_31_8[31:8];
        field {
            name = "ipg_tx_timer";
            desc = "TX frame IPG, in the unit of byte";
            sw = rw; hw = r;
            reset = 0x8;
        } ipg_tx_timer[7:0];
    } IPG_TX_TIMER @ 0x30;
    reg {
        name = "PAUSE_THR";
        desc = "PAUSE_THR is a TX flow control frame IPG register. (offset 0x38; total reset 0x0000002F; PROVEN: Hi3521A/Hi3520D V300 data sheet (Issue 00B07, 2015-12-10), section 5.7, PDF page 1004).";
        field {
            name = "reserved";
            desc = "Reserved";
            sw = r; hw = w;
            reset = 0x0;
        } reserved_31_16[31:16];
        field {
            name = "pause_thr";
            desc = "IPG of the flow control frame. If the flow control time is longer than the IPG, the MAC transmits the flow control frame automatically. The unit of the time period is measured by how long 512 bits are transmitted. In 100 Mbit/s mode, the unit is equivalent to 128 clock periods. In 1000 Mbit/s mode, the unit is equivalent to 64 clock periods.";
            sw = rw; hw = r;
            reset = 0x2f;
        } pause_thr[15:0];
    } PAUSE_THR @ 0x38;
    reg {
        name = "MAX_FRM_SIZE";
        desc = "MAX_FRM_SIZE is a maximum frame length register. (offset 0x3C; total reset 0x000005EE; PROVEN: Hi3521A/Hi3520D V300 data sheet (Issue 00B07, 2015-12-10), section 5.7, PDF page 1005).";
        field {
            name = "reserved";
            desc = "Reserved";
            sw = r; hw = w;
            reset = 0x0;
        } reserved_31_14[31:14];
        field {
            name = "max_frm_size";
            desc = "Maximum frame length on the MAC side If the length of an RX frame is greater than the maximum length, the RX frame is regarded as an oversized frame. When the length of a frame to be transmitted is greater than the maximum length, the frame is broken up and then transmitted as an error frame.";
            sw = rw; hw = r;
            reset = 0x5ee;
        } max_frm_size[13:0];
    } MAX_FRM_SIZE @ 0x3C;
    reg {
        name = "PORT_MODE";
        desc = "PORT_MODE is a port status register. (offset 0x40; total reset 0x00000001; PROVEN: Hi3521A/Hi3520D V300 data sheet (Issue 00B07, 2015-12-10), section 5.7, PDF page 1006).";
        field {
            name = "reserved";
            desc = "Reserved";
            sw = r; hw = w;
            reset = 0x0;
        } reserved_31_3[31:3];
        field {
            name = "port_mode";
            desc = "Current MAC port mode
- 000: 10 Mbit/s
- 001: 100 Mbit/s
- 101: 1000 Mbit/s

Other values: reserved";
            sw = rw; hw = r;
            reset = 0x1;
        } port_mode[2:0];
    } PORT_MODE @ 0x40;
    reg {
        name = "PORT_EN";
        desc = "PORT_EN is a channel enable register. (offset 0x44; total reset 0x00000006; PROVEN: Hi3521A/Hi3520D V300 data sheet (Issue 00B07, 2015-12-10), section 5.7, PDF page 1006).";
        field {
            name = "reserved";
            desc = "Reserved";
            sw = r; hw = w;
            reset = 0x0;
        } reserved_31_3[31:3];
        field {
            name = "tx_en";
            desc = "TX channel enable
- 0: disabled
- 1: enabled";
            sw = rw; hw = r;
            reset = 0x1;
        } tx_en[2:2];
        field {
            name = "rx_en";
            desc = "RX channel enable
- 0: disabled
- 1: enabled";
            sw = rw; hw = r;
            reset = 0x1;
        } rx_en[1:1];
        field {
            name = "reserved";
            desc = "Reserved";
            sw = r; hw = w;
            reset = 0x0;
        } reserved_0_0[0:0];
    } PORT_EN @ 0x44;
    reg {
        name = "PAUSE_EN";
        desc = "PAUSE_EN is a flow control enable register. (offset 0x48; total reset 0x00000007; PROVEN: Hi3521A/Hi3520D V300 data sheet (Issue 00B07, 2015-12-10), section 5.7, PDF page 1007).";
        field {
            name = "reserved";
            desc = "Reserved";
            sw = r; hw = w;
            reset = 0x1;
        } reserved_31_2[31:2];
        field {
            name = "tx_fdfc";
            desc = "Flow control frame transmit enable in full-duplex mode
- 0: disabled
- 1: enabled";
            sw = rw; hw = r;
            reset = 0x1;
        } tx_fdfc[1:1];
        field {
            name = "rx_fdfc";
            desc = "Flow control frame response enable in full-duplex mode
- 0: disabled
- 1: enabled";
            sw = rw; hw = r;
            reset = 0x1;
        } rx_fdfc[0:0];
    } PAUSE_EN @ 0x48;
    reg {
        name = "SHORT_RUNTS_THR";
        desc = "SHORT_RUNTS_THR is a short frame threshold register. (offset 0x50; total reset 0x0000000C; PROVEN: Hi3521A/Hi3520D V300 data sheet (Issue 00B07, 2015-12-10), section 5.7, PDF page 1007).";
        field {
            name = "reserved";
            desc = "Reserved";
            sw = r; hw = w;
            reset = 0x0;
        } reserved_31_5[31:5];
        field {
            name = "short_runts_thr";
            desc = "Short frame threshold (for statistics only)";
            sw = rw; hw = r;
            reset = 0xc;
        } short_runts_thr[4:0];
    } SHORT_RUNTS_THR @ 0x50;
    reg {
        name = "DROP_UNK_CTL_FRM";
        desc = "DROP_UNK_CTL_FRM is a drop enable register for unknown control frames. (offset 0x54; total reset 0x00000001; PROVEN: Hi3521A/Hi3520D V300 data sheet (Issue 00B07, 2015-12-10), section 5.7, PDF page 1008).";
        field {
            name = "reserved";
            desc = "Reserved";
            sw = r; hw = w;
            reset = 0x0;
        } reserved_31_1[31:1];
        field {
            name = "drop_unk_ctl_frm";
            desc = "Processing method of the unknown control frames
- 0: The unknown control frames are forwarded normally.
- 1: The unknown control frames are dropped.";
            sw = rw; hw = r;
            reset = 0x1;
        } drop_unk_ctl_frm[0:0];
    } DROP_UNK_CTL_FRM @ 0x54;
    reg {
        name = "TRANSMIT_CONTROL";
        desc = "TRANSMIT_CONTROL is a common configuration register. (offset 0x60; total reset 0x000000D0; PROVEN: Hi3521A/Hi3520D V300 data sheet (Issue 00B07, 2015-12-10), section 5.7, PDF page 1008).";
        field {
            name = "reserved";
            desc = "Reserved";
            sw = r; hw = w;
            reset = 0x0;
        } reserved_31_8[31:8];
        field {
            name = "pad_enable";
            desc = "PAD addition enable
- 0: disabled
- 1: enabled";
            sw = rw; hw = r;
            reset = 0x1;
        } pad_enable[7:7];
        field {
            name = "crc_add";
            desc = "FCS addition enable
- 0: enabled
- 1: disabled";
            sw = rw; hw = r;
            reset = 0x1;
        } crc_add[6:6];
        field {
            name = "reserved";
            desc = "Reserved";
            sw = r; hw = w;
            reset = 0x10;
        } reserved_5_0[5:0];
    } TRANSMIT_CONTROL @ 0x60;
    reg {
        name = "REC_FILT_CONTROL";
        desc = "REC_FILT_CONTROL is an RX frame filter control register. (offset 0x64; total reset 0x00000000; PROVEN: Hi3521A/Hi3520D V300 data sheet (Issue 00B07, 2015-12-10), section 5.7, PDF page 1009).";
        field {
            name = "reserved";
            desc = "Reserved";
            sw = r; hw = w;
            reset = 0x0;
        } reserved_31_6[31:6];
        field {
            name = "crc_err_pass";
            desc = "CRC error frame filter enable
- 0: disabled
- 1: enabled";
            sw = rw; hw = r;
            reset = 0x0;
        } crc_err_pass[5:5];
        field {
            name = "pause_frm_pass";
            desc = "Flow control frame filter enable
- 0: disabled. This bit takes effect only when flow control is enabled, which is transmitted to the software.
- 1: enabled. This bit takes effect only when flow control is enabled, which is not transmitted to the software.";
            sw = rw; hw = r;
            reset = 0x0;
        } pause_frm_pass[4:4];
        field {
            name = "vlan_drop_en";
            desc = "VLAN frame filter enable
- 0: disabled
- 1: enabled";
            sw = rw; hw = r;
            reset = 0x0;
        } vlan_drop_en[3:3];
        field {
            name = "bc_drop_en";
            desc = "Broadcast frame filter enable
- 0: disabled
- 1: enabled";
            sw = rw; hw = r;
            reset = 0x0;
        } bc_drop_en[2:2];
        field {
            name = "mc_match_en";
            desc = "Multicast frame enable with unmatched DA filter
- 0: disabled
- 1: enabled";
            sw = rw; hw = r;
            reset = 0x0;
        } mc_match_en[1:1];
        field {
            name = "uc_match_en";
            desc = "Unicast frame enable with unmatched DA filter
- 0: disabled
- 1: enabled";
            sw = rw; hw = r;
            reset = 0x0;
        } uc_match_en[0:0];
    } REC_FILT_CONTROL @ 0x64;
    reg {
        name = "PORT_MC_ADDR_LOW";
        desc = "PORT_MC_ADDR_LOW is a multicast address register. (offset 0x68; total reset 0x00000000; PROVEN: Hi3521A/Hi3520D V300 data sheet (Issue 00B07, 2015-12-10), section 5.7, PDF page 1010).";
        field {
            name = "port_mc_addr_low";
            desc = "Lower 32 bits of the multicast address, used to check whether the multicast frames match";
            sw = rw; hw = r;
            reset = 0x0;
        } port_mc_addr_low[31:0];
    } PORT_MC_ADDR_LOW @ 0x68;
    reg {
        name = "PORT_MC_ADDR_HIGH";
        desc = "PORT_MC_ADDR_HIGH is a multicast address register. (offset 0x6C; total reset 0x00000000; PROVEN: Hi3521A/Hi3520D V300 data sheet (Issue 00B07, 2015-12-10), section 5.7, PDF page 1010).";
        field {
            name = "reserved";
            desc = "Reserved";
            sw = r; hw = w;
            reset = 0x0;
        } reserved_31_16[31:16];
        field {
            name = "port_mc_addr_high";
            desc = "Upper 16 bits of the multicast address, used to check whether the multicast frames match";
            sw = rw; hw = r;
            reset = 0x0;
        } port_mc_addr_high[15:0];
    } PORT_MC_ADDR_HIGH @ 0x6C;
    reg {
        name = "MAC_CLR";
        desc = "MAC_CLR is a MAC clear register. (offset 0x70; total reset 0x00000000; PROVEN: Hi3521A/Hi3520D V300 data sheet (Issue 00B07, 2015-12-10), section 5.7, PDF page 1011).";
        field {
            name = "reserved";
            desc = "Reserved";
            sw = r; hw = w;
            reset = 0x0;
        } reserved_31_4[31:4];
        field {
            name = "soft_rst_mdio";
            desc = "MDIO clear signal
- 0: invalid
- 1: valid";
            sw = rw; hw = r;
            reset = 0x0;
        } soft_rst_mdio[3:3];
        field {
            name = "soft_rst_mii";
            desc = "MII clear signal
- 0: invalid
- 1: valid";
            sw = rw; hw = r;
            reset = 0x0;
        } soft_rst_mii[2:2];
        field {
            name = "soft_rst_rx";
            desc = "RX clear signal
- 0: invalid
- 1: valid";
            sw = rw; hw = r;
            reset = 0x0;
        } soft_rst_rx[1:1];
        field {
            name = "soft_rst_tx";
            desc = "TX clear signal
- 0: invalid
- 1: valid";
            sw = rw; hw = r;
            reset = 0x0;
        } soft_rst_tx[0:0];
    } MAC_CLR @ 0x70;
    reg {
        name = "RX_OCTETS_OK_CNT";
        desc = "RX_OCTETS_OK_CNT is a byte count register for valid RX frames. (offset 0x80; total reset 0x00000000; PROVEN: Hi3521A/Hi3520D V300 data sheet (Issue 00B07, 2015-12-10), section 5.7, PDF page 1011).";
        field {
            name = "rx_octets_ok_cnt";
            desc = "Count of bytes of the valid RX frames, ranging from DA to FCS";
            sw = r; hw = w; onread = rclr;
            reset = 0x0;
        } rx_octets_ok_cnt[31:0];
    } RX_OCTETS_OK_CNT @ 0x80;
    reg {
        name = "RX_OCTETS_BAD_CNT";
        desc = "RX_OCTETS_BAD_CNT is a byte count register for error RX frames. (offset 0x84; total reset 0x00000000; PROVEN: Hi3521A/Hi3520D V300 data sheet (Issue 00B07, 2015-12-10), section 5.7, PDF page 1012).";
        field {
            name = "rx_octets_bad_cnt";
            desc = "Count of bytes of the frames with CRC errors and alignment errors";
            sw = r; hw = w; onread = rclr;
            reset = 0x0;
        } rx_octets_bad_cnt[31:0];
    } RX_OCTETS_BAD_CNT @ 0x84;
    reg {
        name = "RX_UC_PKTS";
        desc = "RX_UC_PKTS is a MAC frame count register for RX unicast frames. (offset 0x88; total reset 0x00000000; PROVEN: Hi3521A/Hi3520D V300 data sheet (Issue 00B07, 2015-12-10), section 5.7, PDF page 1012).";
        field {
            name = "rx_uc_pkts_cnt";
            desc = "Count of RX unicast frames, excluding bad frames";
            sw = r; hw = w; onread = rclr;
            reset = 0x0;
        } rx_uc_pkts_cnt[31:0];
    } RX_UC_PKTS @ 0x88;
    reg {
        name = "RX_MC_PKTS";
        desc = "RX_MC_PKTS is a frame count register for RX multicast frames. (offset 0x8C; total reset 0x00000000; PROVEN: Hi3521A/Hi3520D V300 data sheet (Issue 00B07, 2015-12-10), section 5.7, PDF page 1012).";
        field {
            name = "rx_mc_pkts_cnt";
            desc = "Count of RX multicast frames, excluding bad frames";
            sw = r; hw = w; onread = rclr;
            reset = 0x0;
        } rx_mc_pkts_cnt[31:0];
    } RX_MC_PKTS @ 0x8C;
    reg {
        name = "RX_BC_PKTS";
        desc = "RX_BC_PKTS is a frame count register for RX broadcast frames. (offset 0x90; total reset 0x00000000; PROVEN: Hi3521A/Hi3520D V300 data sheet (Issue 00B07, 2015-12-10), section 5.7, PDF page 1013).";
        field {
            name = "rx_bc_pkts_cnt";
            desc = "Count of RX broadcast frames, excluding bad frames";
            sw = r; hw = w; onread = rclr;
            reset = 0x0;
        } rx_bc_pkts_cnt[31:0];
    } RX_BC_PKTS @ 0x90;
    reg {
        name = "RX_PKTS_64OCTETS";
        desc = "RX_PKTS_64OCTETS is a frame count register for RX 64-byte frames. (offset 0x94; total reset 0x00000000; PROVEN: Hi3521A/Hi3520D V300 data sheet (Issue 00B07, 2015-12-10), section 5.7, PDF page 1013).";
        field {
            name = "rx_pks_64oct_cnt";
            desc = "Count of RX 64-byte frames, including bad frames";
            sw = r; hw = w; onread = rclr;
            reset = 0x0;
        } rx_pks_64oct_cnt[31:0];
    } RX_PKTS_64OCTETS @ 0x94;
    reg {
        name = "RX_PKTS_65TO127OCTETS";
        desc = "RX_PKTS_65TO127OCTETS is a frame count register for RX frames ranging from 65 bytes to 127 bytes in length. (offset 0x98; total reset 0x00000000; PROVEN: Hi3521A/Hi3520D V300 data sheet (Issue 00B07, 2015-12-10), section 5.7, PDF page 1013).";
        field {
            name = "rx_pks_65to127_oct_cnt";
            desc = "Count of RX frames ranging from 65 bytes to 127 bytes in length, including bad frames";
            sw = r; hw = w; onread = rclr;
            reset = 0x0;
        } rx_pks_65to127_oct_cnt[31:0];
    } RX_PKTS_65TO127OCTETS @ 0x98;
    reg {
        name = "RX_PKTS_128TO255OCTETS";
        desc = "RX_PKTS_128TO255OCTETS is a frame count register for RX frames ranging from 128 bytes to 255 bytes in length. (offset 0x9C; total reset 0x00000000; PROVEN: Hi3521A/Hi3520D V300 data sheet (Issue 00B07, 2015-12-10), section 5.7, PDF page 1014).";
        field {
            name = "rx_pkts_128to255_oct_cnt";
            desc = "Count of RX frames ranging from 128 bytes to 255 bytes in length, including bad frames";
            sw = r; hw = w; onread = rclr;
            reset = 0x0;
        } rx_pkts_128to255_oct_cnt[31:0];
    } RX_PKTS_128TO255OCTETS @ 0x9C;
    reg {
        name = "RX_PKTS_255TO511OCTETS";
        desc = "RX_PKTS_255TO511OCTETS is a frame count register for RX frames ranging from 256 bytes to 511 bytes in length. (offset 0xA0; total reset 0x00000000; PROVEN: Hi3521A/Hi3520D V300 data sheet (Issue 00B07, 2015-12-10), section 5.7, PDF page 1014).";
        field {
            name = "rx_pkts_256to511_oct_cnt";
            desc = "Count of RX frames ranging from 256 bytes to 511 bytes in length, including bad frames";
            sw = r; hw = w; onread = rclr;
            reset = 0x0;
        } rx_pkts_256to511_oct_cnt[31:0];
    } RX_PKTS_255TO511OCTETS @ 0xA0;
    reg {
        name = "RX_PKTS_512TO1023OCTETS";
        desc = "RX_PKTS_512TO1023OCTETS is a frame count register for RX frames ranging from 512 bytes to 1023 bytes in length. (offset 0xA4; total reset 0x00000000; PROVEN: Hi3521A/Hi3520D V300 data sheet (Issue 00B07, 2015-12-10), section 5.7, PDF page 1015).";
        field {
            name = "rx_pkts_512to1023_oct_cnt";
            desc = "Count of RX frames ranging from 512 bytes to 1023 bytes in length, including bad frames";
            sw = r; hw = w; onread = rclr;
            reset = 0x0;
        } rx_pkts_512to1023_oct_cnt[31:0];
    } RX_PKTS_512TO1023OCTETS @ 0xA4;
    reg {
        name = "RX_PKTS_1024TO1518OCTETS";
        desc = "RX_PKTS_1024TO1518OCTETS is a frame count register for RX frames ranging from 1024 bytes to 1518 bytes in length. (offset 0xA8; total reset 0x00000000; PROVEN: Hi3521A/Hi3520D V300 data sheet (Issue 00B07, 2015-12-10), section 5.7, PDF page 1015).";
        field {
            name = "rx_pkts_1024to1518_oct_cnt";
            desc = "Count of RX frames ranging from 1024 bytes to 1518 bytes in length, including bad frames";
            sw = r; hw = w; onread = rclr;
            reset = 0x0;
        } rx_pkts_1024to1518_oct_cnt[31:0];
    } RX_PKTS_1024TO1518OCTETS @ 0xA8;
    reg {
        name = "RX_PKTS_1519TOMAXOCTETS";
        desc = "RX_PKTS_1519TOMAXOCTETS is a frame count register for RX frames ranging from 1519 bytes to the maximum in length. (offset 0xAC; total reset 0x00000000; PROVEN: Hi3521A/Hi3520D V300 data sheet (Issue 00B07, 2015-12-10), section 5.7, PDF page 1015).";
        field {
            name = "rx_pkts_1519tomax_oct_cnt";
            desc = "Count of RX frames ranging from 1519 bytes to the maximum in length, including bad frames";
            sw = r; hw = w; onread = rclr;
            reset = 0x0;
        } rx_pkts_1519tomax_oct_cnt[31:0];
    } RX_PKTS_1519TOMAXOCTETS @ 0xAC;
    reg {
        name = "RX_FCS_ERRORS";
        desc = "RX_FCS_ERRORS is a frame count register for RX frames with CRC errors. (offset 0xB0; total reset 0x00000000; PROVEN: Hi3521A/Hi3520D V300 data sheet (Issue 00B07, 2015-12-10), section 5.7, PDF page 1016).";
        field {
            name = "rx_fcs_errors";
            desc = "Count of RX frames with CRC errors, excluding short frames";
            sw = r; hw = w; onread = rclr;
            reset = 0x0;
        } rx_fcs_errors[31:0];
    } RX_FCS_ERRORS @ 0xB0;
    reg {
        name = "RX_TAGGED";
        desc = "RX_TAGGED is a frame count register for RX frames with tags. (offset 0xB4; total reset 0x00000000; PROVEN: Hi3521A/Hi3520D V300 data sheet (Issue 00B07, 2015-12-10), section 5.7, PDF page 1016).";
        field {
            name = "rx_tagged";
            desc = "Count of RX frames with tags";
            sw = r; hw = w; onread = rclr;
            reset = 0x0;
        } rx_tagged[31:0];
    } RX_TAGGED @ 0xB4;
    reg {
        name = "RX_DATA_ERR";
        desc = "RX_DATA_ERR is a frame count register for RX frames with data errors. (offset 0xB8; total reset 0x00000000; PROVEN: Hi3521A/Hi3520D V300 data sheet (Issue 00B07, 2015-12-10), section 5.7, PDF page 1016).";
        field {
            name = "rx_data_err";
            desc = "Count of RX frames with data errors";
            sw = r; hw = w; onread = rclr;
            reset = 0x0;
        } rx_data_err[31:0];
    } RX_DATA_ERR @ 0xB8;
    reg {
        name = "RX_ALIGN_ERRORS";
        desc = "RX_ALIGN_ERRORS is a frame count register for RX frames with byte-alignment errors. (offset 0xBC; total reset 0x00000000; PROVEN: Hi3521A/Hi3520D V300 data sheet (Issue 00B07, 2015-12-10), section 5.7, PDF page 1017).";
        field {
            name = "rx_align_errors";
            desc = "Count of RX frames with byte-alignment errors";
            sw = r; hw = w; onread = rclr;
            reset = 0x0;
        } rx_align_errors[31:0];
    } RX_ALIGN_ERRORS @ 0xBC;
    reg {
        name = "RX_LONG_ERRORS";
        desc = "RX_LONG_ERRORS is a frame count register for RX oversized frames. (offset 0xC0; total reset 0x00000000; PROVEN: Hi3521A/Hi3520D V300 data sheet (Issue 00B07, 2015-12-10), section 5.7, PDF page 1017).";
        field {
            name = "rx_long_errors";
            desc = "Count of RX oversized frames (without CRC errors)";
            sw = r; hw = w; onread = rclr;
            reset = 0x0;
        } rx_long_errors[31:0];
    } RX_LONG_ERRORS @ 0xC0;
    reg {
        name = "RX_JABBER_ERRORS";
        desc = "RX_JABBER_ERRORS is a frame count register for RX oversized frames. (offset 0xC4; total reset 0x00000000; PROVEN: Hi3521A/Hi3520D V300 data sheet (Issue 00B07, 2015-12-10), section 5.7, PDF page 1017).";
        field {
            name = "rx_jabber_errors";
            desc = "Count of RX oversized frames with CRC errors or non-integer byte count";
            sw = r; hw = w; onread = rclr;
            reset = 0x0;
        } rx_jabber_errors[31:0];
    } RX_JABBER_ERRORS @ 0xC4;
    reg {
        name = "RX_PAUSE_MACCONTROL_FRAMCOUNTER";
        desc = "RX_PAUSE_MACCONTROL_FRAMCOUNTER is a frame count register for RX flow control frames. (offset 0xC8; total reset 0x00000000; PROVEN: Hi3521A/Hi3520D V300 data sheet (Issue 00B07, 2015-12-10), section 5.7, PDF page 1018).";
        field {
            name = "rx_pause_maccontrol_framecounter";
            desc = "Count of RX flow control frames. The CRC must be correct when it is valid.";
            sw = r; hw = w; onread = rclr;
        } rx_pause_maccontrol_framecounter[31:0];
    } RX_PAUSE_MACCONTROL_FRAMCOUNTER @ 0xC8;
    reg {
        name = "RX_UNKNOWN_MACCONTROL_FRAMCOUNTER";
        desc = "RX_UNKNOWN_MACCONTROL_FRAMCOUNTER is a frame count register for RX non-flow-control frames. (offset 0xCC; total reset 0x00000000; PROVEN: Hi3521A/Hi3520D V300 data sheet (Issue 00B07, 2015-12-10), section 5.7, PDF page 1018).";
        field {
            name = "rx_unknown_maccontrol_framecounter";
            desc = "Count of RX non-flow control frames";
            sw = r; hw = w; onread = rclr;
        } rx_unknown_maccontrol_framecounter[31:0];
    } RX_UNKNOWN_MACCONTROL_FRAMCOUNTER @ 0xCC;
    reg {
        name = "RX_VERY_LONG_ERR_CNT";
        desc = "RX_VERY_LONG_ERR_CNT is a frame count register for RX long frames. (offset 0xD0; total reset 0x00000000; PROVEN: Hi3521A/Hi3520D V300 data sheet (Issue 00B07, 2015-12-10), section 5.7, PDF page 1019).";
        field {
            name = "rx_very_long_err_cnt";
            desc = "Count of RX long frames (with the length more than twice the maximum frame length)";
            sw = r; hw = w; onread = rclr;
            reset = 0x0;
        } rx_very_long_err_cnt[31:0];
    } RX_VERY_LONG_ERR_CNT @ 0xD0;
    reg {
        name = "RX_RUNT_ERR_CNT";
        desc = "RX_RUNT_ERR_CNT is a frame count register for RX frames less than 64 bytes but greater than or equal to 12 bytes in length. (offset 0xD4; total reset 0x00000000; PROVEN: Hi3521A/Hi3520D V300 data sheet (Issue 00B07, 2015-12-10), section 5.7, PDF page 1019).";
        field {
            name = "rx_runt_err_cnt";
            desc = "Count of RX frames less than 64 bytes but greater than or equal to 12 bytes in length";
            sw = r; hw = w; onread = rclr;
            reset = 0x0;
        } rx_runt_err_cnt[31:0];
    } RX_RUNT_ERR_CNT @ 0xD4;
    reg {
        name = "RX_SHORT_ERR_CNT";
        desc = "RX_SHORT_ERR_CNT is a frame count register for RX frames less than 12 bytes in length. (offset 0xD8; total reset 0x00000000; PROVEN: Hi3521A/Hi3520D V300 data sheet (Issue 00B07, 2015-12-10), section 5.7, PDF page 1020).";
        field {
            name = "rx_short_err_cnt";
            desc = "Count of RX frames less than 12 bytes in length.";
            sw = r; hw = w; onread = rclr;
            reset = 0x0;
        } rx_short_err_cnt[31:0];
    } RX_SHORT_ERR_CNT @ 0xD8;
    reg {
        name = "OCTETS_TRANSMITTED_OK";
        desc = "OCTETS_TRANSMITTED_OK is a byte count register for TX normal packets. (offset 0x100; total reset 0x00000000; PROVEN: Hi3521A/Hi3520D V300 data sheet (Issue 00B07, 2015-12-10), section 5.7, PDF page 1020).";
        field {
            name = "octets_transmitted_ok";
            desc = "Count of bytes of the transmitted normal packets, excluding the preambles and SFDs";
            sw = r; hw = w; onread = rclr;
            reset = 0x0;
        } octets_transmitted_ok[31:0];
    } OCTETS_TRANSMITTED_OK @ 0x100;
    reg {
        name = "OCTETS_TRANSMITTED_BAD";
        desc = "OCTETS_TRANSMITTED_BAD is a byte count register for TX bad packets. (offset 0x104; total reset 0x00000000; PROVEN: Hi3521A/Hi3520D V300 data sheet (Issue 00B07, 2015-12-10), section 5.7, PDF page 1020).";
        field {
            name = "octets_transmitted_bad";
            desc = "Count of bytes of the TX bad packets";
            sw = r; hw = w; onread = rclr;
            reset = 0x0;
        } octets_transmitted_bad[31:0];
    } OCTETS_TRANSMITTED_BAD @ 0x104;
    reg {
        name = "TX_UC_PKTS";
        desc = "TX_UC_PKTS is a frame count register for TX unicast frames. (offset 0x108; total reset 0x00000000; PROVEN: Hi3521A/Hi3520D V300 data sheet (Issue 00B07, 2015-12-10), section 5.7, PDF page 1021).";
        field {
            name = "tx_uc_pkts";
            desc = "Count of TX unicast frames, excluding bad packets";
            sw = r; hw = w; onread = rclr;
            reset = 0x0;
        } tx_uc_pkts[31:0];
    } TX_UC_PKTS @ 0x108;
    reg {
        name = "TX_MC_PKTS";
        desc = "TX_MC_PKTS is a frame count register for TX multicast frames. (offset 0x10C; total reset 0x00000000; PROVEN: Hi3521A/Hi3520D V300 data sheet (Issue 00B07, 2015-12-10), section 5.7, PDF page 1021).";
        field {
            name = "tx_mc_pkts";
            desc = "Count of TX multicast frames, excluding bad packets";
            sw = r; hw = w; onread = rclr;
            reset = 0x0;
        } tx_mc_pkts[31:0];
    } TX_MC_PKTS @ 0x10C;
    reg {
        name = "TX_BC_PKTS";
        desc = "TX_BC_PKTS is a frame count register for TX broadcast frames. (offset 0x110; total reset 0x00000000; PROVEN: Hi3521A/Hi3520D V300 data sheet (Issue 00B07, 2015-12-10), section 5.7, PDF page 1021).";
        field {
            name = "tx_bc_pkts";
            desc = "Count of TX broadcast frames, excluding bad packets";
            sw = r; hw = w; onread = rclr;
            reset = 0x0;
        } tx_bc_pkts[31:0];
    } TX_BC_PKTS @ 0x110;
    reg {
        name = "TX_PKTS_64OCTETS";
        desc = "TX_PKTS_64OCTETS is a frame count register for TX 64-byte frames. (offset 0x114; total reset 0x00000000; PROVEN: Hi3521A/Hi3520D V300 data sheet (Issue 00B07, 2015-12-10), section 5.7, PDF page 1022).";
        field {
            name = "tx_pkts_64octets";
            desc = "Count of TX 64-byte frames, including bad packets";
            sw = r; hw = w; onread = rclr;
            reset = 0x0;
        } tx_pkts_64octets[31:0];
    } TX_PKTS_64OCTETS @ 0x114;
    reg {
        name = "TX_PKTS_65TO127OCTETS";
        desc = "TX_PKTS_65TO127OCTETS is a frame count register for TX frames ranging from 65 bytes to 127 bytes in length. (offset 0x118; total reset 0x00000000; PROVEN: Hi3521A/Hi3520D V300 data sheet (Issue 00B07, 2015-12-10), section 5.7, PDF page 1022).";
        field {
            name = "tx_pkts_65to127octets";
            desc = "Count of TX frames ranging from 65 bytes to 127 bytes in length, including bad packets";
            sw = r; hw = w; onread = rclr;
            reset = 0x0;
        } tx_pkts_65to127octets[31:0];
    } TX_PKTS_65TO127OCTETS @ 0x118;
    reg {
        name = "TX_PKTS_128TO255OCTETS";
        desc = "TX_PKTS_128TO255OCTETS is a frame count register for TX frames ranging from 128 bytes to 255 bytes in length. (offset 0x11C; total reset 0x00000000; PROVEN: Hi3521A/Hi3520D V300 data sheet (Issue 00B07, 2015-12-10), section 5.7, PDF page 1023).";
        field {
            name = "tx_pkts_128to255octets";
            desc = "Count of TX frames ranging from 128 bytes to 255 bytes in length, including bad packets";
            sw = r; hw = w; onread = rclr;
            reset = 0x0;
        } tx_pkts_128to255octets[31:0];
    } TX_PKTS_128TO255OCTETS @ 0x11C;
    reg {
        name = "TX_PKTS_255TO511OCTETS";
        desc = "TX_PKTS_255TO511OCTETS is a frame count register for TX frames ranging from 256 bytes to 511 bytes in length. (offset 0x120; total reset 0x00000000; PROVEN: Hi3521A/Hi3520D V300 data sheet (Issue 00B07, 2015-12-10), section 5.7, PDF page 1023).";
        field {
            name = "tx_pkts_256to511octets";
            desc = "Count of TX frames ranging from 256 bytes to 511 bytes in length, including bad packets";
            sw = r; hw = w; onread = rclr;
            reset = 0x0;
        } tx_pkts_256to511octets[31:0];
    } TX_PKTS_255TO511OCTETS @ 0x120;
    reg {
        name = "TX_PKTS_512TO1023OCTETS";
        desc = "TX_PKTS_512TO1023OCTETS is a frame count register for TX frames ranging from 512 bytes to 1023 bytes in length. (offset 0x124; total reset 0x00000000; PROVEN: Hi3521A/Hi3520D V300 data sheet (Issue 00B07, 2015-12-10), section 5.7, PDF page 1024).";
        field {
            name = "tx_pkts_512to1023octets";
            desc = "Count of TX frames ranging from 512 bytes to 1023 bytes in length, including bad packets";
            sw = r; hw = w; onread = rclr;
            reset = 0x0;
        } tx_pkts_512to1023octets[31:0];
    } TX_PKTS_512TO1023OCTETS @ 0x124;
    reg {
        name = "TX_PKTS_1024TO1518OCTETS";
        desc = "TX_PKTS_1024TO1518OCTETS is a frame count register for TX frames ranging from 1024 bytes to 1518 bytes in length. (offset 0x128; total reset 0x00000000; PROVEN: Hi3521A/Hi3520D V300 data sheet (Issue 00B07, 2015-12-10), section 5.7, PDF page 1024).";
        field {
            name = "tx_pkts_1024to1518octets";
            desc = "Count of TX frames ranging from 1024 bytes to 1518 bytes in length, including bad packets";
            sw = r; hw = w; onread = rclr;
            reset = 0x0;
        } tx_pkts_1024to1518octets[31:0];
    } TX_PKTS_1024TO1518OCTETS @ 0x128;
    reg {
        name = "TX_PKTS_1519TOMAXOCTETS";
        desc = "TX_PKTS_1519TOMAXOCTETS is a frame count register for TX frames greater than 1519 bytes in length. (offset 0x12C; total reset 0x00000000; PROVEN: Hi3521A/Hi3520D V300 data sheet (Issue 00B07, 2015-12-10), section 5.7, PDF page 1025).";
        field {
            name = "tx_pkts_1519tomaxoctes";
            desc = "Count of TX frames greater than 1519 bytes in length, including bad packets";
            sw = r; hw = w; onread = rclr;
            reset = 0x0;
        } tx_pkts_1519tomaxoctes[31:0];
    } TX_PKTS_1519TOMAXOCTETS @ 0x12C;
    reg {
        name = "TX_EXC_COL_ERR_CNT";
        desc = "TX_EXC_COL_ERR_CNT is a count register for packets whose number reaches the maximum retransmission number threshold. (offset 0x144; total reset 0x00000000; PROVEN: Hi3521A/Hi3520D V300 data sheet (Issue 00B07, 2015-12-10), section 5.7, PDF page 1025).";
        field {
            name = "tx_exc_col_err_cnt";
            desc = "Count of packets whose number reaches the maximum retransmission number threshold";
            sw = rw; hw = r;
            reset = 0x0;
        } tx_exc_col_err_cnt[31:0];
    } TX_EXC_COL_ERR_CNT @ 0x144;
    reg {
        name = "TX_EXCESSIVE_LENGTH_DROP";
        desc = "TX_EXCESSIVE_LENGTH_DROP is a count register for transmission failures caused by oversized frames. (offset 0x14C; total reset 0x00000000; PROVEN: Hi3521A/Hi3520D V300 data sheet (Issue 00B07, 2015-12-10), section 5.7, PDF page 1026).";
        field {
            name = "tx_excessive_length_drop";
            desc = "Count of transmission failures caused by oversized frames";
            sw = r; hw = w; onread = rclr;
            reset = 0x0;
        } tx_excessive_length_drop[31:0];
    } TX_EXCESSIVE_LENGTH_DROP @ 0x14C;
    reg {
        name = "TX_UNDERRUN";
        desc = "TX_UNDERRUN is a count register for transmission failures caused by internal errors. (offset 0x150; total reset 0x00000000; PROVEN: Hi3521A/Hi3520D V300 data sheet (Issue 00B07, 2015-12-10), section 5.7, PDF page 1026).";
        field {
            name = "tx_underrun";
            desc = "Count of transmission failures caused by internal errors";
            sw = r; hw = w; onread = rclr;
            reset = 0x0;
        } tx_underrun[31:0];
    } TX_UNDERRUN @ 0x150;
    reg {
        name = "TX_TAGGED";
        desc = "TX_TAGGED is a frame count register for TX VLAN frames. (offset 0x154; total reset 0x00000000; PROVEN: Hi3521A/Hi3520D V300 data sheet (Issue 00B07, 2015-12-10), section 5.7, PDF page 1027).";
        field {
            name = "tx_tagged";
            desc = "Count of TX VLAN frames The value of the Type field equals to that of the 0x8100 packet.";
            sw = r; hw = w; onread = rclr;
            reset = 0x0;
        } tx_tagged[31:0];
    } TX_TAGGED @ 0x154;
    reg {
        name = "TX_CRC_ERROR";
        desc = "TX_CRC_ERROR is a frame count register for TX frames with valid lengths and CRC errors. (offset 0x158; total reset 0x00000000; PROVEN: Hi3521A/Hi3520D V300 data sheet (Issue 00B07, 2015-12-10), section 5.7, PDF page 1027).";
        field {
            name = "tx_crc_error";
            desc = "Count of TX frames with valid lengths and CRC errors";
            sw = r; hw = w; onread = rclr;
            reset = 0x0;
        } tx_crc_error[31:0];
    } TX_CRC_ERROR @ 0x158;
    reg {
        name = "TX_PAUSE_FRAMES";
        desc = "TX_PAUSE_FRAMES is a frame count register for TX PAUSE frames. (offset 0x15C; total reset 0x00000000; PROVEN: Hi3521A/Hi3520D V300 data sheet (Issue 00B07, 2015-12-10), section 5.7, PDF page 1027).";
        field {
            name = "tx_pause_frames";
            desc = "Count of TX PAUSE frames";
            sw = r; hw = w; onread = rclr;
            reset = 0x0;
        } tx_pause_frames[31:0];
    } TX_PAUSE_FRAMES @ 0x15C;
    reg {
        name = "LINE_LOOP_BACK";
        desc = "LINE_LOOP_BACK is a loopback register on the MAC line side. (offset 0x1A8; total reset 0x00000000; PROVEN: Hi3521A/Hi3520D V300 data sheet (Issue 00B07, 2015-12-10), section 5.7, PDF page 1028).";
        field {
            name = "reserved";
            desc = "Reserved";
            sw = r; hw = w;
            reset = 0x0;
        } reserved_31_1[31:1];
        field {
            name = "line_loop_back";
            desc = "MAC line-side loopback enable
- 0: disabled
- 1: enabled";
            sw = rw; hw = r;
            reset = 0x0;
        } line_loop_back[0:0];
    } LINE_LOOP_BACK @ 0x1A8;
    reg {
        name = "CF_CRC_STRIP";
        desc = "CF_CRC_STRIP is a CRC strip enable register. (offset 0x1B0; total reset 0x00000001; PROVEN: Hi3521A/Hi3520D V300 data sheet (Issue 00B07, 2015-12-10), section 5.7, PDF page 1028).";
        field {
            name = "reserved";
            desc = "Reserved";
            sw = r; hw = w;
            reset = 0x0;
        } reserved_31_1[31:1];
        field {
            name = "cf_crc_strip";
            desc = "RX CRC strip enable on the MAC side
- 0: disabled. The four bytes of the CRC are regarded as part of the packet.
- 1: enabled. The four bytes of the CRC are stripped from the packet.";
            sw = rw; hw = r;
            reset = 0x1;
        } cf_crc_strip[0:0];
    } CF_CRC_STRIP @ 0x1B0;
    reg {
        name = "MODE_CHANGE_EN";
        desc = "MODE_CHANGE_EN is a port mode change enable register. (offset 0x1B4; total reset 0x00000000; PROVEN: Hi3521A/Hi3520D V300 data sheet (Issue 00B07, 2015-12-10), section 5.7, PDF page 1029).";
        field {
            name = "reserved";
            desc = "Reserved";
            sw = r; hw = w;
            reset = 0x0;
        } reserved_31_1[31:1];
        field {
            name = "mode_change_en";
            desc = "port_mode change enable
- 0: disabled
- 1: enabled";
            sw = rw; hw = r;
            reset = 0x0;
        } mode_change_en[0:0];
    } MODE_CHANGE_EN @ 0x1B4;
    reg {
        name = "COL_SLOT_TIME";
        desc = "COL_SLOT_TIME is a count register for half-duplex collision retransmission intervals. (offset 0x1C0; total reset 0x000040FF; PROVEN: Hi3521A/Hi3520D V300 data sheet (Issue 00B07, 2015-12-10), section 5.7, PDF page 1029).";
        field {
            name = "reserved";
            desc = "Reserved";
            sw = r; hw = w;
            reset = 0x0;
        } reserved_31_24[31:24];
        field {
            name = "cf2bc_slottime";
            desc = "Interval for half-duplex collision retransmission";
            sw = rw; hw = r;
            reset = 0x40;
        } cf2bc_slottime[23:8];
        field {
            name = "cf2bc_random_seed";
            desc = "Random multiple radix for half-duplex collision retransmission";
            sw = rw; hw = r;
            reset = 0xff;
        } cf2bc_random_seed[7:0];
    } COL_SLOT_TIME @ 0x1C0;
    reg {
        name = "LOOP_REG";
        desc = "LOOP_REG is a loopback supplement register. (offset 0x1DC; total reset 0x00000002; PROVEN: Hi3521A/Hi3520D V300 data sheet (Issue 00B07, 2015-12-10), section 5.7, PDF page 1030).";
        field {
            name = "reserved";
            desc = "Reserved";
            sw = r; hw = w;
            reset = 0x0;
        } reserved_31_2[31:2];
        field {
            name = "cf_ext_drive_lp";
            desc = "Generation of the read/write enable signals of the MAC data during loopback on the line side
- 0: The read/write enable signals are generated in the MAC.
- 1: The read/write enable signals are generated based on the MAC enable signals read by the downlink FIFO.";
            sw = rw; hw = r;
            reset = 0x1;
        } cf_ext_drive_lp[1:1];
        field {
            name = "reserved";
            desc = "Reserved";
            sw = r; hw = w;
            reset = 0x0;
        } reserved_0_0[0:0];
    } LOOP_REG @ 0x1DC;
    reg {
        name = "RECV_CONTROL";
        desc = "RECV_CONTROL is an RX control register. (offset 0x1E0; total reset 0x00000000; PROVEN: Hi3521A/Hi3520D V300 data sheet (Issue 00B07, 2015-12-10), section 5.7, PDF page 1030).";
        field {
            name = "reserved";
            desc = "Reserved";
            sw = r; hw = w;
            reset = 0x0;
        } reserved_31_5[31:5];
        field {
            name = "runt_pkt_en";
            desc = "Transparent transmission enable of the RX short frames
- 0: discarded and not transmitted to the software
- 1: transmitted to the software";
            sw = rw; hw = r;
            reset = 0x0;
        } runt_pkt_en[4:4];
        field {
            name = "strip_pad_en";
            desc = "PAD for stripping RX frames enable
- 0: disabled
- 1: enabled";
            sw = rw; hw = r;
            reset = 0x0;
        } strip_pad_en[3:3];
        field {
            name = "reserved";
            desc = "Reserved";
            sw = r; hw = w;
            reset = 0x0;
        } reserved_2_0[2:0];
    } RECV_CONTROL @ 0x1E0;
    reg {
        name = "VLAN_CODE";
        desc = "VLAN_CODE is a VLAN code register. (offset 0x1E8; total reset 0x00008100; PROVEN: Hi3521A/Hi3520D V300 data sheet (Issue 00B07, 2015-12-10), section 5.7, PDF page 1031).";
        field {
            name = "reserved";
            desc = "Reserved";
            sw = r; hw = w;
            reset = 0x0;
        } reserved_31_16[31:16];
        field {
            name = "cf_vlan_code";
            desc = "Ethernet Type field configuration";
            sw = rw; hw = r;
            reset = 0x8100;
        } cf_vlan_code[15:0];
    } VLAN_CODE @ 0x1E8;
    reg {
        name = "RX_OVERRUN_CNT";
        desc = "RX_OVERRUN_CNT is a FIFO overrun count register. (offset 0x1EC; total reset 0x00000000; PROVEN: Hi3521A/Hi3520D V300 data sheet (Issue 00B07, 2015-12-10), section 5.7, PDF page 1031).";
        field {
            name = "rx_overrun_cnt";
            desc = "Count of FIFO overruns on the MAC application side";
            sw = r; hw = w; onread = rclr;
            reset = 0x0;
        } rx_overrun_cnt[31:0];
    } RX_OVERRUN_CNT @ 0x1EC;
    reg {
        name = "RX_LENGTHFIELD_ERR_CNT";
        desc = "RX_LENGTHFIELD_ERR_CNT is a frame count register for RX frames containing PADs. (offset 0x1F4; total reset 0x00000000; PROVEN: Hi3521A/Hi3520D V300 data sheet (Issue 00B07, 2015-12-10), section 5.7, PDF page 1032).";
        field {
            name = "rx_lengthfield_err_cnt";
            desc = "Count of RX frames containing PADs and with the length of not 64 bytes when the PAD strip enable is valid";
            sw = r; hw = w; onread = rclr;
            reset = 0x0;
        } rx_lengthfield_err_cnt[31:0];
    } RX_LENGTHFIELD_ERR_CNT @ 0x1F4;
    reg {
        name = "RX_FAIL_COMMA_CNT";
        desc = "RX_FAIL_COMMA_CNT is a COMMA count register for byte delimitation. (offset 0x1F8; total reset 0x00000000; PROVEN: Hi3521A/Hi3520D V300 data sheet (Issue 00B07, 2015-12-10), section 5.7, PDF page 1032).";
        field {
            name = "rx_fail_comma_cnt";
            desc = "Count of COMMA codes when two or more COMMA codes exist during byte delimitation";
            sw = r; hw = w; onread = rclr;
            reset = 0x0;
        } rx_fail_comma_cnt[31:0];
    } RX_FAIL_COMMA_CNT @ 0x1F8;
    reg {
        name = "MAC_SA_ADDR_L";
        desc = "MAC_SA_ADDR_L is a source MAC address register. (offset 0x200; total reset 0x00000000; PROVEN: Hi3521A/Hi3520D V300 data sheet (Issue 00B07, 2015-12-10), section 5.7, PDF page 1032).";
        field {
            name = "mac_sa_addr_l";
            desc = "Lower 32 bits of the source MAC address used by the PMU, which are inserted into the lower 32 bits of the source address (SA) field";
            sw = rw; hw = r;
            reset = 0x0;
        } mac_sa_addr_l[31:0];
    } MAC_SA_ADDR_L @ 0x200;
    reg {
        name = "MAC_SA_ADDR_H";
        desc = "MAC_SA_ADDR_H is a source MAC address register. (offset 0x204; total reset 0x00000000; PROVEN: Hi3521A/Hi3520D V300 data sheet (Issue 00B07, 2015-12-10), section 5.7, PDF page 1033).";
        field {
            name = "reserved";
            desc = "Reserved";
            sw = r; hw = w;
            reset = 0x0;
        } reserved_31_16[31:16];
        field {
            name = "mac_sa_addr_h";
            desc = "Upper 16 bits of the source MAC address used by the PMU";
            sw = rw; hw = r;
            reset = 0x0;
        } mac_sa_addr_h[15:0];
    } MAC_SA_ADDR_H @ 0x204;
    reg {
        name = "MAC_DA_ADDR_L";
        desc = "MAC_DA_ADDR_L is a destination MAC address register. (offset 0x208; total reset 0x00000000; PROVEN: Hi3521A/Hi3520D V300 data sheet (Issue 00B07, 2015-12-10), section 5.7, PDF page 1033).";
        field {
            name = "mac_da_addr_l";
            desc = "Lower 32 bits of the destination MAC address used by the PMU, which are inserted into the lower 32 bits of the destination address field";
            sw = rw; hw = r;
            reset = 0x0;
        } mac_da_addr_l[31:0];
    } MAC_DA_ADDR_L @ 0x208;
    reg {
        name = "MAC_DA_ADDR_H";
        desc = "MAC_DA_ADDR_H is a destination MAC address register. (offset 0x20C; total reset 0x00000000; PROVEN: Hi3521A/Hi3520D V300 data sheet (Issue 00B07, 2015-12-10), section 5.7, PDF page 1033).";
        field {
            name = "reserved";
            desc = "Reserved";
            sw = r; hw = w;
            reset = 0x0;
        } reserved_31_27[31:27];
        field {
            name = "crf_tx_max_packet";
            desc = "Maximum length of the normal and SG packets allowed by the PMU";
            sw = rw; hw = r;
            reset = 0x0;
        } crf_tx_max_packet[26:16];
        field {
            name = "mac_da_addr_h";
            desc = "Upper 16 bits of the destination MAC address used by the PMU";
            sw = rw; hw = r;
            reset = 0x0;
        } mac_da_addr_h[15:0];
    } MAC_DA_ADDR_H @ 0x20C;
    reg {
        name = "CRF_MIN_PACKET";
        desc = "CRF_MIN_PACKET is a minimum filter packet length register. (offset 0x210; total reset 0x00000F2A; PROVEN: Hi3521A/Hi3520D V300 data sheet (Issue 00B07, 2015-12-10), section 5.7, PDF page 1034).";
        field {
            name = "tso_version";
            desc = "TSO version
- 100: single-byte combination version
- 200: SG or COE version
- 300: TSO version";
            sw = r; hw = w;
            reset = 0x0;
        } tso_version[31:20];
        field {
            name = "reserved";
            desc = "Reserved";
            sw = r; hw = w;
            reset = 0x0;
        } reserved_19_14[19:14];
        field {
            name = "crf_tx_min_packet";
            desc = "Minimum length of the TX packet. The default length is 15 bytes.";
            sw = rw; hw = r;
            reset = 0xf;
        } crf_tx_min_packet[13:8];
        field {
            name = "reserved";
            desc = "Reserved";
            sw = r; hw = w;
            reset = 0x0;
        } reserved_7_6[7:6];
        field {
            name = "crf_rx_min_packet";
            desc = "Minimum length of the RX packet. The default length is 42 bytes.";
            sw = rw; hw = r;
            reset = 0x2a;
        } crf_rx_min_packet[5:0];
    } CRF_MIN_PACKET @ 0x210;
    reg {
        name = "CONTROL_WORD";
        desc = "CONTROL_WORD is a control register. (offset 0x214; total reset 0x00C00640; PROVEN: Hi3521A/Hi3520D V300 data sheet (Issue 00B07, 2015-12-10), section 5.7, PDF page 1035).";
        field {
            name = "reserved";
            desc = "Reserved";
            sw = r; hw = w;
            reset = 0x0;
        } reserved_31_26[31:26];
        field {
            name = "crf_tx_standard";
            desc = "Configuration standard for the transmit waterline of the TX FIFO
- 0: The standard is set based on the packet and empty threshold. If the TX FIFO contains a complete packet or the number of valid data items in the TX FIFO is equal to or greater than the threshold multiplied by 4, a read request is sent to the MAC.
- 1: The standard is set based on the packet. If the TX FIFO contains a complete packet, a read request is sent to the MAC.";
            sw = rw; hw = r;
            reset = 0x0;
        } crf_tx_standard[25:25];
        field {
            name = "reserved";
            desc = "Reserved";
            sw = r; hw = w;
            reset = 0x3;
        } reserved_24_22[24:22];
        field {
            name = "crf_ip_flow_ctrl";
            desc = "IP packet flow control enable
- 0: disabled
- 1: enabled";
            sw = rw; hw = r;
            reset = 0x0;
        } crf_ip_flow_ctrl[21:21];
        field {
            name = "crf_ctrl_flow_ctrl";
            desc = "Control packet flow control enable
- 0: disabled
- 1: enabled";
            sw = rw; hw = r;
            reset = 0x0;
        } crf_ctrl_flow_ctrl[20:20];
        field {
            name = "reserved";
            desc = "Reserved";
            sw = r; hw = w;
            reset = 0x0;
        } reserved_19_18[19:18];
        field {
            name = "crf_filt_unused_pkg";
            desc = "Invalid packets filter enable
- 0: disabled
- 1: enabled";
            sw = rw; hw = r;
            reset = 0x0;
        } crf_filt_unused_pkg[17:17];
        field {
            name = "crf_bm_flow_ctrl";
            desc = "Multicast/broadcast packet flow control enable
- 0: disabled
- 1: enabled";
            sw = rw; hw = r;
            reset = 0x0;
        } crf_bm_flow_ctrl[16:16];
        field {
            name = "crf_peel_dsa";
            desc = "DA/SA stripping control enable
- 0: disabled
- 1: enabled";
            sw = rw; hw = r;
            reset = 0x0;
        } crf_peel_dsa[15:15];
        field {
            name = "crf_add_da_sa";
            desc = "DA/SA addition control enable
- 0: disabled
- 1: enable";
            sw = rw; hw = r;
            reset = 0x0;
        } crf_add_da_sa[14:14];
        field {
            name = "crf_large_packet";
            desc = "Maximum length configured for packets. The default length is 1600 bytes (maximum length of packets used by the PMU).";
            sw = rw; hw = r;
            reset = 0x640;
        } crf_large_packet[13:0];
    } CONTROL_WORD @ 0x214;
    reg {
        name = "FLOW_CTRL_PKG_THRSLD";
        desc = "FLOW_CTRL_PKG_THRSLD is a flow control packet number threshold register. (offset 0x218; total reset 0xFFFFFFFF; PROVEN: Hi3521A/Hi3520D V300 data sheet (Issue 00B07, 2015-12-10), section 5.7, PDF page 1036).";
        field {
            name = "crf_ip_pkg_thrsld";
            desc = "Upper threshold of the number of IP packets. When the number of IP packets that are received within period T exceeds the configured value, the flow is controlled. Otherwise, the flow is not controlled.";
            sw = rw; hw = r;
            reset = 0xffff;
        } crf_ip_pkg_thrsld[31:16];
        field {
            name = "crf_ctrl_pkg_thrsld";
            desc = "Upper threshold of the number of control packets. When the number of control packets that are received within period T exceeds the configured value, the flow is controlled. Otherwise, the flow is not controlled.";
            sw = rw; hw = r;
            reset = 0xffff;
        } crf_ctrl_pkg_thrsld[15:0];
    } FLOW_CTRL_PKG_THRSLD @ 0x218;
    reg {
        name = "CRF_FLOW_TIME_THRSLD";
        desc = "CRF_FLOW_TIME_THRSLD is a flow control time register. (offset 0x21C; total reset 0x000000FF; PROVEN: Hi3521A/Hi3520D V300 data sheet (Issue 00B07, 2015-12-10), section 5.7, PDF page 1036).";
        field {
            name = "reserved";
            desc = "Reserved";
            sw = r; hw = w;
            reset = 0x0;
        } reserved_31_8[31:8];
        field {
            name = "crf_flow_time_thrsld";
            desc = "Flow control time, measured by 125 µs Flow control time T = (crf_flow_time_thrsld + 1) x 125 µs";
            sw = rw; hw = r;
            reset = 0xff;
        } crf_flow_time_thrsld[7:0];
    } CRF_FLOW_TIME_THRSLD @ 0x21C;
    reg FILTER_LISTm_t {
        name = "FILTER_LISTm";
        desc = "FILTER_LISTm (m ranging from 0 to 15) is a filter list register. (offset 0x220, 16 instances at stride 0x4; total reset 0x00000000; PROVEN: Hi3521A/Hi3520D V300 data sheet (Issue 00B07, 2015-12-10), section 5.7, PDF page 1037).";
        field {
            name = "reserved";
            desc = "Reserved";
            sw = r; hw = w;
            reset = 0x0;
        } reserved_31_18[31:18];
        field {
            name = "crf_filt_cfg0";
            desc = "Configured row or not
- 0: not configured
- 1: configured

The content of this list needs to be parsed only when crf_filt_cfg is set to 1. Otherwise, the content of this list can be ignored.";
            sw = rw; hw = r;
            reset = 0x0;
        } crf_filt_cfg0[17:17];
        field {
            name = "crf_filt_id0";
            desc = "Type of the list
- 0: MAC frame
- 1: IP";
            sw = rw; hw = r;
            reset = 0x0;
        } crf_filt_id0[16:16];
        field {
            name = "crf_filt_frm_type0";
            desc = "Configured filter type When the ID is 0, 16 bits of crf_filt_frm_type are valid. When the ID is 1, the lower 8 bits of crf_filt_frm_type are valid, and the upper 8 bits are ignored.";
            sw = rw; hw = r;
            reset = 0x0;
        } crf_filt_frm_type0[15:0];
    };
    FILTER_LISTm_t FILTER_LIST0 @ 0x220;
    FILTER_LISTm_t FILTER_LIST1 @ 0x224;
    FILTER_LISTm_t FILTER_LIST2 @ 0x228;
    FILTER_LISTm_t FILTER_LIST3 @ 0x22C;
    FILTER_LISTm_t FILTER_LIST4 @ 0x230;
    FILTER_LISTm_t FILTER_LIST5 @ 0x234;
    FILTER_LISTm_t FILTER_LIST6 @ 0x238;
    FILTER_LISTm_t FILTER_LIST7 @ 0x23C;
    FILTER_LISTm_t FILTER_LIST8 @ 0x240;
    FILTER_LISTm_t FILTER_LIST9 @ 0x244;
    FILTER_LISTm_t FILTER_LIST10 @ 0x248;
    FILTER_LISTm_t FILTER_LIST11 @ 0x24C;
    FILTER_LISTm_t FILTER_LIST12 @ 0x250;
    FILTER_LISTm_t FILTER_LIST13 @ 0x254;
    FILTER_LISTm_t FILTER_LIST14 @ 0x258;
    FILTER_LISTm_t FILTER_LIST15 @ 0x25C;
    reg {
        name = "CRF_UDP_NO";
        desc = "CRF_UDP_NO is a UDP port number register. (offset 0x260; total reset 0xFFFF0000; PROVEN: Hi3521A/Hi3520D V300 data sheet (Issue 00B07, 2015-12-10), section 5.7, PDF page 1038).";
        field {
            name = "crf_udp_max_no";
            desc = "Maximum number of the UDP ports";
            sw = rw; hw = r;
            reset = 0xffff;
        } crf_udp_max_no[31:16];
        field {
            name = "reserved";
            desc = "Reserved";
            sw = r; hw = w;
            reset = 0x0;
        } reserved_15_0[15:0];
    } CRF_UDP_NO @ 0x260;
    reg {
        name = "CRF_TX_FIFO_THRSLD";
        desc = "CRF_TX_FIFO_THRSLD is a TX FIFO threshold register. (offset 0x264; total reset 0x0271017C; PROVEN: Hi3521A/Hi3520D V300 data sheet (Issue 00B07, 2015-12-10), section 5.7, PDF page 1038).";
        field {
            name = "reserved";
            desc = "Reserved";
            sw = r; hw = w;
            reset = 0x0;
        } reserved_31_27[31:27];
        field {
            name = "crf_tx_p_full_th";
            desc = "Upper threshold of the TX FIFO When the number of valid data packets in the TX FIFO quadruples crf_tx_p_full_th, packets are not transferred from the SDRAM. After the threshold is set, the TX FIFO has sufficient space to receive a packet with the longest frame. The maximum frame length of the packet can be set in CONTROL_WORD bit[13:0] and must meet the following formula: CONTROL_WORD bit[13:0] < 8192 - 4(crf_tx_p_full_th)";
            sw = rw; hw = r;
            reset = 0x271;
        } crf_tx_p_full_th[26:16];
        field {
            name = "reserved";
            desc = "Reserved";
            sw = r; hw = w;
            reset = 0x0;
        } reserved_15_11[15:11];
        field {
            name = "crf_tx_p_empty_th";
            desc = "Lower threshold of the TX FIFO When the number of valid data packets in the TX FIFO quadruples crf_tx_p_full_th, data can be read from the FX FIFO. It is recommended that this threshold be set to 0x14.";
            sw = rw; hw = r;
            reset = 0x17c;
        } crf_tx_p_empty_th[10:0];
    } CRF_TX_FIFO_THRSLD @ 0x264;
    reg {
        name = "CRF_RX_FIFO_THRSLD";
        desc = "CRF_RX_FIFO_THRSLD is an RX FIFO threshold register. (offset 0x268; total reset 0x0E100200; PROVEN: Hi3521A/Hi3520D V300 data sheet (Issue 00B07, 2015-12-10), section 5.7, PDF page 1039).";
        field {
            name = "reserved";
            desc = "Reserved";
            sw = r; hw = w;
            reset = 0x0;
        } reserved_31_28[31:28];
        field {
            name = "crf_rx_p_full_th";
            desc = "Upper threshold of the RX FIFO When the number of valid data packets in the RX FIFO quadruples crf_rx_p_full_th, new packets are not written to the RX FIFO. After the threshold is set, the RX FIFO has sufficient space to receive a packet with the longest frame. The maximum frame length of the packet can be set in CONTROL_WORD bit[13:0] and must meet the following formula: CONTROL_WORD[13:0] < (8192 - 4(crf_rx_p_full_th)";
            sw = rw; hw = r;
            reset = 0xe10;
        } crf_rx_p_full_th[27:16];
        field {
            name = "reserved";
            desc = "Reserved";
            sw = r; hw = w;
            reset = 0x0;
        } reserved_15_12[15:12];
        field {
            name = "crf_rx_p_empty_th";
            desc = "Lower threshold of the RX FIFO. When the number of valid data packets in the RX FIFO quadruples crf_rx_p_empty_th, data can be read from the RX FIFO. This threshold must be set to 0x200 at least.";
            sw = rw; hw = r;
            reset = 0x200;
        } crf_rx_p_empty_th[11:0];
    } CRF_RX_FIFO_THRSLD @ 0x268;
    reg {
        name = "ERR_GIVEN_PKG_CNT";
        desc = "ERR_GIVEN_PKG_CNT is a count register for dropped packets caused by the frame tailors marked as errors. (offset 0x280; total reset 0x00000000; PROVEN: Hi3521A/Hi3520D V300 data sheet (Issue 00B07, 2015-12-10), section 5.7, PDF page 1039).";
        field {
            name = "err_given_pkg_cnt";
            desc = "Count of dropped packets caused by the frame tailors marked as errors";
            sw = r; hw = w; onread = rclr;
            reset = 0x0;
        } err_given_pkg_cnt[31:0];
    } ERR_GIVEN_PKG_CNT @ 0x280;
    reg {
        name = "SHORT_ERR_PKT_CNT";
        desc = "SHORT_ERR_PKT_CNT is a short error packet count register. (offset 0x284; total reset 0x00000000; PROVEN: Hi3521A/Hi3520D V300 data sheet (Issue 00B07, 2015-12-10), section 5.7, PDF page 1040).";
        field {
            name = "short_err_pkt_cnt";
            desc = "Count of short error packets";
            sw = rw; hw = r;
            reset = 0x0;
        } short_err_pkt_cnt[31:0];
    } SHORT_ERR_PKT_CNT @ 0x284;
    reg {
        name = "ERR_FRM_TYPE_CNT";
        desc = "ERR_FRM_TYPE_CNT is a count register for dropped packets caused by the frame types not listed in the filter list. (offset 0x288; total reset 0x00000000; PROVEN: Hi3521A/Hi3520D V300 data sheet (Issue 00B07, 2015-12-10), section 5.7, PDF page 1040).";
        field {
            name = "err_frm_type_cnt";
            desc = "Count of dropped packets caused by the frame types not listed in the filter list";
            sw = r; hw = w; onread = rclr;
            reset = 0x0;
        } err_frm_type_cnt[31:0];
    } ERR_FRM_TYPE_CNT @ 0x288;
    reg {
        name = "ERR_IP_TYPE_CNT";
        desc = "ERR_IP_TYPE_CNT is a count register for dropped packets caused by the IP types not listed in the filter list. (offset 0x28C; total reset 0x00000000; PROVEN: Hi3521A/Hi3520D V300 data sheet (Issue 00B07, 2015-12-10), section 5.7, PDF page 1040).";
        field {
            name = "err_ip_type_cnt";
            desc = "Count of the dropped packets caused by the IP types not listed in the filter list";
            sw = r; hw = w; onread = rclr;
            reset = 0x0;
        } err_ip_type_cnt[31:0];
    } ERR_IP_TYPE_CNT @ 0x28C;
    reg {
        name = "ERR_UDP_CNT";
        desc = "ERR_UDP_CNT is a count register for filtered packets caused by UDP port numbers beyond the specified range. (offset 0x290; total reset 0x00000000; PROVEN: Hi3521A/Hi3520D V300 data sheet (Issue 00B07, 2015-12-10), section 5.7, PDF page 1041).";
        field {
            name = "err_udp_cnt";
            desc = "Count of filtered packets caused by UDP port numbers beyond the specified range";
            sw = r; hw = w; onread = rclr;
            reset = 0x0;
        } err_udp_cnt[31:0];
    } ERR_UDP_CNT @ 0x290;
    reg {
        name = "OVER_FLOW_CNT";
        desc = "OVER_FLOW_CNT is a count register for dropped packets caused by the full RX FIFO. (offset 0x294; total reset 0x00000000; PROVEN: Hi3521A/Hi3520D V300 data sheet (Issue 00B07, 2015-12-10), section 5.7, PDF page 1041).";
        field {
            name = "over_flow_cnt";
            desc = "Count of dropped packets caused by the full RX FIFO";
            sw = r; hw = w; onread = rclr;
            reset = 0x0;
        } over_flow_cnt[31:0];
    } OVER_FLOW_CNT @ 0x294;
    reg {
        name = "OVER_LENGTH_CNT";
        desc = "OVER_LENGTH_CNT is a count register for dropped packets whose size exceeds the upper threshold of the PMU. (offset 0x298; total reset 0x00000000; PROVEN: Hi3521A/Hi3520D V300 data sheet (Issue 00B07, 2015-12-10), section 5.7, PDF page 1041).";
        field {
            name = "over_length_cnt";
            desc = "Count of dropped packets whose size exceeds the upper threshold of the PMU";
            sw = r; hw = w; onread = rclr;
            reset = 0x0;
        } over_length_cnt[31:0];
    } OVER_LENGTH_CNT @ 0x298;
    reg {
        name = "RX_PAUSE_EN";
        desc = "RX_PAUSE_EN is a flow control frame enable register in the RX direction. (offset 0x2A4; total reset 0x00000000; PROVEN: Hi3521A/Hi3520D V300 data sheet (Issue 00B07, 2015-12-10), section 5.7, PDF page 1042).";
        field {
            name = "reserved";
            desc = "Reserved";
            sw = r; hw = w;
            reset = 0x0;
        } reserved_31_3[31:3];
        field {
            name = "rx_fifo_pause_en";
            desc = "rx_fifo flow control frame enable
- 0: disabled
- 1: enabled";
            sw = rw; hw = r;
            reset = 0x0;
        } rx_fifo_pause_en[2:2];
        field {
            name = "rx_bq_pause_en";
            desc = "rx_bq flow control frame enable
- 0: disabled
- 1: enabled";
            sw = rw; hw = r;
            reset = 0x0;
        } rx_bq_pause_en[1:1];
        field {
            name = "rx_fq_pause_en";
            desc = "rx_fq flow control frame enable
- 0: disabled
- 1: enabled";
            sw = rw; hw = r;
            reset = 0x0;
        } rx_fq_pause_en[0:0];
    } RX_PAUSE_EN @ 0x2A4;
    reg {
        name = "CRF_CFF_DATA_NUM";
        desc = "CRF_CFF_DATA_NUM is a configuration FIFO data count register. (offset 0x2A8; total reset 0x00000000; PROVEN: Hi3521A/Hi3520D V300 data sheet (Issue 00B07, 2015-12-10), section 5.7, PDF page 1042).";
        field {
            name = "crf_rx_cfg_num";
            desc = "Count of valid descriptors remained in the rx_fq FIFO";
            sw = rw; hw = r;
            reset = 0x0;
        } crf_rx_cfg_num[31:16];
        field {
            name = "crf_tx_cfg_num";
            desc = "Count of valid descriptors remained in the tx_bq FIFO";
            sw = rw; hw = r;
            reset = 0x0;
        } crf_tx_cfg_num[15:0];
    } CRF_CFF_DATA_NUM @ 0x2A8;
    reg {
        name = "FLOW_OUT_IP_CNT";
        desc = "FLOW_OUT_IP_CNT is a count register for dropped IP packets caused by flow control. (offset 0x2AC; total reset 0x00000000; PROVEN: Hi3521A/Hi3520D V300 data sheet (Issue 00B07, 2015-12-10), section 5.7, PDF page 1043).";
        field {
            name = "flow_out_ip_cnt";
            desc = "Count of dropped IP packets caused by flow control";
            sw = r; hw = w; onread = rclr;
            reset = 0x0;
        } flow_out_ip_cnt[31:0];
    } FLOW_OUT_IP_CNT @ 0x2AC;
    reg {
        name = "FLOW_OUT_CTRL_CNT";
        desc = "FLOW_OUT_CTRL_CNT is a count register for dropped control packets caused by flow control. (offset 0x2B0; total reset 0x00000000; PROVEN: Hi3521A/Hi3520D V300 data sheet (Issue 00B07, 2015-12-10), section 5.7, PDF page 1043).";
        field {
            name = "flow_out_ctrl_cnt";
            desc = "Count of dropped control packets caused by flow control";
            sw = r; hw = w; onread = rclr;
            reset = 0x0;
        } flow_out_ctrl_cnt[31:0];
    } FLOW_OUT_CTRL_CNT @ 0x2B0;
    reg {
        name = "CRF_TX_PAUSE";
        desc = "CRF_TX_PAUSE is a TX flow control frame control register. (offset 0x340; total reset 0x00000000; PROVEN: Hi3521A/Hi3520D V300 data sheet (Issue 00B07, 2015-12-10), section 5.7, PDF page 1044).";
        field {
            name = "reserved";
            desc = "Reserved";
            sw = r; hw = w;
            reset = 0x0;
        } reserved_31_1[31:1];
        field {
            name = "crf_tx_pause_auto";
            desc = "Flow control frame control register, specifying the way in which the MAC transmits flow control frames
- 0: The MAC determines whether to transmit flow control frames according to the actual traffic. When the RX FIFO of the PMU is full or to be full, the MAC transmits flow control frames automatically.
- 1: The MAC is forced to transmit flow control frames.";
            sw = rw; hw = r;
            reset = 0x0;
        } crf_tx_pause_auto[0:0];
    } CRF_TX_PAUSE @ 0x340;
    reg {
        name = "CRF_RX_LEFT_NUM";
        desc = "CRF_RX_LEFT_NUM is a flow control RX address count register. (offset 0x344; total reset 0x0000000A; PROVEN: Hi3521A/Hi3520D V300 data sheet (Issue 00B07, 2015-12-10), section 5.7, PDF page 1044).";
        field {
            name = "reserved";
            desc = "Reserved";
            sw = r; hw = w;
            reset = 0x0;
        } reserved_31_8[31:8];
        field {
            name = "crf_rx_left_num";
            desc = "When the remaining count of addresses in the RX configuration FIFO is less than the configured value, the control packets are allowed to pass only. The data packets are filtered out.";
            sw = rw; hw = r;
            reset = 0xa;
        } crf_rx_left_num[7:0];
    } CRF_RX_LEFT_NUM @ 0x344;
    reg {
        name = "CRF_CTRL_0_TYPE";
        desc = "CRF_CTRL_0_TYPE is a control packet type 0 register. (offset 0x348; total reset 0x00000000; PROVEN: Hi3521A/Hi3520D V300 data sheet (Issue 00B07, 2015-12-10), section 5.7, PDF page 1045).";
        field {
            name = "reserved";
            desc = "Reserved";
            sw = r; hw = w;
            reset = 0x0;
        } reserved_31_16[31:16];
        field {
            name = "crf_ctrl_0_type";
            desc = "Control packet type 0. When the frame type of an RX packet matches the configured type, the RX packet is the control packet.";
            sw = r; hw = w;
            reset = 0x0;
        } crf_ctrl_0_type[15:0];
    } CRF_CTRL_0_TYPE @ 0x348;
    reg {
        name = "CRF_CTRL_1_TYPE";
        desc = "CRF_CTRL_1_TYPE is a control packet type 1 register. (offset 0x34C; total reset 0x00000000; PROVEN: Hi3521A/Hi3520D V300 data sheet (Issue 00B07, 2015-12-10), section 5.7, PDF page 1045).";
        field {
            name = "reserved";
            desc = "Reserved";
            sw = r; hw = w;
            reset = 0x0;
        } reserved_31_16[31:16];
        field {
            name = "crf_ctrl_1_type";
            desc = "Control packet type 1. When the frame type of an RX packet matches the configured type, the RX packet is the control packet.";
            sw = r; hw = w;
            reset = 0x0;
        } crf_ctrl_1_type[15:0];
    } CRF_CTRL_1_TYPE @ 0x34C;
    reg {
        name = "CRF_CTRL_2_TYPE";
        desc = "CRF_CTRL_2_TYPE is a control packet type 2 register. (offset 0x350; total reset 0x00000000; PROVEN: Hi3521A/Hi3520D V300 data sheet (Issue 00B07, 2015-12-10), section 5.7, PDF page 1046).";
        field {
            name = "reserved";
            desc = "Reserved";
            sw = r; hw = w;
            reset = 0x0;
        } reserved_31_16[31:16];
        field {
            name = "crf_ctrl_2_type";
            desc = "Control packet type 2. When the frame type of an RX packet matches the configured type, the RX packet is the control packet.";
            sw = r; hw = w;
            reset = 0x0;
        } crf_ctrl_2_type[15:0];
    } CRF_CTRL_2_TYPE @ 0x350;
    reg {
        name = "CRF_CTRL_3_TYPE";
        desc = "CRF_CTRL_3_TYPE is a control packet type 3 register. (offset 0x354; total reset 0x00000000; PROVEN: Hi3521A/Hi3520D V300 data sheet (Issue 00B07, 2015-12-10), section 5.7, PDF page 1046).";
        field {
            name = "reserved";
            desc = "Reserved";
            sw = r; hw = w;
            reset = 0x0;
        } reserved_31_16[31:16];
        field {
            name = "crf_ctrl_3_type";
            desc = "Control packet type 3. When the frame type of an RX packet matches the configured type, the RX packet is the control packet.";
            sw = rw; hw = r;
            reset = 0x0;
        } crf_ctrl_3_type[15:0];
    } CRF_CTRL_3_TYPE @ 0x354;
    reg {
        name = "CRF_BM_PKT_THRSLD";
        desc = "CRF_BM_PKT_THRSLD is a count threshold register for broadcast/multicast packets under flow control. (offset 0x358; total reset 0x00000001; PROVEN: Hi3521A/Hi3520D V300 data sheet (Issue 00B07, 2015-12-10), section 5.7, PDF page 1046).";
        field {
            name = "reserved";
            desc = "Reserved";
            sw = r; hw = w;
            reset = 0x0;
        } reserved_31_16[31:16];
        field {
            name = "crf_bm_pkt_thrsld";
            desc = "Upper threshold of the number of broadcast/multicast packets under flow control. When the number of broadcast/multicast packets that are received during the flow control time exceeds the configured value, the flow is controlled; otherwise, the flow is not controlled.";
            sw = rw; hw = r;
            reset = 0x1;
        } crf_bm_pkt_thrsld[15:0];
    } CRF_BM_PKT_THRSLD @ 0x358;
    reg {
        name = "CRF_BM_TIME_THRSLD";
        desc = "CRF_BM_TIME_THRSLD is a flow control time threshold register for broadcast and multicast packets. (offset 0x35C; total reset 0x00002710; PROVEN: Hi3521A/Hi3520D V300 data sheet (Issue 00B07, 2015-12-10), section 5.7, PDF page 1047).";
        field {
            name = "reserved";
            desc = "Reserved";
            sw = r; hw = w;
            reset = 0x0;
        } reserved_31_20[31:20];
        field {
            name = "crf_bm_time_thrsld";
            desc = "Flow control time threshold for broadcast and multicast packets, measured by 1 µs. When the count equals the configured threshold, a time limit is reached.";
            sw = rw; hw = r;
            reset = 0x2710;
        } crf_bm_time_thrsld[19:0];
    } CRF_BM_TIME_THRSLD @ 0x35C;
    reg {
        name = "MDIO_SINGLE_CMD";
        desc = "MDIO_SINGLE_CMD is an MDIO single operation register. (offset 0x3C0; total reset 0x00000000; PROVEN: Hi3521A/Hi3520D V300 data sheet (Issue 00B07, 2015-12-10), section 5.7, PDF page 1047).";
        field {
            name = "reserved";
            desc = "Reserved";
            sw = r; hw = w;
            reset = 0x0;
        } reserved_31_21[31:21];
        field {
            name = "mdio_cmd";
            desc = "Operation completion through the MDIO indicator
- 0: The operation through the MDIO is complete.
- 1: The operation through the MDIO starts.";
            sw = rw; hw = r;
            reset = 0x0;
        } mdio_cmd[20:20];
        field {
            name = "reserved";
            desc = "Reserved";
            sw = r; hw = w;
            reset = 0x0;
        } reserved_19_18[19:18];
        field {
            name = "op_code";
            desc = "MDIO operation type
- 00: Reserved
- 01: Write
- 10: Read
- 11: Reserved";
            sw = rw; hw = r;
            reset = 0x0;
        } op_code[17:16];
        field {
            name = "reserved";
            desc = "Reserved";
            sw = r; hw = w;
            reset = 0x0;
        } reserved_15_13[15:13];
        field {
            name = "phy_addr";
            desc = "5 bits of the external PHY address";
            sw = rw; hw = r;
            reset = 0x0;
        } phy_addr[12:8];
        field {
            name = "reserved";
            desc = "Reserved";
            sw = r; hw = w;
            reset = 0x0;
        } reserved_7_5[7:5];
        field {
            name = "reg_addr";
            desc = "Internal address of the PHY component";
            sw = rw; hw = r;
            reset = 0x0;
        } reg_addr[4:0];
    } MDIO_SINGLE_CMD @ 0x3C0;
    reg {
        name = "MDIO_SINGLE_DATA";
        desc = "MDIO_SINGLE_DATA is an MDIO read/write data register. (offset 0x3C4; total reset 0x00000000; PROVEN: Hi3521A/Hi3520D V300 data sheet (Issue 00B07, 2015-12-10), section 5.7, PDF page 1048).";
        field {
            name = "mdio_rd_data";
            desc = "Data that is read back from the external PHY through the MDIO";
            sw = r; hw = w;
            reset = 0x0;
        } mdio_rd_data[31:16];
        field {
            name = "mdio_wr_data";
            desc = "Data that is written through the MDIO";
            sw = rw; hw = r;
            reset = 0x0;
        } mdio_wr_data[15:0];
    } MDIO_SINGLE_DATA @ 0x3C4;
    reg {
        name = "MDIO_CTL";
        desc = "MDIO_CTL is an MDIO control register. (offset 0x3CC; total reset 0x00000000; PROVEN: Hi3521A/Hi3520D V300 data sheet (Issue 00B07, 2015-12-10), section 5.7, PDF page 1049).";
        field {
            name = "reserved";
            desc = "Reserved";
            sw = r; hw = w;
            reset = 0x0;
        } reserved_31_4[31:4];
        field {
            name = "mdio_in_work";
            desc = "Single operation through the MDIO indicator
- 0: The single operation is not performed.
- 1: The single operation is performed.";
            sw = r; hw = w;
            reset = 0x0;
        } mdio_in_work[3:3];
        field {
            name = "mdio_in_work_en";
            desc = "MDIO_IN_WORK bit validity indicator
- 0: The MDIO_IN_WORK bit is invalid.
- 1: The MDIO_IN_WORK bit is valid.";
            sw = rw; hw = r;
            reset = 0x0;
        } mdio_in_work_en[2:2];
        field {
            name = "autoscan_en";
            desc = "Automatic detection enable
- 0: disabled
- 1: enabled (It controls the automatic scanning enable for all the

PHY addresses. The value can be set to 1 because there is only one PHY currently.)";
            sw = rw; hw = r;
            reset = 0x0;
        } autoscan_en[1:1];
        field {
            name = "mdc_speed";
            desc = "Frequency of the MDIO interface clock
- 0: The frequency of the MDIO interface clock is 2.5 MHz.
- 1: The frequency of the MDIO interface clock is 18 MHz.";
            sw = rw; hw = r;
            reset = 0x0;
        } mdc_speed[0:0];
    } MDIO_CTL @ 0x3CC;
    reg {
        name = "MDIO_RDATA_STATUS";
        desc = "MDIO_RDATA_STATUS is an MDIO read data status register. (offset 0x3D0; total reset 0x00000000; PROVEN: Hi3521A/Hi3520D V300 data sheet (Issue 00B07, 2015-12-10), section 5.7, PDF page 1050).";
        field {
            name = "reserved";
            desc = "Reserved";
            sw = r; hw = w;
            reset = 0x0;
        } reserved_31_1[31:1];
        field {
            name = "mdio_rdata_status";
            desc = "Whether the data read by the MDIO is valid
- 0: valid
- 1: invalid";
            sw = r; hw = w; onread = rclr;
            reset = 0x0;
        } mdio_rdata_status[0:0];
    } MDIO_RDATA_STATUS @ 0x3D0;
    reg {
        name = "RX_FQ_START_ADDR";
        desc = "RX_FQ_START_ADDR is a start address register for the idle descriptor queue. (offset 0x500; total reset 0x00000000; PROVEN: Hi3521A/Hi3520D V300 data sheet (Issue 00B07, 2015-12-10), section 5.7, PDF page 1050).";
        field {
            name = "fq_start_addr";
            desc = "Start address of the idle descriptor queue. When rx_fq_start_addr_en of the RX_FQ_REG_EN register is set to 1, the register can be read and written. When rx_fq_start_addr_en is set to 0, the register is read-only. Only word addresses are supported.";
            sw = rw; hw = r;
            reset = 0x0;
        } fq_start_addr[31:0];
    } RX_FQ_START_ADDR @ 0x500;
    reg {
        name = "RX_FQ_DEPTH";
        desc = "RX_FQ_DEPTH is a depth register for the idle descriptor queue. (offset 0x504; total reset 0x00000400; PROVEN: Hi3521A/Hi3520D V300 data sheet (Issue 00B07, 2015-12-10), section 5.7, PDF page 1051).";
        field {
            name = "reserved";
            desc = "Reserved";
            sw = r; hw = w;
            reset = 0x0;
        } reserved_31_19[31:19];
        field {
            name = "fq_depth";
            desc = "Depth of the idle descriptor queue in the RX direction. It indicates the number of words, not the number of descriptors. When rx_fq_depth_en of the RX_FQ_REG_EN register is set to 1, the register can be read and written. When rx_fq_depth_en is set to 0, the register is read-only. The depth must be set to an integral multiple of 8. It is recommended that this field be set to at least 0x400.";
            sw = rw; hw = r;
            reset = 0x400;
        } fq_depth[18:0];
    } RX_FQ_DEPTH @ 0x504;
    reg {
        name = "RX_FQ_WR_ADDR";
        desc = "RX_FQ_WR_ADDR is a write address register for the idle descriptor queue. (offset 0x508; total reset 0x00000000; PROVEN: Hi3521A/Hi3520D V300 data sheet (Issue 00B07, 2015-12-10), section 5.7, PDF page 1051).";
        field {
            name = "reserved";
            desc = "Reserved";
            sw = r; hw = w;
            reset = 0x0;
        } reserved_31_21[31:21];
        field {
            name = "fq_wr_addr";
            desc = "Write address of the idle descriptor queue in the RX direction.";
            sw = rw; hw = r;
            reset = 0x0;
        } fq_wr_addr[20:0];
    } RX_FQ_WR_ADDR @ 0x508;
    reg {
        name = "RX_FQ_RD_ADDR";
        desc = "RX_FQ_WR_ADDR is a read address register for the idle descriptor queue. (offset 0x50C; total reset 0x00000000; PROVEN: Hi3521A/Hi3520D V300 data sheet (Issue 00B07, 2015-12-10), section 5.7, PDF page 1052).";
        field {
            name = "reserved";
            desc = "Reserved";
            sw = r; hw = w;
            reset = 0x0;
        } reserved_31_21[31:21];
        field {
            name = "fq_rd_addr";
            desc = "Read address of the idle descriptor queue in the RX direction. When rx_fq_rd_addr_en of the RX_FQ_REG_EN register is set to 1, the register can be read and written. When rx_fq_rd_addr_en is set to 0, the register is read-only.";
            sw = rw; hw = r;
            reset = 0x0;
        } fq_rd_addr[20:0];
    } RX_FQ_RD_ADDR @ 0x50C;
    reg {
        name = "RX_FQ_VLDDESC_CNT";
        desc = "RX_FQ_VLDDESC_CNT is a valid descriptor number register for the idle descriptor queue. (offset 0x510; total reset 0x00000000; PROVEN: Hi3521A/Hi3520D V300 data sheet (Issue 00B07, 2015-12-10), section 5.7, PDF page 1052).";
        field {
            name = "reserved";
            desc = "Reserved";
            sw = r; hw = w;
            reset = 0x0;
        } reserved_31_16[31:16];
        field {
            name = "fq_vlddesc_cnt";
            desc = "Count of valid descriptors in the idle descriptor queue in the RX direction";
            sw = r; hw = w;
            reset = 0x0;
        } fq_vlddesc_cnt[15:0];
    } RX_FQ_VLDDESC_CNT @ 0x510;
    reg {
        name = "RX_FQ_ALRMPTY_TH";
        desc = "RX_FQ_ALRMPTY_TH is an almost-empty threshold register for the idle descriptor queue. (offset 0x514; total reset 0x00100010; PROVEN: Hi3521A/Hi3520D V300 data sheet (Issue 00B07, 2015-12-10), section 5.7, PDF page 1053).";
        field {
            name = "fq_pause_low_th";
            desc = "Lower flow control threshold of the rx_fq queue. If the count of valid descriptors is less than or equal to the value of fq_pause_low_th, a signal for sending flow control frames is generated.";
            sw = rw; hw = r;
            reset = 0x10;
        } fq_pause_low_th[31:16];
        field {
            name = "fq_alempty_th";
            desc = "Almost-empty threshold of the idle descriptor queue in the RX direction";
            sw = rw; hw = r;
            reset = 0x10;
        } fq_alempty_th[15:0];
    } RX_FQ_ALRMPTY_TH @ 0x514;
    reg {
        name = "RX_FQ_REG_EN";
        desc = "RX_FQ_REG_EN is an enable register related to the idle descriptor queue in the RX direction. (offset 0x518; total reset 0x00000000; PROVEN: Hi3521A/Hi3520D V300 data sheet (Issue 00B07, 2015-12-10), section 5.7, PDF page 1053).";
        field {
            name = "reserved";
            desc = "Reserved";
            sw = r; hw = w;
            reset = 0x0;
        } reserved_31_3[31:3];
        field {
            name = "rx_fq_start_addr_en";
            desc = "Software write enable for the RX_FQ_START_ADDR register
- 0: The RX_FQ_START_ADDR register is protected, and software cannot be written.
- 1: Software of the RX_FQ_START_ADDR register can be written.";
            sw = rw; hw = r;
            reset = 0x0;
        } rx_fq_start_addr_en[2:2];
        field {
            name = "rx_fq_depth_en";
            desc = "Software write enable for the RX_FQ_DEPTH register
- 0: The RX_FQ_DEPTH register is protected, and software cannot be written.
- 1: Software of the RX_FQ_DEPTH register can be written.";
            sw = rw; hw = r;
            reset = 0x0;
        } rx_fq_depth_en[1:1];
        field {
            name = "rx_fq_rd_addr_en";
            desc = "Software write enable for the RX_FQ read address register
- 0: The RX_FQ read address register is protected, and software cannot be written.
- 1: Software of the RX_FQ read address register can be written.";
            sw = rw; hw = r;
            reset = 0x0;
        } rx_fq_rd_addr_en[0:0];
    } RX_FQ_REG_EN @ 0x518;
    reg {
        name = "RX_FQ_ALFULL_TH";
        desc = "RX_FQ_ALFULL_TH is an almost-full threshold register for the idle descriptor queue. (offset 0x51C; total reset 0x00100010; PROVEN: Hi3521A/Hi3520D V300 data sheet (Issue 00B07, 2015-12-10), section 5.7, PDF page 1054).";
        field {
            name = "fq_pause_hi_th";
            desc = "Upper flow control threshold for the rx_fq queue. If the count of valid descriptors is greater than or equal to the value of fq_pause_hi_th, a signal for sending flow control frames is set to 0, indicating that the flow control frames are not transmitted.";
            sw = rw; hw = r;
            reset = 0x10;
        } fq_pause_hi_th[31:16];
        field {
            name = "fq_alfull_th";
            desc = "Almost-full threshold of the idle descriptor queue in the RX direction";
            sw = rw; hw = r;
            reset = 0x10;
        } fq_alfull_th[15:0];
    } RX_FQ_ALFULL_TH @ 0x51C;
    reg {
        name = "RX_BQ_START_ADDR";
        desc = "RX_BQ_START_ADDR is a start address register for the rx_buff descriptor queue. (offset 0x520; total reset 0x00000000; PROVEN: Hi3521A/Hi3520D V300 data sheet (Issue 00B07, 2015-12-10), section 5.7, PDF page 1055).";
        field {
            name = "rx_bq_start_addr";
            desc = "Start address of the buff descriptor queue in the RX direction. When rx_bq_start_addr_en in the RX_BQ_REG_EN register is set to 1, the register can be read and written. When rx_bq_start_addr_en is set to 0, the register is read-only. Only word addresses are supported.";
            sw = rw; hw = r;
            reset = 0x0;
        } rx_bq_start_addr[31:0];
    } RX_BQ_START_ADDR @ 0x520;
    reg {
        name = "RX_BQ_DEPTH";
        desc = "RX_BQ_DEPTH is a depth register for the rx_buff descriptor queue. (offset 0x524; total reset 0x00000400; PROVEN: Hi3521A/Hi3520D V300 data sheet (Issue 00B07, 2015-12-10), section 5.7, PDF page 1055).";
        field {
            name = "reserved";
            desc = "Reserved";
            sw = r; hw = w;
            reset = 0x0;
        } reserved_31_19[31:19];
        field {
            name = "rx_bq_depth";
            desc = "Depth of the buff descriptor queue in the RX direction. It indicates the number of words, not the number of descriptors. When rx_bq_depth_en of the RX_BQ_REG_EN register is set to 1, the register can be read and written. When rx_bq_depth_en is set to 0, the register is read-only. The depth must be set to an integral multiple of 8. It is recommended that this field be set to at least 0x400.";
            sw = rw; hw = r;
            reset = 0x400;
        } rx_bq_depth[18:0];
    } RX_BQ_DEPTH @ 0x524;
    reg {
        name = "RX_BQ_WR_ADDR";
        desc = "RX_BQ_WR_ADDR is a write address register for the rx_buff descriptor queue. (offset 0x528; total reset 0x00000000; PROVEN: Hi3521A/Hi3520D V300 data sheet (Issue 00B07, 2015-12-10), section 5.7, PDF page 1056).";
        field {
            name = "reserved";
            desc = "Reserved";
            sw = r; hw = w;
            reset = 0x0;
        } reserved_31_21[31:21];
        field {
            name = "rx_bq_wr_addr";
            desc = "Write address of the buff descriptor queue in the RX direction. When rx_bq_wr_addr_en of the RX_BQ_REG_EN register is set to 1, the register can be read and written. When rx_bq_wr_addr_en is set to 0, the register is read-only.";
            sw = rw; hw = r;
            reset = 0x0;
        } rx_bq_wr_addr[20:0];
    } RX_BQ_WR_ADDR @ 0x528;
    reg {
        name = "RX_BQ_RD_ADDR";
        desc = "RX_BQ_RD_ADDR is a read address register for the rx_buff descriptor queue. (offset 0x52C; total reset 0x00000000; PROVEN: Hi3521A/Hi3520D V300 data sheet (Issue 00B07, 2015-12-10), section 5.7, PDF page 1056).";
        field {
            name = "reserved";
            desc = "Reserved";
            sw = r; hw = w;
            reset = 0x0;
        } reserved_31_21[31:21];
        field {
            name = "rx_bq_rd_addr";
            desc = "Read address of the buff descriptor queue in the RX direction";
            sw = rw; hw = r;
            reset = 0x0;
        } rx_bq_rd_addr[20:0];
    } RX_BQ_RD_ADDR @ 0x52C;
    reg {
        name = "RX_BQ_FREE_DESC_CNT";
        desc = "RX_BQ_FREE_DESC_CNT is a writable descriptor count register for the rx_buff descriptor queue. (offset 0x530; total reset 0x00000080; PROVEN: Hi3521A/Hi3520D V300 data sheet (Issue 00B07, 2015-12-10), section 5.7, PDF page 1057).";
        field {
            name = "reserved";
            desc = "Reserved";
            sw = r; hw = w;
            reset = 0x0;
        } reserved_31_16[31:16];
        field {
            name = "rx_bq_free_desc_cnt";
            desc = "Count of writable descriptors in the buff descriptor queue in the RX direction";
            sw = rw; hw = r;
            reset = 0x80;
        } rx_bq_free_desc_cnt[15:0];
    } RX_BQ_FREE_DESC_CNT @ 0x530;
    reg {
        name = "RX_BQ_ALEMPTY_TH";
        desc = "RX_BQ_ALEMPTY_TH is an almost-empty threshold register for the rx_buff descriptor queue. (offset 0x534; total reset 0x00100010; PROVEN: Hi3521A/Hi3520D V300 data sheet (Issue 00B07, 2015-12-10), section 5.7, PDF page 1057).";
        field {
            name = "rx_bq_pause_low_th";
            desc = "Flow control threshold of the rx_bq queue. If the count of writable descriptors is less than or equal to the value of bq_pause_low_th, an indicator for sending flow control frames is generated.";
            sw = rw; hw = r;
            reset = 0x10;
        } rx_bq_pause_low_th[31:16];
        field {
            name = "rx_bq_alempty_th";
            desc = "Almost-empty threshold of the buff descriptor queue in the RX direction";
            sw = rw; hw = r;
            reset = 0x10;
        } rx_bq_alempty_th[15:0];
    } RX_BQ_ALEMPTY_TH @ 0x534;
    reg {
        name = "RX_BQ_REG_EN";
        desc = "RX_BQ_REG_EN is an enable register related to the buff descriptor queue in the RX direction. (offset 0x538; total reset 0x00000000; PROVEN: Hi3521A/Hi3520D V300 data sheet (Issue 00B07, 2015-12-10), section 5.7, PDF page 1058).";
        field {
            name = "reserved";
            desc = "Reserved";
            sw = r; hw = w;
            reset = 0x0;
        } reserved_31_3[31:3];
        field {
            name = "rx_bq_start_addr_en";
            desc = "Software write enable for the RX_BQ_START_ADDR register
- 0: The RX_BQ_START_ADDR register is protected, and software cannot be written.
- 1: Software of the RX_BQ_START_ADDR register can be written.";
            sw = rw; hw = r;
            reset = 0x0;
        } rx_bq_start_addr_en[2:2];
        field {
            name = "rx_bq_depth_en";
            desc = "Software write enable for the RX_BQ_DEPTH register
- 0: The RX_BQ_DEPTH register is protected, and software cannot be written.
- 1: Software of the RX_BQ_DEPTH register can be written.";
            sw = rw; hw = r;
            reset = 0x0;
        } rx_bq_depth_en[1:1];
        field {
            name = "rx_bq_wr_addr_en";
            desc = "Software write enable for the RX_BQ write address register
- 0: The RX_BQ write address register is protected, and software cannot be written.
- 1: Software of the RX_BQ write address register can be written.";
            sw = rw; hw = r;
            reset = 0x0;
        } rx_bq_wr_addr_en[0:0];
    } RX_BQ_REG_EN @ 0x538;
    reg {
        name = "RX_BQ_ALFULL_TH";
        desc = "RX_BQ_ALFULL_TH is an almost-full threshold register for the rx_buff descriptor queue. (offset 0x53C; total reset 0x00100010; PROVEN: Hi3521A/Hi3520D V300 data sheet (Issue 00B07, 2015-12-10), section 5.7, PDF page 1059).";
        field {
            name = "rx_bq_pause_hi_th";
            desc = "Upper flow control threshold for the rx_bq queue. If the count of writable descriptors is greater than or equal to the value of bq_pause_hi_th, the indicator for sending flow control frames is set to 0, indicating that the flow control frames are not transmitted.";
            sw = rw; hw = r;
            reset = 0x10;
        } rx_bq_pause_hi_th[31:16];
        field {
            name = "rx_bq_alfull_th";
            desc = "Almost-full threshold of the buff descriptor queue in the RX direction";
            sw = rw; hw = r;
            reset = 0x10;
        } rx_bq_alfull_th[15:0];
    } RX_BQ_ALFULL_TH @ 0x53C;
    reg {
        name = "TX_BQ_START_ADDR";
        desc = "TX_BQ_START_ADDR is a start address register for the tx_buff descriptor queue. (offset 0x580; total reset 0x00000000; PROVEN: Hi3521A/Hi3520D V300 data sheet (Issue 00B07, 2015-12-10), section 5.7, PDF page 1059).";
        field {
            name = "tx_bq_start_addr";
            desc = "Start address of the buff descriptor queue in the TX direction. When tx_bq_start_addr_en in the TX_BQ_REG_EN register is set to 1, the register can be read and written. When tx_bq_start_addr_en is set to 0, the register is read-only. Only word addresses are supported.";
            sw = rw; hw = r;
            reset = 0x0;
        } tx_bq_start_addr[31:0];
    } TX_BQ_START_ADDR @ 0x580;
    reg {
        name = "TX_BQ_DEPTH";
        desc = "TX_BQ_DEPTH is a depth register for the tx_buff descriptor queue. (offset 0x584; total reset 0x00000400; PROVEN: Hi3521A/Hi3520D V300 data sheet (Issue 00B07, 2015-12-10), section 5.7, PDF page 1060).";
        field {
            name = "reserved";
            desc = "Reserved";
            sw = r; hw = w;
            reset = 0x0;
        } reserved_31_19[31:19];
        field {
            name = "tx_bq_depth";
            desc = "Depth of the buff descriptor queue in the TX direction. It indicates the number of words, not the number of descriptors. When tx_bq_depth_en of the TX_BQ_REG_EN register is set to 1, the register can be read and written. When tx_bq_depth_en is set to 0, the register is read-only. The depth must be set to an integral multiple of 8. It is recommended that this field be set to at least 0x400.";
            sw = rw; hw = r;
            reset = 0x400;
        } tx_bq_depth[18:0];
    } TX_BQ_DEPTH @ 0x584;
    reg {
        name = "TX_BQ_WR_ADDR";
        desc = "TX_BQ_WR_ADDR is a write address register for the tx_buff descriptor queue. (offset 0x588; total reset 0x00000000; PROVEN: Hi3521A/Hi3520D V300 data sheet (Issue 00B07, 2015-12-10), section 5.7, PDF page 1060).";
        field {
            name = "reserved";
            desc = "Reserved";
            sw = r; hw = w;
            reset = 0x0;
        } reserved_31_21[31:21];
        field {
            name = "tx_bq_wr_addr";
            desc = "Write address of the buff descriptor queue in the TX direction";
            sw = rw; hw = r;
            reset = 0x0;
        } tx_bq_wr_addr[20:0];
    } TX_BQ_WR_ADDR @ 0x588;
    reg {
        name = "TX_BQ_RD_ADDR";
        desc = "TX_BQ_RD_ADDR is a read address register for the tx_buff descriptor queue. (offset 0x58C; total reset 0x00000000; PROVEN: Hi3521A/Hi3520D V300 data sheet (Issue 00B07, 2015-12-10), section 5.7, PDF page 1061).";
        field {
            name = "reserved";
            desc = "Reserved";
            sw = r; hw = w;
            reset = 0x0;
        } reserved_31_21[31:21];
        field {
            name = "tx_bq_rd_addr";
            desc = "Read address of the buff descriptor queue in the TX direction. When rx_bq_rd_addr_en of the TX_BQ_REG_EN register is set to 1, the register can be read and written. When tx_bq_rd_addr_en is set to 0, the register is read-only.";
            sw = rw; hw = r;
            reset = 0x0;
        } tx_bq_rd_addr[20:0];
    } TX_BQ_RD_ADDR @ 0x58C;
    reg {
        name = "TX_BQ_VLDDESC_CNT";
        desc = "TX_BQ_VLDDESC_CNT is a valid descriptor number register for the tx_buff descriptor queue. (offset 0x590; total reset 0x00000000; PROVEN: Hi3521A/Hi3520D V300 data sheet (Issue 00B07, 2015-12-10), section 5.7, PDF page 1061).";
        field {
            name = "reserved";
            desc = "Reserved";
            sw = r; hw = w;
            reset = 0x0;
        } reserved_31_16[31:16];
        field {
            name = "tx_bq_vlddesc_cnt";
            desc = "Count of valid descriptors in the buff descriptor queue in the TX direction";
            sw = rw; hw = r;
            reset = 0x0;
        } tx_bq_vlddesc_cnt[15:0];
    } TX_BQ_VLDDESC_CNT @ 0x590;
    reg {
        name = "TX_BQ_ALEMPTY_TH";
        desc = "TX_BQ_ALEMPTY_TH is an almost-empty threshold register for the tx_buff descriptor queue. (offset 0x594; total reset 0x00000010; PROVEN: Hi3521A/Hi3520D V300 data sheet (Issue 00B07, 2015-12-10), section 5.7, PDF page 1062).";
        field {
            name = "reserved";
            desc = "Reserved";
            sw = r; hw = w;
            reset = 0x0;
        } reserved_31_16[31:16];
        field {
            name = "tx_bq_alempty_th";
            desc = "Almost-empty threshold of the buff descriptor queue in the TX direction";
            sw = rw; hw = r;
            reset = 0x10;
        } tx_bq_alempty_th[15:0];
    } TX_BQ_ALEMPTY_TH @ 0x594;
    reg {
        name = "TX_BQ_REG_EN";
        desc = "TX_BQ_REG_EN is an enable register related to the buff descriptor queue in the TX direction. (offset 0x598; total reset 0x00000000; PROVEN: Hi3521A/Hi3520D V300 data sheet (Issue 00B07, 2015-12-10), section 5.7, PDF page 1062).";
        field {
            name = "reserved";
            desc = "Reserved";
            sw = r; hw = w;
            reset = 0x0;
        } reserved_31_3[31:3];
        field {
            name = "tx_bq_start_addr_en";
            desc = "Software write enable for the TX_BQ_START_ADDR register
- 0: The TX_BQ_START_ADDR register is protected, and software cannot be written.
- 1: Software of the TX_BQ_START_ADDR register can be written.";
            sw = rw; hw = r;
            reset = 0x0;
        } tx_bq_start_addr_en[2:2];
        field {
            name = "tx_bq_depth_en";
            desc = "Software write enable for the TX_BQ_DEPTH register
- 0: The TX_BQ_DEPTH register is protected, and software cannot be written.
- 1: Software of the TX_BQ_DEPTH register can be written.";
            sw = rw; hw = r;
            reset = 0x0;
        } tx_bq_depth_en[1:1];
        field {
            name = "tx_bq_rd_addr_en";
            desc = "Software write enable for the TX_BQ read address register
- 0: The TX_BQ read address register is protected, and software cannot be written.
- 1: Software of the TX_BQ read address register can be written.";
            sw = rw; hw = r;
            reset = 0x0;
        } tx_bq_rd_addr_en[0:0];
    } TX_BQ_REG_EN @ 0x598;
    reg {
        name = "BQ1_ALFULL_TH";
        desc = "BQ1_ALFULL_TH is an almost-full threshold register for the buff1 descriptor queue. (offset 0x59C; total reset 0x00000000; PROVEN: Hi3521A/Hi3520D V300 data sheet (Issue 00B07, 2015-12-10), section 5.7, PDF page 1063).";
        field {
            name = "reserved";
            desc = "Reserved";
            sw = r; hw = w;
            reset = 0x0;
        } reserved_31_16[31:16];
        field {
            name = "bq1_alfull_th";
            desc = "Almost-full threshold of the buff1 descriptor queue in the TX direction";
            sw = rw; hw = r;
            reset = 0x0;
        } bq1_alfull_th[15:0];
    } BQ1_ALFULL_TH @ 0x59C;
    reg {
        name = "TX_RQ_START_ADDR";
        desc = "TX_RQ_START_ADDR is a start address register for the tx_rq descriptor queue. (offset 0x5A0; total reset 0x00000000; PROVEN: Hi3521A/Hi3520D V300 data sheet (Issue 00B07, 2015-12-10), section 5.7, PDF page 1063).";
        field {
            name = "tx_rq_start_addr";
            desc = "Start address of the recycle descriptor queue in the TX direction. When tx_rq_start_addr_en of the TX_RQ_REG_EN register is set to 1, the register can be read and written. When tx_rq_start_addr_en is set to 0, the register is read-only. Only word addresses are supported.";
            sw = rw; hw = r;
            reset = 0x0;
        } tx_rq_start_addr[31:0];
    } TX_RQ_START_ADDR @ 0x5A0;
    reg {
        name = "TX_RQ_DEPTH";
        desc = "TX_RQ_DEPTH is a depth register for the tx_rq descriptor queue. (offset 0x5A4; total reset 0x00000400; PROVEN: Hi3521A/Hi3520D V300 data sheet (Issue 00B07, 2015-12-10), section 5.7, PDF page 1064).";
        field {
            name = "reserved";
            desc = "Reserved";
            sw = r; hw = w;
            reset = 0x0;
        } reserved_31_19[31:19];
        field {
            name = "tx_rq_depth";
            desc = "Depth of the recycle descriptor queue in the TX direction. It indicates the number of words, not the number of descriptors. When tx_rq_depth_en of the TX_RQ_REG_EN register is set to 1, the register can be read and written. When tx_rq_depth_en is set to 0, the register is read-only. The depth must be set to an integral multiple of 8. It is recommended that this field be set to at least 0x400.";
            sw = rw; hw = r;
            reset = 0x400;
        } tx_rq_depth[18:0];
    } TX_RQ_DEPTH @ 0x5A4;
    reg {
        name = "TX_RQ_WR_ADDR";
        desc = "TX_RQ_WR_ADDR is a write address register for the tx_rq descriptor queue. (offset 0x5A8; total reset 0x00000000; PROVEN: Hi3521A/Hi3520D V300 data sheet (Issue 00B07, 2015-12-10), section 5.7, PDF page 1064).";
        field {
            name = "reserved";
            desc = "Reserved";
            sw = r; hw = w;
            reset = 0x0;
        } reserved_31_21[31:21];
        field {
            name = "tx_rq_wr_addr";
            desc = "Write address of the recycle descriptor queue in the TX direction. When tx_rq_wr_addr_en of the TX_RQ_REG_EN register is set to 1, the register can be read and written. When tx_rq_wr_addr_en is set to 0, the register is read-only.";
            sw = rw; hw = r;
            reset = 0x0;
        } tx_rq_wr_addr[20:0];
    } TX_RQ_WR_ADDR @ 0x5A8;
    reg {
        name = "TX_RQ_RD_ADDR";
        desc = "TX_RQ_RD_ADDR is a read address register for the tx_rq descriptor queue. (offset 0x5AC; total reset 0x00000000; PROVEN: Hi3521A/Hi3520D V300 data sheet (Issue 00B07, 2015-12-10), section 5.7, PDF page 1065).";
        field {
            name = "reserved";
            desc = "Reserved";
            sw = r; hw = w;
            reset = 0x0;
        } reserved_31_21[31:21];
        field {
            name = "tx_rq_rd_addr";
            desc = "Read address of the recycle descriptor queue in the TX direction.";
            sw = rw; hw = r;
            reset = 0x0;
        } tx_rq_rd_addr[20:0];
    } TX_RQ_RD_ADDR @ 0x5AC;
    reg {
        name = "TX_RQ_FREE_DESC_CNT";
        desc = "TX_RQ_FREE_DESC_CNT is a writable descriptor count register for the tx_rq descriptor queue. (offset 0x5B0; total reset 0x00000080; PROVEN: Hi3521A/Hi3520D V300 data sheet (Issue 00B07, 2015-12-10), section 5.7, PDF page 1065).";
        field {
            name = "reserved";
            desc = "Reserved";
            sw = r; hw = w;
            reset = 0x0;
        } reserved_31_16[31:16];
        field {
            name = "tx_rq_free_desc_cnt";
            desc = "Count of writable descriptors in the recycle descriptor queue in the TX direction";
            sw = rw; hw = r;
            reset = 0x80;
        } tx_rq_free_desc_cnt[15:0];
    } TX_RQ_FREE_DESC_CNT @ 0x5B0;
    reg {
        name = "TX_RQ_ALEMPTY_TH";
        desc = "TX_RQ_ALEMPTY_TH is an almost-empty threshold register for the tx_rq descriptor queue. (offset 0x5B4; total reset 0x00000010; PROVEN: Hi3521A/Hi3520D V300 data sheet (Issue 00B07, 2015-12-10), section 5.7, PDF page 1065).";
        field {
            name = "reserved";
            desc = "Reserved";
            sw = r; hw = w;
            reset = 0x0;
        } reserved_31_16[31:16];
        field {
            name = "tx_rq_alempty_th";
            desc = "Almost-empty threshold of the recycle descriptor queue in the TX direction";
            sw = rw; hw = r;
            reset = 0x10;
        } tx_rq_alempty_th[15:0];
    } TX_RQ_ALEMPTY_TH @ 0x5B4;
    reg {
        name = "TX_RQ_REG_EN";
        desc = "TX_RQ_REG_EN is an enable register related to the tx_rq descriptor queue (offset 0x5B8; total reset 0x00000000; PROVEN: Hi3521A/Hi3520D V300 data sheet (Issue 00B07, 2015-12-10), section 5.7, PDF page 1066).";
        field {
            name = "reserved";
            desc = "Reserved";
            sw = r; hw = w;
            reset = 0x0;
        } reserved_31_3[31:3];
        field {
            name = "tx_rq_start_addr_en";
            desc = "Software write enable for the TX_RQ_START_ADDR register
- 0: The TX_RQ_START_ADDR register is protected, and software cannot be written.
- 1: Software of the TX_RQ_START_ADDR register can be written.";
            sw = rw; hw = r;
            reset = 0x0;
        } tx_rq_start_addr_en[2:2];
        field {
            name = "tx_rq_depth_en";
            desc = "Software write enable for the TX_RQ_DEPTH register
- 0: The TX_RQ_DEPTH register is protected, and software cannot be written.
- 1: Software of the TX_RQ_DEPTH register can be written.";
            sw = rw; hw = r;
            reset = 0x0;
        } tx_rq_depth_en[1:1];
        field {
            name = "tx_rq_wr_addr_en";
            desc = "Software write enable for the TX_RQ write address register
- 0: The TX_RQ write address register is protected, and software cannot be written.
- 1: Software of the TX_RQ write address register can be written.";
            sw = rw; hw = r;
            reset = 0x0;
        } tx_rq_wr_addr_en[0:0];
    } TX_RQ_REG_EN @ 0x5B8;
    reg {
        name = "TX_RQ_ALFULL_TH";
        desc = "TX_RQ_ALFULL_TH is an almost-full threshold register for the tx_rq descriptor queue. (offset 0x5BC; total reset 0x00000010; PROVEN: Hi3521A/Hi3520D V300 data sheet (Issue 00B07, 2015-12-10), section 5.7, PDF page 1067).";
        field {
            name = "reserved";
            desc = "Reserved";
            sw = r; hw = w;
            reset = 0x0;
        } reserved_31_16[31:16];
        field {
            name = "tx_rq_alfull_th";
            desc = "Almost-full threshold of the recycle descriptor queue in the TX direction";
            sw = rw; hw = r;
            reset = 0x10;
        } tx_rq_alfull_th[15:0];
    } TX_RQ_ALFULL_TH @ 0x5BC;
    reg {
        name = "RAW_PMU_INT";
        desc = "RAW_PMU_INT is a PMU raw interrupt status register. (offset 0x5C0; total reset 0x00000000; PROVEN: Hi3521A/Hi3520D V300 data sheet (Issue 00B07, 2015-12-10), section 5.7, PDF page 1067).";
        field {
            name = "reserved";
            desc = "Reserved";
            sw = r; hw = w;
            reset = 0x0;
        } reserved_31_31[31:31];
        field {
            name = "raw_mac_fifo_err_int";
            desc = "Raw interrupt of FIFO empty and full errors in the MAC address, cleared by writing 1 to this bit
- 0: No raw interrupt is generated.
- 1: A raw interrupt is generated.

Access type RW in the data sheet; the description says the bit is cleared by writing 1, modeled as write-one-to-clear (INFERRED).";
            sw = rw; hw = w; onwrite = woclr;
            reset = 0x0;
        } raw_mac_fifo_err_int[30:30];
        field {
            name = "raw_tx_rq_in_timeout_int";
            desc = "Raw interrupt of descriptor enqueue timeout in the RQ queue in the TX direction, cleared by writing 1 to this bit
- 0: No raw interrupt is generated.
- 1: A raw interrupt is generated.

Access type RW in the data sheet; the description says the bit is cleared by writing 1, modeled as write-one-to-clear (INFERRED).";
            sw = rw; hw = w; onwrite = woclr;
            reset = 0x0;
        } raw_tx_rq_in_timeout_int[29:29];
        field {
            name = "raw_rx_bq_in_timeout_int";
            desc = "Raw interrupt of descriptor enqueue timeout in the BQ queue in the RX direction, cleared by writing 1 to this bit
- 0: No raw interrupt is generated.
- 1: A raw interrupt is generated.

Access type RW in the data sheet; the description says the bit is cleared by writing 1, modeled as write-one-to-clear (INFERRED).";
            sw = rw; hw = w; onwrite = woclr;
            reset = 0x0;
        } raw_rx_bq_in_timeout_int[28:28];
        field {
            name = "raw_txoutcff_full_int";
            desc = "Raw interrupt of full DESC_OUTCFF in the TX direction, cleared by writing 1 to this bit
- 0: No raw interrupt is generated.
- 1: A raw interrupt is generated.

Access type RW in the data sheet; the description says the bit is cleared by writing 1, modeled as write-one-to-clear (INFERRED).";
            sw = rw; hw = w; onwrite = woclr;
            reset = 0x0;
        } raw_txoutcff_full_int[27:27];
        field {
            name = "raw_txoutcff_empty_int";
            desc = "Raw interrupt of empty DESC_OUTCFF in the TX direction, cleared by writing 1 to this bit
- 0: No raw interrupt is generated.
- 1: A raw interrupt is generated.

Access type RW in the data sheet; the description says the bit is cleared by writing 1, modeled as write-one-to-clear (INFERRED).";
            sw = rw; hw = w; onwrite = woclr;
            reset = 0x0;
        } raw_txoutcff_empty_int[26:26];
        field {
            name = "raw_txcff_full_int";
            desc = "Raw interrupt of full DESC_FIFO in the TX direction, cleared by writing 1 to this bit
- 0: No raw interrupt is generated.
- 1: A raw interrupt is generated.

Access type RW in the data sheet; the description says the bit is cleared by writing 1, modeled as write-one-to-clear (INFERRED).";
            sw = rw; hw = w; onwrite = woclr;
            reset = 0x0;
        } raw_txcff_full_int[25:25];
        field {
            name = "raw_txcff_empty_int";
            desc = "Raw interrupt of empty DESC_FIFO in the TX direction, cleared by writing 1 to this bit
- 0: No raw interrupt is generated.
- 1: A raw interrupt is generated.

Access type RW in the data sheet; the description says the bit is cleared by writing 1, modeled as write-one-to-clear (INFERRED).";
            sw = rw; hw = w; onwrite = woclr;
            reset = 0x0;
        } raw_txcff_empty_int[24:24];
        field {
            name = "raw_rxoutcff_full_int";
            desc = "Raw interrupt of full DESC_OUTCFF in the RX direction, cleared by writing 1 to this bit
- 0: No raw interrupt is generated.
- 1: A raw interrupt is generated.

Access type RW in the data sheet; the description says the bit is cleared by writing 1, modeled as write-one-to-clear (INFERRED).";
            sw = rw; hw = w; onwrite = woclr;
            reset = 0x0;
        } raw_rxoutcff_full_int[23:23];
        field {
            name = "raw_rxoutcff_empty_int";
            desc = "Raw interrupt of empty DESC_OUTCFF in the RX direction, cleared by writing 1 to this bit
- 0: No raw interrupt is generated.
- 1: A raw interrupt is generated.

Access type RW in the data sheet; the description says the bit is cleared by writing 1, modeled as write-one-to-clear (INFERRED).";
            sw = rw; hw = w; onwrite = woclr;
            reset = 0x0;
        } raw_rxoutcff_empty_int[22:22];
        field {
            name = "raw_rxcff_full_int";
            desc = "Raw interrupt of full DESC_FIFO in the RX direction, cleared by writing 1 to this bit
- 0: No raw interrupt is generated.
- 1: A raw interrupt is generated.

Access type RW in the data sheet; the description says the bit is cleared by writing 1, modeled as write-one-to-clear (INFERRED).";
            sw = rw; hw = w; onwrite = woclr;
            reset = 0x0;
        } raw_rxcff_full_int[21:21];
        field {
            name = "raw_rxcff_empty_int";
            desc = "Raw interrupt of empty DESC_FIFO in the RX direction, cleared by writing 1 to this bit
- 0: No raw interrupt is generated.
- 1: A raw interrupt is generated.

Access type RW in the data sheet; the description says the bit is cleared by writing 1, modeled as write-one-to-clear (INFERRED).";
            sw = rw; hw = w; onwrite = woclr;
            reset = 0x0;
        } raw_rxcff_empty_int[20:20];
        field {
            name = "raw_tx_rq_in_int";
            desc = "Raw interrupt of descriptor (multiple or single) enqueue in the tx_rq queue in the TX direction, cleared by writing 1 to this bit
- 0: No raw interrupt is generated.
- 1: A raw interrupt is generated.

Access type RW in the data sheet; the description says the bit is cleared by writing 1, modeled as write-one-to-clear (INFERRED).";
            sw = rw; hw = w; onwrite = woclr;
            reset = 0x0;
        } raw_tx_rq_in_int[19:19];
        field {
            name = "raw_tx_bq_out_int";
            desc = "Raw interrupt of descriptor (multiple or single) dequeue in the tx_bq queue in the TX direction, cleared by writing 1 to this bit
- 0: No raw interrupt is generated.
- 1: A raw interrupt is generated.

Access type RW in the data sheet; the description says the bit is cleared by writing 1, modeled as write-one-to-clear (INFERRED).";
            sw = rw; hw = w; onwrite = woclr;
            reset = 0x0;
        } raw_tx_bq_out_int[18:18];
        field {
            name = "raw_rx_bq_in_int";
            desc = "Raw interrupt of descriptor (multiple or single) enqueue in the rx_bq queue in the RX direction, cleared by writing 1 to this bit
- 0: No raw interrupt is generated.
- 1: A raw interrupt is generated.

Access type RW in the data sheet; the description says the bit is cleared by writing 1, modeled as write-one-to-clear (INFERRED).";
            sw = rw; hw = w; onwrite = woclr;
            reset = 0x0;
        } raw_rx_bq_in_int[17:17];
        field {
            name = "raw_rx_fq_out_int";
            desc = "Raw interrupt of descriptor (multiple or single) dequeue in the rx_fq queue in the RX direction, cleared by writing 1 to this bit
- 0: No raw interrupt is generated.
- 1: A raw interrupt is generated.

Access type RW in the data sheet; the description says the bit is cleared by writing 1, modeled as write-one-to-clear (INFERRED).";
            sw = rw; hw = w; onwrite = woclr;
            reset = 0x0;
        } raw_rx_fq_out_int[16:16];
        field {
            name = "raw_tx_rq_empty_int";
            desc = "Raw interrupt of the empty recycle descriptor queue in the TX direction, cleared by writing 1 to this bit
- 0: No raw interrupt is generated.
- 1: A raw interrupt is generated.

Access type RW in the data sheet; the description says the bit is cleared by writing 1, modeled as write-one-to-clear (INFERRED).";
            sw = rw; hw = w; onwrite = woclr;
            reset = 0x0;
        } raw_tx_rq_empty_int[15:15];
        field {
            name = "raw_tx_rq_full_int";
            desc = "Raw interrupt of the full recycle descriptor queue in the TX direction, cleared by writing 1 to this bit
- 0: No raw interrupt is generated.
- 1: A raw interrupt is generated.

Access type RW in the data sheet; the description says the bit is cleared by writing 1, modeled as write-one-to-clear (INFERRED).";
            sw = rw; hw = w; onwrite = woclr;
            reset = 0x0;
        } raw_tx_rq_full_int[14:14];
        field {
            name = "raw_tx_rq_alempty_int";
            desc = "Raw interrupt of the almost-empty recycle descriptor queue in the TX direction, cleared by writing 1 to this bit
- 0: No raw interrupt is generated.
- 1: A raw interrupt is generated.

Access type RW in the data sheet; the description says the bit is cleared by writing 1, modeled as write-one-to-clear (INFERRED).";
            sw = rw; hw = w; onwrite = woclr;
            reset = 0x0;
        } raw_tx_rq_alempty_int[13:13];
        field {
            name = "raw_tx_rq_alfull_int";
            desc = "Raw interrupt of the almost-full recycle descriptor queue in the TX direction, cleared by writing 1 to this bit
- 0: No raw interrupt is generated.
- 1: A raw interrupt is generated.

Access type RW in the data sheet; the description says the bit is cleared by writing 1, modeled as write-one-to-clear (INFERRED).";
            sw = rw; hw = w; onwrite = woclr;
            reset = 0x0;
        } raw_tx_rq_alfull_int[12:12];
        field {
            name = "raw_tx_bq_empty_int";
            desc = "Raw interrupt of the empty buff descriptor queue in the TX direction, cleared by writing 1 to this bit
- 0: No raw interrupt is generated.
- 1: A raw interrupt is generated.

Access type RW in the data sheet; the description says the bit is cleared by writing 1, modeled as write-one-to-clear (INFERRED).";
            sw = rw; hw = w; onwrite = woclr;
            reset = 0x0;
        } raw_tx_bq_empty_int[11:11];
        field {
            name = "raw_tx_bq_full_int";
            desc = "Raw interrupt of the full buff descriptor queue in the TX direction, cleared by writing 1 to this bit
- 0: No raw interrupt is generated.
- 1: A raw interrupt is generated.

Access type RW in the data sheet; the description says the bit is cleared by writing 1, modeled as write-one-to-clear (INFERRED).";
            sw = rw; hw = w; onwrite = woclr;
            reset = 0x0;
        } raw_tx_bq_full_int[10:10];
        field {
            name = "raw_tx_bq_alempty_int";
            desc = "Raw interrupt of the almost-empty buff descriptor queue in the TX direction, cleared by writing 1 to this bit
- 0: No raw interrupt is generated.
- 1: A raw interrupt is generated.

Access type RW in the data sheet; the description says the bit is cleared by writing 1, modeled as write-one-to-clear (INFERRED).";
            sw = rw; hw = w; onwrite = woclr;
            reset = 0x0;
        } raw_tx_bq_alempty_int[9:9];
        field {
            name = "raw_tx_bq_alfull_int";
            desc = "Raw interrupt of the almost-full buff descriptor queue in the TX direction, cleared by writing 1 to this bit
- 0: No raw interrupt is generated.
- 1: A raw interrupt is generated.

Access type RW in the data sheet; the description says the bit is cleared by writing 1, modeled as write-one-to-clear (INFERRED).";
            sw = rw; hw = w; onwrite = woclr;
            reset = 0x0;
        } raw_tx_bq_alfull_int[8:8];
        field {
            name = "raw_rx_bq_empty_int";
            desc = "Raw interrupt of the empty buff descriptor queue in the RX direction, cleared by writing 1 to this bit
- 0: No raw interrupt is generated.
- 1: A raw interrupt is generated.

Access type RW in the data sheet; the description says the bit is cleared by writing 1, modeled as write-one-to-clear (INFERRED).";
            sw = rw; hw = w; onwrite = woclr;
            reset = 0x0;
        } raw_rx_bq_empty_int[7:7];
        field {
            name = "raw_rx_bq_full_int";
            desc = "Raw interrupt of the full buff descriptor queue in the RX direction, cleared by writing 1 to this bit
- 0: No raw interrupt is generated.
- 1: A raw interrupt is generated.

Access type RW in the data sheet; the description says the bit is cleared by writing 1, modeled as write-one-to-clear (INFERRED).";
            sw = rw; hw = w; onwrite = woclr;
            reset = 0x0;
        } raw_rx_bq_full_int[6:6];
        field {
            name = "raw_rx_bq_alempty_int";
            desc = "Raw interrupt of the almost-empty buff descriptor queue in the RX direction, cleared by writing 1 to this bit
- 0: No raw interrupt is generated.
- 1: A raw interrupt is generated.

Access type RW in the data sheet; the description says the bit is cleared by writing 1, modeled as write-one-to-clear (INFERRED).";
            sw = rw; hw = w; onwrite = woclr;
            reset = 0x0;
        } raw_rx_bq_alempty_int[5:5];
        field {
            name = "raw_rx_bq_alfull_int";
            desc = "Raw interrupt of the almost-full buff descriptor queue in the RX direction, cleared by writing 1 to this bit
- 0: No raw interrupt is generated.
- 1: A raw interrupt is generated.

Access type RW in the data sheet; the description says the bit is cleared by writing 1, modeled as write-one-to-clear (INFERRED).";
            sw = rw; hw = w; onwrite = woclr;
            reset = 0x0;
        } raw_rx_bq_alfull_int[4:4];
        field {
            name = "raw_rx_fq_empty_int";
            desc = "Raw interrupt of the empty idle descriptor queue in the RX direction, cleared by writing 1 to this bit
- 0: No raw interrupt is generated.
- 1: A raw interrupt is generated.

Access type RW in the data sheet; the description says the bit is cleared by writing 1, modeled as write-one-to-clear (INFERRED).";
            sw = rw; hw = w; onwrite = woclr;
            reset = 0x0;
        } raw_rx_fq_empty_int[3:3];
        field {
            name = "raw_rx_fq_full_int";
            desc = "Raw interrupt of the full idle descriptor queue in the RX direction, cleared by writing 1 to this bit
- 0: No raw interrupt is generated.
- 1: A raw interrupt is generated.

Access type RW in the data sheet; the description says the bit is cleared by writing 1, modeled as write-one-to-clear (INFERRED).";
            sw = rw; hw = w; onwrite = woclr;
            reset = 0x0;
        } raw_rx_fq_full_int[2:2];
        field {
            name = "raw_rx_fq_alempty_int";
            desc = "Raw interrupt of the almost-empty idle descriptor queue in the RX direction, cleared by writing 1 to this bit
- 0: No raw interrupt is generated.
- 1: A raw interrupt is generated.

Access type RW in the data sheet; the description says the bit is cleared by writing 1, modeled as write-one-to-clear (INFERRED).";
            sw = rw; hw = w; onwrite = woclr;
            reset = 0x0;
        } raw_rx_fq_alempty_int[1:1];
        field {
            name = "raw_rx_fq_alfull_int";
            desc = "Raw interrupt of the almost-full idle descriptor queue in the RX direction, cleared by writing 1 to this bit
- 0: No raw interrupt is generated.
- 1: A raw interrupt is generated.

Access type RW in the data sheet; the description says the bit is cleared by writing 1, modeled as write-one-to-clear (INFERRED).";
            sw = rw; hw = w; onwrite = woclr;
            reset = 0x0;
        } raw_rx_fq_alfull_int[0:0];
    } RAW_PMU_INT @ 0x5C0;
    reg {
        name = "ENA_PMU_INT";
        desc = "ENA_PMU_INT is a PMU raw interrupt enable register. (offset 0x5C4; total reset 0x00000000; PROVEN: Hi3521A/Hi3520D V300 data sheet (Issue 00B07, 2015-12-10), section 5.7, PDF page 1071).";
        field {
            name = "reserved";
            desc = "Reserved";
            sw = r; hw = w;
            reset = 0x0;
        } reserved_31_31[31:31];
        field {
            name = "ena_mac_fifo_err_int";
            desc = "Internal FIFO empty and full error interrupt enable in the MAC address
- 0: disabled
- 1: enabled";
            sw = rw; hw = r;
            reset = 0x0;
        } ena_mac_fifo_err_int[30:30];
        field {
            name = "ena_tx_rq_in_timeout_int";
            desc = "Descriptor enqueue timeout interrupt enable in the RQ queue in the TX direction
- 0: disabled
- 1: enabled";
            sw = rw; hw = r;
            reset = 0x0;
        } ena_tx_rq_in_timeout_int[29:29];
        field {
            name = "ena_rx_bq_in_timeout_int";
            desc = "Descriptor enqueue timeout interrupt enable in the BQ queue in the RX direction
- 0: disabled
- 1: enabled";
            sw = rw; hw = r;
            reset = 0x0;
        } ena_rx_bq_in_timeout_int[28:28];
        field {
            name = "ena_txoutcff_full_int";
            desc = "Full DESC_OUTCFF interrupt enable in the TX direction
- 0: disabled
- 1: enabled";
            sw = rw; hw = r;
            reset = 0x0;
        } ena_txoutcff_full_int[27:27];
        field {
            name = "ena_txoutcff_empty_int";
            desc = "Empty DESC_OUTCFF interrupt enable in the TX direction
- 0: disabled
- 1: enabled";
            sw = rw; hw = r;
            reset = 0x0;
        } ena_txoutcff_empty_int[26:26];
        field {
            name = "ena_txcff_full_int";
            desc = "Full DESC_FIFO interrupt enable in the TX direction
- 0: disabled
- 1: enabled";
            sw = rw; hw = r;
            reset = 0x0;
        } ena_txcff_full_int[25:25];
        field {
            name = "ena_txcff_empty_int";
            desc = "Empty DESC_FIFO interrupt enable in the TX direction
- 0: disabled
- 1: enabled";
            sw = rw; hw = r;
            reset = 0x0;
        } ena_txcff_empty_int[24:24];
        field {
            name = "ena_rxoutcff_full_int";
            desc = "Full DESC_OUTCFF interrupt enable in the RX direction
- 0: disabled
- 1: enabled";
            sw = rw; hw = r;
            reset = 0x0;
        } ena_rxoutcff_full_int[23:23];
        field {
            name = "ena_rxoutcff_empty_int";
            desc = "Empty DESC_OUTCFF interrupt enable in the RX direction
- 0: disabled
- 1: enabled";
            sw = rw; hw = r;
            reset = 0x0;
        } ena_rxoutcff_empty_int[22:22];
        field {
            name = "ena_rxcff_full_int";
            desc = "Full DESC_FIFO interrupt enable in the RX direction
- 0: disabled
- 1: enabled";
            sw = rw; hw = r;
            reset = 0x0;
        } ena_rxcff_full_int[21:21];
        field {
            name = "ena_rxcff_empty_int";
            desc = "Empty DESC_FIFO interrupt enable in the RX direction
- 0: disabled
- 1: enabled";
            sw = rw; hw = r;
            reset = 0x0;
        } ena_rxcff_empty_int[20:20];
        field {
            name = "ena_tx_rq_in_int";
            desc = "Descriptor (multiple or single) enqueue interrupt enable in the tx_rq queue in the TX direction
- 0: disabled
- 1: enabled";
            sw = rw; hw = r;
            reset = 0x0;
        } ena_tx_rq_in_int[19:19];
        field {
            name = "ena_tx_bq_out_int";
            desc = "Descriptor (multiple or single) dequeue interrupt enable in the tx_bq queue in the TX direction
- 0: disabled
- 1: enabled";
            sw = rw; hw = r;
            reset = 0x0;
        } ena_tx_bq_out_int[18:18];
        field {
            name = "ena_rx_bq_in_int";
            desc = "Descriptor (multiple or single) enqueue interrupt enable in the rx_bq queue in the RX direction
- 0: disabled
- 1: enabled";
            sw = rw; hw = r;
            reset = 0x0;
        } ena_rx_bq_in_int[17:17];
        field {
            name = "ena_rx_fq_out_int";
            desc = "Descriptor (multiple or single) dequeue interrupt enable in the rx_fq queue in the RX direction
- 0: disabled
- 1: enabled";
            sw = rw; hw = r;
            reset = 0x0;
        } ena_rx_fq_out_int[16:16];
        field {
            name = "ena_tx_rq_empty_int";
            desc = "Empty recycle descriptor queue interrupt enable in the TX direction
- 0: disabled
- 1: enabled";
            sw = rw; hw = r;
            reset = 0x0;
        } ena_tx_rq_empty_int[15:15];
        field {
            name = "ena_tx_rq_full_int";
            desc = "Full recycle descriptor queue interrupt enable in the TX direction
- 0: disabled
- 1: enabled";
            sw = rw; hw = r;
            reset = 0x0;
        } ena_tx_rq_full_int[14:14];
        field {
            name = "ena_tx_rq_alempty_int";
            desc = "Almost-empty recycle descriptor queue interrupt enable in the TX direction
- 0: disabled
- 1: enabled";
            sw = rw; hw = r;
            reset = 0x0;
        } ena_tx_rq_alempty_int[13:13];
        field {
            name = "ena_tx_rq_alfull_int";
            desc = "Almost-full recycle descriptor queue interrupt enable in the TX direction
- 0: disabled
- 1: enabled";
            sw = rw; hw = r;
            reset = 0x0;
        } ena_tx_rq_alfull_int[12:12];
        field {
            name = "ena_tx_bq_empty_int";
            desc = "Empty buff descriptor queue interrupt enable in the TX direction
- 0: disabled
- 1: enabled";
            sw = rw; hw = r;
            reset = 0x0;
        } ena_tx_bq_empty_int[11:11];
        field {
            name = "ena_tx_bq_full_int";
            desc = "Full buff descriptor queue interrupt enable in the TX direction
- 1: enabled
- 0: disabled";
            sw = rw; hw = r;
            reset = 0x0;
        } ena_tx_bq_full_int[10:10];
        field {
            name = "ena_tx_bq_alempty_int";
            desc = "Almost-empty buff descriptor queue interrupt enable in the TX direction
- 0: disabled
- 1: enabled";
            sw = rw; hw = r;
            reset = 0x0;
        } ena_tx_bq_alempty_int[9:9];
        field {
            name = "ena_tx_bq_alfull_int";
            desc = "Almost-full buff descriptor queue interrupt enable in the TX direction
- 0: disabled
- 1: enabled";
            sw = rw; hw = r;
            reset = 0x0;
        } ena_tx_bq_alfull_int[8:8];
        field {
            name = "ena_rx_bq_empty_int";
            desc = "Empty buff descriptor queue interrupt enable in the RX direction
- 0: disabled
- 1: enabled";
            sw = rw; hw = r;
            reset = 0x0;
        } ena_rx_bq_empty_int[7:7];
        field {
            name = "ena_rx_bq_full_int";
            desc = "Full buff descriptor queue interrupt enable in the RX direction
- 0: disabled
- 1: enabled";
            sw = rw; hw = r;
            reset = 0x0;
        } ena_rx_bq_full_int[6:6];
        field {
            name = "ena_rx_bq_alempty_int";
            desc = "Almost-empty buff descriptor queue interrupt enable in the RX direction
- 0: disabled
- 1: enabled";
            sw = rw; hw = r;
            reset = 0x0;
        } ena_rx_bq_alempty_int[5:5];
        field {
            name = "ena_rx_bq_alfull_int";
            desc = "Almost-full buff descriptor queue interrupt enable in the RX direction
- 0: disabled
- 1: enabled";
            sw = rw; hw = r;
            reset = 0x0;
        } ena_rx_bq_alfull_int[4:4];
        field {
            name = "ena_rx_fq_empty_int";
            desc = "Empty idle descriptor queue interrupt enable in the RX direction
- 0: disabled
- 1: enabled";
            sw = rw; hw = r;
            reset = 0x0;
        } ena_rx_fq_empty_int[3:3];
        field {
            name = "ena_rx_fq_full_int";
            desc = "Full idle descriptor queue interrupt enable in the RX direction
- 0: disabled
- 1: enabled";
            sw = rw; hw = r;
            reset = 0x0;
        } ena_rx_fq_full_int[2:2];
        field {
            name = "ena_rx_fq_alempty_int";
            desc = "Almost-empty idle descriptor queue interrupt enable in the RX direction
- 0: disabled
- 1: enabled";
            sw = rw; hw = r;
            reset = 0x0;
        } ena_rx_fq_alempty_int[1:1];
        field {
            name = "ena_rx_fq_alfull_int";
            desc = "Almost-full idle descriptor queue interrupt enable in the RX direction
- 0: disabled
- 1: enabled";
            sw = rw; hw = r;
            reset = 0x0;
        } ena_rx_fq_alfull_int[0:0];
    } ENA_PMU_INT @ 0x5C4;
    reg {
        name = "STATUS_PMU_INT";
        desc = "STATUS_PMU_INT is a PMU interrupt status register. (offset 0x5C8; total reset 0x00000000; PROVEN: Hi3521A/Hi3520D V300 data sheet (Issue 00B07, 2015-12-10), section 5.7, PDF page 1074).";
        field {
            name = "reserved";
            desc = "Reserved";
            sw = r; hw = w;
            reset = 0x0;
        } reserved_31_31[31:31];
        field {
            name = "status_mac_fifo_err_int";
            desc = "Status of the MAC internal FIFO empty and full error interrupt
- 0: No interrupt is generated.
- 1: An interrupt is generated.";
            sw = rw; hw = r;
            reset = 0x0;
        } status_mac_fifo_err_int[30:30];
        field {
            name = "status_tx_rq_in_timeout_int";
            desc = "Status of the TX RQ queue descriptor enqueue timeout interrupt
- 0: No interrupt is generated.
- 1: An interrupt is generated.";
            sw = rw; hw = r;
            reset = 0x0;
        } status_tx_rq_in_timeout_int[29:29];
        field {
            name = "status_rx_bq_in_timeout_int";
            desc = "Status of the RX BQ queue descriptor enqueue timeout interrupt
- 0: No interrupt is generated.
- 1: An interrupt is generated.";
            sw = rw; hw = r;
            reset = 0x0;
        } status_rx_bq_in_timeout_int[28:28];
        field {
            name = "status_txoutcff_full_int";
            desc = "Status of the TX DESC_OUTCFF full interrupt
- 0: No interrupt is generated.
- 1: An interrupt is generated.";
            sw = rw; hw = r;
            reset = 0x0;
        } status_txoutcff_full_int[27:27];
        field {
            name = "status_txoutcff_empty_int";
            desc = "Status of the TX DESC_OUTCFF empty interrupt
- 0: No interrupt is generated.
- 1: An interrupt is generated.";
            sw = rw; hw = r;
            reset = 0x0;
        } status_txoutcff_empty_int[26:26];
        field {
            name = "status_txcff_full_int";
            desc = "Status of the TX DESC_FIFO full interrupt
- 0: No interrupt is generated.
- 1: An interrupt is generated.";
            sw = rw; hw = r;
            reset = 0x0;
        } status_txcff_full_int[25:25];
        field {
            name = "status_txcff_empty_int";
            desc = "Status of the TX DESC_FIFO empty interrupt
- 0: No interrupt is generated.
- 1: An interrupt is generated.";
            sw = rw; hw = r;
            reset = 0x0;
        } status_txcff_empty_int[24:24];
        field {
            name = "status_rxoutcff_full_int";
            desc = "Status of the RX DESC_OUTCFF full interrupt
- 0: No interrupt is generated.
- 1: An interrupt is generated.";
            sw = rw; hw = r;
            reset = 0x0;
        } status_rxoutcff_full_int[23:23];
        field {
            name = "status_rxoutcff_empty_int";
            desc = "Status of the RX DESC_OUTCFF empty interrupt
- 0: No interrupt is generated.
- 1: An interrupt is generated.";
            sw = rw; hw = r;
            reset = 0x0;
        } status_rxoutcff_empty_int[22:22];
        field {
            name = "status_rxcff_full_int";
            desc = "Status of the RX DESC_FIFO full interrupt
- 0: No interrupt is generated.
- 1: An interrupt is generated.";
            sw = rw; hw = r;
            reset = 0x0;
        } status_rxcff_full_int[21:21];
        field {
            name = "status_rxcff_empty_int";
            desc = "Status of the RX DESC_FIFO empty interrupt
- 0: No interrupt is generated.
- 1: An interrupt is generated.";
            sw = rw; hw = r;
            reset = 0x0;
        } status_rxcff_empty_int[20:20];
        field {
            name = "status_tx_rq_in_int";
            desc = "Status of the tx_rq queue descriptor (multiple or single) enqueue interrupt
- 0: No interrupt is generated.
- 1: An interrupt is generated.";
            sw = rw; hw = r;
            reset = 0x0;
        } status_tx_rq_in_int[19:19];
        field {
            name = "status_tx_bq_out_int";
            desc = "Status of the tx_bq queue descriptor (multiple or single) dequeue interrupt
- 0: No interrupt is generated.
- 1: An interrupt is generated.";
            sw = rw; hw = r;
            reset = 0x0;
        } status_tx_bq_out_int[18:18];
        field {
            name = "status_rx_bq_in_int";
            desc = "Status of the rx_bq queue descriptor (multiple or single) enqueue interrupt
- 0: No interrupt is generated.
- 1: An interrupt is generated.";
            sw = rw; hw = r;
            reset = 0x0;
        } status_rx_bq_in_int[17:17];
        field {
            name = "status_rx_fq_out_int";
            desc = "Status of the rx_fq queue descriptor (multiple or single) dequeue interrupt
- 0: No interrupt is generated.
- 1: An interrupt is generated.";
            sw = rw; hw = r;
            reset = 0x0;
        } status_rx_fq_out_int[16:16];
        field {
            name = "status_tx_rq_empty_int";
            desc = "Status of the TX recycle descriptor queue empty interrupt
- 0: No interrupt is generated.
- 1: An interrupt is generated.";
            sw = rw; hw = r;
            reset = 0x0;
        } status_tx_rq_empty_int[15:15];
        field {
            name = "status_tx_rq_full_int";
            desc = "Status of the TX recycle descriptor queue full interrupt
- 0: No interrupt is generated.
- 1: An interrupt is generated.";
            sw = rw; hw = r;
            reset = 0x0;
        } status_tx_rq_full_int[14:14];
        field {
            name = "status_tx_rq_alempty_int";
            desc = "Status of the TX recycle descriptor queue almost-empty interrupt
- 0: No interrupt is generated.
- 1: An interrupt is generated.";
            sw = rw; hw = r;
            reset = 0x0;
        } status_tx_rq_alempty_int[13:13];
        field {
            name = "status_tx_rq_alfull_int";
            desc = "Status of the TX recycle descriptor queue almost-full interrupt
- 0: No interrupt is generated.
- 1: An interrupt is generated.";
            sw = rw; hw = r;
            reset = 0x0;
        } status_tx_rq_alfull_int[12:12];
        field {
            name = "status_tx_bq_empty_int";
            desc = "Status of the TX buff descriptor queue empty interrupt
- 0: No interrupt is generated.
- 1: An interrupt is generated.";
            sw = rw; hw = r;
            reset = 0x0;
        } status_tx_bq_empty_int[11:11];
        field {
            name = "status_tx_bq_full_int";
            desc = "Status of the TX buff descriptor queue full interrupt
- 0: No interrupt is generated.
- 1: An interrupt is generated.";
            sw = rw; hw = r;
            reset = 0x0;
        } status_tx_bq_full_int[10:10];
        field {
            name = "status_tx_bq_alempty_int";
            desc = "Status of the TX buff descriptor queue almost-empty interrupt
- 0: No interrupt is generated.
- 1: An interrupt is generated.";
            sw = rw; hw = r;
            reset = 0x0;
        } status_tx_bq_alempty_int[9:9];
        field {
            name = "status_tx_bq_alfull_int";
            desc = "Status of the TX buff descriptor queue almost-full interrupt
- 0: No interrupt is generated.
- 1: An interrupt is generated.";
            sw = rw; hw = r;
            reset = 0x0;
        } status_tx_bq_alfull_int[8:8];
        field {
            name = "status_rx_bq_empty_int";
            desc = "Status of the RX buff descriptor queue empty interrupt
- 0: No interrupt is generated.
- 1: An interrupt is generated.";
            sw = rw; hw = r;
            reset = 0x0;
        } status_rx_bq_empty_int[7:7];
        field {
            name = "status_rx_bq_full_int";
            desc = "Status of the RX buff descriptor queue full interrupt
- 0: No interrupt is generated.
- 1: An interrupt is generated.";
            sw = rw; hw = r;
            reset = 0x0;
        } status_rx_bq_full_int[6:6];
        field {
            name = "status_rx_bq_alempty_int";
            desc = "Status of the RX buff descriptor queue almost-empty interrupt
- 0: No interrupt is generated.
- 1: An interrupt is generated.";
            sw = rw; hw = r;
            reset = 0x0;
        } status_rx_bq_alempty_int[5:5];
        field {
            name = "status_rx_bq_alfull_int";
            desc = "Status of the RX buff descriptor queue almost-full interrupt
- 0: No interrupt is generated.
- 1: An interrupt is generated.";
            sw = rw; hw = r;
            reset = 0x0;
        } status_rx_bq_alfull_int[4:4];
        field {
            name = "status_rx_fq_empty_int";
            desc = "Status of the RX idle descriptor queue empty interrupt
- 0: No interrupt is generated.
- 1: An interrupt is generated.";
            sw = rw; hw = r;
            reset = 0x0;
        } status_rx_fq_empty_int[3:3];
        field {
            name = "status_rx_fq_full_int";
            desc = "Status of the RX idle descriptor queue full interrupt
- 0: No interrupt is generated.
- 1: An interrupt is generated.";
            sw = rw; hw = r;
            reset = 0x0;
        } status_rx_fq_full_int[2:2];
        field {
            name = "status_rx_fq_alempty_int";
            desc = "Status of the RX idle descriptor queue almost-empty interrupt
- 0: No interrupt is generated.
- 1: An interrupt is generated.";
            sw = rw; hw = r;
            reset = 0x0;
        } status_rx_fq_alempty_int[1:1];
        field {
            name = "status_rx_fq_alfull_int";
            desc = "Status of the RX idle descriptor queue almost-full interrupt
- 0: No interrupt is generated.
- 1: An interrupt is generated.";
            sw = rw; hw = r;
            reset = 0x0;
        } status_rx_fq_alfull_int[0:0];
    } STATUS_PMU_INT @ 0x5C8;
    reg {
        name = "DESC_WR_RD_ENA";
        desc = "DESC_WR_RD_ENA is a cff read/write descriptor enable register. (offset 0x5CC; total reset 0x00000000; PROVEN: Hi3521A/Hi3520D V300 data sheet (Issue 00B07, 2015-12-10), section 5.7, PDF page 1077).";
        field {
            name = "reserved";
            desc = "Reserved";
            sw = r; hw = w;
            reset = 0x0;
        } reserved_31_4[31:4];
        field {
            name = "rx_outcff_wr_desc_ena";
            desc = "RX_OUTCFF write descriptor to RX_BQ enable in the RX direction
- 0: disabled
- 1: enabled";
            sw = rw; hw = r;
            reset = 0x0;
        } rx_outcff_wr_desc_ena[3:3];
        field {
            name = "rx_cff_rd_desc_ena";
            desc = "RX_CFF read descriptor from the idle descriptor queue enable in the RX direction
- 0: disabled
- 1: enabled";
            sw = rw; hw = r;
            reset = 0x0;
        } rx_cff_rd_desc_ena[2:2];
        field {
            name = "tx_outcff_wr_desc_ena";
            desc = "TX_OUTCFF write descriptor to TX_RQ enable in the TX direction
- 0: disabled
- 1: enabled";
            sw = rw; hw = r;
            reset = 0x0;
        } tx_outcff_wr_desc_ena[1:1];
        field {
            name = "tx_cff_rd_desc_ena";
            desc = "TX_CFF read descriptor from TX_BQ enable in the TX direction
- 0: disabled
- 1: enabled";
            sw = rw; hw = r;
            reset = 0x0;
        } tx_cff_rd_desc_ena[0:0];
    } DESC_WR_RD_ENA @ 0x5CC;
    reg {
        name = "IN_QUEUE_TH";
        desc = "IN_QUEUE_TH is an rx_bq or tx_rq enqueue interrupt threshold register. (offset 0x5D8; total reset 0x00010001; PROVEN: Hi3521A/Hi3520D V300 data sheet (Issue 00B07, 2015-12-10), section 5.7, PDF page 1078).";
        field {
            name = "reserved";
            desc = "Reserved";
            sw = r; hw = w;
            reset = 0x0;
        } reserved_31_24[31:24];
        field {
            name = "tx_rq_in_th";
            desc = "Threshold for reporting descriptor enqueue interrupts in the TX direction. The threshold must be greater than or equal to 1.";
            sw = rw; hw = r;
            reset = 0x1;
        } tx_rq_in_th[23:16];
        field {
            name = "reserved";
            desc = "Reserved";
            sw = r; hw = w;
            reset = 0x0;
        } reserved_15_8[15:8];
        field {
            name = "rx_bq_in_th";
            desc = "Threshold for reporting descriptor enqueue interrupts in the RX direction. The threshold must be greater than or equal to 1.";
            sw = rw; hw = r;
            reset = 0x1;
        } rx_bq_in_th[7:0];
    } IN_QUEUE_TH @ 0x5D8;
    reg {
        name = "OUT_QUEUE_TH";
        desc = "OUT_QUEUE_TH is an rx_fq or tx_bq dequeue interrupt threshold register. (offset 0x5DC; total reset 0x00010001; PROVEN: Hi3521A/Hi3520D V300 data sheet (Issue 00B07, 2015-12-10), section 5.7, PDF page 1078).";
        field {
            name = "reserved";
            desc = "Reserved";
            sw = r; hw = w;
            reset = 0x0;
        } reserved_31_24[31:24];
        field {
            name = "tx_bq_out_th";
            desc = "Threshold for reporting descriptor dequeue interrupts in the TX direction";
            sw = rw; hw = r;
            reset = 0x1;
        } tx_bq_out_th[23:16];
        field {
            name = "reserved";
            desc = "Reserved";
            sw = r; hw = w;
            reset = 0x0;
        } reserved_15_8[15:8];
        field {
            name = "rx_fq_out_th";
            desc = "Threshold for reporting descriptor dequeue interrupts in the RX direction";
            sw = rw; hw = r;
            reset = 0x1;
        } rx_fq_out_th[7:0];
    } OUT_QUEUE_TH @ 0x5DC;
    reg {
        name = "RX_BQ_IN_TIMEOUT_TH";
        desc = "RX_BQ_IN_TIMEOUT_TH is an rx_bq enqueue timeout raw interrupt threshold register. (offset 0x5E0; total reset 0x00008000; PROVEN: Hi3521A/Hi3520D V300 data sheet (Issue 00B07, 2015-12-10), section 5.7, PDF page 1079).";
        field {
            name = "reserved";
            desc = "Reserved";
            sw = r; hw = w;
            reset = 0x0;
        } reserved_31_24[31:24];
        field {
            name = "rx_bq_in_timeout_th";
            desc = "Threshold for reporting descriptor enqueue timeout interrupts in the BQ queue in the RX direction";
            sw = rw; hw = r;
            reset = 0x8000;
        } rx_bq_in_timeout_th[23:0];
    } RX_BQ_IN_TIMEOUT_TH @ 0x5E0;
    reg {
        name = "TX_RQ_IN_TIMEOUT_TH";
        desc = "TX_RQ_IN_TIMEOUT_TH is a tx_rq enqueue timeout raw interrupt threshold register. (offset 0x5E4; total reset 0x00008000; PROVEN: Hi3521A/Hi3520D V300 data sheet (Issue 00B07, 2015-12-10), section 5.7, PDF page 1079).";
        field {
            name = "reserved";
            desc = "Reserved";
            sw = r; hw = w;
            reset = 0x0;
        } reserved_31_24[31:24];
        field {
            name = "tx_rq_in_timeout_th";
            desc = "Threshold for reporting descriptor enqueue timeout interrupts in the RQ queue in the TX direction";
            sw = rw; hw = r;
            reset = 0x8000;
        } tx_rq_in_timeout_th[23:0];
    } TX_RQ_IN_TIMEOUT_TH @ 0x5E4;
    reg {
        name = "STOP_CMD";
        desc = "STOP_CMD is an RX and TX packet control stop register. (offset 0x5E8; total reset 0x00000000; PROVEN: Hi3521A/Hi3520D V300 data sheet (Issue 00B07, 2015-12-10), section 5.7, PDF page 1080).";
        field {
            name = "reserved";
            desc = "Reserved";
            sw = r; hw = w;
            reset = 0x0;
        } reserved_31_2[31:2];
        field {
            name = "tx_stop_en";
            desc = "Packet TX stop enable
- 0: disabled
- 1: enabled";
            sw = rw; hw = r;
            reset = 0x0;
        } tx_stop_en[1:1];
        field {
            name = "rx_stop_en";
            desc = "Packet RX stop enable
- 0: disabled
- 1: enabled";
            sw = rw; hw = r;
            reset = 0x0;
        } rx_stop_en[0:0];
    } STOP_CMD @ 0x5E8;
    reg {
        name = "FLUSH_CMD";
        desc = "FLUSH_CMD is a recycle descriptor enable register. (offset 0x5EC; total reset 0x00000000; PROVEN: Hi3521A/Hi3520D V300 data sheet (Issue 00B07, 2015-12-10), section 5.7, PDF page 1081).";
        field {
            name = "reserved";
            desc = "Reserved";
            sw = r; hw = w;
            reset = 0x0;
        } reserved_31_6[31:6];
        field {
            name = "tx_flush_cmd";
            desc = "Recycle descriptor command in the TX direction, instructing the descriptors to enter the tx_rq queue
- 0: The recycle descriptor configuration command is invalid.
- 1: The recycle descriptor configuration command is valid.";
            sw = rw; hw = r;
            reset = 0x0;
        } tx_flush_cmd[5:5];
        field {
            name = "rx_flush_cmd";
            desc = "Recycle descriptor command in the RX direction, instructing the descriptors to enter the rx_bq queue
- 0: The recycle descriptor configuration command is invalid.
- 1: The recycle descriptor configuration command is valid.";
            sw = rw; hw = r;
            reset = 0x0;
        } rx_flush_cmd[4:4];
        field {
            name = "tx_flush_flag_down";
            desc = "Recycle descriptor stop indicator in the TX direction. After descriptors are recycled, the logic sets tx_flush_flag to 1, and the software writes 1 to clear the register.

Access type RW in the data sheet; the description says the bit is cleared by writing 1, modeled as write-one-to-clear (INFERRED).";
            sw = rw; hw = w; onwrite = woclr;
            reset = 0x0;
        } tx_flush_flag_down[3:3];
        field {
            name = "tx_flush_flag_up";
            desc = "Recycle descriptor stop indicator in the TX direction. After RX and TX packets are stopped, the logic sets tx_flush_flag to 1, indicating that the software can recycle the descriptors. The software writes 1 to clear the register.

Access type RW in the data sheet; the description says the bit is cleared by writing 1, modeled as write-one-to-clear (INFERRED).";
            sw = rw; hw = w; onwrite = woclr;
            reset = 0x0;
        } tx_flush_flag_up[2:2];
        field {
            name = "rx_flush_flag_down";
            desc = "Recycle descriptor stop indicator in the RX direction. After descriptors are recycled, the logic sets rx_flush_flag_down to 1, and the software writes 1 to clear the register.

Access type RW in the data sheet; the description says the bit is cleared by writing 1, modeled as write-one-to-clear (INFERRED).";
            sw = rw; hw = w; onwrite = woclr;
            reset = 0x0;
        } rx_flush_flag_down[1:1];
        field {
            name = "rx_flush_flag_up";
            desc = "Recycle descriptor indicator in the RX direction. After RX packets are stopped, the logic sets rx_flush_flag_up to 1, indicating that the software can recycle the descriptors. The software writes 1 to clear the register.

Access type RW in the data sheet; the description says the bit is cleared by writing 1, modeled as write-one-to-clear (INFERRED).";
            sw = rw; hw = w; onwrite = woclr;
            reset = 0x0;
        } rx_flush_flag_up[0:0];
    } FLUSH_CMD @ 0x5EC;
    reg {
        name = "U_EEE_INTR_SRC";
        desc = "U_EEE_INTR_SRC is an LPI status register in the RX and TX directions. (offset 0x800; total reset 0x00000000; PROVEN: Hi3521A/Hi3520D V300 data sheet (Issue 00B07, 2015-12-10), section 5.7, PDF page 1082).";
        field {
            name = "reserved";
            desc = "Reserved";
            sw = r; hw = w;
            reset = 0x0;
        } reserved_31_5[31:5];
        field {
            name = "tx_lpi_cond";
            desc = "LPI status in the TX direction
- 0: The TX FIFO and TX descriptors cannot be empty simultaneously.
- 1: The TX FIFO and TX descriptors are empty simultaneously.";
            sw = rw; hw = r;
            reset = 0x0;
        } tx_lpi_cond[4:4];
        field {
            name = "rx_leave_lpi";
            desc = "LPI exit in the RX direction
- 0: not exited
- 1: exited";
            sw = rw; hw = r;
            reset = 0x0;
        } rx_leave_lpi[3:3];
        field {
            name = "rx_entry_lpi";
            desc = "LPI enter in the RX direction
- 0: not entered
- 1: entered";
            sw = rw; hw = r;
            reset = 0x0;
        } rx_entry_lpi[2:2];
        field {
            name = "tx_leave_lpi";
            desc = "LPI exit in the TX direction
- 0: not exited
- 1: exited";
            sw = rw; hw = r;
            reset = 0x0;
        } tx_leave_lpi[1:1];
        field {
            name = "tx_entry_lpi";
            desc = "LPI enter in the TX direction
- 0: not entered
- 1: entered";
            sw = rw; hw = r;
            reset = 0x0;
        } tx_entry_lpi[0:0];
    } U_EEE_INTR_SRC @ 0x800;
    reg {
        name = "U_EEE_INTR_EN";
        desc = "U_EEE_INTR_EN is an interrupt mask and enable register in the RX and TX directions. (offset 0x804; total reset 0x00000000; PROVEN: Hi3521A/Hi3520D V300 data sheet (Issue 00B07, 2015-12-10), section 5.7, PDF page 1083).";
        field {
            name = "reserved";
            desc = "Reserved";
            sw = r; hw = w;
            reset = 0x0;
        } reserved_31_10[31:10];
        field {
            name = "tx_lpi_cond_msk";
            desc = "LPI status interrupt mask in the TX direction
- 0: not masked
- 1: masked";
            sw = rw; hw = r;
            reset = 0x0;
        } tx_lpi_cond_msk[9:9];
        field {
            name = "rx_leave_lpi_msk";
            desc = "LPI status exit interrupt mask in the RX direction
- 0: not masked
- 1: masked";
            sw = rw; hw = r;
            reset = 0x0;
        } rx_leave_lpi_msk[8:8];
        field {
            name = "rx_entry_lpi_msk";
            desc = "LPI status enter interrupt mask in the RX direction
- 0: not masked
- 1: masked";
            sw = rw; hw = r;
            reset = 0x0;
        } rx_entry_lpi_msk[7:7];
        field {
            name = "tx_leave_lpi_msk";
            desc = "LPI status exit interrupt mask in the TX direction
- 0: not masked
- 1: masked";
            sw = rw; hw = r;
            reset = 0x0;
        } tx_leave_lpi_msk[6:6];
        field {
            name = "tx_entry_lpi_msk";
            desc = "LPI status enter interrupt mask in the TX direction
- 0: not masked
- 1: masked";
            sw = rw; hw = r;
            reset = 0x0;
        } tx_entry_lpi_msk[5:5];
        field {
            name = "tx_lpi_cond_en";
            desc = "LPI status interrupt enable in the TX direction
- 0: Disable interrupts.
- 1: Enable interrupts.";
            sw = rw; hw = r;
            reset = 0x0;
        } tx_lpi_cond_en[4:4];
        field {
            name = "rx_leave_lpi_en";
            desc = "LPI status interrupt enable exit in the RX direction
- 0: Disable interrupts.
- 1: Enable interrupts.";
            sw = rw; hw = r;
            reset = 0x0;
        } rx_leave_lpi_en[3:3];
        field {
            name = "rx_entry_lpi_en";
            desc = "LPI status interrupt enable enter in the RX direction
- 0: Disable interrupts.
- 1: Enable interrupts.";
            sw = rw; hw = r;
            reset = 0x0;
        } rx_entry_lpi_en[2:2];
        field {
            name = "tx_leave_lpi_en";
            desc = "LPI status interrupt enable exit in the TX direction
- 0: Disable interrupts.
- 1: Enable interrupts.";
            sw = rw; hw = r;
            reset = 0x0;
        } tx_leave_lpi_en[1:1];
        field {
            name = "tx_entry_lpi_en";
            desc = "LPI status interrupt enable enter in the TX direction
- 0: Disable interrupts.
- 1: Enable interrupts.";
            sw = rw; hw = r;
            reset = 0x0;
        } tx_entry_lpi_en[0:0];
    } U_EEE_INTR_EN @ 0x804;
    reg {
        name = "U_EEE_ENABLE";
        desc = "U_EEE_ENABLE is an EEE enable signal register. (offset 0x808; total reset 0x00F42400; PROVEN: Hi3521A/Hi3520D V300 data sheet (Issue 00B07, 2015-12-10), section 5.7, PDF page 1084).";
        field {
            name = "eee_ls_timer";
            desc = "Buffer time for the buffer software to enable the hardware to enter the LPI when phy_link_sts is set to 1. The default time is 1s.";
            sw = rw; hw = r;
            reset = 0xf4240;
        } eee_ls_timer[31:4];
        field {
            name = "gmii_mode";
            desc = "GMII mode select
- 0: MII mode
- 1: GMII mode";
            sw = rw; hw = r;
            reset = 0x0;
        } gmii_mode[3:3];
        field {
            name = "cond_intr_keep";
            desc = "Interrupt signal TX frequency
- 0: The hardware sends only one tx_lpi_cond interrupt.
- 1: The interrupt is enabled on the rising edge of each clock in LPI mode in the TX direction.";
            sw = rw; hw = r;
            reset = 0x0;
        } cond_intr_keep[2:2];
        field {
            name = "tx_lpi_assert";
            desc = "Software configuring the hardware to enter the LPI state
- 0: The hardware does not enter the LPI state.
- 1: The hardware enters the LPI state.";
            sw = rw; hw = r;
            reset = 0x0;
        } tx_lpi_assert[1:1];
        field {
            name = "eee_enable";
            desc = "EEE module enable
- 0: disabled
- 1: enabled";
            sw = rw; hw = r;
            reset = 0x0;
        } eee_enable[0:0];
    } U_EEE_ENABLE @ 0x808;
    reg {
        name = "U_EEE_TIMER";
        desc = "U_EEE_TIMER is an LPI time threshold register. (offset 0x80C; total reset 0x001E000A; PROVEN: Hi3521A/Hi3520D V300 data sheet (Issue 00B07, 2015-12-10), section 5.7, PDF page 1085).";
        field {
            name = "lpi_tw_timer";
            desc = "Wake-up time of the register from the LPI mode to normal mode. The default time is 30 µs.";
            sw = rw; hw = r;
            reset = 0x1e;
        } lpi_tw_timer[31:16];
        field {
            name = "lpi_cond_timer";
            desc = "Duration when the TX FIFO and EX_DESC are empty at the same time. When the duration is equal to the value of lpi_cond_timer, the register enters the LPI mode.";
            sw = rw; hw = r;
            reset = 0xa;
        } lpi_cond_timer[15:0];
    } U_EEE_TIMER @ 0x80C;
    reg {
        name = "U_EEE_LINK_STATUS";
        desc = "U_EEE_LINK_STATUS is an EEE status register. (offset 0x810; total reset 0x00003F20; PROVEN: Hi3521A/Hi3520D V300 data sheet (Issue 00B07, 2015-12-10), section 5.7, PDF page 1085).";
        field {
            name = "intr_cnt";
            desc = "EEE interrupt count";
            sw = rw; hw = r;
            reset = 0x0;
        } intr_cnt[31:16];
        field {
            name = "eee_tx_lpi_stay";
            desc = "Whether the TX register is in LPI state
- 0: The TX register is not in LPI state.
- 1: The TX register is in LPI state.";
            sw = r; hw = w;
            reset = 0x0;
        } eee_tx_lpi_stay[15:15];
        field {
            name = "eee_rx_lpi_stay_ff3";
            desc = "Whether the RX register is in LPI state
- 0: The TX register is not in LPI state.
- 1: The TX register is in LPI state.";
            sw = r; hw = w;
            reset = 0x0;
        } eee_rx_lpi_stay_ff3[14:14];
        field {
            name = "version";
            desc = "Logical version number";
            sw = r; hw = w;
            reset = 0x3f2;
        } version[13:4];
        field {
            name = "reserved";
            desc = "Reserved";
            sw = r; hw = w;
            reset = 0x0;
        } reserved_3_3[3:3];
        field {
            name = "eee_auto";
            desc = "Automatic EEE entry and exit
- 0: The logic enters or exits the EEE mode by using the software and logic interrupt.
- 1: The logic automatically enters or exits the EEE without the intervention of software.";
            sw = rw; hw = r;
            reset = 0x0;
        } eee_auto[2:2];
        field {
            name = "eee_hold_txdesc_read";
            desc = "Whether the MAC can obtain packets from the TX FIFO in LPI status
- 0: yes
- 1: no";
            sw = rw; hw = r;
            reset = 0x0;
        } eee_hold_txdesc_read[1:1];
        field {
            name = "phy_link_sts";
            desc = "PHY connection state
- 0: link_down
- 1: link_up";
            sw = rw; hw = r;
            reset = 0x0;
        } phy_link_sts[0:0];
    } U_EEE_LINK_STATUS @ 0x810;
    reg {
        name = "U_EEE_TIME_CLK_CNT";
        desc = "U_EEE_TIME_CLK_CNT is a timing pulse count register. (offset 0x814; total reset 0x0000007D; PROVEN: Hi3521A/Hi3520D V300 data sheet (Issue 00B07, 2015-12-10), section 5.7, PDF page 1086).";
        field {
            name = "clk_period_cnt";
            desc = "Count register used to generate a 1 µs timing pulse in the hardware. The clock cycle is 8 ns when the clock frequency is 125 MHz.";
            sw = rw; hw = r;
            reset = 0x7d;
        } clk_period_cnt[31:0];
    } U_EEE_TIME_CLK_CNT @ 0x814;
    reg {
        name = "PMT_CTRL_STAUTS";
        desc = "PMT_CTRL_STAUTS is a PMT control and status register. (offset 0xA00; total reset 0x00000000; PROVEN: Hi3521A/Hi3520D V300 data sheet (Issue 00B07, 2015-12-10), section 5.7, PDF page 1087).";
        field {
            name = "reserved";
            desc = "Reserved";
            sw = r; hw = w;
            reset = 0x0;
        } reserved_31_10[31:10];
        field {
            name = "scr_wkupfrm_glbucast";
            desc = "Whether the unicast frame used to configure the MAC address is the wake-up frame
- 0: The unicast frame is not regarded as the wake-up frame.
- 1: The unicast frame used to configure the MAC address is regarded as the valid wake-up frame.";
            sw = rw; hw = r;
            reset = 0x0;
        } scr_wkupfrm_glbucast[9:9];
        field {
            name = "reserved";
            desc = "Reserved";
            sw = r; hw = w;
            reset = 0x0;
        } reserved_8_7[8:7];
        field {
            name = "rcvd_wkup_frm";
            desc = "Whether a wake_up frame is received
- 0: no
- 1: yes";
            sw = rw; hw = r;
            reset = 0x0;
        } rcvd_wkup_frm[6:6];
        field {
            name = "rcvd_mgk_pkt";
            desc = "Whether the magic packet is received.
- 0: no
- 1: yes";
            sw = rw; hw = r;
            reset = 0x0;
        } rcvd_mgk_pkt[5:5];
        field {
            name = "reserved";
            desc = "Reserved";
            sw = r; hw = w;
            reset = 0x0;
        } reserved_4_4[4:4];
        field {
            name = "scr_intr_en";
            desc = "PMT interrupt enable
- 0: disabled
- 1: enabled";
            sw = rw; hw = r;
            reset = 0x0;
        } scr_intr_en[3:3];
        field {
            name = "scr_wkupfrm_en";
            desc = "wake_up frame receive enable
- 0: disabled
- 1: enabled";
            sw = rw; hw = r;
            reset = 0x0;
        } scr_wkupfrm_en[2:2];
        field {
            name = "scr_mgkpkt_en";
            desc = "Magic packet receive enable
- 0: disabled
- 1: enabled";
            sw = rw; hw = r;
            reset = 0x0;
        } scr_mgkpkt_en[1:1];
        field {
            name = "scr_power_down";
            desc = "Power-down mode enable
- 0: Exit the power-down mode.
- 1: Enter the power-down mode.";
            sw = rw; hw = r;
            reset = 0x0;
        } scr_power_down[0:0];
    } PMT_CTRL_STAUTS @ 0xA00;
    reg {
        name = "FILTER_0_BYTE_MASK";
        desc = "FILTER_0_BYTE_MASK is PMT valid byte selection register 0. (offset 0xA04; total reset 0x00000000; PROVEN: Hi3521A/Hi3520D V300 data sheet (Issue 00B07, 2015-12-10), section 5.7, PDF page 1088).";
        field {
            name = "wkupfrm_filter0bytemsk";
            desc = "Bit[31] must be set to low, indicating that the mask is valid. Bit[30:0] are used for byte mask. If a bit is 1, the corresponding byte is valid.";
            sw = rw; hw = r;
            reset = 0x0;
        } wkupfrm_filter0bytemsk[31:0];
    } FILTER_0_BYTE_MASK @ 0xA04;
    reg {
        name = "FILTER_1_BYTE_MASK";
        desc = "FILTER_1_BYTE_MASK is PMT valid byte selection register 1. (offset 0xA08; total reset 0x00000000; PROVEN: Hi3521A/Hi3520D V300 data sheet (Issue 00B07, 2015-12-10), section 5.7, PDF page 1088).";
        field {
            name = "wkupfrm_filter1bytemsk";
            desc = "Bit[31] must be set to low, indicating that the mask is valid. Bit[30:0] are used for byte mask.";
            sw = rw; hw = r;
            reset = 0x0;
        } wkupfrm_filter1bytemsk[31:0];
    } FILTER_1_BYTE_MASK @ 0xA08;
    reg {
        name = "FILTER_2_BYTE_MASK";
        desc = "FILTER_2_BYTE_MASK is PMT valid byte selection register 2. (offset 0xA0C; total reset 0x00000000; PROVEN: Hi3521A/Hi3520D V300 data sheet (Issue 00B07, 2015-12-10), section 5.7, PDF page 1089).";
        field {
            name = "wkupfrm_filter2bytemsk";
            desc = "Bit[31] must be set to low, indicating that the mask is valid. Bit[30:0] are used for byte mask.";
            sw = rw; hw = r;
            reset = 0x0;
        } wkupfrm_filter2bytemsk[31:0];
    } FILTER_2_BYTE_MASK @ 0xA0C;
    reg {
        name = "FILTER_3_BYTE_MASK";
        desc = "FILTER_3_BYTE_MASK is PMT valid byte selection register 3. (offset 0xA10; total reset 0x00000000; PROVEN: Hi3521A/Hi3520D V300 data sheet (Issue 00B07, 2015-12-10), section 5.7, PDF page 1089).";
        field {
            name = "wkupfrm_filter3bytemsk";
            desc = "Bit[31] must be set to low, indicating that the mask is valid. Bit[30:0] are used for byte mask.";
            sw = rw; hw = r;
            reset = 0x0;
        } wkupfrm_filter3bytemsk[31:0];
    } FILTER_3_BYTE_MASK @ 0xA10;
    reg {
        name = "FILTER_COMMAND";
        desc = "FILTER_COMMAND is a PMT template selection and multicast enable register. (offset 0xA14; total reset 0x00000000; PROVEN: Hi3521A/Hi3520D V300 data sheet (Issue 00B07, 2015-12-10), section 5.7, PDF page 1090).";
        field {
            name = "reserved";
            desc = "Reserved";
            sw = r; hw = w;
            reset = 0x0;
        } reserved_31_28[31:28];
        field {
            name = "wkupfrm_filter3mcast";
            desc = "Address type specified by template 3
- 0: The match of address type is determined based on the valid bytes of the corresponding template and CRC offset address.
- 1: The address is successfully filtered when the destination address is a valid multicast address.";
            sw = rw; hw = r;
            reset = 0x0;
        } wkupfrm_filter3mcast[27:27];
        field {
            name = "reserved";
            desc = "Reserved.";
            sw = r; hw = w;
            reset = 0x0;
        } reserved_26_25[26:25];
        field {
            name = "wkupfrm_filter3en";
            desc = "Filter template 3 enable
- 0: disabled
- 1: enabled";
            sw = rw; hw = r;
            reset = 0x0;
        } wkupfrm_filter3en[24:24];
        field {
            name = "reserved";
            desc = "Reserved";
            sw = r; hw = w;
            reset = 0x0;
        } reserved_23_20[23:20];
        field {
            name = "wkupfrm_filter2mcast";
            desc = "Address type specified by template 2
- 0: The match of address type is determined based on the valid bytes of the corresponding template and CRC offset address.
- 1: The address is successfully filtered when the destination address is a valid multicast address.";
            sw = rw; hw = r;
            reset = 0x0;
        } wkupfrm_filter2mcast[19:19];
        field {
            name = "reserved";
            desc = "Reserved";
            sw = r; hw = w;
            reset = 0x0;
        } reserved_18_17[18:17];
        field {
            name = "wkupfrm_filter2en";
            desc = "Filter template 2 enable
- 0: disabled
- 1: enabled";
            sw = rw; hw = r;
            reset = 0x0;
        } wkupfrm_filter2en[16:16];
        field {
            name = "reserved";
            desc = "Reserved";
            sw = r; hw = w;
            reset = 0x0;
        } reserved_15_12[15:12];
        field {
            name = "wkupfrm_filter1mcast";
            desc = "Address type specified by template 1
- 0: The match of address type is determined based on the valid bytes of the corresponding template and CRC offset address.
- 1: The address is successfully filtered when the destination address is a valid multicast address.";
            sw = rw; hw = r;
            reset = 0x0;
        } wkupfrm_filter1mcast[11:11];
        field {
            name = "reserved";
            desc = "Reserved.";
            sw = r; hw = w;
            reset = 0x0;
        } reserved_10_9[10:9];
        field {
            name = "wkupfrm_filter1en";
            desc = "Filter template 1 enable
- 0: disabled
- 1: enabled";
            sw = rw; hw = r;
            reset = 0x0;
        } wkupfrm_filter1en[8:8];
        field {
            name = "reserved";
            desc = "Reserved";
            sw = r; hw = w;
            reset = 0x0;
        } reserved_7_4[7:4];
        field {
            name = "wkupfrm_filter0mcast";
            desc = "Address type specified by template 0
- 0: The match of address type is determined based on the valid bytes of the corresponding template and CRC offset address.
- 1: The address is successfully filtered when the destination address is a valid multicast address.";
            sw = rw; hw = r;
            reset = 0x0;
        } wkupfrm_filter0mcast[3:3];
        field {
            name = "reserved";
            desc = "Reserved.";
            sw = r; hw = w;
            reset = 0x0;
        } reserved_2_1[2:1];
        field {
            name = "wkupfrm_filter0en";
            desc = "Filter template 0 enable
- 0: disabled
- 1: enabled";
            sw = rw; hw = r;
            reset = 0x0;
        } wkupfrm_filter0en[0:0];
    } FILTER_COMMAND @ 0xA14;
    reg {
        name = "FILTER_OFFSET";
        desc = "FILTER_OFFSET is a CRC position offset register. (offset 0xA18; total reset 0x00000000; PROVEN: Hi3521A/Hi3520D V300 data sheet (Issue 00B07, 2015-12-10), section 5.7, PDF page 1091).";
        field {
            name = "wkupfrm_filter3offset";
            desc = "Template 3 of the four templates, used to calculate the CRC position offset";
            sw = rw; hw = r;
            reset = 0x0;
        } wkupfrm_filter3offset[31:24];
        field {
            name = "wkupfrm_filter2offset";
            desc = "Template 2 of the four templates, used to calculate the CRC position offset";
            sw = rw; hw = r;
            reset = 0x0;
        } wkupfrm_filter2offset[23:16];
        field {
            name = "wkupfrm_filter1offset";
            desc = "Template 1 of the four templates, used to calculate the CRC position offset";
            sw = rw; hw = r;
            reset = 0x0;
        } wkupfrm_filter1offset[15:8];
        field {
            name = "wkupfrm_filter0offset";
            desc = "Template 0 of the four templates, used to calculate the CRC position offset";
            sw = rw; hw = r;
            reset = 0x0;
        } wkupfrm_filter0offset[7:0];
    } FILTER_OFFSET @ 0xA18;
    reg {
        name = "FILTER0_1_CRC";
        desc = "FILTER0_1_CRC is a software-expected CRC value 0 and 1 register. (offset 0xA1C; total reset 0x00000000; PROVEN: Hi3521A/Hi3520D V300 data sheet (Issue 00B07, 2015-12-10), section 5.7, PDF page 1092).";
        field {
            name = "wkupfrm_filter1crc";
            desc = "CRC value expected by software of template 1 in the four templates";
            sw = rw; hw = r;
            reset = 0x0;
        } wkupfrm_filter1crc[31:16];
        field {
            name = "wkupfrm_filter0crc";
            desc = "CRC value expected by software of template 1";
            sw = rw; hw = r;
            reset = 0x0;
        } wkupfrm_filter0crc[15:0];
    } FILTER0_1_CRC @ 0xA1C;
    reg {
        name = "FILTER2_3_CRC";
        desc = "FILTER2_3_CRC is a software-expected CRC value 2 and 3 register. (offset 0xA20; total reset 0x00000000; PROVEN: Hi3521A/Hi3520D V300 data sheet (Issue 00B07, 2015-12-10), section 5.7, PDF page 1092).";
        field {
            name = "wkupfrm_filter3crc";
            desc = "CRC value expected by software of template 3";
            sw = rw; hw = r;
            reset = 0x0;
        } wkupfrm_filter3crc[31:16];
        field {
            name = "wkupfrm_filter2crc";
            desc = "CRC value expected by software of template 2 Contents";
            sw = rw; hw = r;
            reset = 0x0;
        } wkupfrm_filter2crc[15:0];
    } FILTER2_3_CRC @ 0xA20;
};
`endif
