`ifndef HI3520DV300_MDU_RDL
`define HI3520DV300_MDU_RDL
regfile eHI3520DV300_MDU {
    name = "Motion detection unit (MDU)";
    desc = "Motion detection unit (MDU) of the Hi3521A/Hi3520D V300 at base 0x1315_0000. 31 registers extracted programmatically from the Hi3521A/Hi3520D V300 data sheet (Issue 00B07, 2015-12-10) (Table 8-1 Summary of the MDU registers (base address: 0x1315_0000)): register headings, offsets, total reset values, field bit ranges, access types, names, reset values and descriptions, with PDF page numbers in each register description. Field names, bit ranges, access types and offsets are exact; the free-text descriptions are taken from the cell text of the field table and were checked by sampling only. Hardware not verified.";
    reg {
        name = "MDU_INTSTAT";
        desc = "MDU_INTSTAT is an interrupt status register. (offset 0x0; total reset 0x00000000; PROVEN: Hi3521A/Hi3520D V300 data sheet (Issue 00B07, 2015-12-10), section 8.5, PDF page 1115).";
        field {
            name = "mdu_bus_err";
            desc = "Bus read/write error.";
            sw = r; hw = w;
            reset = 0x0;
        } mdu_bus_err[31:31];
        field {
            name = "mdu_cfg_err";
            desc = "Register configuration error.";
            sw = r; hw = w;
            reset = 0x0;
        } mdu_cfg_err[30:30];
        field {
            name = "reserved";
            desc = "Reserved.";
            sw = r; hw = w;
            reset = 0x0;
        } reserved_29_2[29:2];
        field {
            name = "mdu_timeout";
            desc = "MDU timeout interrupt. This interrupt is valid when the timeout detection mode of the MDU is enabled and the working cycle of the MDU is greater than the threshold configured by MDU_TIMEOUT.";
            sw = r; hw = w;
            reset = 0x0;
        } mdu_timeout[1:1];
        field {
            name = "mdu_endofpic";
            desc = "End of picture indicator of the MDU, active high.";
            sw = r; hw = w;
            reset = 0x0;
        } mdu_endofpic[0:0];
    } MDU_INTSTAT @ 0x0;
    reg {
        name = "MDU_INTEN";
        desc = "MDU_INTEN is an interrupt enable register. (offset 0x4; total reset 0x00000000; PROVEN: Hi3521A/Hi3520D V300 data sheet (Issue 00B07, 2015-12-10), section 8.5, PDF page 1115).";
        field {
            name = "mdu_bus_err_en";
            desc = "BUS read/write error interrupt enable.
- 0: disabled
- 1: enabled";
            sw = rw; hw = r;
            reset = 0x0;
        } mdu_bus_err_en[31:31];
        field {
            name = "mdu_cfg_err_en";
            desc = "Register configuration error interrupt enable.
- 0: disabled
- 1: enabled";
            sw = rw; hw = r;
            reset = 0x0;
        } mdu_cfg_err_en[30:30];
        field {
            name = "reserved";
            desc = "Reserved.";
            sw = r; hw = w;
            reset = 0x0;
        } reserved_29_2[29:2];
        field {
            name = "mdu_timeout_en";
            desc = "MDU timeout interrupt enable. When the timeout detection mode of the MDU is enabled and the working cycle of the MDU is greater than the threshold configured by MDU_TIMEOUT, this interrupt is valid.
- 0: disabled
- 1: enabled";
            sw = rw; hw = r;
            reset = 0x0;
        } mdu_timeout_en[1:1];
        field {
            name = "mdu_endofpic_en";
            desc = "End of picture interrupt enable of the MDU
- 0: disabled
- 1: enabled";
            sw = rw; hw = r;
            reset = 0x0;
        } mdu_endofpic_en[0:0];
    } MDU_INTEN @ 0x4;
    reg {
        name = "MDU_RAWINT";
        desc = "MDU_RAWINT is a raw interrupt register. (offset 0x8; total reset 0x00000000; PROVEN: Hi3521A/Hi3520D V300 data sheet (Issue 00B07, 2015-12-10), section 8.5, PDF page 1116).";
        field {
            name = "mdu_bus_err_raw";
            desc = "Raw bus read/write error interrupt, active high.";
            sw = r; hw = w;
            reset = 0x0;
        } mdu_bus_err_raw[31:31];
        field {
            name = "mdu_cfg_err_raw";
            desc = "Raw register configuration error interrupt, active high.";
            sw = r; hw = w;
            reset = 0x0;
        } mdu_cfg_err_raw[30:30];
        field {
            name = "reserved";
            desc = "Reserved.";
            sw = r; hw = w;
            reset = 0x0;
        } reserved_29_2[29:2];
        field {
            name = "mdu_timeout_raw";
            desc = "Raw MDU timeout interrupt, active high.";
            sw = r; hw = w;
            reset = 0x0;
        } mdu_timeout_raw[1:1];
        field {
            name = "mdu_endofpic_raw";
            desc = "Raw end of picture interrupt of the MDU, active high.";
            sw = r; hw = w;
            reset = 0x0;
        } mdu_endofpic_raw[0:0];
    } MDU_RAWINT @ 0x8;
    reg {
        name = "MDU_INTCLR";
        desc = "MDU_INTCLR is an interrupt clear register. (offset 0xC; total reset 0x00000000; PROVEN: Hi3521A/Hi3520D V300 data sheet (Issue 00B07, 2015-12-10), section 8.5, PDF page 1117).";
        field {
            name = "mdu_bus_err_clr";
            desc = "Bus read/write error clear, active high.";
            sw = rw; hw = r;
            reset = 0x0;
        } mdu_bus_err_clr[31:31];
        field {
            name = "mdu_cfg_err_clr";
            desc = "Register configuration error clear, active high.";
            sw = rw; hw = r;
            reset = 0x0;
        } mdu_cfg_err_clr[30:30];
        field {
            name = "reserved";
            desc = "Reserved.";
            sw = r; hw = w;
            reset = 0x0;
        } reserved_29_2[29:2];
        field {
            name = "mdu_timeout_clr";
            desc = "MDU timeout interrupt clear. When the timeout detection mode of the MDU is enabled and the working cycle of the MDU is greater than the threshold configured by MDU_TIMEOUT, this interrupt is valid.";
            sw = rw; hw = r;
            reset = 0x0;
        } mdu_timeout_clr[1:1];
        field {
            name = "mdu_endofpic_clr";
            desc = "End of picture indicator clear of the MDU, active high.";
            sw = rw; hw = r;
            reset = 0x0;
        } mdu_endofpic_clr[0:0];
    } MDU_INTCLR @ 0xC;
    reg {
        name = "MDU_VEDIMGSIZE";
        desc = "MDU_VEDIMGSIZE is a picture size configuration register. (offset 0x20; total reset 0x00000000; PROVEN: Hi3521A/Hi3520D V300 data sheet (Issue 00B07, 2015-12-10), section 8.5, PDF page 1117).";
        field {
            name = "reserved";
            desc = "Reserved.";
            sw = r; hw = w;
            reset = 0x0;
        } reserved_31_29[31:29];
        field {
            name = "imgheightinpixelsminus1";
            desc = "Picture height. The value is in the unit of pixel, and the configured value is obtained by subtracting 1 from the actual height. For example, if the picture height is 352 pixels, this field must be set to 351 pixels. The maximum picture height is 960 pixels.";
            sw = rw; hw = r;
            reset = 0x0;
        } imgheightinpixelsminus1[28:16];
        field {
            name = "reserved";
            desc = "Reserved.";
            sw = r; hw = w;
            reset = 0x0;
        } reserved_15_13[15:13];
        field {
            name = "imgwidthinpixelsminus1";
            desc = "Picture width. The value is in the unit of pixel, and the configured value is obtained by subtracting 1 from the actual width. For example, if the picture width is 288 pixels, this field must be set to 287 pixels. The maximum picture width is 960 pixels.";
            sw = rw; hw = r;
            reset = 0x0;
        } imgwidthinpixelsminus1[12:0];
    } MDU_VEDIMGSIZE @ 0x20;
    reg {
        name = "MDU_MODE";
        desc = "MDU_MODE is a mode configuration register. (offset 0x24; total reset 0x0000019C; PROVEN: Hi3521A/Hi3520D V300 data sheet (Issue 00B07, 2015-12-10), section 8.5, PDF page 1118).";
        field {
            name = "reserved";
            desc = "Reserved.";
            sw = r; hw = w;
            reset = 0x0;
        } reserved_31_9[31:9];
        field {
            name = "mcpi_clkgate_en";
            desc = "Clock gating enable.";
            sw = rw; hw = r;
            reset = 0x1;
        } mcpi_clkgate_en[8:8];
        field {
            name = "mcpi_wrlock_en";
            desc = "Register configuration lock enable. If this field is enabled, registers cannot be configured even if the MDU is started until the detection ends. This avoids modifications made to registers.";
            sw = rw; hw = r;
            reset = 0x1;
        } mcpi_wrlock_en[7:7];
        field {
            name = "timeout_en";
            desc = "MDU timeout detection enable. If this field is enabled, the upper limits of the working cycle that is configured using MDU_TIMEOUT by the software can be automatically queried.
- 0: disabled
- 1: enabled";
            sw = rw; hw = r;
            reset = 0x0;
        } timeout_en[6:6];
        field {
            name = "md_mod";
            desc = "Motion detection mode.
- 0: background algorithm
- 1: frame reference algorithm";
            sw = rw; hw = r;
            reset = 0x0;
        } md_mod[5:5];
        field {
            name = "bg_update_en";
            desc = "Background refresh enable.
- 0: disabled
- 1: enabled

This field is valid only when md_mod is set to 0 (background algorithm).";
            sw = rw; hw = r;
            reset = 0x1;
        } bg_update_en[4:4];
        field {
            name = "eg_find_en";
            desc = "Joint detection enable for OBJ regions.
- 0: disabled
- 1: enabled

If the background algorithm is selected, only the last joint detection based on the background is disabled.";
            sw = rw; hw = r;
            reset = 0x1;
        } eg_find_en[3:3];
        field {
            name = "obj_out_en";
            desc = "OBJ region output enable. If this field is enabled, MDU_OBJ_ADDR must be configured.
- 0: disabled
- 1: enabled";
            sw = rw; hw = r;
            reset = 0x1;
        } obj_out_en[2:2];
        field {
            name = "sad_out_en";
            desc = "SAD output enable. If this field is enabled, MDU_MBSAD_ADDR and MDU_MBSAD_STRIDE must be configured.
- 0: disabled
- 1: enabled";
            sw = rw; hw = r;
            reset = 0x0;
        } sad_out_en[1:1];
        field {
            name = "sad_mad_sel";
            desc = "Number of SAD output bits.
- 0: 8 bits
- 1: 16 bits";
            sw = rw; hw = r;
            reset = 0x0;
        } sad_mad_sel[0:0];
    } MDU_MODE @ 0x24;
    reg {
        name = "MDU_START";
        desc = "MDU_START is an MDU start register. (offset 0x28; total reset 0x00000000; PROVEN: Hi3521A/Hi3520D V300 data sheet (Issue 00B07, 2015-12-10), section 8.5, PDF page 1119).";
        field {
            name = "reserved";
            desc = "Reserved.";
            sw = r; hw = w;
            reset = 0x0;
        } reserved_31_1[31:1];
        field {
            name = "mdu_start";
            desc = "MDU start control.
- 0: The MDU does not work.
- 1: The MDU is started.";
            sw = w; hw = r;
            reset = 0x0;
        } mdu_start[0:0];
    } MDU_START @ 0x28;
    reg {
        name = "MDU_AXI_OUTSTD_NUM";
        desc = "MDU_AXI_OUTSTD_NUM is an AXI outstanding configuration register. (offset 0x2C; total reset 0x00000000; PROVEN: Hi3521A/Hi3520D V300 data sheet (Issue 00B07, 2015-12-10), section 8.5, PDF page 1120).";
        field {
            name = "reserved";
            desc = "Reserved.";
            sw = r; hw = w;
            reset = 0x0;
        } reserved_31_3[31:3];
        field {
            name = "axi_outstd_num";
            desc = "AXI outstanding configuration. The count value is numbered from 0 and the actual value is obtained by adding 1 to the count value.";
            sw = rw; hw = r;
            reset = 0x0;
        } axi_outstd_num[2:0];
    } MDU_AXI_OUTSTD_NUM @ 0x2C;
    reg {
        name = "MDU_REF_YADDR";
        desc = "MDU_REF_YADDR is a luminance storage address register of the reference picture. (offset 0x40; total reset 0x00000000; PROVEN: Hi3521A/Hi3520D V300 data sheet (Issue 00B07, 2015-12-10), section 8.5, PDF page 1120).";
        field {
            name = "mdu_ref_yaddr";
            desc = "Storage address of the Y component of the reference picture. The input raw picture must be Qword-aligned (128 bits). That is, the lower four bits of the address are 0. The hardware automatically sets the lower four bits of the address to 0.";
            sw = rw; hw = r;
            reset = 0x0;
        } mdu_ref_yaddr[31:0];
    } MDU_REF_YADDR @ 0x40;
    reg {
        name = "MDU_REF_YSTRIDE";
        desc = "MDU_REF_YSTRIDE is a luminance stride register of the reference picture. (offset 0x44; total reset 0x00000000; PROVEN: Hi3521A/Hi3520D V300 data sheet (Issue 00B07, 2015-12-10), section 8.5, PDF page 1121).";
        field {
            name = "reserved";
            desc = "Reserved.";
            sw = r; hw = w;
            reset = 0x0;
        } reserved_31_16[31:16];
        field {
            name = "mdu_ref_ystride";
            desc = "Luminance stride, in bytes. The lower four bits of Ystride must be set to 0. This is to ensure that the address is 128-bit-aligned after the picture is wrapped. The hardware automatically sets the lower four bits of Ystride to 0. The stride must be an integral multiple of 64 bytes.";
            sw = rw; hw = r;
            reset = 0x0;
        } mdu_ref_ystride[15:0];
    } MDU_REF_YSTRIDE @ 0x44;
    reg {
        name = "MDU_CUR_YADDR";
        desc = "MDU_CUR_YADDR is a luminance storage address register of the current picture. (offset 0x48; total reset 0x00000000; PROVEN: Hi3521A/Hi3520D V300 data sheet (Issue 00B07, 2015-12-10), section 8.5, PDF page 1121).";
        field {
            name = "mdu_cur_yaddr";
            desc = "Storage address of the Y component of the raw picture. The input raw picture must be Qword-aligned (128 bits). That is, the lower four bits of the address are 0. The hardware automatically sets the lower four bits of the address to 0.";
            sw = rw; hw = r;
            reset = 0x0;
        } mdu_cur_yaddr[31:0];
    } MDU_CUR_YADDR @ 0x48;
    reg {
        name = "MDU_CUR_YSTRIDE";
        desc = "MDU_CUR_YSTRIDE is a luminance stride register of the current picture. (offset 0x4C; total reset 0x00000000; PROVEN: Hi3521A/Hi3520D V300 data sheet (Issue 00B07, 2015-12-10), section 8.5, PDF page 1122).";
        field {
            name = "reserved";
            desc = "Reserved.";
            sw = r; hw = w;
            reset = 0x0;
        } reserved_31_16[31:16];
        field {
            name = "mdu_cur_ystride";
            desc = "Luminance stride, in bytes. The lower four bits of Ystride must be set to 0. This is to ensure that the address is 128-bit-aligned after the picture is wrapped. The hardware automatically sets the lower four bits of Ystride to 0. The stride must be an integral multiple of 64 bytes.";
            sw = rw; hw = r;
            reset = 0x0;
        } mdu_cur_ystride[15:0];
    } MDU_CUR_YSTRIDE @ 0x4C;
    reg {
        name = "MDU_MBSAD_ADDR";
        desc = "MDU_MBSAD_ADDR is a macroblock SAD storage address register. (offset 0x60; total reset 0x00000000; PROVEN: Hi3521A/Hi3520D V300 data sheet (Issue 00B07, 2015-12-10), section 8.5, PDF page 1122).";
        field {
            name = "mdu_mbsad_addr";
            desc = "Address for storing the macroblock SAD. The address must be Qword-aligned. Therefore, the lower four bits must be 0.";
            sw = rw; hw = r;
            reset = 0x0;
        } mdu_mbsad_addr[31:0];
    } MDU_MBSAD_ADDR @ 0x60;
    reg {
        name = "MDU_MBSAD_STRIDE";
        desc = "MDU_MBSAD_STRIDE is a macroblock SAD storage stride register. (offset 0x64; total reset 0x00000000; PROVEN: Hi3521A/Hi3520D V300 data sheet (Issue 00B07, 2015-12-10), section 8.5, PDF page 1122).";
        field {
            name = "reserved";
            desc = "Reserved.";
            sw = r; hw = w;
            reset = 0x0;
        } reserved_31_16[31:16];
        field {
            name = "mdu_mbsad_stride";
            desc = "Macroblock SAD stride, in bytes. The stride must be 128-bit- aligned. Therefore, the lower four bits must be 0.";
            sw = rw; hw = r;
            reset = 0x0;
        } mdu_mbsad_stride[15:0];
    } MDU_MBSAD_STRIDE @ 0x64;
    reg {
        name = "MDU_BACKGROUND_ADDR";
        desc = "MDU_BACKGROUND_ADDR is a luminance storage address register of the background. (offset 0x70; total reset 0x00000000; PROVEN: Hi3521A/Hi3520D V300 data sheet (Issue 00B07, 2015-12-10), section 8.5, PDF page 1123). Compare with the V100 MOTION_DETECT block (HISI_MOTION_DETECT): the data sheet prints bg_yaddr as RO (modeled as printed); the V100 block has it read/write (UNVERIFIED on this chip).";
        field {
            name = "bg_yaddr";
            desc = "Background address. The address must be Qword-aligned. Therefore, the lower four bits must be 0.";
            sw = r; hw = w;
            reset = 0x0;
        } bg_yaddr[31:0];
    } MDU_BACKGROUND_ADDR @ 0x70;
    reg {
        name = "MDU_BACKGROUND_STRIDE";
        desc = "MDU_BACKGROUND_STRIDE is a luminance stride register of the background. (offset 0x74; total reset 0x00000000; PROVEN: Hi3521A/Hi3520D V300 data sheet (Issue 00B07, 2015-12-10), section 8.5, PDF page 1123).";
        field {
            name = "reserved";
            desc = "Reserved.";
            sw = r; hw = w;
            reset = 0x0;
        } reserved_31_16[31:16];
        field {
            name = "bg_ystride";
            desc = "Background stride, in bytes. The stride must be 128-bit-aligned. Therefore, the lower four bits must be 0.";
            sw = rw; hw = r;
            reset = 0x0;
        } bg_ystride[15:0];
    } MDU_BACKGROUND_STRIDE @ 0x74;
    reg {
        name = "MDU_OBJ_ADDR";
        desc = "MDU_OBJ_ADDR is an OBJ region storage address register. (offset 0x78; total reset 0x00000000; PROVEN: Hi3521A/Hi3520D V300 data sheet (Issue 00B07, 2015-12-10), section 8.5, PDF page 1124).";
        field {
            name = "obj_addr";
            desc = "Address for storing OBJ regions. The address must be Qword- aligned. Therefore, the lower four bits must be 0. An OBJ region is stored as follows: The coordinates of the left, top, right, and bottom points of the OBJ region are stored in sequence in four 16-bit spaces. Therefore, two 32-bit DDRs are used to store an OBJ region. When the DDR is allocated by using the software, the minimum DDR size is calculated as follows: 2 x 32 bits x Maximum number of OBJ regions";
            sw = rw; hw = r;
            reset = 0x0;
        } obj_addr[31:0];
    } MDU_OBJ_ADDR @ 0x78;
    reg {
        name = "MDU_BG_UP_WEIGHT";
        desc = "MDU_BG_UP_WEIGHT is a background refresh weight register. (offset 0x7C; total reset 0x00000101; PROVEN: Hi3521A/Hi3520D V300 data sheet (Issue 00B07, 2015-12-10), section 8.5, PDF page 1124).";
        field {
            name = "reserved";
            desc = "Reserved.";
            sw = r; hw = w;
            reset = 0x0;
        } reserved_31_16[31:16];
        field {
            name = "src_weight";
            desc = "New picture weight.";
            sw = rw; hw = r;
            reset = 0x1;
        } src_weight[15:8];
        field {
            name = "weight_sum_exp_2";
            desc = "Exponent of 2 to the weighted sum. When the MDU generates a new background by overlaying the source picture with the existing background, the following formula is used: (Background pixel x ((1<<weight_sum_exp_2) - src_weight) + Pixel of source picture x bg_weight) >> weight_sum_exp_2) The background weight bg_weight is calculated as follows: ((1<<weight_sum_exp_2) - src_weight) The greater the value obtained from background weight bg_weight minus source weight src_weight, the more slowly the background is refreshed. The default value is 0x1, and the maximum value is 0x8.";
            sw = rw; hw = r;
            reset = 0x1;
        } weight_sum_exp_2[7:0];
    } MDU_BG_UP_WEIGHT @ 0x7C;
    reg {
        name = "MDU_MBSAD_TH";
        desc = "MDU_MBSAD_TH is a macroblock motion detection threshold register. (offset 0x80; total reset 0x0000001E; PROVEN: Hi3521A/Hi3520D V300 data sheet (Issue 00B07, 2015-12-10), section 8.5, PDF page 1125).";
        field {
            name = "reserved";
            desc = "Reserved.";
            sw = r; hw = w;
            reset = 0x0;
        } reserved_31_16[31:16];
        field {
            name = "mdu_mbsad_th";
            desc = "Threshold for detecting the motion status of the 4x4 macroblock. All calculations of the MDU are based on the 4x4 macroblock.";
            sw = rw; hw = r;
            reset = 0x1e;
        } mdu_mbsad_th[15:0];
    } MDU_MBSAD_TH @ 0x80;
    reg {
        name = "MDU_TIMEOUT";
        desc = "MDU_TIMEOUT is a timeout upper limit register. (offset 0x84; total reset 0x03600000; PROVEN: Hi3521A/Hi3520D V300 data sheet (Issue 00B07, 2015-12-10), section 8.5, PDF page 1125).";
        field {
            name = "mdu_timeout";
            desc = "Maximum number of working cycles.";
            sw = rw; hw = r;
            reset = 0x3600000;
        } mdu_timeout[31:0];
    } MDU_TIMEOUT @ 0x84;
    reg {
        name = "MDU_WND_SIZE";
        desc = "MDU_WND_SIZE is a SAD output window configuration register. (offset 0x90; total reset 0x00000001; PROVEN: Hi3521A/Hi3520D V300 data sheet (Issue 00B07, 2015-12-10), section 8.5, PDF page 1126).";
        field {
            name = "reserved";
            desc = "Reserved.";
            sw = r; hw = w;
            reset = 0x0;
        } reserved_31_1[31:1];
        field {
            name = "sad_wnd_size";
            desc = "Size of the SAD output window. The calculations of the MDU are based on the 4x4 macroblock. After the sad_out_en bit of the mode register is enabled, the MDU adds the values of multiple 4x4 macroblocks based on the settings of sad_wnd_size, and outputs the value to the DDR.
- 0: 8x8
- 1: 16x16 (default)";
            sw = rw; hw = r;
            reset = 0x1;
        } sad_wnd_size[0:0];
    } MDU_WND_SIZE @ 0x90;
    reg {
        name = "MDU_MIN_OBJ_SIZE";
        desc = "MDU_MIN_OBJ_SIZE is the minimum window configuration register for boundary search. (offset 0x94; total reset 0x03000101; PROVEN: Hi3521A/Hi3520D V300 data sheet (Issue 00B07, 2015-12-10), section 8.5, PDF page 1126).";
        field {
            name = "egsearch_timeout";
            desc = "Boundary search timeout. If the number of points of an OBJ region is greater than the value, the boundary search of the OBJ region stops, and the search for the next region starts.";
            sw = rw; hw = r;
            reset = 0x300;
        } egsearch_timeout[31:16];
        field {
            name = "min_obj_size_h";
            desc = "Minimum height of the OBJ region. The OBJ region whose height is smaller than this value is not reported. The value 1 of min_obj_size_h indicates a 4x4 macroblock.";
            sw = rw; hw = r;
            reset = 0x1;
        } min_obj_size_h[15:8];
        field {
            name = "min_obj_size_w";
            desc = "Minimum width of the OBJ region. The OBJ region whose width is smaller than this value is not reported. The value 1 of min_obj_size_w indicates a 4x4 macroblock.";
            sw = rw; hw = r;
            reset = 0x1;
        } min_obj_size_w[7:0];
    } MDU_MIN_OBJ_SIZE @ 0x94;
    reg {
        name = "MDU_MAX_OBJ_CNT";
        desc = "MDU_MAX_OBJ_CNT is the maximum window configuration register for boundary search. (offset 0x98; total reset 0x00000100; PROVEN: Hi3521A/Hi3520D V300 data sheet (Issue 00B07, 2015-12-10), section 8.5, PDF page 1127).";
        field {
            name = "reserved";
            desc = "Reserved.";
            sw = r; hw = w;
            reset = 0x0;
        } reserved_31_16[31:16];
        field {
            name = "max_obj_cnt";
            desc = "Maximum value for detecting the OBJ regions.";
            sw = rw; hw = r;
            reset = 0x100;
        } max_obj_cnt[15:0];
    } MDU_MAX_OBJ_CNT @ 0x98;
    reg {
        name = "MDU_OBJ_CNT";
        desc = "MDU_OBJ_CNT is an OBJ region information readback register. (offset 0x9C; total reset 0x00000000; PROVEN: Hi3521A/Hi3520D V300 data sheet (Issue 00B07, 2015-12-10), section 8.5, PDF page 1127).";
        field {
            name = "max_obj_index";
            desc = "Maximum OBJ region index. For the statistics register whose name does not contain the digital suffix, the statistics are obtained when the SAD is calculated and the OBJ region is searched for the first time based on the frame reference algorithm or background algorithm.";
            sw = r; hw = w;
            reset = 0x0;
        } max_obj_index[31:16];
        field {
            name = "obj_cnt";
            desc = "Number of detected OBJ regions.";
            sw = r; hw = w;
            reset = 0x0;
        } obj_cnt[15:0];
    } MDU_OBJ_CNT @ 0x9C;
    reg {
        name = "MDU_MAX_OBJ_SIZE";
        desc = "MDU_MAX_OBJ_SIZE is a maximum OBJ region readback register. (offset 0xA0; total reset 0x00000000; PROVEN: Hi3521A/Hi3520D V300 data sheet (Issue 00B07, 2015-12-10), section 8.5, PDF page 1128).";
        field {
            name = "max_obj_size";
            desc = "Maximum size of the OBJ region. This value is used to detect video occlusion. The value is in the unit of pixel. The software calculates the percentage of OBJ regions based on this value and compares the value with the size threshold of the OBJ region. If the value is greater than the threshold, the frame occlusion is considered, and the subsequent frames for detecting video occlusion are not used to refresh the background. In addition, the system checks whether the size of the OBJ region is greater than the threshold for consecutive times. If the occlusion time is greater than the time threshold, video occlusion is considered, and an alarm is generated.";
            sw = r; hw = w;
            reset = 0x0;
        } max_obj_size[31:0];
    } MDU_MAX_OBJ_SIZE @ 0xA0;
    reg {
        name = "MDU_TOTAL_OBJ_SIZE";
        desc = "MDU_TOTAL_OBJ_SIZE is an all OBJ region information readback register. (offset 0xA4; total reset 0x00000000; PROVEN: Hi3521A/Hi3520D V300 data sheet (Issue 00B07, 2015-12-10), section 8.5, PDF page 1128).";
        field {
            name = "total_obj_size";
            desc = "Total size of all OBJ regions. This value is used to detect whether a camera is sprayed. The working principle is the same as that of the max_obj_size field. The MDU adds the sizes of all OBJ regions. The size is in the unit of pixel. The size of each OBJ region is calculated as follows: number of 4x4 macroblocks x 16 NOTE In some cases, the OBJ regions may overlap, and the total size of OBJ regions may be greater than the size of the original picture. Based on the 4x4 macroblock, the height and width of each OBJ region are calculated as follows: Width = (Horizontal coordinate of the right point - Horizontal coordinate of the left point) + 1 Height = (Vertical coordinate of the bottom point - Vertical coordinate of the top point) + 1";
            sw = r; hw = w;
            reset = 0x0;
        } total_obj_size[31:0];
    } MDU_TOTAL_OBJ_SIZE @ 0xA4;
    reg {
        name = "MDU_MOVE_PIX_CNT";
        desc = "MDU_MOVE_PIX_CNT is a motion pixel statistics register for an entire frame. (offset 0xA8; total reset 0x00000000; PROVEN: Hi3521A/Hi3520D V300 data sheet (Issue 00B07, 2015-12-10), section 8.5, PDF page 1129).";
        field {
            name = "move_pix_cnt";
            desc = "Number of motion pixels of an entire frame. This value can be used to detect video occlusion. The working principle is the same as that of the max_obj_size field. Note: The value of this register is based on pixels. Therefore, the register value may be different from the value of total_obj_size.";
            sw = r; hw = w;
            reset = 0x0;
        } move_pix_cnt[31:0];
    } MDU_MOVE_PIX_CNT @ 0xA8;
    reg {
        name = "MDU_OBJ_CNT1";
        desc = "MDU_OBJ_CNT1 is an OBJ region information readback register based on the background. (offset 0xAC; total reset 0x00000000; PROVEN: Hi3521A/Hi3520D V300 data sheet (Issue 00B07, 2015-12-10), section 8.5, PDF page 1129).";
        field {
            name = "max_obj_index1";
            desc = "Index of the maximum OBJ region based on the background. The registers with the suffix 1 indicate statistics registers. The statistics are obtained when the background algorithm is used and the SAD is calculated and the OBJ region is searched for the second time.";
            sw = r; hw = w;
            reset = 0x0;
        } max_obj_index1[31:16];
        field {
            name = "obj_cnt1";
            desc = "Number of detected OBJ regions based on the background.";
            sw = r; hw = w;
            reset = 0x0;
        } obj_cnt1[15:0];
    } MDU_OBJ_CNT1 @ 0xAC;
    reg {
        name = "MDU_MAX_OBJ_SIZE1";
        desc = "MDU_MAX_OBJ_SIZE1 is a maximum OBJ region readback register based on the background. (offset 0xB0; total reset 0x00000000; PROVEN: Hi3521A/Hi3520D V300 data sheet (Issue 00B07, 2015-12-10), section 8.5, PDF page 1130).";
        field {
            name = "max_obj_size1";
            desc = "Maximum size of the OBJ region based on the background. This value is used to detect video occlusion, and is in the unit of pixel. The software calculates the percentage of OBJ regions based on this value and compares the value with the size threshold of the OBJ region. If the value is greater than the threshold, the frame occlusion is considered, and the subsequent frames for detecting video occlusion are not used to refresh the background. In addition, the system checks whether the size of the OBJ region is greater than the threshold for consecutive times. If the occlusion time is greater than the time threshold, video occlusion is considered, and an alarm is generated.";
            sw = r; hw = w;
            reset = 0x0;
        } max_obj_size1[31:0];
    } MDU_MAX_OBJ_SIZE1 @ 0xB0;
    reg {
        name = "MDU_TOTAL_OBJ_SIZE1";
        desc = "MDU_TOTAL_OBJ_SIZE1 is a all OBJ region information readback register based on the background. (offset 0xB4; total reset 0x00000000; PROVEN: Hi3521A/Hi3520D V300 data sheet (Issue 00B07, 2015-12-10), section 8.5, PDF page 1130).";
        field {
            name = "total_obj_size1";
            desc = "Sum of the sizes of all OBJ regions based on the background. This value is used to detect whether a camera is sprayed. The working principle is the same as that of the max_obj_size field.";
            sw = r; hw = w;
            reset = 0x0;
        } total_obj_size1[31:0];
    } MDU_TOTAL_OBJ_SIZE1 @ 0xB4;
    reg {
        name = "MDU_MOVE_PIX_CNT1";
        desc = "MDU_MOVE_PIX_CNT1 is a motion pixel statistics register for an entire frame based on the background. (offset 0xB8; total reset 0x00000000; PROVEN: Hi3521A/Hi3520D V300 data sheet (Issue 00B07, 2015-12-10), section 8.5, PDF page 1131).";
        field {
            name = "move_pix_cnt1";
            desc = "Number of motion pixels of an entire frame based on the background. This value can be used to detect video occlusion. The working principle is the same as that of the max_obj_size field. Contents";
            sw = r; hw = w;
            reset = 0x0;
        } move_pix_cnt1[31:0];
    } MDU_MOVE_PIX_CNT1 @ 0xB8;
};
`endif
