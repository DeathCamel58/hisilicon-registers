`ifndef HI3520DV300_VOIE_RDL
`define HI3520DV300_VOIE_RDL
regfile eHI3520DV300_VOIE {
    name = "Video output image enhancement (VOIE)";
    desc = "Video output image enhancement (VOIE) of the Hi3521A/Hi3520D V300 at base 0x1312_0000. 27 registers extracted programmatically from the Hi3521A/Hi3520D V300 data sheet (Issue 00B07, 2015-12-10) (Table 11-1 Summary of the VOIE registers (base address: 0x1312_0000)): register headings, offsets, total reset values, field bit ranges, access types, names, reset values and descriptions, with PDF page numbers in each register description. Field names, bit ranges, access types and offsets are exact; the free-text descriptions are taken from the cell text of the field table and were checked by sampling only. Hardware not verified.";
    reg {
        name = "VOIE_INTSTAT";
        desc = "VOIE_INTSTAT is an interrupt status register. (offset 0x0; total reset 0x00000000; PROVEN: Hi3521A/Hi3520D V300 data sheet (Issue 00B07, 2015-12-10), section 11.6, PDF page 1405).";
        field {
            name = "reserved";
            desc = "Reserved.";
            sw = r; hw = w;
            reset = 0x0;
        } reserved_31_25[31:25];
        field {
            name = "cfgErr";
            desc = "Configuration error flag.
- 0: correct
- 1: error";
            sw = r; hw = w;
            reset = 0x0;
        } cfgErr[24:24];
        field {
            name = "reserved";
            desc = "Reserved.";
            sw = r; hw = w;
            reset = 0x0;
        } reserved_23_17[23:17];
        field {
            name = "chkErr";
            desc = "Channel variable check error flag.
- 0: correct
- 1: error";
            sw = r; hw = w;
            reset = 0x0;
        } chkErr[16:16];
        field {
            name = "reserved";
            desc = "Reserved.";
            sw = r; hw = w;
            reset = 0x0;
        } reserved_15_9[15:9];
        field {
            name = "VoieEndofSingle";
            desc = "Single channel encoding completion flag.
- 0: incomplete
- 1: complete";
            sw = r; hw = w;
            reset = 0x0;
        } VoieEndofSingle[8:8];
        field {
            name = "reserved";
            desc = "Reserved.";
            sw = r; hw = w;
            reset = 0x0;
        } reserved_7_1[7:1];
        field {
            name = "VoieEndOfFrame";
            desc = "Frame encoding completion flag.
- 0: incomplete
- 1: complete";
            sw = r; hw = w;
            reset = 0x0;
        } VoieEndOfFrame[0:0];
    } VOIE_INTSTAT @ 0x0;
    reg {
        name = "VOIE_INTMASK";
        desc = "VOIE_INTMASK is an interrupt mask register. (offset 0x4; total reset 0x01010101; PROVEN: Hi3521A/Hi3520D V300 data sheet (Issue 00B07, 2015-12-10), section 11.6, PDF page 1406).";
        field {
            name = "reserved";
            desc = "Reserved.";
            sw = r; hw = w;
            reset = 0x0;
        } reserved_31_25[31:25];
        field {
            name = "cfgErrMask";
            desc = "Configuration error flag mask enable.
- 0: enabled
- 1: disabled";
            sw = rw; hw = r;
            reset = 0x1;
        } cfgErrMask[24:24];
        field {
            name = "reserved";
            desc = "Reserved.";
            sw = r; hw = w;
            reset = 0x0;
        } reserved_23_17[23:17];
        field {
            name = "chkErrMask";
            desc = "Check error flag mask enable.
- 0: enabled
- 1: disabled";
            sw = rw; hw = r;
            reset = 0x1;
        } chkErrMask[16:16];
        field {
            name = "reserved";
            desc = "Reserved.";
            sw = r; hw = w;
            reset = 0x0;
        } reserved_15_9[15:9];
        field {
            name = "VoieEndofSingleMask";
            desc = "Single channel encoding completion mask enable.
- 0: enabled
- 1: disabled";
            sw = rw; hw = r;
            reset = 0x1;
        } VoieEndofSingleMask[8:8];
        field {
            name = "reserved";
            desc = "Reserved.";
            sw = r; hw = w;
            reset = 0x0;
        } reserved_7_1[7:1];
        field {
            name = "VoieEndOfPicMask";
            desc = "Frame encoding completion mask enable.
- 0: enabled
- 1: disabled";
            sw = rw; hw = r;
            reset = 0x1;
        } VoieEndOfPicMask[0:0];
    } VOIE_INTMASK @ 0x4;
    reg {
        name = "VOIE_RAWINT";
        desc = "VOIE_RAWINT is a raw interrupt status register. (offset 0x8; total reset 0x00000000; PROVEN: Hi3521A/Hi3520D V300 data sheet (Issue 00B07, 2015-12-10), section 11.6, PDF page 1407).";
        field {
            name = "reserved";
            desc = "Reserved.";
            sw = r; hw = w;
            reset = 0x0;
        } reserved_31_25[31:25];
        field {
            name = "cfgErr";
            desc = "Configuration error flag.
- 0: correct
- 1: incorrect";
            sw = r; hw = w;
            reset = 0x0;
        } cfgErr[24:24];
        field {
            name = "reserved";
            desc = "Reserved.";
            sw = r; hw = w;
            reset = 0x0;
        } reserved_23_17[23:17];
        field {
            name = "chkErr";
            desc = "Channel variable check error flag.
- 0: correct
- 1: error";
            sw = r; hw = w;
            reset = 0x0;
        } chkErr[16:16];
        field {
            name = "reserved";
            desc = "Reserved.";
            sw = r; hw = w;
            reset = 0x0;
        } reserved_15_9[15:9];
        field {
            name = "VoieEndofSingle";
            desc = "Single channel encoding completion flag.
- 0: incomplete
- 1: complete";
            sw = r; hw = w;
            reset = 0x0;
        } VoieEndofSingle[8:8];
        field {
            name = "reserved";
            desc = "Reserved.";
            sw = r; hw = w;
            reset = 0x0;
        } reserved_7_1[7:1];
        field {
            name = "VoieEndOfFrame";
            desc = "Frame encoding completion flag.
- 0: incomplete
- 1: complete";
            sw = r; hw = w;
            reset = 0x0;
        } VoieEndOfFrame[0:0];
    } VOIE_RAWINT @ 0x8;
    reg {
        name = "VOIE_INTCLR";
        desc = "VOIE_INTCLR is an interrupt clear register. (offset 0xC; total reset 0x00000000; PROVEN: Hi3521A/Hi3520D V300 data sheet (Issue 00B07, 2015-12-10), section 11.6, PDF page 1408).";
        field {
            name = "reserved";
            desc = "Reserved.";
            sw = r; hw = w;
            reset = 0x0;
        } reserved_31_25[31:25];
        field {
            name = "cfgErrClr";
            desc = "Configuration error source interrupt clear. Writing 1 clears this bit.

Access type WC in the data sheet: written 1 clears the bit.";
            sw = rw; hw = w; onwrite = woclr;
            reset = 0x0;
        } cfgErrClr[24:24];
        field {
            name = "reserved";
            desc = "Reserved.";
            sw = r; hw = w;
            reset = 0x0;
        } reserved_23_17[23:17];
        field {
            name = "chkErrClr";
            desc = "Channel variable check error flag source interrupt clear. Writing 1 clears this bit.

Access type WC in the data sheet: written 1 clears the bit.";
            sw = rw; hw = w; onwrite = woclr;
            reset = 0x0;
        } chkErrClr[16:16];
        field {
            name = "reserved";
            desc = "Reserved.";
            sw = r; hw = w;
            reset = 0x0;
        } reserved_15_9[15:9];
        field {
            name = "VoieEndofSingleClr";
            desc = "Single channel encoding completion source interrupt clear. Writing 1 clears this bit.

Access type WC in the data sheet: written 1 clears the bit.";
            sw = rw; hw = w; onwrite = woclr;
            reset = 0x0;
        } VoieEndofSingleClr[8:8];
        field {
            name = "reserved";
            desc = "Reserved.";
            sw = r; hw = w;
            reset = 0x0;
        } reserved_7_1[7:1];
        field {
            name = "VoieEndOfFrameClr";
            desc = "Frame encoding completion source interrupt clear. Writing 1 clears this bit.

Access type WC in the data sheet: written 1 clears the bit.";
            sw = rw; hw = w; onwrite = woclr;
            reset = 0x0;
        } VoieEndOfFrameClr[0:0];
    } VOIE_INTCLR @ 0xC;
    reg {
        name = "VIOE_START";
        desc = "VIOE_START is an encoding start signal register. (offset 0x10; total reset 0x00000000; PROVEN: Hi3521A/Hi3520D V300 data sheet (Issue 00B07, 2015-12-10), section 11.6, PDF page 1409).";
        field {
            name = "reserved";
            desc = "Reserved.";
            sw = r; hw = w;
            reset = 0x0;
        } reserved_31_1[31:1];
        field {
            name = "Start";
            desc = "Encoding start signal.
- 0: not start
- 1: start";
            sw = w; hw = r;
            reset = 0x0;
        } Start[0:0];
    } VIOE_START @ 0x10;
    reg {
        name = "VOIE_OUTSTDING";
        desc = "VOIE_OUTSTDING is an outstanding configuration register. (offset 0x14; total reset 0x00000007; PROVEN: Hi3521A/Hi3520D V300 data sheet (Issue 00B07, 2015-12-10), section 11.6, PDF page 1409).";
        field {
            name = "reserved";
            desc = "Reserved.";
            sw = r; hw = w;
            reset = 0x0;
        } reserved_31_4[31:4];
        field {
            name = "voieoutstd";
            desc = "Outstanding depth of the AXI port. The depth range is 0-7.";
            sw = rw; hw = r;
            reset = 0x7;
        } voieoutstd[3:0];
    } VOIE_OUTSTDING @ 0x14;
    reg {
        name = "VOIE_MODE";
        desc = "VOIE_MODE is a VOIE working mode register. (offset 0x20; total reset 0x00000000; PROVEN: Hi3521A/Hi3520D V300 data sheet (Issue 00B07, 2015-12-10), section 11.6, PDF page 1410).";
        field {
            name = "reserved";
            desc = "Reserved.";
            sw = r; hw = w;
            reset = 0x0;
        } reserved_31_19[31:19];
        field {
            name = "memClkGateEn";
            desc = "Memory clock gating enable. Note: This field is invalid and can be ignored.";
            sw = rw; hw = r;
            reset = 0x0;
        } memClkGateEn[18:18];
        field {
            name = "clkGateEn";
            desc = "Clock gating enable Note: This field is invalid and can be ignored.";
            sw = rw; hw = r;
            reset = 0x0;
        } clkGateEn[17:16];
        field {
            name = "reserved";
            desc = "Reserved.";
            sw = r; hw = w;
            reset = 0x0;
        } reserved_15_9[15:9];
        field {
            name = "accesslockEn";
            desc = "Internal configuration lock enable. Note: This field is invalid and can be ignored.";
            sw = rw; hw = r;
            reset = 0x0;
        } accesslockEn[8:8];
        field {
            name = "reserved";
            desc = "Reserved.";
            sw = r; hw = w;
            reset = 0x0;
        } reserved_7_2[7:2];
        field {
            name = "timeEn";
            desc = "Timeout check enable. Note: This field is invalid and can be ignored.";
            sw = rw; hw = r;
            reset = 0x0;
        } timeEn[1:0];
    } VOIE_MODE @ 0x20;
    reg {
        name = "VOIE_CFG";
        desc = "VOIE_CFG is a first linked list address register. (offset 0x28; total reset 0x00000000; PROVEN: Hi3521A/Hi3520D V300 data sheet (Issue 00B07, 2015-12-10), section 11.6, PDF page 1411).";
        field {
            name = "AddrOfFirstLLI";
            desc = "Address for the first linked list for storing the current audio frame. Note: The address must be configured before encoding and must be 128-bit-aligned.";
            sw = rw; hw = r;
            reset = 0x0;
        } AddrOfFirstLLI[31:0];
    } VOIE_CFG @ 0x28;
    reg {
        name = "VOIE_LLICFG0";
        desc = "VOIE_LLICFG0 is a linked list member register (SrcPhyAddr). (offset 0x30; total reset 0x00000000; PROVEN: Hi3521A/Hi3520D V300 data sheet (Issue 00B07, 2015-12-10), section 11.6, PDF page 1411).";
        field {
            name = "SrcPhyAddr";
            desc = "Start physical address for storing the voice frame data to be encoded in the DDR. The address must be 128-bit-aligned. The address is written to the corresponding linked list DDR addresses by the software before encoding and is loaded by the AXI bus after encoding starts. Note: This register is provided only for readback during debugging.";
            sw = r; hw = w;
            reset = 0x0;
        } SrcPhyAddr[31:0];
    } VOIE_LLICFG0 @ 0x30;
    reg {
        name = "VOIE_LLICFG1";
        desc = "VOIE_LLICFG1 is a linked list member register (DstPhyAddr). (offset 0x34; total reset 0x00000000; PROVEN: Hi3521A/Hi3520D V300 data sheet (Issue 00B07, 2015-12-10), section 11.6, PDF page 1411).";
        field {
            name = "DstPhyAddr";
            desc = "The physical address of streams output to the DDR after encoding. The 128-bit address must be aligned. The address is written to the corresponding linked list DDR addresses by the software before encoding and is loaded by the AXI bus after encoding starts. Note: This register is provided only for readback during debugging.";
            sw = r; hw = w;
            reset = 0x0;
        } DstPhyAddr[31:0];
    } VOIE_LLICFG1 @ 0x34;
    reg {
        name = "VOIE_LLICFG2";
        desc = "VOIE_LLICFG2 is a linked list member register (StatePhyAddr). (offset 0x38; total reset 0x00000000; PROVEN: Hi3521A/Hi3520D V300 data sheet (Issue 00B07, 2015-12-10), section 11.6, PDF page 1412).";
        field {
            name = "StatePhyAddr";
            desc = "The physical address for storing the voice frame data to be encoded in the DDR. The address must be 128-bit aligned. This address must be configured during the G726 encoding and ADPCM encoding. As channel variables are not used during the G711 encoding, this register can be ignored. The address is written to the corresponding linked list DDR addresses by the software before encoding and is loaded by the AXI bus. Note: This register is provided only for readback during debugging.";
            sw = r; hw = w;
            reset = 0x0;
        } StatePhyAddr[31:0];
    } VOIE_LLICFG2 @ 0x38;
    reg {
        name = "VOIE_LLICFG3";
        desc = "VOIE_LLICFG3 is a linked list member register (NextLLiAddr). (offset 0x3C; total reset 0x00000000; PROVEN: Hi3521A/Hi3520D V300 data sheet (Issue 00B07, 2015-12-10), section 11.6, PDF page 1412).";
        field {
            name = "NextLLiAddr";
            desc = "Memory address of the next channel linked list. The address must be 128-bit aligned. If the current channel is the last channel of this frame, set the next linked list address to 0x00000000; otherwise, the next linked list address cannot be set to 0. The address is written to the corresponding linked list DDR addresses by the software before encoding and is loaded by the AXI bus after encoding starts. Note: This register is provided only for readback during debugging.";
            sw = r; hw = w;
            reset = 0x0;
        } NextLLiAddr[31:0];
    } VOIE_LLICFG3 @ 0x3C;
    reg {
        name = "VOIE_LLICFG4";
        desc = "VOIE_LLICFG4 is a linked list member register (StCtrl, encoding control). (offset 0x40; total reset 0x00000081; PROVEN: Hi3521A/Hi3520D V300 data sheet (Issue 00B07, 2015-12-10), section 11.6, PDF page 1413).";
        field {
            name = "SamplesPerFrame";
            desc = "Number of audio sampling points in the current voice frame. The values range is 80-2880 and the value must an integral multiple of 80. The address is written to the corresponding linked list DDR addresses by the software before encoding and is loaded by the AXI bus after encoding starts. Note: This register is provided only for readback during debugging.";
            sw = r; hw = w;
            reset = 0x0;
        } SamplesPerFrame[31:16];
        field {
            name = "Codec";
            desc = "Encoding type configuration.
- 0x01: G711 Alaw
- 0x02: G711 Ulaw
- 0x03: ADPCM_DIV4
- 0x04: G726_16 kbps
- 0x05: G726_24 kbps
- 0x06: G726_32 kbps
- 0x07: G726_40 kbps
- 0x24: MEDIA_G726_16 kbps
- 0x25: MEDIA_G726_24 kbps
- 0x26: MEDIA_G726_32 kbps
- 0x27: MEDIA_G726_40 kbps
- 0x43: ADPCM_ORG_DIV4

Other values: invalid configuration. If the VOIE receives other configurations, a configuration error interrupt is reported. The address is written to the corresponding linked list DDR addresses by the software before encoding and is loaded by the AXI bus after encoding starts. Note: This register is provided only for readback during debugging.";
            sw = r; hw = w;
            reset = 0x0;
        } Codec[15:8];
        field {
            name = "hisi_head";
            desc = "Output stream HiSilicon frame header enable.
- 0: exclude HiSilicon frame header
- 1: include HiSilicon frame header

This bit is set to 0x1 by default. The address is written to the corresponding linked list DDR addresses by the software before encoding and is loaded by the AXI bus after encoding starts. Note: This register is provided only for readback during debugging.";
            sw = rw; hw = r;
            reset = 0x1;
        } hisi_head[7:7];
        field {
            name = "reserved";
            desc = "Reserved.";
            sw = r; hw = w;
            reset = 0x1;
        } reserved_6_0[6:0];
    } VOIE_LLICFG4 @ 0x40;
    reg {
        name = "VOIE_LLISTATE0";
        desc = "VOIE_LLISTATE0 is G726 encoding channel variable register 0. (offset 0x50; total reset 0x00000000; PROVEN: Hi3521A/Hi3520D V300 data sheet (Issue 00B07, 2015-12-10), section 11.6, PDF page 1415).";
        field {
            name = "A1";
            desc = "G726 encoding channel variable. Two-tap pole predictor coefficient 1.";
            sw = r; hw = w;
            reset = 0x0;
        } A1[31:16];
        field {
            name = "A2";
            desc = "G726 encoding channel variable. Two-tap pole predictor coefficient 2.";
            sw = r; hw = w;
            reset = 0x0;
        } A2[15:0];
    } VOIE_LLISTATE0 @ 0x50;
    reg {
        name = "VOIE_LLISTATE1";
        desc = "VOIE_LLISTATE1 is G726 encoding channel variable register 1. (offset 0x54; total reset 0x00000000; PROVEN: Hi3521A/Hi3520D V300 data sheet (Issue 00B07, 2015-12-10), section 11.6, PDF page 1415).";
        field {
            name = "AP";
            desc = "G726 encoding channel variable. Delay speed control.";
            sw = r; hw = w;
            reset = 0x0;
        } AP[31:22];
        field {
            name = "reserved";
            desc = "Reserved.";
            sw = r; hw = w;
            reset = 0x0;
        } reserved_21_16[21:16];
        field {
            name = "PK1";
            desc = "G726 encoding channel variable. DQ+SEZ signed bit when the delay is 1.";
            sw = r; hw = w;
            reset = 0x0;
        } PK1[15:15];
        field {
            name = "PK2";
            desc = "G726 encoding channel variable. DQ+SEZ signed bit when the delay is 2.";
            sw = r; hw = w;
            reset = 0x0;
        } PK2[14:14];
        field {
            name = "reserved";
            desc = "Reserved.";
            sw = r; hw = w;
            reset = 0x0;
        } reserved_13_1[13:1];
        field {
            name = "TD";
            desc = "G726 encoding channel variable. Single audio detection signal.";
            sw = r; hw = w;
            reset = 0x0;
        } TD[0:0];
    } VOIE_LLISTATE1 @ 0x54;
    reg {
        name = "VOIE_LLISTATE2";
        desc = "VOIE_LLISTATE2 is G726 encoding channel variable register 2. (offset 0x58; total reset 0x00000000; PROVEN: Hi3521A/Hi3520D V300 data sheet (Issue 00B07, 2015-12-10), section 11.6, PDF page 1416).";
        field {
            name = "B1";
            desc = "G726 encoding channel variable. Six-tap pole predictor coefficient 1.";
            sw = r; hw = w;
            reset = 0x0;
        } B1[31:16];
        field {
            name = "B2";
            desc = "G726 encoding channel variable. Six-tap pole predictor coefficient 2.";
            sw = r; hw = w;
            reset = 0x0;
        } B2[15:0];
    } VOIE_LLISTATE2 @ 0x58;
    reg {
        name = "VOIE_LLISTATE3";
        desc = "VOIE_LLISTATE3 is G726 encoding channel variable register 3. (offset 0x5C; total reset 0x00000000; PROVEN: Hi3521A/Hi3520D V300 data sheet (Issue 00B07, 2015-12-10), section 11.6, PDF page 1416).";
        field {
            name = "B3";
            desc = "G726 encoding channel variable. Six-tap pole predictor coefficient 3.";
            sw = r; hw = w;
            reset = 0x0;
        } B3[31:16];
        field {
            name = "B4";
            desc = "G726 encoding channel variable. Six-tap pole predictor coefficient 4.";
            sw = r; hw = w;
            reset = 0x0;
        } B4[15:0];
    } VOIE_LLISTATE3 @ 0x5C;
    reg {
        name = "VOIE_LLISTATE4";
        desc = "VOIE_LLISTATE4 is G726 encoding channel variable register 4. (offset 0x60; total reset 0x00000000; PROVEN: Hi3521A/Hi3520D V300 data sheet (Issue 00B07, 2015-12-10), section 11.6, PDF page 1417).";
        field {
            name = "B5";
            desc = "G726 encoding channel variable. Six-tap pole predictor coefficient 5.";
            sw = r; hw = w;
            reset = 0x0;
        } B5[31:16];
        field {
            name = "B6";
            desc = "G726 encoding channel variable. Six-tap pole predictor coefficient 6.";
            sw = r; hw = w;
            reset = 0x0;
        } B6[15:0];
    } VOIE_LLISTATE4 @ 0x60;
    reg {
        name = "VOIE_LLISTATE5";
        desc = "VOIE_LLISTATE5 is G726 encoding channel variable register 5. (offset 0x64; total reset 0x00000000; PROVEN: Hi3521A/Hi3520D V300 data sheet (Issue 00B07, 2015-12-10), section 11.6, PDF page 1417).";
        field {
            name = "DML";
            desc = "G726 encoding channel variable. F (I) long-term average value of the delay.";
            sw = r; hw = w;
            reset = 0x0;
        } DML[31:18];
        field {
            name = "reserved";
            desc = "Reserved.";
            sw = r; hw = w;
            reset = 0x0;
        } reserved_17_16[17:16];
        field {
            name = "DMS";
            desc = "G726 encoding channel variable. F (I) short-term average value of the delay.";
            sw = r; hw = w;
            reset = 0x0;
        } DMS[15:4];
        field {
            name = "reserved";
            desc = "Reserved.";
            sw = r; hw = w;
            reset = 0x0;
        } reserved_3_0[3:0];
    } VOIE_LLISTATE5 @ 0x64;
    reg {
        name = "VOIE_LLISTATE6";
        desc = "VOIE_LLISTATE6 is G726 encoding channel variable register 6. (offset 0x68; total reset 0x04000400; PROVEN: Hi3521A/Hi3520D V300 data sheet (Issue 00B07, 2015-12-10), section 11.6, PDF page 1418).";
        field {
            name = "DQ1";
            desc = "G726 encoding channel variable. Quantization difference signal when the delay is 1.";
            sw = r; hw = w;
            reset = 0x20;
        } DQ1[31:21];
        field {
            name = "reserved";
            desc = "Reserved.";
            sw = r; hw = w;
            reset = 0x0;
        } reserved_20_16[20:16];
        field {
            name = "DQ2";
            desc = "G726 encoding channel variable. Quantization difference signal when the delay is 2.";
            sw = r; hw = w;
            reset = 0x20;
        } DQ2[15:5];
        field {
            name = "reserved";
            desc = "Reserved.";
            sw = r; hw = w;
            reset = 0x0;
        } reserved_4_0[4:0];
    } VOIE_LLISTATE6 @ 0x68;
    reg {
        name = "VOIE_LLISTATE7";
        desc = "VOIE_LLISTATE7 is G726 encoding channel variable register 7. (offset 0x6C; total reset 0x04000400; PROVEN: Hi3521A/Hi3520D V300 data sheet (Issue 00B07, 2015-12-10), section 11.6, PDF page 1418).";
        field {
            name = "DQ3";
            desc = "G726 encoding channel variable. Quantization difference signal when the delay is 3.";
            sw = r; hw = w;
            reset = 0x20;
        } DQ3[31:21];
        field {
            name = "reserved";
            desc = "Reserved.";
            sw = r; hw = w;
            reset = 0x0;
        } reserved_20_16[20:16];
        field {
            name = "DQ4";
            desc = "G726 encoding channel variable. Quantization difference signal when the delay is 4.";
            sw = r; hw = w;
            reset = 0x20;
        } DQ4[15:5];
        field {
            name = "reserved";
            desc = "Reserved.";
            sw = r; hw = w;
            reset = 0x0;
        } reserved_4_0[4:0];
    } VOIE_LLISTATE7 @ 0x6C;
    reg {
        name = "VOIE_LLISTATE8";
        desc = "VOIE_LLISTATE8 is G726 encoding channel variable register 8. (offset 0x70; total reset 0x04000400; PROVEN: Hi3521A/Hi3520D V300 data sheet (Issue 00B07, 2015-12-10), section 11.6, PDF page 1419).";
        field {
            name = "DQ5";
            desc = "G726 encoding channel variable. Quantization difference signal when the delay is 5.";
            sw = r; hw = w;
            reset = 0x20;
        } DQ5[31:21];
        field {
            name = "reserved";
            desc = "Reserved.";
            sw = r; hw = w;
            reset = 0x0;
        } reserved_20_16[20:16];
        field {
            name = "DQ6";
            desc = "G726 encoding channel variable. Quantization difference signal when the delay is 6.";
            sw = r; hw = w;
            reset = 0x20;
        } DQ6[15:5];
        field {
            name = "reserved";
            desc = "Reserved.";
            sw = r; hw = w;
            reset = 0x0;
        } reserved_4_0[4:0];
    } VOIE_LLISTATE8 @ 0x70;
    reg {
        name = "VOIE_LLISTATE9";
        desc = "VOIE_LLISTATE9 is G726 encoding channel variable register 9. (offset 0x74; total reset 0x04000400; PROVEN: Hi3521A/Hi3520D V300 data sheet (Issue 00B07, 2015-12-10), section 11.6, PDF page 1419).";
        field {
            name = "SR1";
            desc = "G726 encoding channel variable. Reconstruction signal when the delay is 1.";
            sw = r; hw = w;
            reset = 0x20;
        } SR1[31:21];
        field {
            name = "reserved";
            desc = "Reserved.";
            sw = r; hw = w;
            reset = 0x0;
        } reserved_20_16[20:16];
        field {
            name = "SR2";
            desc = "G726 encoding channel variable. Reconstruction signal when the delay is 2.";
            sw = r; hw = w;
            reset = 0x20;
        } SR2[15:5];
        field {
            name = "reserved";
            desc = "Reserved.";
            sw = r; hw = w;
            reset = 0x0;
        } reserved_4_0[4:0];
    } VOIE_LLISTATE9 @ 0x74;
    reg {
        name = "VOIE_LLISTATE10";
        desc = "VOIE_LLISTATE10 is G726 encoding channel variable register 10. (offset 0x78; total reset 0x11000220; PROVEN: Hi3521A/Hi3520D V300 data sheet (Issue 00B07, 2015-12-10), section 11.6, PDF page 1420).";
        field {
            name = "YL";
            desc = "G726 encoding channel variable. Low-speed quantization scaling factor.";
            sw = r; hw = w;
            reset = 0x8800;
        } YL[31:13];
        field {
            name = "YU";
            desc = "G726 encoding channel variable. High-speed quantization scaling factor.";
            sw = r; hw = w;
            reset = 0x220;
        } YU[12:0];
    } VOIE_LLISTATE10 @ 0x78;
    reg {
        name = "VOIE_STATE_CHK0";
        desc = "VOIE_STATE_CHK0 is a G726 channel variable check register. (offset 0x7C; total reset 0x21001220; PROVEN: Hi3521A/Hi3520D V300 data sheet (Issue 00B07, 2015-12-10), section 11.6, PDF page 1420).";
        field {
            name = "g726_check";
            desc = "G726 channel variable check result.";
            sw = r; hw = w;
            reset = 0x21001220;
        } g726_check[31:0];
    } VOIE_STATE_CHK0 @ 0x7C;
    reg {
        name = "VOIE_LLISTATE11";
        desc = "VOIE_LLISTATE11 is ADPCM encoding channel variable register 11. (offset 0x80; total reset 0x00000000; PROVEN: Hi3521A/Hi3520D V300 data sheet (Issue 00B07, 2015-12-10), section 11.6, PDF page 1421).";
        field {
            name = "valprev";
            desc = "ADPCM encoding channel variable, indicating the reconstruction value of the previous audio point.";
            sw = r; hw = w;
            reset = 0x0;
        } valprev[31:16];
        field {
            name = "reserved";
            desc = "Reserved.";
            sw = r; hw = w;
            reset = 0x0;
        } reserved_15_8[15:8];
        field {
            name = "index";
            desc = "ADPCM encoding channel variable, indicating the index value of the quantization table.";
            sw = r; hw = w;
            reset = 0x0;
        } index[7:0];
    } VOIE_LLISTATE11 @ 0x80;
    reg {
        name = "VOIE_STATE_CHK1";
        desc = "VOIE_STATE_CHK1 is an ADPCM channel variable check register. (offset 0x84; total reset 0x00000000; PROVEN: Hi3521A/Hi3520D V300 data sheet (Issue 00B07, 2015-12-10), section 11.6, PDF page 1421).";
        field {
            name = "adpcm_check";
            desc = "ADPCM channel variable check result.";
            sw = r; hw = w;
            reset = 0x0;
        } adpcm_check[31:0];
    } VOIE_STATE_CHK1 @ 0x84;
};
`endif
