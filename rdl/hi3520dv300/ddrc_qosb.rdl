`ifndef HI3520DV300_DDRC_QOSB_RDL
`define HI3520DV300_DDRC_QOSB_RDL
regfile eHI3520DV300_DDRC_QOSB {
    name = "DDRC QoS buffer";
    desc = "DDRC QoS buffer of the Hi3521A/Hi3520D V300 at base 0x1211_4000. 56 registers extracted programmatically from the Hi3521A/Hi3520D V300 data sheet (Issue 00B07, 2015-12-10) (Table 4-7 Summary of QoSBuf registers (base address: 0x1211_4000)): register headings, offsets, total reset values, field bit ranges, access types, names, reset values and descriptions, with PDF page numbers in each register description. Field names, bit ranges, access types and offsets are exact; the free-text descriptions are taken from the cell text of the field table and were checked by sampling only. Hardware not verified.";
    reg {
        name = "QOSB_PUSH_CTRL";
        desc = "QOSB_PUSH_CTRL is a QosBuf push configuration register. (offset 0x0; total reset 0x00000000; PROVEN: Hi3521A/Hi3520D V300 data sheet (Issue 00B07, 2015-12-10), section 4.1.6.2, PDF page 751).";
        field {
            name = "reserved";
            desc = "Reserved";
            sw = r; hw = w;
            reset = 0x0;
        } reserved_31_3[31:3];
        field {
            name = "mid_push_en";
            desc = "Push enable for commands with the same MID
- 0: disabled
- 1: enabled";
            sw = rw; hw = r;
            reset = 0x0;
        } mid_push_en[2:2];
        field {
            name = "addr_push_en";
            desc = "Push enable for commands with the same address
- 0: disabled
- 1: enabled";
            sw = rw; hw = r;
            reset = 0x0;
        } addr_push_en[1:1];
        field {
            name = "id_push_en";
            desc = "Push enable for commands with the same ID
- 0: disabled
- 1: enabled";
            sw = rw; hw = r;
            reset = 0x0;
        } id_push_en[0:0];
    } QOSB_PUSH_CTRL @ 0x0;
    reg {
        name = "QOSB_ADPT_CTRL";
        desc = "QOSB_ADPT_CTRL is a QoSBuf adaptation configuration register. (offset 0x4; total reset 0x00000FF0; PROVEN: Hi3521A/Hi3520D V300 data sheet (Issue 00B07, 2015-12-10), section 4.1.6.2, PDF page 752).";
        field {
            name = "reserved";
            desc = "Reserved";
            sw = r; hw = w;
            reset = 0x0;
        } reserved_31_20[31:20];
        field {
            name = "adpt_share_cnt";
            desc = "Adapt counter for lower bits. When the value of this counter decreases to 0, the counter for upper bits corresponding to each CMD decreases by 1.";
            sw = rw; hw = r;
            reset = 0xff;
        } adpt_share_cnt[19:4];
        field {
            name = "reserved";
            desc = "Reserved";
            sw = r; hw = w;
            reset = 0x0;
        } reserved_3_1[3:1];
        field {
            name = "adpt_en";
            desc = "Adapt enable
- 0: disabled
- 1: enabled";
            sw = rw; hw = r;
            reset = 0x0;
        } adpt_en[0:0];
    } QOSB_ADPT_CTRL @ 0x4;
    reg QOSB_FLUX_ID_t {
        name = "QOSB_FLUX_ID";
        desc = "QOSB_FLUX_ID is a QoSBuf matched ID register for traffic statistics. (offset 0x8, 7 instances at stride 0x4; total reset 0x00000000; PROVEN: Hi3521A/Hi3520D V300 data sheet (Issue 00B07, 2015-12-10), section 4.1.6.2, PDF page 752).";
        field {
            name = "flux_id";
            desc = "Matched ID for traffic statistics. The ID ranges from 0 to 6, and each ID corresponds to a statistics group. If the traffic ID matches none of the seven IDs, the traffic is included in the default group.";
            sw = rw; hw = r;
            reset = 0x0;
        } flux_id[31:0];
    };
    QOSB_FLUX_ID_t QOSB_FLUX_ID_0 @ 0x8;
    QOSB_FLUX_ID_t QOSB_FLUX_ID_1 @ 0xC;
    QOSB_FLUX_ID_t QOSB_FLUX_ID_2 @ 0x10;
    QOSB_FLUX_ID_t QOSB_FLUX_ID_3 @ 0x14;
    QOSB_FLUX_ID_t QOSB_FLUX_ID_4 @ 0x18;
    QOSB_FLUX_ID_t QOSB_FLUX_ID_5 @ 0x1C;
    QOSB_FLUX_ID_t QOSB_FLUX_ID_6 @ 0x20;
    reg QOSB_FLUX_ID_MASK_t {
        name = "QOSB_FLUX_ID_MASK";
        desc = "QOSB_FLUX_ID_MASK is a QoSBuf traffic statistics ID mask register. (offset 0x24, 7 instances at stride 0x4; total reset 0x00000000; PROVEN: Hi3521A/Hi3520D V300 data sheet (Issue 00B07, 2015-12-10), section 4.1.6.2, PDF page 753).";
        field {
            name = "flux_id_mask";
            desc = "QoSBuf traffic statistics ID mask, corresponding to QOSB_FLUX_ID
- 0: Bits of the corresponding ID are ignored.
- 1: Bits of the corresponding ID are compared.";
            sw = rw; hw = r;
            reset = 0x0;
        } flux_id_mask[31:0];
    };
    QOSB_FLUX_ID_MASK_t QOSB_FLUX_ID_MASK_0 @ 0x24;
    QOSB_FLUX_ID_MASK_t QOSB_FLUX_ID_MASK_1 @ 0x28;
    QOSB_FLUX_ID_MASK_t QOSB_FLUX_ID_MASK_2 @ 0x2C;
    QOSB_FLUX_ID_MASK_t QOSB_FLUX_ID_MASK_3 @ 0x30;
    QOSB_FLUX_ID_MASK_t QOSB_FLUX_ID_MASK_4 @ 0x34;
    QOSB_FLUX_ID_MASK_t QOSB_FLUX_ID_MASK_5 @ 0x38;
    QOSB_FLUX_ID_MASK_t QOSB_FLUX_ID_MASK_6 @ 0x3C;
    reg {
        name = "QOSB_FLUX_PRD";
        desc = "QOSB_FLUX_PRD is a QoSBuf traffic statistical period register. (offset 0x40; total reset 0x00000000; PROVEN: Hi3521A/Hi3520D V300 data sheet (Issue 00B07, 2015-12-10), section 4.1.6.2, PDF page 753).";
        field {
            name = "reserved";
            desc = "Reserved";
            sw = r; hw = w;
            reset = 0x0;
        } reserved_31_16[31:16];
        field {
            name = "flux_prd";
            desc = "Traffic statistical period";
            sw = rw; hw = r;
            reset = 0x0;
        } flux_prd[15:0];
    } QOSB_FLUX_PRD @ 0x40;
    reg QOSB_FLUX_LVL_t {
        name = "QOSB_FLUX_LVL";
        desc = "QOSB_FLUX_LVL is a QoSBuf traffic statistical threshold register. (offset 0x44, 8 instances at stride 0x4; total reset 0x00000000; PROVEN: Hi3521A/Hi3520D V300 data sheet (Issue 00B07, 2015-12-10), section 4.1.6.2, PDF page 754).";
        field {
            name = "reserved";
            desc = "Reserved";
            sw = r; hw = w;
            reset = 0x0;
        } reserved_31_20[31:20];
        field {
            name = "flux_lvl";
            desc = "Traffic statistical threshold. During the statistical period, the priority of the command is decreased to the lowest one when the traffic exceeds the threshold.";
            sw = rw; hw = r;
            reset = 0x0;
        } flux_lvl[19:0];
    };
    QOSB_FLUX_LVL_t QOSB_FLUX_LVL_0 @ 0x44;
    QOSB_FLUX_LVL_t QOSB_FLUX_LVL_1 @ 0x48;
    QOSB_FLUX_LVL_t QOSB_FLUX_LVL_2 @ 0x4C;
    QOSB_FLUX_LVL_t QOSB_FLUX_LVL_3 @ 0x50;
    QOSB_FLUX_LVL_t QOSB_FLUX_LVL_4 @ 0x54;
    QOSB_FLUX_LVL_t QOSB_FLUX_LVL_5 @ 0x58;
    QOSB_FLUX_LVL_t QOSB_FLUX_LVL_6 @ 0x5C;
    QOSB_FLUX_LVL_t QOSB_FLUX_LVL_7 @ 0x60;
    reg {
        name = "QOSB_FLUX_EN";
        desc = "QOSB_FLUX_EN is a QoSBuf traffic statistics enable register. (offset 0x64; total reset 0x00000000; PROVEN: Hi3521A/Hi3520D V300 data sheet (Issue 00B07, 2015-12-10), section 4.1.6.2, PDF page 754).";
        field {
            name = "reserved";
            desc = "Reserved";
            sw = r; hw = w;
            reset = 0x0;
        } reserved_31_1[31:1];
        field {
            name = "flux_en";
            desc = "Traffic statistics enable
- 0: disabled
- 1: enabled";
            sw = rw; hw = r;
            reset = 0x0;
        } flux_en[0:0];
    } QOSB_FLUX_EN @ 0x64;
    reg QOSB_BANK_CTRL_t {
        name = "QOSB_BANK_CTRL";
        desc = "QOSB_BANK_CTRL is a QoSBuf bank rotating control register. (offset 0x68, 2 instances at stride 0x4; total reset 0x00000000; PROVEN: Hi3521A/Hi3520D V300 data sheet (Issue 00B07, 2015-12-10), section 4.1.6.2, PDF page 755).";
        field {
            name = "reserved";
            desc = "Reserved";
            sw = r; hw = w;
            reset = 0x0;
        } reserved_31_8[31:8];
        field {
            name = "ba_cnt_lvl";
            desc = "Bank conflict threshold. When the number of commands with the same bank address exceeds the threshold, bank conflict occurs. Otherwise, there is no bank conflict.";
            sw = rw; hw = r;
            reset = 0x0;
        } ba_cnt_lvl[7:4];
        field {
            name = "reserved";
            desc = "Reserved";
            sw = r; hw = w;
            reset = 0x0;
        } reserved_3_1[3:1];
        field {
            name = "ba_intleav_en";
            desc = "QoSBuf bank rotating enable
- 0: disabled
- 1: enabled";
            sw = rw; hw = r;
            reset = 0x0;
        } ba_intleav_en[0:0];
    };
    QOSB_BANK_CTRL_t QOSB_BANK_CTRL_0 @ 0x68;
    QOSB_BANK_CTRL_t QOSB_BANK_CTRL_1 @ 0x6C;
    reg QOSB_GREEN_CTRL_t {
        name = "QOSB_GREEN_CTRL";
        desc = "QOSB_GREEN_CTRL is a QoSBuf green channel control register. (offset 0x78, 2 instances at stride 0x4; total reset 0x00000000; PROVEN: Hi3521A/Hi3520D V300 data sheet (Issue 00B07, 2015-12-10), section 4.1.6.2, PDF page 755).";
        field {
            name = "reserved";
            desc = "Reserved";
            sw = r; hw = w;
            reset = 0x0;
        } reserved_31_8[31:8];
        field {
            name = "green_lvl";
            desc = "Green channel threshold. That is, the empty locations above this threshold are reserved for green channels. For example, if there are 12 DMC queues (queues 0-11) and the threshold is 9, queues 10 and 11 are reserved for green channels. When this field is set to N, the actual number of allowed commands is (N + 1) because of the pipeline issue. This register cannot be dynamically configured when it is being accessed.";
            sw = rw; hw = r;
            reset = 0x0;
        } green_lvl[7:4];
        field {
            name = "reserved";
            desc = "Reserved";
            sw = r; hw = w;
            reset = 0x0;
        } reserved_3_1[3:1];
        field {
            name = "green_en";
            desc = "Green channel enable (channels are not controlled separately, which needs to be optimized later)
- 0: disabled
- 1: enabled";
            sw = rw; hw = r;
            reset = 0x0;
        } green_en[0:0];
    };
    QOSB_GREEN_CTRL_t QOSB_GREEN_CTRL_0 @ 0x78;
    QOSB_GREEN_CTRL_t QOSB_GREEN_CTRL_1 @ 0x7C;
    reg {
        name = "QOSB_BUF_BYP";
        desc = "QOSB_BUF_BYP is a QoSBuf bypass control register. (offset 0x88; total reset 0x00000000; PROVEN: Hi3521A/Hi3520D V300 data sheet (Issue 00B07, 2015-12-10), section 4.1.6.2, PDF page 756).";
        field {
            name = "reserved";
            desc = "Reserved";
            sw = r; hw = w;
            reset = 0x0;
        } reserved_31_2[31:2];
        field {
            name = "qos_buf_byp";
            desc = "QoSBuf bypass control x0: forcible non-bypass mode. That is, all the commands enter the QoSBuf module when the value is set to 00 or 10.
- 01: whether to bypass depends on the queue status in the DMC
- 11: forcible bypass mode. None of the commands enters the

QoSBuf module. These modes need to be configured before the access. The dynamic configuration is forbidden during the access.";
            sw = rw; hw = r;
            reset = 0x0;
        } qos_buf_byp[1:0];
    } QOSB_BUF_BYP @ 0x88;
    reg QOSB_WBUF_CTRL_t {
        name = "QOSB_WBUF_CTRL";
        desc = "QOSB_WBUF_CTRL is a QoSBuf write command priority adjustment control register. (offset 0x8C, 2 instances at stride 0x4; total reset 0x00000000; PROVEN: Hi3521A/Hi3520D V300 data sheet (Issue 00B07, 2015-12-10), section 4.1.6.2, PDF page 757).";
        field {
            name = "wbuf_ptun_en";
            desc = "Write command priority adjustment enable
- 0: disabled
- 1: enabled";
            sw = rw; hw = r;
            reset = 0x0;
        } wbuf_ptun_en[31:31];
        field {
            name = "wbuf_pri2";
            desc = "Priority of write buffer threshold 2";
            sw = rw; hw = r;
            reset = 0x0;
        } wbuf_pri2[30:28];
        field {
            name = "wbuf_lvl2";
            desc = "Write buffer threshold 2. When the number of commands increasingly reaches the threshold, if the priorities of the write commands are lower than wbuf_pri2, the priorities of the write commands are set to wbuf_pri2. If the priorities of the write commands are higher than wbuf_pri2, the priorities of the write commands are restored to their previous priorities. Note that the threshold cannot be dynamically configured. Otherwise, the write buffer adaptation function becomes invalid.";
            sw = rw; hw = r;
            reset = 0x0;
        } wbuf_lvl2[27:20];
        field {
            name = "reserved";
            desc = "Reserved";
            sw = r; hw = w;
            reset = 0x0;
        } reserved_19_19[19:19];
        field {
            name = "wbuf_pri1";
            desc = "Priority of write buffer threshold 1 priority";
            sw = rw; hw = r;
            reset = 0x0;
        } wbuf_pri1[18:16];
        field {
            name = "wbuf_lvl1";
            desc = "Write buffer threshold 1. When the number of commands increasingly or decreasingly reaches the threshold, if the priorities of the write commands are lower than wbuf_pri1, the priorities of the write commands are set to wbuf_pri1. If the priorities of the write commands are higher than wbuf_pri1, the priorities of the write commands are restored to their previous priorities. Note that the threshold cannot be dynamically configured. Otherwise, the write buffer adaptation function becomes invalid.";
            sw = rw; hw = r;
            reset = 0x0;
        } wbuf_lvl1[15:8];
        field {
            name = "wbuf_lvl0";
            desc = "Write buffer threshold 0. When the number of commands decreasingly reaches the threshold, the priorities of the write commands are decreased to the lowest priority. Note that the threshold cannot be dynamically configured. Otherwise, the write buffer adaptation function becomes invalid.";
            sw = rw; hw = r;
            reset = 0x0;
        } wbuf_lvl0[7:0];
    };
    QOSB_WBUF_CTRL_t QOSB_WBUF_CTRL_0 @ 0x8C;
    QOSB_WBUF_CTRL_t QOSB_WBUF_CTRL_1 @ 0x90;
    reg {
        name = "QOSB_WRTOUT0";
        desc = "QOSB_WRTOUT0 is QoSBuf write command timeout period register 0. (offset 0x9C; total reset 0x00000000; PROVEN: Hi3521A/Hi3520D V300 data sheet (Issue 00B07, 2015-12-10), section 4.1.6.2, PDF page 758).";
        field {
            name = "wr_tout3";
            desc = "Write command timeout period (level 3) The configuration mode is the same as that of wr_tout0.";
            sw = rw; hw = r;
            reset = 0x0;
        } wr_tout3[31:24];
        field {
            name = "wr_tout2";
            desc = "Write command timeout period (level 2) The configuration mode is the same as that of wr_tout0.";
            sw = rw; hw = r;
            reset = 0x0;
        } wr_tout2[23:16];
        field {
            name = "wr_tout1";
            desc = "Write command timeout period (level 1) The configuration mode is the same as that of wr_tout0.";
            sw = rw; hw = r;
            reset = 0x0;
        } wr_tout1[15:8];
        field {
            name = "wr_tout0";
            desc = "Write command timeout period (level 0)
- 0x0: The timeout function is disabled. 0x1-0xFF: n x 4 clock cycles

When the timeout period is set to 8 bits, the actual count value is 10 bits. That is, the lower two bits are fixed at 0.";
            sw = rw; hw = r;
            reset = 0x0;
        } wr_tout0[7:0];
    } QOSB_WRTOUT0 @ 0x9C;
    reg {
        name = "QOSB_WRTOUT1";
        desc = "QOSB_WRTOUT1 is QoSBuf write command timeout period register 1. (offset 0xA0; total reset 0x00000000; PROVEN: Hi3521A/Hi3520D V300 data sheet (Issue 00B07, 2015-12-10), section 4.1.6.2, PDF page 758).";
        field {
            name = "wr_tout7";
            desc = "Write command timeout period (level 7) The configuration mode is the same as that of wr_tout0.";
            sw = rw; hw = r;
            reset = 0x0;
        } wr_tout7[31:24];
        field {
            name = "wr_tout6";
            desc = "Write command timeout period (level 6) The configuration mode is the same as that of wr_tout0.";
            sw = rw; hw = r;
            reset = 0x0;
        } wr_tout6[23:16];
        field {
            name = "wr_tout5";
            desc = "Write command timeout period (level 5) The configuration mode is the same as that of wr_tout0.";
            sw = rw; hw = r;
            reset = 0x0;
        } wr_tout5[15:8];
        field {
            name = "wr_tout4";
            desc = "Write command timeout period (level 4) The configuration mode is the same as that of wr_tout0.";
            sw = rw; hw = r;
            reset = 0x0;
        } wr_tout4[7:0];
    } QOSB_WRTOUT1 @ 0xA0;
    reg {
        name = "QOSB_WRTOUT2";
        desc = "QOSB_WRTOUT2 is QoSBuf write command timeout period register 2. (offset 0xA4; total reset 0x00000000; PROVEN: Hi3521A/Hi3520D V300 data sheet (Issue 00B07, 2015-12-10), section 4.1.6.2, PDF page 759).";
        field {
            name = "wr_tout11";
            desc = "Write command timeout period (level 11) The configuration mode is the same as that of wr_tout0.";
            sw = rw; hw = r;
            reset = 0x0;
        } wr_tout11[31:24];
        field {
            name = "wr_tout10";
            desc = "Write command timeout period (level 10) The configuration mode is the same as that of wr_tout0.";
            sw = rw; hw = r;
            reset = 0x0;
        } wr_tout10[23:16];
        field {
            name = "wr_tout9";
            desc = "Write command timeout period (level 9) The configuration mode is the same as that of wr_tout0.";
            sw = rw; hw = r;
            reset = 0x0;
        } wr_tout9[15:8];
        field {
            name = "wr_tout8";
            desc = "Write command timeout period (level 8) The configuration mode is the same as that of wr_tout0.";
            sw = rw; hw = r;
            reset = 0x0;
        } wr_tout8[7:0];
    } QOSB_WRTOUT2 @ 0xA4;
    reg {
        name = "QOSB_WRTOUT3";
        desc = "QOSB_WRTOUT3 is QoSBuf write command timeout period register 3. (offset 0xA8; total reset 0x00000000; PROVEN: Hi3521A/Hi3520D V300 data sheet (Issue 00B07, 2015-12-10), section 4.1.6.2, PDF page 759).";
        field {
            name = "wr_tout15";
            desc = "Write command timeout period (level 15) The configuration mode is the same as that of wr_tout0.";
            sw = rw; hw = r;
            reset = 0x0;
        } wr_tout15[31:24];
        field {
            name = "wr_tout14";
            desc = "Write command timeout period (level 14) The configuration mode is the same as that of wr_tout0.";
            sw = rw; hw = r;
            reset = 0x0;
        } wr_tout14[23:16];
        field {
            name = "wr_tout13";
            desc = "Write command timeout period (level 13) The configuration mode is the same as that of wr_tout0.";
            sw = rw; hw = r;
            reset = 0x0;
        } wr_tout13[15:8];
        field {
            name = "wr_tout12";
            desc = "Write command timeout period (level 12) The configuration mode is the same as that of wr_tout0.";
            sw = rw; hw = r;
            reset = 0x0;
        } wr_tout12[7:0];
    } QOSB_WRTOUT3 @ 0xA8;
    reg {
        name = "QOSB_RDTOUT0";
        desc = "QOSB_RDTOUT0 is QoSBuf read command timeout period register 0. (offset 0xAC; total reset 0x00000000; PROVEN: Hi3521A/Hi3520D V300 data sheet (Issue 00B07, 2015-12-10), section 4.1.6.2, PDF page 760).";
        field {
            name = "rd_tout3";
            desc = "Read command timeout period (level 3) The configuration mode is the same as that of rd_tout0.";
            sw = rw; hw = r;
            reset = 0x0;
        } rd_tout3[31:24];
        field {
            name = "rd_tout2";
            desc = "Read command timeout period (level 2) The configuration mode is the same as that of rd_tout0.";
            sw = rw; hw = r;
            reset = 0x0;
        } rd_tout2[23:16];
        field {
            name = "rd_tout1";
            desc = "Read command timeout period (level 1) The configuration mode is the same as that of rd_tout0.";
            sw = rw; hw = r;
            reset = 0x0;
        } rd_tout1[15:8];
        field {
            name = "rd_tout0";
            desc = "Read command timeout period (level 0)
- 0x0: The timeout function is disabled. 0x1-0xFF: n x 4 clock cycles

When the timeout period is set to 8 bits, the actual count value is 10 bits. That is, the lower two bits are fixed at 0.";
            sw = rw; hw = r;
            reset = 0x0;
        } rd_tout0[7:0];
    } QOSB_RDTOUT0 @ 0xAC;
    reg {
        name = "QOSB_RDTOUT1";
        desc = "QOSB_RDTOUT1 is QoSBuf read command timeout period register 1. (offset 0xB0; total reset 0x00000000; PROVEN: Hi3521A/Hi3520D V300 data sheet (Issue 00B07, 2015-12-10), section 4.1.6.2, PDF page 761).";
        field {
            name = "rd_tout7";
            desc = "Read command timeout period (level 7) The configuration mode is the same as that of rd_tout0.";
            sw = rw; hw = r;
            reset = 0x0;
        } rd_tout7[31:24];
        field {
            name = "rd_tout6";
            desc = "Read command timeout period (level 6) The configuration mode is the same as that of rd_tout0.";
            sw = rw; hw = r;
            reset = 0x0;
        } rd_tout6[23:16];
        field {
            name = "rd_tout5";
            desc = "Read command timeout period (level 5) The configuration mode is the same as that of rd_tout0.";
            sw = rw; hw = r;
            reset = 0x0;
        } rd_tout5[15:8];
        field {
            name = "rd_tout4";
            desc = "Read command timeout period (level 4) The configuration mode is the same as that of rd_tout0.";
            sw = rw; hw = r;
            reset = 0x0;
        } rd_tout4[7:0];
    } QOSB_RDTOUT1 @ 0xB0;
    reg {
        name = "QOSB_RDTOUT2";
        desc = "QOSB_RDTOUT2 is QoSBuf read command timeout period register 2. (offset 0xB4; total reset 0x00000000; PROVEN: Hi3521A/Hi3520D V300 data sheet (Issue 00B07, 2015-12-10), section 4.1.6.2, PDF page 761).";
        field {
            name = "rd_tout11";
            desc = "Read command timeout period (level 11) The configuration mode is the same as that of rd_tout0.";
            sw = rw; hw = r;
            reset = 0x0;
        } rd_tout11[31:24];
        field {
            name = "rd_tout10";
            desc = "Read command timeout period (level 10) The configuration mode is the same as that of rd_tout0.";
            sw = rw; hw = r;
            reset = 0x0;
        } rd_tout10[23:16];
        field {
            name = "rd_tout9";
            desc = "Read command timeout period (level 9) The configuration mode is the same as that of rd_tout0.";
            sw = rw; hw = r;
            reset = 0x0;
        } rd_tout9[15:8];
        field {
            name = "rd_tout8";
            desc = "Read command timeout period (level 8) The configuration mode is the same as that of rd_tout0.";
            sw = rw; hw = r;
            reset = 0x0;
        } rd_tout8[7:0];
    } QOSB_RDTOUT2 @ 0xB4;
    reg {
        name = "QOSB_RDTOUT3";
        desc = "QOSB_RDTOUT3 is QoSBuf read command timeout period register 3. (offset 0xB8; total reset 0x00000000; PROVEN: Hi3521A/Hi3520D V300 data sheet (Issue 00B07, 2015-12-10), section 4.1.6.2, PDF page 762).";
        field {
            name = "rd_tout15";
            desc = "Read command timeout period (level 15) The configuration mode is the same as that ofrd_tout0.";
            sw = rw; hw = r;
            reset = 0x0;
        } rd_tout15[31:24];
        field {
            name = "rd_tout14";
            desc = "Read command timeout period (level 14) The configuration mode is the same as that ofrd_tout0.";
            sw = rw; hw = r;
            reset = 0x0;
        } rd_tout14[23:16];
        field {
            name = "rd_tout13";
            desc = "Read command timeout period (level 13) The configuration mode is the same as that ofrd_tout0.";
            sw = rw; hw = r;
            reset = 0x0;
        } rd_tout13[15:8];
        field {
            name = "rd_tout12";
            desc = "Read command timeout period (level 12) The configuration mode is the same as that ofrd_tout0.";
            sw = rw; hw = r;
            reset = 0x0;
        } rd_tout12[7:0];
    } QOSB_RDTOUT3 @ 0xB8;
    reg {
        name = "QOSB_WRTOUT_MAP";
        desc = "QOSB_WRTOUT_MAP is a QoSBuf write command timeout mapping mode control register. (offset 0xBC; total reset 0x00000000; PROVEN: Hi3521A/Hi3520D V300 data sheet (Issue 00B07, 2015-12-10), section 4.1.6.2, PDF page 762).";
        field {
            name = "reserved";
            desc = "Reserved";
            sw = r; hw = w;
            reset = 0x0;
        } reserved_31_29[31:29];
        field {
            name = "wrtout_map3";
            desc = "There are 16 levels of timeout periods. Four bits are selected from the ID and the level is determined based on the four bits. wrtout_map3 indicates the position of bit 3 in the ID.";
            sw = rw; hw = r;
            reset = 0x0;
        } wrtout_map3[28:24];
        field {
            name = "reserved";
            desc = "Reserved";
            sw = r; hw = w;
            reset = 0x0;
        } reserved_23_21[23:21];
        field {
            name = "wrtout_map2";
            desc = "There are 16 levels of timeout periods. Four bits are selected from the ID and the level is determined based on the four bits. wrtout_map2 indicates the position of bit 2 in the ID.";
            sw = rw; hw = r;
            reset = 0x0;
        } wrtout_map2[20:16];
        field {
            name = "reserved";
            desc = "Reserved";
            sw = r; hw = w;
            reset = 0x0;
        } reserved_15_13[15:13];
        field {
            name = "wrtout_map1";
            desc = "There are 16 levels of timeout periods. Four bits are selected from the ID and the level is determined based on the four bits. wrtout_map1 indicates the position of bit 1 in the ID.";
            sw = rw; hw = r;
            reset = 0x0;
        } wrtout_map1[12:8];
        field {
            name = "reserved";
            desc = "Reserved";
            sw = r; hw = w;
            reset = 0x0;
        } reserved_7_5[7:5];
        field {
            name = "wrtout_map0";
            desc = "There are 16 levels of timeout periods. Four bits are selected from the ID and the level is determined based on the four bits. wrtout_map0 indicates the position of bit 0 in the ID.";
            sw = rw; hw = r;
            reset = 0x0;
        } wrtout_map0[4:0];
    } QOSB_WRTOUT_MAP @ 0xBC;
    reg {
        name = "QOSB_RDTOUT_MAP";
        desc = "QOSB_RDTOUT_MAP is a QoSBuf read command timeout mapping mode control register. (offset 0xD0; total reset 0x00000000; PROVEN: Hi3521A/Hi3520D V300 data sheet (Issue 00B07, 2015-12-10), section 4.1.6.2, PDF page 763).";
        field {
            name = "reserved";
            desc = "Reserved";
            sw = r; hw = w;
            reset = 0x0;
        } reserved_31_29[31:29];
        field {
            name = "rdtout_map3";
            desc = "There are 16 levels of timeout periods. Four bits are selected from the ID and the level is determined based on the four bits. rdtout_map3 indicates the position of bit 3 in the ID.";
            sw = rw; hw = r;
            reset = 0x0;
        } rdtout_map3[28:24];
        field {
            name = "reserved";
            desc = "Reserved";
            sw = r; hw = w;
            reset = 0x0;
        } reserved_23_21[23:21];
        field {
            name = "rdtout_map2";
            desc = "There are 16 levels of timeout periods. Four bits are selected from the ID and the level is determined based on the four bits. rdtout_map2 indicates the position of bit 2 in the ID.";
            sw = rw; hw = r;
            reset = 0x0;
        } rdtout_map2[20:16];
        field {
            name = "reserved";
            desc = "Reserved";
            sw = r; hw = w;
            reset = 0x0;
        } reserved_15_13[15:13];
        field {
            name = "rdtout_map1";
            desc = "There are 16 levels of timeout periods. Four bits are selected from the ID and the level is determined based on the four bits. rdtout_map1 indicates the position of bit 1 in the ID.";
            sw = rw; hw = r;
            reset = 0x0;
        } rdtout_map1[12:8];
        field {
            name = "reserved";
            desc = "Reserved";
            sw = r; hw = w;
            reset = 0x0;
        } reserved_7_5[7:5];
        field {
            name = "rdtout_map0";
            desc = "There are 16 levels of timeout periods. Four bits are selected from the ID and the level is determined based on the four bits. rdtout_map0 indicates the position of bit 0 in the ID.";
            sw = rw; hw = r;
            reset = 0x0;
        } rdtout_map0[4:0];
    } QOSB_RDTOUT_MAP @ 0xD0;
    reg {
        name = "QOSB_WRAGE0";
        desc = "QOSB_WRAGE0 is QoSBuf write command aging configuration register 0. (offset 0xD4; total reset 0x00000000; PROVEN: Hi3521A/Hi3520D V300 data sheet (Issue 00B07, 2015-12-10), section 4.1.6.2, PDF page 764).";
        field {
            name = "wr_age_prd7";
            desc = "Write command aging cycle (level 7) For details, see wr_age_prd0.";
            sw = rw; hw = r;
            reset = 0x0;
        } wr_age_prd7[31:28];
        field {
            name = "wr_age_prd6";
            desc = "Write command aging cycle (level 6) For details, see wr_age_prd0.";
            sw = rw; hw = r;
            reset = 0x0;
        } wr_age_prd6[27:24];
        field {
            name = "wr_age_prd5";
            desc = "Write command aging cycle (level 5) For details, see wr_age_prd0.";
            sw = rw; hw = r;
            reset = 0x0;
        } wr_age_prd5[23:20];
        field {
            name = "wr_age_prd4";
            desc = "Write command aging cycle (level 4) For details, see wr_age_prd0.";
            sw = rw; hw = r;
            reset = 0x0;
        } wr_age_prd4[19:16];
        field {
            name = "wr_age_prd3";
            desc = "Write command aging cycle (level 3) For details, see wr_age_prd0.";
            sw = rw; hw = r;
            reset = 0x0;
        } wr_age_prd3[15:12];
        field {
            name = "wr_age_prd2";
            desc = "Write command aging cycle (level 2) For details, see wr_age_prd0.";
            sw = rw; hw = r;
            reset = 0x0;
        } wr_age_prd2[11:8];
        field {
            name = "wr_age_prd1";
            desc = "Write command aging cycle (level 1) For details, see wr_age_prd0.";
            sw = rw; hw = r;
            reset = 0x0;
        } wr_age_prd1[7:4];
        field {
            name = "wr_age_prd0";
            desc = "Write command aging cycle (level 0)
- 0x0: The aging function is disabled. 0x1-0xF: (n x 16) clock cycles";
            sw = rw; hw = r;
            reset = 0x0;
        } wr_age_prd0[3:0];
    } QOSB_WRAGE0 @ 0xD4;
    reg {
        name = "QOSB_WRAGE1";
        desc = "QOSB_WRAGE1 is QoSBuf write command aging configuration register 1. (offset 0xD8; total reset 0x00000000; PROVEN: Hi3521A/Hi3520D V300 data sheet (Issue 00B07, 2015-12-10), section 4.1.6.2, PDF page 765).";
        field {
            name = "wr_age_prd15";
            desc = "Write command aging cycle (level 15) For details, see wr_age_prd0.";
            sw = rw; hw = r;
            reset = 0x0;
        } wr_age_prd15[31:28];
        field {
            name = "wr_age_prd14";
            desc = "Write command aging cycle (level 14) For details, see wr_age_prd0.";
            sw = rw; hw = r;
            reset = 0x0;
        } wr_age_prd14[27:24];
        field {
            name = "wr_age_prd13";
            desc = "Write command aging cycle (level 13) For details, see wr_age_prd0.";
            sw = rw; hw = r;
            reset = 0x0;
        } wr_age_prd13[23:20];
        field {
            name = "wr_age_prd12";
            desc = "Write command aging cycle (level 12) For details, see wr_age_prd0.";
            sw = rw; hw = r;
            reset = 0x0;
        } wr_age_prd12[19:16];
        field {
            name = "wr_age_prd11";
            desc = "Write command aging cycle (level 11) For details, see wr_age_prd0.";
            sw = rw; hw = r;
            reset = 0x0;
        } wr_age_prd11[15:12];
        field {
            name = "wr_age_prd10";
            desc = "Write command aging cycle (level 10) For details, see wr_age_prd0.";
            sw = rw; hw = r;
            reset = 0x0;
        } wr_age_prd10[11:8];
        field {
            name = "wr_age_prd9";
            desc = "Write command aging cycle (level 9) For details, see wr_age_prd0.";
            sw = rw; hw = r;
            reset = 0x0;
        } wr_age_prd9[7:4];
        field {
            name = "wr_age_prd8";
            desc = "Write command aging cycle (level 8) For details, see wr_age_prd0.";
            sw = rw; hw = r;
            reset = 0x0;
        } wr_age_prd8[3:0];
    } QOSB_WRAGE1 @ 0xD8;
    reg {
        name = "QOSB_RDAGE0";
        desc = "QOSB_RDAGE0 is QoSBuf read command aging configuration register 0. (offset 0xDC; total reset 0x00000000; PROVEN: Hi3521A/Hi3520D V300 data sheet (Issue 00B07, 2015-12-10), section 4.1.6.2, PDF page 765).";
        field {
            name = "rd_age_prd7";
            desc = "Read command aging cycle (level 7) For details, see rd_age_prd0.";
            sw = rw; hw = r;
            reset = 0x0;
        } rd_age_prd7[31:28];
        field {
            name = "rd_age_prd6";
            desc = "Read command aging cycle (level 6) For details, see rd_age_prd0.";
            sw = rw; hw = r;
            reset = 0x0;
        } rd_age_prd6[27:24];
        field {
            name = "rd_age_prd5";
            desc = "Read command aging cycle (level 5) For details, see rd_age_prd0.";
            sw = rw; hw = r;
            reset = 0x0;
        } rd_age_prd5[23:20];
        field {
            name = "rd_age_prd4";
            desc = "Read command aging cycle (level 4) For details, see rd_age_prd0.";
            sw = rw; hw = r;
            reset = 0x0;
        } rd_age_prd4[19:16];
        field {
            name = "rd_age_prd3";
            desc = "Read command aging cycle (level 3) For details, see rd_age_prd0.";
            sw = rw; hw = r;
            reset = 0x0;
        } rd_age_prd3[15:12];
        field {
            name = "rd_age_prd2";
            desc = "Read command aging cycle (level 2) For details, see rd_age_prd0.";
            sw = rw; hw = r;
            reset = 0x0;
        } rd_age_prd2[11:8];
        field {
            name = "rd_age_prd1";
            desc = "Read command aging cycle (level 1) For details, see rd_age_prd0.";
            sw = rw; hw = r;
            reset = 0x0;
        } rd_age_prd1[7:4];
        field {
            name = "rd_age_prd0";
            desc = "Read command aging cycle (level 0)
- 0x0: The aging function is disabled. 0x1-0xF: (n x 16) clock cycles";
            sw = rw; hw = r;
            reset = 0x0;
        } rd_age_prd0[3:0];
    } QOSB_RDAGE0 @ 0xDC;
    reg {
        name = "QOSB_RDAGE1";
        desc = "QOSB_RDAGE1 is QoSBuf read command aging configuration register 1. (offset 0xE0; total reset 0x00000000; PROVEN: Hi3521A/Hi3520D V300 data sheet (Issue 00B07, 2015-12-10), section 4.1.6.2, PDF page 766).";
        field {
            name = "rd_age_prd15";
            desc = "Read command aging cycle (level 15) For details, see rd_age_prd0.";
            sw = rw; hw = r;
            reset = 0x0;
        } rd_age_prd15[31:28];
        field {
            name = "rd_age_prd14";
            desc = "Read command aging cycle (level 14) For details, see rd_age_prd0.";
            sw = rw; hw = r;
            reset = 0x0;
        } rd_age_prd14[27:24];
        field {
            name = "rd_age_prd13";
            desc = "Read command aging cycle (level 13) For details, see rd_age_prd0.";
            sw = rw; hw = r;
            reset = 0x0;
        } rd_age_prd13[23:20];
        field {
            name = "rd_age_prd12";
            desc = "Read command aging cycle (level 12) For details, see rd_age_prd0.";
            sw = rw; hw = r;
            reset = 0x0;
        } rd_age_prd12[19:16];
        field {
            name = "rd_age_prd11";
            desc = "Read command aging cycle (level 11) For details, see rd_age_prd0.";
            sw = rw; hw = r;
            reset = 0x0;
        } rd_age_prd11[15:12];
        field {
            name = "rd_age_prd10";
            desc = "Read command aging cycle (level 10) For details, see rd_age_prd0.";
            sw = rw; hw = r;
            reset = 0x0;
        } rd_age_prd10[11:8];
        field {
            name = "rd_age_prd9";
            desc = "Read command aging cycle (level 9) For details, see rd_age_prd0.";
            sw = rw; hw = r;
            reset = 0x0;
        } rd_age_prd9[7:4];
        field {
            name = "rd_age_prd8";
            desc = "Read command aging cycle (level 8) For details, see rd_age_prd0.";
            sw = rw; hw = r;
            reset = 0x0;
        } rd_age_prd8[3:0];
    } QOSB_RDAGE1 @ 0xE0;
    reg {
        name = "QOSB_WRAGE_MAP";
        desc = "QOSB_WRAGE_MAP is a QoSBuf write command aging mapping mode control register. (offset 0xE4; total reset 0x00000000; PROVEN: Hi3521A/Hi3520D V300 data sheet (Issue 00B07, 2015-12-10), section 4.1.6.2, PDF page 767).";
        field {
            name = "reserved";
            desc = "Reserved";
            sw = r; hw = w;
            reset = 0x0;
        } reserved_31_29[31:29];
        field {
            name = "wrage_map3";
            desc = "There are 16 levels of aging cycles. Four bits are selected from the ID and the level is determined based on the four bits. wrage_map3 indicates the position of bit 3 in the ID.";
            sw = rw; hw = r;
            reset = 0x0;
        } wrage_map3[28:24];
        field {
            name = "reserved";
            desc = "Reserved";
            sw = r; hw = w;
            reset = 0x0;
        } reserved_23_21[23:21];
        field {
            name = "wrage_map2";
            desc = "There are 16 levels of aging cycles. Four bits are selected from the ID and the level is determined based on the four bits. wrage_map2 indicates the position of bit 2 in the ID.";
            sw = rw; hw = r;
            reset = 0x0;
        } wrage_map2[20:16];
        field {
            name = "reserved";
            desc = "Reserved";
            sw = r; hw = w;
            reset = 0x0;
        } reserved_15_13[15:13];
        field {
            name = "wrage_map1";
            desc = "There are 16 levels of aging cycles. Four bits are selected from the ID and the level is determined based on the four bits. wrage_map1 indicates the position of bit 1 in the ID.";
            sw = rw; hw = r;
            reset = 0x0;
        } wrage_map1[12:8];
        field {
            name = "reserved";
            desc = "Reserved";
            sw = r; hw = w;
            reset = 0x0;
        } reserved_7_5[7:5];
        field {
            name = "wrage_map0";
            desc = "There are 16 levels of aging cycles. Four bits are selected from the ID and the level is determined based on the four bits. wrage_map0 indicates the position of bit 0 in the ID.";
            sw = rw; hw = r;
            reset = 0x0;
        } wrage_map0[4:0];
    } QOSB_WRAGE_MAP @ 0xE4;
    reg {
        name = "QOSB_RDAGE_MAP";
        desc = "QOSB_RDAGE_MAP is a QoSBuf read command aging mapping mode control register. (offset 0xE8; total reset 0x00000000; PROVEN: Hi3521A/Hi3520D V300 data sheet (Issue 00B07, 2015-12-10), section 4.1.6.2, PDF page 768).";
        field {
            name = "reserved";
            desc = "Reserved";
            sw = r; hw = w;
            reset = 0x0;
        } reserved_31_29[31:29];
        field {
            name = "rdage_map3";
            desc = "There are 16 levels of aging cycles. Four bits are selected from the ID and the level is determined based on the four bits. rdage_map3 indicates the position of bit 3 in the ID.";
            sw = rw; hw = r;
            reset = 0x0;
        } rdage_map3[28:24];
        field {
            name = "reserved";
            desc = "Reserved";
            sw = r; hw = w;
            reset = 0x0;
        } reserved_23_21[23:21];
        field {
            name = "rdage_map2";
            desc = "There are 16 levels of aging cycles. Four bits are selected from the ID and the level is determined based on the four bits. rdage_map2 indicates the position of bit 2 in the ID.";
            sw = rw; hw = r;
            reset = 0x0;
        } rdage_map2[20:16];
        field {
            name = "reserved";
            desc = "Reserved";
            sw = r; hw = w;
            reset = 0x0;
        } reserved_15_13[15:13];
        field {
            name = "rdage_map1";
            desc = "There are 16 levels of aging cycles. Four bits are selected from the ID and the level is determined based on the four bits. rdage_map1 indicates the position of bit 1 in the ID.";
            sw = rw; hw = r;
            reset = 0x0;
        } rdage_map1[12:8];
        field {
            name = "reserved";
            desc = "Reserved";
            sw = r; hw = w;
            reset = 0x0;
        } reserved_7_5[7:5];
        field {
            name = "rdage_map0";
            desc = "There are 16 levels of aging cycles. Four bits are selected from the ID and the level is determined based on the four bits. rdage_map0 indicates the position of bit 0 in the ID.";
            sw = rw; hw = r;
            reset = 0x0;
        } rdage_map0[4:0];
    } QOSB_RDAGE_MAP @ 0xE8;
    reg {
        name = "QOSB_ROWHIT_PRILVL";
        desc = "QOSB_ROWHIT_PRILVL is a QoSBuf row-hit priority threshold register. (offset 0xEC; total reset 0x00000000; PROVEN: Hi3521A/Hi3520D V300 data sheet (Issue 00B07, 2015-12-10), section 4.1.6.2, PDF page 769).";
        field {
            name = "reserved";
            desc = "Reserved";
            sw = r; hw = w;
            reset = 0x0;
        } reserved_31_15[31:15];
        field {
            name = "ch3_rowhit_pri_lvl";
            desc = "Channel 3 priority threshold If the current priority is lower than ch3_rohit_pri_lvl, the priority is changed to ch3_rowhit_pri1. If the current priority is higher than ch3_rohit_pri_lvl, the priority is changed to ch3_rowhit_pri0.";
            sw = rw; hw = r;
            reset = 0x0;
        } ch3_rowhit_pri_lvl[14:12];
        field {
            name = "reserved";
            desc = "Reserved";
            sw = r; hw = w;
            reset = 0x0;
        } reserved_11_11[11:11];
        field {
            name = "ch2_rowhit_pri_lvl";
            desc = "Channel 2 priority threshold If the current priority is lower than ch2_rohit_pri_lvl, the priority is changed to ch2_rowhit_pri1. If the current priority is higher than ch2_rohit_pri_lvl, the priority is changed to ch2_rowhit_pri0.";
            sw = rw; hw = r;
            reset = 0x0;
        } ch2_rowhit_pri_lvl[10:8];
        field {
            name = "reserved";
            desc = "Reserved";
            sw = r; hw = w;
            reset = 0x0;
        } reserved_7_7[7:7];
        field {
            name = "ch1_rowhit_pri_lvl";
            desc = "Channel 1 priority threshold If the current priority is lower than ch1_rohit_pri_lvl, the priority is changed to ch1_rowhit_pri1. If the current priority is higher than ch1_rohit_pri_lvl, the priority is changed to ch1_rowhit_pri0.";
            sw = rw; hw = r;
            reset = 0x0;
        } ch1_rowhit_pri_lvl[6:4];
        field {
            name = "reserved";
            desc = "Reserved";
            sw = r; hw = w;
            reset = 0x0;
        } reserved_3_3[3:3];
        field {
            name = "ch0_rowhit_pri_lvl";
            desc = "Channel 0 priority threshold If the current priority is lower than ch0_rohit_pri_lvl, the priority is changed to ch0_rowhit_pri1. If the current priority is higher than ch0_rohit_pri_lvl, the priority is changed to ch0_rowhit_pri0.";
            sw = rw; hw = r;
            reset = 0x0;
        } ch0_rowhit_pri_lvl[2:0];
    } QOSB_ROWHIT_PRILVL @ 0xEC;
    reg {
        name = "QOSB_ROWHIT_PRI";
        desc = "QOSB_ROWHIT_PRI is a QoSBuf row-hit priority control register. (offset 0xF0; total reset 0x00000000; PROVEN: Hi3521A/Hi3520D V300 data sheet (Issue 00B07, 2015-12-10), section 4.1.6.2, PDF page 770).";
        field {
            name = "reserved";
            desc = "Reserved";
            sw = r; hw = w;
            reset = 0x0;
        } reserved_31_31[31:31];
        field {
            name = "ch3_rowhit_pri1";
            desc = "See ch3_rowhit_pri_lvl.";
            sw = rw; hw = r;
            reset = 0x0;
        } ch3_rowhit_pri1[30:28];
        field {
            name = "reserved";
            desc = "Reserved";
            sw = r; hw = w;
            reset = 0x0;
        } reserved_27_27[27:27];
        field {
            name = "ch3_rowhit_pri0";
            desc = "See ch3_rowhit_pri_lvl.";
            sw = rw; hw = r;
            reset = 0x0;
        } ch3_rowhit_pri0[26:24];
        field {
            name = "reserved";
            desc = "Reserved";
            sw = r; hw = w;
            reset = 0x0;
        } reserved_23_23[23:23];
        field {
            name = "ch2_rowhit_pri1";
            desc = "See ch2_rowhit_pri_lvl.";
            sw = rw; hw = r;
            reset = 0x0;
        } ch2_rowhit_pri1[22:20];
        field {
            name = "reserved";
            desc = "Reserved";
            sw = r; hw = w;
            reset = 0x0;
        } reserved_19_19[19:19];
        field {
            name = "ch2_rowhit_pri0";
            desc = "See ch2_rowhit_pri_lvl.";
            sw = rw; hw = r;
            reset = 0x0;
        } ch2_rowhit_pri0[18:16];
        field {
            name = "reserved";
            desc = "Reserved";
            sw = r; hw = w;
            reset = 0x0;
        } reserved_15_15[15:15];
        field {
            name = "ch1_rowhit_pri1";
            desc = "See ch1_rowhit_pri_lvl.";
            sw = rw; hw = r;
            reset = 0x0;
        } ch1_rowhit_pri1[14:12];
        field {
            name = "reserved";
            desc = "Reserved";
            sw = r; hw = w;
            reset = 0x0;
        } reserved_11_11[11:11];
        field {
            name = "ch1_rowhit_pri0";
            desc = "See ch1_rowhit_pri_lvl.";
            sw = rw; hw = r;
            reset = 0x0;
        } ch1_rowhit_pri0[10:8];
        field {
            name = "reserved";
            desc = "Reserved";
            sw = r; hw = w;
            reset = 0x0;
        } reserved_7_7[7:7];
        field {
            name = "ch0_rowhit_pri1";
            desc = "See ch0_rowhit_pri_lvl.";
            sw = rw; hw = r;
            reset = 0x0;
        } ch0_rowhit_pri1[6:4];
        field {
            name = "reserved";
            desc = "Reserved";
            sw = r; hw = w;
            reset = 0x0;
        } reserved_3_3[3:3];
        field {
            name = "ch0_rowhit_pri0";
            desc = "See ch0_rowhit_pri_lvl.";
            sw = rw; hw = r;
            reset = 0x0;
        } ch0_rowhit_pri0[2:0];
    } QOSB_ROWHIT_PRI @ 0xF0;
    reg {
        name = "QOSB_ROWHIT_CTRL";
        desc = "QOSB_ROWHIT_CTRL is a QoSBuf row-hit enable register. (offset 0xF4; total reset 0x00000000; PROVEN: Hi3521A/Hi3520D V300 data sheet (Issue 00B07, 2015-12-10), section 4.1.6.2, PDF page 771).";
        field {
            name = "reserved";
            desc = "Reserved";
            sw = r; hw = w;
            reset = 0x0;
        } reserved_31_8[31:8];
        field {
            name = "ch3_dual_flow_en";
            desc = "Channel 3 row-hit dual-stream enable
- 0: disabled
- 1: enabled";
            sw = rw; hw = r;
            reset = 0x0;
        } ch3_dual_flow_en[7:7];
        field {
            name = "ch2_dual_flow_en";
            desc = "Channel 2 row-hit dual-stream enable
- 0: disabled
- 1: enabled";
            sw = rw; hw = r;
            reset = 0x0;
        } ch2_dual_flow_en[6:6];
        field {
            name = "ch1_dual_flow_en";
            desc = "Channel 1 row-hit dual-stream enable
- 0: disabled
- 1: enabled";
            sw = rw; hw = r;
            reset = 0x0;
        } ch1_dual_flow_en[5:5];
        field {
            name = "ch0_dual_flow_en";
            desc = "Channel 0 row-hit dual-stream enable
- 0: disabled
- 1: enabled";
            sw = rw; hw = r;
            reset = 0x0;
        } ch0_dual_flow_en[4:4];
        field {
            name = "ch3_row_hit_en";
            desc = "Channel 3 row-hit enable
- 0: disabled
- 1: enabled";
            sw = rw; hw = r;
            reset = 0x0;
        } ch3_row_hit_en[3:3];
        field {
            name = "ch2_row_hit_en";
            desc = "Channel 2 row-hit enable
- 0: disabled
- 1: enabled";
            sw = rw; hw = r;
            reset = 0x0;
        } ch2_row_hit_en[2:2];
        field {
            name = "ch1_row_hit_en";
            desc = "Channel 1 row-hit enable
- 0: disabled
- 1: enabled";
            sw = rw; hw = r;
            reset = 0x0;
        } ch1_row_hit_en[1:1];
        field {
            name = "ch0_row_hit_en";
            desc = "Channel 0 row-hit enable
- 0: disabled
- 1: enabled";
            sw = rw; hw = r;
            reset = 0x0;
        } ch0_row_hit_en[0:0];
    } QOSB_ROWHIT_CTRL @ 0xF4;
    reg {
        name = "QOSB_CKG_CFG";
        desc = "QOSB_CKG_CFG is a QoSBuf clock control register. (offset 0x108; total reset 0x00000001; PROVEN: Hi3521A/Hi3520D V300 data sheet (Issue 00B07, 2015-12-10), section 4.1.6.2, PDF page 772).";
        field {
            name = "reserved";
            desc = "Reserved";
            sw = r; hw = w;
            reset = 0x0;
        } reserved_31_1[31:1];
        field {
            name = "dyn_ck_gate";
            desc = "Dynamic clock gating for the QoSBuf module
- 0: The clock is always enabled.
- 1: The clock gating is automatic when the module is idle.";
            sw = rw; hw = r;
            reset = 0x1;
        } dyn_ck_gate[0:0];
    } QOSB_CKG_CFG @ 0x108;
    reg QOSB_DMC_LVL_t {
        name = "QOSB_DMC_LVL";
        desc = "QOSB_DMC_LVL is a QoSBuf threshold control register for commands that enter the DMC module. (offset 0x10C, 2 instances at stride 0x4; total reset 0x0000000F; PROVEN: Hi3521A/Hi3520D V300 data sheet (Issue 00B07, 2015-12-10), section 4.1.6.2, PDF page 772).";
        field {
            name = "reserved";
            desc = "Reserved";
            sw = r; hw = w;
            reset = 0x0;
        } reserved_31_5[31:5];
        field {
            name = "dmc_cmd_full_lvl";
            desc = "Number of QoSBuf commands that enter the DMC module. When this threshold is reached, the DMC queue is full. When this field is set to N, the actual number of commands that enter the DMC module is (N + 1) because of the pipeline issue. This register cannot be dynamically configured when it is being accessed.";
            sw = rw; hw = r;
            reset = 0xf;
        } dmc_cmd_full_lvl[4:0];
    };
    QOSB_DMC_LVL_t QOSB_DMC_LVL_0 @ 0x10C;
    QOSB_DMC_LVL_t QOSB_DMC_LVL_1 @ 0x110;
    reg {
        name = "QOSB_CFG_PERF";
        desc = "QOSB_CFG_PERF is a QoSBuf performance statistics mode register. (offset 0x120; total reset 0x00000000; PROVEN: Hi3521A/Hi3520D V300 data sheet (Issue 00B07, 2015-12-10), section 4.1.6.2, PDF page 773).";
        field {
            name = "reserved";
            desc = "Reserved";
            sw = r; hw = w;
            reset = 0x0;
        } reserved_31_30[31:30];
        field {
            name = "perf_en";
            desc = "Performance statistics enable
- 1: enabled
- 0: disabled

When perf_mode is 0 and this bit is enabled, the performance statistics register starts the cyclic count. When perf_mode is 1, this bit is automatically cleared after the counting is complete.";
            sw = rw; hw = r;
            reset = 0x0;
        } perf_en[29:29];
        field {
            name = "perf_mode";
            desc = "Performance statistical mode
- 0: continuous trigger mode. Counters related to performance statistics keep counting to ensure that no data overflows within 1s.
- 1: single trigger mode. When the performance statistical period reaches the value of perf_prd, the statistical result retains and the counting stops.

The maximum statistical result retains after an overflow occurs.";
            sw = rw; hw = r;
            reset = 0x0;
        } perf_mode[28:28];
        field {
            name = "perf_prd";
            desc = "Performance statistical cycle
- 0x0: invalid 0x1-0xFFFFFFF: statistical cycle

The actual statistical cycle is (perf_prd x 16 x tclk). tclk is the bus clock cycle of the DDRC. This configuration is valid only when perf_mode is 1. When perf_mode is 0, counters related to performance statistics keep counting.";
            sw = rw; hw = r;
            reset = 0x0;
        } perf_prd[27:0];
    } QOSB_CFG_PERF @ 0x120;
    reg {
        name = "QOSB_CMD_SUM";
        desc = "QOSB_CMD_SUM is a QoSBuf accumulated command count register. (offset 0x124; total reset 0x00000000; PROVEN: Hi3521A/Hi3520D V300 data sheet (Issue 00B07, 2015-12-10), section 4.1.6.2, PDF page 774).";
        field {
            name = "qos_cmd_sum";
            desc = "Accumulated value of the commands that are temporarily stored in the QoSBuf in the cycle. The value is wrapped if an overflow occurs.";
            sw = r; hw = w;
            reset = 0x0;
        } qos_cmd_sum[31:0];
    } QOSB_CMD_SUM @ 0x124;
    reg {
        name = "QOSB_SLOT_STAT0";
        desc = "QOSB_SLOT_STAT0 is QoSBuf queue status register 0. (offset 0x128; total reset 0x00000000; PROVEN: Hi3521A/Hi3520D V300 data sheet (Issue 00B07, 2015-12-10), section 4.1.6.2, PDF page 774).";
        field {
            name = "grp_cmd_valid_l";
            desc = "Status of bits 0-31 in the QoSBuf cmd queue. If a bit is set to 1, there are commands stored in the corresponding slot; otherwise, the slot is empty.";
            sw = r; hw = w;
            reset = 0x0;
        } grp_cmd_valid_l[31:0];
    } QOSB_SLOT_STAT0 @ 0x128;
    reg {
        name = "QOSB_SLOT_STAT1";
        desc = "QOSB_SLOT_STAT1 is QoSBuf queue status register 1. (offset 0x12C; total reset 0x00000000; PROVEN: Hi3521A/Hi3520D V300 data sheet (Issue 00B07, 2015-12-10), section 4.1.6.2, PDF page 774).";
        field {
            name = "grp_cmd_valid_m0";
            desc = "Status of bits 32-63 in the QoSBuf cmd queue. If a bit is set to 1, there are commands stored in the corresponding slot; otherwise, the slot is empty.";
            sw = r; hw = w;
            reset = 0x0;
        } grp_cmd_valid_m0[31:0];
    } QOSB_SLOT_STAT1 @ 0x12C;
    reg {
        name = "QOSB_SLOT_STAT2";
        desc = "QOSB_SLOT_STAT2 is QoSBuf queue status register 2. (offset 0x130; total reset 0x00000000; PROVEN: Hi3521A/Hi3520D V300 data sheet (Issue 00B07, 2015-12-10), section 4.1.6.2, PDF page 775).";
        field {
            name = "grp_cmd_valid_m1";
            desc = "Status of bits 64-95 in the QoSBuf cmd queue. If a bit is set to 1, there are commands stored in the corresponding slot; otherwise, the slot is empty.";
            sw = r; hw = w;
            reset = 0x0;
        } grp_cmd_valid_m1[31:0];
    } QOSB_SLOT_STAT2 @ 0x130;
    reg {
        name = "QOSB_SLOT_STAT3";
        desc = "QOSB_SLOT_STAT3 is QoSBuf queue status register 3. (offset 0x134; total reset 0x00000000; PROVEN: Hi3521A/Hi3520D V300 data sheet (Issue 00B07, 2015-12-10), section 4.1.6.2, PDF page 775).";
        field {
            name = "grp_cmd_valid_h";
            desc = "Status of bits 96-127 in the QoSBuf cmd queue. If a bit is set to 1, there are commands stored in the corresponding slot; otherwise, the slot is empty.";
            sw = r; hw = w;
            reset = 0x0;
        } grp_cmd_valid_h[31:0];
    } QOSB_SLOT_STAT3 @ 0x134;
    reg QOSB_WBUF_STAT0_t {
        name = "QOSB_WBUF_STAT0";
        desc = "QOSB_WBUF_STAT0 is QoSBuf write buffer status register 0. (offset 0x140, 2 instances at stride 0x4; total reset 0x00000000; PROVEN: Hi3521A/Hi3520D V300 data sheet (Issue 00B07, 2015-12-10), section 4.1.6.2, PDF page 776).";
        field {
            name = "buf_ldata_valid_l";
            desc = "Status of write buffers 0-31 in the QoSBuf. If a bit is set to 1, a burst is stored in the corresponding buffer; otherwise, the data amount is less than a burst or the buffer is empty.";
            sw = r; hw = w;
            reset = 0x0;
        } buf_ldata_valid_l[31:0];
    };
    QOSB_WBUF_STAT0_t QOSB_WBUF_STAT0_0 @ 0x140;
    QOSB_WBUF_STAT0_t QOSB_WBUF_STAT0_1 @ 0x144;
    reg QOSB_WBUF_STAT1_t {
        name = "QOSB_WBUF_STAT1";
        desc = "QOSB_WBUF_STAT1 is QoSBuf write buffer status register 1. (offset 0x150, 2 instances at stride 0x4; total reset 0x00000000; PROVEN: Hi3521A/Hi3520D V300 data sheet (Issue 00B07, 2015-12-10), section 4.1.6.2, PDF page 776).";
        field {
            name = "buf_ldata_valid_h";
            desc = "Status of write buffers 32-63 in the QoSBuf. If a bit is set to 1, a burst is stored in the corresponding buffer; otherwise, the data amount is less than a burst or the buffer is empty.";
            sw = r; hw = w;
            reset = 0x0;
        } buf_ldata_valid_h[31:0];
    };
    QOSB_WBUF_STAT1_t QOSB_WBUF_STAT1_0 @ 0x150;
    QOSB_WBUF_STAT1_t QOSB_WBUF_STAT1_1 @ 0x154;
    reg QOSB_RDRBUF_STAT_t {
        name = "QOSB_RDRBUF_STAT";
        desc = "QOSB_RDRBUF_STAT is a buffer status register for the Reorder module. (offset 0x160, 2 instances at stride 0x4; total reset 0x00000000; PROVEN: Hi3521A/Hi3520D V300 data sheet (Issue 00B07, 2015-12-10), section 4.1.6.2, PDF page 777).";
        field {
            name = "e_vld";
            desc = "Status of reorder buffers 0-31 in the Reorder. If a bit is set to 1, a burst is stored in the corresponding buffer; otherwise, the data amount is less than a burst or the buffer is empty.";
            sw = r; hw = w;
            reset = 0x0;
        } e_vld[31:0];
    };
    QOSB_RDRBUF_STAT_t QOSB_RDRBUF_STAT_0 @ 0x160;
    QOSB_RDRBUF_STAT_t QOSB_RDRBUF_STAT_1 @ 0x164;
    reg {
        name = "QOSB_INTMSK";
        desc = "QOSB_INTMSK is a QoSBuf interrupt mask register. (offset 0x170; total reset 0x00000000; PROVEN: Hi3521A/Hi3520D V300 data sheet (Issue 00B07, 2015-12-10), section 4.1.6.2, PDF page 777).";
        field {
            name = "reserved";
            desc = "Reserved";
            sw = r; hw = w;
            reset = 0x0;
        } reserved_31_1[31:1];
        field {
            name = "qos_stat_int_mask";
            desc = "QoSBuf command statistics interrupt mask enable
- 1: masked
- 0: enabled";
            sw = rw; hw = r;
            reset = 0x0;
        } qos_stat_int_mask[0:0];
    } QOSB_INTMSK @ 0x170;
    reg {
        name = "QOSB_RINT";
        desc = "QOSB_RINT is a QoSBuf raw interrupt register. (offset 0x174; total reset 0x00000000; PROVEN: Hi3521A/Hi3520D V300 data sheet (Issue 00B07, 2015-12-10), section 4.1.6.2, PDF page 778).";
        field {
            name = "reserved";
            desc = "Reserved";
            sw = r; hw = w;
            reset = 0x0;
        } reserved_31_1[31:1];
        field {
            name = "qos_stat_rint";
            desc = "QoSBuf command statistics interrupt. Writing 1 clears the interrupt.

Access type INT_WC in the data sheet: written 1 clears the bit.";
            sw = rw; hw = w; onwrite = woclr;
            reset = 0x0;
        } qos_stat_rint[0:0];
    } QOSB_RINT @ 0x174;
    reg {
        name = "QOSB_INTSTS";
        desc = "QOSB_INTSTS is a QoSBuf interrupt status register. (offset 0x178; total reset 0x00000000; PROVEN: Hi3521A/Hi3520D V300 data sheet (Issue 00B07, 2015-12-10), section 4.1.6.2, PDF page 778).";
        field {
            name = "reserved";
            desc = "Reserved";
            sw = r; hw = w;
            reset = 0x0;
        } reserved_31_1[31:1];
        field {
            name = "qos_stat_intsts";
            desc = "QoSBuf command statistics interrupt

Access type INT (interrupt status) in the data sheet.";
            sw = r; hw = w;
            reset = 0x0;
        } qos_stat_intsts[0:0];
    } QOSB_INTSTS @ 0x178;
    reg {
        name = "QOSB_CMD_CNT";
        desc = "QOSB_CMD_CNT is a QoSBuf command statistics register. (offset 0x180; total reset 0x00000000; PROVEN: Hi3521A/Hi3520D V300 data sheet (Issue 00B07, 2015-12-10), section 4.1.6.2, PDF page 779).";
        field {
            name = "reserved";
            desc = "Reserved";
            sw = r; hw = w;
            reset = 0x0;
        } reserved_31_8[31:8];
        field {
            name = "qos_cmd_cnt";
            desc = "Number of commands in the QoSBuf, including those on the pipeline

Access type INT (interrupt status) in the data sheet.";
            sw = r; hw = w;
            reset = 0x0;
        } qos_cmd_cnt[7:0];
    } QOSB_CMD_CNT @ 0x180;
    reg QOSB_RNK_CNT_t {
        name = "QOSB_RNK_CNT";
        desc = "QOSB_RNK_CNT is a QoSBuf command (in each rank) statistics register. (offset 0x190, 2 instances at stride 0x4; total reset 0x00000000; PROVEN: Hi3521A/Hi3520D V300 data sheet (Issue 00B07, 2015-12-10), section 4.1.6.2, PDF page 779).";
        field {
            name = "reserved";
            desc = "Reserved";
            sw = r; hw = w;
            reset = 0x0;
        } reserved_31_8[31:8];
        field {
            name = "rnk0_cmd_cnt";
            desc = "Number of rank 0 commands in the current channel in the QoSBuf";
            sw = r; hw = w;
            reset = 0x0;
        } rnk0_cmd_cnt[7:0];
    };
    QOSB_RNK_CNT_t QOSB_RNK_CNT_0 @ 0x190;
    QOSB_RNK_CNT_t QOSB_RNK_CNT_1 @ 0x194;
    reg QOSB_BNK_CNT0_t {
        name = "QOSB_BNK_CNT0";
        desc = "QOSB_BNK_CNT0 is a QoSBuf command (in each bank) statistics register. (offset 0x1A0, 2 instances at stride 0x4; total reset 0x00000000; PROVEN: Hi3521A/Hi3520D V300 data sheet (Issue 00B07, 2015-12-10), section 4.1.6.2, PDF page 779).";
        field {
            name = "bnk3_cmd_cnt";
            desc = "Number of bank 3 commands in the current channel in the DMC";
            sw = r; hw = w;
            reset = 0x0;
        } bnk3_cmd_cnt[31:24];
        field {
            name = "bnk2_cmd_cnt";
            desc = "Number of bank 2 commands in the current channel in the DMC";
            sw = r; hw = w;
            reset = 0x0;
        } bnk2_cmd_cnt[23:16];
        field {
            name = "bnk1_cmd_cnt";
            desc = "Number of bank 1 commands in the current channel in the DMC";
            sw = r; hw = w;
            reset = 0x0;
        } bnk1_cmd_cnt[15:8];
        field {
            name = "bnk0_cmd_cnt";
            desc = "Number of bank 0 commands in the current channel in the DMC";
            sw = r; hw = w;
            reset = 0x0;
        } bnk0_cmd_cnt[7:0];
    };
    QOSB_BNK_CNT0_t QOSB_BNK_CNT0_0 @ 0x1A0;
    QOSB_BNK_CNT0_t QOSB_BNK_CNT0_1 @ 0x1A4;
    reg QOSB_BNK_CNT1_t {
        name = "QOSB_BNK_CNT1";
        desc = "QOSB_BNK_CNT1 is a QoSBuf command (in each bank) statistics register. (offset 0x1B0, 2 instances at stride 0x4; total reset 0x00000000; PROVEN: Hi3521A/Hi3520D V300 data sheet (Issue 00B07, 2015-12-10), section 4.1.6.2, PDF page 780).";
        field {
            name = "bnk7_cmd_cnt";
            desc = "Number of bank 7 commands in the current channel in the DMC";
            sw = r; hw = w;
            reset = 0x0;
        } bnk7_cmd_cnt[31:24];
        field {
            name = "bnk6_cmd_cnt";
            desc = "Number of bank 6 commands in the current channel in the DMC";
            sw = r; hw = w;
            reset = 0x0;
        } bnk6_cmd_cnt[23:16];
        field {
            name = "bnk5_cmd_cnt";
            desc = "Number of bank 5 commands in the current channel in the DMC";
            sw = r; hw = w;
            reset = 0x0;
        } bnk5_cmd_cnt[15:8];
        field {
            name = "bnk4_cmd_cnt";
            desc = "Number of bank 4 commands in the current channel in the DMC";
            sw = r; hw = w;
            reset = 0x0;
        } bnk4_cmd_cnt[7:0];
    };
    QOSB_BNK_CNT1_t QOSB_BNK_CNT1_0 @ 0x1B0;
    QOSB_BNK_CNT1_t QOSB_BNK_CNT1_1 @ 0x1B4;
    reg QOSB_BNK_CNT2_t {
        name = "QOSB_BNK_CNT2";
        desc = "QOSB_BNK_CNT2 is a QoSBuf command (in each bank) statistics register. (offset 0x1C0, 2 instances at stride 0x4; total reset 0x00000000; PROVEN: Hi3521A/Hi3520D V300 data sheet (Issue 00B07, 2015-12-10), section 4.1.6.2, PDF page 780).";
        field {
            name = "bnk11_cmd_cnt";
            desc = "Number of bank 11 commands in the current channel in the DMC";
            sw = r; hw = w;
            reset = 0x0;
        } bnk11_cmd_cnt[31:24];
        field {
            name = "bnk10_cmd_cnt";
            desc = "Number of bank 10 commands in the current channel in the DMC";
            sw = r; hw = w;
            reset = 0x0;
        } bnk10_cmd_cnt[23:16];
        field {
            name = "bnk9_cmd_cnt";
            desc = "Number of bank 9 commands in the current channel in the DMC";
            sw = r; hw = w;
            reset = 0x0;
        } bnk9_cmd_cnt[15:8];
        field {
            name = "bnk8_cmd_cnt";
            desc = "Number of bank 8 commands in the current channel in the DMC";
            sw = r; hw = w;
            reset = 0x0;
        } bnk8_cmd_cnt[7:0];
    };
    QOSB_BNK_CNT2_t QOSB_BNK_CNT2_0 @ 0x1C0;
    QOSB_BNK_CNT2_t QOSB_BNK_CNT2_1 @ 0x1C4;
    reg QOSB_BNK_CNT3_t {
        name = "QOSB_BNK_CNT3";
        desc = "QOSB_BNK_CNT3 is a QoSBuf command (in each bank) statistics register. (offset 0x1D0, 2 instances at stride 0x4; total reset 0x00000000; PROVEN: Hi3521A/Hi3520D V300 data sheet (Issue 00B07, 2015-12-10), section 4.1.6.2, PDF page 781).";
        field {
            name = "bnk15_cmd_cnt";
            desc = "Number of bank 15 commands in the current channel in the DMC";
            sw = r; hw = w;
            reset = 0x0;
        } bnk15_cmd_cnt[31:24];
        field {
            name = "bnk14_cmd_cnt";
            desc = "Number of bank 14 commands in the current channel in the DMC";
            sw = r; hw = w;
            reset = 0x0;
        } bnk14_cmd_cnt[23:16];
        field {
            name = "bnk13_cmd_cnt";
            desc = "Number of bank 13 commands in the current channel in the DMC";
            sw = r; hw = w;
            reset = 0x0;
        } bnk13_cmd_cnt[15:8];
        field {
            name = "bnk12_cmd_cnt";
            desc = "Number of bank 12 commands in the current channel in the DMC";
            sw = r; hw = w;
            reset = 0x0;
        } bnk12_cmd_cnt[7:0];
    };
    QOSB_BNK_CNT3_t QOSB_BNK_CNT3_0 @ 0x1D0;
    QOSB_BNK_CNT3_t QOSB_BNK_CNT3_1 @ 0x1D4;
    reg {
        name = "QOSB_OSTD_CNT";
        desc = "QOSB_OSTD_CNT is a QoSBuf OSTD command (in each channel) statistics register. (offset 0x1E0; total reset 0x00000000; PROVEN: Hi3521A/Hi3520D V300 data sheet (Issue 00B07, 2015-12-10), section 4.1.6.2, PDF page 781).";
        field {
            name = "reserved";
            desc = "Reserved";
            sw = r; hw = w;
            reset = 0x0;
        } reserved_31_16[31:16];
        field {
            name = "ch1_cmd_ostd";
            desc = "Number of OSTD commands in channel 1 in the QoSBuf";
            sw = r; hw = w;
            reset = 0x0;
        } ch1_cmd_ostd[15:8];
        field {
            name = "ch0_cmd_ostd";
            desc = "Number of OSTD commands in channel 0 in the QoSBuf";
            sw = r; hw = w;
            reset = 0x0;
        } ch0_cmd_ostd[7:0];
    } QOSB_OSTD_CNT @ 0x1E0;
    reg {
        name = "QOSB_WR_CMD_SUM";
        desc = "QOSB_WR_CMD_SUM is a QoSBuf accumulated write command count register. (offset 0x1E4; total reset 0x00000000; PROVEN: Hi3521A/Hi3520D V300 data sheet (Issue 00B07, 2015-12-10), section 4.1.6.2, PDF page 782).";
        field {
            name = "qos_wr_cmd_sum";
            desc = "Accumulated value of the write commands that are temporarily stored in the QoSBuf in the cycle. The value is wrapped if an overflow occurs.";
            sw = r; hw = w;
            reset = 0x0;
        } qos_wr_cmd_sum[31:0];
    } QOSB_WR_CMD_SUM @ 0x1E4;
    reg {
        name = "QOSB_RD_CMD_SUM";
        desc = "QOSB_RD_CMD_SUM is a QoSBuf accumulated read command count register. (offset 0x1E8; total reset 0x00000000; PROVEN: Hi3521A/Hi3520D V300 data sheet (Issue 00B07, 2015-12-10), section 4.1.6.2, PDF page 782).";
        field {
            name = "qos_rd_cmd_sum";
            desc = "Accumulated value of the read commands that are temporarily stored in the QoSBuf in the cycle. The value is wrapped if an overflow occurs.";
            sw = r; hw = w;
            reset = 0x0;
        } qos_rd_cmd_sum[31:0];
    } QOSB_RD_CMD_SUM @ 0x1E8;
    reg {
        name = "QOSB_TIMEOUT_MODE";
        desc = "QOSB_TIMEOUT_MODE is a QoSBuf timeout mode selection register. (offset 0x1F0; total reset 0x00000000; PROVEN: Hi3521A/Hi3520D V300 data sheet (Issue 00B07, 2015-12-10), section 4.1.6.2, PDF page 783).";
        field {
            name = "reserved";
            desc = "Reserved";
            sw = r; hw = w;
            reset = 0x0;
        } reserved_31_1[31:1];
        field {
            name = "timeout_mode";
            desc = "Read/Write command timeout mapping mode select
- 0: The timeout mode is mapped by using the ID and there are 16 levels of timeout periods. For details about the definition of each level, see QOSB_WRTOUT0 to QOSB_WRTOUT3 or

QOSB_RDTOUT0 to QOSB_RDTOUT3.
- 1: The timeout mode is mapped by using the priority and there are eight levels of timeout periods. The levels in the priority mapping table are the same as the lower eight levels in the ID mapping table.";
            sw = rw; hw = r;
            reset = 0x0;
        } timeout_mode[0:0];
    } QOSB_TIMEOUT_MODE @ 0x1F0;
    reg {
        name = "QOSB_WBUF_PRI_CTRL";
        desc = "QOSB_WBUF_PRI_CTRL is a QoSBuf write buffer priority adjustment control register. (offset 0x1F4; total reset 0x00200000; PROVEN: Hi3521A/Hi3520D V300 data sheet (Issue 00B07, 2015-12-10), section 4.1.6.2, PDF page 783).";
        field {
            name = "wbuf_hcnt";
            desc = "The value of this field is used by the internal counter only when the number of write commands reaches the value of QOSB_WBUF_CTRL[wbuf_lvl2] (write buffer threshold 2). When the number reaches wbuf_lvl2, the internal counter starts counting. The priorities of the write commands in the write buffer are increased to pri2 until the count value reaches wbuf_hcnt. Note: pri2 indicates the priority of the write buffer threshold 2. For details, see QOSB_WBUF_CTRL[wbuf_pri2].";
            sw = rw; hw = r;
            reset = 0x20;
        } wbuf_hcnt[31:16];
        field {
            name = "wbuf_lcnt";
            desc = "The value of this field is used by the internal counter only when the number of write commands reaches the value of QOSB_WBUF_CTRL[wbuf_lvl2] (write buffer threshold 2) and the count value has already reached wbuf_hcnt. When the count value reaches wbuf_hcnt, the internal counter starts counting again. The priorities of the write commands are increased to pril1 until the count value reaches wbuf_lcnt. If the count value is 0, the priorities of the write commands are always pri2. Note: pri1 indicates the priority of the write buffer threshold 1. For details, see QOSB_WBUF_CTRL[wbuf_pri1].";
            sw = rw; hw = r;
            reset = 0x0;
        } wbuf_lcnt[15:0];
    } QOSB_WBUF_PRI_CTRL @ 0x1F4;
    reg {
        name = "QOSB_RHIT_CTRL";
        desc = "QOSB_RHIT_CTRL is a QoSBuf row-hit priority adjustment control register. (offset 0x1F8; total reset 0x00FF000F; PROVEN: Hi3521A/Hi3520D V300 data sheet (Issue 00B07, 2015-12-10), section 4.1.6.2, PDF page 784).";
        field {
            name = "rhit_hcnt";
            desc = "Time allowed to maintain the row-hit command stream Note: The row-hit command stream is forcibly disconnected when the time for maintaining the row-hit command stream reaches rhit_hcnt. Then the internal counter starts counting again, and the row-hit command stream is allowed to raise the arbitration request until the count value reaches rhit_lcnt.";
            sw = rw; hw = r;
            reset = 0xff;
        } rhit_hcnt[31:16];
        field {
            name = "rhit_lcnt";
            desc = "Duration that the row-hit command stream is disconnected Note: The row-hit command stream is forcibly disconnected when the time for maintaining the row-hit command stream reaches rhit_hcnt. Then the internal counter starts counting again, and the row-hit command stream is allowed to raise the arbitration request until the count value reaches rhit_lcnt.";
            sw = rw; hw = r;
            reset = 0xf;
        } rhit_lcnt[15:0];
    } QOSB_RHIT_CTRL @ 0x1F8;
};
`endif
