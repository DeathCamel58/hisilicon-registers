`ifndef HI3520DV300_RTC_INT_RDL
`define HI3520DV300_RTC_INT_RDL
regfile eHI3520DV300_RTC_INT {
    name = "Internal RTC register file (device addresses reached through the RTC SPI interface, NOT memory mapped; the instance base 0x120B0100 in the SoC map is a placeholder)";
    desc = "Internal RTC register file (device addresses reached through the RTC SPI interface, NOT memory mapped; the instance base 0x120B0100 in the SoC map is a placeholder) of the Hi3521A/Hi3520D V300 at base 0x00. 35 registers extracted programmatically from the Hi3521A/Hi3520D V300 data sheet (Issue 00B07, 2015-12-10) (Table 3-19 Summary of internal RTC registers (base address: 0x00)): register headings, offsets, total reset values, field bit ranges, access types, names, reset values and descriptions, with PDF page numbers in each register description. Field names, bit ranges, access types and offsets are exact; the free-text descriptions are taken from the cell text of the field table and were checked by sampling only. Hardware not verified.";
    reg {
        name = "RTC_10MS_COUNT";
        desc = "RTC_10MS_COUNT is a count value register for the RTC 10 ms counter. (offset 0x0; total reset 0x00000000; PROVEN: Hi3521A/Hi3520D V300 data sheet (Issue 00B07, 2015-12-10), section 3.10.7, PDF page 673).";
        regwidth = 8;
        field {
            name = "reserved";
            desc = "Reserved";
            sw = r; hw = w;
            reset = 0x0;
        } reserved_7_7[7:7];
        field {
            name = "rtc_10ms_count";
            desc = "RTC 10 ms counter value. It indicates the currently counted time. Its unit is 10 ms. The value range is 0-99.";
            sw = r; hw = w;
            reset = 0x0;
        } rtc_10ms_count[6:0];
    } RTC_10MS_COUNT @ 0x0;
    reg {
        name = "RTC_S_COUNT";
        desc = "RTC_S_COUNT is a count value register for the RTC second counter. (offset 0x1; total reset 0x00000000; PROVEN: Hi3521A/Hi3520D V300 data sheet (Issue 00B07, 2015-12-10), section 3.10.7, PDF page 673).";
        regwidth = 8;
        field {
            name = "reserved";
            desc = "Reserved";
            sw = r; hw = w;
            reset = 0x0;
        } reserved_7_6[7:6];
        field {
            name = "rtc_s_count";
            desc = "RTC second counter value. It indicates the currently counted seconds. The value range is 0-59.";
            sw = r; hw = w;
            reset = 0x0;
        } rtc_s_count[5:0];
    } RTC_S_COUNT @ 0x1;
    reg {
        name = "RTC_M_COUNT";
        desc = "RTC_M_COUNT is a count value register for the RTC minute counter. (offset 0x2; total reset 0x00000000; PROVEN: Hi3521A/Hi3520D V300 data sheet (Issue 00B07, 2015-12-10), section 3.10.7, PDF page 674).";
        regwidth = 8;
        field {
            name = "reserved";
            desc = "Reserved";
            sw = r; hw = w;
            reset = 0x0;
        } reserved_7_6[7:6];
        field {
            name = "rtc_m_count";
            desc = "RTC minute counter value. It indicates the currently counted minutes. The value range is 0-59.";
            sw = r; hw = w;
            reset = 0x0;
        } rtc_m_count[5:0];
    } RTC_M_COUNT @ 0x2;
    reg {
        name = "RTC_H_COUNT";
        desc = "RTC_H_COUNT is a count value register for the RTC hour counter. (offset 0x3; total reset 0x00000000; PROVEN: Hi3521A/Hi3520D V300 data sheet (Issue 00B07, 2015-12-10), section 3.10.7, PDF page 674).";
        regwidth = 8;
        field {
            name = "reserved";
            desc = "Reserved";
            sw = r; hw = w;
            reset = 0x0;
        } reserved_7_5[7:5];
        field {
            name = "rtc_h_count";
            desc = "RTC hour counter value. It indicates the currently counted hours. The value range is 0-23.";
            sw = r; hw = w;
            reset = 0x0;
        } rtc_h_count[4:0];
    } RTC_H_COUNT @ 0x3;
    reg {
        name = "RTC_D_COUNT_L";
        desc = "RTC_D_COUNT_L is a lower-8-bit count value register for the RTC day counter. (offset 0x4; total reset 0x00000000; PROVEN: Hi3521A/Hi3520D V300 data sheet (Issue 00B07, 2015-12-10), section 3.10.7, PDF page 675).";
        regwidth = 8;
        field {
            name = "rtc_d_count_l";
            desc = "Lower eight bits of the RTC day counter value. This field works with RTC_D_COUNT_H to indicate the currently counted days. The day range is 0-65535.";
            sw = r; hw = w;
            reset = 0x0;
        } rtc_d_count_l[7:0];
    } RTC_D_COUNT_L @ 0x4;
    reg {
        name = "RTC_D_COUNT_H";
        desc = "RTC_D_COUNT_H is an upper-8-bit count value register for the RTC day counter. (offset 0x5; total reset 0x00000000; PROVEN: Hi3521A/Hi3520D V300 data sheet (Issue 00B07, 2015-12-10), section 3.10.7, PDF page 675).";
        regwidth = 8;
        field {
            name = "rtc_d_count_h";
            desc = "Upper eight bits of the RTC day counter value. This field works with RTC_D_COUNT_L to indicate the currently counted day. The day range is 0-65535.";
            sw = r; hw = w;
            reset = 0x0;
        } rtc_d_count_h[7:0];
    } RTC_D_COUNT_H @ 0x5;
    reg {
        name = "RTC_MR_10MS";
        desc = "RTC_MR_10MS is a match value register for the RTC 10 ms counter. (offset 0x6; total reset 0x0000007F; PROVEN: Hi3521A/Hi3520D V300 data sheet (Issue 00B07, 2015-12-10), section 3.10.7, PDF page 676).";
        regwidth = 8;
        field {
            name = "reserved";
            desc = "Reserved";
            sw = r; hw = w;
            reset = 0x0;
        } reserved_7_7[7:7];
        field {
            name = "rtc_mr_10ms";
            desc = "Match value of the RTC 10 ms counter The value range is 0-99.";
            sw = rw; hw = r;
            reset = 0x7f;
        } rtc_mr_10ms[6:0];
    } RTC_MR_10MS @ 0x6;
    reg {
        name = "RTC_MR_S";
        desc = "RTC_MR_S is a match value register for the RTC second counter. (offset 0x7; total reset 0x0000003F; PROVEN: Hi3521A/Hi3520D V300 data sheet (Issue 00B07, 2015-12-10), section 3.10.7, PDF page 676).";
        regwidth = 8;
        field {
            name = "reserved";
            desc = "Reserved";
            sw = r; hw = w;
            reset = 0x0;
        } reserved_7_6[7:6];
        field {
            name = "rtc_mr_s";
            desc = "Match value of the RTC second counter The value range is 0-59.";
            sw = rw; hw = r;
            reset = 0x3f;
        } rtc_mr_s[5:0];
    } RTC_MR_S @ 0x7;
    reg {
        name = "RTC_MR_M";
        desc = "RTC_MR_M is a match value register for the RTC minute counter. (offset 0x8; total reset 0x0000003F; PROVEN: Hi3521A/Hi3520D V300 data sheet (Issue 00B07, 2015-12-10), section 3.10.7, PDF page 677).";
        regwidth = 8;
        field {
            name = "reserved";
            desc = "Reserved";
            sw = r; hw = w;
            reset = 0x0;
        } reserved_7_6[7:6];
        field {
            name = "rtc_mr_m";
            desc = "Match value of the RTC minute counter The value range is 0-59.";
            sw = rw; hw = r;
            reset = 0x3f;
        } rtc_mr_m[5:0];
    } RTC_MR_M @ 0x8;
    reg {
        name = "RTC_MR_H";
        desc = "RTC_MR_H is a match value register for the RTC hour counter. (offset 0x9; total reset 0x0000001F; PROVEN: Hi3521A/Hi3520D V300 data sheet (Issue 00B07, 2015-12-10), section 3.10.7, PDF page 677).";
        regwidth = 8;
        field {
            name = "reserved";
            desc = "Reserved";
            sw = r; hw = w;
            reset = 0x0;
        } reserved_7_5[7:5];
        field {
            name = "rtc_mr_h";
            desc = "Match value of the RTC hour counter The value range is 0-23.";
            sw = rw; hw = r;
            reset = 0x1f;
        } rtc_mr_h[4:0];
    } RTC_MR_H @ 0x9;
    reg {
        name = "RTC_MR_D_L";
        desc = "RTC_MR_D_L is a lower-8-bit match value register for the RTC day counter. (offset 0xA; total reset 0x000000FF; PROVEN: Hi3521A/Hi3520D V300 data sheet (Issue 00B07, 2015-12-10), section 3.10.7, PDF page 677).";
        regwidth = 8;
        field {
            name = "rtc_mr_d_l";
            desc = "Lower eight bits of the match value of the RTC day counter. This field works with RTC_MR_D_H to indicate the matched day. The day range is 0-65535.";
            sw = rw; hw = r;
            reset = 0xff;
        } rtc_mr_d_l[7:0];
    } RTC_MR_D_L @ 0xA;
    reg {
        name = "RTC_MR_D_H";
        desc = "RTC_MR_D_H is an upper-8-bit match value register for the RTC day counter. (offset 0xB; total reset 0x000000FF; PROVEN: Hi3521A/Hi3520D V300 data sheet (Issue 00B07, 2015-12-10), section 3.10.7, PDF page 678).";
        regwidth = 8;
        field {
            name = "rtc_mr_d_h";
            desc = "Upper eight bits of the match value of the RTC day counter. This field works with RTC_MR_D_L to indicate the matched day. The day range is 0-65535.";
            sw = rw; hw = r;
            reset = 0xff;
        } rtc_mr_d_h[7:0];
    } RTC_MR_D_H @ 0xB;
    reg {
        name = "RTC_LR_10MS";
        desc = "RTC_LR_10MS is a configured value register for the RTC 10 ms counter. (offset 0xC; total reset 0x00000000; PROVEN: Hi3521A/Hi3520D V300 data sheet (Issue 00B07, 2015-12-10), section 3.10.7, PDF page 678).";
        regwidth = 8;
        field {
            name = "reserved";
            desc = "Reserved";
            sw = r; hw = w;
            reset = 0x0;
        } reserved_7_7[7:7];
        field {
            name = "rtc_lr_10ms";
            desc = "Configured value of the RTC 10 ms counter The value range is 0-99.";
            sw = rw; hw = r;
            reset = 0x0;
        } rtc_lr_10ms[6:0];
    } RTC_LR_10MS @ 0xC;
    reg {
        name = "RTC_LR_S";
        desc = "RTC_LR_S is a configured value register for the RTC second counter. (offset 0xD; total reset 0x00000000; PROVEN: Hi3521A/Hi3520D V300 data sheet (Issue 00B07, 2015-12-10), section 3.10.7, PDF page 679).";
        regwidth = 8;
        field {
            name = "reserved";
            desc = "Reserved";
            sw = r; hw = w;
            reset = 0x0;
        } reserved_7_6[7:6];
        field {
            name = "rtc_lr_s";
            desc = "Configured value of the RTC second counter The value range is 0-59.";
            sw = rw; hw = r;
            reset = 0x0;
        } rtc_lr_s[5:0];
    } RTC_LR_S @ 0xD;
    reg {
        name = "RTC_LR_M";
        desc = "RTC_LR_M is a configured value register for the RTC minute counter. (offset 0xE; total reset 0x00000000; PROVEN: Hi3521A/Hi3520D V300 data sheet (Issue 00B07, 2015-12-10), section 3.10.7, PDF page 679).";
        regwidth = 8;
        field {
            name = "reserved";
            desc = "Reserved";
            sw = r; hw = w;
            reset = 0x0;
        } reserved_7_6[7:6];
        field {
            name = "rtc_lr_m";
            desc = "Configured value of the RTC minute counter The value range is 0-59.";
            sw = rw; hw = r;
            reset = 0x0;
        } rtc_lr_m[5:0];
    } RTC_LR_M @ 0xE;
    reg {
        name = "RTC_LR_H";
        desc = "RTC_LR_H is a configured value register for the RTC hour counter. (offset 0xF; total reset 0x00000000; PROVEN: Hi3521A/Hi3520D V300 data sheet (Issue 00B07, 2015-12-10), section 3.10.7, PDF page 680).";
        regwidth = 8;
        field {
            name = "reserved";
            desc = "Reserved";
            sw = r; hw = w;
            reset = 0x0;
        } reserved_7_5[7:5];
        field {
            name = "rtc_lr_h";
            desc = "Configured value of the RTC hour counter The value range is 0-23.";
            sw = rw; hw = r;
            reset = 0x0;
        } rtc_lr_h[4:0];
    } RTC_LR_H @ 0xF;
    reg {
        name = "RTC_LR_D_L";
        desc = "RTC_LR_D_L is a lower-8-bit configured value register for the RTC day counter. (offset 0x10; total reset 0x00000000; PROVEN: Hi3521A/Hi3520D V300 data sheet (Issue 00B07, 2015-12-10), section 3.10.7, PDF page 680).";
        regwidth = 8;
        field {
            name = "rtc_lr_d_l";
            desc = "Lower eight bits of the configured value of the RTC day counter. This field works with RTC_LR_D_H to indicate the configured day. The day range is 0-65535.";
            sw = rw; hw = r;
            reset = 0x0;
        } rtc_lr_d_l[7:0];
    } RTC_LR_D_L @ 0x10;
    reg {
        name = "RTC_LR_D_H";
        desc = "RTC_LR_D_H is an upper-8-bit configured value register for the RTC day counter. (offset 0x11; total reset 0x00000000; PROVEN: Hi3521A/Hi3520D V300 data sheet (Issue 00B07, 2015-12-10), section 3.10.7, PDF page 680).";
        regwidth = 8;
        field {
            name = "rtc_lr_d_h";
            desc = "Upper eight bits of the configured value of the RTC day counter. This field works with RTC_LR_D_L to indicate the configured day. The day range is 0-65535.";
            sw = rw; hw = r;
            reset = 0x0;
        } rtc_lr_d_h[7:0];
    } RTC_LR_D_H @ 0x11;
    reg {
        name = "RTC_LORD";
        desc = "RTC_LORD is an RTC configured value loading enable register. (offset 0x12; total reset 0x00000000; PROVEN: Hi3521A/Hi3520D V300 data sheet (Issue 00B07, 2015-12-10), section 3.10.7, PDF page 681).";
        regwidth = 8;
        field {
            name = "reserved";
            desc = "Reserved";
            sw = r; hw = w;
            reset = 0x0;
        } reserved_7_3[7:3];
        field {
            name = "rtc_lock_bypass";
            desc = "RTC lock enable
- 0: enabled. The RTC count value (0x00-0x05) is updated only after the RTC is successfully locked.
- 1: disabled. The RTC count value (0x00-0x05) is updated in real time.";
            sw = rw; hw = r;
            reset = 0x0;
        } rtc_lock_bypass[2:2];
        field {
            name = "rtc_lock";
            desc = "RTC lock. If software writes 1, this field is automatically cleared by hardware after the RTC is successfully locked. Note: This field is valid only when rtc_lock_bypass is 0.";
            sw = rw; hw = r;
            reset = 0x0;
        } rtc_lock[1:1];
        field {
            name = "rtc_load";
            desc = "RTC configured value loading enable. When the field is enabled, the RTC configured value will be loaded to the RTC accumulator. If software writes 1 to load the configured value, this field is automatically cleared by hardware after successful loading.";
            sw = rw; hw = r;
            reset = 0x0;
        } rtc_load[0:0];
    } RTC_LORD @ 0x12;
    reg {
        name = "RTC_IMSC";
        desc = "RTC_IMSC is an RTC interrupt enable register. (offset 0x13; total reset 0x00000000; PROVEN: Hi3521A/Hi3520D V300 data sheet (Issue 00B07, 2015-12-10), section 3.10.7, PDF page 682).";
        regwidth = 8;
        field {
            name = "reserved";
            desc = "Reserved";
            sw = r; hw = w;
            reset = 0x0;
        } reserved_7_3[7:3];
        field {
            name = "rtc_imsc";
            desc = "RTC global interrupt output enable
- 0: disabled
- 1: enabled";
            sw = rw; hw = r;
            reset = 0x0;
        } rtc_imsc[2:2];
        field {
            name = "rtc_imsc_uv";
            desc = "Battery low voltage detection interrupt output enable
- 0: disabled
- 1: enabled";
            sw = rw; hw = r;
            reset = 0x0;
        } rtc_imsc_uv[1:1];
        field {
            name = "rtc_imsc";
            desc = "RTC timing interrupt enable
- 0: disabled
- 1: enabled";
            sw = rw; hw = r;
            reset = 0x0;
        } rtc_imsc_0_0[0:0];
    } RTC_IMSC @ 0x13;
    reg {
        name = "RTC_INT_CLR";
        desc = "RTC_INT_CLR is an RTC interrupt clear register. (offset 0x14; total reset 0x00000000; PROVEN: Hi3521A/Hi3520D V300 data sheet (Issue 00B07, 2015-12-10), section 3.10.7, PDF page 682).";
        regwidth = 8;
        field {
            name = "reserved";
            desc = "Reserved";
            sw = r; hw = w;
            reset = 0x0;
        } reserved_7_1[7:1];
        field {
            name = "rtc_int_clr";
            desc = "RTC interrupt clear register. Software writes any value to clear the interrupt. Reading back the value has no effect.";
            sw = rw; hw = r;
            reset = 0x0;
        } rtc_int_clr[0:0];
    } RTC_INT_CLR @ 0x14;
    reg {
        name = "RTC_MSC_INT";
        desc = "RTC_MSC_INT is an RTC mask interrupt status register. (offset 0x15; total reset 0x00000000; PROVEN: Hi3521A/Hi3520D V300 data sheet (Issue 00B07, 2015-12-10), section 3.10.7, PDF page 683).";
        regwidth = 8;
        field {
            name = "reserved";
            desc = "Reserved";
            sw = r; hw = w;
            reset = 0x0;
        } reserved_7_2[7:2];
        field {
            name = "mask_int_uv";
            desc = "Masked battery low voltage detection interrupt status";
            sw = r; hw = w;
            reset = 0x0;
        } mask_int_uv[1:1];
        field {
            name = "mask_int_time";
            desc = "Masked RTC timing interrupt status";
            sw = r; hw = w;
            reset = 0x0;
        } mask_int_time[0:0];
    } RTC_MSC_INT @ 0x15;
    reg {
        name = "RTC_RAW_INT";
        desc = "RTC_RAW_INT is an RTC raw interrupt status register. (offset 0x16; total reset 0x00000000; PROVEN: Hi3521A/Hi3520D V300 data sheet (Issue 00B07, 2015-12-10), section 3.10.7, PDF page 683).";
        regwidth = 8;
        field {
            name = "reserved";
            desc = "Reserved";
            sw = r; hw = w;
            reset = 0x0;
        } reserved_7_2[7:2];
        field {
            name = "raw_int_uv";
            desc = "Battery low voltage detection raw interrupt status";
            sw = r; hw = w;
            reset = 0x0;
        } raw_int_uv[1:1];
        field {
            name = "raw_int";
            desc = "Raw interrupt status";
            sw = r; hw = w;
            reset = 0x0;
        } raw_int[0:0];
    } RTC_RAW_INT @ 0x16;
    reg {
        name = "RTC_CLK";
        desc = "RTC_CLK is an RTC output clock select register. (offset 0x17; total reset 0x00000000; PROVEN: Hi3521A/Hi3520D V300 data sheet (Issue 00B07, 2015-12-10), section 3.10.7, PDF page 683).";
        regwidth = 8;
        field {
            name = "reserved";
            desc = "Reserved";
            sw = r; hw = w;
            reset = 0x0;
        } reserved_7_2[7:2];
        field {
            name = "clk_out_sel";
            desc = "Output test clock of the RTC
- 00: output crystal oscillator clock
- 01: output corrected 100 Hz clock 1x: output 1 Hz clock";
            sw = rw; hw = r;
            reset = 0x0;
        } clk_out_sel[1:0];
    } RTC_CLK @ 0x17;
    reg {
        name = "RTC_POR_N";
        desc = "RTC_POR_N is an RTC reset control register. (offset 0x18; total reset 0x00000001; PROVEN: Hi3521A/Hi3520D V300 data sheet (Issue 00B07, 2015-12-10), section 3.10.7, PDF page 684).";
        regwidth = 8;
        field {
            name = "reserved";
            desc = "Reserved";
            sw = r; hw = w;
            reset = 0x0;
        } reserved_7_1[7:1];
        field {
            name = "rtc_por_n";
            desc = "RTC reset. This field is automatically set to 1 after the RTC is successfully reset.
- 0: reset";
            sw = rw; hw = r;
            reset = 0x1;
        } rtc_por_n[0:0];
    } RTC_POR_N @ 0x18;
    reg {
        name = "SDM_COEF_OUSIDE_H";
        desc = "SDM_COEF_OUSIDE_H is an external upper-4-bit clock divider register. (offset 0x51; total reset 0x00000008; PROVEN: Hi3521A/Hi3520D V300 data sheet (Issue 00B07, 2015-12-10), section 3.10.7, PDF page 684).";
        regwidth = 8;
        field {
            name = "reserved";
            desc = "Reserved";
            sw = r; hw = w;
            reset = 0x0;
        } reserved_7_4[7:4];
        field {
            name = "Sdm_coef_ouside_h";
            desc = "Upper 4 bits of the clock divider in fixed frequency-division mode";
            sw = rw; hw = r;
            reset = 0x8;
        } Sdm_coef_ouside_h[3:0];
    } SDM_COEF_OUSIDE_H @ 0x51;
    reg {
        name = "SDM_COEF_OUSIDE_L";
        desc = "SDM_COEF_OUSIDE_L is an external lower-8-bit clock divider register. (offset 0x52; total reset 0x0000001B; PROVEN: Hi3521A/Hi3520D V300 data sheet (Issue 00B07, 2015-12-10), section 3.10.7, PDF page 685).";
        regwidth = 8;
        field {
            name = "Sdm_coef_ouside_l";
            desc = "Lower eight bits of the clock divider in fixed frequency-division mode Note: When Sdm_coef_ouside_h and Sdm_coef_ouside_l are read or written, you need to read or write to the upper four bits and then the lower eight bits continuously.";
            sw = rw; hw = r;
            reset = 0x1b;
        } Sdm_coef_ouside_l[7:0];
    } SDM_COEF_OUSIDE_L @ 0x52;
    reg {
        name = "USER_REGISTER1";
        desc = "USER_REGISTER1 is 64-bit user register 1. (offset 0x53; total reset 0x00000000; PROVEN: Hi3521A/Hi3520D V300 data sheet (Issue 00B07, 2015-12-10), section 3.10.7, PDF page 685).";
        regwidth = 8;
        field {
            name = "user_register1";
            desc = "64-bit user register 1 corresponding to bit[7:0]";
            sw = rw; hw = r;
            reset = 0x0;
        } user_register1[7:0];
    } USER_REGISTER1 @ 0x53;
    reg {
        name = "USER_REGISTER2";
        desc = "USER_REGISTER2 is 64-bit user register 2. (offset 0x54; total reset 0x00000000; PROVEN: Hi3521A/Hi3520D V300 data sheet (Issue 00B07, 2015-12-10), section 3.10.7, PDF page 685).";
        regwidth = 8;
        field {
            name = "user_register2";
            desc = "64-bit user register 2 corresponding to bit[15:8]";
            sw = rw; hw = r;
            reset = 0x0;
        } user_register2[7:0];
    } USER_REGISTER2 @ 0x54;
    reg {
        name = "USER_REGISTER3";
        desc = "USER_REGISTER3 is 64-bit user register 3. (offset 0x55; total reset 0x00000000; PROVEN: Hi3521A/Hi3520D V300 data sheet (Issue 00B07, 2015-12-10), section 3.10.7, PDF page 686).";
        regwidth = 8;
        field {
            name = "user_register3";
            desc = "64-bit user register 3 corresponding to bit[23:16]";
            sw = rw; hw = r;
            reset = 0x0;
        } user_register3[7:0];
    } USER_REGISTER3 @ 0x55;
    reg {
        name = "USER_REGISTER4";
        desc = "USER_REGISTER4 is 64-bit user register 4. (offset 0x56; total reset 0x00000000; PROVEN: Hi3521A/Hi3520D V300 data sheet (Issue 00B07, 2015-12-10), section 3.10.7, PDF page 686).";
        regwidth = 8;
        field {
            name = "user_register4";
            desc = "64-bit user register 4 corresponding to bit[31:24]";
            sw = rw; hw = r;
            reset = 0x0;
        } user_register4[7:0];
    } USER_REGISTER4 @ 0x56;
    reg {
        name = "USER_REGISTER5";
        desc = "USER_REGISTER5 is 64-bit user register 5. (offset 0x57; total reset 0x00000000; PROVEN: Hi3521A/Hi3520D V300 data sheet (Issue 00B07, 2015-12-10), section 3.10.7, PDF page 686).";
        regwidth = 8;
        field {
            name = "user_register5";
            desc = "64-bit user register 5 corresponding to bit[39:32]";
            sw = rw; hw = r;
            reset = 0x0;
        } user_register5[7:0];
    } USER_REGISTER5 @ 0x57;
    reg {
        name = "USER_REGISTER6";
        desc = "USER_REGISTER6 is 64-bit user register 6. (offset 0x58; total reset 0x00000000; PROVEN: Hi3521A/Hi3520D V300 data sheet (Issue 00B07, 2015-12-10), section 3.10.7, PDF page 687).";
        regwidth = 8;
        field {
            name = "user_register6";
            desc = "64-bit user register 6 corresponding to bit[47:40]";
            sw = rw; hw = r;
            reset = 0x0;
        } user_register6[7:0];
    } USER_REGISTER6 @ 0x58;
    reg {
        name = "USER_REGISTER7";
        desc = "USER_REGISTER7 is 64-bit user register 7. (offset 0x59; total reset 0x00000000; PROVEN: Hi3521A/Hi3520D V300 data sheet (Issue 00B07, 2015-12-10), section 3.10.7, PDF page 687).";
        regwidth = 8;
        field {
            name = "user_register7";
            desc = "64-bit user register 7 corresponding to bit[55:48]";
            sw = rw; hw = r;
            reset = 0x0;
        } user_register7[7:0];
    } USER_REGISTER7 @ 0x59;
    reg {
        name = "USER_REGISTER8";
        desc = "USER_REGISTER8 is 64-bit user register 8. (offset 0x5A; total reset 0x00000000; PROVEN: Hi3521A/Hi3520D V300 data sheet (Issue 00B07, 2015-12-10), section 3.10.7, PDF page 687).";
        regwidth = 8;
        field {
            name = "user_register8";
            desc = "64-bit user register 8 corresponding to bit[63:56]";
            sw = rw; hw = r;
            reset = 0x0;
        } user_register8[7:0];
    } USER_REGISTER8 @ 0x5A;
};
`endif
