`ifndef HI3520DV300_SYS_CTRL_RDL
`define HI3520DV300_SYS_CTRL_RDL
regfile eHI3520DV300_SYS_CTRL {
    name = "System controller (SC)";
    desc = "System controller (SC) of the Hi3521A/Hi3520D V300 at base 0x1205_0000. 10 registers extracted programmatically from the Hi3521A/Hi3520D V300 data sheet (Issue 00B07, 2015-12-10) (Table 3-8 Summary of system controller registers (base address: 0x1205_0000)): register headings, offsets, total reset values, field bit ranges, access types, names, reset values and descriptions, with PDF page numbers in each register description. Field names, bit ranges, access types and offsets are exact; the free-text descriptions are taken from the cell text of the field table and were checked by sampling only. Hardware not verified.";
    reg {
        name = "SC_CTRL";
        desc = "SC_CTRL is a system control register. It is used to specify the operations to be performed by the system. Write protection for this register can be enabled by configuring SC_LOCKEN. This register can be written only when write protection is disabled. (offset 0x0; total reset 0x00000212; PROVEN: Hi3521A/Hi3520D V300 data sheet (Issue 00B07, 2015-12-10), section 3.5.4.2, PDF page 559).";
        field {
            name = "timeren7ov";
            desc = "Timer 7 count clock select
- 0: 3 MHz clock
- 1: bus clock";
            sw = rw; hw = r;
            reset = 0x0;
        } timeren7ov[31:31];
        field {
            name = "reserved";
            desc = "Reserved";
            sw = rw; hw = r;
            reset = 0x0;
        } reserved_30_30[30:30];
        field {
            name = "timeren6ov";
            desc = "Timer6 count clock select
- 0: 3 MHz clock
- 1: bus clock";
            sw = rw; hw = r;
            reset = 0x0;
        } timeren6ov[29:29];
        field {
            name = "reserved";
            desc = "Reserved";
            sw = rw; hw = r;
            reset = 0x0;
        } reserved_28_28[28:28];
        field {
            name = "timeren5ov";
            desc = "Timer 5 count clock select
- 0: 3 MHz clock
- 1: bus clock";
            sw = rw; hw = r;
            reset = 0x0;
        } timeren5ov[27:27];
        field {
            name = "reserved";
            desc = "Reserved";
            sw = rw; hw = r;
            reset = 0x0;
        } reserved_26_26[26:26];
        field {
            name = "timeren4ov";
            desc = "Timer 4 count clock select
- 0: 3 MHz clock
- 1: bus clock";
            sw = rw; hw = r;
            reset = 0x0;
        } timeren4ov[25:25];
        field {
            name = "reserved";
            desc = "Reserved";
            sw = rw; hw = r;
            reset = 0x0;
        } reserved_24_24[24:24];
        field {
            name = "wdogenov";
            desc = "Watchdog count clock select
- 0: 3 MHz clock
- 1: bus clock";
            sw = rw; hw = r;
            reset = 0x0;
        } wdogenov[23:23];
        field {
            name = "timeren3ov";
            desc = "Timer 3 count clock select
- 0: 3 MHz clock
- 1: bus clock";
            sw = rw; hw = r;
            reset = 0x0;
        } timeren3ov[22:22];
        field {
            name = "reserved";
            desc = "Reserved";
            sw = r; hw = w;
            reset = 0x0;
        } reserved_21_21[21:21];
        field {
            name = "timeren2ov";
            desc = "Timer 2 count clock select
- 0: 3 MHz clock
- 1: bus clock";
            sw = rw; hw = r;
            reset = 0x0;
        } timeren2ov[20:20];
        field {
            name = "reserved";
            desc = "Reserved";
            sw = rw; hw = r;
            reset = 0x0;
        } reserved_19_19[19:19];
        field {
            name = "timeren1ov";
            desc = "Timer 1 count clock select
- 0: 3 MHz clock
- 1: bus clock";
            sw = rw; hw = r;
            reset = 0x0;
        } timeren1ov[18:18];
        field {
            name = "reserved";
            desc = "Reserved";
            sw = rw; hw = r;
            reset = 0x0;
        } reserved_17_17[17:17];
        field {
            name = "timeren0ov";
            desc = "Timer 0 count clock select
- 0: 3 MHz clock
- 1: bus clock";
            sw = rw; hw = r;
            reset = 0x0;
        } timeren0ov[16:16];
        field {
            name = "reserved";
            desc = "Reserved";
            sw = rw; hw = r;
            reset = 0x0;
        } reserved_15_10[15:10];
        field {
            name = "remapstat";
            desc = "Address remap status
- 0: The address is not remapped.
- 1: The address is remapped. The BOOTROM, NANDC CS 0, or

SFC CS 1 is remapped to address 0.";
            sw = r; hw = w;
            reset = 0x1;
        } remapstat[9:9];
        field {
            name = "remapclear";
            desc = "Address remap clear
- 0: The remap status is retained.
- 1: The remap status is cleared.

For details about the address mappings before and after remapping is cleared, see Table 1-2 \"Address space mapping\" in chapter 1 \"Product Description.\"";
            sw = rw; hw = r;
            reset = 0x0;
        } remapclear[8:8];
        field {
            name = "reserved";
            desc = "Reserved. Reading this field returns 0, and writing to this field has no effect.";
            sw = r; hw = w;
            reset = 0x12;
        } reserved_7_0[7:0];
    } SC_CTRL @ 0x0;
    reg {
        name = "SC_SYSRES";
        desc = "SC_SYSRES is a system soft reset register. When a value is written to this register, the system controller sends a system soft reset request to the reset module. Then the reset module resets the system. Write protection for this register can be enabled by configuring SC_LOCKEN. This register can be written only when write protection is disabled. (offset 0x4; total reset 0x00000002; PROVEN: Hi3521A/Hi3520D V300 data sheet (Issue 00B07, 2015-12-10), section 3.5.4.2, PDF page 561).";
        field {
            name = "softresreq";
            desc = "Writing any value to this register soft-resets the system.";
            sw = w; hw = r;
            reset = 0x2;
        } softresreq[31:0];
    } SC_SYSRES @ 0x4;
    reg {
        name = "SOLFINT";
        desc = "SOLFINT is a software interrupt register. This register is not reset when the system is soft-reset. (offset 0x1C; total reset 0x00000000; PROVEN: Hi3521A/Hi3520D V300 data sheet (Issue 00B07, 2015-12-10), section 3.5.4.2, PDF page 561).";
        field {
            name = "reserved";
            desc = "Reserved";
            sw = r; hw = w;
            reset = 0x0;
        } reserved_31_1[31:1];
        field {
            name = "software_int";
            desc = "Software interrupt
- 0: No interrupt is generated.
- 1: An interrupt is generated.";
            sw = rw; hw = r;
            reset = 0x0;
        } software_int[0:0];
    } SOLFINT @ 0x1C;
    reg {
        name = "SOLFTYPE";
        desc = "SOLFTYPE is a software interrupt vector register. This register is not reset when the system is soft-reset. (offset 0x20; total reset 0x00000000; PROVEN: Hi3521A/Hi3520D V300 data sheet (Issue 00B07, 2015-12-10), section 3.5.4.2, PDF page 562).";
        field {
            name = "software_int_vectorSoftware";
            desc = "interrupt vector";
            sw = r; hw = w;
            reset = 0x0;
        } software_int_vectorSoftware[31:0];
    } SOLFTYPE @ 0x20;
    reg {
        name = "SC_LOCKEN";
        desc = "SC_LOCKEN is a key register lock registers. The register does not support soft reset. (offset 0x44; total reset 0x00000000; PROVEN: Hi3521A/Hi3520D V300 data sheet (Issue 00B07, 2015-12-10), section 3.5.4.2, PDF page 562).";
        field {
            name = "scper_lockl";
            desc = "Register for locking key system control registers. The key registers include SC_CTRL, SC_SYSSTAT, SC_PLLCTRL, and SC_PLLFCTRL. When 0x1ACC_E551 is written to SC_LOCKEN, the write permission for all registers is enabled; when any other value is written to SC_LOCKEN, the write permission is disabled. Reading this register returns the lock status but not the written value. 0x0000_0000: The write permission is enabled (unlocked). 0x0000_0001: The write permission is disabled (locked).";
            sw = rw; hw = r;
            reset = 0x0;
        } scper_lockl[31:0];
    } SC_LOCKEN @ 0x44;
    reg {
        name = "SYSSTAT";
        desc = "SYSSTAT is a system status register. (offset 0x8C; total reset 0x00000000; PROVEN: Hi3521A/Hi3520D V300 data sheet (Issue 00B07, 2015-12-10), section 3.5.4.2, PDF page 563).";
        field {
            name = "bootrom_sel";
            desc = "Whether the system boots from the BOOTROM
- 0: no
- 1: yes";
            sw = r; hw = w;
            reset = 0x0;
        } bootrom_sel[31:31];
        field {
            name = "reserved";
            desc = "Reserved";
            sw = r; hw = w;
            reset = 0x0;
        } reserved_30_9[30:9];
        field {
            name = "sfc_device_mode";
            desc = "SPI flash type
- 0: SPI NOR flash
- 1: SPI NAND flash";
            sw = r; hw = w;
            reset = 0x0;
        } sfc_device_mode[8:8];
        field {
            name = "sfc_addr_mode";
            desc = "This bit indicates the SPI NOR flash boot address mode when sfc_device_mode is 0.
- 0: 3-byte address mode
- 1: 4-byte address mode

This bit indicates the SPI NAND flash boot mode when sfc_device_mode is 1.
- 0: 1-wire mode
- 1: 4-wire mode";
            sw = r; hw = w;
            reset = 0x0;
        } sfc_addr_mode[7:7];
        field {
            name = "reserved";
            desc = "Reserved";
            sw = r; hw = w;
            reset = 0x0;
        } reserved_6_0[6:0];
    } SYSSTAT @ 0x8C;
    reg {
        name = "SCSYSID0";
        desc = "SCSYSID0 is chip ID register 0. (offset 0xEE0; total reset 0x00000000; PROVEN: Hi3521A/Hi3520D V300 data sheet (Issue 00B07, 2015-12-10), section 3.5.4.2, PDF page 564).";
        field {
            name = "sysid0";
            desc = "Reading this register returns 0x00.";
            sw = r; hw = w;
            reset = 0x0;
        } sysid0[7:0];
    } SCSYSID0 @ 0xEE0;
    reg {
        name = "SCSYSID1";
        desc = "SCSYSID1 is chip ID register 1. (offset 0xEE4; total reset 0x000000A1; PROVEN: Hi3521A/Hi3520D V300 data sheet (Issue 00B07, 2015-12-10), section 3.5.4.2, PDF page 564).";
        field {
            name = "sysid1";
            desc = "Reading this register returns 0xA1.";
            sw = r; hw = w;
            reset = 0xa1;
        } sysid1[7:0];
    } SCSYSID1 @ 0xEE4;
    reg {
        name = "SCSYSID2";
        desc = "SCSYSID2 is chip ID register 2. (offset 0xEE8; total reset 0x00000021; PROVEN: Hi3521A/Hi3520D V300 data sheet (Issue 00B07, 2015-12-10), section 3.5.4.2, PDF page 565).";
        field {
            name = "sysid2";
            desc = "Reading this register returns 0x21.";
            sw = r; hw = w;
            reset = 0x21;
        } sysid2[7:0];
    } SCSYSID2 @ 0xEE8;
    reg {
        name = "SCSYSID3";
        desc = "SCSYSID3 is chip ID register 3. (offset 0xEEC; total reset 0x00000035; PROVEN: Hi3521A/Hi3520D V300 data sheet (Issue 00B07, 2015-12-10), section 3.5.4.2, PDF page 565).";
        field {
            name = "sysid3";
            desc = "Reading this register returns 0X35.";
            sw = r; hw = w;
            reset = 0x35;
        } sysid3[7:0];
    } SCSYSID3 @ 0xEEC;
};
`endif
