`ifndef HI3520DV300_FMC_RDL
`define HI3520DV300_FMC_RDL
regfile eHI3520DV300_FMC {
    name = "Flash memory controller (FMC)";
    desc = "Flash memory controller (FMC) of the Hi3521A/Hi3520D V300 at base 0x10000000. 30 registers extracted programmatically from the Hi3521A/Hi3520D V300 data sheet (Issue 00B07, 2015-12-10) (Table 4-15 Summary of FMC registers (base address of 0x1000_0000) Offset Register Description Page Address): register headings, offsets, total reset values, field bit ranges, access types, names, reset values and descriptions, with PDF page numbers in each register description. Field names, bit ranges, access types and offsets are exact; the free-text descriptions are taken from the cell text of the field table and were checked by sampling only. Hardware not verified.";
    reg {
        name = "FMC_CFG";
        desc = "FMC_CFG is a component configuration register. (offset 0x0; total reset 0x00001820; PROVEN: Hi3521A/Hi3520D V300 data sheet (Issue 00B07, 2015-12-10), section 4.2.8, PDF page 964).";
        field {
            name = "reserved";
            desc = "Reserved";
            sw = r; hw = w;
            reset = 0x3;
        } reserved_31_11[31:11];
        field {
            name = "spi_nor_addr_mode";
            desc = "SPI address mode (valid only for the SPI NOR flash)
- 0: (default): 3-byte address mode
- 1: 4-byte address mode";
            sw = rw; hw = r;
            reset = 0x0;
        } spi_nor_addr_mode[10:10];
        field {
            name = "block_size";
            desc = "Block size of the SPI NAND flash
- 00: 64 pages

Other values: reserved";
            sw = rw; hw = r;
            reset = 0x0;
        } block_size[9:8];
        field {
            name = "ecc_type";
            desc = "ECC type of the controller
- 000: no ECC
- 001: 8-bit ECC
- 010: 16-bit ECC
- 011: 24-bit ECC
- 100: 28-bit ECC

Other values: reserved";
            sw = rw; hw = r;
            reset = 0x1;
        } ecc_type[7:5];
        field {
            name = "page_size";
            desc = "Page size of the SPI NAND flash
- 00: 2 KB page size
- 01: 4 KB page size

Other values: reserved";
            sw = rw; hw = r;
            reset = 0x0;
        } page_size[4:3];
        field {
            name = "flash_sel";
            desc = "Flash type select
- 00: SPI NOR flash
- 01: SPI NAND flash

Other values: reserved The reset value is determined by the FMC_FLASH_SEL pin.";
            sw = rw; hw = r;
            reset = 0x0;
        } flash_sel[2:1];
        field {
            name = "op_mode";
            desc = "FMC operation mode
- 0: boot mode
- 1: normal mode";
            sw = rw; hw = r;
            reset = 0x0;
        } op_mode[0:0];
    } FMC_CFG @ 0x0;
    reg {
        name = "GLOBAL_CFG";
        desc = "GLOBAL_CFG is a global configuration register. (offset 0x4; total reset 0x00000040; PROVEN: Hi3521A/Hi3520D V300 data sheet (Issue 00B07, 2015-12-10), section 4.2.8, PDF page 965).";
        field {
            name = "reserved";
            desc = "Reserved";
            sw = r; hw = w;
            reset = 0x0;
        } reserved_31_7[31:7];
        field {
            name = "wp_en";
            desc = "Write protection enable for the WP pin. When this bit is enabled, the chip outputs 0 to the WP pin.
- 0: disabled
- 1: enabled";
            sw = rw; hw = r;
            reset = 0x1;
        } wp_en[6:6];
        field {
            name = "reserved";
            desc = "Reserved";
            sw = r; hw = w;
            reset = 0x0;
        } reserved_5_0[5:0];
    } GLOBAL_CFG @ 0x4;
    reg {
        name = "TIMING_SPI_CFG";
        desc = "TIMING_SPI_CFG is an SPI timing configuration register. (offset 0x8; total reset 0x0000066F; PROVEN: Hi3521A/Hi3520D V300 data sheet (Issue 00B07, 2015-12-10), section 4.2.8, PDF page 966).";
        field {
            name = "reserved";
            desc = "Reserved";
            sw = r; hw = w;
            reset = 0x0;
        } reserved_31_12[31:12];
        field {
            name = "tcsh";
            desc = "CS hold time 000-111: (n + 1) interface clock cycles (n = 0, 1, 2, …, 7)";
            sw = rw; hw = r;
            reset = 0x6;
        } tcsh[11:8];
        field {
            name = "tcss";
            desc = "CS setup time 000-111: (n + 1) interface clock cycles (n = 0, 1, 2, …, 7)";
            sw = rw; hw = r;
            reset = 0x6;
        } tcss[7:4];
        field {
            name = "tshsl";
            desc = "CS deselect time. It is equal to the interval between two flash operations. 0000-1111: (n + 1) interface clock cycles (n = 0, 1, 2, …, 15)";
            sw = rw; hw = r;
            reset = 0xf;
        } tshsl[3:0];
    } TIMING_SPI_CFG @ 0x8;
    reg {
        name = "FMC_INT";
        desc = "FMC_INT is an interrupt status register. (offset 0x18; total reset 0x00000000; PROVEN: Hi3521A/Hi3520D V300 data sheet (Issue 00B07, 2015-12-10), section 4.2.8, PDF page 966).";
        field {
            name = "reserved";
            desc = "Reserved";
            sw = r; hw = w;
            reset = 0x0;
        } reserved_31_8[31:8];
        field {
            name = "ahb_op_int";
            desc = "CPU read/write internal buffer interrupt enable when the FMC is reading/writing data from/to the flash memory
- 0: No interrupt is generated.
- 1: An interrupt is generated.";
            sw = r; hw = w;
            reset = 0x0;
        } ahb_op_int[7:7];
        field {
            name = "reserved";
            desc = "Reserved";
            sw = r; hw = w;
            reset = 0x0;
        } reserved_6_6[6:6];
        field {
            name = "dma_err_int";
            desc = "DMA transfer bus error interrupt
- 0: No interrupt is generated.
- 1: An interrupt is generated.";
            sw = r; hw = w;
            reset = 0x0;
        } dma_err_int[5:5];
        field {
            name = "err_alarm_int";
            desc = "ECC alarm interrupt. An interrupt is generated when the number of error bits reaches the preset threshold.
- 0: No interrupt is generated.
- 1: An interrupt is generated.";
            sw = r; hw = w;
            reset = 0x0;
        } err_alarm_int[4:4];
        field {
            name = "err_inval_int";
            desc = "Uncorrectable ECC error interrupt In 8-bit ECC mode, if errors occur in eight or more bits of the checked 1024-byte data, an interrupt is generated. In 16-bit ECC mode, if errors occur in 16 or more bits of the checked 1024-byte data, an interrupt is generated. In 24-bit ECC mode, if errors occur in 24 or more bits of the checked 1024-byte data, an interrupt is generated. In 28-bit ECC mode, if errors occur in 28 or more bits of the checked 1024-byte data, an interrupt is generated.
- 0: No interrupt is generated.
- 1: An interrupt is generated.";
            sw = r; hw = w;
            reset = 0x0;
        } err_inval_int[3:3];
        field {
            name = "err_val_int";
            desc = "Correctable ECC error interrupt In 8-bit ECC mode, if errors occur in one to eight bits of the checked 1024-byte data, an interrupt is generated. In 16-bit ECC mode, if errors occur in one to 16 bits of the checked 1024-byte data, an interrupt is generated. In 24-bit ECC mode, if errors occur in one to 24 bits of the checked 1024-byte data, an interrupt is generated. In 28-bit ECC mode, if errors occur in one to 28 bits of the checked 1024-byte data, an interrupt is generated.
- 0: No interrupt is generated.
- 1: An interrupt is generated.";
            sw = r; hw = w;
            reset = 0x0;
        } err_val_int[2:2];
        field {
            name = "op_fail_int";
            desc = "Programming (timeout) failure interrupt in DMA mode
- 0: No interrupt is generated.
- 1: An interrupt is generated.";
            sw = r; hw = w;
            reset = 0x0;
        } op_fail_int[1:1];
        field {
            name = "op_done_int";
            desc = "Current controller operation completion interrupt. This bit is automatically cleared when the operation register is written.
- 0: No interrupt is generated.
- 1: An interrupt is generated.";
            sw = r; hw = w;
            reset = 0x0;
        } op_done_int[0:0];
    } FMC_INT @ 0x18;
    reg {
        name = "FMC_INT_EN";
        desc = "FMC_INT_EN is an interrupt enable register. (offset 0x1C; total reset 0x00000000; PROVEN: Hi3521A/Hi3520D V300 data sheet (Issue 00B07, 2015-12-10), section 4.2.8, PDF page 968).";
        field {
            name = "reserved";
            desc = "Reserved";
            sw = r; hw = w;
            reset = 0x0;
        } reserved_31_8[31:8];
        field {
            name = "ahb_op_int_en";
            desc = "CPU read/write internal buffer error interrupt enable when the FMC is reading/writing data from/to the flash memory
- 0: disabled
- 1: enabled";
            sw = rw; hw = r;
            reset = 0x0;
        } ahb_op_int_en[7:7];
        field {
            name = "reserved";
            desc = "Reserved";
            sw = rw; hw = r;
            reset = 0x0;
        } reserved_6_6[6:6];
        field {
            name = "dma_err_int_en";
            desc = "DMA transfer bus error interrupt enable
- 0: disabled
- 1: enabled";
            sw = rw; hw = r;
            reset = 0x0;
        } dma_err_int_en[5:5];
        field {
            name = "err_alarm_int_en";
            desc = "ECC alarm interrupt enable. An interrupt is generated when the number of error bits reaches the threshold
- 0: disabled
- 1: enabled";
            sw = rw; hw = r;
            reset = 0x0;
        } err_alarm_int_en[4:4];
        field {
            name = "err_inval_int_en";
            desc = "ECC uncorrectable error interrupt enable
- 0: disabled
- 1: enabled";
            sw = rw; hw = r;
            reset = 0x0;
        } err_inval_int_en[3:3];
        field {
            name = "err_val_int_en";
            desc = "ECC correctable error interrupt enable
- 0: disabled
- 1: enabled";
            sw = rw; hw = r;
            reset = 0x0;
        } err_val_int_en[2:2];
        field {
            name = "op_fail_int_en";
            desc = "Programming operation failure interrupt enable in DMA mode
- 0: disabled
- 1: enabled";
            sw = rw; hw = r;
            reset = 0x0;
        } op_fail_int_en[1:1];
        field {
            name = "op_done_int_en";
            desc = "Current operation completion interrupt enable of the FMC
- 0: disabled
- 1: enabled";
            sw = rw; hw = r;
            reset = 0x0;
        } op_done_int_en[0:0];
    } FMC_INT_EN @ 0x1C;
    reg {
        name = "FMC_INT_CLR";
        desc = "FMC_INT_CLR is an interrupt clear register. (offset 0x20; total reset 0x00000000; PROVEN: Hi3521A/Hi3520D V300 data sheet (Issue 00B07, 2015-12-10), section 4.2.8, PDF page 969).";
        field {
            name = "reserved";
            desc = "Reserved";
            sw = r; hw = w;
            reset = 0x0;
        } reserved_31_8[31:8];
        field {
            name = "ahb_op_int_clr";
            desc = "ahb_op_err interrupt clear. Writing 1 clears the interrupt.

Access type WC in the data sheet: written 1 clears the bit.";
            sw = rw; hw = w; onwrite = woclr;
            reset = 0x0;
        } ahb_op_int_clr[7:7];
        field {
            name = "reserved";
            desc = "Reserved

Access type WC in the data sheet: written 1 clears the bit.";
            sw = rw; hw = w; onwrite = woclr;
            reset = 0x0;
        } reserved_6_6[6:6];
        field {
            name = "dma_err_int_clr";
            desc = "DMA transfer bus error interrupt clear. Writing 1 clears the interrupt.

Access type WC in the data sheet: written 1 clears the bit.";
            sw = rw; hw = w; onwrite = woclr;
            reset = 0x0;
        } dma_err_int_clr[5:5];
        field {
            name = "err_alarm_int_clr";
            desc = "err_alarm interrupt clear. Writing 1 clears the interrupt.

Access type WC in the data sheet: written 1 clears the bit.";
            sw = rw; hw = w; onwrite = woclr;
            reset = 0x0;
        } err_alarm_int_clr[4:4];
        field {
            name = "err_inval_int_clr";
            desc = "err_invalid interrupt clear. Writing 1 clears the interrupt.

Access type WC in the data sheet: written 1 clears the bit.";
            sw = rw; hw = w; onwrite = woclr;
            reset = 0x0;
        } err_inval_int_clr[3:3];
        field {
            name = "err_val_int_clr";
            desc = "err_valid interrupt clear. Writing 1 clears the interrupt.

Access type WC in the data sheet: written 1 clears the bit.";
            sw = rw; hw = w; onwrite = woclr;
            reset = 0x0;
        } err_val_int_clr[2:2];
        field {
            name = "op_fail_int_clr";
            desc = "op_fail interrupt clear. Writing 1 clears the interrupt.

Access type WC in the data sheet: written 1 clears the bit.";
            sw = rw; hw = w; onwrite = woclr;
            reset = 0x0;
        } op_fail_int_clr[1:1];
        field {
            name = "op_done_int_clr";
            desc = "op_done interrupt clear. Writing 1 clears the interrupt.

Access type WC in the data sheet: written 1 clears the bit.";
            sw = rw; hw = w; onwrite = woclr;
            reset = 0x0;
        } op_done_int_clr[0:0];
    } FMC_INT_CLR @ 0x20;
    reg {
        name = "FMC_CMD";
        desc = "FMC_CMD is a command word configuration register. (offset 0x24; total reset 0x00000000; PROVEN: Hi3521A/Hi3520D V300 data sheet (Issue 00B07, 2015-12-10), section 4.2.8, PDF page 969).";
        field {
            name = "reserved";
            desc = "Reserved";
            sw = r; hw = w;
            reset = 0x0;
        } reserved_31_8[31:8];
        field {
            name = "cmd1";
            desc = "commands sent to the SPI NOR/SPI NAND flash";
            sw = rw; hw = r;
            reset = 0x0;
        } cmd1[7:0];
    } FMC_CMD @ 0x24;
    reg {
        name = "FMC_ADDRH";
        desc = "FMC_ADDRH is an upper-byte component address configuration register. (offset 0x28; total reset 0x00000000; PROVEN: Hi3521A/Hi3520D V300 data sheet (Issue 00B07, 2015-12-10), section 4.2.8, PDF page 970).";
        field {
            name = "reserved";
            desc = "Reserved";
            sw = r; hw = w;
            reset = 0x0;
        } reserved_31_8[31:8];
        field {
            name = "addrh";
            desc = "Upper-byte of the operation address for the SPI NAND flash";
            sw = rw; hw = r;
            reset = 0x0;
        } addrh[7:0];
    } FMC_ADDRH @ 0x28;
    reg {
        name = "FMC_ADDRL";
        desc = "FMC_ADDRL is a lower-byte component address configuration register. (offset 0x2C; total reset 0x00000000; PROVEN: Hi3521A/Hi3520D V300 data sheet (Issue 00B07, 2015-12-10), section 4.2.8, PDF page 970).";
        field {
            name = "addrl";
            desc = "Lower-byte of the operation address for the flash memory, and component address for the SPI NOR flash";
            sw = rw; hw = r;
            reset = 0x0;
        } addrl[31:0];
    } FMC_ADDRL @ 0x2C;
    reg {
        name = "FMC_OP_CFG";
        desc = "FMC_OP_CFG is an operation configuration register. (offset 0x30; total reset 0x00000000; PROVEN: Hi3521A/Hi3520D V300 data sheet (Issue 00B07, 2015-12-10), section 4.2.8, PDF page 971).";
        field {
            name = "reserved";
            desc = "Reserved";
            sw = r; hw = w;
            reset = 0x0;
        } reserved_31_12[31:12];
        field {
            name = "fm_cs";
            desc = "CS corresponding to the flash to be operated used for register operation and invalid for DMA operations
- 0: CS0
- 1: CS1";
            sw = rw; hw = r;
            reset = 0x0;
        } fm_cs[11:11];
        field {
            name = "force_cs_en";
            desc = "CS forcible pull-down enable
- 0: disabled
- 1: enabled";
            sw = rw; hw = r;
            reset = 0x0;
        } force_cs_en[10:10];
        field {
            name = "mem_if_type";
            desc = "SPI flash interface type select (read operation)
- 000: standard SPI
- 001: dual-output/dual-input SPI
- 010: dual I/O SPI
- 011: quad-output/quad-input SPI
- 100: quad I/O SPI 101-111: reserved";
            sw = rw; hw = r;
            reset = 0x0;
        } mem_if_type[9:7];
        field {
            name = "addr_num";
            desc = "Number of bytes of the address sent to the flash";
            sw = rw; hw = r;
            reset = 0x0;
        } addr_num[6:4];
        field {
            name = "dummy_num";
            desc = "Number of bytes to be operated for dummy_en (one byte is equivalent to two clock cycles in 4-wire mode, four clock cycles in 2-wire mode, or eight clock cycles in 1-wire mode)";
            sw = rw; hw = r;
            reset = 0x0;
        } dummy_num[3:0];
    } FMC_OP_CFG @ 0x30;
    reg {
        name = "FMC_DATA_NUM";
        desc = "FMC_DATA_NUM is a data length register. (offset 0x38; total reset 0x00000000; PROVEN: Hi3521A/Hi3520D V300 data sheet (Issue 00B07, 2015-12-10), section 4.2.8, PDF page 972).";
        field {
            name = "reserved";
            desc = "Reserved.";
            sw = r; hw = w;
            reset = 0x0;
        } reserved_31_14[31:14];
        field {
            name = "op_data_num";
            desc = "Length of data to be processed during one operation. This register needs to be configured when there is data transfer and does not need to be configured for the DMA operations. This register is valid for the SPI NAND flash only in ECC0 mode.";
            sw = rw; hw = r;
            reset = 0x0;
        } op_data_num[13:0];
    } FMC_DATA_NUM @ 0x38;
    reg {
        name = "FMC_OP";
        desc = "FMC_OP is an operation register. (offset 0x3C; total reset 0x00000000; PROVEN: Hi3521A/Hi3520D V300 data sheet (Issue 00B07, 2015-12-10), section 4.2.8, PDF page 972).";
        field {
            name = "reserved";
            desc = "Reserved";
            sw = r; hw = w;
            reset = 0x0;
        } reserved_31_9[31:9];
        field {
            name = "dummy_en";
            desc = "Dummy byte transfer enable after the address operation is enabled
- 0: disabled
- 1: enabled";
            sw = rw; hw = r;
            reset = 0x0;
        } dummy_en[8:8];
        field {
            name = "cmd1_en";
            desc = "Enable for transmitting command 1 to the flash
- 0: disabled
- 1: enabled";
            sw = rw; hw = r;
            reset = 0x0;
        } cmd1_en[7:7];
        field {
            name = "addr_en";
            desc = "Enable for writing the operation address to the flash
- 0: disabled
- 1: enabled";
            sw = rw; hw = r;
            reset = 0x0;
        } addr_en[6:6];
        field {
            name = "write_data_en";
            desc = "Enable for writing data to the flash
- 0: disabled
- 1: enabled

Note: read_data_en and write_data_en cannot be 1 at the same time.";
            sw = rw; hw = r;
            reset = 0x0;
        } write_data_en[5:5];
        field {
            name = "reserved";
            desc = "Reserved";
            sw = r; hw = w;
            reset = 0x0;
        } reserved_4_3[4:3];
        field {
            name = "read_data_en";
            desc = "Enable for reading data from the flash
- 0: disabled
- 1: enabled

Note: read_data_en and write_data_en cannot be 1 at the same time.";
            sw = rw; hw = r;
            reset = 0x0;
        } read_data_en[2:2];
        field {
            name = "read_status_en";
            desc = "Read component status register enable
- 0: disabled
- 1: enabled

When this bit is 1, the value of the FMC read component FMC_STATUS is written in the fm_status field of the status register instead of the internal butter.";
            sw = rw; hw = r;
            reset = 0x0;
        } read_status_en[1:1];
        field {
            name = "reg_op_start";
            desc = "Controller status when commands are issued by configuring the FMC_OP register
- 0: The controller is ready. This bit can be set only to 1 when software issues the command, indicating that the logic is enabled.
- 1: The controller is busy. This bit is automatically set to 0 after the operation is complete, indicating that the logic is complete.

Access type RWSC in the data sheet (self-clearing).";
            sw = rw; hw = rw;
            reset = 0x0;
        } reg_op_start[0:0];
    } FMC_OP @ 0x3C;
    reg {
        name = "FMC_DMA_LEN";
        desc = "FMC_DMA_LEN is a DMA operation length register. (offset 0x40; total reset 0x00000000; PROVEN: Hi3521A/Hi3520D V300 data sheet (Issue 00B07, 2015-12-10), section 4.2.8, PDF page 973).";
        field {
            name = "reserved";
            desc = "Reserved";
            sw = r; hw = w;
            reset = 0x0;
        } reserved_31_28[31:28];
        field {
            name = "dma_len";
            desc = "Data transfer length for DMA operations, in byte. This register is used to configure the spare area length of the SPI NAND flash in ECC0 mode and length of the data to be read from or written to the SPI NOR flash in DMC mode.";
            sw = rw; hw = r;
            reset = 0x0;
        } dma_len[27:0];
    } FMC_DMA_LEN @ 0x40;
    reg {
        name = "FMC_DMA_AHB_CTRL";
        desc = "FMC_DMA_AHB_CTRL is a DMA AHB bus control register. (offset 0x48; total reset 0x00000007; PROVEN: Hi3521A/Hi3520D V300 data sheet (Issue 00B07, 2015-12-10), section 4.2.8, PDF page 974).";
        field {
            name = "reserved";
            desc = "Reserved";
            sw = r; hw = w;
            reset = 0x0;
        } reserved_31_3[31:3];
        field {
            name = "burst16_en";
            desc = "Burst16 enable
- 0: disabled
- 1: enabled";
            sw = rw; hw = r;
            reset = 0x1;
        } burst16_en[2:2];
        field {
            name = "burst8_en";
            desc = "Burst8 enable
- 0: disabled
- 1: enabled";
            sw = rw; hw = r;
            reset = 0x1;
        } burst8_en[1:1];
        field {
            name = "burst4_en";
            desc = "Burst4 enable
- 0: disabled
- 1: enabled";
            sw = rw; hw = r;
            reset = 0x1;
        } burst4_en[0:0];
    } FMC_DMA_AHB_CTRL @ 0x48;
    reg {
        name = "FMC_DMA_SADDR_D0";
        desc = "FMC_DMA_SADDR_D0 is DDR start address register 0 for DMA operations. (offset 0x4C; total reset 0x00000000; PROVEN: Hi3521A/Hi3520D V300 data sheet (Issue 00B07, 2015-12-10), section 4.2.8, PDF page 974).";
        field {
            name = "dma_mem_saddr_d0";
            desc = "For the SPI NOR flash, this register indicates the DDR start address register for DMA operations. For the SPI NAND flash, this register indicates the DDR operation data base address register for DMA operations.";
            sw = rw; hw = r;
            reset = 0x0;
        } dma_mem_saddr_d0[31:0];
    } FMC_DMA_SADDR_D0 @ 0x4C;
    reg {
        name = "FMC_DMA_SADDR_OOB";
        desc = "FMC_DMA_SADDR_OOB is a DDR OOB information storage start address register for DMA operations. (offset 0x5C; total reset 0x00000000; PROVEN: Hi3521A/Hi3520D V300 data sheet (Issue 00B07, 2015-12-10), section 4.2.8, PDF page 975).";
        field {
            name = "dma_mem_saddr_oob";
            desc = "DDR base address for the OOB area that stores the data to be read or written";
            sw = rw; hw = r;
            reset = 0x0;
        } dma_mem_saddr_oob[31:0];
    } FMC_DMA_SADDR_OOB @ 0x5C;
    reg {
        name = "FMC_OP_CTRL";
        desc = "FMC_OP_CTRL is an DMA operation control register. (offset 0x68; total reset 0x00030200; PROVEN: Hi3521A/Hi3520D V300 data sheet (Issue 00B07, 2015-12-10), section 4.2.8, PDF page 975).";
        field {
            name = "reserved";
            desc = "Reserved";
            sw = r; hw = w;
            reset = 0x0;
        } reserved_31_24[31:24];
        field {
            name = "rd_opcode";
            desc = "SPI NAND/SPI NOR flash, DMA read command, non-bus mode (FAST_READ/READ/DUAL_READ)";
            sw = rw; hw = r;
            reset = 0x3;
        } rd_opcode[23:16];
        field {
            name = "wr_opcode";
            desc = "SPI NAND/SPI NOR flash, DMA write command";
            sw = rw; hw = r;
            reset = 0x2;
        } wr_opcode[15:8];
        field {
            name = "reserved";
            desc = "Reserved";
            sw = r; hw = w;
            reset = 0x0;
        } reserved_7_6[7:6];
        field {
            name = "rd_op_sel";
            desc = "Area of data to be read
- 00: The whole page is read.
- 01: Only the OOB is read. 1x: reserved";
            sw = rw; hw = r;
            reset = 0x0;
        } rd_op_sel[5:4];
        field {
            name = "reserved";
            desc = "Reserved";
            sw = r; hw = w;
            reset = 0x0;
        } reserved_3_2[3:2];
        field {
            name = "rw_op";
            desc = "DMA write/read mode select
- 0: DMA read mode
- 1: DMA write mode";
            sw = rw; hw = r;
            reset = 0x0;
        } rw_op[1:1];
        field {
            name = "dma_op_ready";
            desc = "Controller status when commands are issued by configuring the FMC_OP_CTRL register
- 0: The controller is ready. This bit can be set only to 1 when software issues the command, indicating that the logic is enabled.
- 1: The controller is busy. This bit is automatically set to 0 after the operation is complete, indicating that the logic is complete.

Access type RWSC in the data sheet (self-clearing).";
            sw = rw; hw = rw;
            reset = 0x0;
        } dma_op_ready[0:0];
    } FMC_OP_CTRL @ 0x68;
    reg {
        name = "FMC_TIMEOUT_WR";
        desc = "FMC_TIMEOUT_WR is a write operation timeout register. (offset 0x6C; total reset 0x00FFFFFF; PROVEN: Hi3521A/Hi3520D V300 data sheet (Issue 00B07, 2015-12-10), section 4.2.8, PDF page 976).";
        field {
            name = "reserved";
            desc = "Reserved";
            sw = r; hw = w;
            reset = 0x0;
        } reserved_31_24[31:24];
        field {
            name = "timeout_wr";
            desc = "Program operation busy wait time, timeout period. The timeout period is in the unit of one interface clock cycle for the SPI NAND/SPI NOR flash.";
            sw = rw; hw = r;
            reset = 0xffffff;
        } timeout_wr[23:0];
    } FMC_TIMEOUT_WR @ 0x6C;
    reg {
        name = "FMC_OP_PARA";
        desc = "FMC_OP_PARA is a data segment ID register for reading/writing to the SPI NAND flash in DMA mode. (offset 0x70; total reset 0x00000000; PROVEN: Hi3521A/Hi3520D V300 data sheet (Issue 00B07, 2015-12-10), section 4.2.8, PDF page 977).";
        field {
            name = "reserved";
            desc = "Reserved";
            sw = r; hw = w;
            reset = 0x0;
        } reserved_31_2[31:2];
        field {
            name = "rd_oob_only";
            desc = "Only the sector that stores the OOB information is read when the flash read command is issued.";
            sw = rw; hw = r;
            reset = 0x0;
        } rd_oob_only[1:1];
        field {
            name = "reserved";
            desc = "Reserved";
            sw = r; hw = w;
            reset = 0x0;
        } reserved_0_0[0:0];
    } FMC_OP_PARA @ 0x70;
    reg {
        name = "FMC_BOOT_SET";
        desc = "FMC_BOOT_SET is a boot setting register. (offset 0x74; total reset 0x00000001; PROVEN: Hi3521A/Hi3520D V300 data sheet (Issue 00B07, 2015-12-10), section 4.2.8, PDF page 977).";
        field {
            name = "reserved";
            desc = "Reserved";
            sw = r; hw = w;
            reset = 0x0;
        } reserved_31_5[31:5];
        field {
            name = "bb_err";
            desc = "Boot failure information
- 0: bootable
- 1: boot failure";
            sw = rw; hw = r;
            reset = 0x0;
        } bb_err[4:4];
        field {
            name = "reserved";
            desc = "Reserved";
            sw = r; hw = w;
            reset = 0x0;
        } reserved_3_2[3:2];
        field {
            name = "boot_quad_mode";
            desc = "Whether to use the 4-wire boot mode for the SPI NAND flash. The reset value is determined by the pin.
- 0: no. The 1-wire boot mode is used.
- 1: yes";
            sw = rw; hw = r;
            reset = 0x0;
        } boot_quad_mode[1:1];
        field {
            name = "boot_page0_cfg";
            desc = "Boot mode select
- 0: default boot mode
- 1: boot mode without configuring pins

The reset value is determined by the boot_page0_cfg pin.";
            sw = rw; hw = r;
            reset = 0x1;
        } boot_page0_cfg[0:0];
    } FMC_BOOT_SET @ 0x74;
    reg {
        name = "FMC_LP_CTRL";
        desc = "FMC_LP_CTRL is a low-power control register. (offset 0x78; total reset 0x00000000; PROVEN: Hi3521A/Hi3520D V300 data sheet (Issue 00B07, 2015-12-10), section 4.2.8, PDF page 978).";
        field {
            name = "reserved";
            desc = "Reserved";
            sw = r; hw = w;
            reset = 0x0;
        } reserved_31_1[31:1];
        field {
            name = "clk_gate_en";
            desc = "Clock gating select. If the clock gating is enabled, the low-power design is used and the module working clocks are disabled by logic.
- 0: All clocks are enabled.
- 1: Clocks are disabled according to the low-power design.";
            sw = rw; hw = r;
            reset = 0x0;
        } clk_gate_en[0:0];
    } FMC_LP_CTRL @ 0x78;
    reg {
        name = "FMC_ERR_THD";
        desc = "FMC_ERR_THD is an ECC alarm threshold register. (offset 0xA8; total reset 0x000000FF; PROVEN: Hi3521A/Hi3520D V300 data sheet (Issue 00B07, 2015-12-10), section 4.2.8, PDF page 979).";
        field {
            name = "reserved";
            desc = "Reserved";
            sw = r; hw = w;
            reset = 0x0;
        } reserved_31_8[31:8];
        field {
            name = "fmc_err_thd";
            desc = "ECC alarm threshold. When the number of error bits reaches the threshold, an ECC alarm interrupt is triggered. If an uncorrectable ECC error occurs, an uncorrectable interrupt is reported regardless of the register value. When the register value is set to 0 or 1, an alarm interrupt is reported as long as an error occurs. When the configured value exceeds the number of correctable error bits, no alarm interrupt is reported regardless of the number of error bits. Only the correctable error interrupt and uncorrectable error interrupt are generated.";
            sw = rw; hw = r;
            reset = 0xff;
        } fmc_err_thd[7:0];
    } FMC_ERR_THD @ 0xA8;
    reg {
        name = "FMC_STATUS";
        desc = "FMC_STATUS is a component operating status register. (offset 0xAC; total reset 0x00000000; PROVEN: Hi3521A/Hi3520D V300 data sheet (Issue 00B07, 2015-12-10), section 4.2.8, PDF page 979).";
        field {
            name = "reserved";
            desc = "Reserved";
            sw = r; hw = w;
            reset = 0x0;
        } reserved_31_8[31:8];
        field {
            name = "fm_status";
            desc = "Component operating status";
            sw = r; hw = w;
            reset = 0x0;
        } fm_status[7:0];
    } FMC_STATUS @ 0xAC;
    reg {
        name = "FMC_MEM_CTRL";
        desc = "FMC_MEM_CTRL is an SRAM pin configuration register. (offset 0xB4; total reset 0x00000002; PROVEN: Hi3521A/Hi3520D V300 data sheet (Issue 00B07, 2015-12-10), section 4.2.8, PDF page 980).";
        field {
            name = "reserved";
            desc = "Reserved";
            sw = r; hw = w;
            reset = 0x0;
        } reserved_31_5[31:5];
        field {
            name = "mem_emaw";
            desc = "EMAW pin configuration for the single-port SRAM";
            sw = rw; hw = r;
            reset = 0x0;
        } mem_emaw[4:3];
        field {
            name = "mem_ema";
            desc = "EMA pin configuration for the single-port SRAM; configuration values of the EMAA and EMAB pins for the dual-port SRAM";
            sw = rw; hw = r;
            reset = 0x2;
        } mem_ema[2:0];
    } FMC_MEM_CTRL @ 0xB4;
    reg {
        name = "VERSION";
        desc = "VERSION is a version register. (offset 0xBC; total reset 0x00000100; PROVEN: Hi3521A/Hi3520D V300 data sheet (Issue 00B07, 2015-12-10), section 4.2.8, PDF page 980).";
        field {
            name = "version";
            desc = "FMC V100";
            sw = r; hw = w;
            reset = 0x100;
        } version[31:0];
    } VERSION @ 0xBC;
    reg {
        name = "FMC_ERR_NUM0_BUF0";
        desc = "FMC_ERR_NUM0_BUF0 is an SPI NAND flash error correction information 0 statistics register for the first buffer operation. (offset 0xC0; total reset 0x00000000; PROVEN: Hi3521A/Hi3520D V300 data sheet (Issue 00B07, 2015-12-10), section 4.2.8, PDF page 981).";
        field {
            name = "err_num0_buf0";
            desc = "Number of error bits in the 4 KB data when the page size is 2 KB bit[31:24]: number of error bits in the fourth 1 KB data bit[23:16]: number of error bits in the third 1 KB data bit[15:8]: number of error bits in the second 1 KB data bit[7:0]: number of error bits in the first 1 KB data";
            sw = r; hw = w;
            reset = 0x0;
        } err_num0_buf0[31:0];
    } FMC_ERR_NUM0_BUF0 @ 0xC0;
    reg {
        name = "FMC_ERR_ALARM_ADDRH";
        desc = "FMC_ERR_ALARM_ADDRH is an upper-byte ECC alarm flash address register. (offset 0xD0; total reset 0x00000000; PROVEN: Hi3521A/Hi3520D V300 data sheet (Issue 00B07, 2015-12-10), section 4.2.8, PDF page 981).";
        field {
            name = "reserved";
            desc = "Reserved";
            sw = r; hw = w;
            reset = 0x0;
        } reserved_31_8[31:8];
        field {
            name = "fmc_err_alarm_addrh";
            desc = "Upper bytes of the operation address of the flash that triggers the last interrupt when an ECC alarm interrupt is generated";
            sw = r; hw = w;
            reset = 0x0;
        } fmc_err_alarm_addrh[7:0];
    } FMC_ERR_ALARM_ADDRH @ 0xD0;
    reg {
        name = "FMC_ERR_ALARM_ADDRL";
        desc = "FMC_ERR_ALARM_ADDRL is a lower-byte ECC alarm flash address register. (offset 0xD4; total reset 0x00000000; PROVEN: Hi3521A/Hi3520D V300 data sheet (Issue 00B07, 2015-12-10), section 4.2.8, PDF page 982).";
        field {
            name = "fmc_err_alarm_addrl";
            desc = "Lower bytes of the operation address of the flash that triggers the last interrupt when an ECC alarm interrupt is generated";
            sw = r; hw = w;
            reset = 0x0;
        } fmc_err_alarm_addrl[31:0];
    } FMC_ERR_ALARM_ADDRL @ 0xD4;
    reg {
        name = "FMC_ECC_INVALID_ADDRH";
        desc = "FMC_ECC_INVALID_ADDRH is an upper-byte ECC uncorrectable address register. (offset 0xD8; total reset 0x00000000; PROVEN: Hi3521A/Hi3520D V300 data sheet (Issue 00B07, 2015-12-10), section 4.2.8, PDF page 982).";
        field {
            name = "reserved";
            desc = "Reserved";
            sw = r; hw = w;
            reset = 0x0;
        } reserved_31_8[31:8];
        field {
            name = "fmc_ecc_invalid_addrh";
            desc = "Upper bytes of the operation address of the flash that triggers the last interrupt when an uncorrectable ECC error occurs";
            sw = r; hw = w;
            reset = 0x0;
        } fmc_ecc_invalid_addrh[7:0];
    } FMC_ECC_INVALID_ADDRH @ 0xD8;
    reg {
        name = "FMC_ECC_INVALID_ADDRL";
        desc = "FMC_ECC_INVALID_ADDRL is a lower-byte ECC uncorrectable address register. (offset 0xDC; total reset 0x00000000; PROVEN: Hi3521A/Hi3520D V300 data sheet (Issue 00B07, 2015-12-10), section 4.2.8, PDF page 982).";
        field {
            name = "fmc_ecc_invalid_addrl";
            desc = "Lower bytes of the operation address of the flash that triggers the last interrupt when an uncorrectable ECC error occurs Contents";
            sw = r; hw = w;
            reset = 0x0;
        } fmc_ecc_invalid_addrl[31:0];
    } FMC_ECC_INVALID_ADDRL @ 0xDC;
};
`endif
