`ifndef HI3520DV300_SPI_RDL
`define HI3520DV300_SPI_RDL
regfile eHI3520DV300_SPI {
    name = "SPI (SSP, PL022)";
    desc = "SPI (SSP, PL022) of the Hi3521A/Hi3520D V300 at base 0x120D_0000. 12 registers extracted programmatically from the Hi3521A/Hi3520D V300 data sheet (Issue 00B07, 2015-12-10) (Table 13-4 Summary of SPI registers (base address: 0x120D_0000)): register headings, offsets, total reset values, field bit ranges, access types, names, reset values and descriptions, with PDF page numbers in each register description. Field names, bit ranges, access types and offsets are exact; the free-text descriptions are taken from the cell text of the field table and were checked by sampling only. Hardware not verified.";
    reg {
        name = "SPICR0";
        desc = "SPICR0 is SPI control register 0. (offset 0x0; total reset 0x00000000; PROVEN: Hi3521A/Hi3520D V300 data sheet (Issue 00B07, 2015-12-10), section 13.3.7, PDF page 1537).";
        field {
            name = "SCR";
            desc = "Serial clock rate, ranging from 0 to 255. The value of the SCR is used to generate the TX and RX bit rates of the SPI. The formula is as follows: FSSPCLK/(CPSDVSR (1 + SCR). CPSDVSR is an even ranging from 2 to 254, and it is configured by SPICPSR.";
            sw = rw; hw = r;
            reset = 0x0;
        } SCR[15:8];
        field {
            name = "SPH";
            desc = "SPICLKOUT phase. For details, see the \"SPI frame format of Peripheral Bus Timings\" in section 13.3.4 'Peripheral Bus Timings.'";
            sw = rw; hw = r;
            reset = 0x0;
        } SPH[7:7];
        field {
            name = "SPO";
            desc = "SPICLKOUT polarity. For details, see the \"SPI Frame Format of Peripheral Bus Timings\" in section 13.3.4 'Peripheral Bus Timings.'";
            sw = rw; hw = r;
            reset = 0x0;
        } SPO[6:6];
        field {
            name = "FRF";
            desc = "Frame format select
- 00: Motorola SPI frame format
- 01: TI synchronous serial frame format
- 10: National microwire frame format
- 11: reserved";
            sw = rw; hw = r;
            reset = 0x0;
        } FRF[5:4];
        field {
            name = "DSS";
            desc = "Data width
- 0011: 4 bits";
            sw = rw; hw = r;
            reset = 0x0;
        } DSS[3:0];
    } SPICR0 @ 0x0;
    reg {
        name = "SPICR1";
        desc = "SPICR1 is SPI control register 1. (offset 0x4; total reset 0x00007F00; PROVEN: Hi3521A/Hi3520D V300 data sheet (Issue 00B07, 2015-12-10), section 13.3.7, PDF page 1538).";
        field {
            name = "WaitEn";
            desc = "Wait enable. This bit is valid when the SPICR0[FRF] is set to the national microwire frame format.
- 0: disabled
- 1: enabled";
            sw = rw; hw = r;
            reset = 0x0;
        } WaitEn[15:15];
        field {
            name = "WaitVal";
            desc = "Number of waiting beats between read and write when in the national microwire frame format. When WaitEn is 1 and the frame format is national microwire, WaitVal is valid.";
            sw = rw; hw = r;
            reset = 0x7f;
        } WaitVal[14:8];
        field {
            name = "reserved";
            desc = "Reserved";
            sw = rw; hw = r;
            reset = 0x0;
        } reserved_7_5[7:5];
        field {
            name = "BigEnd";
            desc = "Data endian mode
- 0: little endian
- 1: big endian";
            sw = rw; hw = r;
            reset = 0x0;
        } BigEnd[4:4];
        field {
            name = "reserved";
            desc = "Reserved";
            sw = rw; hw = r;
            reset = 0x0;
        } reserved_3_3[3:3];
        field {
            name = "MS";
            desc = "Master or slave mode. This bit can be changed only when the SPI is disabled.
- 0: master mode (default value)
- 1: reserved";
            sw = rw; hw = r;
            reset = 0x0;
        } MS[2:2];
        field {
            name = "SSE";
            desc = "SPI enable
- 0: disabled
- 1: enabled";
            sw = rw; hw = r;
            reset = 0x0;
        } SSE[1:1];
        field {
            name = "LBM";
            desc = "Loopback mode
- 0: A normal serial port operation is enabled.
- 1: The output of the TX serial shift register is connected to the input of the RX serial shift register.";
            sw = rw; hw = r;
            reset = 0x0;
        } LBM[0:0];
    } SPICR1 @ 0x4;
    reg {
        name = "SPIDR";
        desc = "SPIDR is a data register. (offset 0x8; total reset 0x00000000; PROVEN: Hi3521A/Hi3520D V300 data sheet (Issue 00B07, 2015-12-10), section 13.3.7, PDF page 1539).";
        field {
            name = "DATA";
            desc = "TX or RX FIFO Read: RX FIFO Write: TX FIFO If the data is less than 16 bits, the data must be aligned to the right. The TX logic ignores the unused upper bits, and the RX logic automatically aligns the data to the right.";
            sw = rw; hw = r;
            reset = 0x0;
        } DATA[15:0];
    } SPIDR @ 0x8;
    reg {
        name = "SPISR";
        desc = "SPISR is a status register. (offset 0xC; total reset 0x00000003; PROVEN: Hi3521A/Hi3520D V300 data sheet (Issue 00B07, 2015-12-10), section 13.3.7, PDF page 1540). Compare with the V100 SPI block (HISI_SPI, ARM PL022): the data sheet prints every field as RW (modeled as printed); on the PL022 TFE/TNF/RNE/RFF/BSY are read-only status bits (UNVERIFIED on this chip).";
        field {
            name = "reserved";
            desc = "Reserved";
            sw = rw; hw = r;
            reset = 0x0;
        } reserved_15_5[15:5];
        field {
            name = "BSY";
            desc = "SPI busy flag
- 0: idle
- 1: busy";
            sw = rw; hw = r;
            reset = 0x0;
        } BSY[4:4];
        field {
            name = "RFF";
            desc = "Whether the RX FIFO is full
- 0: not full
- 1: full.";
            sw = rw; hw = r;
            reset = 0x0;
        } RFF[3:3];
        field {
            name = "RNE";
            desc = "Whether the RX FIFO is not empty
- 0: empty
- 1: not empty";
            sw = rw; hw = r;
            reset = 0x0;
        } RNE[2:2];
        field {
            name = "TNF";
            desc = "Whether the TX FIFO is not full
- 0: full
- 1: not full";
            sw = rw; hw = r;
            reset = 0x1;
        } TNF[1:1];
        field {
            name = "TFE";
            desc = "Whether the TX FIFO is empty
- 0: not empty
- 1: empty";
            sw = rw; hw = r;
            reset = 0x1;
        } TFE[0:0];
    } SPISR @ 0xC;
    reg {
        name = "SPICPSR";
        desc = "SPICPSR is a clock divider register. (offset 0x10; total reset 0x00000000; PROVEN: Hi3521A/Hi3520D V300 data sheet (Issue 00B07, 2015-12-10), section 13.3.7, PDF page 1540).";
        field {
            name = "reserved";
            desc = "Reserved";
            sw = rw; hw = r;
            reset = 0x0;
        } reserved_15_8[15:8];
        field {
            name = "CPSDVSR";
            desc = "Clock divider. The value must be an even ranging from 2 to 254. It depends on the frequency of the input clock SPICLK. The LSB is read as 0.";
            sw = rw; hw = r;
            reset = 0x0;
        } CPSDVSR[7:0];
    } SPICPSR @ 0x10;
    reg {
        name = "SPIIMSC";
        desc = "SCIIMSC is an interrupt mask register. The value 0 indicates an interrupt is masked and the value1 indicates an interrupt is not masked. (offset 0x14; total reset 0x00000000; PROVEN: Hi3521A/Hi3520D V300 data sheet (Issue 00B07, 2015-12-10), section 13.3.7, PDF page 1541).";
        field {
            name = "reserved";
            desc = "Reserved";
            sw = rw; hw = r;
            reset = 0x0;
        } reserved_15_4[15:4];
        field {
            name = "TXIM";
            desc = "TX FIFO interrupt mask
- 0: The interrupt is masked when only half of or less data is left in the TX FIFO.
- 1: The interrupt is not masked when only half of or less data is left in the TX FIFO.";
            sw = rw; hw = r;
            reset = 0x0;
        } TXIM[3:3];
        field {
            name = "RXIM";
            desc = "RX FIFO interrupt mask
- 0: The interrupt is masked when only half of or less data is left in the RX FIFO.
- 1: The interrupt is not masked when only half of or less data is left in the RX FIFO.";
            sw = rw; hw = r;
            reset = 0x0;
        } RXIM[2:2];
        field {
            name = "RTIM";
            desc = "RX timeout interrupt mask
- 0: masked
- 1: not masked";
            sw = rw; hw = r;
            reset = 0x0;
        } RTIM[1:1];
        field {
            name = "RORIM";
            desc = "RX overflow interrupt mask
- 0: masked
- 1: not masked

When the value is 1, the hardware stream control function is enabled. That is, when the RX FIFO is full, the SPI stops transmitting data.";
            sw = rw; hw = r;
            reset = 0x0;
        } RORIM[0:0];
    } SPIIMSC @ 0x14;
    reg {
        name = "SPIRIS";
        desc = "SPIRIS is a raw interrupt status register. The value 0 indicates no interrupts are generated, and the value 1 indicates interrupts are generated. (offset 0x18; total reset 0x00000008; PROVEN: Hi3521A/Hi3520D V300 data sheet (Issue 00B07, 2015-12-10), section 13.3.7, PDF page 1542).";
        field {
            name = "reserved";
            desc = "Reserved";
            sw = r; hw = w;
            reset = 0x0;
        } reserved_15_4[15:4];
        field {
            name = "TXRIS";
            desc = "Raw TX FIFO interrupt status";
            sw = r; hw = w;
            reset = 0x1;
        } TXRIS[3:3];
        field {
            name = "RXRIS";
            desc = "Raw RX FIFO interrupt status";
            sw = r; hw = w;
            reset = 0x0;
        } RXRIS[2:2];
        field {
            name = "RTRIS";
            desc = "Raw RX timeout interrupt status";
            sw = r; hw = w;
            reset = 0x0;
        } RTRIS[1:1];
        field {
            name = "RORRIS";
            desc = "Raw RX overflow interrupt status";
            sw = r; hw = w;
            reset = 0x0;
        } RORRIS[0:0];
    } SPIRIS @ 0x18;
    reg {
        name = "SPIMIS";
        desc = "SPIMIS is a masked interrupt status register. The value 0 indicates no interrupts are generated, and the value 1 indicates interrupts are generated. (offset 0x1C; total reset 0x00000000; PROVEN: Hi3521A/Hi3520D V300 data sheet (Issue 00B07, 2015-12-10), section 13.3.7, PDF page 1542).";
        field {
            name = "reserved";
            desc = "Reserved";
            sw = r; hw = w;
            reset = 0x0;
        } reserved_15_4[15:4];
        field {
            name = "TXMIS";
            desc = "Status of the masked TX FIFO interrupt";
            sw = r; hw = w;
            reset = 0x0;
        } TXMIS[3:3];
        field {
            name = "RXMIS";
            desc = "Status of the masked RX FIFO interrupt";
            sw = r; hw = w;
            reset = 0x0;
        } RXMIS[2:2];
        field {
            name = "RTMIS";
            desc = "Status of the masked RX timeout interrupt";
            sw = r; hw = w;
            reset = 0x0;
        } RTMIS[1:1];
        field {
            name = "RORMIS";
            desc = "Status of the masked RX overflow interrupt";
            sw = r; hw = w;
            reset = 0x0;
        } RORMIS[0:0];
    } SPIMIS @ 0x1C;
    reg {
        name = "SPIICR";
        desc = "SCIICR is an interrupt clear register. Writing 1 clears an interrupt, and writing 0 has no effect. (offset 0x20; total reset 0x00000000; PROVEN: Hi3521A/Hi3520D V300 data sheet (Issue 00B07, 2015-12-10), section 13.3.7, PDF page 1543). Compare with the V100 SPI block (HISI_SPI, ARM PL022): the data sheet prints RTIC and RORIC as RO (modeled as printed); on the PL022 writing 1 clears the interrupts (UNVERIFIED on this chip).";
        field {
            name = "reserved";
            desc = "Reserved";
            sw = r; hw = w;
            reset = 0x0;
        } reserved_15_2[15:2];
        field {
            name = "RTIC";
            desc = "RX timeout interrupt clear";
            sw = r; hw = w;
            reset = 0x0;
        } RTIC[1:1];
        field {
            name = "RORIC";
            desc = "RX overflow interrupt clear";
            sw = r; hw = w;
            reset = 0x0;
        } RORIC[0:0];
    } SPIICR @ 0x20;
    reg {
        name = "SPIDMACR";
        desc = "SCIDMACR is a DMA control register. (offset 0x24; total reset 0x00000000; PROVEN: Hi3521A/Hi3520D V300 data sheet (Issue 00B07, 2015-12-10), section 13.3.7, PDF page 1543). Compare with the V100 SPI block (HISI_SPI, ARM PL022): the data sheet prints the fields as WO (modeled as printed); on the PL022 TXDMAE/RXDMAE are read/write (UNVERIFIED on this chip).";
        field {
            name = "reserved";
            desc = "Reserved";
            sw = w; hw = r;
            reset = 0x0;
        } reserved_15_2[15:2];
        field {
            name = "TXDMAE";
            desc = "DMA TX FIFO enable
- 0: disabled
- 1: enabled";
            sw = w; hw = r;
            reset = 0x0;
        } TXDMAE[1:1];
        field {
            name = "RXDMAE";
            desc = "DMA RX FIFO enable
- 0: disabled
- 1: enabled";
            sw = w; hw = r;
            reset = 0x0;
        } RXDMAE[0:0];
    } SPIDMACR @ 0x24;
    reg {
        name = "SPITXFIFOCR";
        desc = "SPITXFIFOCR is a TX FIFO control register. (offset 0x28; total reset 0x00000001; PROVEN: Hi3521A/Hi3520D V300 data sheet (Issue 00B07, 2015-12-10), section 13.3.7, PDF page 1544).";
        field {
            name = "reserved";
            desc = "Reserved";
            sw = rw; hw = r;
            reset = 0x0;
        } reserved_15_6[15:6];
        field {
            name = "TXINTSize";
            desc = "Threshold for generating the TX FIFO request interrupt. That is, when the number of data segments in the TX FIFO is less than or equal to the value of TXINTSize, TXRIS is valid.
- 000: 1
- 001: 4
- 010: 8
- 011: 16
- 100: 32
- 101: 64
- 110: 64
- 111: 64";
            sw = rw; hw = r;
            reset = 0x0;
        } TXINTSize[5:3];
        field {
            name = "DMATXBRSize";
            desc = "Threshold for generating the TX FIFO request DMA transfer burst. That is, when the number of data segments in the TX FIFO is less than or equal to the configured value (256 - DMATXBRSize), DMATXBREQ is valid. The width of the TX FIFO is 16 bits.
- 000: 1
- 001: 4
- 010: 8
- 011: 16
- 100: 32
- 101: 64
- 110: 128
- 111: 128";
            sw = rw; hw = r;
            reset = 0x1;
        } DMATXBRSize[2:0];
    } SPITXFIFOCR @ 0x28;
    reg {
        name = "SPIRXFIFOCR";
        desc = "SPIRXFIFOCR is an RX FIFO control register. (offset 0x2C; total reset 0x00000009; PROVEN: Hi3521A/Hi3520D V300 data sheet (Issue 00B07, 2015-12-10), section 13.3.7, PDF page 1545).";
        field {
            name = "reserved";
            desc = "Reserved";
            sw = rw; hw = r;
            reset = 0x0;
        } reserved_15_6[15:6];
        field {
            name = "RXINTSize";
            desc = "Threshold for generating the RX FIFO request interrupt. That is, when the number of data segments in the TX FIFO is less than or equal to the configured value (256 - RXINTSize), RXRIS is valid. The width of the RX FIFO is 16 bits.
- 000: 1
- 001: 4
- 010: 8
- 011: 16
- 100: 32
- 101: 64
- 110: 64
- 111: 64";
            sw = rw; hw = r;
            reset = 0x1;
        } RXINTSize[5:3];
        field {
            name = "DMARXBRSize";
            desc = "Burst transfer threshold. When this threshold is reached, the RX FIFO asks the DMA to perform a burst transfer. That is, when number of data segments in the TX FIFO is less than or equal to the value of DMARXBRSize, DMARXBREQ is valid.
- 000: 1
- 001: 4
- 010: 8
- 011: 16
- 100: 32
- 101: 64
- 110: 128
- 111: 224";
            sw = rw; hw = r;
            reset = 0x1;
        } DMARXBRSize[2:0];
    } SPIRXFIFOCR @ 0x2C;
};
`endif
