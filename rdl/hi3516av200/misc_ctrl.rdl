`ifndef MISC_RDL
`define MISC_RDL

regfile eMISC_CTRL {
    name = "MISC register";

    reg {
        name = "VICAP/VPSS/MIPI PHY control register";
        field {
            name = "shutter_flash_trig_sel";
            reset = 0x0;
        } shutter_flash_trig_sel[10:10];

        field {
            name = "vicap0_vpss0_online";
            reset = 0x0;
        } vicap0_vpss0_online[9:9];

        field {
            name = "mipi0_work_mode";
            reset = 0x1;
        } mipi0_work_mode[7:6];

        field {
            name = "mipi1_work_mode";
            reset = 0x1;
        } mipi1_work_mode[5:4];

        field {
            name = "vicap1_input_sel";
            reset = 0x1;
        } vicap1_input_sel[3:2];

        field {
            name = "vicap0_input_sel";
            reset = 0x0;
        } vicap0_input_sel[1:0];
    } MISC_CTRL0 @ 0x0000;
    
    reg {
        name = "Peripheral function selection register 0";
        field {
            name = "Ssp2_cs_sel";
            reset = 0x0;
        } Ssp2_cs_sel[27:26];

        field {
            name = "dma_01_sel";
            reset = 0x0;
        } dma_01_sel[24:24];

        field {
            name = "dma_67_sel";
            reset = 0x0;
        } dma_67_sel[23:22];

        field {
            name = "dma_89_sel";
            reset = 0x0;
        } dma_89_sel[21:21];

        field {
            name = "dma_ab_sel";
            reset = 0x0;
        } dma_ab_sel[20:20];

        field {
            name = "dma_cd_sel";
            reset = 0x0;
        } dma_cd_sel[19:19];

        field {
            name = "usb2phy_ctrl_sel";
            reset = 0x0;
        } usb2phy_ctrl_sel[15:15];

        field {
            name = "bootrom_pg";
            reset = 0x0;
        } bootrom_pg[13:13];

        field {
            name = "spi3_cs0_ctrl";
            reset = 0x0;
        } spi3_cs0_ctrl[12:12];

        field {
            name = "spi2_cs0_ctrl";
            reset = 0x0;
        } spi2_cs0_ctrl[11:11];

        field {
            name = "spi2_cs1_ctrl";
            reset = 0x0;
        } spi2_cs1_ctrl[10:10];

        field {
            name = "spi1_cs0_ctrl";
            reset = 0x0;
        } spi1_cs0_ctrl[9:9];

        field {
            name = "spi0_cs0_ctrl";
            reset = 0x0;
        } spi0_cs0_ctrl[8:8];

        field {
            name = "bootram_ck_gt_en";
            reset = 0x0;
        } bootram_ck_gt_en[2:2];
    } MISC_CTRL1 @ 0x0004;

    reg {
        name = "PCIe/USB 3.0 read outstanding limit control register";
        field {
            name = "pcie_m_od_bypass_limit";
            reset = 0x1;
        } pcie_m_od_bypass_limit[8:8];

        field {
            name = "pcie_m_od_max";
            reset = 0x4;
        } pcie_m_od_max[7:0];
    } MISC_CTRL2 @ 0x0008;

    reg {
        name = "Power switch control register";
        field {
            name = "powerswitch1_enable_mux";
            reset = 0x1;
        } powerswitch1_enable_mux[7:7];

        field {
            name = "powerswitch0_enable_mux";
            reset = 0x1;
        } powerswitch0_enable_mux[6:6];

        field {
            name = "powerswitch1_enable";
            reset = 0x0;
        } powerswitch1_enable[5:5];

        field {
            name = "powerswitch0_enable";
            reset = 0x0;
        } powerswitch0_enable[4:4];

        field {
            name = "powerswitch1_sel_mux";
            reset = 0x1;
        } powerswitch1_sel_mux[3:3];

        field {
            name = "powerswitch1_sel";
            reset = 0x0;
        } powerswitch1_sel[2:2];

        field {
            name = "powerswitch0_sel_mux";
            reset = 0x1;
        } powerswitch0_sel_mux[1:1];

        field {
            name = "powerswitch0_sel";
            reset = 0x0;
        } powerswitch0_sel[0:0];
    } MISC_CTRL3 @ 0x000C;

    reg {
        name = "RET1N control register";
        field {
            name = "vedu_ret1n_bypass";
            reset = 0x1;
        } vedu_ret1n_bypass[31:31];

        field {
            name = "emmc_ret1n";
            reset = 0x1;
        } emmc_ret1n[7:7];

        field {
            name = "sdio1_ret1n";
            reset = 0x1;
        } sdio1_ret1n[6:6];

        field {
            name = "sdio0_ret1n";
            reset = 0x1;
        } sdio0_ret1n[5:5];

        field {
            name = "gsf_ret1n";
            reset = 0x1;
        } gsf_ret1n[4:4];

        field {
            name = "cipher_ret1n";
            reset = 0x1;
        } cipher_ret1n[1:1];

        field {
            name = "bootram_ret1n";
            reset = 0x1;
        } bootram_ret1n[0:0];
    } MISC_CTRL4 @ 0x0010;

    reg {
        name = "System bus arbitration control register 0";
        field {
            name = "sysaxi_timeout_en_m2";
            reset = 0x0;
        } sysaxi_timeout_en_m2[31:31];

        field {
            name = "sysaxi_timeout_value_m2";
            reset = 0x0;
        } sysaxi_timeout_value_m2[30:16];

        field {
            name = "sysaxi_timeout_en_m1";
            reset = 0x0;
        } sysaxi_timeout_en_m1[15:15];

        field {
            name = "sysaxi_timeout_value_m1";
            reset = 0x0;
        } sysaxi_timeout_value_m1[14:0];
    } MISC_CTRL5 @ 0x0014;

    reg {
        name = "System bus arbitration control register 1";
        field {
            name = "sysaxi_timeout_en_m3";
            reset = 0x0;
        } sysaxi_timeout_en_m3[15:15];

        field {
            name = "sysaxi_timeout_value_m3";
            reset = 0x0;
        } sysaxi_timeout_value_m3[14:0];
    } MISC_CTRL6 @ 0x0018;

    reg {
        name = "System bus arbitration control register 2";
        field {
            name = "sysaxi_timeout_en_m5";
            reset = 0x0;
        } sysaxi_timeout_en_m5[15:15];

        field {
            name = "sysaxi_timeout_value_m5";
            reset = 0x0;
        } sysaxi_timeout_value_m5[14:0];
    } MISC_CTRL7 @ 0x001C;

    reg {
        name = "System bus priority control register 0";
        field {
            name = "sysaxi_port5_pri";
            reset = 0x4;
        } sysaxi_port5_pri[18:16];

        field {
            name = "sysaxi_port3_pri";
            reset = 0x2;
        } sysaxi_port3_pri[10:8];

        field {
            name = "sysaxi_port2_pri";
            reset = 0x1;
        } sysaxi_port2_pri[6:4];

        field {
            name = "sysaxi_port1_pri";
            reset = 0x0;
        } sysaxi_port1_pri[2:0];
    } MISC_CTRL8 @ 0x0020;

    reg {
        name = "System bus priority control register 1";
        field {
            name = "sysaxi_slave_priority_s2";
            reset = 0x1;
        } sysaxi_slave_priority_s2[6:4];

        field {
            name = "sysaxi_slave_priority_s1";
            reset = 0x0;
        } sysaxi_slave_priority_s1[2:0];
    } MISC_CTRL9 @ 0x0024;

    reg {
        name = "Media 0 bus arbitration control register 0";
        field {
            name = "media0axi_timeout_en_m2";
            reset = 0x0;
        } media0axi_timeout_en_m2[31:31];

        field {
            name = "media0axi_timeout_value_m2";
            reset = 0x0;
        } media0axi_timeout_value_m2[30:16];

        field {
            name = "media0axi_timeout_en_m1";
            reset = 0x0;
        } media0axi_timeout_en_m1[15:15];

        field {
            name = "media0axi_timeout_value_m1";
            reset = 0x0;
        } media0axi_timeout_value_m1[14:0];
    } MISC_CTRL11 @ 0x002C;

    reg {
        name = "Media 0 bus arbitration control register 1";
        field {
            name = "media0axi_timeout_en_m4";
            reset = 0x0;
        } media0axi_timeout_en_m4[31:31];

        field {
            name = "media0axi_timeout_value_m4";
            reset = 0x0;
        } media0axi_timeout_value_m4[30:16];
    } MISC_CTRL12 @ 0x0030;

    reg {
        name = "Media 0 bus priority control register";
        field {
            name = "media0axi_port4_pri";
            reset = 0x0;
        } media0axi_port4_pri[14:12];

        field {
            name = "media0axi_port2_pri";
            reset = 0x2;
        } media0axi_port2_pri[6:4];

        field {
            name = "media0axi_port1_pri";
            reset = 0x3;
        } media0axi_port1_pri[2:0];
    } MISC_CTRL14 @ 0x0038;

    reg {
        name = "Media 1 bus arbitration control register 0";
        field {
            name = "media1axi_timeout_en_m2";
            reset = 0x0;
        } media1axi_timeout_en_m2[31:31];

        field {
            name = "media1axi_timeout_value_m2";
            reset = 0x0;
        } media1axi_timeout_value_m2[30:16];

        field {
            name = "media1axi_timeout_en_m1";
            reset = 0x0;
        } media1axi_timeout_en_m1[15:15];

        field {
            name = "media1axi_timeout_value_m1";
            reset = 0x0;
        } media1axi_timeout_value_m1[14:0];
    } MISC_CTRL15 @ 0x003C;

    reg {
        name = "Media 1 bus arbitration control register 1";
        field {
            name = "media1axi_timeout_en_m4";
            reset = 0x0;
        } media1axi_timeout_en_m4[31:31];

        field {
            name = "media1axi_timeout_value_m4";
            reset = 0x0;
        } media1axi_timeout_value_m4[30:16];

        field {
            name = "media1axi_timeout_en_m3";
            reset = 0x0;
        } media1axi_timeout_en_m3[15:15];

        field {
            name = "media1axi_timeout_value_m3";
            reset = 0x0;
        } media1axi_timeout_value_m3[14:0];
    } MISC_CTRL16 @ 0x0040;

    reg {
        name = "Media 1 bus priority control register";
        field {
            name = "media1axi_port4_pri";
            reset = 0x3;
        } media1axi_port4_pri[14:12];

        field {
            name = "media1axi_port3_pri";
            reset = 0x2;
        } media1axi_port3_pri[10:8];

        field {
            name = "media1axi_port2_pri";
            reset = 0x1;
        } media1axi_port2_pri[6:4];

        field {
            name = "media1axi_port1_pri";
            reset = 0x0;
        } media1axi_port1_pri[2:0];
    } MISC_CTRL18 @ 0x0048;

    reg {
        name = "DDR QoS control register 0";
        field {
            name = "cci_w_qosmap";
            reset = 0x7;
        } cci_w_qosmap[31:28];

        field {
            name = "ddrt_w_qosmap";
            reset = 0x5;
        } ddrt_w_qosmap[23:20];

        field {
            name = "gzip_qosmap";
            reset = 0x2;
        } gzip_qosmap[11:8];
    } MISC_CTRL21 @ 0x0054;

    reg {
        name = "DDR QoS control register 1";
        field {
            name = "vicap1_w_qosmap";
            reset = 0x7;
        } vicap1_w_qosmap[31:28];

        field {
            name = "hash_w_qosmap";
            reset = 0x6;
        } hash_w_qosmap[27:24];

        field {
            name = "ive_w_qosmap";
            reset = 0x5;
        } ive_w_qosmap[23:20];

        field {
            name = "aio_w_qosmap";
            reset = 0x4;
        } aio_w_qosmap[19:16];

        field {
            name = "jpge_w_qosmap";
            reset = 0x3;
        } jpge_w_qosmap[15:12];

        field {
            name = "tde_w_qosmap";
            reset = 0x2;
        } tde_w_qosmap[11:8];

        field {
            name = "vicap0_w_qosmap";
            reset = 0x1;
        } vicap0_w_qosmap[7:4];

        field {
            name = "vdp_w_qosmap";
            reset = 0x0;
        } vdp_w_qosmap[3:0];
    } MISC_CTRL22 @ 0x0058;

    reg {
        name = "DDR QoS control register 2";
        field {
            name = "emmc_w_qosmap";
            reset = 0x7;
        } emmc_w_qosmap[31:28];

        field {
            name = "a17_w_qosmap";
            reset = 0x6;
        } a17_w_qosmap[27:24];

        field {
            name = "fmc_w_qosmap";
            reset = 0x5;
        } fmc_w_qosmap[23:20];

        field {
            name = "sdio1_w_qosmap";
            reset = 0x4;
        } sdio1_w_qosmap[19:16];

        field {
            name = "sdio0_w_qosmap";
            reset = 0x3;
        } sdio0_w_qosmap[15:12];

        field {
            name = "a7_w_qosmap";
            reset = 0x2;
        } a7_w_qosmap[11:8];

        field {
            name = "vpss0_w_qosmap";
            reset = 0x1;
        } vpss0_w_qosmap[7:4];

        field {
            name = "vgs_w_qosmap";
            reset = 0x0;
        } vgs_w_qosmap[3:0];
    } MISC_CTRL23 @ 0x005C;

    reg {
        name = "DDR QoS control register 3";
        field {
            name = "gdc_w_qosmap";
            reset = 0x7;
        } gdc_w_qosmap[31:28];

        field {
            name = "usb3_pcie_w_qosmap";
            reset = 0x6;
        } usb3_pcie_w_qosmap[27:24];

        field {
            name = "vedu_w_qosmap";
            reset = 0x5;
        } vedu_w_qosmap[23:20];

        field {
            name = "usb2_w_qosmap";
            reset = 0x4;
        } usb2_w_qosmap[19:16];

        field {
            name = "cipher_w_qosmap";
            reset = 0x3;
        } cipher_w_qosmap[15:12];

        field {
            name = "dma2_w_qosmap";
            reset = 0x2;
        } dma2_w_qosmap[11:8];

        field {
            name = "dma1_w_qosmap";
            reset = 0x1;
        } dma1_w_qosmap[7:4];

        field {
            name = "gsf_w_qosmap";
            reset = 0x0;
        } gsf_w_qosmap[3:0];
    } MISC_CTRL24 @ 0x0060;

    reg {
        name = "DDR QoS control register 4";
        field {
            name = "cci_r_qosmap";
            reset = 0x7;
        } cci_r_qosmap[31:28];

        field {
            name = "ddrt_r_qosmap";
            reset = 0x5;
        } ddrt_r_qosmap[23:20];

        field {
            name = "gzip_r_qosmap";
            reset = 0x2;
        } gzip_r_qosmap[11:8];
    } MISC_CTRL25 @ 0x0064;

    reg {
        name = "DDR QoS control register 5";
        field {
            name = "vicap1_r_qosmap";
            reset = 0x7;
        } vicap1_r_qosmap[31:28];

        field {
            name = "hash_r_qosmap";
            reset = 0x6;
        } hash_r_qosmap[27:24];

        field {
            name = "ive_r_qosmap";
            reset = 0x5;
        } ive_r_qosmap[23:20];

        field {
            name = "aio_r_qosmap";
            reset = 0x4;
        } aio_r_qosmap[19:16];

        field {
            name = "jpge_r_qosmap";
            reset = 0x3;
        } jpge_r_qosmap[15:12];

        field {
            name = "tde_r_qosmap";
            reset = 0x2;
        } tde_r_qosmap[11:8];

        field {
            name = "vicap0_r_qosmap";
            reset = 0x1;
        } vicap0_r_qosmap[7:4];

        field {
            name = "vdp_r_qosmap";
            reset = 0x0;
        } vdp_r_qosmap[3:0];
    } MISC_CTRL26 @ 0x0068;

    reg {
        name = "DDR QoS control register 6";
        field {
            name = "emmc_r_qosmap";
            reset = 0x7;
        } emmc_r_qosmap[31:28];

        field {
            name = "a17_r_qosmap";
            reset = 0x6;
        } a17_r_qosmap[27:24];

        field {
            name = "fmc_r_qosmap";
            reset = 0x5;
        } fmc_r_qosmap[23:20];

        field {
            name = "sdio1_r_qosmap";
            reset = 0x4;
        } sdio1_r_qosmap[19:16];

        field {
            name = "sdio0_r_qosmap";
            reset = 0x3;
        } sdio0_r_qosmap[15:12];

        field {
            name = "a7_r_qosmap";
            reset = 0x2;
        } a7_r_qosmap[11:8];

        field {
            name = "vpss0_r_qosmap";
            reset = 0x1;
        } vpss0_r_qosmap[7:4];

        field {
            name = "vgs_r_qosmap";
            reset = 0x0;
        } vgs_r_qosmap[3:0];
    } MISC_CTRL27 @ 0x006C;

    reg {
        name = "DDR QoS control register 7";
        field {
            name = "gdc_r_qosmap";
            reset = 0x7;
        } gdc_r_qosmap[31:28];

        field {
            name = "usb3_pcie_r_qosmap";
            reset = 0x6;
        } usb3_pcie_r_qosmap[27:24];

        field {
            name = "vedu_r_qosmap";
            reset = 0x5;
        } vedu_r_qosmap[23:20];

        field {
            name = "usb2_r_qosmap";
            reset = 0x4;
        } usb2_r_qosmap[19:16];

        field {
            name = "cipher_r_qosmap";
            reset = 0x3;
        } cipher_r_qosmap[15:12];

        field {
            name = "dma2_r_qosmap";
            reset = 0x2;
        } dma2_r_qosmap[11:8];

        field {
            name = "dma1_r_qosmap";
            reset = 0x1;
        } dma1_r_qosmap[7:4];

        field {
            name = "gsf_r_qosmap";
            reset = 0x0;
        } gsf_r_qosmap[3:0];
    } MISC_CTRL28 @ 0x0070;

    reg {
        name = "USB 3.0 control register";
        field {
            name = "usb3_host_current_belt";
            sw = r;
            hw = w;
            reset = 0x0;
        } usb3_host_current_belt[31:20];

        field {
            name = "usb3_host_port_power_control_present";
            reset = 0x0;
        } usb3_host_port_power_control_present[19:19];

        field {
            name = "usb3_fladj_30mhz_reg";
            reset = 0x20;
        } usb3_fladj_30mhz_reg[18:13];

        field {
            name = "usb3_host_msi_enable";
            reset = 0x0;
        } usb3_host_msi_enable[12:12];

        field {
            name = "usb3_bus_filter_bypass";
            reset = 0xF;
        } usb3_bus_filter_bypass[11:8];

        field {
            name = "usb3_port_pwren_pol";
            reset = 0x1;
        } usb3_port_pwren_pol[6:6];

        field {
            name = "usb3_port_pwr_ctrl_en";
            reset = 0x1;
        } usb3_port_pwr_ctrl_en[4:4];

        field {
            name = "usb3_host_u3_port_disable";
            reset = 0x0;
        } usb3_host_u3_port_disable[3:3];

        field {
            name = "usb3_host_u2_port_disable";
            reset = 0x0;
        } usb3_host_u2_port_disable[2:2];

        field {
            name = "usb3_hub_port_perm_attach";
            reset = 0x0;
        } usb3_hub_port_perm_attach[1:0];
    } MISC_CTRL29 @ 0x0074;

    reg {
        name = "USB 2.0 control register 0";
        field {
            name = "usb_chipid";
            reset = 0x0;
        } usb_chipid[31:31];

        field {
            name = "ss_scaledown_mode";
            reset = 0x0;
        } ss_scaledown_mode[25:24];

        field {
            name = "ss_hubsetup_min_i";
            reset = 0x0;
        } ss_hubsetup_min_i[22:22];

        field {
            name = "usbpwr_pctrl";
            reset = 0x1;
        } usbpwr_pctrl[16:16];

        field {
            name = "port_pwr_en";
            reset = 0x1;
        } port_pwr_en[12:12];

        field {
            name = "ss_ena_incr16_i";
            reset = 0x1;
        } ss_ena_incr16_i[9:9];

        field {
            name = "ss_ena_incr8_i";
            reset = 0x1;
        } ss_ena_incr8_i[8:8];

        field {
            name = "ss_ena_incr4_i";
            reset = 0x1;
        } ss_ena_incr4_i[7:7];

        field {
            name = "ss_ena_incr_align_i";
            reset = 0x0;
        } ss_ena_incr_align_i[6:6];

        field {
            name = "app_start_clk_i";
            reset = 0x0;
        } app_start_clk_i[2:2];

        field {
            name = "ohci_susp_lgcy_i";
            reset = 0x0;
        } ohci_susp_lgcy_i[1:1];

        field {
            name = "ss_word_if_i";
            reset = 0x0;
        } ss_word_if_i[0:0];
    } MISC_CTRL30 @ 0x0078;

    reg {
        name = "Test clock and USB 2.0 PHY access test channel mode selection register";
        field {
            name = "test_clk_sel";
            reset = 0x3;
        } test_clk_sel[3:0];
    } MISC_CTRL31 @ 0x007C;

    reg {
        name = "USB 2.0 PHY test channel register";
        field {
            name = "usb2_phy_testdataout";
            sw = r;
            hw = w;
            reset = 0x0;
        } usb2_phy_testdataout[31:24];

        field {
            name = "usb2_phy_test_rstn";
            reset = 0x0;
        } usb2_phy_test_rstn[23:23];

        field {
            name = "usb2_phy_wren";
            reset = 0x0;
        } usb2_phy_wren[21:21];

        field {
            name = "usb2_phy_testaddr";
            reset = 0x0;
        } usb2_phy_testaddr[18:8];

        field {
            name = "usb2_phy_testdatain";
            reset = 0x0;
        } usb2_phy_testdatain[7:0];
    } MISC_CTRL32 @ 0x0080;

    reg {
        name = "COMB PHY test channel register";
        field {
            name = "comb_phy_test_write";
            reset = 0x0;
        } comb_phy_test_write[16:16];

        field {
            name = "comb_phy_test_addr";
            reset = 0x0;
        } comb_phy_test_addr[12:8];

        field {
            name = "comb_phy_test_o";
            sw = r;
            hw = w;
            reset = 0x0;
        } comb_phy_test_o[7:4];

        field {
            name = "comb_phy_test_i";
            reset = 0x0;
        } comb_phy_test_i[3:0];
    } MISC_CTRL33 @ 0x0084;

    reg {
        name = "PCIe and USB 3.0 PHY control register";
        field {
            name = "combo_phy_tx_deemp";
            reset = 0x0;
        } combo_phy_tx_deemp[14:12];

        field {
            name = "combo_phy_tx_deemp_sel";
            reset = 0x0;
        } combo_phy_tx_deemp_sel[11:11];

        field {
            name = "pcie_clkreq_filter_bypass";
            reset = 0x1;
        } pcie_clkreq_filter_bypass[9:9];

        field {
            name = "usb3_phy_rx_standby";
            reset = 0x0;
        } usb3_phy_rx_standby[5:5];

        field {
            name = "usb3_phy_bypass_codec";
            reset = 0x0;
        } usb3_phy_bypass_codec[4:4];

        field {
            name = "pcie_phy_rx_standby";
            reset = 0x0;
        } pcie_phy_rx_standby[1:1];

        field {
            name = "pcie_phy_bypass_codec";
            reset = 0x0;
        } pcie_phy_bypass_codec[0:0];
    } MISC_CTRL34 @ 0x0088;

    reg {
        name = "Audio CODEC ANA register 0";
        field {
            name = "acodec_dacl_pop_en";
            reset = 0x1;
        } acodec_dacl_pop_en[18:18];

        field {
            name = "acodec_dacr_pop_en";
            reset = 0x1;
        } acodec_dacr_pop_en[16:16];

        field {
            name = "acodec_mute_dacr";
            reset = 0x1;
        } acodec_mute_dacr[14:14];

        field {
            name = "acodec_mute_dacl";
            reset = 0x1;
        } acodec_mute_dacl[13:13];

        field {
            name = "acodec_pd_dacr";
            reset = 0x1;
        } acodec_pd_dacr[12:12];

        field {
            name = "acodec_pd_dacl";
            reset = 0x1;
        } acodec_pd_dacl[11:11];

        field {
            name = "acodec_pd_dacr_dff";
            reset = 0x0;
        } acodec_pd_dacr_dff[9:9];

        field {
            name = "acodec_pd_dacl_dff";
            reset = 0x0;
        } acodec_pd_dacl_dff[8:8];

        field {
            name = "acodec_pd_micbias2";
            reset = 0x1;
        } acodec_pd_micbias2[7:7];

        field {
            name = "acodec_pd_micbias1";
            reset = 0x1;
        } acodec_pd_micbias1[6:6];

        field {
            name = "acodec_pd_linein_r";
            reset = 0x1;
        } acodec_pd_linein_r[5:5];

        field {
            name = "acodec_pd_linein_l";
            reset = 0x1;
        } acodec_pd_linein_l[4:4];

        field {
            name = "acodec_pd_adcr";
            reset = 0x1;
        } acodec_pd_adcr[3:3];

        field {
            name = "acodec_pd_adcl";
            reset = 0x1;
        } acodec_pd_adcl[2:2];

        field {
            name = "acodec_pd_vref";
            reset = 0x1;
        } acodec_pd_vref[0:0];
    } MISC_CTRL45 @ 0x00B4;

    reg {
        name = "Audio CODEC ANA register 1";
        field {
            name = "acodec_linein_r_sel";
            reset = 0x0;
        } acodec_linein_r_sel[31:28];

        field {
            name = "acodec_linein_l_sel";
            reset = 0x0;
        } acodec_linein_l_sel[27:24];

        field {
            name = "acodec_adcr_gain_boost";
            reset = 0x0;
        } acodec_adcr_gain_boost[22:22];

        field {
            name = "acodec_linein_r_gain_codec";
            reset = 0x0;
        } acodec_linein_r_gain_codec[20:16];

        field {
            name = "acodec_adcl_gain_boost";
            reset = 0x0;
        } acodec_adcl_gain_boost[14:14];

        field {
            name = "acodec_linein_l_gain_code";
            reset = 0x0;
        } acodec_linein_l_gain_code[12:8];

        field {
            name = "acodec_mute_lineinr";
            reset = 0x1;
        } acodec_mute_lineinr[5:5];

        field {
            name = "acodec_mute_lineinl";
            reset = 0x1;
        } acodec_mute_lineinl[4:4];
    } MISC_CTRL46 @ 0x00B8;

    reg {
        name = "Audio CODEC ANA register 2";
        field {
            name = "acodec_rst";
            reset = 0x0;
        } acodec_rst[23:23];
    } MISC_CTRL47 @ 0x00BC;

    reg {
        name = "Audio CODEC ANA register 3";
        field {
            name = "acodec_vref_exmode";
            reset = 0x0;
        } acodec_vref_exmode[7:7];

        field {
            name = "acodec_pop_res_sel";
            reset = 0x0;
        } acodec_pop_res_sel[4:3];
    } MISC_CTRL48 @ 0x00C0;

    reg {
        name = "Audio CODEC DIG control register 0";
        field {
            name = "dacl_rst_n";
            reset = 0x0;
        } dacl_rst_n[31:31];

        field {
            name = "dacr_rst_n";
            reset = 0x0;
        } dacr_rst_n[30:30];

        field {
            name = "adcl_rst_n";
            reset = 0x0;
        } adcl_rst_n[29:29];

        field {
            name = "adcr_rst_n";
            reset = 0x0;
        } adcr_rst_n[28:28];

        field {
            name = "dacl_en";
            reset = 0x0;
        } dacl_en[27:27];

        field {
            name = "dacr_en";
            reset = 0x0;
        } dacr_en[26:26];

        field {
            name = "adcl_en";
            reset = 0x0;
        } adcl_en[25:25];

        field {
            name = "adcr_en";
            reset = 0x0;
        } adcr_en[24:24];

        field {
            name = "i2s1_fs_sel";
            reset = 0x1A;
        } i2s1_fs_sel[17:13];
    } MISC_CTRL51 @ 0x00CC;

    reg {
        name = "Audio CODEC DIG control register 1";
        field {
            name = "smutel";
            reset = 0x0;
        } smutel[31:31];

        field {
            name = "smuter";
            reset = 0x0;
        } smuter[30:30];

        field {
            name = "sunmutel";
            reset = 0x0;
        } sunmutel[29:29];

        field {
            name = "sunmuter";
            reset = 0x0;
        } sunmuter[28:28];

        field {
            name = "dacvu";
            reset = 0x0;
        } dacvu[27:27];

        field {
            name = "mutel_rate";
            reset = 0x0;
        } mutel_rate[26:25];

        field {
            name = "muter_rate";
            reset = 0x0;
        } muter_rate[24:23];
    } MISC_CTRL52 @ 0x00D0;

    reg {
        name = "Audio CODEC DIG control register 2";
        field {
            name = "dacl_mute";
            reset = 0x0;
        } dacl_mute[31:31];

        field {
            name = "dacl_vol";
            reset = 0x6;
        } dacl_vol[30:24];

        field {
            name = "dacr_mute";
            reset = 0x0;
        } dacr_mute[23:23];

        field {
            name = "dacr_vol";
            reset = 0x6;
        } dacr_vol[22:16];
    } MISC_CTRL53 @ 0x00D4;

    reg {
        name = "Audio CODEC DIG control register 3";
        field {
            name = "adcl_mute";
            reset = 0x0;
        } adcl_mute[31:31];

        field {
            name = "adcl_vol";
            reset = 0x1E;
        } adcl_vol[30:24];

        field {
            name = "adcr_mute";
            reset = 0x0;
        } adcr_mute[23:23];

        field {
            name = "adcr_vol";
            reset = 0x1E;
        } adcr_vol[22:16];

        field {
            name = "adcl_hpf_en";
            reset = 0x0;
        } adcl_hpf_en[15:15];

        field {
            name = "adcr_hpf_en";
            reset = 0x0;
        } adcr_hpf_en[14:14];
    } MISC_CTRL54 @ 0x00D8;

    reg {
        name = "I2S channel selection control register";
        field {
            name = "i2s_pad_mclk_sel";
            reset = 0x0;
        } i2s_pad_mclk_sel[3:3];

        field {
            name = "i2s_pad_enable";
            reset = 0x0;
        } i2s_pad_enable[1:1];

        field {
            name = "audio_enable";
            reset = 0x0;
        } audio_enable[0:0];
    } MISC_CTRL56 @ 0x00E0;

    reg {
        name = "MDDRC scrambling random seed lower 32 bits register";
        field {
            name = "mddrca_random_low";
            reset = 0x0;
        } mddrca_random_low[31:0];
    } MISC_CTRL62 @ 0x00F8;

    reg {
        name = "MDDRC scrambling random seed upper 32 bits register";
        field {
            name = "mddrca_random_high";
            reset = 0x0;
        } mddrca_random_high[31:0];
    } MISC_CTRL63 @ 0x00FC;

    reg {
        name = "MDDRC scrambling control register";
        field {
            name = "mddrca_update";
            reset = 0x0;
        } mddrca_update[4:4];

        field {
            name = "mddrca_en";
            reset = 0x5;
        } mddrca_en[3:0];
    } MISC_CTRL64 @ 0x0100;

    reg {
        name = "eMMC DLL control register 0";
        field {
            name = "emmc_dll_ssel";
            reset = 0x0;
        } emmc_dll_ssel[15:8];

        field {
            name = "emmc_dll_mode";
            reset = 0x0;
        } emmc_dll_mode[7:7];

        field {
            name = "emmc_dll_stop";
            reset = 0x0;
        } emmc_dll_stop[6:6];

        field {
            name = "emmc_dll_bypass";
            reset = 0x0;
        } emmc_dll_bypass[5:5];

        field {
            name = "emmc_dll_slave_en";
            reset = 0x0;
        } emmc_dll_slave_en[4:4];

        field {
            name = "emmc_dll_tune";
            reset = 0x0;
        } emmc_dll_tune[3:0];
    } MISC_CTRL80 @ 0x0140;

    reg {
        name = "eMMC DLL control register 1";
        field {
            name = "emmc_dll_lock";
            sw = r;
            hw = w;
            reset = 0x0;
        } emmc_dll_lock[10:10];

        field {
            name = "emmc_dll_ready";
            sw = r;
            hw = w;
            reset = 0x0;
        } emmc_dll_ready[9:9];

        field {
            name = "emmc_dll_overflow";
            sw = r;
            hw = w;
            reset = 0x0;
        } emmc_dll_overflow[8:8];

        field {
            name = "emmc_dll_mdly_tap";
            sw = r;
            hw = w;
            reset = 0x0;
        } emmc_dll_mdly_tap[7:0];
    } MISC_CTRL81 @ 0x0144;

    reg {
        name = "Peripheral bus arbitration control register";
        field {
            name = "periaxi_timeout_en_m2";
            reset = 0x0;
        } periaxi_timeout_en_m2[31:31];

        field {
            name = "periaxi_timeout_value_m2";
            reset = 0x0;
        } periaxi_timeout_value_m2[30:16];

        field {
            name = "periaxi_timeout_en_m1";
            reset = 0x0;
        } periaxi_timeout_en_m1[15:15];

        field {
            name = "periaxi_timeout_value_m1";
            reset = 0x0;
        } periaxi_timeout_value_m1[14:0];
    } MISC_CTRL85 @ 0x0154;

    reg {
        name = "Peripheral bus priority control register";
        field {
            name = "periaxi_port2_pri";
            reset = 0x2;
        } periaxi_port2_pri[6:4];

        field {
            name = "periaxi_port1_pri";
            reset = 0x3;
        } periaxi_port1_pri[2:0];
    } MISC_CTRL88 @ 0x0160;

    reg {
        name = "Peripheral bus priority control register";
        field {
            name = "periaxi_slave_priority_s5";
            reset = 0x0;
        } periaxi_slave_priority_s5[18:16];

        field {
            name = "periaxi_slave_priority_s4";
            reset = 0x1;
        } periaxi_slave_priority_s4[14:12];

        field {
            name = "periaxi_slave_priority_s3";
            reset = 0x2;
        } periaxi_slave_priority_s3[10:8];

        field {
            name = "periaxi_slave_priority_s2";
            reset = 0x3;
        } periaxi_slave_priority_s2[6:4];

        field {
            name = "periaxi_slave_priority_s1";
            reset = 0x4;
        } periaxi_slave_priority_s1[2:0];
    } MISC_CTRL89 @ 0x0164;

    reg {
        name = "VDP_AIAO bus arbitration control register";
        field {
            name = "vdp_aiao_axi_timeout_en_m2";
            reset = 0x0;
        } vdp_aiao_axi_timeout_en_m2[31:31];

        field {
            name = "vdp_aiao_axi_timeout_value_m2";
            reset = 0x0;
        } vdp_aiao_axi_timeout_value_m2[30:16];

        field {
            name = "vdp_aiao_axi_timeout_en_m1";
            reset = 0x0;
        } vdp_aiao_axi_timeout_en_m1[15:15];

        field {
            name = "vdp_aiao_axi_timeout_value_m1";
            reset = 0x0;
        } vdp_aiao_axi_timeout_value_m1[14:0];
    } MISC_CTRL93 @ 0x0174;

    reg {
        name = "VO_AIO bus priority control register";
        field {
            name = "vdp_aiao_axi_port2_pri";
            reset = 0x0;
        } vdp_aiao_axi_port2_pri[6:4];

        field {
            name = "vdp_aiao_axi_port1_pri";
            reset = 0x1;
        } vdp_aiao_axi_port1_pri[2:0];
    } MISC_CTRL94 @ 0x0178;

    reg {
        name = "VICAP bus arbitration control register";
        field {
            name = "vicapaxi_timeout_en_m2";
            reset = 0x0;
        } vicapaxi_timeout_en_m2[31:31];

        field {
            name = "vicapaxi_timeout_value_m2";
            reset = 0x0;
        } vicapaxi_timeout_value_m2[30:16];

        field {
            name = "vicapaxi_timeout_en_m1";
            reset = 0x0;
        } vicapaxi_timeout_en_m1[15:15];

        field {
            name = "vicapaxi_timeout_value_m1";
            reset = 0x0;
        } vicapaxi_timeout_value_m1[14:0];
    } MISC_CTRL95 @ 0x017C;

    reg {
        name = "VICAP bus priority control register";
        field {
            name = "vicapaxi_port2_pri";
            reset = 0x0;
        } vicapaxi_port2_pri[6:4];

        field {
            name = "vicapaxi_port1_pri";
            reset = 0x1;
        } vicapaxi_port1_pri[2:0];
    } MISC_CTRL96 @ 0x0180;

    reg {
        name = "IOCO bus arbitration control register";
        field {
            name = "iocoaxi_timeout_en_m2";
            reset = 0x0;
        } iocoaxi_timeout_en_m2[31:31];

        field {
            name = "iocoaxi_timeout_value_m2";
            reset = 0x0;
        } iocoaxi_timeout_value_m2[30:16];
    } MISC_CTRL97 @ 0x0184;

    reg {
        name = "IOCO bus priority control register";
        field {
            name = "iocoaxi_port2_pri";
            reset = 0x0;
        } iocoaxi_port2_pri[6:4];
    } MISC_CTRL98 @ 0x018C;

    reg {
        name = "rootkey_aes lower 32 bits register";
        field {
            name = "otp_rootkey_aes_0";
            sw = r;
            hw = w;
            reset = 0x0;
        } otp_rootkey_aes_0[31:0];
    } OTP_ROOTKEY_AES_0 @ 0x3000;

    reg {
        name = "rootkey_aes bits 63–32 register";
        field {
            name = "otp_rootkey_aes_1";
            sw = r;
            hw = w;
            reset = 0x0;
        } otp_rootkey_aes_1[31:0];
    } OTP_ROOTKEY_AES_1 @ 0x3004;

    reg {
        name = "rootkey_aes bits 95–64 register";
        field {
            name = "otp_rootkey_aes_2";
            sw = r;
            hw = w;
            reset = 0x0;
        } otp_rootkey_aes_2[31:0];
    } OTP_ROOTKEY_AES_2 @ 0x3008;

    reg {
        name = "rootkey_aes bits 127–96 register";
        field {
            name = "otp_rootkey_aes_3";
            sw = r;
            hw = w;
            reset = 0x0;
        } otp_rootkey_aes_3[31:0];
    } OTP_ROOTKEY_AES_3 @ 0x300C;

    reg {
        name = "OTP ctrlbit programming mode control register";
        field {
            name = "otp_ctrlbit_pg_mode";
            reset = 0x0;
        } otp_ctrlbit_pg_mode[31:0];
    } OTP_CTRLBIT_PG_MODE @ 0x5000;

    reg {
        name = "OTP ctrlbit programming mode status register";
        field {
            name = "otp_ctrlbit_pg_busy";
            sw = r;
            hw = w;
            reset = 0x0;
        } otp_ctrlbit_pg_busy[0:0];

    } OTP_CTRLBIT_PG_BUSY @ 0x5004;

    reg {
        name = "OTP ctrlbit bit 0 programming control register";
        field {
            name = "otp_ctrlbit_pg_bit0";
            reset = 0x0;
        } otp_ctrlbit_pg_bit0[31:0];
    } OTP_CTRLBIT_PG_BIT0 @ 0x5008;

    reg {
        name = "OTP ctrlbit bit 1 programming control register";
        field {
            name = "otp_ctrlbit_pg_bit1";
            reset = 0x0;
        } otp_ctrlbit_pg_bit1[31:0];
    } OTP_CTRLBIT_PG_BIT1 @ 0x500C;

    reg {
        name = "OTP ctrlbit bit 2 programming control register";
        field {
            name = "otp_ctrlbit_pg_bit2";
            reset = 0x0;
        } otp_ctrlbit_pg_bit2[31:0];
    } OTP_CTRLBIT_PG_BIT2 @ 0x5010;

    reg {
        name = "OTP ctrlbit bit 3 programming control register";
        field {
            name = "otp_ctrlbit_pg_bit3";
            reset = 0x0;
        } otp_ctrlbit_pg_bit3[31:0];
    } OTP_CTRLBIT_PG_BIT3 @ 0x5014;

};
`endif
