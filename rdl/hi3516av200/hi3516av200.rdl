`include "defines.rdl"

`include "mddrc_ddr_phy.rdl"
`include "misc_ctrl.rdl"
`include "mux.rdl"
`include "pad_ctrl.rdl"
`include "peri_crg.rdl"
`include "peri_pmc.rdl"
`include "../common/ARM_GIC400.rdl"
`include "../common/ARM_PL011.rdl"
`include "../common/ARM_PL061.rdl"
`include "../common/HISI_AIAO.rdl"
`include "../common/HISI_CIPHER_MC.rdl"
`include "../common/HISI_DDRT.rdl"
`include "../common/HISI_DMAC.rdl"
`include "../common/HISI_DWMMC.rdl"
`include "../common/HISI_FMC.rdl"
`include "../common/HISI_GMAC.rdl"
`include "../common/HISI_HASH.rdl"
`include "../common/HISI_I2C_DW.rdl"
`include "../common/HISI_IR.rdl"
`include "../common/HISI_ISP_AV200.rdl"
`include "../common/HISI_IVE.rdl"
`include "../common/HISI_JPGE.rdl"
`include "../common/HISI_LSADC_V2.rdl"
`include "../common/HISI_MDDRC.rdl"
`include "../common/HISI_MIPI_RX_AV200.rdl"
`include "../common/HISI_OTP_KEY_CTRL.rdl"
`include "../common/HISI_PWM.rdl"
`include "../common/HISI_RSA.rdl"
`include "../common/HISI_RTC_SPI.rdl"
`include "../common/HISI_RTC_SPI_V3.rdl"
`include "../common/HISI_SPI.rdl"
`include "../common/HISI_SPI_3WIRE.rdl"
`include "../common/HISI_SYS_CTRL.rdl"
`include "../common/HISI_TDE.rdl"
`include "../common/HISI_TIMER_SP804.rdl"
`include "../common/HISI_TRNG.rdl"
`include "../common/HISI_USB_DEVICE.rdl"
`include "../common/HISI_USB_HOST.rdl"
`include "../common/HISI_VDP_AV200.rdl"
`include "../common/HISI_VEDU_V2.rdl"
`include "../common/HISI_VGS.rdl"
`include "../common/HISI_VICAP_AV200.rdl"
`include "../common/HISI_VPSS.rdl"
`include "../common/HISI_WDG_SP805.rdl"

addrmap hi3516av200 {
    name = "hi3516av200 registers";
    desc = "
        ## Datasheets

        * [Full Datasheet](assets/Hi3516AV200-Datasheet.pdf)

        ## Diagrams

        ![Application Block Diagram](assets/Application-Block-Diagram.png)
        ![Logic Block Diagram](assets/Logic-Block-Diagram.png)

        ## Addresses
        
        | Start Address | End Address | Description                                                                                                    | Documented Here |
        |---------------|-------------|----------------------------------------------------------------------------------------------------------------|-----------------|
        | 0x00000000    | 0x03FFFFFF  | Memory selected for address remapping. The address points to the on-chip RAM after remapping is cleared. 64 MB | &#10060;        |
        | 0x04000000    | 0x0400FFFF  | BOOTROM address space 64 KB The actual size is 32 KB.                                                          | &#10060;        |
        | 0x04010000    | 0x0401FFFF  | BOOTRAM address space 64 KB The actual size is 32 KB.                                                          | &#10060;        |
        | 0x04020000    | 0x0406FFFF  | Reserved 320 KB                                                                                                | &#10060;        |
        | 0x04070000    | 0x0FFFFFFF  | Reserved -                                                                                                     | &#10060;        |
        | 0x10000000    | 0x1000FFFF  | FMC register 64 KB                                                                                             | &#9989;         |
        | 0x10010000    | 0x1001FFFF  | Reserved 64 KB                                                                                                 | &#10060;        |
        | 0x10020000    | 0x1002FFFF  | Reserved 64 KB                                                                                                 | &#10060;        |
        | 0x10030000    | 0x1003FFFF  | DMAC register 64 KB                                                                                            | &#9989;         |
        | 0x10040000    | 0x1004FFFF  | Reserved 64 KB                                                                                                 | &#10060;        |
        | 0x10050000    | 0x1005FFFF  | GSF register 64 KB                                                                                             | &#9989;         |
        | 0x10060000    | 0x1006FFFF  | Reserved 64 KB                                                                                                 | &#10060;        |
        | 0x10070000    | 0x1007FFFF  | Reserved 64 KB                                                                                                 | &#10060;        |
        | 0x10080000    | 0x1008FFFF  | Cipher register 64 KB                                                                                          | &#9989;         |
        | 0x10090000    | 0x1009FFFF  | Hash register 64 KB                                                                                            | &#9989;         |
        | 0x100A0000    | 0x100AFFFF  | Reserved 64 KB                                                                                                 | &#10060;        |
        | 0x100B0000    | 0x100BFFFF  | Reserved 64 KB                                                                                                 | &#10060;        |
        | 0x100C0000    | 0x100CFFFF  | MMC0 register 64 KB                                                                                            | &#9989;         |
        | 0x100D0000    | 0x100DFFFF  | MMC1 register 64 KB                                                                                            | &#9989;         |
        | 0x100E0000    | 0x100EFFFF  | MMC2 register 64 KB                                                                                            | &#9989;         |
        | 0x100F0000    | 0x100FFFFF  | Reserved 64 KB                                                                                                 | &#10060;        |
        | 0x10100000    | 0x1010FFFF  | Reserved 64 KB                                                                                                 | &#10060;        |
        | 0x10110000    | 0x1011FFFF  | USB 2.0 host OHCI register 64 KB                                                                               | &#9989;         |
        | 0x10120000    | 0x1012FFFF  | USB 2.0 host EHCI register 64 KB                                                                               | &#9989;         |
        | 0x10130000    | 0x1013FFFF  | USB 2.0 device register 64 KB                                                                                  | &#9989;         |
        | 0x10140000    | 0x1014FFFF  | Reserved 64 KB                                                                                                 | &#10060;        |
        | 0x10150000    | 0x1015FFFF  | Reserved 64 KB                                                                                                 | &#10060;        |
        | 0x10160000    | 0x1016FFFF  | Reserved 64 KB                                                                                                 | &#10060;        |
        | 0x10170000    | 0x1017FFFF  | Reserved 64 KB                                                                                                 | &#10060;        |
        | 0x10180000    | 0x1018FFFF  | USB 3.0 register 64 KB                                                                                         | &#10060;        |
        | 0x10190000    | 0x1019FFFF  | Reserved -                                                                                                     | &#10060;        |
        | 0x101A0000    | 0x101AFFFF  | Reserved 64 KB                                                                                                 | &#10060;        |
        | 0x101B0000    | 0x101BFFFF  | Reserved 64 KB                                                                                                 | &#10060;        |
        | 0x101C0000    | 0x101DFFFF  | Reserved 128 KB                                                                                                | &#10060;        |
        | 0x101E0000    | 0x101FFFFF  | Reserved 128 KB                                                                                                | &#10060;        |
        | 0x10200000    | 0x1020FFFF  | Reserved 64 KB                                                                                                 | &#10060;        |
        | 0x10210000    | 0x102FFFFF  | Reserved -                                                                                                     | &#10060;        |
        | 0x10300000    | 0x1030FFFF  | GIC register 64 KB                                                                                             | &#9989;         |
        | 0x10310000    | 0x103FFFFF  | Reserved 64 KB                                                                                                 | &#10060;        |
        | 0x10400000    | 0x1051FFFF  | Reserved 1088 KB                                                                                               | &#10060;        |
        | 0x10600000    | 0x106FFFFF  | Reserved -                                                                                                     | &#10060;        |
        | 0x10700000    | 0x1070FFFF  | Reserved 64 KB                                                                                                 | &#10060;        |
        | 0x10710000    | 0x10FFFFFF  | Reserved -                                                                                                     | &#10060;        |
        | 0x11000000    | 0x1100FFFF  | VDP register 64 KB                                                                                             | &#9989;         |
        | 0x11010000    | 0x1101FFFF  | Reserved 64 KB                                                                                                 | &#10060;        |
        | 0x11020000    | 0x1102FFFF  | Reserved 64 KB                                                                                                 | &#10060;        |
        | 0x11030000    | 0x1103FFFF  | Reserved 64 KB                                                                                                 | &#10060;        |
        | 0x11040000    | 0x1104FFFF  | IVE register 64 KB                                                                                             | &#9989;         |
        | 0x11050000    | 0x1105FFFF  | Reserved 64 KB                                                                                                 | &#10060;        |
        | 0x11070000    | 0x1107FFFF  | Reserved 64 KB                                                                                                 | &#10060;        |
        | 0x11080000    | 0x1108FFFF  | AIAO register 64 KB                                                                                            | &#9989;         |
        | 0x11090000    | 0x1109FFFF  | Reserved 64 KB                                                                                                 | &#10060;        |
        | 0x110A0000    | 0x110AFFFF  | Reserved 64 KB                                                                                                 | &#10060;        |
        | 0x110B0000    | 0x110BFFFF  | Reserved 64 KB                                                                                                 | &#10060;        |
        | 0x110C0000    | 0x110CFFFF  | GZIP register 64 KB                                                                                            | &#10060;        |
        | 0x110D0000    | 0x110FFFFF  | Reserved -                                                                                                     | &#10060;        |
        | 0x11100000    | 0x1110FFFF  | TDE register 64 KB                                                                                             | &#9989;         |
        | 0x11110000    | 0x1111FFFF  | GDC register 64 KB                                                                                             | &#10060;        |
        | 0x11120000    | 0x1112FFFF  | VGS register 64 KB                                                                                             | &#9989;        |
        | 0x11130000    | 0x1117FFFF  | Reserved -                                                                                                     | &#10060;        |
        | 0x11180000    | 0x1118FFFF  | VPSS register 64 KB                                                                                            | &#9989;         |
        | 0x11190000    | 0x1119FFFF  | Reserved 64 KB                                                                                                 | &#10060;        |
        | 0x111A0000    | 0x111AFFFF  | Reserved 64 KB                                                                                                 | &#10060;        |
        | 0x111B0000    | 0x111BFFFF  | Reserved 64 KB                                                                                                 | &#10060;        |
        | 0x111C0000    | 0x111FFFFF  | Reserved -                                                                                                     | &#10060;        |
        | 0x11200000    | 0x1120FFFF  | JPGE register 64 KB                                                                                            | &#9989;        |
        | 0x11210000    | 0x1121FFFF  | Reserved 64 KB                                                                                                 | &#10060;        |
        | 0x11220000    | 0x1123FFFF  | Reserved -                                                                                                     | &#10060;        |
        | 0x11240000    | 0x1124FFFF  | Reserved 64 KB                                                                                                 | &#10060;        |
        | 0x11250000    | 0x1125FFFF  | Reserved 64 KB                                                                                                 | &#10060;        |
        | 0x11260000    | 0x1126FFFF  | Reserved 64 KB                                                                                                 | &#10060;        |
        | 0x11270000    | 0x1127FFFF  | Reserved 64 KB                                                                                                 | &#10060;        |
        | 0x11280000    | 0x1128FFFF  | VEDU register 64 KB                                                                                            | &#9989;         |
        | 0x11290000    | 0x1129FFFF  | Reserved 64 KB                                                                                                 | &#10060;        |
        | 0x112A0000    | 0x112AFFFF  | Reserved 64 KB                                                                                                 | &#10060;        |
        | 0x112B0000    | 0x112BFFFF  | Reserved 64 KB                                                                                                 | &#10060;        |
        | 0x112C0000    | 0x112FFFFF  | Reserved 64 KB                                                                                                 | &#10060;        |
        | 0x11300000    | 0x1130FFFF  | MIPI0/1 register 64 KB                                                                                         | &#9989;         |
        | 0x11310000    | 0x1137FFFF  | Reserved -                                                                                                     | &#10060;        |
        | 0x11380000    | 0x113EFFFF  | VICAP0 register 448 KB                                                                                         | &#9989;         |
        | 0x113F0000    | 0x1147FFFF  | Reserved -                                                                                                     | &#10060;        |
        | 0x11480000    | 0x114EFFFF  | VICAP1 register 448 KB                                                                                         | &#10060;        |
        | 0x114F0000    | 0x11FFFFFF  | Reserved -                                                                                                     | &#10060;        |
        | 0x12000000    | 0x12000FFF  | Timer0/Timer1 register 4 KB                                                                                    | &#9989;         |
        | 0x12001000    | 0x12001FFF  | Timer2/Timer3 register 4 KB                                                                                    | &#9989;         |
        | 0x12002000    | 0x12002FFF  | Timer4/Timer5 register 4 KB                                                                                    | &#9989;         |
        | 0x12003000    | 0x12003FFF  | Reserved 4 KB                                                                                                  | &#10060;        |
        | 0x12004000    | 0x1200FFFF  | Reserved 48 KB                                                                                                 | &#10060;        |
        | 0x12010000    | 0x1201FFFF  | CRG register 64 KB                                                                                             | &#10060;        |
        | 0x12020000    | 0x1202FFFF  | SYSCTRL register 64 KB                                                                                         | &#10060;        |
        | 0x12030000    | 0x1203FFFF  | MISC register 64 KB                                                                                            | &#10060;        |
        | 0x12040000    | 0x120407FF  | I/O MUX configuration register 2 KB Multiplexing relationship                                                  | &#10060;        |
        | 0x12040800    | 0x1204FFFF  | I/O CTRL configuration register 62 KB Drive current                                                            | &#10060;        |
        | 0x12050000    | 0x12050FFF  | DDRT register 4 KB                                                                                             | &#9989;         |
        | 0x12051000    | 0x12051FFF  | Reserved 60 KB                                                                                                 | &#10060;        |
        | 0x12060000    | 0x1206FFFF  | MDDRC/DDR PHY register 64 KB                                                                                   | &#9989;         |
        | 0x12070000    | 0x120707FF  | Reserved 2 KB                                                                                                  | &#10060;        |
        | 0x12070800    | 0x1207FFFF  | OTP key control register 62 KB                                                                                 | &#9989;         |
        | 0x12080000    | 0x1208FFFF  | WDG register 64 KB                                                                                             | &#9989;         |
        | 0x12090000    | 0x12097FFF  | RTC register 32 KB                                                                                             | &#9989;         |
        | 0x12098000    | 0x1209FFFF  | Power Controller register 32KB                                                                                 | &#10060;        |
        | 0x120A0000    | 0x120AFFFF  | PMC register 64 KB                                                                                             | &#9989;         |
        | 0x120B0000    | 0x120BFFFF  | RSA register 64 KB                                                                                             | &#9989;         |
        | 0x120C0000    | 0x120CFFFF  | TRNG register 64 KB                                                                                            | &#9989;         |
        | 0x120D0000    | 0x120DFFFF  | SYSCNT register 64 KB                                                                                          | &#10060;        |
        | 0x120E0000    | 0x120EFFFF  | LSADC register 64 KB                                                                                           | &#9989;         |
        | 0x120F0000    | 0x120FFFFF  | IR register 64 KB                                                                                              | &#9989;         |
        | 0x12100000    | 0x12100FFF  | UART0 register 4 KB                                                                                            | &#9989;         |
        | 0x12101000    | 0x12101FFF  | UART1 register 4 KB                                                                                            | &#9989;         |
        | 0x12102000    | 0x12102FFF  | UART2 register 4 KB                                                                                            | &#9989;         |
        | 0x12103000    | 0x12103FFF  | UART3 register 4 KB                                                                                            | &#9989;         |
        | 0x12104000    | 0x12104FFF  | UART4 register 4 KB                                                                                            | &#9989;         |
        | 0x12105000    | 0x1210FFFF  | Reserved 44 KB                                                                                                 | &#10060;        |
        | 0x12110000    | 0x12110FFF  | I2C0 register 4 KB                                                                                             | &#9989;         |
        | 0x12111000    | 0x12111FFF  | I2C1 register 4 KB                                                                                             | &#9989;         |
        | 0x12112000    | 0x12112FFF  | I2C2 register 4 KB                                                                                             | &#9989;         |
        | 0x12113000    | 0x12113FFF  | I2C3 register 4 KB                                                                                             | &#9989;         |
        | 0x12114000    | 0x12114FFF  | Reserved 4 KB                                                                                                  | &#10060;        |
        | 0x12115000    | 0x1211FFFF  | Reserved 44 KB                                                                                                 | &#10060;        |
        | 0x12120000    | 0x12120FFF  | SSP0 register 4 KB                                                                                             | &#9989;           |
        | 0x12121000    | 0x12121FFF  | SSP1 register 4 KB                                                                                             | &#9989;           |
        | 0x12122000    | 0x12122FFF  | SSP2 register 4 KB                                                                                             | &#9989;           |
        | 0x12123000    | 0x12123FFF  | SSP3 register 4 KB                                                                                             | &#9989;           |
        | 0x12124000    | 0x12124FFF  | spi_3wire0 register 4 KB                                                                                       | &#9989;         |
        | 0x12125000    | 0x12125FFF  | spi_3wire1 register 4 KB                                                                                       | &#9989;         |
        | 0x12126000    | 0x1212FFFF  | Reserved 40 KB                                                                                                 | &#10060;        |
        | 0x12130000    | 0x1213FFFF  | PWM register 64 KB                                                                                             | &#9989;         |
        | 0x12140000    | 0x12140FFF  | GPIO0 register 4 KB                                                                                            | &#9989;         |
        | 0x12141000    | 0x12141FFF  | GPIO1 register 4 KB                                                                                            | &#9989;         |
        | 0x12142000    | 0x12142FFF  | GPIO2 register 4 KB                                                                                            | &#9989;         |
        | 0x12143000    | 0x12143FFF  | GPIO3 register 4 KB                                                                                            | &#9989;         |
        | 0x12144000    | 0x12144FFF  | GPIO4 register 4 KB                                                                                            | &#9989;         |
        | 0x12145000    | 0x12145FFF  | GPIO5 register 4 KB                                                                                            | &#9989;         |
        | 0x12146000    | 0x12146FFF  | GPIO6 register 4 KB                                                                                            | &#9989;         |
        | 0x12147000    | 0x12147FFF  | GPIO7 register 4 KB                                                                                            | &#9989;         |
        | 0x12148000    | 0x12148FFF  | GPIO8 register 4 KB                                                                                            | &#9989;         |
        | 0x12149000    | 0x12149FFF  | GPIO9 register 4 KB                                                                                            | &#9989;         |
        | 0x1214A000    | 0x1214AFFF  | GPIO10 register 4 KB                                                                                           | &#9989;         |
        | 0x1214B000    | 0x1214BFFF  | GPIO11 register 4 KB                                                                                           | &#9989;         |
        | 0x1214C000    | 0x1214CFFF  | GPIO12 register 4 KB                                                                                           | &#9989;         |
        | 0x1214D000    | 0x1214DFFF  | GPIO13 register 4 KB                                                                                           | &#9989;         |
        | 0x1214E000    | 0x1214EFFF  | GPIO14 register 4 KB                                                                                           | &#9989;         |
        | 0x1214F000    | 0x1214FFFF  | Reserved 4 KB                                                                                                  | &#10060;        |
        | 0x12150000    | 0x12150FFF  | GPIO16 register 4 KB                                                                                           | &#9989;         |
        | 0x12151000    | 0x1215FFFF  | Reserved 60 KB                                                                                                 | &#10060;        |
        | 0x12160000    | 0x1216FFFF  | PCIe register 64 KB                                                                                            | &#10060;        |
        | 0x12170000    | 0x1217FFFF  | Reserved 64 KB                                                                                                 | &#10060;        |
        | 0x12180000    | 0x12FFFFFF  | Reserved -                                                                                                     | &#10060;        |
        | 0x13000000    | 0x13FFFFFF  | Reserved -                                                                                                     | &#10060;        |
        | 0x14000000    | 0x14FFFFFF  | FMC storage address space 16 MB                                                                                | &#10060;        |
        | 0x15000000    | 0x1EFFFFFF  | Reserved -                                                                                                     | &#10060;        |
        | 0x1F000000    | 0x1F0FFFFF  | CCI register 1 MB                                                                                              | &#10060;        |
        | 0x1F10FFFF    | 0x1FFEFFFF  | Reserved -                                                                                                     | &#10060;        |
        | 0x20000000    | 0x27FFFFFF  | PCIe configuration space 128 MB                                                                                | &#10060;        |
        | 0x28000000    | 0x2FFFFFFF  | PCIe memory space 128 MB                                                                                       | &#10060;        |
        | 0x30000000    | 0x37FFFFFF  | Reserved 128 MB                                                                                                | &#10060;        |
        | 0x38000000    | 0x3FFFFFFF  | Reserved 128 MB                                                                                                | &#10060;        |
        | 0x40000000    | 0x7FFFFFFF  | Reserved 1 GB                                                                                                  | &#10060;        |
        | 0x80000000    | 0xFFFFFFFF  | DDR address space 2 GB                                                                                         | &#10060;        |

        <!-- overview:begin -->

        ### Diagrams

        ![Logic block diagram](assets/diagrams/hi3516av200-logic.svg)

        ![Register blocks by function](assets/diagrams/hi3516av200-blocks.svg)

        ![Clock tree](assets/diagrams/hi3516av200-clocks.svg)

        ![Boot flow](assets/diagrams/hi3516av200-boot.svg)

        ![Video pipeline](assets/diagrams/hi3516av200-video.svg)

        ![Interrupt topology](assets/diagrams/hi3516av200-irq.svg)

        ![Reset tree](assets/diagrams/hi3516av200-resets.svg)

        ![Storage, USB and Ethernet paths](assets/diagrams/hi3516av200-io.svg)

        ![DMA request lines](assets/diagrams/hi3516av200-dma.svg)

        ![Power domains](assets/diagrams/hi3516av200-power.svg)

        ![CRG register map](assets/diagrams/hi3516av200-crgmap.svg)

        ![IP editions across the camera family](assets/diagrams/hi3516av200-editions.svg)

        ### Variants and key specifications (Hi3516A V200 data sheet Issue 01 2018-07-05 and Hi3519 V101 data sheet Issue 01 2018-07-05, chapter 1)

        |  | Hi3516A V200 | Hi3519 V101 |
        |---|---|---|
        | Chip ID | SCSYSID (0xEE0) reads 0x06000001 | SC_SYSID 0x35190101 (four byte registers SCSYSID3..0) |
        | CPU | big.LITTLE: Cortex-A17 up to 1.25 GHz (32 KB I + 32 KB D L1, 256 KB L2) plus Cortex-A7 up to 800 MHz (32 KB I + 32 KB D, 128 KB L2); NEON + FPU | same |
        | DDR | 32-bit DDR4 / DDR3 / DDR3L / LPDDR3 up to 800 MHz (1.6 Gbit/s); 1024 MB per 16-bit part, 2048 MB total | same list; the logic figure labels 933 MHz for DDR4/DDR3/DDR3L and 800 MHz for LPDDR3 |
        | Video encode | H.264 BP/MP/HP, H.265 MP, I/P/B, MJPEG/JPEG; 16 MP (4608 x 3456) max, 100 Mbit/s; 5M@30 + 720p@30, 6M@30 + VGA@30; JPEG 3840 x 2160@30 | 3840 x 2160@30 + 1080p@30 + 3840 x 2160@2 snapshot; same maxima |
        | ISP / VI | 2 independent ISP channels; main input 16 MP (12-lane MIPI/LVDS/sub-LVDS/HiSPi), second input 8 MP (4096 x 2160) or 9 MP (3000 x 3000) on 4 lanes; DC 8/10/12/14-bit 150 MHz, BT.601/656/1120; WDR 4F/3F/2F (second channel: 2F only), fisheye / lens correction (GDC) | same |
        | Video output | CVBS (load detect), BT.1120/BT.656 up to 1080p@60, LCD | same |
        | Audio | 16-bit codec with dual differential MIC input, I2S | same |
        | Peripherals | 5 UART, IR, I2C (4), SSP (4), GPIO, 8 PWM, 3-channel SAR ADC, RTC, POR, external reset, 2 SD 3.0 / SDIO 3.0, 1 USB 3.0/2.0 host/device port, 1 PCIe 2.0 lane (RC or EP), GMAC RGMII/RMII with TSO | same |
        | Flash | SPI NOR (1/2/4 wire, 3/4-byte address, 32 MB), SPI NAND (512 MB), eMMC 5.0 (2 TB), NAND (8-bit, SLC/MLC, 4/8/24/40/64-bit ECC) | same |
        | Security | AES / DES / 3DES, RSA 1024/2048/4096 verify, SHA1/256 + HMAC, 512-bit OTP, TRNG | same |
        | Package / supply | FC-CSP 10 x 10 mm, 0.4 mm pitch; core 0.9 V, I/O 3.3 V; 1.35 W typical | same package; 1.5 W typical |
        | SDK | Linux 3.18 | same |

        The two data sheets are otherwise textually identical (same boot table, address map, CRG and DMAC chapters); the RDL folders differ in the instances present (see the edition matrix below).

        ### Boot modes (data sheet 1.4, Table 1-1; strap pins in parentheses)

        Strap pins: BOOTROM_SEL (VO_DATA2), BOOT_SEL1 (VO_DATA1), BOOT_SEL0 (VO_DATA0), SFC_EMMC_BOOT_MODE (VO_DATA3), SFC_DEVICE_MODE (VO_DATA4), SPI_NAND_SEL (VO_DATA8), UPDATE_FROM_SDIO0 (VO_DATA6), UPDATE_FROM_SDIO0_N (PWR_BUTTON1).

        | BOOTROM_SEL | BOOT_SEL1 | BOOT_SEL0 | SFC_EMMC_BOOT_MODE | SFC_DEVICE_MODE | SPI_NAND_SEL | Boot mode |
        |---|---|---|---|---|---|---|
        | 1 | x | x | x | x | x | BOOTROM, fastboot (serial download); UPDATE_FROM_SDIO0 = 0 and _N = 1 |
        | x | x | x | x | x | x | BOOTROM, SDIO0 upgrade mode when UPDATE_FROM_SDIO0 = 1 or UPDATE_FROM_SDIO0_N = 0 |
        | 0 | 0 | 0 | 0 | 0 | x | SPI NOR, 3-byte address |
        | 0 | 0 | 0 | 1 | 0 | x | SPI NOR, 4-byte address |
        | 0 | 0 | 0 | 0 | 1 | 0 | SPI NAND, 1-wire, plane address bit disabled |
        | 0 | 0 | 0 | 1 | 1 | 0 | SPI NAND, 4-wire, plane address bit disabled |
        | 0 | 0 | 0 | 0 | 1 | 1 | SPI NAND, 1-wire, plane address bit enabled |
        | 0 | 0 | 0 | 1 | 1 | 1 | SPI NAND, 4-wire, plane address bit enabled |
        | 0 | 0 | 1 | x | x | x | NAND flash |
        | 0 | 1 | 0 | 0 | x | x | eMMC, 4-wire |
        | 0 | 1 | 0 | 1 | x | x | eMMC, 8-wire |
        | 0 | 1 | 1 | x | x | x | slave mode: CPU held in reset, a PCIe master loads the DDR and releases the reset |

        In fastboot and SDIO0 upgrade mode the BOOTROM, after a serial timeout or a failed card upgrade, falls back to BOOT_SEL1/BOOT_SEL0 (00 SPI flash, 01 NAND, 10 eMMC); in upgrade mode the same two straps choose the device to be programmed. The 0x00000000 window follows {BOOTROM_SEL, BOOT_SEL1, BOOT_SEL0}: 000 SPI flash, 001 NAND, 011 BOOTRAM, otherwise BOOTROM, until the remap is cleared.

        ### Memory map notes (data sheet 1.5, Table 1-2)

        | Window | Size | Function |
        |---|---|---|
        | 0x00000000-0x03FFFFFF | 64 MB | boot memory selected by the straps until the remap is cleared, then on-chip RAM |
        | 0x04000000 | 64 KB window, 32 KB real | BOOTROM |
        | 0x04010000 | 64 KB window, 32 KB real | BOOTRAM (on-chip RAM) |
        | 0x14000000-0x14FFFFFF | 16 MB | FMC storage window (SPI NOR / SPI NAND / NAND) |
        | 0x1F000000 | 1 MB | CCI-400 registers |
        | 0x20000000-0x27FFFFFF | 128 MB | PCIe configuration space |
        | 0x28000000-0x2FFFFFFF | 128 MB | PCIe memory space |
        | 0x80000000-0xFFFFFFFF | 2 GB | DDR |

        Register windows: a 4 KB or 64 KB window per block; the I/O MUX (2 KB) and I/O CTRL (62 KB) registers share the 0x12040000 window and the RTC (32 KB) and power controller (32 KB) share 0x12090000.

        ### Clocks (data sheet 3.2; identical in the Hi3516A V200 and Hi3519 V101 data sheets except the VEDU choices)

        XIN is a fixed 24 MHz crystal, RTC_XIN a 32.768 kHz crystal. Four PLLs (APLL, DPLL, VPLL, EPLL) with two PERI_CRG_PLLn registers each; FOUTVCO = 24 MHz x (fbdiv + frac/2^24) / refdiv with 800 MHz < FOUTVCO <= 2.3 GHz, FOUTPOSTDIV = FOUTVCO / (pstdiv1 x pstdiv2) with pstdiv1 >= pstdiv2, FOUT1PH0 / 2 / 3 / 4 = FOUTVCO / (pstdiv1 x pstdiv2 x 2 / 4 / 6 / 8); FOUTVCO2X = 2 x FOUTVCO. APLL and DPLL are programmable, the others fixed. Reprogram: switch to a non-PLL source, change the PLL, wait 0.1 ms, poll PERI_CRG58[4:0] for lock.

        | PLL | Config registers |
        |---|---|
        | APLL | PERI_CRG_PLL0 / PERI_CRG_PLL1 |
        | DPLL | PERI_CRG_PLL4 / PERI_CRG_PLL5 |
        | VPLL | PERI_CRG_PLL6 / PERI_CRG_PLL7 |
        | EPLL | PERI_CRG_PLL8 / PERI_CRG_PLL9 |

        Fixed outputs in Figure 3-3: VCO 1188 MHz (VPLL: 594 / 297 / 148.5 / 99 / 74.25 MHz), VCO 1500 MHz (EPLL: 500 / 250 / 125 MHz, 750 MHz and 3000 MHz VCO2X), VCO 2376 MHz (792 / 475 / 340 / 396 / 198 / 54 / 37 / 27 MHz after dividers); the PLL names above are the assignment implied by the register tables (INFERRED for which VCO belongs to which PLL).

        | Module | Default | Selectable frequencies (MHz) |
        |---|---|---|
        | A7 | 24 | 24, APLL POSTDIV, 594, 792 |
        | A17 | 24 | 24, APLL_FOUTVCO, APLL_POSTDIV, 792, 594 |
        | DDR | 24 | 24, DPLL_POSTDIV, 396, 340, 300 |
        | SYSAXI | 24 | 24, 198 |
        | VEDU | reserved | 396 (Hi3516A V200); 396, 500, 594 (Hi3519 V101): select before starting the module |
        | IVE / VGS | 300 | 300, 396, 500 |
        | GDC | 340 | 340, 475, 400 |
        | VPSS | 214 | 214, 300, 396 |
        | ISP0 / ISP1 | 214 | 214, 300, 340 or the VI clock (VI / VI/2); ISP1 max 300 when VI1 is selected |
        | VI0 / VI1 | 214 | 214, 300, 500, 600, 340, 396 |
        | TDE | 150 | 150 |
        | JPGE | 400 | 400 |
        | GZIP | 500 | 500 |
        | AIAO | 1188 | 1188, 1500 (divided to the working clock) |
        | FMC | 24 | 24, 75, 125, 150, 200, 250, 300, 400 |
        | MMC0/1/2 | 100 | 100, 200, 400, 594, 792, 1188 (divided) |
        | VDP core | 300 | 198, 300 |
        | VDP clock out | 148.5 | 148.5, 74, 37, 107, 54, 27, LCD divider |
        | sensor0/1 clock out | 74.25 | 74.25, 72, 54, 50, 24, 37.125, 36, 27, 25, 12 |

        Select registers (Table 3-5/3-6): a7_clksel PERI_CRG13[9:7], a17_clksel [6:4], ddr_clksel [2:0], sysaxi_clksel [13:12]; vdp_core_clksel PERI_CRG17[17], vdp_out_clksel [16:14], hd_div_mode [13:12], lcd_mclk_div PERI_CRG18[26:0]; sensor0_clksel PERI_CRG16[3:0], sensor1_clksel [11:8], vi0_clksel PERI_CRG19[2:0], vi1_clksel PERI_CRG21[2:0], isp0_clksel PERI_CRG21[18:14], isp1_clksel [10:6]; vpss PERI_CRG19[7:5], vedu [12:10], vgs [15:13], gdc [18:16], ive [21:19]; fmc_clksel PERI_CRG48[4:2]; mmc0/1/2_clksel PERI_CRG49[12:10] / [4:2] / [20:18] (clk_mode bits [13] / [5] / [21]); ca_clksel PERI_CRG31[6]; pwm_clksel PERI_CRG55[3:2], i2c_clksel PERI_CRG57[26], uart_clksel PERI_CRG57[25]; mac_speed / port_select PERI_CRG59[1:0]; ext_fephy_clksel PERI_CRG51[6], rmii_clksel [4]; aiao_clksel PERI_CRG32[3:2]; combphy_refclk_sel PERI_CRG43[9], usb3_utmi_clksel PERI_CRG46[13].

        ### Resets and power (data sheet 3.1, 3.10)

        Reset types: global hard reset npor (external reset pin and internal POR), watchdog reset (wdg_rst_req), global soft reset sys_rst_n (system controller, level 1), per-module reset xx_rst_n (CRG PERI_CRGn bits, level 2; level controlled, not self-clearing); soft reset deasserts after at least 360 system clocks and must not be requested again inside that window.

        Power: the power controller (0x12098000) and RTC form the always-on area; PWR_SEQ0-2 switch the other supplies through PWR_EN0/1/2 with wakeup pins PWR_WAKEUP0/1/2 and PWR_BUTTON0/1; it runs from the 32.768 kHz RTC clock, so the RTC crystal and AVDD_BAT must be present. Standby current is in the microampere range. Further: clock gating / frequency selects, module low-power, DDR self-refresh, DVFS based on A17 load, AVS (PMC at 0x120A0000).

        ### DMAC request lines (data sheet 3.6, Table 3-11; 4 channels; identical in the Hi3519 V101 data sheet)

        | Request lines | Peripheral | Select |
        |---|---|---|
        | 0 / 1 | UART0 or UART4 RX / TX | MISC_CTRL1 dma_01_sel |
        | 2 / 3 | UART1 RX / TX |  |
        | 4 / 5 | UART2 RX / TX |  |
        | 6 / 7 | UART3, I2C3 or SSP3 RX / TX | dma_67_sel |
        | 8 / 9 | I2C0 or SSP0 RX / TX | dma_89_sel |
        | 10 / 11 | I2C1 or SSP1 RX / TX | dma_ab_sel |
        | 12 / 13 | SSP2 RX / TX |  |
        | 14 / 15 | I2C2 RX / TX |  |

        Selection fields live in MISC_CTRL1 (dma_01_sel: 0 UART0, 1 UART4; dma_67_sel: 0 UART3, 1 I2C3, 2 or 3 SSP3; dma_89_sel: 0 I2C0, 1 SSP0; dma_ab_sel: 0 I2C1, 1 SSP1). Memory has no request line; channels 2 and 3 insert an idle cycle after each bus operation.

        ### Pin multiplexing summary (generated from the RDL MUX block)

        106 pad registers (MUX at 0x12040000, one 32-bit register per pad: the field value selects the pad function, 0 is the GPIO function on almost every pad); up to 4 functions per pad. Drive strength and slew are in the separate pad-control registers. Pad counts per function family (a pad that offers several families is counted in each):

        | Function family | Pads | Pads (first six) |
        |---|---|---|
        | GPIO | 106 | FLASH_TRIG, SHUTTER_TRIG, SENSOR1_CLK, SENSOR1_RSTN, SENSOR1_HS, SENSOR1_VS, ... |
        | UART | 8 | UART1_RTSN, UART1_RXD, UART1_CTSN, UART1_TXD, UART2_RXD, UART2_TXD, ... |
        | SPI / SSP | 21 | FLASH_TRIG, SPI1_SCLK, SPI1_SDO, SPI1_SDI, SPI1_CSN, SPI2_SCLK, ... |
        | I2C | 10 | SPI1_SCLK, SPI1_SDO, I2C2_SDA, I2C2_SCL, VO_DATA12, VO_DATA13, ... |
        | PWM | 15 | FLASH_TRIG, SHUTTER_TRIG, JTAG_TRSTN, JTAG_TCK, JTAG_TMS, JTAG_TDO, ... |
        | Video input (VI, sensor, MIPI, ISP) | 19 | FLASH_TRIG, SHUTTER_TRIG, SENSOR1_CLK, SENSOR1_RSTN, SENSOR1_HS, SENSOR1_VS, ... |
        | Video output (VO, LCD, BT) | 28 | VO_CLK, VO_DATA0, VO_DATA1, VO_DATA2, VO_DATA3, VO_DATA4, ... |
        | Storage (SFC, NAND, eMMC, SDIO) | 18 | SDIO0_CARD_POWER_EN, SDIO0_CARD_DETECT, SDIO0_CWPR, SDIO0_CCLK_OUT, SDIO0_CCMD, SDIO0_CDATA0, ... |
        | Ethernet (RGMII, RMII, MII) | 14 | RGMII_TX_EN, RGMII_TX_CLK, RGMII_TXD0, RGMII_TXD1, RGMII_TXD2, RGMII_TXD3, ... |
        | Audio (I2S, AIAO, codec) | 7 | SPI2_SCLK, SPI2_SDO, JTAG_TRSTN, JTAG_TCK, JTAG_TMS, JTAG_TDO, ... |
        | Debug, JTAG, clocks | 5 | JTAG_TRSTN, JTAG_TCK, JTAG_TMS, JTAG_TDO, JTAG_TDI |
        | Interrupt, IR, ADC, misc | 6 | JTAG_TDI, USB3_PWREN, USB2_PWREN, SAR_ADC_CH1, SAR_ADC_CH2, SAR_ADC_CH3 |
        | Other | 8 | PWM0, PWM1, PWM2, PWM3, SDIO0_CDATA1, MDCK, ... |

        ### IP editions in the RDL (generated; same name = same IP edition, a different name = a different IP doing the same job)

        | Function | A V100 | D V100 | A V200 | 3519 V101 | A V300 | D V300 |
        |---|---|---|---|---|---|---|
        | CPU / interrupt | ARM_GIC400 | ARM_GIC400 | ARM_GIC400 | ARM_GIC400 | - | - |
        | DMA controller | DMAC | DMAC | DMAC | DMAC | DMAC_V2 | DMAC_V2 |
        | Timers / watchdog | TIMER_SP804, WDG_SP805 | TIMER_SP804, WDG_SP805 | TIMER_SP804, WDG_SP805 | TIMER_SP804, WDG_SP805 | TIMER_SP804, WDG_SP805 | TIMER_SP804, WDG_SP805 |
        | UART | ARM_PL011 | ARM_PL011 | ARM_PL011 | ARM_PL011 | ARM_PL011 | ARM_PL011 |
        | I2C | I2C_DW | I2C_DW | I2C_DW | I2C_DW | I2C_V2 | I2C_V2 |
        | SPI | SPI | SPI | SPI, SPI_3WIRE | SPI, SPI_3WIRE | SPI, SPI_3WIRE | SPI, SPI_3WIRE |
        | GPIO | ARM_PL061 | ARM_PL061 | ARM_PL061 | ARM_PL061 | ARM_PL061 | ARM_PL061 |
        | PWM | PWM_GRP | PWM_GRP | PWM_GRP | PWM_GRP | PWM_GRP | PWM_GRP |
        | LSADC / SAR ADC | LSADC | LSADC | LSADC_V2 | LSADC_V2 | LSADC_V2 | LSADC_V2 |
        | IR / RTC | IR, RTC_SPI | IR, RTC_SPI | IR, RTC_SPI | IR, RTC_SPI | IR, RTC_SPI | IR, RTC_SPI |
        | Ethernet | GMAC | GMAC | GMAC | GMAC | FEMAC | FEMAC |
        | USB | USB_DEVICE, USB_EHCI, USB_OHCI | USB_DEVICE, USB_EHCI, USB_OHCI | USB_DEVICE, USB_EHCI, USB_OHCI | USB_DEVICE, USB_EHCI, USB_OHCI | - | chip-local USB, chip-local USB2_PHY |
        | SD / eMMC | DWMMC | DWMMC | DWMMC | DWMMC | DWMMC | DWMMC |
        | Flash controller | NANDC, SFC_350, SNFC | NANDC, SFC_350, SNFC | FMC | FMC | FMC | FMC |
        | DDR controller | DDRC_V2 | DDRC_V2 | MDDRC | MDDRC | - | chip-local DDRC_AXI, chip-local DDRC_DMC, chip-local DDRC_PHY, chip-local DDRC_QOSB, chip-local DDRC_TZASC |
        | System / clock | CRG, MISC_CTRL, SYS_CTRL | CRG, MISC_CTRL, SYS_CTRL | MISC_CTRL, PERI_CRG, SYS_CTRL | MISC_CTRL, PERI_CRG, SYS_CTRL | CRG, MISC_CTRL, SYS_CTRL | CRG, chip-local MISC_CTRL, chip-local SYS_CTRL |
        | Pin control | IO_CONFIG | IO_CONFIG | MUX, PAD | MUX, PAD | - | - |
        | Security | CIPHER_MC | CIPHER_MC | CIPHER_MC, HASH, OTP_KEY_CTRL, RSA, TRNG | CIPHER_MC, HASH, OTP_KEY_CTRL, RSA, TRNG | OTP_USER, RSA, SPACC, TRNG | OTP_USER, RSA, SPACC, TRNG |
        | Audio | AIAO | AIAO | AIAO | AIAO | AIAO | AIAO, chip-local ACODEC |
        | VICAP / MIPI / ISP | MIPI_RX_AV100, VICAP_AV100 | MIPI_RX_AV100, VICAP_AV100 | ISP_AV200, MIPI_RX_AV200, VICAP_AV200 | ISP_AV200, MIPI_RX_AV200, VICAP_AV200 | MIPI_RX_AV300, VICAP_AV300 | chip-local MIPI_RX, chip-local MIPI_TX, chip-local VICAP |
        | VDP | VDP_AV100 | VDP_AV100 | VDP_AV200 | VDP_AV200 | VDP_AV300 | chip-local VDP |
        | VPSS / VGS / GDC | VGS, VPSS | VGS, VPSS | VGS, VPSS | VGS, VPSS | VGS, VPSS | - |
        | TDE / IVE / NNIE | IVE, TDE_G2 | IVE, TDE_G2 | IVE, TDE | IVE, TDE | IVE, TDE_G3 | - |
        | Video codec | JPGE, VEDU_V100, VEDU_V2 | JPGE, VEDU_V100, VEDU_V2 | JPGE, VEDU_V2 | JPGE, VEDU_V2 | JPGD_AV300, JPGE_AV300, VEDU_V3 | - |

        A V100 and D V100 share one register description (one data sheet). The A V200 and 3519 V101 use the same block types (the _AV200 ISP/VICAP/MIPI/VDP editions, MDDRC, FMC, PERI_CRG, MUX/PAD). The A V300 and D V300 are the next generation: DMAC_V2, I2C_V2, FEMAC, LSADC_V2, SPACC/RSA/OTP_USER, VEDU_V3 and the _AV300 editions; the D V300 root uses chip-local blocks extracted from its own data sheet where the A V300 root has shared editions or none (VICAP, VDP and CRG/MISC_CTRL registers are identical to the A V300 ones: docs/rdl-campaign/hi3516dv300-compare.md). Blocks that are absent in a column are absent from that root (not necessarily from the chip; see block-presence.csv).

        ### Interrupts (GIC interrupt IDs, data sheet Table 3-8)

        | # | Source | # | Source | # | Source |
        |---|---|---|---|---|---|
        | 0-31 | CPU internal interrupt | 55 | MMC0 | 79 | CCI |
        | 32 | WatchDog | 56 | MMC1 | 80 | GDC |
        | 33 | RTC/TEM_CAP | 57 | GSF | 81 | A17_COMMRX |
        | 34 | Reserved | 58 | Cipher | 82 | A17_COMMTX |
        | 35 | Reserved | 59 | VDP | 83 | A7_COMMRX |
        | 36 | UART0 | 60 | MIPI0 | 84 | A7_COMMTX |
        | 37 | UART1 | 61 | MIPI1 | 85 | Reserved |
        | 38 | UART2 | 62 | VICAP0 | 86 | PCIE_CFG_LINK_AUTO_BW |
        | 39 | UART3 | 63 | VICAP1 | 87 | PCIE_CFG_BW_MGT |
        | 40 | UART4 | 64 | VPSS | 88 | PCIE_PM |
        | 41 | SSP0/I2C0 | 65 | Reserved | 89 | PCIE_INTA |
        | 42 | SSP1/I2C1 | 66 | TDE | 90 | PCIE_INTB |
        | 43 | SSP2 | 67 | VGS | 91 | PCIE_INTC |
        | 44 | SSP3/I2C3 | 68 | AIAO | 92 | PCIE_INTD |
        | 45 | MMC2 | 69 | VEDU | 93 | PCIE_EDMA |
        | 46 | I2C2 | 70 | JPGE | 94 | PCIE_MSI |
        | 47 | IR | 71 | IVE | 95 | PCIE_LINK_DOWN |
        | 48 | LSADC | 72 | Reserved | 96 | Timer0 |
        | 49 | DMAC | 73 | GZIP | 97 | Timer1 |
        | 50 | FMC | 74 | Software int | 98 | Timer2 |
        | 51 | USB2_EHCI | 75 | GPIO0−7 | 99 | Timer3 |
        | 52 | USB2_OHCI | 76 | GPIO8−14 and GPIO16 | 100 | Timer4 |
        | 53 | USB2_DEV | 77 | A7_PMU | 101 | Timer5 |
        | 54 | USB3 | 78 | A17_PMU | 102-127 | Reserved |

        ### Clock-gate and reset map (generated from the PERI_CRG registers)

        | Offset | Register | Description | Gate / reset fields |
        |---|---|---|---|
        | 0x028 | PERI_CRG10 | CoreSight & A17 clock reset configuration register | a17_wakeup_srst_req, a17_toppdbg_clken, a17_wakeup_clken, cs_clken |
        | 0x02C | PERI_CRG11 | A7 clock reset configuration register | pclkdbg_clken, a7_wakeup_clken, a7_wakeup_srst_req, a7_pcieboot_srst_req |
        | 0x030 | PERI_CRG12 | DDR clock configuration register | ddr_hipack_srst_req, ddr_apb_srst_req, ddr_cfg_clken, ddr_hipack_clken, ddr_apb_clken |
        | 0x03C | PERI_CRG15 | VI-MIPI clock reset configuration register | vi0_srst_req, vi0_hrst_req, mipi0_srst_req, mipi_hrst_req, isp0_core_srst_req, isp0_cfg_srst_req, mipi0_core_srst_req, vi0_clken, vi1_srst_req, vi1_hrst_req, ... |
        | 0x040 | PERI_CRG16 | Sensor clock configuration register | sensor0_clken, sensor0_srst_req, sensor0_ctrl_srst_req, sensor1_clken, sensor1_srst_req, sensor1_ctrl_srst_req |
        | 0x044 | PERI_CRG17 | VDP clock and reset control register | vdp_srst_req, vdp_cfg_clken, vdp_core_clken, vdp_pclken, vdp_aclken, vdp_out_clken, vdp_hd_clken, vdp_sd_clken, vdac_clken |
        | 0x048 | PERI_CRG18 | LCD clock configuration register | lcd_clken |
        | 0x050 | PERI_CRG20 | VEDU clock and soft reset control register | vedu_srst_req, vedu_clken |
        | 0x058 | PERI_CRG22 | LCD clock configuration register | vpss_srst_req, vpss_clken |
        | 0x05C | PERI_CRG23 | VGS clock and soft reset control register | vgs_srst_req, vgs_clken |
        | 0x060 | PERI_CRG24 | JPGE clock and soft reset control register | jpge_srst_req, jpge_clken |
        | 0x064 | PERI_CRG25 | TDE clock and soft reset control register | tde_srst_req, tde_clken |
        | 0x06C | PERI_CRG27 | IVE clock and soft reset control register | ive_srst_req, ive_clken |
        | 0x074 | PERI_CRG29 | GDC clock and soft reset control register | gdc_srst_req, gdc_clken |
        | 0x07C | PERI_CRG31 | Hash/LSADC/Cipher clock and soft reset control register | cipher_srst_req, cipher_clken, lsadc_srst_req, lsadc_clken, hash_srst_req, hash_clken |
        | 0x080 | PERI_CRG32 | AIAO clock reset control register | aiao_srst_req, aiao_clken |
        | 0x084 | PERI_CRG33 | GZIP clock and soft reset control register | gzip_srst_req, gzip_clken |
        | 0x0AC | PERI_CRG43 | COMB PHY clock reset control register | combphy_srst_req, combphy_srst_req_sel, combphy_ref_clken |
        | 0x0B0 | PERI_CRG44 | PCIe CTRL clock and soft reset control register | pcie_bus_srst_req, pcie_sys_srst_req, pcie_srst_req, pcie_bus_clken, pcie_sys_clken, pcie_pipe_clken, pcie_aux_clken |
        | 0x0B4 | PERI_CRG45 | USB 2.0 clock and soft reset control register | usb2_hrst_req, usb2_clken, usb2_device_ctrl_srst_req |
        | 0x0B8 | PERI_CRG46 | USB 3.0 CTRL clock and soft reset control register | usb3_vcc_srst_req, usb3_bus_clken, usb3_ref_clken, usb3_suspend_clken, usb3_pipe_clken, usb3_utmi_clken |
        | 0x0C0 | PERI_CRG48 | FMC clock and soft reset control register | fmc_srst_req, fmc_clken |
        | 0x0C4 | PERI_CRG49 | MMC0/1/2 clock and soft reset control register | mmc1_srst_req, mmc1_clken, mmc0_srst_req, mmc0_clken, mmc2_srst_req, mmc2_clken, mmc2_dll_clken, mmc2_dll_srst_req |
        | 0x0CC | PERI_CRG51 | GSF/GMAC clock and soft reset control register | gsf_srst_req, gsf_clken, gmac_if_srst_req, gmac_if_clken, ext_fephy_srst_req |
        | 0x0D8 | PERI_CRG54 | DDRT and IO_HPM clock and soft reset control register | ddrt_srst_req, ddrt_clken |
        | 0x0DC | PERI_CRG55 | PWM clock and reset control register | pwm_srst_req, pwm_clken |
        | 0x0E0 | PERI_CRG56 | RSA/TRNG/KLAD/DMA clock and soft reset control register | dmac_srst_req, dmac_clken, klad_srst_req, klad_clken, trng_srst_req, trng_clken, rsa_srst_req, rsa_clken |
        | 0x0E4 | PERI_CRG57 | Clock soft reset control register for other APB modules | i2c0_srst_req, i2c1_srst_req, i2c2_srst_req, t_cap_srst_req, ssp0_srst_req, ssp1_srst_req, ssp2_srst_req, ir_srst_req, uart0_srst_req, uart1_srst_req, ... |
        | 0x0E8 | PERI_CRG58 | CRG status register | gzip_rst_ok |

        Only fields whose names contain a clock-enable or reset keyword are listed; the field descriptions in the register pages give the polarity and the clocks they gate.

        ### Register blocks (generated from this description)

        | Base | Instance | Block | Register space |
        |---|---|---|---|
        | 0x10000000 | FMC | HiSilicon flash memory controller v100 (SPI NOR / SPI NAND) | 324 B |
        | 0x10030000 | DMAC | HiSilicon DMA controller (PL080-compatible, 4 or 8 channels) | 384 B |
        | 0x10050000 | ETH | HiSilicon GSF gigabit Ethernet MAC with descriptor queues and MDIO | 2596 B |
        | 0x10080000 | CIPHER | CIPHER (8 channels) | 5184 B |
        | 0x10090000 | HASH | HASH (SHA1 / SHA256 / HMAC) | 176 B |
        | 0x100C0000 | MMC0 | HiSilicon MMC/SD/SDIO controller (DesignWare-MMC based, himciv200) | 516 B |
        | 0x100D0000 | MMC1 | HiSilicon MMC/SD/SDIO controller (DesignWare-MMC based, himciv200) | 516 B |
        | 0x100E0000 | MMC2 | HiSilicon MMC/SD/SDIO controller (DesignWare-MMC based, himciv200) | 516 B |
        | 0x10110000 | OHCI | HiSilicon USB 2.0 host controller - OHCI | 92 B |
        | 0x10120000 | EHCI | HiSilicon USB 2.0 host controller - EHCI | 176 B |
        | 0x10130000 | USB_DEV | HiSilicon USB 2.0 device controller (DesignWare DWC_otg, device mode) | 3328 B |
        | 0x10300000 | GIC | Generic interrupt controller (ARM GIC-400, GICv2) | 12292 B |
        | 0x11000000 | VDP | HiSilicon video display processor (Hi3516A V200, Hi3519 V101) | 62292 B |
        | 0x11040000 | IVE | HiSilicon intelligent video engine | 140 B |
        | 0x11080000 | AIAO | AIAO (audio input/output) | 8368 B |
        | 0x11100000 | TDE | HiSilicon TDE (registers not described) | 64 KB |
        | 0x11120000 | VGS | HiSilicon VGS (registers not described) | 64 KB |
        | 0x11180000 | VPSS | HiSilicon VPSS (registers not described) | 64 KB |
        | 0x11200000 | JPGE | HiSilicon JPEG encoder (JPGE, r004 register layout) | 4288 B |
        | 0x11280000 | VEDU | HiSilicon VEDU, H.265/H.264 generation V2 (control registers, vendor-derived) | 68 B |
        | 0x11300000 | MIPI | MIPI RX (sensor serial interface receiver, Hi3516A V200 / Hi3519 V101) | 10236 B |
        | 0x11380000 | VICAP | VICAP (video capture, Hi3516A V200 / Hi3519 V101) | 10996 B |
        | 0x11390000 | ISP | ISP (image signal processor, Hi3516A V200 / Hi3519 V101) | 342772 B |
        | 0x12000000 | TIMER0 | Timer Registers | 28 B |
        | 0x12000020 | TIMER1 | Timer Registers | 28 B |
        | 0x12001000 | TIMER2 | Timer Registers | 28 B |
        | 0x12001020 | TIMER3 | Timer Registers | 28 B |
        | 0x12002000 | TIMER4 | Timer Registers | 28 B |
        | 0x12002020 | TIMER5 | Timer Registers | 28 B |
        | 0x12010000 | PERI_CRG | Clock and reset generator (CRG), Hi3516A V200 | 320 B |
        | 0x12020000 | SYS_CTRL | System Controller Registers | 3812 B |
        | 0x12030000 | MISC_CTRL | Miscellaneous control (MISC_CTRL), Hi3516A V200 | 20504 B |
        | 0x12040000 | MUX |  I/O MUX configuration register | 484 B |
        | 0x12040800 | PAD | I/O CTRL configuration register | 2232 B |
        | 0x12050000 | DDRT | HiSilicon DDR test module | 132 B |
        | 0x12060000 | MDDRC | HiSilicon MDDRC (DDR3/DDR4/LPDDR3 controller, Hi3516A V200 / Hi3519 V101) | 33976 B |
        | 0x12070800 | OTP_KEY_CTRL | OTP key control (key ladder) | 48 B |
        | 0x12080000 | WDG | Watchdog Registers | 3076 B |
        | 0x12090000 | RTC | HiSilicon SPI-bridged RTC (APB registers) | 164 B |
        | 0x120A0000 | PERI_PMC | Power management control (PMC) | 356 B |
        | 0x120B0000 | RSA | RSA (SEC_RSA modular exponentiation engine) | 120 B |
        | 0x120C0000 | TRNG | HISEC_TRNG_CTRL (true random number generator) | 540 B |
        | 0x120E0000 | LSADC | HiSilicon LSADC controller, 10-bit generation (2-3 channels) | 60 B |
        | 0x120F0000 | IR | HiSilicon IR receiver | 56 B |
        | 0x12100000 | UART0 | UART (ARM PrimeCell PL011) | 4 KB |
        | 0x12101000 | UART1 | UART (ARM PrimeCell PL011) | 4 KB |
        | 0x12102000 | UART2 | UART (ARM PrimeCell PL011) | 4 KB |
        | 0x12103000 | UART3 | UART (ARM PrimeCell PL011) | 4 KB |
        | 0x12104000 | UART4 | UART (ARM PrimeCell PL011) | 4 KB |
        | 0x12110000 | I2C0 | HiSilicon I2C Master Controller (DesignWare-style register map) | 2080 B |
        | 0x12111000 | I2C1 | HiSilicon I2C Master Controller (DesignWare-style register map) | 2080 B |
        | 0x12112000 | I2C2 | HiSilicon I2C Master Controller (DesignWare-style register map) | 2080 B |
        | 0x12113000 | I2C3 | HiSilicon I2C Master Controller (DesignWare-style register map) | 2080 B |
        | 0x12120000 | SPI0 | SPI Registers | 48 B |
        | 0x12121000 | SPI1 | SPI Registers | 48 B |
        | 0x12122000 | SPI2 | SPI Registers | 48 B |
        | 0x12123000 | SPI3 | SPI Registers | 48 B |
        | 0x12124000 | SPI_3WIRE0 | 3-wire SPI master (sensor control, spi_3wire) | 12 B |
        | 0x12125000 | SPI_3WIRE1 | 3-wire SPI master (sensor control, spi_3wire) | 12 B |
        | 0x12130000 | PWM | HiSilicon PWM group | 256 B |
        | 0x12140000 | GPIO0 | ARM PL061 | 1053 B |
        | 0x12141000 | GPIO1 | ARM PL061 | 1053 B |
        | 0x12142000 | GPIO2 | ARM PL061 | 1053 B |
        | 0x12143000 | GPIO3 | ARM PL061 | 1053 B |
        | 0x12144000 | GPIO4 | ARM PL061 | 1053 B |
        | 0x12145000 | GPIO5 | ARM PL061 | 1053 B |
        | 0x12146000 | GPIO6 | ARM PL061 | 1053 B |
        | 0x12147000 | GPIO7 | ARM PL061 | 1053 B |
        | 0x12148000 | GPIO8 | ARM PL061 | 1053 B |
        | 0x12149000 | GPIO9 | ARM PL061 | 1053 B |
        | 0x1214A000 | GPIO10 | ARM PL061 | 1053 B |
        | 0x1214B000 | GPIO11 | ARM PL061 | 1053 B |
        | 0x1214C000 | GPIO12 | ARM PL061 | 1053 B |
        | 0x1214D000 | GPIO13 | ARM PL061 | 1053 B |
        | 0x1214E000 | GPIO14 | ARM PL061 | 1053 B |
        | 0x12150000 | GPIO16 | ARM PL061 | 1053 B |

        The table is generated from the elaborated root (instances at their absolute addresses; register space is the span of the block's registers, not the data sheet window).

        <!-- overview:end -->
    ";

    eHISI_FMC           FMC             @ 0x10000000;
    eHISI_DMAC          DMAC            @ 0x10030000;
    eHISI_GMAC          ETH             @ 0x10050000;
    eHISI_CIPHER_MC     CIPHER          @ 0x10080000;
    eHISI_HASH          HASH            @ 0x10090000;
    eHISI_DWMMC         MMC0            @ 0x100C0000;
    eHISI_DWMMC         MMC1            @ 0x100D0000;
    eHISI_DWMMC         MMC2            @ 0x100E0000;
    eHISI_USB_OHCI      OHCI            @ 0x10110000;
    eHISI_USB_EHCI      EHCI            @ 0x10120000;
    eHISI_USB_DEVICE    USB_DEV         @ 0x10130000;
    eARM_GIC400         GIC             @ 0x10300000;
    eHISI_VDP_AV200     VDP             @ 0x11000000;
    eHISI_IVE           IVE             @ 0x11040000;
    eHISI_AIAO          AIAO            @ 0x11080000;
    aHISI_TDE           TDE             @ 0x11100000;
    aHISI_VPSS          VPSS            @ 0x11180000;
    eHISI_JPGE          JPGE            @ 0x11200000;
    aHISI_VEDU_V2       VEDU            @ 0x11280000;
    aHISI_VGS           VGS             @ 0x11120000;
    eHISI_MIPI_RX_AV200 MIPI            @ 0x11300000;
    eHISI_VICAP_AV200   VICAP           @ 0x11380000;
    eHISI_ISP_AV200     ISP             @ 0x11390000;
    eHISI_TIMER_SP804   TIMER0          @ 0x12000000;
    eHISI_TIMER_SP804   TIMER1          @ 0x12000020;
    eHISI_TIMER_SP804   TIMER2          @ 0x12001000;
    eHISI_TIMER_SP804   TIMER3          @ 0x12001020;
    eHISI_TIMER_SP804   TIMER4          @ 0x12002000;
    eHISI_TIMER_SP804   TIMER5          @ 0x12002020;
    ePERI_CRG           PERI_CRG        @ 0x12010000;
    eSYS_CTRL           SYS_CTRL        @ 0x12020000;
    eMISC_CTRL          MISC_CTRL       @ 0x12030000;
    eMUX                MUX             @ 0x12040000;
    ePAD                PAD             @ 0x12040800;
    eHISI_DDRT          DDRT            @ 0x12050000;
    eHISI_MDDRC         MDDRC           @ 0x12060000;
    eHISI_OTP_KEY_CTRL  OTP_KEY_CTRL    @ 0x12070800;
    eHISI_WDG_SP805     WDG             @ 0x12080000;
    eHISI_RTC_SPI       RTC             @ 0x12090000;
    eHISI_RSA           RSA             @ 0x120B0000;
    eHISI_TRNG          TRNG            @ 0x120C0000;
    eHISI_LSADC_V2      LSADC           @ 0x120E0000;
    eHISI_IR            IR              @ 0x120F0000;
    eARM_PL011          UART0           @ 0x12100000;
    eARM_PL011          UART1           @ 0x12101000;
    eARM_PL011          UART2           @ 0x12102000;
    eARM_PL011          UART3           @ 0x12103000;
    eARM_PL011          UART4           @ 0x12104000;
    eHISI_I2C_DW        I2C0            @ 0x12110000;
    eHISI_I2C_DW        I2C1            @ 0x12111000;
    eHISI_I2C_DW        I2C2            @ 0x12112000;
    eHISI_I2C_DW        I2C3            @ 0x12113000;
    eHISI_SPI           SPI0            @ 0x12120000;
    eHISI_SPI           SPI1            @ 0x12121000;
    eHISI_SPI           SPI2            @ 0x12122000;
    eHISI_SPI           SPI3            @ 0x12123000;
    ePERI_PMC           PERI_PMC        @ 0x120A0000;
    eHISI_SPI_3WIRE     SPI_3WIRE0      @ 0x12124000;
    eHISI_SPI_3WIRE     SPI_3WIRE1      @ 0x12125000;
    eHISI_PWM_GRP       PWM             @ 0x12130000;
    eARM_PL061          GPIO0           @ 0x12140000;
    eARM_PL061          GPIO1           @ 0x12141000;
    eARM_PL061          GPIO2           @ 0x12142000;
    eARM_PL061          GPIO3           @ 0x12143000;
    eARM_PL061          GPIO4           @ 0x12144000;
    eARM_PL061          GPIO5           @ 0x12145000;
    eARM_PL061          GPIO6           @ 0x12146000;
    eARM_PL061          GPIO7           @ 0x12147000;
    eARM_PL061          GPIO8           @ 0x12148000;
    eARM_PL061          GPIO9           @ 0x12149000;
    eARM_PL061          GPIO10          @ 0x1214A000;
    eARM_PL061          GPIO11          @ 0x1214B000;
    eARM_PL061          GPIO12          @ 0x1214C000;
    eARM_PL061          GPIO13          @ 0x1214D000;
    eARM_PL061          GPIO14          @ 0x1214E000;
    eARM_PL061          GPIO16          @ 0x12150000;
};

