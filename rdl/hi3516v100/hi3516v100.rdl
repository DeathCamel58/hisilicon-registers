`include "defines.rdl"

`include "CRG.rdl"
`include "IO_CONFIG.rdl"
`include "../common/ARM_A9_MPCORE.rdl"
`include "../common/ARM_PL011.rdl"
`include "../common/ARM_PL061.rdl"
`include "../common/HISI_CIPHER_MC.rdl"
`include "../common/HISI_DDRC.rdl"
`include "../common/HISI_DMAC.rdl"
`include "../common/HISI_DWMMC.rdl"
`include "../common/HISI_GMAC.rdl"
`include "../common/HISI_I2C.rdl"
`include "../common/HISI_IR.rdl"
`include "../common/HISI_IVE.rdl"
`include "../common/HISI_JPGE.rdl"
`include "../common/HISI_L2CACHE_V200.rdl"
`include "../common/HISI_MOTION_DETECT.rdl"
`include "../common/HISI_NANDC.rdl"
`include "../common/HISI_PWM_V1.rdl"
`include "../common/HISI_RTC.rdl"
`include "../common/HISI_SFC_300.rdl"
`include "../common/HISI_SPI.rdl"
`include "../common/HISI_SYS_CTRL.rdl"
`include "../common/HISI_TDE.rdl"
`include "../common/HISI_TIMER_SP804.rdl"
`include "../common/HISI_USB_HOST.rdl"
`include "../common/HISI_VDP_3516V100.rdl"
`include "../common/HISI_VEDU.rdl"
`include "../common/HISI_VICAP_3516V100.rdl"
`include "../common/HISI_WDG_SP805.rdl"

addrmap hi3516v100 {
    name = "hi3516v100 registers";
    desc = "
        ## Datasheets

        * [Full Datasheet](assets/Hi3516-Datasheet.pdf)

        ## Diagrams

        ![Application Block Diagram](assets/Application-Block-Diagram.png)
        ![Logic Block Diagram](assets/Logic-Block-Diagram.png)

        ## Addresses

        | Start Address | End Address | Description                                                                                 | Documented Here |
        |---------------|-------------|---------------------------------------------------------------------------------------------|-----------------|
        | 0x80000000    | 0xFFFFFFFF  | DDR address space 2 GB                                                                               | &#10060;        |
        | 0x5C000000    | 0x7FFFFFFF  | Reserved - -                                                                                      | &#10060;        |
        | 0x58000000    | 0x5BFFFFFF  | SPI FLASH memory space 64 MB                                                                        | &#10060;        |
        | 0x54000000    | 0x57FFFFFF  | Reserved - -                                                                                      | &#10060;        |
        | 0x50000000    | 0x53FFFFFF  | NANDC memory space 64 MB                                                                            | &#10060;        |
        | 0x40000000    | 0x4FFFFFFF  | PCIE configuration space 256 MB                                                                            | &#10060;        |
        | 0x30000000    | 0x3FFFFFFF  | PCIE MEMORY address space 256 MB                                                                    | &#10060;        |
        | 0x20810000    | 0x2FFFFFFF  | Reserved - -                                                                                      | &#10060;        |
        | 0x20800000    | 0x2080FFFF  | PCIE registers 64 KB                                                                              | &#10060;        |
        | 0x20700000    | 0x207FFFFF  | L2 CACHE space 1 MB                                                                            | &#9989;         |
        | 0x20690000    | 0x206FFFFF  | Reserved - -                                                                                      | &#10060;        |
        | 0x20650000    | 0x2068FFFF  | VICAP registers 256 KB                                                                            | &#9989;         |
        | 0x20640000    | 0x2064FFFF  | VDP registers 64 KB                                                                               | &#9989;         |
        | 0x20630000    | 0x2063FFFF  | TDE registers 64 KB                                                                               | &#9989;         |
        | 0x20620000    | 0x2062FFFF  | MD registers 64 KB                                                                                | &#9989;         |
        | 0x20610000    | 0x2061FFFF  | JPEG registers 64 KB                                                                              | &#9989;        |
        | 0x20600000    | 0x2060FFFF  | VEDU registers-see the video encoding chapter                                                                          | &#9989;         |
        | 0x20520000    | 0x205FFFFF  | Reserved - -                                                                                      | &#10060;        |
        | 0x20400000    | 0x2051FFFF  | ARM DEBUG 1152 KB (CoreSight debug APB window of the Cortex-A9, not described; data sheet remark: see the system chapter, which has none)                                                                           | &#10060;        |
        | 0x20310000    | 0x203FFFFF  | Reserved - -                                                                                      | &#10060;        |
        | 0x20300000    | 0x2030FFFF  | ARM wdg/timer/gic and other internal registers 64 KB                                                             | &#9989;         |
        | 0x20240000    | 0x202FFFFF  | Reserved - -                                                                                      | &#10060;        |
        | 0x20220000    | 0x2022FFFF  | GPIO 1064 KB                                                                                | &#9989;         |
        | 0x20210000    | 0x2021FFFF  | GPIO 964 KB                                                                                 | &#9989;         |
        | 0x20200000    | 0x2020FFFF  | GPIO 864 KB                                                                                 | &#9989;         |
        | 0x201F0000    | 0x201FFFFF  | Reserved - -                                                                                      | &#10060;        |
        | 0x201E0000    | 0x201EFFFF  | PWM 164 KB                                                                                  | &#9989;         |
        | 0x201D0000    | 0x201DFFFF  | PWM 064 KB                                                                                  | &#9989;         |
        | 0x201C0000    | 0x201CFFFF  | GPIO 764 KB                                                                                 | &#9989;         |
        | 0x201B0000    | 0x201BFFFF  | GPIO 664 KB                                                                                 | &#9989;         |
        | 0x201A0000    | 0x201AFFFF  | GPIO 564 KB                                                                                 | &#9989;         |
        | 0x20190000    | 0x2019FFFF  | GPIO 464 KB                                                                                 | &#9989;         |
        | 0x20180000    | 0x2018FFFF  | GPIO 364 KB                                                                                 | &#9989;         |
        | 0x20170000    | 0x2017FFFF  | GPIO 264 KB                                                                                 | &#9989;         |
        | 0x20160000    | 0x2016FFFF  | GPIO 164 KB                                                                                 | &#9989;         |
        | 0x20150000    | 0x2015FFFF  | Reserved 64 KB                                                                                    | &#10060;        |
        | 0x20140000    | 0x2014FFFF  | Reserved 64 KB                                                                                    | &#10060;        |
        | 0x20130000    | 0x2013FFFF  | IVE 64 KB                                                                                   | &#9989;         |
        | 0x20120000    | 0x2012FFFF  | Reserved 64 KB                                                                                    | &#10060;        |
        | 0x20110000    | 0x2011FFFF  | DDRC 64 KB                                                                                  | &#9989;         |
        | 0x20100000    | 0x2010FFFF  | Reserved 64 KB                                                                                    | &#10060;        |
        | 0x200F0000    | 0x200FFFFF  | IO config registers 64 KB                                                                         | &#9989;         |
        | 0x200E0000    | 0x200EFFFF  | SPI1 registers 64 KB                                                                              | &#10060;        |
        | 0x200D0000    | 0x200DFFFF  | I2C registers 64 KB                                                                               | &#9989;         |
        | 0x200C0000    | 0x200CFFFF  | SPI0 registers 64 KB                                                                              | &#10060;        |
        | 0x200B0000    | 0x200BFFFF  | UART3 registers 64 KB                                                                             | &#9989;         |
        | 0x200A0000    | 0x200AFFFF  | UART2 registers 64 KB                                                                             | &#9989;         |
        | 0x20090000    | 0x2009FFFF  | UART1 registers 64 KB                                                                             | &#9989;         |
        | 0x20080000    | 0x2008FFFF  | UART0 registers 64 KB                                                                             | &#9989;         |
        | 0x20070000    | 0x2007FFFF  | IR 64 KB                                                                                    | &#9989;         |
        | 0x20060000    | 0x2006FFFF  | RTC 64 KB                                                                                   | &#9989;         |
        | 0x20050000    | 0x2005FFFF  | SYS_CTRL 64 KB                                                                              | &#9989;         |
        | 0x20040000    | 0x2004FFFF  | WDG 64 KB                                                                                   | &#10060;        |
        | 0x20030000    | 0x2003FFFF  | CRG 64 KB                                                                                   | &#9989;         |
        | 0x20020000    | 0x2002FFFF  | Reserved 64 KB                                                                                    | &#10060;        |
        | 0x20000000    | 0x2000FFFF  | Timer0/ 164 KB                                                                              | &#9989;         |
        | 0x10110000    | 0x1FFFFFFF  | Reserved - -                                                                                      | &#10060;        |
        | 0x10100000    | 0x1010FFFF  | Reserved 64 KB                                                                                    | &#10060;        |
        | 0x100E0000    | 0x100EFFFF  | Reserved 64 KB                                                                                    | &#10060;        |
        | 0x100D0000    | 0x100DFFFF  | DMAC registers 64 KB                                                                              | &#9989;         |
        | 0x100C0000    | 0x100CFFFF  | CIPHER registers 64 KB                                                                            | &#9989;         |
        | 0x100B0000    | 0x100BFFFF  | USB20HOST EHCI registers 64 KB                                                                   | &#9989;         |
        | 0x100A0000    | 0x100AFFFF  | USB20HOST OHCI registers 64 KB                                                                   | &#9989;         |
        | 0x10090000    | 0x1009FFFF  | GMAC registers 64 KB                                                                              | &#9989;         |
        | 0x10080000    | 0x1008FFFF  | Reserved 64 KB                                                                                    | &#10060;        |
        | 0x10070000    | 0x1007FFFF  | Efuse registers 64 KB                                                                             | &#10060;        |
        | 0x10060000    | 0x1006FFFF  | SIO2 registers 64 KB                                                                              | &#10060;        |
        | 0x10050000    | 0x1005FFFF  | SIO 1 registers 64 KB                                                                             | &#10060;        |
        | 0x10040000    | 0x1004FFFF  | SIO 0 registers 64 KB                                                                             | &#10060;        |
        | 0x10030000    | 0x1003FFFF  | SDIO1 registers 64 KB                                                                             | &#9989;         |
        | 0x10020000    | 0x1002FFFF  | SDIO0 registers 64 KB                                                                             | &#9989;         |
        | 0x10010000    | 0x1001FFFF  | SPI FLASH registers 64 KB NOTE: This is not the HISFC V350. This is probably the earlier version. | &#9989;         |
        | 0x10000000    | 0x1000FFFF  | NANDC registers 64 KB                                                                             | &#9989;         |
        | 0x04000000    | 0x0FFFFFFF  | Reserved - -                                                                                      | &#10060;        |
        | 0x00000000    | 0x03FFFFFF  | Memory selected by address remapping. 64 MB                                                                         | &#10060;        |

        <!-- overview:begin -->

        ### Diagrams

        ![Register blocks by function](assets/diagrams/hi3516v100-blocks.svg)

        ### Interrupts (Cortex-A9 GIC interrupt IDs, data sheet Table 3-19); the data sheet is Chinese, names translated

        | # | Source | # | Source | # | Source |
        |---|---|---|---|---|---|
        | 0-31 | A9 internal use | 49 | UART3 | 67 | DMAC |
        | 32 | COMMTX (CPU debug) | 50 | VICAP | 68 | USB0_EHCI |
        | 33 | COMMRX (CPU debug) | 51 | VEDU | 69 | USB0_OHCI |
        | 34 | WatchDog | 52 | VOU | 70 | SDIO0 |
        | 35 | Timer0/1 | 53 | TDE | 71 | SDIO1 |
        | 36 | Timer2/3 | 54 | JPEG | 72 | L2CACHE_CHK0_INT |
        | 37 | GPIO0 | 55 | MD | 73 | L2CACHE_CHK1_INT |
        | 38 | GPIO1 | 56 | VAPU | 74 | L2CACHE_INT_COMB |
        | 39 | GPIO2 | 57 | SIO0 | 75 | A9_PMU_INT0 |
        | 40 | GPIO3 | 58 | SIO1 | 76 | Pcie_radm_inta |
        | 41 | GPIO4 | 59 | SIO2 | 77 | Pcie_radm_intb |
        | 42 | GPIO5 | 60 | GMAC | 78 | Pcie_radm_intc |
        | 43 | GPIO6 | 61 | Cipher | 79 | Pcie_radm_intd |
        | 44 | GPIO7 | 62 | IR | 80 | Pcie_cfg_pme_int |
        | 45 | I2C | 63 | NandC | 81 | Pcie_hp_pme_int |
        | 46 | UART0 | 64 | SFC (SPI flash controller) | 82 | Pcie_hp_int |
        | 47 | UART1 | 65 | SSP0 | 83 | Pcie_cfg_aer_rc_err_int |
        | 48 | UART2 | 66 | SSP1 |  |  |

        ### Clock-gate and reset map (generated from the CRG registers)

        | Offset | Register | Description | Gate / reset fields |
        |---|---|---|---|
        | 0x020 | PERI_CRG8 | A9 frequency mode and reset configuration register | cpu_srst_req, cluster_dbg_srst_req, wd_srst_req, cluster_peri_srst_req, cluster_scu_srst_req, cs_srst_req |
        | 0x034 | PERI_CRG13 | SIO0 clock and soft reset control register | sio0_srst_req, sio0_cken |
        | 0x038 | PERI_CRG14 | SIO1 clock and soft reset control register | sio1_srst_req, sio1_cken |
        | 0x03C | PERI_CRG15 | SIO2 clock and soft reset control register | sio2_srst_req, sio2_cken, audio_codec_rst_req |
        | 0x040 | PERI_CRG16 | VIU | viu_hrst_req, vi0_rst_req, vi1_rst_req, vi_dll_rst, vi_hclk_en, vi_ch0_clken, vi_ch1_clken, vi_ch2_clken, vi_ch3_clken, vi_ch4_clken, ... |
        | 0x044 | PERI_CRG17 | VOU clock and reset control register | vou_srst_req, vou_sd_cken, vou_hd_cken |
        | 0x048 | PERI_CRG18 | VEDU clock and soft reset control register | vedu_srst_req, vedu_cken |
        | 0x04C | PERI_CRG19 | JPGE clock and soft reset control register | jpge_srst_req, jpge_cken |
        | 0x050 | PERI_CRG20 | MD clock and soft reset control register | md_srst_req, md_cken |
        | 0x054 | PERI_CRG21 | GMAC clock and soft reset control register | gmac_rst_req, gmac_cken |
        | 0x058 | PERI_CRG22 | IVE clock and soft reset control register | ive_srst_req, ive_cken |
        | 0x05C | PERI_CRG23 | TDE clock and soft reset control register | tde_srst_req, tde_cken |
        | 0x060 | PERI_CRG24 | NFC clock and soft reset control register | nfc_srst_req, nfc_cken |
        | 0x064 | PERI_CRG25 | SFC clock and soft reset control register | sfc_srst_req, sfc_cken |
        | 0x068 | PERI_CRG26 | PWM0/PWM1/EFUSE clock and soft reset control register | pwm0_srst_req, pwm0_cken, pwm1_srst_req, pwm1_cken, efuse_srst_req, efuse_cken |
        | 0x06C | PERI_CRG27 | DMA clock and soft reset control register | dma_srst_req, dma_cken |
        | 0x070 | PERI_CRG28 | SSP0 clock and soft reset control register | ssp0_srst_req, ssp0_cken |
        | 0x074 | PERI_CRG29 | SSP1 clock and soft reset control register | ssp1_srst_req, ssp1_cken |
        | 0x078 | PERI_CRG30 | USB clock and soft reset control register | usb_ahb_srst_req, usb_cken |
        | 0x07C | PERI_CRG31 | PCIE clock and soft reset control register | pcie_srst_req, pcie_cken |
        | 0x080 | PERI_CRG32 | SDIO0/SDIO1 clock and soft reset control register | sdio0_srst_req, sdio0_cken, sdio1_srst_req, sdio1_cken |
        | 0x084 | PERI_CRG33 | UART0 clock and soft reset control register | uart0_srst_req, uart0_cken |
        | 0x088 | PERI_CRG34 | UART1 clock and soft reset control register | uart1_srst_req, uart1_cken |
        | 0x08C | PERI_CRG35 | UART2 clock and soft reset control register | uart2_srst_req, uart2_cken |
        | 0x090 | PERI_CRG36 | UART3 clock and soft reset control register | uart3_srst_req, uart3_cken |
        | 0x094 | PERI_CRG37 | I2C clock and soft reset control register | i2c_srst_req, i2c_cken |
        | 0x098 | PERI_CRG38 | IR/RTC/CIPHER clock and soft reset control register | ir_srst_req, ir_cken, rtc_srst_req, rtc_cken, cipher_srst_req, cipher_cken |
        | 0x0A8 | PERI_CRG42 | CRG test register | test_clk_en |

        Only fields whose names contain a clock-enable or reset keyword are listed; the field descriptions in the register pages give the polarity and the clocks they gate.

        ### Register blocks (generated from this description)

        | Base | Instance | Block | Register space |
        |---|---|---|---|
        | 0x10000000 | NANDC | HiSilicon parallel NAND flash controller (hinfc300/301/504 family) | 156 B |
        | 0x10010000 | SFC | SPI Flash Controller Registers (hisfc300 generation) | 96 B |
        | 0x10020000 | SDIO0 | HiSilicon MMC/SD/SDIO controller (DesignWare-MMC based, himciv200) | 260 B |
        | 0x10030000 | SDIO1 | HiSilicon MMC/SD/SDIO controller (DesignWare-MMC based, himciv200) | 260 B |
        | 0x10090000 | ETH | HiSilicon GSF gigabit Ethernet MAC with descriptor queues and MDIO | 1520 B |
        | 0x100A0000 | OHCI | HiSilicon USB 2.0 host controller - OHCI | 92 B |
        | 0x100B0000 | EHCI | HiSilicon USB 2.0 host controller - EHCI | 176 B |
        | 0x100C0000 | CIPHER | CIPHER (8 channels) | 5184 B |
        | 0x100D0000 | DMAC | HiSilicon DMA controller (PL080-compatible, 4 or 8 channels) | 512 B |
        | 0x20000000 | TIMER0 | Timer Registers | 28 B |
        | 0x20000020 | TIMER1 | Timer Registers | 28 B |
        | 0x20010000 | TIMER2 | Timer Registers | 28 B |
        | 0x20010020 | TIMER3 | Timer Registers | 28 B |
        | 0x20030000 | CRG | Clock and reset generator (CRG), Hi3516 V100 | 176 B |
        | 0x20040000 | WDG | Watchdog Registers | 3076 B |
        | 0x20050000 | SYS_CTRL | System Controller Registers | 3824 B |
        | 0x20060000 | RTC | RTC (ARM PL031-style 32-bit counter) | 32 B |
        | 0x20070000 | IR | HiSilicon IR receiver | 56 B |
        | 0x20080000 | UART0 | UART (ARM PrimeCell PL011) | 4 KB |
        | 0x20090000 | UART1 | UART (ARM PrimeCell PL011) | 4 KB |
        | 0x200A0000 | UART2 | UART (ARM PrimeCell PL011) | 4 KB |
        | 0x200B0000 | UART3 | UART (ARM PrimeCell PL011) | 4 KB |
        | 0x200C0000 | SPI0 | SPI Registers | 48 B |
        | 0x200D0000 | I2C | HiSilicon I2C Master Controller | 32 B |
        | 0x200E0000 | SPI1 | SPI Registers | 48 B |
        | 0x200F0000 | IO_CONFIG | IO configuration (pin multiplexing control), Hi3516 V100 | 336 B |
        | 0x20110000 | DDRC | DDRC Registers | 908 B |
        | 0x20130000 | IVE | HiSilicon intelligent video engine | 28 B |
        | 0x20160000 | GPIO1 | ARM PL061 | 1053 B |
        | 0x20170000 | GPIO2 | ARM PL061 | 1053 B |
        | 0x20180000 | GPIO3 | ARM PL061 | 1053 B |
        | 0x20190000 | GPIO4 | ARM PL061 | 1053 B |
        | 0x201A0000 | GPIO5 | ARM PL061 | 1053 B |
        | 0x201B0000 | GPIO6 | ARM PL061 | 1053 B |
        | 0x201C0000 | GPIO7 | ARM PL061 | 1053 B |
        | 0x201D0000 | PWM0 | HiSilicon PWM module (V1) | 48 B |
        | 0x201E0000 | PWM1 | HiSilicon PWM module (V1) | 48 B |
        | 0x20200000 | GPIO8 | ARM PL061 | 1053 B |
        | 0x20210000 | GPIO9 | ARM PL061 | 1053 B |
        | 0x20220000 | GPIO10 | ARM PL061 | 1053 B |
        | 0x20300000 | A9_PERI | Cortex-A9 MPCore private memory region | 8 KB |
        | 0x20600000 | VEDU | HiSilicon VEDU (registers not described) | 64 KB |
        | 0x20610000 | JPEG | HiSilicon JPGE (window only, registers not described) | 64 KB |
        | 0x20620000 | MOTION_DETECT | Motion Detect Unit Registers | 188 B |
        | 0x20630000 | TDE | HiSilicon TDE (registers not described) | 64 KB |
        | 0x20640000 | VDP | VDP (video display processor, Hi3516 V100) | 5780 B |
        | 0x20650000 | VICAP | VICAP (video capture, Hi3516 V100) | 36892 B |
        | 0x20700000 | L2CACHE | HiSilicon L2 cache controller v200 | 2060 B |

        The table is generated from the elaborated root (instances at their absolute addresses; register space is the span of the block's registers, not the data sheet window).

        <!-- overview:end -->
    ";

    eHISI_NANDC         NANDC           @ 0x10000000;
    eHISI_SFC_300       SFC             @ 0x10010000;
    eHISI_DWMMC         SDIO0           @ 0x10020000;
    eHISI_DWMMC         SDIO1           @ 0x10030000;
    eHISI_GMAC          ETH             @ 0x10090000;
    eHISI_USB_OHCI      OHCI            @ 0x100A0000;
    eHISI_USB_EHCI      EHCI            @ 0x100B0000;
    eHISI_CIPHER_MC     CIPHER          @ 0x100C0000;
    eHISI_DMAC          DMAC            @ 0x100D0000;
    eHISI_TIMER_SP804   TIMER0          @ 0x20000000;
    eHISI_TIMER_SP804   TIMER1          @ 0x20000020;
    // TODO: Verify TIMER2/TIMER3
    eHISI_TIMER_SP804   TIMER2          @ 0x20010000;
    eHISI_TIMER_SP804   TIMER3          @ 0x20010020;
    eCRG                CRG             @ 0x20030000;
    eHISI_WDG_SP805     WDG             @ 0x20040000;
    eSYS_CTRL           SYS_CTRL        @ 0x20050000;
    eHISI_RTC           RTC             @ 0x20060000;
    eHISI_IR            IR              @ 0x20070000;
    eARM_PL011          UART0           @ 0x20080000;
    eARM_PL011          UART1           @ 0x20090000;
    eARM_PL011          UART2           @ 0x200A0000;
    eARM_PL011          UART3           @ 0x200B0000;
    eHISI_SPI           SPI0            @ 0x200C0000;
    eHISI_I2C           I2C             @ 0x200D0000;
    eHISI_SPI           SPI1            @ 0x200E0000;
    eIO_CONFIG          IO_CONFIG       @ 0x200F0000;
    eDDRC               DDRC            @ 0x20110000;
    eHISI_IVE           IVE             @ 0x20130000;
    eARM_PL061          GPIO1           @ 0x20160000;
    eARM_PL061          GPIO2           @ 0x20170000;
    eARM_PL061          GPIO3           @ 0x20180000;
    eARM_PL061          GPIO4           @ 0x20190000;
    eARM_PL061          GPIO5           @ 0x201A0000;
    eARM_PL061          GPIO6           @ 0x201B0000;
    eARM_PL061          GPIO7           @ 0x201C0000;
    eHISI_PWM_V1_GRP    PWM0            @ 0x201D0000;
    eHISI_PWM_V1_GRP    PWM1            @ 0x201E0000;
    eARM_PL061          GPIO8           @ 0x20200000;
    eARM_PL061          GPIO9           @ 0x20210000;
    eARM_PL061          GPIO10          @ 0x20220000;
    eARM_A9_MPCORE      A9_PERI         @ 0x20300000;
    aHISI_VEDU          VEDU            @ 0x20600000;
    aHISI_JPGE          JPEG            @ 0x20610000;
    eMOTION_DETECT      MOTION_DETECT   @ 0x20620000;
    aHISI_TDE           TDE             @ 0x20630000;
    eHISI_VDP_3516V100  VDP             @ 0x20640000;
    eHISI_VICAP_3516V100 VICAP           @ 0x20650000;
    eHISI_L2CACHE_V200  L2CACHE         @ 0x20700000;
};

