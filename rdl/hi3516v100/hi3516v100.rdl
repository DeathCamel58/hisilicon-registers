`include "defines.rdl"

`include "CRG.rdl"
`include "IO_CONFIG.rdl"
`include "../common/ARM_A9_MPCORE.rdl"
`include "../common/ARM_PL011.rdl"
`include "../common/ARM_PL061.rdl"
`include "../common/HISI_CIPHER_MC.rdl"
`include "../common/HISI_DDRC.rdl"
`include "../common/HISI_DMAC.rdl"
`include "../common/HISI_DWMMC.rdl"
`include "../common/HISI_GMAC.rdl"
`include "../common/HISI_I2C.rdl"
`include "../common/HISI_IR.rdl"
`include "../common/HISI_IVE.rdl"
`include "../common/HISI_JPGE.rdl"
`include "../common/HISI_L2CACHE_V200.rdl"
`include "../common/HISI_MOTION_DETECT.rdl"
`include "../common/HISI_NANDC.rdl"
`include "../common/HISI_PWM_V1.rdl"
`include "../common/HISI_RTC.rdl"
`include "../common/HISI_SFC_300.rdl"
`include "../common/HISI_SPI.rdl"
`include "../common/HISI_SYS_CTRL.rdl"
`include "../common/HISI_TDE.rdl"
`include "../common/HISI_TIMER_SP804.rdl"
`include "../common/HISI_USB_HOST.rdl"
`include "../common/HISI_VDP_3516V100.rdl"
`include "../common/HISI_VEDU.rdl"
`include "../common/HISI_VICAP_3516V100.rdl"
`include "../common/HISI_WDG_SP805.rdl"

addrmap hi3516v100 {
    name = "hi3516v100 registers";
    desc = "
        ## Datasheets

        * [Full Datasheet](assets/Hi3516-Datasheet.pdf)

        ## Diagrams

        ![Application Block Diagram](assets/Application-Block-Diagram.png)
        ![Logic Block Diagram](assets/Logic-Block-Diagram.png)

        ## Addresses

        | Start Address | End Address | Description                                                                                 | Documented Here |
        |---------------|-------------|---------------------------------------------------------------------------------------------|-----------------|
        | 0x80000000    | 0xFFFFFFFF  | DDR address space 2 GB                                                                               | &#10060;        |
        | 0x5C000000    | 0x7FFFFFFF  | Reserved - -                                                                                      | &#10060;        |
        | 0x58000000    | 0x5BFFFFFF  | SPI FLASH memory space 64 MB                                                                        | &#10060;        |
        | 0x54000000    | 0x57FFFFFF  | Reserved - -                                                                                      | &#10060;        |
        | 0x50000000    | 0x53FFFFFF  | NANDC memory space 64 MB                                                                            | &#10060;        |
        | 0x40000000    | 0x4FFFFFFF  | PCIE configuration space 256 MB                                                                            | &#10060;        |
        | 0x30000000    | 0x3FFFFFFF  | PCIE MEMORY address space 256 MB                                                                    | &#10060;        |
        | 0x20810000    | 0x2FFFFFFF  | Reserved - -                                                                                      | &#10060;        |
        | 0x20800000    | 0x2080FFFF  | PCIE registers 64 KB                                                                              | &#10060;        |
        | 0x20700000    | 0x207FFFFF  | L2 CACHE space 1 MB                                                                            | &#9989;         |
        | 0x20690000    | 0x206FFFFF  | Reserved - -                                                                                      | &#10060;        |
        | 0x20650000    | 0x2068FFFF  | VICAP registers 256 KB                                                                            | &#9989;         |
        | 0x20640000    | 0x2064FFFF  | VDP registers 64 KB                                                                               | &#9989;         |
        | 0x20630000    | 0x2063FFFF  | TDE registers 64 KB                                                                               | &#9989;         |
        | 0x20620000    | 0x2062FFFF  | MD registers 64 KB                                                                                | &#9989;         |
        | 0x20610000    | 0x2061FFFF  | JPEG registers 64 KB                                                                              | &#9989;        |
        | 0x20600000    | 0x2060FFFF  | VEDU registers-see the video encoding chapter                                                                          | &#9989;         |
        | 0x20520000    | 0x205FFFFF  | Reserved - -                                                                                      | &#10060;        |
        | 0x20400000    | 0x2051FFFF  | ARM DEBUG 1152 KB (CoreSight debug APB window of the Cortex-A9, not described; data sheet remark: see the system chapter, which has none)                                                                           | &#10060;        |
        | 0x20310000    | 0x203FFFFF  | Reserved - -                                                                                      | &#10060;        |
        | 0x20300000    | 0x2030FFFF  | ARM wdg/timer/gic and other internal registers 64 KB                                                             | &#9989;         |
        | 0x20240000    | 0x202FFFFF  | Reserved - -                                                                                      | &#10060;        |
        | 0x20220000    | 0x2022FFFF  | GPIO 1064 KB                                                                                | &#9989;         |
        | 0x20210000    | 0x2021FFFF  | GPIO 964 KB                                                                                 | &#9989;         |
        | 0x20200000    | 0x2020FFFF  | GPIO 864 KB                                                                                 | &#9989;         |
        | 0x201F0000    | 0x201FFFFF  | Reserved - -                                                                                      | &#10060;        |
        | 0x201E0000    | 0x201EFFFF  | PWM 164 KB                                                                                  | &#9989;         |
        | 0x201D0000    | 0x201DFFFF  | PWM 064 KB                                                                                  | &#9989;         |
        | 0x201C0000    | 0x201CFFFF  | GPIO 764 KB                                                                                 | &#9989;         |
        | 0x201B0000    | 0x201BFFFF  | GPIO 664 KB                                                                                 | &#9989;         |
        | 0x201A0000    | 0x201AFFFF  | GPIO 564 KB                                                                                 | &#9989;         |
        | 0x20190000    | 0x2019FFFF  | GPIO 464 KB                                                                                 | &#9989;         |
        | 0x20180000    | 0x2018FFFF  | GPIO 364 KB                                                                                 | &#9989;         |
        | 0x20170000    | 0x2017FFFF  | GPIO 264 KB                                                                                 | &#9989;         |
        | 0x20160000    | 0x2016FFFF  | GPIO 164 KB                                                                                 | &#9989;         |
        | 0x20150000    | 0x2015FFFF  | Reserved 64 KB                                                                                    | &#10060;        |
        | 0x20140000    | 0x2014FFFF  | Reserved 64 KB                                                                                    | &#10060;        |
        | 0x20130000    | 0x2013FFFF  | IVE 64 KB                                                                                   | &#9989;         |
        | 0x20120000    | 0x2012FFFF  | Reserved 64 KB                                                                                    | &#10060;        |
        | 0x20110000    | 0x2011FFFF  | DDRC 64 KB                                                                                  | &#9989;         |
        | 0x20100000    | 0x2010FFFF  | Reserved 64 KB                                                                                    | &#10060;        |
        | 0x200F0000    | 0x200FFFFF  | IO config registers 64 KB                                                                         | &#9989;         |
        | 0x200E0000    | 0x200EFFFF  | SPI1 registers 64 KB                                                                              | &#10060;        |
        | 0x200D0000    | 0x200DFFFF  | I2C registers 64 KB                                                                               | &#9989;         |
        | 0x200C0000    | 0x200CFFFF  | SPI0 registers 64 KB                                                                              | &#10060;        |
        | 0x200B0000    | 0x200BFFFF  | UART3 registers 64 KB                                                                             | &#9989;         |
        | 0x200A0000    | 0x200AFFFF  | UART2 registers 64 KB                                                                             | &#9989;         |
        | 0x20090000    | 0x2009FFFF  | UART1 registers 64 KB                                                                             | &#9989;         |
        | 0x20080000    | 0x2008FFFF  | UART0 registers 64 KB                                                                             | &#9989;         |
        | 0x20070000    | 0x2007FFFF  | IR 64 KB                                                                                    | &#9989;         |
        | 0x20060000    | 0x2006FFFF  | RTC 64 KB                                                                                   | &#9989;         |
        | 0x20050000    | 0x2005FFFF  | SYS_CTRL 64 KB                                                                              | &#9989;         |
        | 0x20040000    | 0x2004FFFF  | WDG 64 KB                                                                                   | &#10060;        |
        | 0x20030000    | 0x2003FFFF  | CRG 64 KB                                                                                   | &#9989;         |
        | 0x20020000    | 0x2002FFFF  | Reserved 64 KB                                                                                    | &#10060;        |
        | 0x20000000    | 0x2000FFFF  | Timer0/ 164 KB                                                                              | &#9989;         |
        | 0x10110000    | 0x1FFFFFFF  | Reserved - -                                                                                      | &#10060;        |
        | 0x10100000    | 0x1010FFFF  | Reserved 64 KB                                                                                    | &#10060;        |
        | 0x100E0000    | 0x100EFFFF  | Reserved 64 KB                                                                                    | &#10060;        |
        | 0x100D0000    | 0x100DFFFF  | DMAC registers 64 KB                                                                              | &#9989;         |
        | 0x100C0000    | 0x100CFFFF  | CIPHER registers 64 KB                                                                            | &#9989;         |
        | 0x100B0000    | 0x100BFFFF  | USB20HOST EHCI registers 64 KB                                                                   | &#9989;         |
        | 0x100A0000    | 0x100AFFFF  | USB20HOST OHCI registers 64 KB                                                                   | &#9989;         |
        | 0x10090000    | 0x1009FFFF  | GMAC registers 64 KB                                                                              | &#9989;         |
        | 0x10080000    | 0x1008FFFF  | Reserved 64 KB                                                                                    | &#10060;        |
        | 0x10070000    | 0x1007FFFF  | Efuse registers 64 KB                                                                             | &#10060;        |
        | 0x10060000    | 0x1006FFFF  | SIO2 registers 64 KB                                                                              | &#10060;        |
        | 0x10050000    | 0x1005FFFF  | SIO 1 registers 64 KB                                                                             | &#10060;        |
        | 0x10040000    | 0x1004FFFF  | SIO 0 registers 64 KB                                                                             | &#10060;        |
        | 0x10030000    | 0x1003FFFF  | SDIO1 registers 64 KB                                                                             | &#9989;         |
        | 0x10020000    | 0x1002FFFF  | SDIO0 registers 64 KB                                                                             | &#9989;         |
        | 0x10010000    | 0x1001FFFF  | SPI FLASH registers 64 KB NOTE: This is not the HISFC V350. This is probably the earlier version. | &#9989;         |
        | 0x10000000    | 0x1000FFFF  | NANDC registers 64 KB                                                                             | &#9989;         |
        | 0x04000000    | 0x0FFFFFFF  | Reserved - -                                                                                      | &#10060;        |
        | 0x00000000    | 0x03FFFFFF  | Memory selected by address remapping. 64 MB                                                                         | &#10060;        |

        <!-- overview:begin -->

        ### Diagrams

        ![Logic block diagram](assets/diagrams/hi3516v100-logic.svg)

        ![Register blocks by function](assets/diagrams/hi3516v100-blocks.svg)

        ![Clock tree](assets/diagrams/hi3516v100-clocks.svg)

        ![Boot flow](assets/diagrams/hi3516v100-boot.svg)

        ![Video pipeline](assets/diagrams/hi3516v100-video.svg)

        ![Interrupt topology](assets/diagrams/hi3516v100-irq.svg)

        ![Reset tree](assets/diagrams/hi3516v100-resets.svg)

        ![Storage, USB and Ethernet paths](assets/diagrams/hi3516v100-io.svg)

        ![DMA request lines](assets/diagrams/hi3516v100-dma.svg)

        ![CRG register map](assets/diagrams/hi3516v100-crgmap.svg)

        ![IP editions across the camera family](assets/diagrams/hi3516v100-editions.svg)

        ### Camera family comparison (data sheet chapter 1)

        One column per chip, taken from the data sheets named in the header row below; `-` = the sheet gives no value. The Hi3518 sheet covers the A and C variants; the Hi3518E V200 sheet covers V200, V201 and Hi3516C V200.

        | Item | Hi3516 V100 | Hi3516C V100 | Hi3518A V100 | Hi3518C V100 | Hi3518E V100 | Hi3516C V300 | Hi3516E V100 | Hi3518E V200 | Hi3518E V201 | Hi3516C V200 |
        |---|---|---|---|---|---|---|---|---|---|---|
        | Data sheet (issue, date, language) | 00B60 2011-08-12, Chinese | 00B02 2013-02-05 | Hi3518 sheet (A and C in one document) | same document as A | 03 2015-11-26 | 05 2018-05-10 (C V300 and E V100 in one document) | same document as C V300 | 02 2017-06-12 (one document for V200, V201, Hi3516C V200) | same document | same document |
        | CPU | Cortex-A9 up to 800 MHz, VFP, 32 KB I + 32 KB D L1, 256 KB L2, about 2000 DMIPS | ARM926 up to 440 MHz, 16 KB I + 16 KB D, 2 KB ITCM | ARM926 up to 440 MHz, 16 KB I + 16 KB D, 2 KB ITCM | ARM926 up to 440 MHz, 16 KB I + 16 KB D, 2 KB ITCM | ARM926 up to 440 MHz, 16 KB I + 16 KB D | ARM926 up to 800 MHz, 32 KB I + 32 KB D | ARM926 up to 800 MHz, 32 KB I + 32 KB D | ARM926 540 MHz, 32 KB I + 32 KB D | ARM926 540 MHz, 32 KB I + 32 KB D | ARM926 600 MHz, 32 KB I + 32 KB D |
        | Interrupt controller | ARM GIC (A9 MPCore), IDs 0-31 internal | PL190 VIC | PL190 VIC | PL190 VIC | PL190 VIC | PL190 VIC | PL190 VIC | PL190 VIC | PL190 VIC | PL190 VIC |
        | DDR | DDR2/DDR3, 32 or 16 bit, up to 500 MHz, 1 GB (32 bit) / 512 MB (16 bit) | DDR2/DDR3, 16 bit, up to 440 MHz, up to 256 MB | DDR2/DDR3, 16 bit, up to 400 MHz, up to 256 MB | DDR2/DDR3, 16 bit, up to 400 MHz, up to 128 MB | embedded 16-bit DDR2, up to 512 Mbit | external 16-bit DDR3/DDR3L, up to 4 Gbit | embedded 512 Mbit DDR (1.8 V) | embedded 16-bit DDR2 512 Mbit, 360 MHz | embedded 16-bit DDR2 256 Mbit, 360 MHz | external 16-bit DDR2/DDR3/DDR3L, up to 4 Gbit, 400 MHz |
        | Boot media | NAND, SPI flash, or PCIe load into DDR | SPI NOR, NAND | SPI NOR, NAND | SPI NOR only | SPI NOR only | SPI NOR/NAND, eMMC (4-bit), serial (fastboot), SD/USB update | same as C V300 (SPI NOR/NAND, eMMC, fastboot, update) | serial (BOOTROM), SPI NOR/NAND, eMMC | same as V200 | same as V200 |
        | Flash controllers | NANDC (2 CS), SFC (2 CS) | SFC (1 CS), NANDC | SFC (1 CS), NANDC | SFC (1 CS) | SFC (1 CS) | FMC (SPI NOR/NAND), eMMC via MMC | FMC, eMMC via MMC | FMC, eMMC | FMC, eMMC | FMC, eMMC |
        | Video encoder | H.264 BP/MP/HP, MPEG4 SP, JPEG; up to 16 Mpixel | H.264 BP/MP, MJPEG/JPEG; 1080p@30 + VGA@30 + JPEG 1080p@1 | H.264 BP/MP, MJPEG/JPEG; 720p@30 + VGA@30 + QVGA@30 + JPEG 720p@1 | H.264 BP/MP, MJPEG/JPEG; 720p@30 + QVGA@30 + JPEG 720p@1 | H.264 BP/MP, MJPEG/JPEG; 720p@25 + JPEG 720p@3 | H.264 BP/MP/HP, H.265 Main, MJPEG/JPEG; 2048x2048@15 + 640x640@15, or 1080p@30 + 480p@30 + 240p@30 | same codecs; 1536x1536 (width up to 2048); 1080p@20 + 576p@20 | H.264 BP/MP/HP, MJPEG/JPEG; 1080p@20 | H.264 BP/MP/HP, MJPEG/JPEG; 960p@25 (no LDC, no 90/270 rotation) | H.264 BP/MP/HP, MJPEG/JPEG; 1080p@30 |
        | Video in | 8-16 bit RGB Bayer up to 150 MHz, BT.601/656/1120, dual sensor | 8/10/12-bit Bayer up to 74.25 MHz, BT.656/BT.1120 | 8/10/12-bit Bayer up to 74.25 MHz, BT.656/BT.1120 | 8/10/12-bit Bayer up to 74.25 MHz, BT.656/BT.1120 | 8/10/12-bit Bayer up to 74.25 MHz, BT.656/BT.1120, 1080p@30 / 720p@30 | 8-14 bit Bayer DC, BT.601/656/1120, MIPI, LVDS/sub-LVDS, HiSPi, up to 2048x2048 and 250 Mpixel/s | same as C V300 | MIPI / LVDS / HiSPi / BT.656 (VICAP) | same as V200 | same as V200, plus differential and single-ended pin modes |
        | Video out | CVBS, BT.656, BT.1120 (1080p@30) | CVBS, BT.1120 (1080p@30) | CVBS, BT.1120 | BT.1120 (no CVBS) | BT.1120 (no CVBS) | PAL/NTSC CVBS, BT.656, 6-bit RGB565 LCD | BT.656, RGB565 LCD (no CVBS) | - | - | - |
        | Ethernet | GMAC 10/100/1000, RGMII/MII | MAC 10/100, RGMII/MII | MAC 10/100, RGMII/MII | MAC 10/100, RGMII/MII | MAC 10/100, RMII/MII | MAC 10/100 RMII, TSO | MAC 10/100 RMII, TSO | MAC + internal FE PHY | MAC + internal FE PHY | MAC + internal FE PHY |
        | USB | 2 x USB 2.0 host | 1 x USB 2.0 host | 1 x USB 2.0 host | 1 x USB 2.0 host | 1 x USB 2.0 host | 1 x USB 2.0 host/device | 1 x USB 2.0 host/device | USB 2.0 host/device | USB 2.0 host/device | USB 2.0 host/device |
        | SDIO/MMC | 2 x MMC (SD/SDIO/eMMC) | 1 x SDIO 2.0 | 1 x SDIO 2.0 | 1 x SDIO 2.0 | 1 x SDIO 2.0 | 3 x SDIO 2.0 (two with 3.3/1.8 V) + eMMC 4.5 | 3 x SDIO 2.0 + eMMC 4.5 | 2 x SDIO + eMMC | 2 x SDIO + eMMC | 2 x SDIO + eMMC |
        | Package | FC-CSP 416, 15x15 mm, 0.65 mm | FCBGA 293, 13x13x1.37 mm, 0.65 mm | FCBGA 293, 13x13x1.37 mm, 0.65 mm | ePad QFP, 20x20x1.0 mm, 0.4 mm | BGA 220, 11x11 mm, 0.65 mm | TFBGA 273, 12x12 mm, 0.65 mm | TFBGA 231, 10x14 mm, 0.65 mm | TFBGA 192, 10x10 mm | TFBGA 192, 10x10 mm | TFBGA 273, 12x12 mm |
        | Typical power | 1200 mW | 850 mW | 700 mW | 700 mW (one value for the Hi3518 sheet) | 900 mW | 550 mW (1080p30) | 600 mW (1080p20) | - | - | - |
        | Core / DDR voltage | 1.0 V core; 1.8/1.5 V DDR; 2.5 V, 3.3 V | 1.2 V; 1.5/1.8 V DDR; 3.3 V I/O | 1.2 V; 1.5/1.8 V DDR; 3.3 V I/O | 1.2 V; 1.5/1.8 V DDR; 3.3 V I/O | 1.2 V; 1.8 V embedded DDR; 3.3 V I/O | 0.9 V; 1.5/1.35 V DDR; 3.3 V I/O | 0.9 V; 1.8 V DDR; 3.3 V I/O | - | - | - |
        | Chip ID (SC_SYSID) | 0x3516_0100 | 0x3518_0100 (as printed in the sheet) | 0x3518_0100 | 0x3518_0100 | 0x3518_0100 (as printed) | 0x3516_C300 | 0x3516_C300 (one value printed for both) | 0x3518E200, SCSYSID0[31:24] = 0x02 | 0x3518E200, [31:24] = 0x03 | 0x3518E200, [31:24] = 0x01 |
        | SDK kernel | - | Linux 3.0.y | Linux 3.0.y | Linux 3.0.y | Linux 3.0.y | Linux 3.18 | Linux 3.18 | - | - | - |

        Differences the data sheets state: the Hi3518C has no NAND controller, no CVBS output, no 90/270 degree rotation, no autofocus, two UARTs, no SSP/IR and 128 MB maximum DDR; the Hi3516C V100 is the Hi3518A with 1080p encoding; the Hi3518E V100 is a 720p part with embedded DDR2 and no NAND controller; the Hi3516E V100 differs from the Hi3516C V300 by embedded 512 Mbit DDR, a 231-pin package, no CVBS output, no two-frame WDR and the lower encoder limit; the Hi3518E V200/V201/Hi3516C V200 differ in CPU speed, DDR, package and encoder performance (table in the root description above).

        Chip: Hi3516 V100 (Hi3516 Full-HD IP-Cam SoC user guide / data sheet, issue 00B60 (2011-08-12), Chinese, chapter 1 (translated)).

        ### Boot selection (data sheet 1.3 / 1.4)

        | Strap | Boot medium |
        |---|---|
        | BOOT_SEL1 (PWM1_OUT0) = 0, BOOT_SEL0 (PWM0_OUT2) = 1 | NAND flash (NANDC) |
        | BOOT_SEL1 = 0, BOOT_SEL0 = 0 | SPI flash (SFC) |
        | BOOT_SEL1 = 1 | PCIe load: the A9 reset stays asserted until an external master has loaded DDR over PCIe; zero address is DDR |

        ### Memory map notes

        * 0x00000000 remap window; NANDC space 0x50000000 (64 MB), SPI flash 0x58000000 (64 MB), PCIe memory 0x30000000 and PCIe configuration 0x40000000 (256 MB each), PCIe registers 0x20800000, L2 cache controller 0x20700000 (1 MB window, internal), ARM debug 0x20400000 (1152 KB), A9 private (watchdog, timer, GIC) 0x20300000, DDR 0x80000000-0xFFFFFFFF (2 GB window) (Chinese Table 1-1).

        ### DMA request lines (data sheet table 3-21 (Chinese), DMAC at 0x100D0000)

        | Req | Peripheral | Req | Peripheral | Req | Peripheral | Req | Peripheral |
        |---|---|---|---|---|---|---|---|
        | 0 | SIO0 RX | 4 | SIO2 TX (as printed) | 8 | SSP1 RX | 12 | UART1 RX |
        | 1 | SIO0 TX | 5 | SIO2 TX (printed twice; request 5 is probably RX: INFERRED) | 9 | SSP1 TX | 13 | UART1 TX |
        | 2 | SIO1 RX | 6 | SSP0 RX | 10 | UART0 RX | 14 | UART2 RX |
        | 3 | SIO1 TX | 7 | SSP0 TX | 11 | UART0 TX | 15 | UART2 TX |

        Requests are assigned to channels by software (the data sheet example: request 0 as source of channel 3).

        ### Pin multiplexing summary (generated from the IO_CONFIG registers)

        84 one-per-pin `muxctrl_regN` registers. Alternate functions per interface, as named in the register enumerations (GPIO is always one of the choices); 0 pins have no alternate function other than GPIO. Per-pin choices are in the IO_CONFIG register pages.

        | Interface | Functions |
        |---|---|
        | Serial flash (SFC / FMC) | SFC_CS0N |
        | NAND (NANDC) | NF_CSN0, NF_CSN1, NF_DQ0-7, NF_PAGE0, NF_PAGE1, NF_RDY0, NF_RDY1 |
        | SD / SDIO / eMMC | SDIO0_CARD_DETECT, SDIO0_CARD_POWER, SDIO0_CCMD, SDIO0_CCMD_ODPULLUP, SDIO0_CDATA0-7, SDIO0_CWPR, SDIO1_CARD_DETECT, SDIO1_CARD_POWER, SDIO1_CCLK_OUT, SDIO1_CCMD, SDIO1_CCMD_ODPULLUP, SDIO1_CDATA0-7, SDIO1_CWPR |
        | Ethernet (MAC, MII/RMII/RGMII, MDIO, PHY clock) | EPHY_CLK, RGMII_COL, RGMII_CRS, RGMII_TXCKOUT |
        | Video input (VI / VIU) | VIU0_DAT12-15, VIU1_CLK, VIU1_DAT0-15, VIU1_HS, VIU1_VS |
        | Video output (VO / LCD) | VOU0_CLK, VOU0_DATA0-15, VOU0_DV, VOU0_HS, VOU0_VS, VOU1_CLK, VOU1_DATA0-7 |
        | UART | UART1_CTSN, UART1_RTSN, UART1_RXD, UART1_TXD, UART2_RXD, UART2_TXD, UART3_RXD, UART3_TXD |
        | SPI / SSP | SPI0_CSN0, SPI0_CSN1, SPI0_SCLK, SPI0_SDI, SPI0_SDO, SPI1_CSN0, SPI1_SCLK, SPI1_SDI, SPI1_SDO |
        | I2C | I2C_SCL, I2C_SDA |
        | Audio (I2S / SIO) | SIO0_DIN, SIO0_DOUT, SIO0_MCLK, SIO0_RCLK, SIO0_RFS, SIO0_XCLK, SIO0_XFS, SIO1_DIN, SIO1_DOUT, SIO1_RCLK, SIO1_RFS, SIO1_XCLK, SIO1_XFS |
        | PWM | PWM1_OUT1, PWM1_OUT2 |
        | IR, ADC, USB, JTAG | IR, USB0_OVRCUR, USB0_PWREN, USB1_OVRCUR, USB1_PWREN |
        | Boot straps and test | CLK_TEST_OUT0-3 |
        | Other | PLL_TEST_OUT0-3, RESERVE, SENS_CLK |

        ### Clocks (data sheet 3.2, Chinese; translated)

        Inputs: XIN (24 MHz crystal, PLL input), VIU0_CLK / VIU1_CLK (video input), RGMII_RXCK / RGMII_TXCK (GMAC). Four PLLs, two registers each: APLL PERI_CRG0/1 (A9, DDR controller and bus clocks), VPLL0 PERI_CRG2/3 (VOSD clock), VPLL1 PERI_CRG4/5 (VOHD clock), EPLL PERI_CRG6/7 (GMAC and PCIe clocks). FOUTVCO = 24 MHz x (fbdiv + frac/2^24) / refdiv, between 800 MHz and 2.4 GHz. A9 : AXI ratio from a9_axi_freq_mode (11 = 1:1, 10 = 2:1, 01 = 3:1, 00 = 4:1); a9_max_freq_mode = 0 allows A9 800 MHz (APLL FOUTPOSTDIV 800 MHz), 1 allows 750 MHz (FOUTPOSTDIV 1500 MHz).

        Timer count clocks: SC_CTRL timeren0sel..3sel (bits 15, 17, 19, 21) select the 3 MHz clock; timeren0ov..3ov (bits 16, 18, 20, 22): reference clock (0) or bus clock (1).

        ### Reset and power

        * Reset sources (data sheet 3.1, Chinese): power-on reset and global soft reset from the system controller; system soft reset deasserts after at least 360 system clocks; per-module soft resets are not self-clearing (write 1 to reset, then 0). A9/AXI frequency modes and the maximum A9 frequency mode (800 MHz, or 750 MHz with a9_max_freq_mode = 1 and APLL FOUTPOSTDIV at 1500 MHz) are in the CRG.

        ### Interrupts (Cortex-A9 GIC interrupt IDs, data sheet Table 3-19); the data sheet is Chinese, names translated

        | # | Source | # | Source | # | Source |
        |---|---|---|---|---|---|
        | 0-31 | A9 internal use | 49 | UART3 | 67 | DMAC |
        | 32 | COMMTX (CPU debug) | 50 | VICAP | 68 | USB0_EHCI |
        | 33 | COMMRX (CPU debug) | 51 | VEDU | 69 | USB0_OHCI |
        | 34 | WatchDog | 52 | VOU | 70 | SDIO0 |
        | 35 | Timer0/1 | 53 | TDE | 71 | SDIO1 |
        | 36 | Timer2/3 | 54 | JPEG | 72 | L2CACHE_CHK0_INT |
        | 37 | GPIO0 | 55 | MD | 73 | L2CACHE_CHK1_INT |
        | 38 | GPIO1 | 56 | VAPU | 74 | L2CACHE_INT_COMB |
        | 39 | GPIO2 | 57 | SIO0 | 75 | A9_PMU_INT0 |
        | 40 | GPIO3 | 58 | SIO1 | 76 | Pcie_radm_inta |
        | 41 | GPIO4 | 59 | SIO2 | 77 | Pcie_radm_intb |
        | 42 | GPIO5 | 60 | GMAC | 78 | Pcie_radm_intc |
        | 43 | GPIO6 | 61 | Cipher | 79 | Pcie_radm_intd |
        | 44 | GPIO7 | 62 | IR | 80 | Pcie_cfg_pme_int |
        | 45 | I2C | 63 | NandC | 81 | Pcie_hp_pme_int |
        | 46 | UART0 | 64 | SFC (SPI flash controller) | 82 | Pcie_hp_int |
        | 47 | UART1 | 65 | SSP0 | 83 | Pcie_cfg_aer_rc_err_int |
        | 48 | UART2 | 66 | SSP1 |  |  |

        ### Clock-gate and reset map (generated from the CRG registers)

        | Offset | Register | Description | Gate / reset fields |
        |---|---|---|---|
        | 0x020 | PERI_CRG8 | A9 frequency mode and reset configuration register | cpu_srst_req, cluster_dbg_srst_req, wd_srst_req, cluster_peri_srst_req, cluster_scu_srst_req, cs_srst_req |
        | 0x034 | PERI_CRG13 | SIO0 clock and soft reset control register | sio0_srst_req, sio0_cken |
        | 0x038 | PERI_CRG14 | SIO1 clock and soft reset control register | sio1_srst_req, sio1_cken |
        | 0x03C | PERI_CRG15 | SIO2 clock and soft reset control register | sio2_srst_req, sio2_cken, audio_codec_rst_req |
        | 0x040 | PERI_CRG16 | VIU | viu_hrst_req, vi0_rst_req, vi1_rst_req, vi_dll_rst, vi_hclk_en, vi_ch0_clken, vi_ch1_clken, vi_ch2_clken, vi_ch3_clken, vi_ch4_clken, ... |
        | 0x044 | PERI_CRG17 | VOU clock and reset control register | vou_srst_req, vou_sd_cken, vou_hd_cken |
        | 0x048 | PERI_CRG18 | VEDU clock and soft reset control register | vedu_srst_req, vedu_cken |
        | 0x04C | PERI_CRG19 | JPGE clock and soft reset control register | jpge_srst_req, jpge_cken |
        | 0x050 | PERI_CRG20 | MD clock and soft reset control register | md_srst_req, md_cken |
        | 0x054 | PERI_CRG21 | GMAC clock and soft reset control register | gmac_rst_req, gmac_cken |
        | 0x058 | PERI_CRG22 | IVE clock and soft reset control register | ive_srst_req, ive_cken |
        | 0x05C | PERI_CRG23 | TDE clock and soft reset control register | tde_srst_req, tde_cken |
        | 0x060 | PERI_CRG24 | NFC clock and soft reset control register | nfc_srst_req, nfc_cken |
        | 0x064 | PERI_CRG25 | SFC clock and soft reset control register | sfc_srst_req, sfc_cken |
        | 0x068 | PERI_CRG26 | PWM0/PWM1/EFUSE clock and soft reset control register | pwm0_srst_req, pwm0_cken, pwm1_srst_req, pwm1_cken, efuse_srst_req, efuse_cken |
        | 0x06C | PERI_CRG27 | DMA clock and soft reset control register | dma_srst_req, dma_cken |
        | 0x070 | PERI_CRG28 | SSP0 clock and soft reset control register | ssp0_srst_req, ssp0_cken |
        | 0x074 | PERI_CRG29 | SSP1 clock and soft reset control register | ssp1_srst_req, ssp1_cken |
        | 0x078 | PERI_CRG30 | USB clock and soft reset control register | usb_ahb_srst_req, usb_cken |
        | 0x07C | PERI_CRG31 | PCIE clock and soft reset control register | pcie_srst_req, pcie_cken |
        | 0x080 | PERI_CRG32 | SDIO0/SDIO1 clock and soft reset control register | sdio0_srst_req, sdio0_cken, sdio1_srst_req, sdio1_cken |
        | 0x084 | PERI_CRG33 | UART0 clock and soft reset control register | uart0_srst_req, uart0_cken |
        | 0x088 | PERI_CRG34 | UART1 clock and soft reset control register | uart1_srst_req, uart1_cken |
        | 0x08C | PERI_CRG35 | UART2 clock and soft reset control register | uart2_srst_req, uart2_cken |
        | 0x090 | PERI_CRG36 | UART3 clock and soft reset control register | uart3_srst_req, uart3_cken |
        | 0x094 | PERI_CRG37 | I2C clock and soft reset control register | i2c_srst_req, i2c_cken |
        | 0x098 | PERI_CRG38 | IR/RTC/CIPHER clock and soft reset control register | ir_srst_req, ir_cken, rtc_srst_req, rtc_cken, cipher_srst_req, cipher_cken |
        | 0x0A8 | PERI_CRG42 | CRG test register | test_clk_en |

        Only fields whose names contain a clock-enable or reset keyword are listed; the field descriptions in the register pages give the polarity and the clocks they gate.

        ### Register blocks (generated from this description)

        | Base | Instance | Block | Register space |
        |---|---|---|---|
        | 0x10000000 | NANDC | HiSilicon parallel NAND flash controller (hinfc300/301/504 family) | 156 B |
        | 0x10010000 | SFC | SPI Flash Controller Registers (hisfc300 generation) | 96 B |
        | 0x10020000 | SDIO0 | HiSilicon MMC/SD/SDIO controller (DesignWare-MMC based, himciv200) | 260 B |
        | 0x10030000 | SDIO1 | HiSilicon MMC/SD/SDIO controller (DesignWare-MMC based, himciv200) | 260 B |
        | 0x10090000 | ETH | HiSilicon GSF gigabit Ethernet MAC with descriptor queues and MDIO | 1520 B |
        | 0x100A0000 | OHCI | HiSilicon USB 2.0 host controller - OHCI | 92 B |
        | 0x100B0000 | EHCI | HiSilicon USB 2.0 host controller - EHCI | 176 B |
        | 0x100C0000 | CIPHER | CIPHER (8 channels) | 5184 B |
        | 0x100D0000 | DMAC | HiSilicon DMA controller (PL080-compatible, 4 or 8 channels) | 512 B |
        | 0x20000000 | TIMER0 | Timer Registers | 28 B |
        | 0x20000020 | TIMER1 | Timer Registers | 28 B |
        | 0x20010000 | TIMER2 | Timer Registers | 28 B |
        | 0x20010020 | TIMER3 | Timer Registers | 28 B |
        | 0x20030000 | CRG | Clock and reset generator (CRG), Hi3516 V100 | 176 B |
        | 0x20040000 | WDG | Watchdog Registers | 3076 B |
        | 0x20050000 | SYS_CTRL | System Controller Registers | 3824 B |
        | 0x20060000 | RTC | RTC (ARM PL031-style 32-bit counter) | 32 B |
        | 0x20070000 | IR | HiSilicon IR receiver | 56 B |
        | 0x20080000 | UART0 | UART (ARM PrimeCell PL011) | 4 KB |
        | 0x20090000 | UART1 | UART (ARM PrimeCell PL011) | 4 KB |
        | 0x200A0000 | UART2 | UART (ARM PrimeCell PL011) | 4 KB |
        | 0x200B0000 | UART3 | UART (ARM PrimeCell PL011) | 4 KB |
        | 0x200C0000 | SPI0 | SPI Registers | 48 B |
        | 0x200D0000 | I2C | HiSilicon I2C Master Controller | 32 B |
        | 0x200E0000 | SPI1 | SPI Registers | 48 B |
        | 0x200F0000 | IO_CONFIG | IO configuration (pin multiplexing control), Hi3516 V100 | 336 B |
        | 0x20110000 | DDRC | DDRC Registers | 908 B |
        | 0x20130000 | IVE | HiSilicon intelligent video engine | 28 B |
        | 0x20160000 | GPIO1 | ARM PL061 | 1053 B |
        | 0x20170000 | GPIO2 | ARM PL061 | 1053 B |
        | 0x20180000 | GPIO3 | ARM PL061 | 1053 B |
        | 0x20190000 | GPIO4 | ARM PL061 | 1053 B |
        | 0x201A0000 | GPIO5 | ARM PL061 | 1053 B |
        | 0x201B0000 | GPIO6 | ARM PL061 | 1053 B |
        | 0x201C0000 | GPIO7 | ARM PL061 | 1053 B |
        | 0x201D0000 | PWM0 | HiSilicon PWM module (V1) | 48 B |
        | 0x201E0000 | PWM1 | HiSilicon PWM module (V1) | 48 B |
        | 0x20200000 | GPIO8 | ARM PL061 | 1053 B |
        | 0x20210000 | GPIO9 | ARM PL061 | 1053 B |
        | 0x20220000 | GPIO10 | ARM PL061 | 1053 B |
        | 0x20300000 | A9_PERI | Cortex-A9 MPCore private memory region | 8 KB |
        | 0x20600000 | VEDU | HiSilicon VEDU (registers not described) | 64 KB |
        | 0x20610000 | JPEG | HiSilicon JPGE (window only, registers not described) | 64 KB |
        | 0x20620000 | MOTION_DETECT | Motion Detect Unit Registers | 188 B |
        | 0x20630000 | TDE | HiSilicon TDE (registers not described) | 64 KB |
        | 0x20640000 | VDP | VDP (video display processor, Hi3516 V100) | 5780 B |
        | 0x20650000 | VICAP | VICAP (video capture, Hi3516 V100) | 36892 B |
        | 0x20700000 | L2CACHE | HiSilicon L2 cache controller v200 | 2060 B |

        The table is generated from the elaborated root (instances at their absolute addresses; register space is the span of the block's registers, not the data sheet window).

        <!-- overview:end -->
    ";

    eHISI_NANDC         NANDC           @ 0x10000000;
    eHISI_SFC_300       SFC             @ 0x10010000;
    eHISI_DWMMC         SDIO0           @ 0x10020000;
    eHISI_DWMMC         SDIO1           @ 0x10030000;
    eHISI_GMAC          ETH             @ 0x10090000;
    eHISI_USB_OHCI      OHCI            @ 0x100A0000;
    eHISI_USB_EHCI      EHCI            @ 0x100B0000;
    eHISI_CIPHER_MC     CIPHER          @ 0x100C0000;
    eHISI_DMAC          DMAC            @ 0x100D0000;
    eHISI_TIMER_SP804   TIMER0          @ 0x20000000;
    eHISI_TIMER_SP804   TIMER1          @ 0x20000020;
    // TODO: Verify TIMER2/TIMER3
    eHISI_TIMER_SP804   TIMER2          @ 0x20010000;
    eHISI_TIMER_SP804   TIMER3          @ 0x20010020;
    eCRG                CRG             @ 0x20030000;
    eHISI_WDG_SP805     WDG             @ 0x20040000;
    eSYS_CTRL           SYS_CTRL        @ 0x20050000;
    eHISI_RTC           RTC             @ 0x20060000;
    eHISI_IR            IR              @ 0x20070000;
    eARM_PL011          UART0           @ 0x20080000;
    eARM_PL011          UART1           @ 0x20090000;
    eARM_PL011          UART2           @ 0x200A0000;
    eARM_PL011          UART3           @ 0x200B0000;
    eHISI_SPI           SPI0            @ 0x200C0000;
    eHISI_I2C           I2C             @ 0x200D0000;
    eHISI_SPI           SPI1            @ 0x200E0000;
    eIO_CONFIG          IO_CONFIG       @ 0x200F0000;
    eDDRC               DDRC            @ 0x20110000;
    eHISI_IVE           IVE             @ 0x20130000;
    eARM_PL061          GPIO1           @ 0x20160000;
    eARM_PL061          GPIO2           @ 0x20170000;
    eARM_PL061          GPIO3           @ 0x20180000;
    eARM_PL061          GPIO4           @ 0x20190000;
    eARM_PL061          GPIO5           @ 0x201A0000;
    eARM_PL061          GPIO6           @ 0x201B0000;
    eARM_PL061          GPIO7           @ 0x201C0000;
    eHISI_PWM_V1_GRP    PWM0            @ 0x201D0000;
    eHISI_PWM_V1_GRP    PWM1            @ 0x201E0000;
    eARM_PL061          GPIO8           @ 0x20200000;
    eARM_PL061          GPIO9           @ 0x20210000;
    eARM_PL061          GPIO10          @ 0x20220000;
    eARM_A9_MPCORE      A9_PERI         @ 0x20300000;
    aHISI_VEDU          VEDU            @ 0x20600000;
    aHISI_JPGE          JPEG            @ 0x20610000;
    eMOTION_DETECT      MOTION_DETECT   @ 0x20620000;
    aHISI_TDE           TDE             @ 0x20630000;
    eHISI_VDP_3516V100  VDP             @ 0x20640000;
    eHISI_VICAP_3516V100 VICAP           @ 0x20650000;
    eHISI_L2CACHE_V200  L2CACHE         @ 0x20700000;
};

