`ifndef HI3516V100_IO_CONFIG_RDL
`define HI3516V100_IO_CONFIG_RDL

regfile eIO_CONFIG {
    name = "IO configuration (pin multiplexing control), Hi3516 V100";
    desc = "
    Pin multiplexing control registers of the Hi3516 V100 at 0x200F0000 ('IO config 寄存器', 64 KB window, DS Table 1-1 line 1013): 84 registers `muxctrl_reg0`..`muxctrl_reg83` at offsets 0x0..0x14C,
    one register per software-multiplexed pin, each holding one RW field (1 or 2 bits) that selects the pin function; all reset to 0 (the first listed
    function, usually the pin's primary function, GPIO where the pin is GPIO by default). The register name is the data sheet's; the register title names the pin.

    Source: Hi3516 Full-HD IP-Cam SOC 用户指南 (user guide / data sheet), original Chinese edition 文档版本 00B60 (2011-08-12), section 2.1.4 (summary Table 2-30, dump line 4038) and section 2.1.5 (register descriptions, dump lines 4262..6849). Chinese original, so the
    values are high confidence; the function names are copied verbatim, the sentences translated. No Hi3516 V100 vendor code (U-Boot/kernel board files) exists in this
    workspace to cross-check against (only Hi3520D and Hi3516A trees), so the register set is data-sheet only.

    | Register | Offset | Pin | Values |
    |----------|--------|-----|--------|
    | muxctrl_reg0 | 0x0 | VIU0_DAT15 | 0=VIU0_DAT15, 1=GPIO1_0 |
    | muxctrl_reg1 | 0x4 | VIU0_DAT14 | 0=VIU0_DAT14, 1=GPIO1_1 |
    | muxctrl_reg2 | 0x8 | VIU0_DAT13 | 0=VIU0_DAT13, 1=GPIO1_2 |
    | muxctrl_reg3 | 0xC | VIU0_DAT12 | 0=VIU0_DAT12, 1=GPIO1_3 |
    | muxctrl_reg4 | 0x10 | VIU1_CLK | 00=VIU1_CLK, 01=GPIO1_4, 10=VOU0_CLK, 11=SDIO1_CCLK_OUT |
    | muxctrl_reg5 | 0x14 | VIU1_VS | 00=VIU1_VS, 01=GPIO1_5, 10=VOU0_VS |
    | muxctrl_reg6 | 0x18 | VIU1_HS | 00=VIU1_HS, 01=GPIO1_6, 10=VOU0_HS, 11=SDIO1_CWPR |
    | muxctrl_reg7 | 0x1C | VIU1_DAT15 | 00=VIU1_DAT15, 01=GPIO1_7, 10=VOU0_DATA15, 11=SDIO1_CARD_POWER_EN |
    | muxctrl_reg8 | 0x20 | VIU1_DAT14 | 00=VIU1_DAT14, 01=GPIO2_0, 10=VOU0_DATA14, 11=SDIO1_CARD_DETECT |
    | muxctrl_reg9 | 0x24 | VIU1_DAT13 | 00=VIU1_DAT13, 01=GPIO2_1, 10=VOU0_DATA13, 11=SDIO1_CCMD_ODPULLUP_EN_N |
    | muxctrl_reg10 | 0x28 | VIU1_DAT12 | 00=VIU1_DAT12, 01=GPIO2_2, 10=VOU0_DATA12, 11=SDIO1_CCMD |
    | muxctrl_reg11 | 0x2C | VIU1_DAT11 | 00=VIU1_DAT11, 01=GPIO2_3, 10=VOU0_DATA11, 11=SDIO1_CDATA0 |
    | muxctrl_reg12 | 0x30 | VIU1_DAT10 | 00=VIU1_DAT10, 01=GPIO2_4, 10=VOU0_DATA10, 11=SDIO1_CDATA1 |
    | muxctrl_reg13 | 0x34 | VIU1_DAT9 | 00=VIU1_DAT9, 01=GPIO2_5, 10=VOU0_DATA9, 11=SDIO1_CDATA2 |
    | muxctrl_reg14 | 0x38 | VIU1_DAT8 | 00=VIU1_DAT8, 01=GPIO2_6, 10=VOU0_DATA8, 11=SDIO1_CDATA3 |
    | muxctrl_reg15 | 0x3C | VIU1_DAT7 | 00=VIU1_DAT7, 01=GPIO2_7, 10=VOU0_DATA7, 11=SDIO1_CDATA4 |
    | muxctrl_reg16 | 0x40 | VIU1_DAT6 | 00=VIU1_DAT6, 01=GPIO3_0, 10=VOU0_DATA6, 11=SDIO1_CDATA5 |
    | muxctrl_reg17 | 0x44 | VIU1_DAT5 | 00=VIU1_DAT5, 01=GPIO3_1, 10=VOU0_DATA5, 11=SDIO1_CDATA6 |
    | muxctrl_reg18 | 0x48 | VIU1_DAT4 | 00=VIU1_DAT4, 01=GPIO3_2, 10=VOU0_DATA4, 11=SDIO1_CDATA7 |
    | muxctrl_reg19 | 0x4C | VIU1_DAT3 | 00=VIU1_DAT3, 01=GPIO3_3, 10=VOU0_DATA3 |
    | muxctrl_reg20 | 0x50 | VIU1_DAT2 | 00=VIU1_DAT2, 01=GPIO3_4, 10=VOU0_DATA2 |
    | muxctrl_reg21 | 0x54 | VIU1_DAT1 | 00=VIU1_DAT1, 01=GPIO3_5, 10=VOU0_DATA1 |
    | muxctrl_reg22 | 0x58 | VIU1_DAT0 | 00=VIU1_DAT0, 01=GPIO3_6, 10=VOU0_DATA0 |
    | muxctrl_reg23 | 0x5C | SIO0_MCLK | 0=GPIO3_7, 1=SIO0_MCLK |
    | muxctrl_reg24 | 0x60 | SIO0_XCLK | 00=GPIO4_0, 01=SIO0_XCLK, 10=SPI1_SCLK |
    | muxctrl_reg25 | 0x64 | SIO0_XFS | 00=GPIO4_1, 01=SIO0_XFS, 10=SPI1_CSN0 |
    | muxctrl_reg26 | 0x68 | SIO0_RCLK | 0=GPIO4_2, 1=SIO0_RCLK |
    | muxctrl_reg27 | 0x6C | SIO0_RFS | 0=GPIO4_3, 1=SIO0_RFS |
    | muxctrl_reg28 | 0x70 | SIO0_DOUT | 00=GPIO4_4, 01=SIO0_DOUT, 10=SPI1_SDO |
    | muxctrl_reg29 | 0x74 | SIO0_DIN | 00=GPIO4_5, 01=SIO0_DIN, 10=SPI1_SDI |
    | muxctrl_reg30 | 0x78 | SPI0_SCLK | 0=GPIO4_6, 1=SPI0_SCLK |
    | muxctrl_reg31 | 0x7C | SPI0_SDO | 0=GPIO4_7, 1=SPI0_SDO |
    | muxctrl_reg32 | 0x80 | SPI0_SDI | 0=GPIO5_0, 1=SPI0_SDI |
    | muxctrl_reg33 | 0x84 | SPI0_CSN0 | 0=GPIO5_1, 1=SPI0_CSN0 |
    | muxctrl_reg34 | 0x88 | SPI0_CSN1 | 00=GPIO5_2, 01=SPI0_CSN1, 10=VOU0_DV |
    | muxctrl_reg35 | 0x8C | I2C_SDA | 0=GPIO5_3, 1=I2C_SDA |
    | muxctrl_reg36 | 0x90 | I2C_SCL | 0=GPIO5_4, 1=I2C_SCL |
    | muxctrl_reg37 | 0x94 | UART1_RTSN | 0=GPIO5_5, 1=UART1_RTSN |
    | muxctrl_reg38 | 0x98 | UART1_RXD | 0=GPIO5_6, 1=UART1_RXD |
    | muxctrl_reg39 | 0x9C | UART1_CTSN | 0=GPIO5_7, 1=UART1_CTSN |
    | muxctrl_reg40 | 0xA0 | UART1_TXD | 0=GPIO6_0, 1=UART1_TXD |
    | muxctrl_reg41 | 0xA4 | RGMII_TXCKOUT | 0=GPIO6_1, 1=RGMII_TXCKOUT |
    | muxctrl_reg42 | 0xA8 | RGMII_CRS | 0=RGMII_CRS, 1=GPIO6_2 |
    | muxctrl_reg43 | 0xAC | RGMII_COL | 0=RGMII_COL, 1=GPIO6_3 |
    | muxctrl_reg44 | 0xB0 | IR_IN | 0=IR_IN, 1=GPIO6_4 |
    | muxctrl_reg45 | 0xB4 | NF_DQ0 | 0=NF_DQ0, 1=GPIO6_5 |
    | muxctrl_reg46 | 0xB8 | NF_DQ1 | 0=NF_DQ1, 1=GPIO6_6 |
    | muxctrl_reg47 | 0xBC | NF_DQ2 | 0=NF_DQ2, 1=GPIO6_7 |
    | muxctrl_reg48 | 0xC0 | NF_DQ3 | 0=NF_DQ3, 1=GPIO7_0 |
    | muxctrl_reg49 | 0xC4 | NF_DQ4 | 0=NF_DQ4, 1=GPIO7_1 |
    | muxctrl_reg50 | 0xC8 | NF_DQ5 | 0=NF_DQ5, 1=GPIO7_2 |
    | muxctrl_reg51 | 0xCC | NF_DQ6 | 0=NF_DQ6, 1=GPIO7_3 |
    | muxctrl_reg52 | 0xD0 | NF_DQ7 | 0=NF_DQ7, 1=GPIO7_4 |
    | muxctrl_reg53 | 0xD4 | NF_RDY0 | 0=NF_RDY0, 1=GPIO7_5 |
    | muxctrl_reg54 | 0xD8 | NF_RDY1 | 0=NF_RDY1, 1=GPIO7_6 |
    | muxctrl_reg55 | 0xDC | NF_CSN0 | 0=NF_CSN0, 1=GPIO7_7 |
    | muxctrl_reg56 | 0xE0 | NF_CSN1 | 0=NF_CSN1, 1=GPIO8_0 |
    | muxctrl_reg57 | 0xE4 | SDIO0_CARD_POWER_EN | 0=GPIO8_1, 1=SDIO0_CARD_POWER_EN |
    | muxctrl_reg58 | 0xE8 | SDIO0_CARD_DETECT | 0=SDIO0_CARD_DETECT, 1=GPIO8_2 |
    | muxctrl_reg59 | 0xEC | SDIO0_CWPR | 0=SDIO0_CWPR, 1=GPIO8_3 |
    | muxctrl_reg60 | 0xF0 | SDIO0_CCMD_ODPULLUP_EN_N | 0=GPIO8_4, 1=SDIO0_CCMD_ODPULLUP_EN_N |
    | muxctrl_reg61 | 0xF4 | SDIO0_CCMD | 0=SDIO0_CCMD, 1=GPIO8_5 |
    | muxctrl_reg62 | 0xF8 | SDIO0_CDATA0 | 0=SDIO0_CDATA0, 1=GPIO8_6 |
    | muxctrl_reg63 | 0xFC | SDIO0_CDATA1 | 0=SDIO0_CDATA1, 1=RESERVE |
    | muxctrl_reg64 | 0x100 | SDIO0_CDATA4 | 0=SDIO0_CDATA4, 1=UART2_RXD |
    | muxctrl_reg65 | 0x104 | SDIO0_CDATA5 | 0=SDIO0_CDATA5, 1=UART2_TXD |
    | muxctrl_reg66 | 0x108 | SDIO0_CDATA6 | 00=SDIO0_CDATA6, 01=UART3_RXD, 10=PWM1_OUT1 |
    | muxctrl_reg67 | 0x10C | SDIO0_CDATA7 | 00=SDIO0_CDATA7, 01=UART3_TXD, 10=PWM1_OUT2 |
    | muxctrl_reg68 | 0x110 | SFC_CS0N | 0=SFC_CS0N, 1=GPIO8_7 |
    | muxctrl_reg69 | 0x114 | VOU1_CLK | 0=GPIO9_0, 1=VOU1_CLK |
    | muxctrl_reg70 | 0x118 | VOU1_DATA7 | 00=GPIO9_1, 01=VOU1_DATA7, 10=SIO1_XCLK |
    | muxctrl_reg71 | 0x11C | VOU1_DATA6 | 00=GPIO9_2, 01=VOU1_DATA6, 10=SIO1_XFS |
    | muxctrl_reg72 | 0x120 | VOU1_DATA5 | 00=GPIO9_3, 01=VOU1_DATA5, 10=SIO1_RCLK |
    | muxctrl_reg73 | 0x124 | VOU1_DATA4 | 00=GPIO9_4, 01=VOU1_DATA4, 10=SIO1_RFS |
    | muxctrl_reg74 | 0x128 | VOU1_DATA3 | 00=GPIO9_5, 01=VOU1_DATA3, 10=SIO1_DOUT |
    | muxctrl_reg75 | 0x12C | VOU1_DATA2 | 00=GPIO9_6, 01=VOU1_DATA2, 10=SIO1_DIN |
    | muxctrl_reg76 | 0x130 | VOU1_DATA1 | 000=CLK_TEST_OUT0, 001=VOU1_DATA1, 010=NF_PAGE1, 011=CLK_TEST_OUT1, 100=CLK_TEST_OUT2, 101=CLK_TEST_OUT3 |
    | muxctrl_reg77 | 0x134 | VOU1_DATA0 | 000=PLL_TEST_OUT0, 001=VOU1_DATA0, 010=NF_PAGE0, 011=PLL_TEST_OUT1, 100=PLL_TEST_OUT2, 101=PLL_TEST_OUT3 |
    | muxctrl_reg78 | 0x138 | USB0_OVRCUR | 00=USB0_OVRCUR, 10=GPIO9_7 |
    | muxctrl_reg79 | 0x13C | USB0_PWREN | 00=USB0_PWREN, 10=GPIO10_0 |
    | muxctrl_reg80 | 0x140 | USB1_OVRCUR | 00=USB1_OVRCUR, 10=GPIO10_1 |
    | muxctrl_reg81 | 0x144 | USB1_PWREN | 00=USB1_PWREN, 10=GPIO10_2 |
    | muxctrl_reg82 | 0x148 | SENS_CLK | 0=GPIO10_3, 1=SENS_CLK |
    | muxctrl_reg83 | 0x14C | EPHY_CLK | 0=GPIO10_4, 1=EPHY_CLK |
    ";

    reg {
        name = "Multiplexing control register for the VIU0_DAT15 pin";
        desc = "muxctrl_reg0 is the multiplexing control register for the VIU0_DAT15 pin (DS: VIU0_DAT15 管脚复用控制寄存器). Reset value 0 selects VIU0_DAT15.

Data sheet 2.1.5 muxctrl_reg0 (offset 0x0, printed page 2-54, `hi3516v100--Hi3516-Datasheet.txt` line 4262).";

        enum muxctrl_reg0_muxctrl_reg0_enum {
            VIU0_DAT15 = 0 { name = "Viu0 Dat15"; desc = "VIU0_DAT15"; };
            GPIO1_0 = 1 { name = "Gpio1 0"; desc = "GPIO1_0"; };
        };

        field {
            name = "muxctrl_reg0";
            desc = "Function of the VIU0_DAT15 pin (DS: VIU0_DAT15 管脚的具体复用情况).";
            sw = rw;
            hw = r;
            encode = muxctrl_reg0_muxctrl_reg0_enum;
            reset = 0x0;
        } muxctrl_reg0[0:0];
    } muxctrl_reg0 @ 0x0;

    reg {
        name = "Multiplexing control register for the VIU0_DAT14 pin";
        desc = "muxctrl_reg1 is the multiplexing control register for the VIU0_DAT14 pin (DS: VIU0_DAT14 管脚复用控制寄存器). Reset value 0 selects VIU0_DAT14.

Data sheet 2.1.5 muxctrl_reg1 (offset 0x4, printed page 2-55, `hi3516v100--Hi3516-Datasheet.txt` line 4299).";

        enum muxctrl_reg1_muxctrl_reg1_enum {
            VIU0_DAT14 = 0 { name = "Viu0 Dat14"; desc = "VIU0_DAT14"; };
            GPIO1_1 = 1 { name = "Gpio1 1"; desc = "GPIO1_1"; };
        };

        field {
            name = "muxctrl_reg1";
            desc = "Function of the VIU0_DAT14 pin (DS: VIU0_DAT14 管脚的具体复用情况).";
            sw = rw;
            hw = r;
            encode = muxctrl_reg1_muxctrl_reg1_enum;
            reset = 0x0;
        } muxctrl_reg1[0:0];
    } muxctrl_reg1 @ 0x4;

    reg {
        name = "Multiplexing control register for the VIU0_DAT13 pin";
        desc = "muxctrl_reg2 is the multiplexing control register for the VIU0_DAT13 pin (DS: VIU0_DAT13 管脚复用控制寄存器). Reset value 0 selects VIU0_DAT13.

Data sheet 2.1.5 muxctrl_reg2 (offset 0x8, printed page 2-55, `hi3516v100--Hi3516-Datasheet.txt` line 4326).";

        enum muxctrl_reg2_muxctrl_reg2_enum {
            VIU0_DAT13 = 0 { name = "Viu0 Dat13"; desc = "VIU0_DAT13"; };
            GPIO1_2 = 1 { name = "Gpio1 2"; desc = "GPIO1_2"; };
        };

        field {
            name = "muxctrl_reg2";
            desc = "Function of the VIU0_DAT13 pin (DS: VIU0_DAT13 管脚的具体复用情况).";
            sw = rw;
            hw = r;
            encode = muxctrl_reg2_muxctrl_reg2_enum;
            reset = 0x0;
        } muxctrl_reg2[0:0];
    } muxctrl_reg2 @ 0x8;

    reg {
        name = "Multiplexing control register for the VIU0_DAT12 pin";
        desc = "muxctrl_reg3 is the multiplexing control register for the VIU0_DAT12 pin (DS: VIU0_DAT12 管脚复用控制寄存器). Reset value 0 selects VIU0_DAT12.

Data sheet 2.1.5 muxctrl_reg3 (offset 0xC, printed page 2-56, `hi3516v100--Hi3516-Datasheet.txt` line 4363).";

        enum muxctrl_reg3_muxctrl_reg3_enum {
            VIU0_DAT12 = 0 { name = "Viu0 Dat12"; desc = "VIU0_DAT12"; };
            GPIO1_3 = 1 { name = "Gpio1 3"; desc = "GPIO1_3"; };
        };

        field {
            name = "muxctrl_reg3";
            desc = "Function of the VIU0_DAT12 pin (DS: VIU0_DAT12 管脚的具体复用情况).";
            sw = rw;
            hw = r;
            encode = muxctrl_reg3_muxctrl_reg3_enum;
            reset = 0x0;
        } muxctrl_reg3[0:0];
    } muxctrl_reg3 @ 0xC;

    reg {
        name = "Multiplexing control register for the VIU1_CLK pin";
        desc = "muxctrl_reg4 is the multiplexing control register for the VIU1_CLK pin (DS: VIU1_CLK 管脚复用控制寄存器). Reset value 0 selects VIU1_CLK.

Data sheet 2.1.5 muxctrl_reg4 (offset 0x10, printed page 2-56, `hi3516v100--Hi3516-Datasheet.txt` line 4391).";

        enum muxctrl_reg4_muxctrl_reg4_enum {
            VIU1_CLK = 0 { name = "Viu1 Clk"; desc = "VIU1_CLK"; };
            GPIO1_4 = 1 { name = "Gpio1 4"; desc = "GPIO1_4"; };
            VOU0_CLK = 2 { name = "Vou0 Clk"; desc = "VOU0_CLK"; };
            SDIO1_CCLK_OUT = 3 { name = "Sdio1 Cclk Out"; desc = "SDIO1_CCLK_OUT"; };
        };

        field {
            name = "muxctrl_reg4";
            desc = "Function of the VIU1_CLK pin (DS: VIU1_CLK 管脚的具体复用情况).";
            sw = rw;
            hw = r;
            encode = muxctrl_reg4_muxctrl_reg4_enum;
            reset = 0x0;
        } muxctrl_reg4[1:0];
    } muxctrl_reg4 @ 0x10;

    reg {
        name = "Multiplexing control register for the VIU1_VS pin";
        desc = "muxctrl_reg5 is the multiplexing control register for the VIU1_VS pin (DS: VIU1_VS 管脚复用控制寄存器). Reset value 0 selects VIU1_VS. Other values: reserved (其它：保留).

Data sheet 2.1.5 muxctrl_reg5 (offset 0x14, printed page 2-57, `hi3516v100--Hi3516-Datasheet.txt` line 4426).";

        enum muxctrl_reg5_muxctrl_reg5_enum {
            VIU1_VS = 0 { name = "Viu1 Vs"; desc = "VIU1_VS"; };
            GPIO1_5 = 1 { name = "Gpio1 5"; desc = "GPIO1_5"; };
            VOU0_VS = 2 { name = "Vou0 Vs"; desc = "VOU0_VS"; };
        };

        field {
            name = "muxctrl_reg5";
            desc = "Function of the VIU1_VS pin (DS: VIU1_VS 管脚的具体复用情况).";
            sw = rw;
            hw = r;
            encode = muxctrl_reg5_muxctrl_reg5_enum;
            reset = 0x0;
        } muxctrl_reg5[1:0];
    } muxctrl_reg5 @ 0x14;

    reg {
        name = "Multiplexing control register for the VIU1_HS pin";
        desc = "muxctrl_reg6 is the multiplexing control register for the VIU1_HS pin (DS: VIU1_HS 管脚复用控制寄存器). Reset value 0 selects VIU1_HS.

Data sheet 2.1.5 muxctrl_reg6 (offset 0x18, printed page 2-57, `hi3516v100--Hi3516-Datasheet.txt` line 4452).";

        enum muxctrl_reg6_muxctrl_reg6_enum {
            VIU1_HS = 0 { name = "Viu1 Hs"; desc = "VIU1_HS"; };
            GPIO1_6 = 1 { name = "Gpio1 6"; desc = "GPIO1_6"; };
            VOU0_HS = 2 { name = "Vou0 Hs"; desc = "VOU0_HS"; };
            SDIO1_CWPR = 3 { name = "Sdio1 Cwpr"; desc = "SDIO1_CWPR"; };
        };

        field {
            name = "muxctrl_reg6";
            desc = "Function of the VIU1_HS pin (DS: VIU1_HS 管脚的具体复用情况).";
            sw = rw;
            hw = r;
            encode = muxctrl_reg6_muxctrl_reg6_enum;
            reset = 0x0;
        } muxctrl_reg6[1:0];
    } muxctrl_reg6 @ 0x18;

    reg {
        name = "Multiplexing control register for the VIU1_DAT15 pin";
        desc = "muxctrl_reg7 is the multiplexing control register for the VIU1_DAT15 pin (DS: VIU1_DAT15 管脚复用控制寄存器). Reset value 0 selects VIU1_DAT15.

Data sheet 2.1.5 muxctrl_reg7 (offset 0x1C, printed page 2-58, `hi3516v100--Hi3516-Datasheet.txt` line 4486).";

        enum muxctrl_reg7_muxctrl_reg7_enum {
            VIU1_DAT15 = 0 { name = "Viu1 Dat15"; desc = "VIU1_DAT15"; };
            GPIO1_7 = 1 { name = "Gpio1 7"; desc = "GPIO1_7"; };
            VOU0_DATA15 = 2 { name = "Vou0 Data15"; desc = "VOU0_DATA15"; };
            SDIO1_CARD_POWER = 3 { name = "Sdio1 Card Power"; desc = "SDIO1_CARD_POWER_EN"; };
        };

        field {
            name = "muxctrl_reg7";
            desc = "Function of the VIU1_DAT15 pin (DS: VIU1_DAT15 管脚的具体复用情况).";
            sw = rw;
            hw = r;
            encode = muxctrl_reg7_muxctrl_reg7_enum;
            reset = 0x0;
        } muxctrl_reg7[1:0];
    } muxctrl_reg7 @ 0x1C;

    reg {
        name = "Multiplexing control register for the VIU1_DAT14 pin";
        desc = "muxctrl_reg8 is the multiplexing control register for the VIU1_DAT14 pin (DS: VIU1_DAT14 管脚复用控制寄存器). Reset value 0 selects VIU1_DAT14.

Data sheet 2.1.5 muxctrl_reg8 (offset 0x20, printed page 2-58, `hi3516v100--Hi3516-Datasheet.txt` line 4512).";

        enum muxctrl_reg8_muxctrl_reg8_enum {
            VIU1_DAT14 = 0 { name = "Viu1 Dat14"; desc = "VIU1_DAT14"; };
            GPIO2_0 = 1 { name = "Gpio2 0"; desc = "GPIO2_0"; };
            VOU0_DATA14 = 2 { name = "Vou0 Data14"; desc = "VOU0_DATA14"; };
            SDIO1_CARD_DETECT = 3 { name = "Sdio1 Card Detect"; desc = "SDIO1_CARD_DETECT"; };
        };

        field {
            name = "muxctrl_reg8";
            desc = "Function of the VIU1_DAT14 pin (DS: VIU1_DAT14 管脚的具体复用情况).";
            sw = rw;
            hw = r;
            encode = muxctrl_reg8_muxctrl_reg8_enum;
            reset = 0x0;
        } muxctrl_reg8[1:0];
    } muxctrl_reg8 @ 0x20;

    reg {
        name = "Multiplexing control register for the VIU1_DAT13 pin";
        desc = "muxctrl_reg9 is the multiplexing control register for the VIU1_DAT13 pin (DS: VIU1_DAT13 管脚复用控制寄存器). Reset value 0 selects VIU1_DAT13.

Data sheet 2.1.5 muxctrl_reg9 (offset 0x24, printed page 2-59, `hi3516v100--Hi3516-Datasheet.txt` line 4546).";

        enum muxctrl_reg9_muxctrl_reg9_enum {
            VIU1_DAT13 = 0 { name = "Viu1 Dat13"; desc = "VIU1_DAT13"; };
            GPIO2_1 = 1 { name = "Gpio2 1"; desc = "GPIO2_1"; };
            VOU0_DATA13 = 2 { name = "Vou0 Data13"; desc = "VOU0_DATA13"; };
            SDIO1_CCMD_ODPULLUP = 3 { name = "Sdio1 Ccmd Odpullup"; desc = "SDIO1_CCMD_ODPULLUP_EN_N"; };
        };

        field {
            name = "muxctrl_reg9";
            desc = "Function of the VIU1_DAT13 pin (DS: VIU1_DAT13 管脚的具体复用情况).";
            sw = rw;
            hw = r;
            encode = muxctrl_reg9_muxctrl_reg9_enum;
            reset = 0x0;
        } muxctrl_reg9[1:0];
    } muxctrl_reg9 @ 0x24;

    reg {
        name = "Multiplexing control register for the VIU1_DAT12 pin";
        desc = "muxctrl_reg10 is the multiplexing control register for the VIU1_DAT12 pin (DS: VIU1_DAT12 管脚复用控制寄存器). Reset value 0 selects VIU1_DAT12.

Data sheet 2.1.5 muxctrl_reg10 (offset 0x28, printed page 2-59, `hi3516v100--Hi3516-Datasheet.txt` line 4572).";

        enum muxctrl_reg10_muxctrl_reg10_enum {
            VIU1_DAT12 = 0 { name = "Viu1 Dat12"; desc = "VIU1_DAT12"; };
            GPIO2_2 = 1 { name = "Gpio2 2"; desc = "GPIO2_2"; };
            VOU0_DATA12 = 2 { name = "Vou0 Data12"; desc = "VOU0_DATA12"; };
            SDIO1_CCMD = 3 { name = "Sdio1 Ccmd"; desc = "SDIO1_CCMD"; };
        };

        field {
            name = "muxctrl_reg10";
            desc = "Function of the VIU1_DAT12 pin (DS: VIU1_DAT12 管脚的具体复用情况).";
            sw = rw;
            hw = r;
            encode = muxctrl_reg10_muxctrl_reg10_enum;
            reset = 0x0;
        } muxctrl_reg10[1:0];
    } muxctrl_reg10 @ 0x28;

    reg {
        name = "Multiplexing control register for the VIU1_DAT11 pin";
        desc = "muxctrl_reg11 is the multiplexing control register for the VIU1_DAT11 pin (DS: VIU1_DAT11 管脚复用控制寄存器). Reset value 0 selects VIU1_DAT11.

Data sheet 2.1.5 muxctrl_reg11 (offset 0x2C, printed page 2-60, `hi3516v100--Hi3516-Datasheet.txt` line 4606).";

        enum muxctrl_reg11_muxctrl_reg11_enum {
            VIU1_DAT11 = 0 { name = "Viu1 Dat11"; desc = "VIU1_DAT11"; };
            GPIO2_3 = 1 { name = "Gpio2 3"; desc = "GPIO2_3"; };
            VOU0_DATA11 = 2 { name = "Vou0 Data11"; desc = "VOU0_DATA11"; };
            SDIO1_CDATA0 = 3 { name = "Sdio1 Cdata0"; desc = "SDIO1_CDATA0"; };
        };

        field {
            name = "muxctrl_reg11";
            desc = "Function of the VIU1_DAT11 pin (DS: VIU1_DAT11 管脚的具体复用情况).";
            sw = rw;
            hw = r;
            encode = muxctrl_reg11_muxctrl_reg11_enum;
            reset = 0x0;
        } muxctrl_reg11[1:0];
    } muxctrl_reg11 @ 0x2C;

    reg {
        name = "Multiplexing control register for the VIU1_DAT10 pin";
        desc = "muxctrl_reg12 is the multiplexing control register for the VIU1_DAT10 pin (DS: VIU1_DAT10 管脚复用控制寄存器). Reset value 0 selects VIU1_DAT10.

Data sheet 2.1.5 muxctrl_reg12 (offset 0x30, printed page 2-60, `hi3516v100--Hi3516-Datasheet.txt` line 4632).";

        enum muxctrl_reg12_muxctrl_reg12_enum {
            VIU1_DAT10 = 0 { name = "Viu1 Dat10"; desc = "VIU1_DAT10"; };
            GPIO2_4 = 1 { name = "Gpio2 4"; desc = "GPIO2_4"; };
            VOU0_DATA10 = 2 { name = "Vou0 Data10"; desc = "VOU0_DATA10"; };
            SDIO1_CDATA1 = 3 { name = "Sdio1 Cdata1"; desc = "SDIO1_CDATA1"; };
        };

        field {
            name = "muxctrl_reg12";
            desc = "Function of the VIU1_DAT10 pin (DS: VIU1_DAT10 管脚的具体复用情况).";
            sw = rw;
            hw = r;
            encode = muxctrl_reg12_muxctrl_reg12_enum;
            reset = 0x0;
        } muxctrl_reg12[1:0];
    } muxctrl_reg12 @ 0x30;

    reg {
        name = "Multiplexing control register for the VIU1_DAT9 pin";
        desc = "muxctrl_reg13 is the multiplexing control register for the VIU1_DAT9 pin (DS: VIU1_DAT9 管脚复用控制寄存器). Reset value 0 selects VIU1_DAT9.

Data sheet 2.1.5 muxctrl_reg13 (offset 0x34, printed page 2-61, `hi3516v100--Hi3516-Datasheet.txt` line 4666).";

        enum muxctrl_reg13_muxctrl_reg13_enum {
            VIU1_DAT9 = 0 { name = "Viu1 Dat9"; desc = "VIU1_DAT9"; };
            GPIO2_5 = 1 { name = "Gpio2 5"; desc = "GPIO2_5"; };
            VOU0_DATA9 = 2 { name = "Vou0 Data9"; desc = "VOU0_DATA9"; };
            SDIO1_CDATA2 = 3 { name = "Sdio1 Cdata2"; desc = "SDIO1_CDATA2"; };
        };

        field {
            name = "muxctrl_reg13";
            desc = "Function of the VIU1_DAT9 pin (DS: VIU1_DAT9 管脚的具体复用情况).";
            sw = rw;
            hw = r;
            encode = muxctrl_reg13_muxctrl_reg13_enum;
            reset = 0x0;
        } muxctrl_reg13[1:0];
    } muxctrl_reg13 @ 0x34;

    reg {
        name = "Multiplexing control register for the VIU1_DAT8 pin";
        desc = "muxctrl_reg14 is the multiplexing control register for the VIU1_DAT8 pin (DS: VIU1_DAT8 管脚复用控制寄存器). Reset value 0 selects VIU1_DAT8.

Data sheet 2.1.5 muxctrl_reg14 (offset 0x38, printed page 2-61, `hi3516v100--Hi3516-Datasheet.txt` line 4692).";

        enum muxctrl_reg14_muxctrl_reg14_enum {
            VIU1_DAT8 = 0 { name = "Viu1 Dat8"; desc = "VIU1_DAT8"; };
            GPIO2_6 = 1 { name = "Gpio2 6"; desc = "GPIO2_6"; };
            VOU0_DATA8 = 2 { name = "Vou0 Data8"; desc = "VOU0_DATA8"; };
            SDIO1_CDATA3 = 3 { name = "Sdio1 Cdata3"; desc = "SDIO1_CDATA3"; };
        };

        field {
            name = "muxctrl_reg14";
            desc = "Function of the VIU1_DAT8 pin (DS: VIU1_DAT8 管脚的具体复用情况).";
            sw = rw;
            hw = r;
            encode = muxctrl_reg14_muxctrl_reg14_enum;
            reset = 0x0;
        } muxctrl_reg14[1:0];
    } muxctrl_reg14 @ 0x38;

    reg {
        name = "Multiplexing control register for the VIU1_DAT7 pin";
        desc = "muxctrl_reg15 is the multiplexing control register for the VIU1_DAT7 pin (DS: VIU1_DAT7 管脚复用控制寄存器). Reset value 0 selects VIU1_DAT7.

Data sheet 2.1.5 muxctrl_reg15 (offset 0x3C, printed page 2-62, `hi3516v100--Hi3516-Datasheet.txt` line 4726).";

        enum muxctrl_reg15_muxctrl_reg15_enum {
            VIU1_DAT7 = 0 { name = "Viu1 Dat7"; desc = "VIU1_DAT7"; };
            GPIO2_7 = 1 { name = "Gpio2 7"; desc = "GPIO2_7"; };
            VOU0_DATA7 = 2 { name = "Vou0 Data7"; desc = "VOU0_DATA7"; };
            SDIO1_CDATA4 = 3 { name = "Sdio1 Cdata4"; desc = "SDIO1_CDATA4"; };
        };

        field {
            name = "muxctrl_reg15";
            desc = "Function of the VIU1_DAT7 pin (DS: VIU1_DAT7 管脚的具体复用情况).";
            sw = rw;
            hw = r;
            encode = muxctrl_reg15_muxctrl_reg15_enum;
            reset = 0x0;
        } muxctrl_reg15[1:0];
    } muxctrl_reg15 @ 0x3C;

    reg {
        name = "Multiplexing control register for the VIU1_DAT6 pin";
        desc = "muxctrl_reg16 is the multiplexing control register for the VIU1_DAT6 pin (DS: VIU1_DAT6 管脚复用控制寄存器). Reset value 0 selects VIU1_DAT6.

Data sheet 2.1.5 muxctrl_reg16 (offset 0x40, printed page 2-62, `hi3516v100--Hi3516-Datasheet.txt` line 4752).";

        enum muxctrl_reg16_muxctrl_reg16_enum {
            VIU1_DAT6 = 0 { name = "Viu1 Dat6"; desc = "VIU1_DAT6"; };
            GPIO3_0 = 1 { name = "Gpio3 0"; desc = "GPIO3_0"; };
            VOU0_DATA6 = 2 { name = "Vou0 Data6"; desc = "VOU0_DATA6"; };
            SDIO1_CDATA5 = 3 { name = "Sdio1 Cdata5"; desc = "SDIO1_CDATA5"; };
        };

        field {
            name = "muxctrl_reg16";
            desc = "Function of the VIU1_DAT6 pin (DS: VIU1_DAT6 管脚的具体复用情况).";
            sw = rw;
            hw = r;
            encode = muxctrl_reg16_muxctrl_reg16_enum;
            reset = 0x0;
        } muxctrl_reg16[1:0];
    } muxctrl_reg16 @ 0x40;

    reg {
        name = "Multiplexing control register for the VIU1_DAT5 pin";
        desc = "muxctrl_reg17 is the multiplexing control register for the VIU1_DAT5 pin (DS: VIU1_DAT5 管脚复用控制寄存器). Reset value 0 selects VIU1_DAT5.

Data sheet 2.1.5 muxctrl_reg17 (offset 0x44, printed page 2-63, `hi3516v100--Hi3516-Datasheet.txt` line 4786).";

        enum muxctrl_reg17_muxctrl_reg17_enum {
            VIU1_DAT5 = 0 { name = "Viu1 Dat5"; desc = "VIU1_DAT5"; };
            GPIO3_1 = 1 { name = "Gpio3 1"; desc = "GPIO3_1"; };
            VOU0_DATA5 = 2 { name = "Vou0 Data5"; desc = "VOU0_DATA5"; };
            SDIO1_CDATA6 = 3 { name = "Sdio1 Cdata6"; desc = "SDIO1_CDATA6"; };
        };

        field {
            name = "muxctrl_reg17";
            desc = "Function of the VIU1_DAT5 pin (DS: VIU1_DAT5 管脚的具体复用情况).";
            sw = rw;
            hw = r;
            encode = muxctrl_reg17_muxctrl_reg17_enum;
            reset = 0x0;
        } muxctrl_reg17[1:0];
    } muxctrl_reg17 @ 0x44;

    reg {
        name = "Multiplexing control register for the VIU1_DAT4 pin";
        desc = "muxctrl_reg18 is the multiplexing control register for the VIU1_DAT4 pin (DS: VIU1_DAT4 管脚复用控制寄存器). Reset value 0 selects VIU1_DAT4.

Data sheet 2.1.5 muxctrl_reg18 (offset 0x48, printed page 2-63, `hi3516v100--Hi3516-Datasheet.txt` line 4812).";

        enum muxctrl_reg18_muxctrl_reg18_enum {
            VIU1_DAT4 = 0 { name = "Viu1 Dat4"; desc = "VIU1_DAT4"; };
            GPIO3_2 = 1 { name = "Gpio3 2"; desc = "GPIO3_2"; };
            VOU0_DATA4 = 2 { name = "Vou0 Data4"; desc = "VOU0_DATA4"; };
            SDIO1_CDATA7 = 3 { name = "Sdio1 Cdata7"; desc = "SDIO1_CDATA7"; };
        };

        field {
            name = "muxctrl_reg18";
            desc = "Function of the VIU1_DAT4 pin (DS: VIU1_DAT4 管脚的具体复用情况).";
            sw = rw;
            hw = r;
            encode = muxctrl_reg18_muxctrl_reg18_enum;
            reset = 0x0;
        } muxctrl_reg18[1:0];
    } muxctrl_reg18 @ 0x48;

    reg {
        name = "Multiplexing control register for the VIU1_DAT3 pin";
        desc = "muxctrl_reg19 is the multiplexing control register for the VIU1_DAT3 pin (DS: VIU1_DAT3 管脚复用控制寄存器). Reset value 0 selects VIU1_DAT3. Other values: reserved (其它：保留).

Data sheet 2.1.5 muxctrl_reg19 (offset 0x4C, printed page 2-64, `hi3516v100--Hi3516-Datasheet.txt` line 4846).";

        enum muxctrl_reg19_muxctrl_reg19_enum {
            VIU1_DAT3 = 0 { name = "Viu1 Dat3"; desc = "VIU1_DAT3"; };
            GPIO3_3 = 1 { name = "Gpio3 3"; desc = "GPIO3_3"; };
            VOU0_DATA3 = 2 { name = "Vou0 Data3"; desc = "VOU0_DATA3"; };
        };

        field {
            name = "muxctrl_reg19";
            desc = "Function of the VIU1_DAT3 pin (DS: VIU1_DAT3 管脚的具体复用情况).";
            sw = rw;
            hw = r;
            encode = muxctrl_reg19_muxctrl_reg19_enum;
            reset = 0x0;
        } muxctrl_reg19[1:0];
    } muxctrl_reg19 @ 0x4C;

    reg {
        name = "Multiplexing control register for the VIU1_DAT2 pin";
        desc = "muxctrl_reg20 is the multiplexing control register for the VIU1_DAT2 pin (DS: VIU1_DAT2 管脚复用控制寄存器). Reset value 0 selects VIU1_DAT2. Other values: reserved (其它：保留).

Data sheet 2.1.5 muxctrl_reg20 (offset 0x50, printed page 2-64, `hi3516v100--Hi3516-Datasheet.txt` line 4872).";

        enum muxctrl_reg20_muxctrl_reg20_enum {
            VIU1_DAT2 = 0 { name = "Viu1 Dat2"; desc = "VIU1_DAT2"; };
            GPIO3_4 = 1 { name = "Gpio3 4"; desc = "GPIO3_4"; };
            VOU0_DATA2 = 2 { name = "Vou0 Data2"; desc = "VOU0_DATA2"; };
        };

        field {
            name = "muxctrl_reg20";
            desc = "Function of the VIU1_DAT2 pin (DS: VIU1_DAT2 管脚的具体复用情况).";
            sw = rw;
            hw = r;
            encode = muxctrl_reg20_muxctrl_reg20_enum;
            reset = 0x0;
        } muxctrl_reg20[1:0];
    } muxctrl_reg20 @ 0x50;

    reg {
        name = "Multiplexing control register for the VIU1_DAT1 pin";
        desc = "muxctrl_reg21 is the multiplexing control register for the VIU1_DAT1 pin (DS: VIU1_DAT1 管脚复用控制寄存器). Reset value 0 selects VIU1_DAT1. Other values: reserved (其它：保留).

Data sheet 2.1.5 muxctrl_reg21 (offset 0x54, printed page 2-65, `hi3516v100--Hi3516-Datasheet.txt` line 4906).";

        enum muxctrl_reg21_muxctrl_reg21_enum {
            VIU1_DAT1 = 0 { name = "Viu1 Dat1"; desc = "VIU1_DAT1"; };
            GPIO3_5 = 1 { name = "Gpio3 5"; desc = "GPIO3_5"; };
            VOU0_DATA1 = 2 { name = "Vou0 Data1"; desc = "VOU0_DATA1"; };
        };

        field {
            name = "muxctrl_reg21";
            desc = "Function of the VIU1_DAT1 pin (DS: VIU1_DAT1 管脚的具体复用情况).";
            sw = rw;
            hw = r;
            encode = muxctrl_reg21_muxctrl_reg21_enum;
            reset = 0x0;
        } muxctrl_reg21[1:0];
    } muxctrl_reg21 @ 0x54;

    reg {
        name = "Multiplexing control register for the VIU1_DAT0 pin";
        desc = "muxctrl_reg22 is the multiplexing control register for the VIU1_DAT0 pin (DS: VIU1_DAT0 管脚复用控制寄存器). Reset value 0 selects VIU1_DAT0. Other values: reserved (其它：保留).

Data sheet 2.1.5 muxctrl_reg22 (offset 0x58, printed page 2-65, `hi3516v100--Hi3516-Datasheet.txt` line 4932).";

        enum muxctrl_reg22_muxctrl_reg22_enum {
            VIU1_DAT0 = 0 { name = "Viu1 Dat0"; desc = "VIU1_DAT0"; };
            GPIO3_6 = 1 { name = "Gpio3 6"; desc = "GPIO3_6"; };
            VOU0_DATA0 = 2 { name = "Vou0 Data0"; desc = "VOU0_DATA0"; };
        };

        field {
            name = "muxctrl_reg22";
            desc = "Function of the VIU1_DAT0 pin (DS: VIU1_DAT0 管脚的具体复用情况).";
            sw = rw;
            hw = r;
            encode = muxctrl_reg22_muxctrl_reg22_enum;
            reset = 0x0;
        } muxctrl_reg22[1:0];
    } muxctrl_reg22 @ 0x58;

    reg {
        name = "Multiplexing control register for the SIO0_MCLK pin";
        desc = "muxctrl_reg23 is the multiplexing control register for the SIO0_MCLK pin (DS: SIO0_MCLK 管脚复用控制寄存器). Reset value 0 selects GPIO3_7.

Data sheet 2.1.5 muxctrl_reg23 (offset 0x5C, printed page 2-66, `hi3516v100--Hi3516-Datasheet.txt` line 4966).";

        enum muxctrl_reg23_muxctrl_reg23_enum {
            GPIO3_7 = 0 { name = "Gpio3 7"; desc = "GPIO3_7"; };
            SIO0_MCLK = 1 { name = "Sio0 Mclk"; desc = "SIO0_MCLK"; };
        };

        field {
            name = "muxctrl_reg23";
            desc = "Function of the SIO0_MCLK pin (DS: SIO0_MCLK 管脚的具体复用情况).";
            sw = rw;
            hw = r;
            encode = muxctrl_reg23_muxctrl_reg23_enum;
            reset = 0x0;
        } muxctrl_reg23[0:0];
    } muxctrl_reg23 @ 0x5C;

    reg {
        name = "Multiplexing control register for the SIO0_XCLK pin";
        desc = "muxctrl_reg24 is the multiplexing control register for the SIO0_XCLK pin (DS: SIO0_XCLK 管脚复用控制寄存器). Reset value 0 selects GPIO4_0. Other values: reserved (其它：保留).

Data sheet 2.1.5 muxctrl_reg24 (offset 0x60, printed page 2-66, `hi3516v100--Hi3516-Datasheet.txt` line 4990).";

        enum muxctrl_reg24_muxctrl_reg24_enum {
            GPIO4_0 = 0 { name = "Gpio4 0"; desc = "GPIO4_0"; };
            SIO0_XCLK = 1 { name = "Sio0 Xclk"; desc = "SIO0_XCLK"; };
            SPI1_SCLK = 2 { name = "Spi1 Sclk"; desc = "SPI1_SCLK"; };
        };

        field {
            name = "muxctrl_reg24";
            desc = "Function of the SIO0_XCLK pin (DS: SIO0_XCLK 管脚的具体复用情况).";
            sw = rw;
            hw = r;
            encode = muxctrl_reg24_muxctrl_reg24_enum;
            reset = 0x0;
        } muxctrl_reg24[1:0];
    } muxctrl_reg24 @ 0x60;

    reg {
        name = "Multiplexing control register for the SIO0_XFS pin";
        desc = "muxctrl_reg25 is the multiplexing control register for the SIO0_XFS pin (DS: SIO0_XFS 管脚复用控制寄存器). Reset value 0 selects GPIO4_1. Other values: reserved (其它：保留).

Data sheet 2.1.5 muxctrl_reg25 (offset 0x64, printed page 2-67, `hi3516v100--Hi3516-Datasheet.txt` line 5025).";

        enum muxctrl_reg25_muxctrl_reg25_enum {
            GPIO4_1 = 0 { name = "Gpio4 1"; desc = "GPIO4_1"; };
            SIO0_XFS = 1 { name = "Sio0 Xfs"; desc = "SIO0_XFS"; };
            SPI1_CSN0 = 2 { name = "Spi1 Csn0"; desc = "SPI1_CSN0"; };
        };

        field {
            name = "muxctrl_reg25";
            desc = "Function of the SIO0_XFS pin (DS: SIO0_XFS 管脚的具体复用情况).";
            sw = rw;
            hw = r;
            encode = muxctrl_reg25_muxctrl_reg25_enum;
            reset = 0x0;
        } muxctrl_reg25[1:0];
    } muxctrl_reg25 @ 0x64;

    reg {
        name = "Multiplexing control register for the SIO0_RCLK pin";
        desc = "muxctrl_reg26 is the multiplexing control register for the SIO0_RCLK pin (DS: SIO0_RCLK 管脚复用控制寄存器). Reset value 0 selects GPIO4_2.

Data sheet 2.1.5 muxctrl_reg26 (offset 0x68, printed page 2-67, `hi3516v100--Hi3516-Datasheet.txt` line 5051).";

        enum muxctrl_reg26_muxctrl_reg26_enum {
            GPIO4_2 = 0 { name = "Gpio4 2"; desc = "GPIO4_2"; };
            SIO0_RCLK = 1 { name = "Sio0 Rclk"; desc = "SIO0_RCLK"; };
        };

        field {
            name = "muxctrl_reg26";
            desc = "Function of the SIO0_RCLK pin (DS: SIO0_RCLK 管脚的具体复用情况).";
            sw = rw;
            hw = r;
            encode = muxctrl_reg26_muxctrl_reg26_enum;
            reset = 0x0;
        } muxctrl_reg26[0:0];
    } muxctrl_reg26 @ 0x68;

    reg {
        name = "Multiplexing control register for the SIO0_RFS pin";
        desc = "muxctrl_reg27 is the multiplexing control register for the SIO0_RFS pin (DS: SIO0_RFS 管脚复用控制寄存器). Reset value 0 selects GPIO4_3.

Data sheet 2.1.5 muxctrl_reg27 (offset 0x6C, printed page 2-68, `hi3516v100--Hi3516-Datasheet.txt` line 5088).";

        enum muxctrl_reg27_muxctrl_reg27_enum {
            GPIO4_3 = 0 { name = "Gpio4 3"; desc = "GPIO4_3"; };
            SIO0_RFS = 1 { name = "Sio0 Rfs"; desc = "SIO0_RFS"; };
        };

        field {
            name = "muxctrl_reg27";
            desc = "Function of the SIO0_RFS pin (DS: SIO0_RFS 管脚的具体复用情况).";
            sw = rw;
            hw = r;
            encode = muxctrl_reg27_muxctrl_reg27_enum;
            reset = 0x0;
        } muxctrl_reg27[0:0];
    } muxctrl_reg27 @ 0x6C;

    reg {
        name = "Multiplexing control register for the SIO0_DOUT pin";
        desc = "muxctrl_reg28 is the multiplexing control register for the SIO0_DOUT pin (DS: SIO0_DOUT 管脚复用控制寄存器). Reset value 0 selects GPIO4_4. Other values: reserved (其它：保留).

Data sheet 2.1.5 muxctrl_reg28 (offset 0x70, printed page 2-68, `hi3516v100--Hi3516-Datasheet.txt` line 5116).";

        enum muxctrl_reg28_muxctrl_reg28_enum {
            GPIO4_4 = 0 { name = "Gpio4 4"; desc = "GPIO4_4"; };
            SIO0_DOUT = 1 { name = "Sio0 Dout"; desc = "SIO0_DOUT"; };
            SPI1_SDO = 2 { name = "Spi1 Sdo"; desc = "SPI1_SDO"; };
        };

        field {
            name = "muxctrl_reg28";
            desc = "Function of the SIO0_DOUT pin (DS: SIO0_DOUT 管脚的具体复用情况).";
            sw = rw;
            hw = r;
            encode = muxctrl_reg28_muxctrl_reg28_enum;
            reset = 0x0;
        } muxctrl_reg28[1:0];
    } muxctrl_reg28 @ 0x70;

    reg {
        name = "Multiplexing control register for the SIO0_DIN pin";
        desc = "muxctrl_reg29 is the multiplexing control register for the SIO0_DIN pin (DS: SIO0_DIN 管脚复用控制寄存器). Reset value 0 selects GPIO4_5. Other values: reserved (其它：保留).

Data sheet 2.1.5 muxctrl_reg29 (offset 0x74, printed page 2-69, `hi3516v100--Hi3516-Datasheet.txt` line 5151).";

        enum muxctrl_reg29_muxctrl_reg29_enum {
            GPIO4_5 = 0 { name = "Gpio4 5"; desc = "GPIO4_5"; };
            SIO0_DIN = 1 { name = "Sio0 Din"; desc = "SIO0_DIN"; };
            SPI1_SDI = 2 { name = "Spi1 Sdi"; desc = "SPI1_SDI"; };
        };

        field {
            name = "muxctrl_reg29";
            desc = "Function of the SIO0_DIN pin (DS: SIO0_DIN 管脚的具体复用情况).";
            sw = rw;
            hw = r;
            encode = muxctrl_reg29_muxctrl_reg29_enum;
            reset = 0x0;
        } muxctrl_reg29[1:0];
    } muxctrl_reg29 @ 0x74;

    reg {
        name = "Multiplexing control register for the SPI0_SCLK pin";
        desc = "muxctrl_reg30 is the multiplexing control register for the SPI0_SCLK pin (DS: SPI0_SCLK 管脚复用控制寄存器). Reset value 0 selects GPIO4_6.

Data sheet 2.1.5 muxctrl_reg30 (offset 0x78, printed page 2-69, `hi3516v100--Hi3516-Datasheet.txt` line 5177).";

        enum muxctrl_reg30_muxctrl_reg30_enum {
            GPIO4_6 = 0 { name = "Gpio4 6"; desc = "GPIO4_6"; };
            SPI0_SCLK = 1 { name = "Spi0 Sclk"; desc = "SPI0_SCLK"; };
        };

        field {
            name = "muxctrl_reg30";
            desc = "Function of the SPI0_SCLK pin (DS: SPI0_SCLK 管脚的具体复用情况).";
            sw = rw;
            hw = r;
            encode = muxctrl_reg30_muxctrl_reg30_enum;
            reset = 0x0;
        } muxctrl_reg30[0:0];
    } muxctrl_reg30 @ 0x78;

    reg {
        name = "Multiplexing control register for the SPI0_SDO pin";
        desc = "muxctrl_reg31 is the multiplexing control register for the SPI0_SDO pin (DS: SPI0_SDO 管脚复用控制寄存器). Reset value 0 selects GPIO4_7.

Data sheet 2.1.5 muxctrl_reg31 (offset 0x7C, printed page 2-70, `hi3516v100--Hi3516-Datasheet.txt` line 5210).";

        enum muxctrl_reg31_muxctrl_reg31_enum {
            GPIO4_7 = 0 { name = "Gpio4 7"; desc = "GPIO4_7"; };
            SPI0_SDO = 1 { name = "Spi0 Sdo"; desc = "SPI0_SDO"; };
        };

        field {
            name = "muxctrl_reg31";
            desc = "Function of the SPI0_SDO pin (DS: SPI0_SDO 管脚的具体复用情况).";
            sw = rw;
            hw = r;
            encode = muxctrl_reg31_muxctrl_reg31_enum;
            reset = 0x0;
        } muxctrl_reg31[0:0];
    } muxctrl_reg31 @ 0x7C;

    reg {
        name = "Multiplexing control register for the SPI0_SDI pin";
        desc = "muxctrl_reg32 is the multiplexing control register for the SPI0_SDI pin (DS: SPI0_SDI 管脚复用控制寄存器). Reset value 0 selects GPIO5_0.

Data sheet 2.1.5 muxctrl_reg32 (offset 0x80, printed page 2-70, `hi3516v100--Hi3516-Datasheet.txt` line 5237).";

        enum muxctrl_reg32_muxctrl_reg32_enum {
            GPIO5_0 = 0 { name = "Gpio5 0"; desc = "GPIO5_0"; };
            SPI0_SDI = 1 { name = "Spi0 Sdi"; desc = "SPI0_SDI"; };
        };

        field {
            name = "muxctrl_reg32";
            desc = "Function of the SPI0_SDI pin (DS: SPI0_SDI 管脚的具体复用情况).";
            sw = rw;
            hw = r;
            encode = muxctrl_reg32_muxctrl_reg32_enum;
            reset = 0x0;
        } muxctrl_reg32[0:0];
    } muxctrl_reg32 @ 0x80;

    reg {
        name = "Multiplexing control register for the SPI0_CSN0 pin";
        desc = "muxctrl_reg33 is the multiplexing control register for the SPI0_CSN0 pin (DS: SPI0_CSN0 管脚复用控制寄存器). Reset value 0 selects GPIO5_1.

Data sheet 2.1.5 muxctrl_reg33 (offset 0x84, printed page 2-71, `hi3516v100--Hi3516-Datasheet.txt` line 5274).";

        enum muxctrl_reg33_muxctrl_reg33_enum {
            GPIO5_1 = 0 { name = "Gpio5 1"; desc = "GPIO5_1"; };
            SPI0_CSN0 = 1 { name = "Spi0 Csn0"; desc = "SPI0_CSN0"; };
        };

        field {
            name = "muxctrl_reg33";
            desc = "Function of the SPI0_CSN0 pin (DS: SPI0_CSN0 管脚的具体复用情况).";
            sw = rw;
            hw = r;
            encode = muxctrl_reg33_muxctrl_reg33_enum;
            reset = 0x0;
        } muxctrl_reg33[0:0];
    } muxctrl_reg33 @ 0x84;

    reg {
        name = "Multiplexing control register for the SPI0_CSN1 pin";
        desc = "muxctrl_reg34 is the multiplexing control register for the SPI0_CSN1 pin (DS: SPI0_CSN1 管脚复用控制寄存器). Reset value 0 selects GPIO5_2. Other values: reserved (其它：保留).

Data sheet 2.1.5 muxctrl_reg34 (offset 0x88, printed page 2-71, `hi3516v100--Hi3516-Datasheet.txt` line 5302).";

        enum muxctrl_reg34_muxctrl_reg34_enum {
            GPIO5_2 = 0 { name = "Gpio5 2"; desc = "GPIO5_2"; };
            SPI0_CSN1 = 1 { name = "Spi0 Csn1"; desc = "SPI0_CSN1"; };
            VOU0_DV = 2 { name = "Vou0 Dv"; desc = "VOU0_DV"; };
        };

        field {
            name = "muxctrl_reg34";
            desc = "Function of the SPI0_CSN1 pin (DS: SPI0_CSN1 管脚的具体复用情况).";
            sw = rw;
            hw = r;
            encode = muxctrl_reg34_muxctrl_reg34_enum;
            reset = 0x0;
        } muxctrl_reg34[1:0];
    } muxctrl_reg34 @ 0x88;

    reg {
        name = "Multiplexing control register for the I2C_SDA pin";
        desc = "muxctrl_reg35 is the multiplexing control register for the I2C_SDA pin (DS: I2C_SDA 管脚复用控制寄存器). Reset value 0 selects GPIO5_3.

Data sheet 2.1.5 muxctrl_reg35 (offset 0x8C, printed page 2-72, `hi3516v100--Hi3516-Datasheet.txt` line 5337).";

        enum muxctrl_reg35_muxctrl_reg35_enum {
            GPIO5_3 = 0 { name = "Gpio5 3"; desc = "GPIO5_3"; };
            I2C_SDA = 1 { name = "I2C Sda"; desc = "I2C_SDA"; };
        };

        field {
            name = "muxctrl_reg35";
            desc = "Function of the I2C_SDA pin (DS: I2C_SDA 管脚的具体复用情况).";
            sw = rw;
            hw = r;
            encode = muxctrl_reg35_muxctrl_reg35_enum;
            reset = 0x0;
        } muxctrl_reg35[0:0];
    } muxctrl_reg35 @ 0x8C;

    reg {
        name = "Multiplexing control register for the I2C_SCL pin";
        desc = "muxctrl_reg36 is the multiplexing control register for the I2C_SCL pin (DS: I2C_SCL 管脚复用控制寄存器). Reset value 0 selects GPIO5_4.

Data sheet 2.1.5 muxctrl_reg36 (offset 0x90, printed page 2-72, `hi3516v100--Hi3516-Datasheet.txt` line 5364).";

        enum muxctrl_reg36_muxctrl_reg36_enum {
            GPIO5_4 = 0 { name = "Gpio5 4"; desc = "GPIO5_4"; };
            I2C_SCL = 1 { name = "I2C Scl"; desc = "I2C_SCL"; };
        };

        field {
            name = "muxctrl_reg36";
            desc = "Function of the I2C_SCL pin (DS: I2C_SCL 管脚的具体复用情况).";
            sw = rw;
            hw = r;
            encode = muxctrl_reg36_muxctrl_reg36_enum;
            reset = 0x0;
        } muxctrl_reg36[0:0];
    } muxctrl_reg36 @ 0x90;

    reg {
        name = "Multiplexing control register for the UART1_RTSN pin";
        desc = "muxctrl_reg37 is the multiplexing control register for the UART1_RTSN pin (DS: UART1_RTSN 管脚复用控制寄存器). Reset value 0 selects GPIO5_5.

Data sheet 2.1.5 muxctrl_reg37 (offset 0x94, printed page 2-73, `hi3516v100--Hi3516-Datasheet.txt` line 5401).";

        enum muxctrl_reg37_muxctrl_reg37_enum {
            GPIO5_5 = 0 { name = "Gpio5 5"; desc = "GPIO5_5"; };
            UART1_RTSN = 1 { name = "Uart1 Rtsn"; desc = "UART1_RTSN"; };
        };

        field {
            name = "muxctrl_reg37";
            desc = "Function of the UART1_RTSN pin (DS: UART1_RTSN 管脚的具体复用情况).";
            sw = rw;
            hw = r;
            encode = muxctrl_reg37_muxctrl_reg37_enum;
            reset = 0x0;
        } muxctrl_reg37[0:0];
    } muxctrl_reg37 @ 0x94;

    reg {
        name = "Multiplexing control register for the UART1_RXD pin";
        desc = "muxctrl_reg38 is the multiplexing control register for the UART1_RXD pin (DS: UART1_RXD 管脚复用控制寄存器). Reset value 0 selects GPIO5_6.

Data sheet 2.1.5 muxctrl_reg38 (offset 0x98, printed page 2-73, `hi3516v100--Hi3516-Datasheet.txt` line 5428).";

        enum muxctrl_reg38_muxctrl_reg38_enum {
            GPIO5_6 = 0 { name = "Gpio5 6"; desc = "GPIO5_6"; };
            UART1_RXD = 1 { name = "Uart1 Rxd"; desc = "UART1_RXD"; };
        };

        field {
            name = "muxctrl_reg38";
            desc = "Function of the UART1_RXD pin (DS: UART1_RXD 管脚的具体复用情况).";
            sw = rw;
            hw = r;
            encode = muxctrl_reg38_muxctrl_reg38_enum;
            reset = 0x0;
        } muxctrl_reg38[0:0];
    } muxctrl_reg38 @ 0x98;

    reg {
        name = "Multiplexing control register for the UART1_CTSN pin";
        desc = "muxctrl_reg39 is the multiplexing control register for the UART1_CTSN pin (DS: UART1_CTSN 管脚复用控制寄存器). Reset value 0 selects GPIO5_7.

Data sheet 2.1.5 muxctrl_reg39 (offset 0x9C, printed page 2-74, `hi3516v100--Hi3516-Datasheet.txt` line 5464).";

        enum muxctrl_reg39_muxctrl_reg39_enum {
            GPIO5_7 = 0 { name = "Gpio5 7"; desc = "GPIO5_7"; };
            UART1_CTSN = 1 { name = "Uart1 Ctsn"; desc = "UART1_CTSN"; };
        };

        field {
            name = "muxctrl_reg39";
            desc = "Function of the UART1_CTSN pin (DS: UART1_CTSN 管脚的具体复用情况).";
            sw = rw;
            hw = r;
            encode = muxctrl_reg39_muxctrl_reg39_enum;
            reset = 0x0;
        } muxctrl_reg39[0:0];
    } muxctrl_reg39 @ 0x9C;

    reg {
        name = "Multiplexing control register for the UART1_TXD pin";
        desc = "muxctrl_reg40 is the multiplexing control register for the UART1_TXD pin (DS: UART1_TXD 管脚复用控制寄存器). Reset value 0 selects GPIO6_0.

Data sheet 2.1.5 muxctrl_reg40 (offset 0xA0, printed page 2-74, `hi3516v100--Hi3516-Datasheet.txt` line 5491).";

        enum muxctrl_reg40_muxctrl_reg40_enum {
            GPIO6_0 = 0 { name = "Gpio6 0"; desc = "GPIO6_0"; };
            UART1_TXD = 1 { name = "Uart1 Txd"; desc = "UART1_TXD"; };
        };

        field {
            name = "muxctrl_reg40";
            desc = "Function of the UART1_TXD pin (DS: UART1_TXD 管脚的具体复用情况).";
            sw = rw;
            hw = r;
            encode = muxctrl_reg40_muxctrl_reg40_enum;
            reset = 0x0;
        } muxctrl_reg40[0:0];
    } muxctrl_reg40 @ 0xA0;

    reg {
        name = "Multiplexing control register for the RGMII_TXCKOUT pin";
        desc = "muxctrl_reg41 is the multiplexing control register for the RGMII_TXCKOUT pin (DS: RGMII_TXCKOUT 管脚复用控制寄存器). Reset value 0 selects GPIO6_1.

Data sheet 2.1.5 muxctrl_reg41 (offset 0xA4, printed page 2-75, `hi3516v100--Hi3516-Datasheet.txt` line 5528).";

        enum muxctrl_reg41_muxctrl_reg41_enum {
            GPIO6_1 = 0 { name = "Gpio6 1"; desc = "GPIO6_1"; };
            RGMII_TXCKOUT = 1 { name = "Rgmii Txckout"; desc = "RGMII_TXCKOUT"; };
        };

        field {
            name = "muxctrl_reg41";
            desc = "Function of the RGMII_TXCKOUT pin (DS: RGMII_TXCKOUT 管脚的具体复用情况).";
            sw = rw;
            hw = r;
            encode = muxctrl_reg41_muxctrl_reg41_enum;
            reset = 0x0;
        } muxctrl_reg41[0:0];
    } muxctrl_reg41 @ 0xA4;

    reg {
        name = "Multiplexing control register for the RGMII_CRS pin";
        desc = "muxctrl_reg42 is the multiplexing control register for the RGMII_CRS pin (DS: RGMII_CRS 管脚复用控制寄存器). Reset value 0 selects RGMII_CRS.

Data sheet 2.1.5 muxctrl_reg42 (offset 0xA8, printed page 2-75, `hi3516v100--Hi3516-Datasheet.txt` line 5555).";

        enum muxctrl_reg42_muxctrl_reg42_enum {
            RGMII_CRS = 0 { name = "Rgmii Crs"; desc = "RGMII_CRS"; };
            GPIO6_2 = 1 { name = "Gpio6 2"; desc = "GPIO6_2"; };
        };

        field {
            name = "muxctrl_reg42";
            desc = "Function of the RGMII_CRS pin (DS: RGMII_CRS 管脚的具体复用情况).";
            sw = rw;
            hw = r;
            encode = muxctrl_reg42_muxctrl_reg42_enum;
            reset = 0x0;
        } muxctrl_reg42[0:0];
    } muxctrl_reg42 @ 0xA8;

    reg {
        name = "Multiplexing control register for the RGMII_COL pin";
        desc = "muxctrl_reg43 is the multiplexing control register for the RGMII_COL pin (DS: RGMII_COL 管脚复用控制寄存器). Reset value 0 selects RGMII_COL.

Data sheet 2.1.5 muxctrl_reg43 (offset 0xAC, printed page 2-76, `hi3516v100--Hi3516-Datasheet.txt` line 5592).";

        enum muxctrl_reg43_muxctrl_reg43_enum {
            RGMII_COL = 0 { name = "Rgmii Col"; desc = "RGMII_COL"; };
            GPIO6_3 = 1 { name = "Gpio6 3"; desc = "GPIO6_3"; };
        };

        field {
            name = "muxctrl_reg43";
            desc = "Function of the RGMII_COL pin (DS: RGMII_COL 管脚的具体复用情况).";
            sw = rw;
            hw = r;
            encode = muxctrl_reg43_muxctrl_reg43_enum;
            reset = 0x0;
        } muxctrl_reg43[0:0];
    } muxctrl_reg43 @ 0xAC;

    reg {
        name = "Multiplexing control register for the IR_IN pin";
        desc = "muxctrl_reg44 is the multiplexing control register for the IR_IN pin (DS: IR_IN 管脚复用控制寄存器). Reset value 0 selects IR_IN.

Data sheet 2.1.5 muxctrl_reg44 (offset 0xB0, printed page 2-76, `hi3516v100--Hi3516-Datasheet.txt` line 5619).";

        enum muxctrl_reg44_muxctrl_reg44_enum {
            IR = 0 { name = "Ir"; desc = "IR_IN"; };
            GPIO6_4 = 1 { name = "Gpio6 4"; desc = "GPIO6_4"; };
        };

        field {
            name = "muxctrl_reg44";
            desc = "Function of the IR_IN pin (DS: IR_IN 管脚的具体复用情况).";
            sw = rw;
            hw = r;
            encode = muxctrl_reg44_muxctrl_reg44_enum;
            reset = 0x0;
        } muxctrl_reg44[0:0];
    } muxctrl_reg44 @ 0xB0;

    reg {
        name = "Multiplexing control register for the NF_DQ0 pin";
        desc = "muxctrl_reg45 is the multiplexing control register for the NF_DQ0 pin (DS: NF_DQ0 管脚复用控制寄存器). Reset value 0 selects NF_DQ0.

Data sheet 2.1.5 muxctrl_reg45 (offset 0xB4, printed page 2-77, `hi3516v100--Hi3516-Datasheet.txt` line 5655).";

        enum muxctrl_reg45_muxctrl_reg45_enum {
            NF_DQ0 = 0 { name = "Nf Dq0"; desc = "NF_DQ0"; };
            GPIO6_5 = 1 { name = "Gpio6 5"; desc = "GPIO6_5"; };
        };

        field {
            name = "muxctrl_reg45";
            desc = "Function of the NF_DQ0 pin (DS: NF_DQ0 管脚的具体复用情况).";
            sw = rw;
            hw = r;
            encode = muxctrl_reg45_muxctrl_reg45_enum;
            reset = 0x0;
        } muxctrl_reg45[0:0];
    } muxctrl_reg45 @ 0xB4;

    reg {
        name = "Multiplexing control register for the NF_DQ1 pin";
        desc = "muxctrl_reg46 is the multiplexing control register for the NF_DQ1 pin (DS: NF_DQ1 管脚复用控制寄存器). Reset value 0 selects NF_DQ1.

Data sheet 2.1.5 muxctrl_reg46 (offset 0xB8, printed page 2-77, `hi3516v100--Hi3516-Datasheet.txt` line 5682).";

        enum muxctrl_reg46_muxctrl_reg46_enum {
            NF_DQ1 = 0 { name = "Nf Dq1"; desc = "NF_DQ1"; };
            GPIO6_6 = 1 { name = "Gpio6 6"; desc = "GPIO6_6"; };
        };

        field {
            name = "muxctrl_reg46";
            desc = "Function of the NF_DQ1 pin (DS: NF_DQ1 管脚的具体复用情况).";
            sw = rw;
            hw = r;
            encode = muxctrl_reg46_muxctrl_reg46_enum;
            reset = 0x0;
        } muxctrl_reg46[0:0];
    } muxctrl_reg46 @ 0xB8;

    reg {
        name = "Multiplexing control register for the NF_DQ2 pin";
        desc = "muxctrl_reg47 is the multiplexing control register for the NF_DQ2 pin (DS: NF_DQ2 管脚复用控制寄存器). Reset value 0 selects NF_DQ2.

Data sheet 2.1.5 muxctrl_reg47 (offset 0xBC, printed page 2-78, `hi3516v100--Hi3516-Datasheet.txt` line 5718).";

        enum muxctrl_reg47_muxctrl_reg47_enum {
            NF_DQ2 = 0 { name = "Nf Dq2"; desc = "NF_DQ2"; };
            GPIO6_7 = 1 { name = "Gpio6 7"; desc = "GPIO6_7"; };
        };

        field {
            name = "muxctrl_reg47";
            desc = "Function of the NF_DQ2 pin (DS: NF_DQ2 管脚的具体复用情况).";
            sw = rw;
            hw = r;
            encode = muxctrl_reg47_muxctrl_reg47_enum;
            reset = 0x0;
        } muxctrl_reg47[0:0];
    } muxctrl_reg47 @ 0xBC;

    reg {
        name = "Multiplexing control register for the NF_DQ3 pin";
        desc = "muxctrl_reg48 is the multiplexing control register for the NF_DQ3 pin (DS: NF_DQ3 管脚复用控制寄存器). Reset value 0 selects NF_DQ3.

Data sheet 2.1.5 muxctrl_reg48 (offset 0xC0, printed page 2-78, `hi3516v100--Hi3516-Datasheet.txt` line 5745).";

        enum muxctrl_reg48_muxctrl_reg48_enum {
            NF_DQ3 = 0 { name = "Nf Dq3"; desc = "NF_DQ3"; };
            GPIO7_0 = 1 { name = "Gpio7 0"; desc = "GPIO7_0"; };
        };

        field {
            name = "muxctrl_reg48";
            desc = "Function of the NF_DQ3 pin (DS: NF_DQ3 管脚的具体复用情况).";
            sw = rw;
            hw = r;
            encode = muxctrl_reg48_muxctrl_reg48_enum;
            reset = 0x0;
        } muxctrl_reg48[0:0];
    } muxctrl_reg48 @ 0xC0;

    reg {
        name = "Multiplexing control register for the NF_DQ4 pin";
        desc = "muxctrl_reg49 is the multiplexing control register for the NF_DQ4 pin (DS: NF_DQ4 管脚复用控制寄存器). Reset value 0 selects NF_DQ4.

Data sheet 2.1.5 muxctrl_reg49 (offset 0xC4, printed page 2-79, `hi3516v100--Hi3516-Datasheet.txt` line 5781).";

        enum muxctrl_reg49_muxctrl_reg49_enum {
            NF_DQ4 = 0 { name = "Nf Dq4"; desc = "NF_DQ4"; };
            GPIO7_1 = 1 { name = "Gpio7 1"; desc = "GPIO7_1"; };
        };

        field {
            name = "muxctrl_reg49";
            desc = "Function of the NF_DQ4 pin (DS: NF_DQ4 管脚的具体复用情况).";
            sw = rw;
            hw = r;
            encode = muxctrl_reg49_muxctrl_reg49_enum;
            reset = 0x0;
        } muxctrl_reg49[0:0];
    } muxctrl_reg49 @ 0xC4;

    reg {
        name = "Multiplexing control register for the NF_DQ5 pin";
        desc = "muxctrl_reg50 is the multiplexing control register for the NF_DQ5 pin (DS: NF_DQ5 管脚复用控制寄存器). Reset value 0 selects NF_DQ5.

Data sheet 2.1.5 muxctrl_reg50 (offset 0xC8, printed page 2-79, `hi3516v100--Hi3516-Datasheet.txt` line 5809).";

        enum muxctrl_reg50_muxctrl_reg50_enum {
            NF_DQ5 = 0 { name = "Nf Dq5"; desc = "NF_DQ5"; };
            GPIO7_2 = 1 { name = "Gpio7 2"; desc = "GPIO7_2"; };
        };

        field {
            name = "muxctrl_reg50";
            desc = "Function of the NF_DQ5 pin (DS: NF_DQ5 管脚的具体复用情况).";
            sw = rw;
            hw = r;
            encode = muxctrl_reg50_muxctrl_reg50_enum;
            reset = 0x0;
        } muxctrl_reg50[0:0];
    } muxctrl_reg50 @ 0xC8;

    reg {
        name = "Multiplexing control register for the NF_DQ6 pin";
        desc = "muxctrl_reg51 is the multiplexing control register for the NF_DQ6 pin (DS: NF_DQ6 管脚复用控制寄存器). Reset value 0 selects NF_DQ6.

Data sheet 2.1.5 muxctrl_reg51 (offset 0xCC, printed page 2-80, `hi3516v100--Hi3516-Datasheet.txt` line 5846).";

        enum muxctrl_reg51_muxctrl_reg51_enum {
            NF_DQ6 = 0 { name = "Nf Dq6"; desc = "NF_DQ6"; };
            GPIO7_3 = 1 { name = "Gpio7 3"; desc = "GPIO7_3"; };
        };

        field {
            name = "muxctrl_reg51";
            desc = "Function of the NF_DQ6 pin (DS: NF_DQ6 管脚的具体复用情况).";
            sw = rw;
            hw = r;
            encode = muxctrl_reg51_muxctrl_reg51_enum;
            reset = 0x0;
        } muxctrl_reg51[0:0];
    } muxctrl_reg51 @ 0xCC;

    reg {
        name = "Multiplexing control register for the NF_DQ7 pin";
        desc = "muxctrl_reg52 is the multiplexing control register for the NF_DQ7 pin (DS: NF_DQ7 管脚复用控制寄存器). Reset value 0 selects NF_DQ7.

Data sheet 2.1.5 muxctrl_reg52 (offset 0xD0, printed page 2-80, `hi3516v100--Hi3516-Datasheet.txt` line 5873).";

        enum muxctrl_reg52_muxctrl_reg52_enum {
            NF_DQ7 = 0 { name = "Nf Dq7"; desc = "NF_DQ7"; };
            GPIO7_4 = 1 { name = "Gpio7 4"; desc = "GPIO7_4"; };
        };

        field {
            name = "muxctrl_reg52";
            desc = "Function of the NF_DQ7 pin (DS: NF_DQ7 管脚的具体复用情况).";
            sw = rw;
            hw = r;
            encode = muxctrl_reg52_muxctrl_reg52_enum;
            reset = 0x0;
        } muxctrl_reg52[0:0];
    } muxctrl_reg52 @ 0xD0;

    reg {
        name = "Multiplexing control register for the NF_RDY0 pin";
        desc = "muxctrl_reg53 is the multiplexing control register for the NF_RDY0 pin (DS: NF_RDY0 管脚复用控制寄存器). Reset value 0 selects NF_RDY0.

Data sheet 2.1.5 muxctrl_reg53 (offset 0xD4, printed page 2-81, `hi3516v100--Hi3516-Datasheet.txt` line 5909).";

        enum muxctrl_reg53_muxctrl_reg53_enum {
            NF_RDY0 = 0 { name = "Nf Rdy0"; desc = "NF_RDY0"; };
            GPIO7_5 = 1 { name = "Gpio7 5"; desc = "GPIO7_5"; };
        };

        field {
            name = "muxctrl_reg53";
            desc = "Function of the NF_RDY0 pin (DS: NF_RDY0 管脚的具体复用情况).";
            sw = rw;
            hw = r;
            encode = muxctrl_reg53_muxctrl_reg53_enum;
            reset = 0x0;
        } muxctrl_reg53[0:0];
    } muxctrl_reg53 @ 0xD4;

    reg {
        name = "Multiplexing control register for the NF_RDY1 pin";
        desc = "muxctrl_reg54 is the multiplexing control register for the NF_RDY1 pin (DS: NF_RDY1 管脚复用控制寄存器). Reset value 0 selects NF_RDY1.

Data sheet 2.1.5 muxctrl_reg54 (offset 0xD8, printed page 2-81, `hi3516v100--Hi3516-Datasheet.txt` line 5936).";

        enum muxctrl_reg54_muxctrl_reg54_enum {
            NF_RDY1 = 0 { name = "Nf Rdy1"; desc = "NF_RDY1"; };
            GPIO7_6 = 1 { name = "Gpio7 6"; desc = "GPIO7_6"; };
        };

        field {
            name = "muxctrl_reg54";
            desc = "Function of the NF_RDY1 pin (DS: NF_RDY1 管脚的具体复用情况).";
            sw = rw;
            hw = r;
            encode = muxctrl_reg54_muxctrl_reg54_enum;
            reset = 0x0;
        } muxctrl_reg54[0:0];
    } muxctrl_reg54 @ 0xD8;

    reg {
        name = "Multiplexing control register for the NF_CSN0 pin";
        desc = "muxctrl_reg55 is the multiplexing control register for the NF_CSN0 pin (DS: NF_CSN0 管脚复用控制寄存器). Reset value 0 selects NF_CSN0.

Data sheet 2.1.5 muxctrl_reg55 (offset 0xDC, printed page 2-82, `hi3516v100--Hi3516-Datasheet.txt` line 5973).";

        enum muxctrl_reg55_muxctrl_reg55_enum {
            NF_CSN0 = 0 { name = "Nf Csn0"; desc = "NF_CSN0"; };
            GPIO7_7 = 1 { name = "Gpio7 7"; desc = "GPIO7_7"; };
        };

        field {
            name = "muxctrl_reg55";
            desc = "Function of the NF_CSN0 pin (DS: NF_CSN0 管脚的具体复用情况).";
            sw = rw;
            hw = r;
            encode = muxctrl_reg55_muxctrl_reg55_enum;
            reset = 0x0;
        } muxctrl_reg55[0:0];
    } muxctrl_reg55 @ 0xDC;

    reg {
        name = "Multiplexing control register for the NF_CSN1 pin";
        desc = "muxctrl_reg56 is the multiplexing control register for the NF_CSN1 pin (DS: NF_CSN1 管脚复用控制寄存器). Reset value 0 selects NF_CSN1.

Data sheet 2.1.5 muxctrl_reg56 (offset 0xE0, printed page 2-82, `hi3516v100--Hi3516-Datasheet.txt` line 6000).";

        enum muxctrl_reg56_muxctrl_reg56_enum {
            NF_CSN1 = 0 { name = "Nf Csn1"; desc = "NF_CSN1"; };
            GPIO8_0 = 1 { name = "Gpio8 0"; desc = "GPIO8_0"; };
        };

        field {
            name = "muxctrl_reg56";
            desc = "Function of the NF_CSN1 pin (DS: NF_CSN1 管脚的具体复用情况).";
            sw = rw;
            hw = r;
            encode = muxctrl_reg56_muxctrl_reg56_enum;
            reset = 0x0;
        } muxctrl_reg56[0:0];
    } muxctrl_reg56 @ 0xE0;

    reg {
        name = "Multiplexing control register for the SDIO0_CARD_POWER_EN pin";
        desc = "muxctrl_reg57 is the multiplexing control register for the SDIO0_CARD_POWER_EN pin (DS: SDIO0_CARD_POWER_EN 管脚复用控制寄存器). Reset value 0 selects GPIO8_1.

Data sheet 2.1.5 muxctrl_reg57 (offset 0xE4, printed page 2-83, `hi3516v100--Hi3516-Datasheet.txt` line 6036).";

        enum muxctrl_reg57_muxctrl_reg57_enum {
            GPIO8_1 = 0 { name = "Gpio8 1"; desc = "GPIO8_1"; };
            SDIO0_CARD_POWER = 1 { name = "Sdio0 Card Power"; desc = "SDIO0_CARD_POWER_EN"; };
        };

        field {
            name = "muxctrl_reg57";
            desc = "Function of the SDIO0_CARD_POWER_EN pin (DS: SDIO0_CARD_POWER_EN 管脚的具体复用情况).";
            sw = rw;
            hw = r;
            encode = muxctrl_reg57_muxctrl_reg57_enum;
            reset = 0x0;
        } muxctrl_reg57[0:0];
    } muxctrl_reg57 @ 0xE4;

    reg {
        name = "Multiplexing control register for the SDIO0_CARD_DETECT pin";
        desc = "muxctrl_reg58 is the multiplexing control register for the SDIO0_CARD_DETECT pin (DS: SDIO0_CARD_DETECT 管脚复用控制寄存器). Reset value 0 selects SDIO0_CARD_DETECT.

Data sheet 2.1.5 muxctrl_reg58 (offset 0xE8, printed page 2-83, `hi3516v100--Hi3516-Datasheet.txt` line 6063).";

        enum muxctrl_reg58_muxctrl_reg58_enum {
            SDIO0_CARD_DETECT = 0 { name = "Sdio0 Card Detect"; desc = "SDIO0_CARD_DETECT"; };
            GPIO8_2 = 1 { name = "Gpio8 2"; desc = "GPIO8_2"; };
        };

        field {
            name = "muxctrl_reg58";
            desc = "Function of the SDIO0_CARD_DETECT pin (DS: SDIO0_CARD_DETECT 管脚的具体复用情况).";
            sw = rw;
            hw = r;
            encode = muxctrl_reg58_muxctrl_reg58_enum;
            reset = 0x0;
        } muxctrl_reg58[0:0];
    } muxctrl_reg58 @ 0xE8;

    reg {
        name = "Multiplexing control register for the SDIO0_CWPR pin";
        desc = "muxctrl_reg59 is the multiplexing control register for the SDIO0_CWPR pin (DS: SDIO0_CWPR 管脚复用控制寄存器). Reset value 0 selects SDIO0_CWPR.

Data sheet 2.1.5 muxctrl_reg59 (offset 0xEC, printed page 2-84, `hi3516v100--Hi3516-Datasheet.txt` line 6100).";

        enum muxctrl_reg59_muxctrl_reg59_enum {
            SDIO0_CWPR = 0 { name = "Sdio0 Cwpr"; desc = "SDIO0_CWPR"; };
            GPIO8_3 = 1 { name = "Gpio8 3"; desc = "GPIO8_3"; };
        };

        field {
            name = "muxctrl_reg59";
            desc = "Function of the SDIO0_CWPR pin (DS: SDIO0_CWPR 管脚的具体复用情况).";
            sw = rw;
            hw = r;
            encode = muxctrl_reg59_muxctrl_reg59_enum;
            reset = 0x0;
        } muxctrl_reg59[0:0];
    } muxctrl_reg59 @ 0xEC;

    reg {
        name = "Multiplexing control register for the SDIO0_CCMD_ODPULLUP_EN_N pin";
        desc = "muxctrl_reg60 is the multiplexing control register for the SDIO0_CCMD_ODPULLUP_EN_N pin (DS: SDIO0_CCMD_ODPULLUP_EN_N 管脚复用控制寄存器). Reset value 0 selects GPIO8_4.

Data sheet 2.1.5 muxctrl_reg60 (offset 0xF0, printed page 2-84, `hi3516v100--Hi3516-Datasheet.txt` line 6127).";

        enum muxctrl_reg60_muxctrl_reg60_enum {
            GPIO8_4 = 0 { name = "Gpio8 4"; desc = "GPIO8_4"; };
            SDIO0_CCMD_ODPULLUP = 1 { name = "Sdio0 Ccmd Odpullup"; desc = "SDIO0_CCMD_ODPULLUP_EN_N"; };
        };

        field {
            name = "muxctrl_reg60";
            desc = "Function of the SDIO0_CCMD_ODPULLUP_EN_N pin (DS: SDIO0_CCMD_ODPULLUP_EN_N 管脚的具体复用情况).";
            sw = rw;
            hw = r;
            encode = muxctrl_reg60_muxctrl_reg60_enum;
            reset = 0x0;
        } muxctrl_reg60[0:0];
    } muxctrl_reg60 @ 0xF0;

    reg {
        name = "Multiplexing control register for the SDIO0_CCMD pin";
        desc = "muxctrl_reg61 is the multiplexing control register for the SDIO0_CCMD pin (DS: SDIO0_CCMD 管脚复用控制寄存器). Reset value 0 selects SDIO0_CCMD.

Data sheet 2.1.5 muxctrl_reg61 (offset 0xF4, printed page 2-85, `hi3516v100--Hi3516-Datasheet.txt` line 6164).";

        enum muxctrl_reg61_muxctrl_reg61_enum {
            SDIO0_CCMD = 0 { name = "Sdio0 Ccmd"; desc = "SDIO0_CCMD"; };
            GPIO8_5 = 1 { name = "Gpio8 5"; desc = "GPIO8_5"; };
        };

        field {
            name = "muxctrl_reg61";
            desc = "Function of the SDIO0_CCMD pin (DS: SDIO0_CCMD 管脚的具体复用情况).";
            sw = rw;
            hw = r;
            encode = muxctrl_reg61_muxctrl_reg61_enum;
            reset = 0x0;
        } muxctrl_reg61[0:0];
    } muxctrl_reg61 @ 0xF4;

    reg {
        name = "Multiplexing control register for the SDIO0_CDATA0 pin";
        desc = "muxctrl_reg62 is the multiplexing control register for the SDIO0_CDATA0 pin (DS: SDIO0_CDATA0 管脚复用控制寄存器). Reset value 0 selects SDIO0_CDATA0.

Data sheet 2.1.5 muxctrl_reg62 (offset 0xF8, printed page 2-85, `hi3516v100--Hi3516-Datasheet.txt` line 6192).";

        enum muxctrl_reg62_muxctrl_reg62_enum {
            SDIO0_CDATA0 = 0 { name = "Sdio0 Cdata0"; desc = "SDIO0_CDATA0"; };
            GPIO8_6 = 1 { name = "Gpio8 6"; desc = "GPIO8_6"; };
        };

        field {
            name = "muxctrl_reg62";
            desc = "Function of the SDIO0_CDATA0 pin (DS: SDIO0_CDATA0 管脚的具体复用情况).";
            sw = rw;
            hw = r;
            encode = muxctrl_reg62_muxctrl_reg62_enum;
            reset = 0x0;
        } muxctrl_reg62[0:0];
    } muxctrl_reg62 @ 0xF8;

    reg {
        name = "Multiplexing control register for the SDIO0_CDATA1 pin";
        desc = "muxctrl_reg63 is the multiplexing control register for the SDIO0_CDATA1 pin (DS: SDIO0_CDATA1 管脚复用控制寄存器). Reset value 0 selects SDIO0_CDATA1.

Data sheet 2.1.5 muxctrl_reg63 (offset 0xFC, printed page 2-86, `hi3516v100--Hi3516-Datasheet.txt` line 6229).";

        enum muxctrl_reg63_muxctrl_reg63_enum {
            SDIO0_CDATA1 = 0 { name = "Sdio0 Cdata1"; desc = "SDIO0_CDATA1"; };
            RESERVE = 1 { name = "Reserve"; desc = "RESERVE"; };
        };

        field {
            name = "muxctrl_reg63";
            desc = "Function of the SDIO0_CDATA1 pin (DS: SDIO0_CDATA1 管脚的具体复用情况).";
            sw = rw;
            hw = r;
            encode = muxctrl_reg63_muxctrl_reg63_enum;
            reset = 0x0;
        } muxctrl_reg63[0:0];
    } muxctrl_reg63 @ 0xFC;

    reg {
        name = "Multiplexing control register for the SDIO0_CDATA4 pin";
        desc = "muxctrl_reg64 is the multiplexing control register for the SDIO0_CDATA4 pin (DS: SDIO0_CDATA4 管脚复用控制寄存器). Reset value 0 selects SDIO0_CDATA4.

Data sheet 2.1.5 muxctrl_reg64 (offset 0x100, printed page 2-86, `hi3516v100--Hi3516-Datasheet.txt` line 6256).";

        enum muxctrl_reg64_muxctrl_reg64_enum {
            SDIO0_CDATA4 = 0 { name = "Sdio0 Cdata4"; desc = "SDIO0_CDATA4"; };
            UART2_RXD = 1 { name = "Uart2 Rxd"; desc = "UART2_RXD"; };
        };

        field {
            name = "muxctrl_reg64";
            desc = "Function of the SDIO0_CDATA4 pin (DS: SDIO0_CDATA4 管脚的具体复用情况).";
            sw = rw;
            hw = r;
            encode = muxctrl_reg64_muxctrl_reg64_enum;
            reset = 0x0;
        } muxctrl_reg64[0:0];
    } muxctrl_reg64 @ 0x100;

    reg {
        name = "Multiplexing control register for the SDIO0_CDATA5 pin";
        desc = "muxctrl_reg65 is the multiplexing control register for the SDIO0_CDATA5 pin (DS: SDIO0_CDATA5 管脚复用控制寄存器). Reset value 0 selects SDIO0_CDATA5.

Data sheet 2.1.5 muxctrl_reg65 (offset 0x104, printed page 2-87, `hi3516v100--Hi3516-Datasheet.txt` line 6292).";

        enum muxctrl_reg65_muxctrl_reg65_enum {
            SDIO0_CDATA5 = 0 { name = "Sdio0 Cdata5"; desc = "SDIO0_CDATA5"; };
            UART2_TXD = 1 { name = "Uart2 Txd"; desc = "UART2_TXD"; };
        };

        field {
            name = "muxctrl_reg65";
            desc = "Function of the SDIO0_CDATA5 pin (DS: SDIO0_CDATA5 管脚的具体复用情况).";
            sw = rw;
            hw = r;
            encode = muxctrl_reg65_muxctrl_reg65_enum;
            reset = 0x0;
        } muxctrl_reg65[0:0];
    } muxctrl_reg65 @ 0x104;

    reg {
        name = "Multiplexing control register for the SDIO0_CDATA6 pin";
        desc = "muxctrl_reg66 is the multiplexing control register for the SDIO0_CDATA6 pin (DS: SDIO0_CDATA6 管脚复用控制寄存器). Reset value 0 selects SDIO0_CDATA6. Other values: reserved (其它：保留).

Data sheet 2.1.5 muxctrl_reg66 (offset 0x108, printed page 2-87, `hi3516v100--Hi3516-Datasheet.txt` line 6319).";

        enum muxctrl_reg66_muxctrl_reg66_enum {
            SDIO0_CDATA6 = 0 { name = "Sdio0 Cdata6"; desc = "SDIO0_CDATA6"; };
            UART3_RXD = 1 { name = "Uart3 Rxd"; desc = "UART3_RXD"; };
            PWM1_OUT1 = 2 { name = "Pwm1 Out1"; desc = "PWM1_OUT1"; };
        };

        field {
            name = "muxctrl_reg66";
            desc = "Function of the SDIO0_CDATA6 pin (DS: SDIO0_CDATA6 管脚的具体复用情况).";
            sw = rw;
            hw = r;
            encode = muxctrl_reg66_muxctrl_reg66_enum;
            reset = 0x0;
        } muxctrl_reg66[1:0];
    } muxctrl_reg66 @ 0x108;

    reg {
        name = "Multiplexing control register for the SDIO0_CDATA7 pin";
        desc = "muxctrl_reg67 is the multiplexing control register for the SDIO0_CDATA7 pin (DS: SDIO0_CDATA7 管脚复用控制寄存器). Reset value 0 selects SDIO0_CDATA7. Other values: reserved (其它：保留).

Data sheet 2.1.5 muxctrl_reg67 (offset 0x10C, printed page 2-88, `hi3516v100--Hi3516-Datasheet.txt` line 6354).";

        enum muxctrl_reg67_muxctrl_reg67_enum {
            SDIO0_CDATA7 = 0 { name = "Sdio0 Cdata7"; desc = "SDIO0_CDATA7"; };
            UART3_TXD = 1 { name = "Uart3 Txd"; desc = "UART3_TXD"; };
            PWM1_OUT2 = 2 { name = "Pwm1 Out2"; desc = "PWM1_OUT2"; };
        };

        field {
            name = "muxctrl_reg67";
            desc = "Function of the SDIO0_CDATA7 pin (DS: SDIO0_CDATA7 管脚的具体复用情况).";
            sw = rw;
            hw = r;
            encode = muxctrl_reg67_muxctrl_reg67_enum;
            reset = 0x0;
        } muxctrl_reg67[1:0];
    } muxctrl_reg67 @ 0x10C;

    reg {
        name = "Multiplexing control register for the SFC_CS0N pin";
        desc = "muxctrl_reg68 is the multiplexing control register for the SFC_CS0N pin (DS: SFC_CS0N 管脚复用控制寄存器). Reset value 0 selects SFC_CS0N.

Data sheet 2.1.5 muxctrl_reg68 (offset 0x110, printed page 2-88, `hi3516v100--Hi3516-Datasheet.txt` line 6380).";

        enum muxctrl_reg68_muxctrl_reg68_enum {
            SFC_CS0N = 0 { name = "Sfc Cs0N"; desc = "SFC_CS0N"; };
            GPIO8_7 = 1 { name = "Gpio8 7"; desc = "GPIO8_7"; };
        };

        field {
            name = "muxctrl_reg68";
            desc = "Function of the SFC_CS0N pin (DS: SFC_CS0N 管脚的具体复用情况).";
            sw = rw;
            hw = r;
            encode = muxctrl_reg68_muxctrl_reg68_enum;
            reset = 0x0;
        } muxctrl_reg68[0:0];
    } muxctrl_reg68 @ 0x110;

    reg {
        name = "Multiplexing control register for the VOU1_CLK pin";
        desc = "muxctrl_reg69 is the multiplexing control register for the VOU1_CLK pin (DS: VOU1_CLK 管脚复用控制寄存器). Reset value 0 selects GPIO9_0.

Data sheet 2.1.5 muxctrl_reg69 (offset 0x114, printed page 2-89, `hi3516v100--Hi3516-Datasheet.txt` line 6416).";

        enum muxctrl_reg69_muxctrl_reg69_enum {
            GPIO9_0 = 0 { name = "Gpio9 0"; desc = "GPIO9_0"; };
            VOU1_CLK = 1 { name = "Vou1 Clk"; desc = "VOU1_CLK"; };
        };

        field {
            name = "muxctrl_reg69";
            desc = "Function of the VOU1_CLK pin (DS: VOU1_CLK 管脚的具体复用情况).";
            sw = rw;
            hw = r;
            encode = muxctrl_reg69_muxctrl_reg69_enum;
            reset = 0x0;
        } muxctrl_reg69[0:0];
    } muxctrl_reg69 @ 0x114;

    reg {
        name = "Multiplexing control register for the VOU1_DATA7 pin";
        desc = "muxctrl_reg70 is the multiplexing control register for the VOU1_DATA7 pin (DS: VOU1_DATA7 管脚复用控制寄存器). Reset value 0 selects GPIO9_1. Other values: reserved (其它：保留).

Data sheet 2.1.5 muxctrl_reg70 (offset 0x118, printed page 2-89, `hi3516v100--Hi3516-Datasheet.txt` line 6443).";

        enum muxctrl_reg70_muxctrl_reg70_enum {
            GPIO9_1 = 0 { name = "Gpio9 1"; desc = "GPIO9_1"; };
            VOU1_DATA7 = 1 { name = "Vou1 Data7"; desc = "VOU1_DATA7"; };
            SIO1_XCLK = 2 { name = "Sio1 Xclk"; desc = "SIO1_XCLK"; };
        };

        field {
            name = "muxctrl_reg70";
            desc = "Function of the VOU1_DATA7 pin (DS: VOU1_DATA7 管脚的具体复用情况).";
            sw = rw;
            hw = r;
            encode = muxctrl_reg70_muxctrl_reg70_enum;
            reset = 0x0;
        } muxctrl_reg70[1:0];
    } muxctrl_reg70 @ 0x118;

    reg {
        name = "Multiplexing control register for the VOU1_DATA6 pin";
        desc = "muxctrl_reg71 is the multiplexing control register for the VOU1_DATA6 pin (DS: VOU1_DATA6 管脚复用控制寄存器). Reset value 0 selects GPIO9_2. Other values: reserved (其它：保留).

Data sheet 2.1.5 muxctrl_reg71 (offset 0x11C, printed page 2-90, `hi3516v100--Hi3516-Datasheet.txt` line 6478).";

        enum muxctrl_reg71_muxctrl_reg71_enum {
            GPIO9_2 = 0 { name = "Gpio9 2"; desc = "GPIO9_2"; };
            VOU1_DATA6 = 1 { name = "Vou1 Data6"; desc = "VOU1_DATA6"; };
            SIO1_XFS = 2 { name = "Sio1 Xfs"; desc = "SIO1_XFS"; };
        };

        field {
            name = "muxctrl_reg71";
            desc = "Function of the VOU1_DATA6 pin (DS: VOU1_DATA6 管脚的具体复用情况).";
            sw = rw;
            hw = r;
            encode = muxctrl_reg71_muxctrl_reg71_enum;
            reset = 0x0;
        } muxctrl_reg71[1:0];
    } muxctrl_reg71 @ 0x11C;

    reg {
        name = "Multiplexing control register for the VOU1_DATA5 pin";
        desc = "muxctrl_reg72 is the multiplexing control register for the VOU1_DATA5 pin (DS: VOU1_DATA5 管脚复用控制寄存器). Reset value 0 selects GPIO9_3. Other values: reserved (其它：保留).

Data sheet 2.1.5 muxctrl_reg72 (offset 0x120, printed page 2-90, `hi3516v100--Hi3516-Datasheet.txt` line 6504).";

        enum muxctrl_reg72_muxctrl_reg72_enum {
            GPIO9_3 = 0 { name = "Gpio9 3"; desc = "GPIO9_3"; };
            VOU1_DATA5 = 1 { name = "Vou1 Data5"; desc = "VOU1_DATA5"; };
            SIO1_RCLK = 2 { name = "Sio1 Rclk"; desc = "SIO1_RCLK"; };
        };

        field {
            name = "muxctrl_reg72";
            desc = "Function of the VOU1_DATA5 pin (DS: VOU1_DATA5 管脚的具体复用情况).";
            sw = rw;
            hw = r;
            encode = muxctrl_reg72_muxctrl_reg72_enum;
            reset = 0x0;
        } muxctrl_reg72[1:0];
    } muxctrl_reg72 @ 0x120;

    reg {
        name = "Multiplexing control register for the VOU1_DATA4 pin";
        desc = "muxctrl_reg73 is the multiplexing control register for the VOU1_DATA4 pin (DS: VOU1_DATA4 管脚复用控制寄存器). Reset value 0 selects GPIO9_4. Other values: reserved (其它：保留).

Data sheet 2.1.5 muxctrl_reg73 (offset 0x124, printed page 2-91, `hi3516v100--Hi3516-Datasheet.txt` line 6538).";

        enum muxctrl_reg73_muxctrl_reg73_enum {
            GPIO9_4 = 0 { name = "Gpio9 4"; desc = "GPIO9_4"; };
            VOU1_DATA4 = 1 { name = "Vou1 Data4"; desc = "VOU1_DATA4"; };
            SIO1_RFS = 2 { name = "Sio1 Rfs"; desc = "SIO1_RFS"; };
        };

        field {
            name = "muxctrl_reg73";
            desc = "Function of the VOU1_DATA4 pin (DS: VOU1_DATA4 管脚的具体复用情况).";
            sw = rw;
            hw = r;
            encode = muxctrl_reg73_muxctrl_reg73_enum;
            reset = 0x0;
        } muxctrl_reg73[1:0];
    } muxctrl_reg73 @ 0x124;

    reg {
        name = "Multiplexing control register for the VOU1_DATA3 pin";
        desc = "muxctrl_reg74 is the multiplexing control register for the VOU1_DATA3 pin (DS: VOU1_DATA3 管脚复用控制寄存器). Reset value 0 selects GPIO9_5. Other values: reserved (其它：保留).

Data sheet 2.1.5 muxctrl_reg74 (offset 0x128, printed page 2-91, `hi3516v100--Hi3516-Datasheet.txt` line 6564).";

        enum muxctrl_reg74_muxctrl_reg74_enum {
            GPIO9_5 = 0 { name = "Gpio9 5"; desc = "GPIO9_5"; };
            VOU1_DATA3 = 1 { name = "Vou1 Data3"; desc = "VOU1_DATA3"; };
            SIO1_DOUT = 2 { name = "Sio1 Dout"; desc = "SIO1_DOUT"; };
        };

        field {
            name = "muxctrl_reg74";
            desc = "Function of the VOU1_DATA3 pin (DS: VOU1_DATA3 管脚的具体复用情况).";
            sw = rw;
            hw = r;
            encode = muxctrl_reg74_muxctrl_reg74_enum;
            reset = 0x0;
        } muxctrl_reg74[1:0];
    } muxctrl_reg74 @ 0x128;

    reg {
        name = "Multiplexing control register for the VOU1_DATA2 pin";
        desc = "muxctrl_reg75 is the multiplexing control register for the VOU1_DATA2 pin (DS: VOU1_DATA2 管脚复用控制寄存器). Reset value 0 selects GPIO9_6. Other values: reserved (其它：保留).

Data sheet 2.1.5 muxctrl_reg75 (offset 0x12C, printed page 2-92, `hi3516v100--Hi3516-Datasheet.txt` line 6598).";

        enum muxctrl_reg75_muxctrl_reg75_enum {
            GPIO9_6 = 0 { name = "Gpio9 6"; desc = "GPIO9_6"; };
            VOU1_DATA2 = 1 { name = "Vou1 Data2"; desc = "VOU1_DATA2"; };
            SIO1_DIN = 2 { name = "Sio1 Din"; desc = "SIO1_DIN"; };
        };

        field {
            name = "muxctrl_reg75";
            desc = "Function of the VOU1_DATA2 pin (DS: VOU1_DATA2 管脚的具体复用情况).";
            sw = rw;
            hw = r;
            encode = muxctrl_reg75_muxctrl_reg75_enum;
            reset = 0x0;
        } muxctrl_reg75[1:0];
    } muxctrl_reg75 @ 0x12C;

    reg {
        name = "Multiplexing control register for the VOU1_DATA1 pin";
        desc = "muxctrl_reg76 is the multiplexing control register for the VOU1_DATA1 pin (DS: VOU1_DATA1 管脚复用控制寄存器). Reset value 0 selects CLK_TEST_OUT0. Other values: reserved (其它：保留).

Data sheet 2.1.5 muxctrl_reg76 (offset 0x130, printed page 2-92, `hi3516v100--Hi3516-Datasheet.txt` line 6624).";

        enum muxctrl_reg76_muxctrl_reg76_enum {
            CLK_TEST_OUT0 = 0 { name = "Clk Test Out0"; desc = "CLK_TEST_OUT0"; };
            VOU1_DATA1 = 1 { name = "Vou1 Data1"; desc = "VOU1_DATA1"; };
            NF_PAGE1 = 2 { name = "Nf Page1"; desc = "NF_PAGE1"; };
            CLK_TEST_OUT1 = 3 { name = "Clk Test Out1"; desc = "CLK_TEST_OUT1"; };
            CLK_TEST_OUT2 = 4 { name = "Clk Test Out2"; desc = "CLK_TEST_OUT2"; };
            CLK_TEST_OUT3 = 5 { name = "Clk Test Out3"; desc = "CLK_TEST_OUT3"; };
        };

        field {
            name = "muxctrl_reg76";
            desc = "Function of the VOU1_DATA1 pin (DS: VOU1_DATA1 管脚的具体复用情况).";
            sw = rw;
            hw = r;
            encode = muxctrl_reg76_muxctrl_reg76_enum;
            reset = 0x0;
        } muxctrl_reg76[2:0];
    } muxctrl_reg76 @ 0x130;

    reg {
        name = "Multiplexing control register for the VOU1_DATA0 pin";
        desc = "muxctrl_reg77 is the multiplexing control register for the VOU1_DATA0 pin (DS: VOU1_DATA0 管脚复用控制寄存器). Reset value 0 selects PLL_TEST_OUT0. Other values: reserved (其它：保留).

Data sheet 2.1.5 muxctrl_reg77 (offset 0x134, printed page 2-93, `hi3516v100--Hi3516-Datasheet.txt` line 6663).";

        enum muxctrl_reg77_muxctrl_reg77_enum {
            PLL_TEST_OUT0 = 0 { name = "Pll Test Out0"; desc = "PLL_TEST_OUT0"; };
            VOU1_DATA0 = 1 { name = "Vou1 Data0"; desc = "VOU1_DATA0"; };
            NF_PAGE0 = 2 { name = "Nf Page0"; desc = "NF_PAGE0"; };
            PLL_TEST_OUT1 = 3 { name = "Pll Test Out1"; desc = "PLL_TEST_OUT1"; };
            PLL_TEST_OUT2 = 4 { name = "Pll Test Out2"; desc = "PLL_TEST_OUT2"; };
            PLL_TEST_OUT3 = 5 { name = "Pll Test Out3"; desc = "PLL_TEST_OUT3"; };
        };

        field {
            name = "muxctrl_reg77";
            desc = "Function of the VOU1_DATA0 pin (DS: VOU1_DATA0 管脚的具体复用情况).";
            sw = rw;
            hw = r;
            encode = muxctrl_reg77_muxctrl_reg77_enum;
            reset = 0x0;
        } muxctrl_reg77[2:0];
    } muxctrl_reg77 @ 0x134;

    reg {
        name = "Multiplexing control register for the USB0_OVRCUR pin";
        desc = "muxctrl_reg78 is the multiplexing control register for the USB0_OVRCUR pin (DS: USB0_OVRCUR 管脚复用控制寄存器). Reset value 0 selects USB0_OVRCUR. Other values: reserved (其它：保留).

Data sheet 2.1.5 muxctrl_reg78 (offset 0x138, printed page 2-93, `hi3516v100--Hi3516-Datasheet.txt` line 6696).";

        enum muxctrl_reg78_muxctrl_reg78_enum {
            USB0_OVRCUR = 0 { name = "Usb0 Ovrcur"; desc = "USB0_OVRCUR"; };
            GPIO9_7 = 2 { name = "Gpio9 7"; desc = "GPIO9_7"; };
        };

        field {
            name = "muxctrl_reg78";
            desc = "Function of the USB0_OVRCUR pin (DS: USB0_OVRCUR 管脚的具体复用情况).";
            sw = rw;
            hw = r;
            encode = muxctrl_reg78_muxctrl_reg78_enum;
            reset = 0x0;
        } muxctrl_reg78[1:0];
    } muxctrl_reg78 @ 0x138;

    reg {
        name = "Multiplexing control register for the USB0_PWREN pin";
        desc = "muxctrl_reg79 is the multiplexing control register for the USB0_PWREN pin (DS: USB0_PWREN 管脚复用控制寄存器). Reset value 0 selects USB0_PWREN. Other values: reserved (其它：保留).

Data sheet 2.1.5 muxctrl_reg79 (offset 0x13C, printed page 2-94, `hi3516v100--Hi3516-Datasheet.txt` line 6730).";

        enum muxctrl_reg79_muxctrl_reg79_enum {
            USB0_PWREN = 0 { name = "Usb0 Pwren"; desc = "USB0_PWREN"; };
            GPIO10_0 = 2 { name = "Gpio10 0"; desc = "GPIO10_0"; };
        };

        field {
            name = "muxctrl_reg79";
            desc = "Function of the USB0_PWREN pin (DS: USB0_PWREN 管脚的具体复用情况).";
            sw = rw;
            hw = r;
            encode = muxctrl_reg79_muxctrl_reg79_enum;
            reset = 0x0;
        } muxctrl_reg79[1:0];
    } muxctrl_reg79 @ 0x13C;

    reg {
        name = "Multiplexing control register for the USB1_OVRCUR pin";
        desc = "muxctrl_reg80 is the multiplexing control register for the USB1_OVRCUR pin (DS: USB1_OVRCUR 管脚复用控制寄存器). Reset value 0 selects USB1_OVRCUR. Other values: reserved (其它：保留).

Data sheet 2.1.5 muxctrl_reg80 (offset 0x140, printed page 2-94, `hi3516v100--Hi3516-Datasheet.txt` line 6756).";

        enum muxctrl_reg80_muxctrl_reg80_enum {
            USB1_OVRCUR = 0 { name = "Usb1 Ovrcur"; desc = "USB1_OVRCUR"; };
            GPIO10_1 = 2 { name = "Gpio10 1"; desc = "GPIO10_1"; };
        };

        field {
            name = "muxctrl_reg80";
            desc = "Function of the USB1_OVRCUR pin (DS: USB1_OVRCUR 管脚的具体复用情况).";
            sw = rw;
            hw = r;
            encode = muxctrl_reg80_muxctrl_reg80_enum;
            reset = 0x0;
        } muxctrl_reg80[1:0];
    } muxctrl_reg80 @ 0x140;

    reg {
        name = "Multiplexing control register for the USB1_PWREN pin";
        desc = "muxctrl_reg81 is the multiplexing control register for the USB1_PWREN pin (DS: USB1_PWREN 管脚复用控制寄存器). Reset value 0 selects USB1_PWREN. Other values: reserved (其它：保留).

Data sheet 2.1.5 muxctrl_reg81 (offset 0x144, printed page 2-95, `hi3516v100--Hi3516-Datasheet.txt` line 6788).";

        enum muxctrl_reg81_muxctrl_reg81_enum {
            USB1_PWREN = 0 { name = "Usb1 Pwren"; desc = "USB1_PWREN"; };
            GPIO10_2 = 2 { name = "Gpio10 2"; desc = "GPIO10_2"; };
        };

        field {
            name = "muxctrl_reg81";
            desc = "Function of the USB1_PWREN pin (DS: USB1_PWREN 管脚的具体复用情况).";
            sw = rw;
            hw = r;
            encode = muxctrl_reg81_muxctrl_reg81_enum;
            reset = 0x0;
        } muxctrl_reg81[1:0];
    } muxctrl_reg81 @ 0x144;

    reg {
        name = "Multiplexing control register for the SENS_CLK pin";
        desc = "muxctrl_reg82 is the multiplexing control register for the SENS_CLK pin (DS: SENS_CLK 管脚复用控制寄存器). Reset value 0 selects GPIO10_3.

Data sheet 2.1.5 muxctrl_reg82 (offset 0x148, printed page 2-95, `hi3516v100--Hi3516-Datasheet.txt` line 6814).";

        enum muxctrl_reg82_muxctrl_reg82_enum {
            GPIO10_3 = 0 { name = "Gpio10 3"; desc = "GPIO10_3"; };
            SENS_CLK = 1 { name = "Sens Clk"; desc = "SENS_CLK"; };
        };

        field {
            name = "muxctrl_reg82";
            desc = "Function of the SENS_CLK pin (DS: SENS_CLK 管脚的具体复用情况).";
            sw = rw;
            hw = r;
            encode = muxctrl_reg82_muxctrl_reg82_enum;
            reset = 0x0;
        } muxctrl_reg82[0:0];
    } muxctrl_reg82 @ 0x148;

    reg {
        name = "Multiplexing control register for the EPHY_CLK pin";
        desc = "muxctrl_reg83 is the multiplexing control register for the EPHY_CLK pin (DS: EPHY_CLK 管脚复用控制寄存器). Reset value 0 selects GPIO10_4.

Data sheet 2.1.5 muxctrl_reg83 (offset 0x14C, printed page 2-96, `hi3516v100--Hi3516-Datasheet.txt` line 6849).";

        enum muxctrl_reg83_muxctrl_reg83_enum {
            GPIO10_4 = 0 { name = "Gpio10 4"; desc = "GPIO10_4"; };
            EPHY_CLK = 1 { name = "Ephy Clk"; desc = "EPHY_CLK"; };
        };

        field {
            name = "muxctrl_reg83";
            desc = "Function of the EPHY_CLK pin (DS: EPHY_CLK 管脚的具体复用情况).";
            sw = rw;
            hw = r;
            encode = muxctrl_reg83_muxctrl_reg83_enum;
            reset = 0x0;
        } muxctrl_reg83[0:0];
    } muxctrl_reg83 @ 0x14C;
};

`endif
