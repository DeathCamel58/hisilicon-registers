`ifndef EHI3535_SATA_PORT_RDL
`define EHI3535_SATA_PORT_RDL
regfile eHI3535_SATA_PORT {
    name = "SATA port configuration";
    desc = "SATA port configuration. 28 registers extracted programmatically from the Hi3535 H.264 codec processor (Hi3535 user guide) data sheet (Issue 00B08, 2014-02-25); chapter 13.8.7.2, table 13-19. Field names, bit ranges, access types and reset values are taken from the register tables; reset values are the data sheet total reset values split onto the fields (per-field values where the table has them). Label: PROVEN. Hardware not verified here (no board).";
    reg {
        name = "SATA_PORT_CLB";
        desc = "SATA_PORT_CLB is the command list base address register. SATA_PORT_CLB (offset 0x000+n x 0x80, total reset 0x0000_0000; PROVEN: Hi3535 data sheet, PDF page 1386, section 13.8.7.2). Per-port register (offset = 0x000+n x 0x80); instantiated as an array of 3 ports (SATA_GHC_CAP1.np = 0x02 means 3 ports, base 0x12010100, stride 0x80).";
        field {
            name = "port_clb";
            desc = "Sets the base address in memory of the port command list. Resetting the controller with the SATA_GHC_GHC[hab_rst] bit does not affect the value of this register.";
            sw = rw; hw = r;
            reset = 0x0;
        } port_clb[31:10];
        field {
            name = "reserved";
            desc = "Reserved.";
            sw = r; hw = w;
            reset = 0x0;
        } reserved_9_0[9:0];
    } SATA_PORT_CLB @ 0x0;
    reg {
        name = "SATA_PORT_FB";
        desc = "SATA_PORT_FB is the received FIS base address register. SATA_PORT_FB (offset 0x008+n x 0x80, total reset 0x0000_0000; PROVEN: Hi3535 data sheet, PDF page 1387, section 13.8.7.2). Per-port register (offset = 0x008+n x 0x80); instantiated as an array of 3 ports (SATA_GHC_CAP1.np = 0x02 means 3 ports, base 0x12010100, stride 0x80).";
        field {
            name = "port_fb";
            desc = "Sets the base address in memory where the port's received frames are stored. Resetting the controller with the SATA_GHC_GHC[hab_rst] bit does not affect this register value.";
            sw = rw; hw = r;
            reset = 0x0;
        } port_fb[31:8];
        field {
            name = "reserved";
            desc = "Reserved.";
            sw = r; hw = w;
            reset = 0x0;
        } reserved_7_0[7:0];
    } SATA_PORT_FB @ 0x8;
    reg {
        name = "SATA_PORT_IS";
        desc = "SATA_PORT_IS is the port interrupt status register. SATA_PORT_IS (offset 0x010+n x 0x80, total reset 0x0000_0000; PROVEN: Hi3535 data sheet, PDF page 1387, section 13.8.7.2). Per-port register (offset = 0x010+n x 0x80); instantiated as an array of 3 ports (SATA_GHC_CAP1.np = 0x02 means 3 ports, base 0x12010100, stride 0x80).";
        field {
            name = "reserved";
            desc = "Reserved.";
            sw = r; hw = w;
            reset = 0x0;
        } reserved_31_31[31:31];
        field {
            name = "pxis_tfes";
            desc = "TFD error interrupt status.
- 0: SATA_PORT_TFD bit[0] being 1 was not detected.
- 1: SATA_PORT_TFD bit[0] being 1 was detected. (data sheet access type WC)";
            sw = rw; hw = r; onwrite = woclr;
            reset = 0x0;
        } pxis_tfes[30:30];
        field {
            name = "reserved";
            desc = "Reserved.";
            sw = r; hw = w;
            reset = 0x0;
        } reserved_29_29[29:29];
        field {
            name = "pxis_hbds";
            desc = "Internal bus error interrupt.
- 0: The DMAC accessed memory normally.
- 1: An error occurred when the DMAC accessed memory. (data sheet access type WC)";
            sw = rw; hw = r; onwrite = woclr;
            reset = 0x0;
        } pxis_hbds[28:28];
        field {
            name = "pxis_ifs";
            desc = "Fatal error interrupt status.
- 0: No error occurred during data frame transfer.
- 1: An error occurred during data frame transfer. (data sheet access type WC)";
            sw = rw; hw = r; onwrite = woclr;
            reset = 0x0;
        } pxis_ifs[27:27];
        field {
            name = "pxis_infs";
            desc = "Non-fatal error interrupt status.
- 0: No error occurred during a non-data frame transfer;
- 1: An error occurred during a non-data frame transfer. (data sheet access type WC)";
            sw = rw; hw = r; onwrite = woclr;
            reset = 0x0;
        } pxis_infs[26:26];
        field {
            name = "reserved";
            desc = "Reserved.";
            sw = r; hw = w;
            reset = 0x0;
        } reserved_25_25[25:25];
        field {
            name = "pxis_ofs";
            desc = "Data transfer overflow interrupt status.
- 0: No overflow condition detected.
- 1: During data frame transfer, if the data memory space occupied by the command is detected to be smaller than the actual amount of data transferred, an interrupt is reported at the end of the data transfer. (data sheet access type WC)";
            sw = rw; hw = r; onwrite = woclr;
            reset = 0x0;
        } pxis_ofs[24:24];
        field {
            name = "pxis_ipms";
            desc = "PM port error interrupt status.
- 0: No PM port number error detected in a received frame;
- 1: A PM port number error was detected when receiving a frame. (data sheet access type WC)";
            sw = rw; hw = r; onwrite = woclr;
            reset = 0x0;
        } pxis_ipms[23:23];
        field {
            name = "pxis_prcs";
            desc = "PHY state change interrupt status.
- 0: No change of the phyrdy signal detected;
- 1: A change of the phyrdy signal detected. This bit directly reflects the SATA_PORT_SERR[diag_n] bit.";
            sw = r; hw = w;
            reset = 0x0;
        } pxis_prcs[22:22];
        field {
            name = "reserved";
            desc = "Reserved.";
            sw = r; hw = w;
            reset = 0x0;
        } reserved_21_7[21:7];
        field {
            name = "pxis_pcs";
            desc = "Port connection change interrupt status.
- 0: No COMINIT signal from the device was detected.
- 1: A COMINIT signal sent by the device was detected. This bit directly reflects the SATA_PORT_SERR[diag.x] bit.";
            sw = r; hw = w;
            reset = 0x0;
        } pxis_pcs[6:6];
        field {
            name = "pxis_dps";
            desc = "Linked list end interrupt status.
- 0: No linked list data transfer with the PRD \"I\" bit set to 1 completed.
- 1: The linked list data with the PRD \"I\" bit set to 1 was transferred normally. (data sheet access type WC)";
            sw = rw; hw = r; onwrite = woclr;
            reset = 0x0;
        } pxis_dps[5:5];
        field {
            name = "pxis_ufs";
            desc = "Unknown FIS interrupt status.
- 0: No Unknown FIS received;
- 1: An Unknown FIS was received.";
            sw = r; hw = w;
            reset = 0x0;
        } pxis_ufs[4:4];
        field {
            name = "pxis_sdbs";
            desc = "Set Device Bits FIS interrupt status.
- 0: No effect;
- 1: A Set Device Bits FIS with the I bit set to 1 was received. (data sheet access type WC)";
            sw = rw; hw = r; onwrite = woclr;
            reset = 0x0;
        } pxis_sdbs[3:3];
        field {
            name = "pxis_dss";
            desc = "DMA Setup FIS interrupt status.
- 0: No meaning.
- 1: A DMA Setup FIS with the I bit set to 1 was received. (data sheet access type WC)";
            sw = rw; hw = r; onwrite = woclr;
            reset = 0x0;
        } pxis_dss[2:2];
        field {
            name = "pxis_pss";
            desc = "PIO Setup FIS interrupt status.
- 0: No meaning;
- 1: A PIO Setup FIS with the I bit set to 1 was received. (data sheet access type WC)";
            sw = rw; hw = r; onwrite = woclr;
            reset = 0x0;
        } pxis_pss[1:1];
        field {
            name = "pxis_dhrs";
            desc = "D2H Register FIS interrupt status.
- 0: No meaning;
- 1: A D2H Register FIS with the I bit set to 1 was received. (data sheet access type WC)";
            sw = rw; hw = r; onwrite = woclr;
            reset = 0x0;
        } pxis_dhrs[0:0];
    } SATA_PORT_IS @ 0x10;
    reg {
        name = "SATA_PORT_IE";
        desc = "SATA_PORT_IE is the port interrupt mask register. SATA_PORT_IE (offset 0x014+n x 0x80, total reset 0x0000_0000; PROVEN: Hi3535 data sheet, PDF page 1389, section 13.8.7.2). Per-port register (offset = 0x014+n x 0x80); instantiated as an array of 3 ports (SATA_GHC_CAP1.np = 0x02 means 3 ports, base 0x12010100, stride 0x80).";
        field {
            name = "reserved";
            desc = "Reserved.";
            sw = r; hw = w;
            reset = 0x0;
        } reserved_31_31[31:31];
        field {
            name = "pxie_tfee";
            desc = "TFD error interrupt mask.
- 0: Masked.
- 1: Not masked.";
            sw = rw; hw = r;
            reset = 0x0;
        } pxie_tfee[30:30];
        field {
            name = "reserved";
            desc = "Reserved.";
            sw = r; hw = w;
            reset = 0x0;
        } reserved_29_29[29:29];
        field {
            name = "pxie_hbde";
            desc = "Internal bus error interrupt mask.
- 0: Masked;
- 1: Not masked.";
            sw = rw; hw = r;
            reset = 0x0;
        } pxie_hbde[28:28];
        field {
            name = "pxie_ife";
            desc = "Fatal error interrupt mask.
- 0: Masked.
- 1: Not masked.";
            sw = rw; hw = r;
            reset = 0x0;
        } pxie_ife[27:27];
        field {
            name = "pxie_infe";
            desc = "Non-fatal error interrupt mask.
- 0: Masked;
- 1: Not masked.";
            sw = rw; hw = r;
            reset = 0x0;
        } pxie_infe[26:26];
        field {
            name = "reserved";
            desc = "Reserved.";
            sw = r; hw = w;
            reset = 0x0;
        } reserved_25_25[25:25];
        field {
            name = "pxie_ofe";
            desc = "Data transfer overflow interrupt mask.
- 0: Masked;
- 1: Not masked.";
            sw = rw; hw = r;
            reset = 0x0;
        } pxie_ofe[24:24];
        field {
            name = "pxie_ipme";
            desc = "PM port error interrupt mask.
- 0: Masked;
- 1: Not masked.";
            sw = rw; hw = r;
            reset = 0x0;
        } pxie_ipme[23:23];
        field {
            name = "pxie_prce";
            desc = "PHY status change interrupt mask.
- 0: Masked.
- 1: Not masked.";
            sw = rw; hw = r;
            reset = 0x0;
        } pxie_prce[22:22];
        field {
            name = "reserved";
            desc = "Reserved.";
            sw = r; hw = w;
            reset = 0x0;
        } reserved_21_7[21:7];
        field {
            name = "pxie_pce";
            desc = "Port connect change interrupt mask.
- 0: Masked;
- 1: Not masked.";
            sw = rw; hw = r;
            reset = 0x0;
        } pxie_pce[6:6];
        field {
            name = "pxie_dpe";
            desc = "Linked list end interrupt mask.
- 0: Masked;
- 1: Not masked.";
            sw = rw; hw = r;
            reset = 0x0;
        } pxie_dpe[5:5];
        field {
            name = "pxie_ufe";
            desc = "Unknown FIS interrupt mask.
- 0: Masked.
- 1: Not masked.";
            sw = rw; hw = r;
            reset = 0x0;
        } pxie_ufe[4:4];
        field {
            name = "pxie_sdbe";
            desc = "Set Device Bits FIS interrupt mask.
- 0: Masked.
- 1: Not masked.";
            sw = rw; hw = r;
            reset = 0x0;
        } pxie_sdbe[3:3];
        field {
            name = "pxie_dse";
            desc = "DMA Setup FIS interrupt mask.
- 0: Masked.
- 1: Not masked.";
            sw = rw; hw = r;
            reset = 0x0;
        } pxie_dse[2:2];
        field {
            name = "pxie_pse";
            desc = "PIO Setup FIS interrupt mask.
- 0: Masked.
- 1: Not masked.";
            sw = rw; hw = r;
            reset = 0x0;
        } pxie_pse[1:1];
        field {
            name = "pxie_dhre";
            desc = "D2H Register FIS interrupt mask.
- 0: Masked.
- 1: Not masked.";
            sw = rw; hw = r;
            reset = 0x0;
        } pxie_dhre[0:0];
    } SATA_PORT_IE @ 0x14;
    reg {
        name = "SATA_PORT_CMD";
        desc = "SATA_PORT_CMD is the port command and status register. SATA_PORT_CMD (offset 0x018+n x 0x80, total reset 0x0060_0000; PROVEN: Hi3535 data sheet, PDF page 1391, section 13.8.7.2). Per-port register (offset = 0x018+n x 0x80); instantiated as an array of 3 ports (SATA_GHC_CAP1.np = 0x02 means 3 ports, base 0x12010100, stride 0x80). Data sheet inconsistency: the bit diagram also shows reserved bit 2 as 1 (0x0060_0004); the total reset value 0x0060_0000 is used here.";
        field {
            name = "cmd_icc";
            desc = "Interface communication control signal.
- 0x0: No operation, indicating that the next interface state request can be made;
- 0x1: Request the interface to enter the active state;
- 0x2: Request the interface to enter the partial state;
- 0x6: Request the interface to enter the slumber state; Others: Reserved. When software writes one of the non-reserved values above, the controller performs the corresponding operation and then clears cmd_icc to 0; when software requests the interface to enter the state it is already in, the controller clears cmd_icc to 0 directly; if software requests the interface to go from one low-power mode to another, for example from partial to slumber, software should first request the interface to go from the partial state to the active state, and then request it to go from the active state to the slumber state.";
            sw = rw; hw = r;
            reset = 0x0;
        } cmd_icc[31:28];
        field {
            name = "cmd_asp";
            desc = "Select the power management state to enter actively, Slumber/Partial.
- 0: Actively enter the partial state;
- 1: Actively enter the slumber state.";
            sw = rw; hw = r;
            reset = 0x0;
        } cmd_asp[27:27];
        field {
            name = "cmd_alpe";
            desc = "Automatic power management enable.
- 0: Disable;
- 1: Enable. Once SATA_PORT_CI and SATA_PORT_SACT are cleared to 0, the controller automatically enters a power management state: partial if cmd_asp is 1, slumber if cmd_asp is 0.";
            sw = rw; hw = r;
            reset = 0x0;
        } cmd_alpe[26:26];
        field {
            name = "cmd_dlae";
            desc = "LED drive enable in ATAPI mode.
- 0: The LED pin is driven when cmd_atapi is 0 and a command is being executed.
- 1: The LED pin is driven whenever a command is being executed.";
            sw = rw; hw = r;
            reset = 0x0;
        } cmd_dlae[25:25];
        field {
            name = "cmd_atapi";
            desc = "ATAPI device indication.
- 0: The current device is not an ATAPI device;
- 1: The current device is an ATAPI device.";
            sw = rw; hw = r;
            reset = 0x0;
        } cmd_atapi[24:24];
        field {
            name = "reserved";
            desc = "Reserved.";
            sw = r; hw = w;
            reset = 0x0;
        } reserved_23_23[23:23];
        field {
            name = "fbscp";
            desc = "Whether this port supports FIS-based Switching. This bit must be set to 1 when both CAP.SPM and CAP.FBSS are set to 1.
- 0: Not supported;
- 1: Supported.";
            sw = r; hw = w;
            reset = 0x1;
        } fbscp[22:22];
        field {
            name = "cmd_esp";
            desc = "Always 1, indicating support for External SATA devices.";
            sw = r; hw = w;
            reset = 0x1;
        } cmd_esp[21:21];
        field {
            name = "reserved";
            desc = "Reserved.";
            sw = r; hw = w;
            reset = 0x0;
        } reserved_20_18[20:18];
        field {
            name = "cmd_pma";
            desc = "Port Multiplier device identification indication.
- 0: No Port Multiplier device is connected to the port.
- 1: A Port Multiplier device is connected to the port.";
            sw = rw; hw = r;
            reset = 0x0;
        } cmd_pma[17:17];
        field {
            name = "reserved";
            desc = "Reserved.";
            sw = r; hw = w;
            reset = 0x0;
        } reserved_16_16[16:16];
        field {
            name = "cmd_cr";
            desc = "Command list processing indication signal.
- 0: No command is executing;
- 1: A command is executing.";
            sw = r; hw = w;
            reset = 0x0;
        } cmd_cr[15:15];
        field {
            name = "cmd_fr";
            desc = "FIS receive processing indication signal.
- 0: No FIS is being received.
- 1: A FIS is being received.";
            sw = r; hw = w;
            reset = 0x0;
        } cmd_fr[14:14];
        field {
            name = "reserved";
            desc = "Reserved.";
            sw = r; hw = w;
            reset = 0x0;
        } reserved_13_13[13:13];
        field {
            name = "cmd_ccs";
            desc = "Current command slot number. This bit is valid when cmd_st is 1 and is cleared when cmd_st is 0.";
            sw = r; hw = w;
            reset = 0x0;
        } cmd_ccs[12:8];
        field {
            name = "reserved";
            desc = "Reserved.";
            sw = r; hw = w;
            reset = 0x0;
        } reserved_7_5[7:5];
        field {
            name = "cmd_fre";
            desc = "FIS receive enable control signal.
- 0: Writing received FIS to system memory is disabled;
- 1: Receiving FIS and writing it to system memory is enabled.
Software must set the receive FIS base address SATA_PORT_FB before enabling this bit to receive FIS; this bit must be 1 while cmd_st is 1.";
            sw = rw; hw = r;
            reset = 0x0;
        } cmd_fre[4:4];
        field {
            name = "cmd_clo";
            desc = "Busy/Drq clear control. Software can use this bit to force-clear BSY and DRQ and send a command to the device.
- 0: No effect;
- 1: Clears the BSY and DRQ bits of the SATA_PORT_TFD[tfd_sts] register. The bit clears itself after BSY and DRQ become 0. This bit may only be written to 1 immediately before cmd_st is set from 0 to 1, and software must write 1 to cmd_st after this bit is cleared.";
            sw = rw; hw = r;
            reset = 0x0;
        } cmd_clo[3:3];
        field {
            name = "reserved";
            desc = "Reserved.";
            sw = r; hw = w;
            reset = 0x0;
        } reserved_2_2[2:2];
        field {
            name = "cmd_sud";
            desc = "Spin-up device control.
- 0: When SATA_PORT_SCTL[det] is 0, the controller enters listen mode;
- 1: After system power-up or HBA reset, the controller starts sending the COMRESET sequence to initialize the hard disk device.";
            sw = rw; hw = r;
            reset = 0x0;
        } cmd_sud[1:1];
        field {
            name = "cmd_st";
            desc = "Command list processing enable.
- 0: The controller enters the idle state.
- 1: The controller starts from slot 0 and processes the commands of the slots marked valid in the SATA_PORT_CI register. cmd_st can be set to 1 only after cmd_fre is 1.";
            sw = rw; hw = r;
            reset = 0x0;
        } cmd_st[0:0];
    } SATA_PORT_CMD @ 0x18;
    reg {
        name = "SATA_PORT_TFD";
        desc = "SATA_PORT_TFD is the port task file register. SATA_PORT_TFD (offset 0x20+n x 0x80, total reset 0x0000_007F; PROVEN: Hi3535 data sheet, PDF page 1393, section 13.8.7.2). Per-port register (offset = 0x20+n x 0x80); instantiated as an array of 3 ports (SATA_GHC_CAP1.np = 0x02 means 3 ports, base 0x12010100, stride 0x80).";
        field {
            name = "reserved";
            desc = "Reserved.";
            sw = r; hw = w;
            reset = 0x0;
        } reserved_31_16[31:16];
        field {
            name = "tfd_err";
            desc = "Task file error register value. The controller updates this register bit when it receives a D2H register/PIO setup/SDB FIS.";
            sw = r; hw = w;
            reset = 0x0;
        } tfd_err[15:8];
        field {
            name = "tfd_sts";
            desc = "Task file status register value. bit[7]: BSY bit, indicates the device is busy. bit[6:4]: Meaning differs by command. bit[3]: DRQ bit, indicates the device has data to transfer. bit[2:1]: Meaning differs by command. bit[0]: ERR bit, indicates the device encountered an error during the transfer. The controller updates these register bits when it receives a D2H register/PIO setup/SDB FIS.";
            sw = r; hw = w;
            reset = 0x7f;
        } tfd_sts[7:0];
    } SATA_PORT_TFD @ 0x20;
    reg {
        name = "SATA_PORT_SIG";
        desc = "SATA_PORT_SIG is the port signature register. SATA_PORT_SIG (offset 0x24+n x 0x80, total reset 0xFFFF_FFFF; PROVEN: Hi3535 data sheet, PDF page 1394, section 13.8.7.2). Per-port register (offset = 0x24+n x 0x80); instantiated as an array of 3 ports (SATA_GHC_CAP1.np = 0x02 means 3 ports, base 0x12010100, stride 0x80).";
        field {
            name = "signature";
            desc = "LBA address and sector addressing. The allocation is as follows: bit[31:24]: LBA high address; bit[23:16]: LBA middle address; bit[15:8]: LBA low address; bit[7:0]: sector count. This register is updated by the first D2H register FIS after the hard disk device is reset.";
            sw = r; hw = w;
            reset = 0xffffffff;
        } signature[31:0];
    } SATA_PORT_SIG @ 0x24;
    reg {
        name = "SATA_PORT_SSTS";
        desc = "SATA_PORT_SSTS is the interface status register. SATA_PORT_SSTS (offset 0x028+n x 0x80, total reset 0x0000_0000; PROVEN: Hi3535 data sheet, PDF page 1394, section 13.8.7.2). Per-port register (offset = 0x028+n x 0x80); instantiated as an array of 3 ports (SATA_GHC_CAP1.np = 0x02 means 3 ports, base 0x12010100, stride 0x80).";
        field {
            name = "reserved";
            desc = "Reserved.";
            sw = r; hw = w;
            reset = 0x0;
        } reserved_31_12[31:12];
        field {
            name = "pxssts_ipm";
            desc = "Current interface status.
- 0x0: No device, or communication not established;
- 0x1: Active state;
- 0x2: Partial state;
- 0x6: Slumber state;
Other values: reserved.";
            sw = r; hw = w;
            reset = 0x0;
        } pxssts_ipm[11:8];
        field {
            name = "pxssts_spd";
            desc = "Interface negotiated speed status.
- 0x0: No device or communication not established;
- 0x1: Communication negotiated at speed 1;
- 0x2: Communication negotiated at speed 2;
- 0x3: Communication negotiated at speed 3; Others: Reserved.";
            sw = r; hw = w;
            reset = 0x0;
        } pxssts_spd[7:4];
        field {
            name = "pxssts_det";
            desc = "Device detection and PHY status.
- 0x0: No device detected and PHY communication not established.
- 0x1: Device detected but PHY communication not established.
- 0x3: Device detected and PHY communication established.
- 0x4: PHY is offline or in BIST state. Others: Reserved.";
            sw = r; hw = w;
            reset = 0x0;
        } pxssts_det[3:0];
    } SATA_PORT_SSTS @ 0x28;
    reg {
        name = "SATA_PORT_SCTL";
        desc = "SATA_PORT_SCTL is the interface control register. SATA_PORT_SCTL (offset 0x02C+n x 0x80, total reset 0x0000_0000; PROVEN: Hi3535 data sheet, PDF page 1395, section 13.8.7.2). Per-port register (offset = 0x02C+n x 0x80); instantiated as an array of 3 ports (SATA_GHC_CAP1.np = 0x02 means 3 ports, base 0x12010100, stride 0x80).";
        field {
            name = "reserved";
            desc = "Reserved.";
            sw = r; hw = w;
            reset = 0x0;
        } reserved_31_12[31:12];
        field {
            name = "pxsctl_ipm";
            desc = "Interface power management state control.
- 0x0: No special requirement;
- 0x1: Entering the Partial state is prohibited;
- 0x2: Entering the Slumber state is prohibited;
- 0x3: Entering the Partial or Slumber state is prohibited;
Other values: reserved.";
            sw = rw; hw = r;
            reset = 0x0;
        } pxsctl_ipm[11:8];
        field {
            name = "pxsctl_spd";
            desc = "Interface communication speed control.
- 0x0: No special requirement.
- 0x1: Limit communication to speed 1.
- 0x2: Limit communication to speed 2.
- 0x3: Limit communication to speed 3. Others: Reserved.";
            sw = rw; hw = r;
            reset = 0x0;
        } pxsctl_spd[7:4];
        field {
            name = "pxsctl_det";
            desc = "Device detection and interface initialization control.
- 0x0: No device detection or initialization request.
- 0x1: Request the interface to perform the reset initialization sequence COMRESET.
- 0x4: Force the interface into the offline state. Others: Reserved. When pxsctl_det is set to 1, the controller sends a COMRESET sequence to the device; software should keep this bit at 1 for at least 1 ms to ensure the device receives the

COMRESET sequence.";
            sw = rw; hw = r;
            reset = 0x0;
        } pxsctl_det[3:0];
    } SATA_PORT_SCTL @ 0x2c;
    reg {
        name = "SATA_PORT_SERR";
        desc = "SATA_PORT_SERR is the error diagnostic status register. SATA_PORT_SERR (offset 0x30+n x 0x80, total reset 0x0000_0000; PROVEN: Hi3535 data sheet, PDF page 1396, section 13.8.7.2). Per-port register (offset = 0x30+n x 0x80); instantiated as an array of 3 ports (SATA_GHC_CAP1.np = 0x02 means 3 ports, base 0x12010100, stride 0x80).";
        field {
            name = "reserved";
            desc = "Reserved.";
            sw = r; hw = w;
            reset = 0x0;
        } reserved_31_27[31:27];
        field {
            name = "diag_x";
            desc = "Device detection status.
- 0: No COMINIT signal from the device detected;
- 1: A COMINIT signal from the device was detected. (data sheet access type WC)";
            sw = rw; hw = r; onwrite = woclr;
            reset = 0x0;
        } diag_x[26:26];
        field {
            name = "diag_f";
            desc = "Unknown FIS detection status.
- 0: No Unknown FIS received.
- 1: Set to 1 when an Unknown FIS is received and its CRC check is correct. (data sheet access type WC)";
            sw = rw; hw = r; onwrite = woclr;
            reset = 0x0;
        } diag_f[25:25];
        field {
            name = "reserved";
            desc = "Reserved.";
            sw = r; hw = w;
            reset = 0x0;
        } reserved_24_24[24:24];
        field {
            name = "diag_s";
            desc = "Link layer error status.
- 0: No state transition error occurred in the link layer.
- 1: A state transition error occurred in the link layer. (data sheet access type WC)";
            sw = rw; hw = r; onwrite = woclr;
            reset = 0x0;
        } diag_s[23:23];
        field {
            name = "diag_h";
            desc = "Handshake error status.
- 0: No R_ERR primitive received from the device;
- 1: One or more R_ERR primitives received from the device. (data sheet access type WC)";
            sw = rw; hw = r; onwrite = woclr;
            reset = 0x0;
        } diag_h[22:22];
        field {
            name = "diag_c";
            desc = "CRC error status.
- 0: No CRC error occurred in a received FIS;
- 1: CRC error in a received FIS. (data sheet access type WC)";
            sw = rw; hw = r; onwrite = woclr;
            reset = 0x0;
        } diag_c[21:21];
        field {
            name = "reserved";
            desc = "Reserved.";
            sw = r; hw = w;
            reset = 0x0;
        } reserved_20_20[20:20];
        field {
            name = "diag_b";
            desc = "Decode error status.
- 0: No 10B to 8B decode error detected;
- 1: 10B to 8B decode error detected. (data sheet access type WC)";
            sw = rw; hw = r; onwrite = woclr;
            reset = 0x0;
        } diag_b[19:19];
        field {
            name = "diag_w";
            desc = "COMWAKE status.
- 0: No COMWAKE signal from the device is detected.
- 1: A COMWAKE signal from the device is detected. (data sheet access type WC)";
            sw = rw; hw = r; onwrite = woclr;
            reset = 0x0;
        } diag_w[18:18];
        field {
            name = "diag_i";
            desc = "PHY internal error status.
- 0: No PHY internal error detected;
- 1: PHY internal error detected. (data sheet access type WC)";
            sw = rw; hw = r; onwrite = woclr;
            reset = 0x0;
        } diag_i[17:17];
        field {
            name = "diag_n";
            desc = "PhyRdy signal change status.
- 0: The PhyRdy signal has not changed.
- 1: The PhyRdy signal has changed. Set to 1 when the PhyRdy signal changes from 1 to 0 or from 0 to 1. (data sheet access type WC)";
            sw = rw; hw = r; onwrite = woclr;
            reset = 0x0;
        } diag_n[16:16];
        field {
            name = "reserved";
            desc = "Reserved.";
            sw = r; hw = w;
            reset = 0x0;
        } reserved_15_11[15:11];
        field {
            name = "err_p";
            desc = "SATA protocol violation error status.
- 0: No device behavior violating the SATA protocol detected;
- 1: Device behavior violating the SATA protocol detected. (data sheet access type WC)";
            sw = rw; hw = r; onwrite = woclr;
            reset = 0x0;
        } err_p[10:10];
        field {
            name = "reserved";
            desc = "Reserved.";
            sw = r; hw = w;
            reset = 0x0;
        } reserved_9_9[9:9];
        field {
            name = "err_t";
            desc = "Data integrity error status.
- 0: No data integrity error detected;
- 1: Data integrity error detected. (data sheet access type WC)";
            sw = rw; hw = r; onwrite = woclr;
            reset = 0x0;
        } err_t[8:8];
        field {
            name = "reserved";
            desc = "Reserved.";
            sw = r; hw = w;
            reset = 0x0;
        } reserved_7_0[7:0];
    } SATA_PORT_SERR @ 0x30;
    reg {
        name = "SATA_PORT_SACT";
        desc = "SATA_PORT_SACT is the NCQ command tag control register. SATA_PORT_SACT (offset 0x034+n x 0x80, total reset 0x0000_0000; PROVEN: Hi3535 data sheet, PDF page 1398, section 13.8.7.2). Per-port register (offset = 0x034+n x 0x80); instantiated as an array of 3 ports (SATA_GHC_CAP1.np = 0x02 means 3 ports, base 0x12010100, stride 0x80).";
        field {
            name = "port_sact";
            desc = "NCQ command tag control register. Each bit of this register corresponds to a tag number and an NCQ command in memory; bit[31:0] correspond to the commands of slot31 to slot0 and to tag31 to tag0. Taking bit[3] as an example, the meaning of each bit is:
- 0: The slot3 command is a non-NCQ command.
- 1: The slot3 command is an NCQ command. Software must set bit[3] of this register before setting the SATA_PORT_CI[3] bit. After the command data transfer completes, the device sends an SDB FIS, and the controller clears bit[3] according to SActive in the FIS. Software can set this register only when cmd_st is 1; it is entirely cleared when cmd_st is 0.";
            sw = rw; hw = r;
            reset = 0x0;
        } port_sact[31:0];
    } SATA_PORT_SACT @ 0x34;
    reg {
        name = "SATA_PORT_CI";
        desc = "SATA_PORT_CI is the command issue control register. SATA_PORT_CI (offset 0x38+n x 0x80, total reset 0x0000_0000; PROVEN: Hi3535 data sheet, PDF page 1399, section 13.8.7.2). Per-port register (offset = 0x38+n x 0x80); instantiated as an array of 3 ports (SATA_GHC_CAP1.np = 0x02 means 3 ports, base 0x12010100, stride 0x80).";
        field {
            name = "port_ci";
            desc = "Command pending-to-send control. Each bit of this register represents one command in memory; bit[31:0] correspond to the commands of slot31 to slot0. Taking bit[3] as an example, the meaning of each bit is:
- 0: Slot3 has no command waiting to be sent or executed;
- 1: The slot3 command has been built in memory and the controller can send this command; when the controller finishes executing the command, receives the corresponding FIS and clears the BSY, DRQ and ERR bits of the SATA_PORT_TFD register, bit[3] is also cleared.

The bits of this register can be set only when cmd_st is 1, and are all cleared when cmd_st is 0.";
            sw = rw; hw = r;
            reset = 0x0;
        } port_ci[31:0];
    } SATA_PORT_CI @ 0x38;
    reg {
        name = "SATA_PORT_SNTF";
        desc = "SATA_PORT_SNTF is the asynchronous notification event indication register. SATA_PORT_SNTF (offset 0x3C+n x 0x80, total reset 0x0000_0000; PROVEN: Hi3535 data sheet, PDF page 1399, section 13.8.7.2). Per-port register (offset = 0x3C+n x 0x80); instantiated as an array of 3 ports (SATA_GHC_CAP1.np = 0x02 means 3 ports, base 0x12010100, stride 0x80).";
        field {
            name = "reserved";
            desc = "Reserved.";
            sw = r; hw = w;
            reset = 0x0;
        } reserved_31_16[31:16];
        field {
            name = "pxsntf_pmn";
            desc = "Asynchronous notification event status. If the controller receives an SDB FIS from a device behind the PM and the \"N\" bit of that FIS is 1, the register bit corresponding to the device PM port number is set to 1. Taking bit[3] as an example, the meaning of each bit is:
- 0: No asynchronous notification event occurred for the device with PM port number 3.
- 1: An asynchronous notification event occurred for the device with PM port number 3. (data sheet access type WC)";
            sw = rw; hw = r; onwrite = woclr;
            reset = 0x0;
        } pxsntf_pmn[15:0];
    } SATA_PORT_SNTF @ 0x3c;
    reg {
        name = "SATA_PORT_FBS";
        desc = "SATA_PORT_FBS is the FIS-Based Switching control register. SATA_PORT_FBS (offset 0x40+nx0x80, total reset 0x0000_F000; PROVEN: Hi3535 data sheet, PDF page 1400, section 13.8.7.2). Per-port register (offset = 0x40+nx0x80); instantiated as an array of 3 ports (SATA_GHC_CAP1.np = 0x02 means 3 ports, base 0x12010100, stride 0x80).";
        field {
            name = "reserved";
            desc = "Reserved.";
            sw = r; hw = w;
            reset = 0x0;
        } reserved_31_20[31:20];
        field {
            name = "fbs_dwe";
            desc = "Set by hardware to indicate that a fatal error occurred on the device attached to the current PM port. This field is valid only when PxFBS.SDE is 1.";
            sw = r; hw = w;
            reset = 0x0;
        } fbs_dwe[19:16];
        field {
            name = "fbs_ado";
            desc = "Set by hardware; indicates the maximum number of PM attached devices the current FIS-base Switch can support. For best performance, when building commands software should keep the number of PM ports addressed by a command below this value.";
            sw = r; hw = w;
            reset = 0xf;
        } fbs_ado[15:12];
        field {
            name = "fbs_dev";
            desc = "Set by software; indicates the PM port number to which the next command should be sent. Software must not send commands to multiple PM port numbers, so when a CI is built, commands to multiple PM ports cannot be set up; the same CI must use the same PM port.";
            sw = rw; hw = r;
            reset = 0x0;
        } fbs_dev[11:8];
        field {
            name = "reserved";
            desc = "Reserved.";
            sw = r; hw = w;
            reset = 0x0;
        } reserved_7_3[7:3];
        field {
            name = "fbs_sde";
            desc = "When set to 1, indicates that a fatal error has occurred, and the hardware should assume that software will handle this error with priority. To clear it to 0, software must clear PxCMD.ST to 0. This bit should be cleared to 0 when PxFBS.DEC is set to 1 or when PxCMD.ST is cleared to 0.";
            sw = r; hw = w;
            reset = 0x0;
        } fbs_sde[2:2];
        field {
            name = "fbs_dec";
            desc = "When software sets this bit to 1, the HBA clears the condition corresponding to the error and also clears the outstanding commands of the corresponding Device, including clearing the PxCI and PxSACT of that Device. When the hardware completes error recovery, it clears this bit to 0. Writing 0 to this bit has no effect. Software may set this bit to 1 only when both PxFBS.EN and PxFBS.SDE are set to 1.";
            sw = rw; hw = r;
            reset = 0x0;
        } fbs_dec[1:1];
        field {
            name = "fbs_en";
            desc = "When set to 1, a PM is currently attached and the HBA should use FIS-Base Switching to communicate with it. When cleared to 0, FIS-Base Switching cannot be used. Software may modify this bit only when PxCMD.ST is 0.";
            sw = rw; hw = r;
            reset = 0x0;
        } fbs_en[0:0];
    } SATA_PORT_FBS @ 0x40;
    reg {
        name = "SATA_PORT_FIFOTH";
        desc = "SATA_PORT_FIFOTH is the receive FIFO watermark register. SATA_PORT_FIFOTH (offset 0x044+n x 0x80, total reset 0x0001_9F24; PROVEN: Hi3535 data sheet, PDF page 1401, section 13.8.7.2). Per-port register (offset = 0x044+n x 0x80); instantiated as an array of 3 ports (SATA_GHC_CAP1.np = 0x02 means 3 ports, base 0x12010100, stride 0x80).";
        field {
            name = "reserved";
            desc = "Reserved.";
            sw = rw; hw = r;
            reset = 0x0;
        } reserved_31_18[31:18];
        field {
            name = "mem_ctrl";
            desc = "Controls the timing parameters of the Mem. [13:11]: corresponds to EMAA in the mem; [14]: corresponds to EMSA in the mem; [17:15]: corresponds to EMAB in the mem.";
            sw = rw; hw = r;
            reset = 0x33;
        } mem_ctrl[17:11];
        field {
            name = "reserved";
            desc = "Reserved.";
            sw = r; hw = w;
            reset = 0x3;
        } reserved_10_9[10:9];
        field {
            name = "dmac_rxfifo_th";
            desc = "DMAC receive FIFO flow control watermark. When receiving data, the controller starts flow control if the amount of data in the DMAC FIFO exceeds this value.";
            sw = rw; hw = r;
            reset = 0x12;
        } dmac_rxfifo_th[8:4];
        field {
            name = "rxfifo_th_sel";
            desc = "Flow control FIFO selection.
- 0: Link receive FIFO flow control is active;
- 1: DMAC receive FIFO flow control is active.";
            sw = rw; hw = r;
            reset = 0x0;
        } rxfifo_th_sel[3:3];
        field {
            name = "link_rxfifo_th";
            desc = "link receive FIFO flow control watermark. When receiving data, the controller starts flow control if the amount of data in the DMAC FIFO exceeds this value.";
            sw = rw; hw = r;
            reset = 0x4;
        } link_rxfifo_th[2:0];
    } SATA_PORT_FIFOTH @ 0x44;
    reg {
        name = "SATA_PORT_PHYCTL1";
        desc = "SATA_PORT_PHYCTL1 is PHY control register 1. SATA_PORT_PHYCTL1 (offset 0x048+nx0x80, total reset 0x002E_5CB8; PROVEN: Hi3535 data sheet, PDF page 1402, section 13.8.7.2). Per-port register (offset = 0x048+nx0x80); instantiated as an array of 3 ports (SATA_GHC_CAP1.np = 0x02 means 3 ports, base 0x12010100, stride 0x80).";
        field {
            name = "reserved";
            desc = "Reserved.";
            sw = r; hw = w;
            reset = 0x0;
        } reserved_31_28[31:28];
        field {
            name = "px_tx_invert";
            desc = "Whether polarity inversion in the transmit direction is allowed.
- 0: Not allowed;
- 1: Allowed.";
            sw = rw; hw = r;
            reset = 0x0;
        } px_tx_invert[27:27];
        field {
            name = "px_nearafelb";
            desc = "Set the loopback mode for BIST testing.";
            sw = rw; hw = r;
            reset = 0x0;
        } px_nearafelb[26:26];
        field {
            name = "px_bpr_reset";
            desc = "Reset in BIST mode.";
            sw = rw; hw = r;
            reset = 0x0;
        } px_bpr_reset[25:25];
        field {
            name = "px_rx_eq";
            desc = "Equalization setting in the receive direction.";
            sw = rw; hw = r;
            reset = 0x0;
        } px_rx_eq[24:22];
        field {
            name = "px_tx_amplitude_gen3";
            desc = "Transmit signal swing control in Gen3 mode.";
            sw = rw; hw = r;
            reset = 0x5c;
        } px_tx_amplitude_gen3[21:15];
        field {
            name = "px_tx_amplitude_gen2";
            desc = "Transmit signal swing control in Gen2 mode.";
            sw = rw; hw = r;
            reset = 0x5c;
        } px_tx_amplitude_gen2[14:8];
        field {
            name = "px_tx_amplitude_gen1";
            desc = "Transmit signal swing control in Gen1 mode.";
            sw = rw; hw = r;
            reset = 0x5c;
        } px_tx_amplitude_gen1[7:1];
        field {
            name = "px_rx_invert";
            desc = "Whether polarity inversion in the receive direction is allowed.
- 0: Not allowed;
- 1: Allowed.";
            sw = rw; hw = r;
            reset = 0x0;
        } px_rx_invert[0:0];
    } SATA_PORT_PHYCTL1 @ 0x48;
    reg {
        name = "SATA_PORT_PHYCTL2";
        desc = "SATA_PORT_PHYCTL2 is PHY control register 2. SATA_PORT_PHYCTL2 (offset 0x04C+nx0x80, total reset 0x0002_0555; PROVEN: Hi3535 data sheet, PDF page 1403, section 13.8.7.2). Per-port register (offset = 0x04C+nx0x80); instantiated as an array of 3 ports (SATA_GHC_CAP1.np = 0x02 means 3 ports, base 0x12010100, stride 0x80).";
        field {
            name = "reserved";
            desc = "Reserved.";
            sw = r; hw = w;
            reset = 0x0;
        } reserved_31_19[31:19];
        field {
            name = "px_reset";
            desc = "SerDes lane reset signal, asynchronous reset, active high.";
            sw = rw; hw = r;
            reset = 0x0;
        } px_reset[18:18];
        field {
            name = "px_tx_preemph_gen3";
            desc = "Transmit pre-emphasis control in Gen3 mode.";
            sw = rw; hw = r;
            reset = 0x20;
        } px_tx_preemph_gen3[17:12];
        field {
            name = "px_tx_preemph_gen2";
            desc = "Transmit pre-emphasis control in Gen2 mode.";
            sw = rw; hw = r;
            reset = 0x15;
        } px_tx_preemph_gen2[11:6];
        field {
            name = "px_tx_preemph_gen1";
            desc = "Transmit pre-emphasis control in Gen1 mode.";
            sw = rw; hw = r;
            reset = 0x15;
        } px_tx_preemph_gen1[5:0];
    } SATA_PORT_PHYCTL2 @ 0x4c;
    reg {
        name = "SATA_PORT_HBA";
        desc = "SATA_PORT_HBA is the HBA test status register. SATA_PORT_HBA (offset 0x050+n x 0x80, total reset 0x0100_0000; PROVEN: Hi3535 data sheet, PDF page 1403, section 13.8.7.2). Per-port register (offset = 0x050+n x 0x80); instantiated as an array of 3 ports (SATA_GHC_CAP1.np = 0x02 means 3 ports, base 0x12010100, stride 0x80).";
        field {
            name = "reserved";
            desc = "Reserved.";
            sw = r; hw = w;
            reset = 0x0;
        } reserved_31_28[31:28];
        field {
            name = "p_curr_st";
            desc = "Current state of the HBA_PINIT_STATE state machine.";
            sw = r; hw = w;
            reset = 0x1;
        } p_curr_st[27:24];
        field {
            name = "reserved";
            desc = "Reserved.";
            sw = r; hw = w;
            reset = 0x0;
        } reserved_23_21[23:21];
        field {
            name = "ndr_curr_st";
            desc = "Current state of the HBA_NDR_STATE state machine.";
            sw = r; hw = w;
            reset = 0x0;
        } ndr_curr_st[20:16];
        field {
            name = "cfis_curr_st";
            desc = "Current state of the HBA_CFIS_STATE state machine.";
            sw = r; hw = w;
            reset = 0x0;
        } cfis_curr_st[15:12];
        field {
            name = "reserved";
            desc = "Reserved.";
            sw = r; hw = w;
            reset = 0x0;
        } reserved_11_11[11:11];
        field {
            name = "pio_curr_st";
            desc = "Current state of the HBA_PIO_STATE state machine.";
            sw = r; hw = w;
            reset = 0x0;
        } pio_curr_st[10:8];
        field {
            name = "reserved";
            desc = "Reserved.";
            sw = r; hw = w;
            reset = 0x0;
        } reserved_7_7[7:7];
        field {
            name = "pm_curr_st";
            desc = "Current state of the HBA_PM_STATE state machine.";
            sw = r; hw = w;
            reset = 0x0;
        } pm_curr_st[6:4];
        field {
            name = "err_curr_st";
            desc = "Current state of the HBA_ERR_STATE state machine.";
            sw = r; hw = w;
            reset = 0x0;
        } err_curr_st[3:0];
    } SATA_PORT_HBA @ 0x50;
    reg {
        name = "SATA_PORT_LINK";
        desc = "SATA_PORT_LINK is the Link test status register. SATA_PORT_LINK (offset 0x054+n x 0x80, total reset 0x0020_2020; PROVEN: Hi3535 data sheet, PDF page 1404, section 13.8.7.2). Per-port register (offset = 0x054+n x 0x80); instantiated as an array of 3 ports (SATA_GHC_CAP1.np = 0x02 means 3 ports, base 0x12010100, stride 0x80). Data sheet inconsistency: the bit diagram shows link_curr_st = 0x3 (0x0320_2020); the total reset value 0x0020_2020 (link_curr_st = 0) is used here.";
        field {
            name = "reserved";
            desc = "Reserved.";
            sw = r; hw = w;
            reset = 0x0;
        } reserved_31_29[31:29];
        field {
            name = "link_curr_st";
            desc = "Current state of the LINK_CTL_STATE state machine.";
            sw = r; hw = w;
            reset = 0x0;
        } link_curr_st[28:24];
        field {
            name = "reserved";
            desc = "Reserved.";
            sw = r; hw = w;
            reset = 0x0;
        } reserved_23_23[23:23];
        field {
            name = "link_df_fifo_full";
            desc = "Link frequency-difference elimination FIFO full flag.
- 0: FIFO not full;
- 1: FIFO full.";
            sw = r; hw = w;
            reset = 0x0;
        } link_df_fifo_full[22:22];
        field {
            name = "link_df_fifo_empty";
            desc = "Link frequency-difference elimination FIFO empty flag.
- 0: FIFO not empty;
- 1: FIFO empty.";
            sw = r; hw = w;
            reset = 0x1;
        } link_df_fifo_empty[21:21];
        field {
            name = "link_df_fifo_count";
            desc = "Link frequency-offset compensation FIFO data level.";
            sw = r; hw = w;
            reset = 0x0;
        } link_df_fifo_count[20:16];
        field {
            name = "reserved";
            desc = "Reserved.";
            sw = r; hw = w;
            reset = 0x0;
        } reserved_15_15[15:15];
        field {
            name = "link_rx_fifo_full";
            desc = "Link receive FIFO full flag.
- 0: FIFO not full;
- 1: FIFO full.";
            sw = r; hw = w;
            reset = 0x0;
        } link_rx_fifo_full[14:14];
        field {
            name = "link_rx_fifo_empty";
            desc = "Link receive FIFO empty flag.
- 0: FIFO not empty.
- 1: FIFO empty.";
            sw = r; hw = w;
            reset = 0x1;
        } link_rx_fifo_empty[13:13];
        field {
            name = "link_rx_fifo_count";
            desc = "Link receive FIFO data level.";
            sw = r; hw = w;
            reset = 0x0;
        } link_rx_fifo_count[12:8];
        field {
            name = "reserved";
            desc = "Reserved.";
            sw = r; hw = w;
            reset = 0x0;
        } reserved_7_7[7:7];
        field {
            name = "link_tx_fifo_full";
            desc = "Link transmit FIFO full flag.
- 0: FIFO not full;
- 1: FIFO full.";
            sw = r; hw = w;
            reset = 0x0;
        } link_tx_fifo_full[6:6];
        field {
            name = "link_tx_fifo_empty";
            desc = "Link transmit FIFO empty flag.
- 0: FIFO not empty;
- 1: FIFO empty.";
            sw = r; hw = w;
            reset = 0x1;
        } link_tx_fifo_empty[5:5];
        field {
            name = "link_tx_fifo_count";
            desc = "Amount of data in the Link transmit FIFO.";
            sw = r; hw = w;
            reset = 0x0;
        } link_tx_fifo_count[4:0];
    } SATA_PORT_LINK @ 0x54;
    reg {
        name = "SATA_PORT_DMA1";
        desc = "SATA_PORT_DMA1 is DMAC test status register 1. SATA_PORT_DMA1 (offset 0x058+n x 0x80, total reset 0x0000_0000; PROVEN: Hi3535 data sheet, PDF page 1405, section 13.8.7.2). Per-port register (offset = 0x058+n x 0x80); instantiated as an array of 3 ports (SATA_GHC_CAP1.np = 0x02 means 3 ports, base 0x12010100, stride 0x80).";
        field {
            name = "reserved";
            desc = "Reserved.";
            sw = r; hw = w;
            reset = 0x0;
        } reserved_31_28[31:28];
        field {
            name = "txdmac_cur_state";
            desc = "Current state of the SATA_TX_DMAC state machine.";
            sw = r; hw = w;
            reset = 0x0;
        } txdmac_cur_state[27:24];
        field {
            name = "txdmac_prd_i";
            desc = "The \"I\" bit in the entry of the PRD list in SATA_TX_DAMC.";
            sw = r; hw = w;
            reset = 0x0;
        } txdmac_prd_i[23:23];
        field {
            name = "tx_entry_dbc_cnt";
            desc = "Down counter in SATA_TX_DMAC: the number of data bytes in the Entry currently in use.";
            sw = r; hw = w;
            reset = 0x0;
        } tx_entry_dbc_cnt[22:0];
    } SATA_PORT_DMA1 @ 0x58;
    reg {
        name = "SATA_PORT_DMA2";
        desc = "SATA_PORT_DMA2 is DMAC test status register 2. SATA_PORT_DMA2 (offset 0x05C+n x 0x80, total reset 0x0020_0000; PROVEN: Hi3535 data sheet, PDF page 1406, section 13.8.7.2). Per-port register (offset = 0x05C+n x 0x80); instantiated as an array of 3 ports (SATA_GHC_CAP1.np = 0x02 means 3 ports, base 0x12010100, stride 0x80).";
        field {
            name = "reserved";
            desc = "Reserved.";
            sw = r; hw = w;
            reset = 0x0;
        } reserved_31_24[31:24];
        field {
            name = "tx_data_fis_cnt";
            desc = "Down counter in SATA_TX_DMAC, indicating the number of Data FIS bytes during PIO, Legacy DMA, and First Party DMA operations. For PIO operations its initial value is the transcount in PIO Setup; for Legacy DMA or First Party DMA operations its initial value is 0x2000";
            sw = r; hw = w;
            reset = 0x2000;
        } tx_data_fis_cnt[23:8];
        field {
            name = "tx_cmdh_prdtl";
            desc = "Down counter in the SATA_TX_DMAC: parameter in the Command Header indicating how many Entries are in the PRDT.";
            sw = r; hw = w;
            reset = 0x0;
        } tx_cmdh_prdtl[7:0];
    } SATA_PORT_DMA2 @ 0x5c;
    reg {
        name = "SATA_PORT_DMA3";
        desc = "SATA_PORT_DMA3 is DMAC test status register 3. SATA_PORT_DMA3 (offset 0x060+n x 0x80, total reset 0x0000_0000; PROVEN: Hi3535 data sheet, PDF page 1406, section 13.8.7.2). Per-port register (offset = 0x060+n x 0x80); instantiated as an array of 3 ports (SATA_GHC_CAP1.np = 0x02 means 3 ports, base 0x12010100, stride 0x80).";
        field {
            name = "tx_fpdma_tran_cnt";
            desc = "Down counter in the SATA_TX_DMAC, indicating the number of Data FIS bytes during a First Party DMA operation. Its initial value is the transcount in the DMA Setup.";
            sw = r; hw = w;
            reset = 0x0;
        } tx_fpdma_tran_cnt[31:0];
    } SATA_PORT_DMA3 @ 0x60;
    reg {
        name = "SATA_PORT_DMA4";
        desc = "SATA_PORT_DMA4 is DMAC test status register 4. SATA_PORT_DMA4 (offset 0x064+n x 0x80, total reset 0x0000_0000; PROVEN: Hi3535 data sheet, PDF page 1407, section 13.8.7.2). Per-port register (offset = 0x064+n x 0x80); instantiated as an array of 3 ports (SATA_GHC_CAP1.np = 0x02 means 3 ports, base 0x12010100, stride 0x80).";
        field {
            name = "reserved";
            desc = "Reserved.";
            sw = r; hw = w;
            reset = 0x0;
        } reserved_31_28[31:28];
        field {
            name = "rxdmac_cur_state";
            desc = "Current state machine signal of SATA_RX_DMAC.";
            sw = r; hw = w;
            reset = 0x0;
        } rxdmac_cur_state[27:24];
        field {
            name = "rxdmac_prd_i";
            desc = "The \"I\" bit in the entry of the PRD list in SATA_RX_DAMC.";
            sw = r; hw = w;
            reset = 0x0;
        } rxdmac_prd_i[23:23];
        field {
            name = "rx_entry_dbc_cnt";
            desc = "Down counter in the SATA_RX_DMAC: number of data bytes in the Entry currently in use.";
            sw = r; hw = w;
            reset = 0x0;
        } rx_entry_dbc_cnt[22:0];
    } SATA_PORT_DMA4 @ 0x64;
    reg {
        name = "SATA_PORT_DMA5";
        desc = "SATA_PORT_DMA5 is DMAC test status register 5. SATA_PORT_DMA5 (offset 0x068+n x 0x80, total reset 0x0020_0000; PROVEN: Hi3535 data sheet, PDF page 1407, section 13.8.7.2). Per-port register (offset = 0x068+n x 0x80); instantiated as an array of 3 ports (SATA_GHC_CAP1.np = 0x02 means 3 ports, base 0x12010100, stride 0x80).";
        field {
            name = "reserved";
            desc = "Reserved.";
            sw = r; hw = w;
            reset = 0x0;
        } reserved_31_24[31:24];
        field {
            name = "rx_data_fis_cnt";
            desc = "Down counter in SATA_RX_DMAC, indicating the number of Data FIS bytes during PIO, Legacy DMA, and First Party DMA operations. For PIO operations, its initial value is the transcount in the PIO Setup; for Legacy DMA or First Party DMA operations, its initial value is 0x2000";
            sw = r; hw = w;
            reset = 0x2000;
        } rx_data_fis_cnt[23:8];
        field {
            name = "rx_cmdh_prdtl";
            desc = "Down counter in the SATA_RX_DMAC, a parameter in the Command Header, indicating how many entries are in the PRDT.";
            sw = r; hw = w;
            reset = 0x0;
        } rx_cmdh_prdtl[7:0];
    } SATA_PORT_DMA5 @ 0x68;
    reg {
        name = "SATA_PORT_DMA6";
        desc = "SATA_PORT_DMA6 is DMAC test status register 6. SATA_PORT_DMA6 (offset 0x6C+n x 0x80, total reset 0x0000_0000; PROVEN: Hi3535 data sheet, PDF page 1408, section 13.8.7.2). Per-port register (offset = 0x6C+n x 0x80); instantiated as an array of 3 ports (SATA_GHC_CAP1.np = 0x02 means 3 ports, base 0x12010100, stride 0x80).";
        field {
            name = "rx_fpdma_tran_cnt";
            desc = "Down counter in the SATA_RX_DMAC, indicating the number of Data FIS bytes during a First Party DMA operation. Its initial value is the transcount value in the DMA Setup.";
            sw = r; hw = w;
            reset = 0x0;
        } rx_fpdma_tran_cnt[31:0];
    } SATA_PORT_DMA6 @ 0x6c;
    reg {
        name = "SATA_PORT_DMA7";
        desc = "SATA_PORT_DMA7 is DMAC test status register 7. SATA_PORT_DMA7 (offset 0x070+n x 0x80, total reset 0x0005_0000; PROVEN: Hi3535 data sheet, PDF page 1408, section 13.8.7.2). Per-port register (offset = 0x070+n x 0x80); instantiated as an array of 3 ports (SATA_GHC_CAP1.np = 0x02 means 3 ports, base 0x12010100, stride 0x80).";
        field {
            name = "reserved";
            desc = "Reserved.";
            sw = r; hw = w;
            reset = 0x0;
        } reserved_31_22[31:22];
        field {
            name = "pio_op";
            desc = "PIO operation indication.
- 0: The current command is not a PIO operation.
- 1: The current command is a PIO operation.";
            sw = r; hw = w;
            reset = 0x0;
        } pio_op[21:21];
        field {
            name = "fpdma_op";
            desc = "First Party DMA operation indication.
- 0: The current command is not a First Party DMA operation;
- 1: The current command is a First Party DMA operation.";
            sw = r; hw = w;
            reset = 0x0;
        } fpdma_op[20:20];
        field {
            name = "dmac_rx_fifo_full";
            desc = "SATA_DMAC_RX_FIFO full status.
- 0: FIFO not full.
- 1: FIFO full.";
            sw = r; hw = w;
            reset = 0x0;
        } dmac_rx_fifo_full[19:19];
        field {
            name = "dmac_rx_fifo_empty";
            desc = "SATA_DMAC_RX_FIFO empty status.
- 0: FIFO not empty;
- 1: FIFO empty.";
            sw = r; hw = w;
            reset = 0x1;
        } dmac_rx_fifo_empty[18:18];
        field {
            name = "dmac_tx_fifo_full";
            desc = "SATA_DMAC_TX_FIFO full status.
- 0: FIFO not full;
- 1: FIFO full.";
            sw = r; hw = w;
            reset = 0x0;
        } dmac_tx_fifo_full[17:17];
        field {
            name = "dmac_tx_fifo_empty";
            desc = "SATA_DMAC_TX_FIFO empty status.
- 0: FIFO not empty;
- 1: FIFO empty.";
            sw = r; hw = w;
            reset = 0x1;
        } dmac_tx_fifo_empty[16:16];
        field {
            name = "dmac_rx_fifo_cnt";
            desc = "Number of data entries in SATA_DMAC_RX_FIFO, in DWORDs.";
            sw = r; hw = w;
            reset = 0x0;
        } dmac_rx_fifo_cnt[15:8];
        field {
            name = "dmac_tx_fifo_cnt";
            desc = "Number of data items in the SATA_DMAC_TX_FIFO, in DWORDs.";
            sw = r; hw = w;
            reset = 0x0;
        } dmac_tx_fifo_cnt[7:0];
    } SATA_PORT_DMA7 @ 0x70;
    reg {
        name = "SATA_PORT_PHYCTL";
        desc = "SATA_PORT_PHYCTL is the PHY control register. SATA_PORT_PHYCTL (offset 0x074+n x 0x80, total reset 0x0E24_0000; PROVEN: Hi3535 data sheet, PDF page 1409, section 13.8.7.2). Per-port register (offset = 0x074+n x 0x80); instantiated as an array of 3 ports (SATA_GHC_CAP1.np = 0x02 means 3 ports, base 0x12010100, stride 0x80).";
        field {
            name = "reserved";
            desc = "Reserved.";
            sw = r; hw = w;
            reset = 0x0;
        } reserved_31_29[31:29];
        field {
            name = "phy_disable";
            desc = "Whether to use the PHY.
- 0: Use the PHY;
- 1: Do not use the PHY.";
            sw = rw; hw = r;
            reset = 0x0;
        } phy_disable[28:28];
        field {
            name = "phy_calibrated";
            desc = "Whether to calibrate the PHY.
- 0: Do not calibrate;
- 1: Calibrate.";
            sw = rw; hw = r;
            reset = 0x1;
        } phy_calibrated[27:27];
        field {
            name = "spd_change_ack";
            desc = "Whether speed switching is allowed.
- 0: Speed switching is not allowed.
- 1: Speed switching is allowed.";
            sw = rw; hw = r;
            reset = 0x1;
        } spd_change_ack[26:26];
        field {
            name = "dp_rdy";
            desc = "Whether the PHY is ready to send data.
- 0: Not ready;
- 1: Ready.";
            sw = rw; hw = r;
            reset = 0x1;
        } dp_rdy[25:25];
        field {
            name = "bist_tx_fspd";
            desc = "BIST mode forced transmit clock frequency.
- 0: Not forced.
- 1: Forced.";
            sw = rw; hw = r;
            reset = 0x0;
        } bist_tx_fspd[24:24];
        field {
            name = "neg_mode_b";
            desc = "Negotiation mode B select.
- 0: Not supported;
- 1: Supported.";
            sw = rw; hw = r;
            reset = 0x0;
        } neg_mode_b[23:23];
        field {
            name = "gen2_en";
            desc = "Transmit control signal, whether 3G mode is allowed.
- 00: 1.5G mode supported;
- 01: 3G mode supported;
- 10: 6G mode supported;
- 11: Reserved;";
            sw = rw; hw = r;
            reset = 0x1;
        } gen2_en[22:21];
        field {
            name = "speed_ctrl";
            desc = "Speed support mode control.
- 0: Select hardware auto-negotiation.
- 1: Select software control.";
            sw = rw; hw = r;
            reset = 0x0;
        } speed_ctrl[20:20];
        field {
            name = "rx_dpll_mode";
            desc = "Which rate profile the PHY currently selects.
- 00: 1.5G profile;
- 01: 3.0G profile;
- 10: 6.0G profile;
- 11: Reserved.";
            sw = rw; hw = r;
            reset = 0x1;
        } rx_dpll_mode[19:18];
        field {
            name = "half_rate";
            desc = "Software forced speed.
- 00: Force 1.5G mode;
- 01: Force 3G mode, provided the Device supports 3G or above;
- 10: Force 6G mode, provided the Device supports 6G;
- 11: Reserved.";
            sw = rw; hw = r;
            reset = 0x0;
        } half_rate[17:16];
        field {
            name = "reserved";
            desc = "Reserved.";
            sw = r; hw = w;
            reset = 0x0;
        } reserved_15_0[15:0];
    } SATA_PORT_PHYCTL @ 0x74;
    reg {
        name = "SATA_PORT_PHYSTS";
        desc = "SATA_PORT_PHYSTS is the PHY test status register. SATA_PORT_PHYSTS (offset 0x078+nx0x80, total reset 0x0000_0002; PROVEN: Hi3535 data sheet, PDF page 1411, section 13.8.7.2). Per-port register (offset = 0x078+nx0x80); instantiated as an array of 3 ports (SATA_GHC_CAP1.np = 0x02 means 3 ports, base 0x12010100, stride 0x80).";
        field {
            name = "reserved";
            desc = "Reserved.";
            sw = r; hw = w;
            reset = 0x0;
        } reserved_31_25[31:25];
        field {
            name = "ln_bslip_ackt";
            desc = "Symbol alignment bit slip acknowledge flag, that is, the BIT SLIP response.";
            sw = r; hw = w;
            reset = 0x0;
        } ln_bslip_ackt[24:24];
        field {
            name = "ln_cominit_det";
            desc = "OOB Cominit detect signal.";
            sw = r; hw = w;
            reset = 0x0;
        } ln_cominit_det[23:23];
        field {
            name = "ln_comwake_det";
            desc = "OOB Comwake detect signal.";
            sw = r; hw = w;
            reset = 0x0;
        } ln_comwake_det[22:22];
        field {
            name = "ln_sig_level_valid_";
            desc = "Signal level valid indication, asynchronous, directly from the analog signal detector.
- 0: No signal is detected on the lnX_rxp_i/lnX_rxm_i pins.
- 1: A signal is detected on the lnX_rxp_i/lnX_rxm_i pins.";
            sw = r; hw = w;
            reset = 0x0;
        } ln_sig_level_valid[21:21];
        field {
            name = "ln_ok";
            desc = "Lane OK indication.";
            sw = r; hw = w;
            reset = 0x0;
        } ln_ok[20:20];
        field {
            name = "ln_runlen_err";
            desc = "Run length error indication.";
            sw = r; hw = w;
            reset = 0x0;
        } ln_runlen_err[19:19];
        field {
            name = "ln_ebuf_stat";
            desc = "Elastic Buffer status indication.
- 000: No error.
- 001: Underflow.
- 010: Overflow.
- 011: SKP added.
- 100: SKP removed. Others: Reserved.";
            sw = r; hw = w;
            reset = 0x0;
        } ln_ebuf_stat[18:16];
        field {
            name = "ln_dec_disp_err";
            desc = "8B/10B decode disparity error indication. [0] corresponds to lnX_rxdata_i[9:0], [1] corresponds to lnX_rxdata_i[19:10].";
            sw = r; hw = w;
            reset = 0x0;
        } ln_dec_disp_err[15:14];
        field {
            name = "ln_dec_err";
            desc = "8B/10B decode error indication. [0] corresponds to lnX_rxdata_i[9:0], [1] corresponds to lnX_rxdata_i[19:10].";
            sw = r; hw = w;
            reset = 0x0;
        } ln_dec_err[13:12];
        field {
            name = "ln_rx_locked";
            desc = "Rx lock indication, indicating that the symbol alignment logic has locked onto the data and the data is valid. [0] corresponds to lnX_rxdata_i[9:0], [1] corresponds to lnX_rxdata_i[19:10].";
            sw = r; hw = w;
            reset = 0x0;
        } ln_rx_locked[11:10];
        field {
            name = "ln_k28p5_det";
            desc = "K28.5 detection indication. [0] corresponds to lnX_rxdata_i[9:0], [1] corresponds to lnX_rxdata_i[19:10].
- 00: Not a K28.5 word;
- 01: The word is a K28.5 word.";
            sw = r; hw = w;
            reset = 0x0;
        } ln_k28p5_det[9:8];
        field {
            name = "spd_change";
            desc = "Requested conversion rate.";
            sw = r; hw = w;
            reset = 0x0;
        } spd_change[7:7];
        field {
            name = "link_rdy";
            desc = "When 1, indicates that enough D10.2 have been sent.";
            sw = r; hw = w;
            reset = 0x0;
        } link_rdy[6:6];
        field {
            name = "init_compl";
            desc = "When 1, indicates that a non-ALIGN primitive was received and initialization is complete.";
            sw = r; hw = w;
            reset = 0x0;
        } init_compl[5:5];
        field {
            name = "pwr_state";
            desc = "When 1, indicates a low-power mode (partial or slumber); otherwise the Active state.";
            sw = r; hw = w;
            reset = 0x0;
        } pwr_state[4:4];
        field {
            name = "phy_comwake";
            desc = "When 1, indicates that the PHY detected COMWAKE.";
            sw = r; hw = w;
            reset = 0x0;
        } phy_comwake[3:3];
        field {
            name = "phy_cominit";
            desc = "When 1, indicates that the PHY detected COMINIT.";
            sw = r; hw = w;
            reset = 0x0;
        } phy_cominit[2:2];
        field {
            name = "half_rate";
            desc = "PHY operating rate mode.
- 0: Full-speed mode;
- 1: Half-speed mode;";
            sw = r; hw = w;
            reset = 0x1;
        } half_rate[1:1];
        field {
            name = "phyrdy";
            desc = "When 1, indicates that the PHY is now operating normally.";
            sw = r; hw = w;
            reset = 0x0;
        } phyrdy[0:0];
    } SATA_PORT_PHYSTS @ 0x78;
};

`endif
