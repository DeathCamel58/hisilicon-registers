`ifndef EHI3535_PCIE_RDL
`define EHI3535_PCIE_RDL
regfile eHI3535_PCIE {
    name = "PCIe controller registers: iATU and DMA (offsets from 0x20800000)";
    desc = "PCIe controller registers: iATU and DMA (offsets from 0x20800000). 38 registers extracted programmatically from the Hi3535 H.264 codec processor (Hi3535 user guide) data sheet (Issue 00B08, 2014-02-25); chapter 13.7.6, tables 13-14/13-15. Field names, bit ranges, access types and reset values are taken from the register tables; reset values are the data sheet total reset values split onto the fields (per-field values where the table has them). Label: PROVEN. Hardware not verified here (no board).";
    reg {
        name = "ATU_VIEWPORT";
        desc = "ATU_VIEWPORT is the ATU region number register. ATU_VIEWPORT (offset 0x0900, total reset 0x0000_0000; PROVEN: Hi3535 data sheet, PDF page 1328, section 13.7.6.2).";
        field {
            name = "atu_reg_region_dir";
            desc = "Region direction. Indicates whether this is a transmit or receive address translation region; used together with the region number to determine the specific ATU region being operated on.
- 0: Outbound address translation region.
- 1: Inbound address translation region.";
            sw = rw; hw = r;
            reset = 0x0;
        } atu_reg_region_dir[31:31];
        field {
            name = "reserved";
            desc = "Reserved.";
            sw = r; hw = w;
            reset = 0x0;
        } reserved_30_4[30:4];
        field {
            name = "atu_reg_region_index";
            desc = "Region number. Indicates the region number targeted by the address translation control register operation. The region number ranges from 0 to 5.";
            sw = rw; hw = r;
            reset = 0x0;
        } atu_reg_region_index[3:0];
    } ATU_VIEWPORT @ 0x900;
    reg {
        name = "ATU_REGION_CTRL1";
        desc = "ATU_REGION_CTRL1 is the ATU region control register. ATU_REGION_CTRL1 (offset 0x0904, total reset 0x0000_0000; PROVEN: Hi3535 data sheet, PDF page 1328, section 13.7.6.2).";
        field {
            name = "reserved";
            desc = "Reserved.";
            sw = r; hw = w;
            reset = 0x0;
        } reserved_31_23[31:23];
        field {
            name = "atu_reg_func_num";
            desc = "Function number. Outbound: when a transmitted TLP falls within this ATU region, the function number field in the TLP packet is replaced with the value of this register. Inbound: when the received TLP matches the BAR address of the function number corresponding to this register value, address translation is applied to the received TLP (only when the inbound region match mode is BAR address match).";
            sw = rw; hw = r;
            reset = 0x0;
        } atu_reg_func_num[22:20];
        field {
            name = "reserved";
            desc = "Reserved.";
            sw = r; hw = w;
            reset = 0x0;
        } reserved_19_18[19:18];
        field {
            name = "atu_reg_at";
            desc = "AT field. Outbound: when a transmitted TLP falls within this ATU region, the AT field in the TLP packet is replaced with the value of this register. Inbound: when the AT field in a received TLP matches this register, address translation is applied to the received TLP.";
            sw = rw; hw = r;
            reset = 0x0;
        } atu_reg_at[17:16];
        field {
            name = "reserved";
            desc = "Reserved.";
            sw = r; hw = w;
            reset = 0x0;
        } reserved_15_11[15:11];
        field {
            name = "atu_reg_attr";
            desc = "ATTR field. Outbound: When a transmitted TLP falls within this ATU region, the ATTR field in the TLP packet is replaced with the value of this register. Inbound: When the ATTR field in a received TLP matches this register, address translation is performed on the received TLP.";
            sw = rw; hw = r;
            reset = 0x0;
        } atu_reg_attr[10:9];
        field {
            name = "atu_reg_td";
            desc = "TD field. Transmit (Outbound): When the transmitted TLP falls within this ATU region, the TD field in the TLP packet is replaced with the value of this register. Receive (Inbound): When the TD field in a received TLP matches this register, address translation is performed on the received TLP.";
            sw = rw; hw = r;
            reset = 0x0;
        } atu_reg_td[8:8];
        field {
            name = "atu_reg_tc";
            desc = "TC field. Outbound: when a transmitted TLP falls within this ATU region, the TC field in the TLP packet is replaced with the value of this register. Inbound: when the TC field in a received TLP matches this register, address translation is applied to the received TLP.";
            sw = rw; hw = r;
            reset = 0x0;
        } atu_reg_tc[7:5];
        field {
            name = "atu_reg_type";
            desc = "TYPE field. Outbound: When a transmitted TLP falls within this ATU region, the TYPE field in the TLP packet is replaced with the value of this register. Inbound: When the TYPE field in a received TLP matches this register, address translation is performed on the received TLP.";
            sw = rw; hw = r;
            reset = 0x0;
        } atu_reg_type[4:0];
    } ATU_REGION_CTRL1 @ 0x904;
    reg {
        name = "ATU_REGION_CTRL2";
        desc = "ATU_REGION_CTRL2 is the ATU region control register. ATU_REGION_CTRL2 (offset 0x0908, total reset 0x0000_0000; PROVEN: Hi3535 data sheet, PDF page 1330, section 13.7.6.2).";
        field {
            name = "atu_reg_region_enable";
            desc = "ATU region enable.
- 0: Disable.
- 1: Enable.";
            sw = rw; hw = r;
            reset = 0x0;
        } atu_reg_region_enable[31:31];
        field {
            name = "atu_reg_in_bar_match";
            desc = "Inbound ATU match mode select. Outbound: no effect. Inbound: selects the match mode for received MEM/IO packets.
- 0: Address match mode: address translation is performed when the address of a received MEM/IO TLP matches the address in ATU control register 1.
- 1: BAR match mode: address translation is performed when the address of a received MEM/IO TLP matches the BAR number.";
            sw = rw; hw = r;
            reset = 0x0;
        } atu_reg_in_bar_match[30:30];
        field {
            name = "reserved";
            desc = "Reserved.";
            sw = r; hw = w;
            reset = 0x0;
        } reserved_29_29[29:29];
        field {
            name = "atu_reg_shift";
            desc = "Configure the transaction shift function. This register is enabled for configuration type conversion; it converts the operation address into the bus number, device number, and function number (so that all configuration space can be accessed with a 256M address space). Outbound: bits 27 to 12 of the untranslated address are assigned to bits 31 to 16 of the translated address. Inbound: bits 31 to 16 of the untranslated address of the received configuration transaction are assigned to bits 27 to 12 of the translated address.
- 0: Disable;
- 1: Enable.";
            sw = rw; hw = r;
            reset = 0x0;
        } atu_reg_shift[28:28];
        field {
            name = "atu_reg_fuzzy";
            desc = "Fuzzy type match mode. If enabled, the transaction type fuzzy match mode is enabled.
- 0: Disable;
- 1: Enable.";
            sw = rw; hw = r;
            reset = 0x0;
        } atu_reg_fuzzy[27:27];
        field {
            name = "reserved";
            desc = "Reserved.";
            sw = r; hw = w;
            reset = 0x0;
        } reserved_26_26[26:26];
        field {
            name = "atu_reg_rsp_code";
            desc = "Completion status code: must be set to 0.";
            sw = rw; hw = r;
            reset = 0x0;
        } atu_reg_rsp_code[25:24];
        field {
            name = "reserved";
            desc = "Reserved.";
            sw = r; hw = w;
            reset = 0x0;
        } reserved_23_22[23:22];
        field {
            name = "atu_reg_msgcode_match_en";
            desc = "Message code match enable. Outbound: Not used. Inbound: When enabled, the message code in the received TLP is matched against atu_reg_msg_code in ATURegionCtrl2.
- 0: Disable;
- 1: Enable.";
            sw = rw; hw = r;
            reset = 0x0;
        } atu_reg_msgcode_match_en[21:21];
        field {
            name = "reserved";
            desc = "Reserved.";
            sw = r; hw = w;
            reset = 0x0;
        } reserved_20_20[20:20];
        field {
            name = "atu_reg_func_match_en";
            desc = "Function number match enable. Transmit (Outbound): Not used. Receive (Inbound): When enabled, the function number in a received TLP is matched against atu_reg_func_num in ATURegionCtrl1.
- 0: Disable.
- 1: Enable.";
            sw = rw; hw = r;
            reset = 0x0;
        } atu_reg_func_match_en[19:19];
        field {
            name = "atu_reg_at_match_en";
            desc = "AT field match enable. Transmit (Outbound): Not used. Receive (Inbound): When enabled, the AT field of the received TLP is matched against atu_reg_at in ATURegionCtrl1.
- 0: Disable;
- 1: Enable.";
            sw = rw; hw = r;
            reset = 0x0;
        } atu_reg_at_match_en[18:18];
        field {
            name = "reserved";
            desc = "Reserved.";
            sw = r; hw = w;
            reset = 0x0;
        } reserved_17_17[17:17];
        field {
            name = "atu_reg_attr_match_en";
            desc = "ATTR field match enable. Outbound: unused. Inbound: when enabled, the ATTR field of the received TLP is compared with atu_reg_attr in ATURegionCtrl1.
- 0: Disable;
- 1: Enable.";
            sw = rw; hw = r;
            reset = 0x0;
        } atu_reg_attr_match_en[16:16];
        field {
            name = "atu_reg_td_match_en";
            desc = "TD field match enable. Outbound: Not used. Inbound: When enabled, the TD field in the received TLP is matched against atu_reg_td in ATURegionCtrl1.
- 0: Disable.
- 1: Enable.";
            sw = rw; hw = r;
            reset = 0x0;
        } atu_reg_td_match_en[15:15];
        field {
            name = "atu_reg_tc_match_en";
            desc = "TC field match enable. Transmit (Outbound): Not used. Receive (Inbound): When enabled, the TC field of a received TLP is matched against atu_reg_tc in ATURegionCtrl1.
- 0: Disable.
- 1: Enable.";
            sw = rw; hw = r;
            reset = 0x0;
        } atu_reg_tc_match_en[14:14];
        field {
            name = "reserved";
            desc = "Reserved.";
            sw = r; hw = w;
            reset = 0x0;
        } reserved_13_11[13:11];
        field {
            name = "atu_reg_bar_num";
            desc = "BAR number. Outbound: unused. Inbound: when the BAR address in the received TLP matches the BAR address corresponding to this register, address translation is applied to the TLP.
- 000: BAR#0;
- 001: BAR#1;
- 010: BAR#2;
- 011: BAR#3;
- 100: BAR#4;
- 101: BAR#5;
- 110: ROM;
- 111: Reserved.";
            sw = rw; hw = r;
            reset = 0x0;
        } atu_reg_bar_num[10:8];
        field {
            name = "atu_reg_msg_code";
            desc = "Message code. Outbound: when the address of a transmitted TLP matches this region and the atu_reg_type field in ATURegionCtrl1 is MSG, the MSP field of the translated TLP is set to the value of this register. Inbound: when atu_reg_msgcode_match_en in ATURegionCtrl2 is enabled and the message code in a received message transaction matches the value of this register, address translation is performed on the transaction packet.";
            sw = rw; hw = r;
            reset = 0x0;
        } atu_reg_msg_code[7:0];
    } ATU_REGION_CTRL2 @ 0x908;
    reg {
        name = "ATU_BASE_LOW";
        desc = "ATU_BASE_LOW is the ATU base address low register. ATU_BASE_LOW (offset 0x090C, total reset 0x0000_0000; PROVEN: Hi3535 data sheet, PDF page 1333, section 13.7.6.2).";
        field {
            name = "atu_reg_base_low";
            desc = "Bits 31 to 16 of the start address of this region. The address match condition is met when the untranslated address lies between the start address and the address limit. ATUBaseLow and ATUBaseHigh together form the base address.";
            sw = rw; hw = r;
            reset = 0x0;
        } atu_reg_base_low[31:16];
        field {
            name = "reserved";
            desc = "Reserved.";
            sw = r; hw = w;
            reset = 0x0;
        } reserved_15_0[15:0];
    } ATU_BASE_LOW @ 0x90c;
    reg {
        name = "ATU_BASE_HIGH";
        desc = "ATU_BASE_HIGH is the ATU base address high register. ATU_BASE_HIGH (offset 0x0910, total reset 0x0000_0000; PROVEN: Hi3535 data sheet, PDF page 1333, section 13.7.6.2).";
        field {
            name = "atu_reg_base_high";
            desc = "High 32 bits of the base address. Bits 63-63 of the start address of this region; the address match condition is met when the untranslated address lies between the start address and the address limit. (This register is valid only with 64-bit addresses and must be set to 0 in 32-bit address mode.) ATUBaseLow and ATUBaseHigh together form the base address.";
            sw = rw; hw = r;
            reset = 0x0;
        } atu_reg_base_high[31:0];
    } ATU_BASE_HIGH @ 0x910;
    reg {
        name = "ATU_LIMIT";
        desc = "ATU_LIMIT is the ATU address limit register. ATU_LIMIT (offset 0x0914, total reset 0x0000_FFFF; PROVEN: Hi3535 data sheet, PDF page 1334, section 13.7.6.2).";
        field {
            name = "atu_reg_limit";
            desc = "Address limit. Bits 31 to 16 of the limit address of this region. When the untranslated address lies between the start address and the address limit, the address match condition is met.";
            sw = rw; hw = r;
            reset = 0x0;
        } atu_reg_limit[31:16];
        field {
            name = "reserved";
            desc = "Reserved.";
            sw = r; hw = w;
            reset = 0xffff;
        } reserved_15_0[15:0];
    } ATU_LIMIT @ 0x914;
    reg {
        name = "ATU_TARGET_LOW";
        desc = "ATU_TARGET_LOW is the ATU target address low register. ATU_TARGET_LOW (offset 0x0918, total reset 0x0000_0000; PROVEN: Hi3535 data sheet, PDF page 1334, section 13.7.6.2).";
        field {
            name = "atu_reg_trgt_low";
            desc = "Lower 32 bits of the target address. When performing address translation, these are bits 31 to 16 of the translated address. ATUTargetLow and ATUTargetHigh together form the target address. The address translation formula is: translated address = address to translate - base address + target address.";
            sw = rw; hw = r;
            reset = 0x0;
        } atu_reg_trgt_low[31:16];
        field {
            name = "reserved";
            desc = "Reserved.";
            sw = r; hw = w;
            reset = 0x0;
        } reserved_15_0[15:0];
    } ATU_TARGET_LOW @ 0x918;
    reg {
        name = "ATU_TARGET_HIGH";
        desc = "ATU_TARGET_HIGH is the ATU target address high register. ATU_TARGET_HIGH (offset 0x091C, total reset 0x0000_0000; PROVEN: Hi3535 data sheet, PDF page 1335, section 13.7.6.2).";
        field {
            name = "atu_reg_trgt_high";
            desc = "Upper 32 bits of the target address. When address translation is performed, bits 63 to 32 of the translated address. Together with ATUTargetLow, they form the target address.";
            sw = rw; hw = r;
            reset = 0x0;
        } atu_reg_trgt_high[31:0];
    } ATU_TARGET_HIGH @ 0x91c;
    reg {
        name = "DMA_WR_ENGINE_EN";
        desc = "DMA_WR_ENGINE_EN is the DMA write channel enable register. DMA_WR_ENGINE_EN (offset 0x097C, total reset 0x0000_0000; PROVEN: Hi3535 data sheet, PDF page 1337, section 13.7.6.4).";
        field {
            name = "reserved";
            desc = "Reserved.";
            sw = rw; hw = r;
            reset = 0x0;
        } reserved_31_1[31:1];
        field {
            name = "dma_wr_engine_en";
            desc = "DMA write channel enable.
- 0: Disable the DMA write channel.
- 1: Enable the DMA write channel.";
            sw = rw; hw = r;
            reset = 0x0;
        } dma_wr_engine_en[0:0];
    } DMA_WR_ENGINE_EN @ 0x97c;
    reg {
        name = "DMA_WR_DOORBELL";
        desc = "DMA_WR_DOORBELL is the DMA write operation start and stop control register. DMA_WR_DOORBELL (offset 0x0980, total reset 0x0000_0000; PROVEN: Hi3535 data sheet, PDF page 1338, section 13.7.6.4).";
        field {
            name = "dma_wr_stop";
            desc = "DMA write channel stop. Used together with wr_doorbell_num to stop data transfer on the corresponding DMA write channel.
- 0: No effect.
- 1: Stop the current DMA transfer.";
            sw = rw; hw = r;
            reset = 0x0;
        } dma_wr_stop[31:31];
        field {
            name = "reserved";
            desc = "Reserved.";
            sw = r; hw = w;
            reset = 0x0;
        } reserved_30_3[30:3];
        field {
            name = "wr_doorbell_num";
            desc = "DMA write channel start. Writing 0 to this register starts a DMA write transfer (the DMA engine starts the DMA operation of the corresponding write channel when it detects a write to this register. Because the PCIe controller currently supports only one write channel, this register must be written with 0).";
            sw = rw; hw = r;
            reset = 0x0;
        } wr_doorbell_num[2:0];
    } DMA_WR_DOORBELL @ 0x980;
    reg {
        name = "DMA_RD_ENGINE_EN";
        desc = "DMA_RD_ENGINE_EN is the DMA read channel enable register. DMA_RD_ENGINE_EN (offset 0x099C, total reset 0x0000_0000; PROVEN: Hi3535 data sheet, PDF page 1338, section 13.7.6.4).";
        field {
            name = "reserved";
            desc = "Reserved.";
            sw = r; hw = w;
            reset = 0x0;
        } reserved_31_1[31:1];
        field {
            name = "dma_wr_engine_en";
            desc = "DMA read channel enable.
- 0: Disable the DMA read channel.
- 1: Enable the DMA read channel.";
            sw = rw; hw = r;
            reset = 0x0;
        } dma_wr_engine_en[0:0];
    } DMA_RD_ENGINE_EN @ 0x99c;
    reg {
        name = "DMA_RD_DOORBELL";
        desc = "DMA_RD_DOORBELL is the DMA read operation start and stop control register. DMA_RD_DOORBELL (offset 0x09A0, total reset 0x0000_0000; PROVEN: Hi3535 data sheet, PDF page 1339, section 13.7.6.4).";
        field {
            name = "dma_rd_stop";
            desc = "DMA read channel stop. Used together with rd_doorbell_num to stop data transfer on the corresponding DMA read channel.
- 0: No effect.
- 1: Stop the current DMA transfer.";
            sw = rw; hw = r;
            reset = 0x0;
        } dma_rd_stop[31:31];
        field {
            name = "reserved";
            desc = "Reserved.";
            sw = r; hw = w;
            reset = 0x0;
        } reserved_30_3[30:3];
        field {
            name = "rd_doorbell_num";
            desc = "DMA read channel start. Writing 0 to this register starts a DMA read transfer (the DMA engine starts the DMA operation of the corresponding read channel when it detects a write to this register. Because the PCIe controller currently supports only one read channel, this register must be written with 0).";
            sw = rw; hw = r;
            reset = 0x0;
        } rd_doorbell_num[2:0];
    } DMA_RD_DOORBELL @ 0x9a0;
    reg {
        name = "DMA_WR_INT_STAT";
        desc = "DMA_WR_INT_STAT is the DMA write operation interrupt status register. DMA_WR_INT_STAT (offset 0x09BC, total reset 0x0000_0000; PROVEN: Hi3535 data sheet, PDF page 1340, section 13.7.6.4).";
        field {
            name = "reserved";
            desc = "Reserved.";
            sw = r; hw = w;
            reset = 0x0;
        } reserved_31_17[31:17];
        field {
            name = "dma_wr_abort_int_stat";
            desc = "DMA write abort interrupt status. Indicates that the DMA write channel detected an error or the DMA write operation was stopped manually.
- 0: Inactive.
- 1: Active.";
            sw = rw; hw = r;
            reset = 0x0;
        } dma_wr_abort_int_stat[16:16];
        field {
            name = "reserved";
            desc = "Reserved.";
            sw = r; hw = w;
            reset = 0x0;
        } reserved_15_1[15:1];
        field {
            name = "dma_wr_done_int_stat";
            desc = "DMA write completion interrupt status. Indicates that a DMA write operation has completed successfully.
- 0: Not set.
- 1: Set.";
            sw = rw; hw = r;
            reset = 0x0;
        } dma_wr_done_int_stat[0:0];
    } DMA_WR_INT_STAT @ 0x9bc;
    reg {
        name = "DMA_WR_INT_MASK";
        desc = "DMA_WR_INT_MASK is the DMA write operation interrupt mask register. DMA_WR_INT_MASK (offset 0x09C4, total reset 0x0000_0000; PROVEN: Hi3535 data sheet, PDF page 1341, section 13.7.6.4).";
        field {
            name = "reserved";
            desc = "Reserved.";
            sw = r; hw = w;
            reset = 0x0;
        } reserved_31_17[31:17];
        field {
            name = "dma_wr_abort_int_mask";
            desc = "DMA write abort interrupt mask.
- 0: dma_wr_abort_int_stat does not generate the edma_int interrupt.
- 1: dma_wr_abort_int_stat can generate the edma_int interrupt.";
            sw = rw; hw = r;
            reset = 0x0;
        } dma_wr_abort_int_mask[16:16];
        field {
            name = "reserved";
            desc = "Reserved.";
            sw = r; hw = w;
            reset = 0x0;
        } reserved_15_1[15:1];
        field {
            name = "dma_wr_done_int_mask";
            desc = "DMA write completion interrupt mask.
- 0: dma_wr_done_int_stat does not generate the edma_int interrupt.
- 1: dma_wr_done_int_stat can generate the edma_int interrupt.";
            sw = rw; hw = r;
            reset = 0x0;
        } dma_wr_done_int_mask[0:0];
    } DMA_WR_INT_MASK @ 0x9c4;
    reg {
        name = "DMA_WR_INT_CLR";
        desc = "DMA_WR_INT_CLR is the DMA write operation interrupt clear register. DMA_WR_INT_CLR (offset 0x09C8, total reset 0x0000_0000; PROVEN: Hi3535 data sheet, PDF page 1342, section 13.7.6.4).";
        field {
            name = "reserved";
            desc = "Reserved.";
            sw = r; hw = w;
            reset = 0x0;
        } reserved_31_17[31:17];
        field {
            name = "dma_wr_abort_int_clr";
            desc = "DMA write abort interrupt clear. Writing 1 to this bit clears the dma_wr_abort_int_stat interrupt status in the DMA_WR_INT_STAT register.";
            sw = rw; hw = r;
            reset = 0x0;
        } dma_wr_abort_int_clr[16:16];
        field {
            name = "reserved";
            desc = "Reserved.";
            sw = r; hw = w;
            reset = 0x0;
        } reserved_15_1[15:1];
        field {
            name = "dma_wr_done_int_clr";
            desc = "DMA write completion interrupt clear. Writing 1 to this bit clears the dma_wr_done_int_stat interrupt status in the DMA_WR_INT_STAT register.";
            sw = rw; hw = r;
            reset = 0x0;
        } dma_wr_done_int_clr[0:0];
    } DMA_WR_INT_CLR @ 0x9c8;
    reg {
        name = "DMA_WR_ERR_STAT";
        desc = "DMA_WR_ERR_STAT is the DMA write operation error status register. DMA_WR_ERR_STAT (offset 0x09CC, total reset 0x0000_0000; PROVEN: Hi3535 data sheet, PDF page 1342, section 13.7.6.4).";
        field {
            name = "reserved";
            desc = "Reserved.";
            sw = r; hw = w;
            reset = 0x0;
        } reserved_31_17[31:17];
        field {
            name = "reserved";
            desc = "Reserved";
            sw = r; hw = w;
            reset = 0x0;
        } reserved_16_16[16:16];
        field {
            name = "reserved";
            desc = "Reserved.";
            sw = r; hw = w;
            reset = 0x0;
        } reserved_15_1[15:1];
        field {
            name = "app_rd_err_det";
            desc = "DMA write channel read data error.";
            sw = rw; hw = r;
            reset = 0x0;
        } app_rd_err_det[0:0];
    } DMA_WR_ERR_STAT @ 0x9cc;
    reg {
        name = "DMA_WR_DONE_IMWR_ADDR_LOW";
        desc = "DMA_WR_DONE_IMWR_ADDR_LOW is the lower bits of the address of the DMA write done message interrupt (low register). DMA_WR_DONE_IMWR_ADDR_LOW (offset 0x09D0, total reset 0x0000_0000; PROVEN: Hi3535 data sheet, PDF page 1343, section 13.7.6.4).";
        field {
            name = "dma_wr_done_imwr_addr_low";
            desc = "Lower 32 bits of the write done interrupt message address.";
            sw = rw; hw = r;
            reset = 0x0;
        } dma_wr_done_imwr_addr_low[31:0];
    } DMA_WR_DONE_IMWR_ADDR_LOW @ 0x9d0;
    reg {
        name = "DMA_WR_DONE_IMWR_ADDR_HIGH";
        desc = "DMA_WR_DONE_IMWR_ADDR_HIGH is the upper bits of the address of the DMA write done message interrupt (high register). DMA_WR_DONE_IMWR_ADDR_HIGH (offset 0x09D4, total reset 0x0000_0000; PROVEN: Hi3535 data sheet, PDF page 1343, section 13.7.6.4).";
        field {
            name = "dma_wr_done_imwr_addr_high";
            desc = "Upper 32 bits of the write done interrupt message address.";
            sw = rw; hw = r;
            reset = 0x0;
        } dma_wr_done_imwr_addr_high[31:0];
    } DMA_WR_DONE_IMWR_ADDR_HIGH @ 0x9d4;
    reg {
        name = "DMA_WR_ABORT_IMWR_ADDR_LOW";
        desc = "DMA_WR_ABORT_IMWR_ADDR_LOW is the lower bits of the address of the DMA write abort message interrupt (low register). DMA_WR_ABORT_IMWR_ADDR_LOW (offset 0x09D8, total reset 0x0000_0000; PROVEN: Hi3535 data sheet, PDF page 1344, section 13.7.6.4).";
        field {
            name = "dma_wr_abort_imwr_addr_low";
            desc = "Lower 32 bits of the write abort interrupt message address.";
            sw = rw; hw = r;
            reset = 0x0;
        } dma_wr_abort_imwr_addr_low[31:0];
    } DMA_WR_ABORT_IMWR_ADDR_LOW @ 0x9d8;
    reg {
        name = "DMA_WR_ABORT_IMWR_ADDR_HIGH";
        desc = "DMA_WR_ABORT_IMWR_ADDR_HIGH is the upper bits of the address of the DMA write abort message interrupt (high register). DMA_WR_ABORT_IMWR_ADDR_HIGH (offset 0x09DC, total reset 0x0000_0000; PROVEN: Hi3535 data sheet, PDF page 1344, section 13.7.6.4).";
        field {
            name = "dma_wr_abort_imwr_addr_high";
            desc = "Upper 32 bits of the write abort interrupt message address.";
            sw = rw; hw = r;
            reset = 0x0;
        } dma_wr_abort_imwr_addr_high[31:0];
    } DMA_WR_ABORT_IMWR_ADDR_HIGH @ 0x9dc;
    reg {
        name = "DMA_WR_IMWR_DATA_0";
        desc = "DMA_WR_IMWR_DATA_0 is the DMA write operation message interrupt data register. DMA_WR_IMWR_DATA_0 (offset 0x09E0, total reset 0x0000_0000; PROVEN: Hi3535 data sheet, PDF page 1344, section 13.7.6.4).";
        field {
            name = "reserved";
            desc = "Reserved.";
            sw = r; hw = w;
            reset = 0x0;
        } reserved_31_16[31:16];
        field {
            name = "dma_wr_imwr_data_0";
            desc = "Interrupt message data of DMA write channel 0.";
            sw = rw; hw = r;
            reset = 0x0;
        } dma_wr_imwr_data_0[15:0];
    } DMA_WR_IMWR_DATA_0 @ 0x9e0;
    reg {
        name = "DMA_RD_INT_STAT";
        desc = "DMA_RD_INT_STAT is the DMA read operation interrupt status register. DMA_RD_INT_STAT (offset 0x0A10, total reset 0x0000_0000; PROVEN: Hi3535 data sheet, PDF page 1345, section 13.7.6.4).";
        field {
            name = "reserved";
            desc = "Reserved.";
            sw = r; hw = w;
            reset = 0x0;
        } reserved_31_17[31:17];
        field {
            name = "dma_wr_abort_int_stat";
            desc = "DMA read abort interrupt status. Indicates that the DMA read channel detected an error or the DMA write operation was stopped manually.
- 0: Inactive.
- 1: Active.";
            sw = rw; hw = r;
            reset = 0x0;
        } dma_wr_abort_int_stat[16:16];
        field {
            name = "reserved";
            desc = "Reserved.";
            sw = r; hw = w;
            reset = 0x0;
        } reserved_15_1[15:1];
        field {
            name = "dma_wr_done_int_stat";
            desc = "DMA read operation done interrupt status. Indicates that a DMA read operation has completed successfully.
- 0: Invalid.
- 1: Valid.";
            sw = rw; hw = r;
            reset = 0x0;
        } dma_wr_done_int_stat[0:0];
    } DMA_RD_INT_STAT @ 0xa10;
    reg {
        name = "DMA_RD_INT_MASK";
        desc = "DMA_RD_INT_MASK is the DMA read operation interrupt mask register. DMA_RD_INT_MASK (offset 0x0A18, total reset 0x0000_0000; PROVEN: Hi3535 data sheet, PDF page 1346, section 13.7.6.4).";
        field {
            name = "reserved";
            desc = "Reserved.";
            sw = r; hw = w;
            reset = 0x0;
        } reserved_31_17[31:17];
        field {
            name = "dma_wr_abort_int_mask";
            desc = "DMA read abort interrupt mask.
- 0: dma_rd_abort_int_stat does not generate the edma_int interrupt.
- 1: dma_rd_abort_int_stat can generate the edma_int interrupt.";
            sw = rw; hw = r;
            reset = 0x0;
        } dma_wr_abort_int_mask[16:16];
        field {
            name = "reserved";
            desc = "Reserved.";
            sw = r; hw = w;
            reset = 0x0;
        } reserved_15_1[15:1];
        field {
            name = "dma_wr_done_int_mask";
            desc = "DMA read completion interrupt mask.
- 0: dma_rd_done_int_stat does not generate the edma_int interrupt.
- 1: dma_rd_done_int_stat can generate the edma_int interrupt.";
            sw = rw; hw = r;
            reset = 0x0;
        } dma_wr_done_int_mask[0:0];
    } DMA_RD_INT_MASK @ 0xa18;
    reg {
        name = "DMA_RD_INT_CLR";
        desc = "DMA_RD_INT_CLR is the DMA read operation interrupt clear register. DMA_RD_INT_CLR (offset 0x0A1C, total reset 0x0000_0000; PROVEN: Hi3535 data sheet, PDF page 1347, section 13.7.6.4).";
        field {
            name = "reserved";
            desc = "Reserved.";
            sw = r; hw = w;
            reset = 0x0;
        } reserved_31_17[31:17];
        field {
            name = "dma_wr_abort_int_clr";
            desc = "DMA read abort interrupt clear. Writing 1 to this bit clears the dma_rd_abort_int_stat interrupt status in the DMA_RD_INT_STAT register.";
            sw = rw; hw = r;
            reset = 0x0;
        } dma_wr_abort_int_clr[16:16];
        field {
            name = "reserved";
            desc = "Reserved.";
            sw = r; hw = w;
            reset = 0x0;
        } reserved_15_1[15:1];
        field {
            name = "dma_wr_done_int_clr";
            desc = "DMA read abort interrupt clear. Writing 1 to this bit clears the dma_rd_done_int_stat interrupt status in the DMA_RD_INT_STAT register.";
            sw = rw; hw = r;
            reset = 0x0;
        } dma_wr_done_int_clr[0:0];
    } DMA_RD_INT_CLR @ 0xa1c;
    reg {
        name = "DMA_RD_ERR_STAT_LOW";
        desc = "DMA_RD_ERR_STAT_LOW is the DMA read operation error status low register. DMA_RD_ERR_STAT_LOW (offset 0x0A24, total reset 0x0000_0000; PROVEN: Hi3535 data sheet, PDF page 1348, section 13.7.6.4).";
        field {
            name = "reserved";
            desc = "Reserved.";
            sw = r; hw = w;
            reset = 0x0;
        } reserved_31_17[31:17];
        field {
            name = "reserved";
            desc = "Reserved.";
            sw = r; hw = w;
            reset = 0x0;
        } reserved_16_16[16:16];
        field {
            name = "reserved";
            desc = "Reserved.";
            sw = r; hw = w;
            reset = 0x0;
        } reserved_15_1[15:1];
        field {
            name = "app_rd_err_det";
            desc = "The DMA read channel detected an AXI bus error response.";
            sw = rw; hw = r;
            reset = 0x0;
        } app_rd_err_det[0:0];
    } DMA_RD_ERR_STAT_LOW @ 0xa24;
    reg {
        name = "DMA_RD_ERR_STAT_HIGH";
        desc = "DMA_RD_ERR_STAT_HIGH is the DMA read operation error status high register. DMA_RD_ERR_STAT_HIGH (offset 0x0A28, total reset 0x0000_0000; PROVEN: Hi3535 data sheet, PDF page 1348, section 13.7.6.4).";
        field {
            name = "reserved";
            desc = "Reserved.";
            sw = r; hw = w;
            reset = 0x0;
        } reserved_31_25[31:25];
        field {
            name = "dp_err";
            desc = "The DMA channel detected poisoned data from the remote device.";
            sw = rw; hw = r;
            reset = 0x0;
        } dp_err[24:24];
        field {
            name = "reserved";
            desc = "Reserved.";
            sw = r; hw = w;
            reset = 0x0;
        } reserved_23_17[23:17];
        field {
            name = "to_err";
            desc = "DMA channel read operation timeout.";
            sw = rw; hw = r;
            reset = 0x0;
        } to_err[16:16];
        field {
            name = "reserved";
            desc = "Reserved.";
            sw = r; hw = w;
            reset = 0x0;
        } reserved_15_9[15:9];
        field {
            name = "ca_err";
            desc = "The DMA channel detected a CA (Completion Abort) completion packet from the remote device.";
            sw = rw; hw = r;
            reset = 0x0;
        } ca_err[8:8];
        field {
            name = "reserved";
            desc = "Reserved.";
            sw = r; hw = w;
            reset = 0x0;
        } reserved_7_1[7:1];
        field {
            name = "ur_err";
            desc = "The DMA channel detected a UR (Unsupported Request) completion packet from the peer device.";
            sw = rw; hw = r;
            reset = 0x0;
        } ur_err[0:0];
    } DMA_RD_ERR_STAT_HIGH @ 0xa28;
    reg {
        name = "DMA_RD_DONE_IMWR_ADDR_LOW";
        desc = "DMA_RD_DONE_IMWR_ADDR_LOW is the lower bits of the address of the DMA read done message interrupt (low register). DMA_RD_DONE_IMWR_ADDR_LOW (offset 0x0A3C, total reset 0x0000_0000; PROVEN: Hi3535 data sheet, PDF page 1349, section 13.7.6.4).";
        field {
            name = "dma_rd_done_imwr_addr_low";
            desc = "Lower 32 bits of the read completion interrupt message address.";
            sw = rw; hw = r;
            reset = 0x0;
        } dma_rd_done_imwr_addr_low[31:0];
    } DMA_RD_DONE_IMWR_ADDR_LOW @ 0xa3c;
    reg {
        name = "DMA_RD_DONE_IMWR_ADDR_HIGH";
        desc = "DMA_RD_DONE_IMWR_ADDR_HIGH is the upper bits of the address of the DMA read done message interrupt (high register). DMA_RD_DONE_IMWR_ADDR_HIGH (offset 0x0A40, total reset 0x0000_0000; PROVEN: Hi3535 data sheet, PDF page 1349, section 13.7.6.4).";
        field {
            name = "dma_rd_done_imwr_addr_high";
            desc = "Upper 32 bits of the read completion interrupt message address.";
            sw = rw; hw = r;
            reset = 0x0;
        } dma_rd_done_imwr_addr_high[31:0];
    } DMA_RD_DONE_IMWR_ADDR_HIGH @ 0xa40;
    reg {
        name = "DMA_RD_ABORT_IMWR_ADDR_LOW";
        desc = "DMA_RD_ABORT_IMWR_ADDR_LOW is the lower bits of the address of the DMA read abort message interrupt (low register). DMA_RD_ABORT_IMWR_ADDR_LOW (offset 0x0A44, total reset 0x0000_0000; PROVEN: Hi3535 data sheet, PDF page 1350, section 13.7.6.4).";
        field {
            name = "dma_rd_abort_imwr_addr_low";
            desc = "Lower 32 bits of the read abort interrupt message address.";
            sw = rw; hw = r;
            reset = 0x0;
        } dma_rd_abort_imwr_addr_low[31:0];
    } DMA_RD_ABORT_IMWR_ADDR_LOW @ 0xa44;
    reg {
        name = "DMA_RD_ABORT_IMWR_ADDR_HIGH";
        desc = "DMA_RD_ABORT_IMWR_ADDR_HIGH is the upper bits of the address of the DMA read abort message interrupt (high register). DMA_RD_ABORT_IMWR_ADDR_HIGH (offset 0x0A48, total reset 0x0000_0000; PROVEN: Hi3535 data sheet, PDF page 1350, section 13.7.6.4).";
        field {
            name = "dma_rd_abort_imwr_addr_high";
            desc = "Upper 32 bits of the read abort interrupt message address.";
            sw = rw; hw = r;
            reset = 0x0;
        } dma_rd_abort_imwr_addr_high[31:0];
    } DMA_RD_ABORT_IMWR_ADDR_HIGH @ 0xa48;
    reg {
        name = "DMA_RD_IMWR_DATA_0";
        desc = "DMA_RD_IMWR_DATA_0 is the DMA read operation message interrupt data register. DMA_RD_IMWR_DATA_0 (offset 0x0A4C, total reset 0x0000_0000; PROVEN: Hi3535 data sheet, PDF page 1350, section 13.7.6.4).";
        field {
            name = "reserved";
            desc = "Reserved.";
            sw = r; hw = w;
            reset = 0x0;
        } reserved_31_16[31:16];
        field {
            name = "dma_wr_imwr_data_0";
            desc = "Interrupt message data of DMA read channel 0.";
            sw = rw; hw = r;
            reset = 0x0;
        } dma_wr_imwr_data_0[15:0];
    } DMA_RD_IMWR_DATA_0 @ 0xa4c;
    reg {
        name = "DMA_CH_INDEX";
        desc = "DMA_CH_INDEX is the DMA channel index register. DMA_CH_INDEX (offset 0x0A6C, total reset 0x0000_0000; PROVEN: Hi3535 data sheet, PDF page 1351, section 13.7.6.4).";
        field {
            name = "ch_dir";
            desc = "Channel direction. This bit selects whether the register to be configured belongs to the read channel or the write channel.
- 0: Write channel.
- 1: Read channel.";
            sw = rw; hw = r;
            reset = 0x0;
        } ch_dir[31:31];
        field {
            name = "reserved";
            desc = "Reserved.";
            sw = r; hw = w;
            reset = 0x0;
        } reserved_30_3[30:3];
        field {
            name = "reserved";
            desc = "Reserved, must be set to 0.";
            sw = r; hw = w;
            reset = 0x0;
        } reserved_2_0[2:0];
    } DMA_CH_INDEX @ 0xa6c;
    reg {
        name = "DMA_CH_CTRL";
        desc = "DMA_CH_CTRL is the DMA channel control register. DMA_CH_CTRL (offset 0x0A70, total reset 0x0000_0000; PROVEN: Hi3535 data sheet, PDF page 1352, section 13.7.6.4).";
        field {
            name = "addr_trans";
            desc = "PCIe transaction AT bits. The AT bits in PCIe memory read/write transaction packets initiated by the DMA are replaced by this field value.";
            sw = rw; hw = r;
            reset = 0x0;
        } addr_trans[31:30];
        field {
            name = "traffic_class";
            desc = "PCIe transaction TC bits. The TC bits in the PCIe memory read/write transaction packets initiated by the DMA are replaced by the value of this field.";
            sw = rw; hw = r;
            reset = 0x0;
        } traffic_class[29:27];
        field {
            name = "traffic_digest";
            desc = "PCIe transaction TD bit. The TD bit in the PCIe memory read/write transaction packets initiated by the DMA is replaced by the value of this field.";
            sw = rw; hw = r;
            reset = 0x0;
        } traffic_digest[26:26];
        field {
            name = "relaxed_order";
            desc = "PCIe transaction RO bit. The RO bit in the PCIe memory read/write transaction packets initiated by the DMA is replaced by the value of this field.";
            sw = rw; hw = r;
            reset = 0x0;
        } relaxed_order[25:25];
        field {
            name = "no_snoop";
            desc = "PCIe transaction NS bit. The NS bit in PCIe memory read/write transaction packets initiated by the DMA is replaced with the value of this field.";
            sw = rw; hw = r;
            reset = 0x0;
        } no_snoop[24:24];
        field {
            name = "reserved";
            desc = "Reserved.";
            sw = r; hw = w;
            reset = 0x0;
        } reserved_23_17[23:17];
        field {
            name = "fun_num";
            desc = "PCIe transaction fun_num bits. The function number in PCIe memory read/write transaction packets initiated by the DMA is replaced by this field value.";
            sw = rw; hw = r;
            reset = 0x0;
        } fun_num[16:12];
        field {
            name = "reserved";
            desc = "Reserved.";
            sw = r; hw = w;
            reset = 0x0;
        } reserved_11_10[11:10];
        field {
            name = "reserved";
            desc = "Reserved.";
            sw = r; hw = w;
            reset = 0x0;
        } reserved_9_9[9:9];
        field {
            name = "reserved";
            desc = "Reserved.";
            sw = r; hw = w;
            reset = 0x0;
        } reserved_8_8[8:8];
        field {
            name = "reserved";
            desc = "Reserved.";
            sw = r; hw = w;
            reset = 0x0;
        } reserved_7_7[7:7];
        field {
            name = "ch_status";
            desc = "Channel status. Indicates the working state of the channel.
- 00: Reserved.
- 01: DMA transfer in progress.
- 10: Run error.
- 11: The channel completed the DMA transfer successfully or the channel was stopped manually.";
            sw = rw; hw = r;
            reset = 0x0;
        } ch_status[6:5];
        field {
            name = "remote_int_enable";
            desc = "Remote DMA interrupt enable. When this bit is set, a DMA interrupt can be sent to the remote device when the DMA transfer completes or fails.
- 0: Disable the DMA remote interrupt.
- 1: Enable the DMA remote interrupt.";
            sw = rw; hw = r;
            reset = 0x0;
        } remote_int_enable[4:4];
        field {
            name = "local_int_enable";
            desc = "Local DMA interrupt enable. When set, a DMA local interrupt can be issued when a DMA transfer completes or fails.
- 0: Disable the DMA local interrupt.
- 1: Enable the DMA local interrupt.";
            sw = rw; hw = r;
            reset = 0x0;
        } local_int_enable[3:3];
        field {
            name = "reserved";
            desc = "Reserved.";
            sw = r; hw = w;
            reset = 0x0;
        } reserved_2_2[2:2];
        field {
            name = "reserved";
            desc = "Reserved.";
            sw = r; hw = w;
            reset = 0x0;
        } reserved_1_1[1:1];
        field {
            name = "reserved";
            desc = "Reserved.";
            sw = r; hw = w;
            reset = 0x0;
        } reserved_0_0[0:0];
    } DMA_CH_CTRL @ 0xa70;
    reg {
        name = "DMA_TRANS_SIZE";
        desc = "DMA_TRANS_SIZE is the DMA transfer size register. DMA_TRANS_SIZE (offset 0x0A78, total reset 0x0000_0000; PROVEN: Hi3535 data sheet, PDF page 1353, section 13.7.6.4).";
        field {
            name = "dma_trans_size";
            desc = "DMA transfer length. Before a DMA transfer, write the length of the data to be transferred to this register. The minimum transfer length is 1 byte and the maximum is 4 GB. During the DMA transfer, the value of this register decrements automatically. The register value is the number of bytes not yet transferred; after a successful transfer completes, this register is 0.";
            sw = rw; hw = r;
            reset = 0x0;
        } dma_trans_size[31:0];
    } DMA_TRANS_SIZE @ 0xa78;
    reg {
        name = "DMA_SAR_LOW";
        desc = "DMA_SAR_LOW is the DMA data source address low register. DMA_SAR_LOW (offset 0x0A7C, total reset 0x0000_0000; PROVEN: Hi3535 data sheet, PDF page 1354, section 13.7.6.4).";
        field {
            name = "dma_sar_low";
            desc = "Source address of the DMA transfer (low 32 bits). Before a DMA transfer, write the start address of the source data to this register; the DMA channel fetches the data to be transferred from this address. During the DMA transfer, the value of this register increments automatically. The low 2 bits of this register must be 0.";
            sw = rw; hw = r;
            reset = 0x0;
        } dma_sar_low[31:0];
    } DMA_SAR_LOW @ 0xa7c;
    reg {
        name = "DMA_SAR_HIGH";
        desc = "DMA_SAR_HIGH is the DMA source address high register. DMA_SAR_HIGH (offset 0x0A80, total reset 0x0000_0000; PROVEN: Hi3535 data sheet, PDF page 1354, section 13.7.6.4).";
        field {
            name = "dma_sar_high";
            desc = "Source address of the DMA transfer data (upper 32 bits). Must be 0 in 32-bit address mode. In 64-bit address mode, combined with DMA_SAR_LOW to form a 64-bit source address.";
            sw = rw; hw = r;
            reset = 0x0;
        } dma_sar_high[31:0];
    } DMA_SAR_HIGH @ 0xa80;
    reg {
        name = "DMA_DAR_LOW";
        desc = "DMA_DAR_LOW is the DMA destination address low register. DMA_DAR_LOW (offset 0x0A84, total reset 0x0000_0000; PROVEN: Hi3535 data sheet, PDF page 1355, section 13.7.6.4).";
        field {
            name = "dma_dar_low";
            desc = "Destination address (low 32 bits) of the DMA transfer. Write the destination address to this register before the DMA transfer; the DMA channel writes the data fetched from the source address to the destination address. During the DMA transfer, the value of this register increments automatically. The low 2 bits of this register must be 0.";
            sw = rw; hw = r;
            reset = 0x0;
        } dma_dar_low[31:0];
    } DMA_DAR_LOW @ 0xa84;
    reg {
        name = "DMA_DAR_HIGH";
        desc = "DMA_DAR_HIGH is the DMA destination address high register. DMA_DAR_HIGH (offset 0x0A88, total reset 0x0000_0000; PROVEN: Hi3535 data sheet, PDF page 1355, section 13.7.6.4).";
        field {
            name = "dma_dar_high";
            desc = "Destination address (upper 32 bits) of DMA data transfers. Must be 0 in 32-bit address mode. In 64-bit address mode it forms the 64-bit destination address together with DMA_DAR_LOW.";
            sw = rw; hw = r;
            reset = 0x0;
        } dma_dar_high[31:0];
    } DMA_DAR_HIGH @ 0xa88;
};

`endif
