`ifndef EHI3535_DDRC_MUX_RDL
`define EHI3535_DDRC_MUX_RDL
regfile eHI3535_DDRC_MUX {
    name = "DDRC MUX module";
    desc = "DDRC MUX module. 5 registers extracted programmatically from the Hi3535 H.264 codec processor (Hi3535 user guide) data sheet (Issue 00B08, 2014-02-25); chapter 4.1.7, tables 4-4/4-5. Field names, bit ranges, access types and reset values are taken from the register tables; reset values are the data sheet total reset values split onto the fields (per-field values where the table has them). Label: PROVEN. Hardware not verified here (no board).";
    reg {
        name = "MUX_DDR_MODE";
        desc = "MUX_DDR_MODE is the register that configures the DDR device concatenation mode. MUX_DDR_MODE (offset 0x000, total reset 0x0000_0000; PROVEN: Hi3535 data sheet, PDF page 660, section 4.1.7.2).";
        field {
            name = "reserved";
            desc = "Reserved.";
            sw = r; hw = w;
            reset = 0x0;
        } reserved_31_3[31:3];
        field {
            name = "mem_comb";
            desc = "When mem_mode=1'b1, the capacity ratio of the low 16-bit DDR device to the high 16-bit DDR device:
- 00: 2G bit:1G bit;
- 01: 4G bit:2G bit;
- 10: 8G bit:4G bit;
Other values: reserved.";
            sw = rw; hw = r;
            reset = 0x0;
        } mem_comb[2:1];
        field {
            name = "mem_mode";
            desc = "DDR device mode selection when the memory data width is 32 bits.
- 0: The low 16-bit DDR device and the high 16-bit DDR have the same capacity;
- 1: The low 16-bit DDR device and the high 16-bit DDR have different capacities, and the low 16-bit DDR device is larger than the high 16-bit DDR. Note: Must be configured as 0 when the memory data width is 16 bits.";
            sw = rw; hw = r;
            reset = 0x0;
        } mem_mode[0:0];
    } MUX_DDR_MODE @ 0x0;
    reg {
        name = "MUX_CLKGCFG";
        desc = "MUX_CLKGCFG is the MUX module clock gate configuration register. MUX_CLKGCFG (offset 0x004, total reset 0x0000_0007; PROVEN: Hi3535 data sheet, PDF page 661, section 4.1.7.2).";
        field {
            name = "reserved";
            desc = "Reserved.";
            sw = r; hw = w;
            reset = 0x0;
        } reserved_31_3[31:3];
        field {
            name = "detaddr_gt_en";
            desc = "Static clock gating of the address detection module.
- 0: Clock off.
- 1: Clock always on.";
            sw = rw; hw = r;
            reset = 0x1;
        } detaddr_gt_en[2:2];
        field {
            name = "muxcmd_gt_en";
            desc = "Static clock gating of the command select module.
- 0: Clock off.
- 1: Clock always on.";
            sw = rw; hw = r;
            reset = 0x1;
        } muxcmd_gt_en[1:1];
        field {
            name = "apg_gt_en";
            desc = "Static clock gating of the register module.
- 0: Clock off;
- 1: Clock always on.";
            sw = rw; hw = r;
            reset = 0x1;
        } apg_gt_en[0:0];
    } MUX_CLKGCFG @ 0x4;
    reg {
        name = "AWADDR_SRVLNC_STARTN";
        desc = "AWADDR_SRVLNC_STARTN is the register for the start address of the n-th monitored address region. AWADDR_SRVLNC_STARTN (offset 0x100+0x8xaddr_zones (addr_zones = 0~31), total reset 0x0000_0000; PROVEN: Hi3535 data sheet, PDF page 662, section 4.1.7.2).";
        field {
            name = "awaddr_srvlnc_start";
            desc = "Start address of address region n. Note: The low 4 address bits are ignored.";
            sw = rw; hw = r;
            reset = 0x0;
        } awaddr_srvlnc_start[31:0];
    } AWADDR_SRVLNC_STARTN_0 @ 0x100;
    reg {
        name = "AWADDR_SRVLNC_STARTN";
        desc = "AWADDR_SRVLNC_STARTN is the register for the start address of the n-th monitored address region. AWADDR_SRVLNC_STARTN (offset 0x100+0x8xaddr_zones (addr_zones = 0~31), total reset 0x0000_0000; PROVEN: Hi3535 data sheet, PDF page 662, section 4.1.7.2).";
        field {
            name = "awaddr_srvlnc_start";
            desc = "Start address of address region n. Note: The low 4 address bits are ignored.";
            sw = rw; hw = r;
            reset = 0x0;
        } awaddr_srvlnc_start[31:0];
    } AWADDR_SRVLNC_STARTN_1 @ 0x108;
    reg {
        name = "AWADDR_SRVLNC_STARTN";
        desc = "AWADDR_SRVLNC_STARTN is the register for the start address of the n-th monitored address region. AWADDR_SRVLNC_STARTN (offset 0x100+0x8xaddr_zones (addr_zones = 0~31), total reset 0x0000_0000; PROVEN: Hi3535 data sheet, PDF page 662, section 4.1.7.2).";
        field {
            name = "awaddr_srvlnc_start";
            desc = "Start address of address region n. Note: The low 4 address bits are ignored.";
            sw = rw; hw = r;
            reset = 0x0;
        } awaddr_srvlnc_start[31:0];
    } AWADDR_SRVLNC_STARTN_2 @ 0x110;
    reg {
        name = "AWADDR_SRVLNC_STARTN";
        desc = "AWADDR_SRVLNC_STARTN is the register for the start address of the n-th monitored address region. AWADDR_SRVLNC_STARTN (offset 0x100+0x8xaddr_zones (addr_zones = 0~31), total reset 0x0000_0000; PROVEN: Hi3535 data sheet, PDF page 662, section 4.1.7.2).";
        field {
            name = "awaddr_srvlnc_start";
            desc = "Start address of address region n. Note: The low 4 address bits are ignored.";
            sw = rw; hw = r;
            reset = 0x0;
        } awaddr_srvlnc_start[31:0];
    } AWADDR_SRVLNC_STARTN_3 @ 0x118;
    reg {
        name = "AWADDR_SRVLNC_STARTN";
        desc = "AWADDR_SRVLNC_STARTN is the register for the start address of the n-th monitored address region. AWADDR_SRVLNC_STARTN (offset 0x100+0x8xaddr_zones (addr_zones = 0~31), total reset 0x0000_0000; PROVEN: Hi3535 data sheet, PDF page 662, section 4.1.7.2).";
        field {
            name = "awaddr_srvlnc_start";
            desc = "Start address of address region n. Note: The low 4 address bits are ignored.";
            sw = rw; hw = r;
            reset = 0x0;
        } awaddr_srvlnc_start[31:0];
    } AWADDR_SRVLNC_STARTN_4 @ 0x120;
    reg {
        name = "AWADDR_SRVLNC_STARTN";
        desc = "AWADDR_SRVLNC_STARTN is the register for the start address of the n-th monitored address region. AWADDR_SRVLNC_STARTN (offset 0x100+0x8xaddr_zones (addr_zones = 0~31), total reset 0x0000_0000; PROVEN: Hi3535 data sheet, PDF page 662, section 4.1.7.2).";
        field {
            name = "awaddr_srvlnc_start";
            desc = "Start address of address region n. Note: The low 4 address bits are ignored.";
            sw = rw; hw = r;
            reset = 0x0;
        } awaddr_srvlnc_start[31:0];
    } AWADDR_SRVLNC_STARTN_5 @ 0x128;
    reg {
        name = "AWADDR_SRVLNC_STARTN";
        desc = "AWADDR_SRVLNC_STARTN is the register for the start address of the n-th monitored address region. AWADDR_SRVLNC_STARTN (offset 0x100+0x8xaddr_zones (addr_zones = 0~31), total reset 0x0000_0000; PROVEN: Hi3535 data sheet, PDF page 662, section 4.1.7.2).";
        field {
            name = "awaddr_srvlnc_start";
            desc = "Start address of address region n. Note: The low 4 address bits are ignored.";
            sw = rw; hw = r;
            reset = 0x0;
        } awaddr_srvlnc_start[31:0];
    } AWADDR_SRVLNC_STARTN_6 @ 0x130;
    reg {
        name = "AWADDR_SRVLNC_STARTN";
        desc = "AWADDR_SRVLNC_STARTN is the register for the start address of the n-th monitored address region. AWADDR_SRVLNC_STARTN (offset 0x100+0x8xaddr_zones (addr_zones = 0~31), total reset 0x0000_0000; PROVEN: Hi3535 data sheet, PDF page 662, section 4.1.7.2).";
        field {
            name = "awaddr_srvlnc_start";
            desc = "Start address of address region n. Note: The low 4 address bits are ignored.";
            sw = rw; hw = r;
            reset = 0x0;
        } awaddr_srvlnc_start[31:0];
    } AWADDR_SRVLNC_STARTN_7 @ 0x138;
    reg {
        name = "AWADDR_SRVLNC_STARTN";
        desc = "AWADDR_SRVLNC_STARTN is the register for the start address of the n-th monitored address region. AWADDR_SRVLNC_STARTN (offset 0x100+0x8xaddr_zones (addr_zones = 0~31), total reset 0x0000_0000; PROVEN: Hi3535 data sheet, PDF page 662, section 4.1.7.2).";
        field {
            name = "awaddr_srvlnc_start";
            desc = "Start address of address region n. Note: The low 4 address bits are ignored.";
            sw = rw; hw = r;
            reset = 0x0;
        } awaddr_srvlnc_start[31:0];
    } AWADDR_SRVLNC_STARTN_8 @ 0x140;
    reg {
        name = "AWADDR_SRVLNC_STARTN";
        desc = "AWADDR_SRVLNC_STARTN is the register for the start address of the n-th monitored address region. AWADDR_SRVLNC_STARTN (offset 0x100+0x8xaddr_zones (addr_zones = 0~31), total reset 0x0000_0000; PROVEN: Hi3535 data sheet, PDF page 662, section 4.1.7.2).";
        field {
            name = "awaddr_srvlnc_start";
            desc = "Start address of address region n. Note: The low 4 address bits are ignored.";
            sw = rw; hw = r;
            reset = 0x0;
        } awaddr_srvlnc_start[31:0];
    } AWADDR_SRVLNC_STARTN_9 @ 0x148;
    reg {
        name = "AWADDR_SRVLNC_STARTN";
        desc = "AWADDR_SRVLNC_STARTN is the register for the start address of the n-th monitored address region. AWADDR_SRVLNC_STARTN (offset 0x100+0x8xaddr_zones (addr_zones = 0~31), total reset 0x0000_0000; PROVEN: Hi3535 data sheet, PDF page 662, section 4.1.7.2).";
        field {
            name = "awaddr_srvlnc_start";
            desc = "Start address of address region n. Note: The low 4 address bits are ignored.";
            sw = rw; hw = r;
            reset = 0x0;
        } awaddr_srvlnc_start[31:0];
    } AWADDR_SRVLNC_STARTN_10 @ 0x150;
    reg {
        name = "AWADDR_SRVLNC_STARTN";
        desc = "AWADDR_SRVLNC_STARTN is the register for the start address of the n-th monitored address region. AWADDR_SRVLNC_STARTN (offset 0x100+0x8xaddr_zones (addr_zones = 0~31), total reset 0x0000_0000; PROVEN: Hi3535 data sheet, PDF page 662, section 4.1.7.2).";
        field {
            name = "awaddr_srvlnc_start";
            desc = "Start address of address region n. Note: The low 4 address bits are ignored.";
            sw = rw; hw = r;
            reset = 0x0;
        } awaddr_srvlnc_start[31:0];
    } AWADDR_SRVLNC_STARTN_11 @ 0x158;
    reg {
        name = "AWADDR_SRVLNC_STARTN";
        desc = "AWADDR_SRVLNC_STARTN is the register for the start address of the n-th monitored address region. AWADDR_SRVLNC_STARTN (offset 0x100+0x8xaddr_zones (addr_zones = 0~31), total reset 0x0000_0000; PROVEN: Hi3535 data sheet, PDF page 662, section 4.1.7.2).";
        field {
            name = "awaddr_srvlnc_start";
            desc = "Start address of address region n. Note: The low 4 address bits are ignored.";
            sw = rw; hw = r;
            reset = 0x0;
        } awaddr_srvlnc_start[31:0];
    } AWADDR_SRVLNC_STARTN_12 @ 0x160;
    reg {
        name = "AWADDR_SRVLNC_STARTN";
        desc = "AWADDR_SRVLNC_STARTN is the register for the start address of the n-th monitored address region. AWADDR_SRVLNC_STARTN (offset 0x100+0x8xaddr_zones (addr_zones = 0~31), total reset 0x0000_0000; PROVEN: Hi3535 data sheet, PDF page 662, section 4.1.7.2).";
        field {
            name = "awaddr_srvlnc_start";
            desc = "Start address of address region n. Note: The low 4 address bits are ignored.";
            sw = rw; hw = r;
            reset = 0x0;
        } awaddr_srvlnc_start[31:0];
    } AWADDR_SRVLNC_STARTN_13 @ 0x168;
    reg {
        name = "AWADDR_SRVLNC_STARTN";
        desc = "AWADDR_SRVLNC_STARTN is the register for the start address of the n-th monitored address region. AWADDR_SRVLNC_STARTN (offset 0x100+0x8xaddr_zones (addr_zones = 0~31), total reset 0x0000_0000; PROVEN: Hi3535 data sheet, PDF page 662, section 4.1.7.2).";
        field {
            name = "awaddr_srvlnc_start";
            desc = "Start address of address region n. Note: The low 4 address bits are ignored.";
            sw = rw; hw = r;
            reset = 0x0;
        } awaddr_srvlnc_start[31:0];
    } AWADDR_SRVLNC_STARTN_14 @ 0x170;
    reg {
        name = "AWADDR_SRVLNC_STARTN";
        desc = "AWADDR_SRVLNC_STARTN is the register for the start address of the n-th monitored address region. AWADDR_SRVLNC_STARTN (offset 0x100+0x8xaddr_zones (addr_zones = 0~31), total reset 0x0000_0000; PROVEN: Hi3535 data sheet, PDF page 662, section 4.1.7.2).";
        field {
            name = "awaddr_srvlnc_start";
            desc = "Start address of address region n. Note: The low 4 address bits are ignored.";
            sw = rw; hw = r;
            reset = 0x0;
        } awaddr_srvlnc_start[31:0];
    } AWADDR_SRVLNC_STARTN_15 @ 0x178;
    reg {
        name = "AWADDR_SRVLNC_STARTN";
        desc = "AWADDR_SRVLNC_STARTN is the register for the start address of the n-th monitored address region. AWADDR_SRVLNC_STARTN (offset 0x100+0x8xaddr_zones (addr_zones = 0~31), total reset 0x0000_0000; PROVEN: Hi3535 data sheet, PDF page 662, section 4.1.7.2).";
        field {
            name = "awaddr_srvlnc_start";
            desc = "Start address of address region n. Note: The low 4 address bits are ignored.";
            sw = rw; hw = r;
            reset = 0x0;
        } awaddr_srvlnc_start[31:0];
    } AWADDR_SRVLNC_STARTN_16 @ 0x180;
    reg {
        name = "AWADDR_SRVLNC_STARTN";
        desc = "AWADDR_SRVLNC_STARTN is the register for the start address of the n-th monitored address region. AWADDR_SRVLNC_STARTN (offset 0x100+0x8xaddr_zones (addr_zones = 0~31), total reset 0x0000_0000; PROVEN: Hi3535 data sheet, PDF page 662, section 4.1.7.2).";
        field {
            name = "awaddr_srvlnc_start";
            desc = "Start address of address region n. Note: The low 4 address bits are ignored.";
            sw = rw; hw = r;
            reset = 0x0;
        } awaddr_srvlnc_start[31:0];
    } AWADDR_SRVLNC_STARTN_17 @ 0x188;
    reg {
        name = "AWADDR_SRVLNC_STARTN";
        desc = "AWADDR_SRVLNC_STARTN is the register for the start address of the n-th monitored address region. AWADDR_SRVLNC_STARTN (offset 0x100+0x8xaddr_zones (addr_zones = 0~31), total reset 0x0000_0000; PROVEN: Hi3535 data sheet, PDF page 662, section 4.1.7.2).";
        field {
            name = "awaddr_srvlnc_start";
            desc = "Start address of address region n. Note: The low 4 address bits are ignored.";
            sw = rw; hw = r;
            reset = 0x0;
        } awaddr_srvlnc_start[31:0];
    } AWADDR_SRVLNC_STARTN_18 @ 0x190;
    reg {
        name = "AWADDR_SRVLNC_STARTN";
        desc = "AWADDR_SRVLNC_STARTN is the register for the start address of the n-th monitored address region. AWADDR_SRVLNC_STARTN (offset 0x100+0x8xaddr_zones (addr_zones = 0~31), total reset 0x0000_0000; PROVEN: Hi3535 data sheet, PDF page 662, section 4.1.7.2).";
        field {
            name = "awaddr_srvlnc_start";
            desc = "Start address of address region n. Note: The low 4 address bits are ignored.";
            sw = rw; hw = r;
            reset = 0x0;
        } awaddr_srvlnc_start[31:0];
    } AWADDR_SRVLNC_STARTN_19 @ 0x198;
    reg {
        name = "AWADDR_SRVLNC_STARTN";
        desc = "AWADDR_SRVLNC_STARTN is the register for the start address of the n-th monitored address region. AWADDR_SRVLNC_STARTN (offset 0x100+0x8xaddr_zones (addr_zones = 0~31), total reset 0x0000_0000; PROVEN: Hi3535 data sheet, PDF page 662, section 4.1.7.2).";
        field {
            name = "awaddr_srvlnc_start";
            desc = "Start address of address region n. Note: The low 4 address bits are ignored.";
            sw = rw; hw = r;
            reset = 0x0;
        } awaddr_srvlnc_start[31:0];
    } AWADDR_SRVLNC_STARTN_20 @ 0x1a0;
    reg {
        name = "AWADDR_SRVLNC_STARTN";
        desc = "AWADDR_SRVLNC_STARTN is the register for the start address of the n-th monitored address region. AWADDR_SRVLNC_STARTN (offset 0x100+0x8xaddr_zones (addr_zones = 0~31), total reset 0x0000_0000; PROVEN: Hi3535 data sheet, PDF page 662, section 4.1.7.2).";
        field {
            name = "awaddr_srvlnc_start";
            desc = "Start address of address region n. Note: The low 4 address bits are ignored.";
            sw = rw; hw = r;
            reset = 0x0;
        } awaddr_srvlnc_start[31:0];
    } AWADDR_SRVLNC_STARTN_21 @ 0x1a8;
    reg {
        name = "AWADDR_SRVLNC_STARTN";
        desc = "AWADDR_SRVLNC_STARTN is the register for the start address of the n-th monitored address region. AWADDR_SRVLNC_STARTN (offset 0x100+0x8xaddr_zones (addr_zones = 0~31), total reset 0x0000_0000; PROVEN: Hi3535 data sheet, PDF page 662, section 4.1.7.2).";
        field {
            name = "awaddr_srvlnc_start";
            desc = "Start address of address region n. Note: The low 4 address bits are ignored.";
            sw = rw; hw = r;
            reset = 0x0;
        } awaddr_srvlnc_start[31:0];
    } AWADDR_SRVLNC_STARTN_22 @ 0x1b0;
    reg {
        name = "AWADDR_SRVLNC_STARTN";
        desc = "AWADDR_SRVLNC_STARTN is the register for the start address of the n-th monitored address region. AWADDR_SRVLNC_STARTN (offset 0x100+0x8xaddr_zones (addr_zones = 0~31), total reset 0x0000_0000; PROVEN: Hi3535 data sheet, PDF page 662, section 4.1.7.2).";
        field {
            name = "awaddr_srvlnc_start";
            desc = "Start address of address region n. Note: The low 4 address bits are ignored.";
            sw = rw; hw = r;
            reset = 0x0;
        } awaddr_srvlnc_start[31:0];
    } AWADDR_SRVLNC_STARTN_23 @ 0x1b8;
    reg {
        name = "AWADDR_SRVLNC_STARTN";
        desc = "AWADDR_SRVLNC_STARTN is the register for the start address of the n-th monitored address region. AWADDR_SRVLNC_STARTN (offset 0x100+0x8xaddr_zones (addr_zones = 0~31), total reset 0x0000_0000; PROVEN: Hi3535 data sheet, PDF page 662, section 4.1.7.2).";
        field {
            name = "awaddr_srvlnc_start";
            desc = "Start address of address region n. Note: The low 4 address bits are ignored.";
            sw = rw; hw = r;
            reset = 0x0;
        } awaddr_srvlnc_start[31:0];
    } AWADDR_SRVLNC_STARTN_24 @ 0x1c0;
    reg {
        name = "AWADDR_SRVLNC_STARTN";
        desc = "AWADDR_SRVLNC_STARTN is the register for the start address of the n-th monitored address region. AWADDR_SRVLNC_STARTN (offset 0x100+0x8xaddr_zones (addr_zones = 0~31), total reset 0x0000_0000; PROVEN: Hi3535 data sheet, PDF page 662, section 4.1.7.2).";
        field {
            name = "awaddr_srvlnc_start";
            desc = "Start address of address region n. Note: The low 4 address bits are ignored.";
            sw = rw; hw = r;
            reset = 0x0;
        } awaddr_srvlnc_start[31:0];
    } AWADDR_SRVLNC_STARTN_25 @ 0x1c8;
    reg {
        name = "AWADDR_SRVLNC_STARTN";
        desc = "AWADDR_SRVLNC_STARTN is the register for the start address of the n-th monitored address region. AWADDR_SRVLNC_STARTN (offset 0x100+0x8xaddr_zones (addr_zones = 0~31), total reset 0x0000_0000; PROVEN: Hi3535 data sheet, PDF page 662, section 4.1.7.2).";
        field {
            name = "awaddr_srvlnc_start";
            desc = "Start address of address region n. Note: The low 4 address bits are ignored.";
            sw = rw; hw = r;
            reset = 0x0;
        } awaddr_srvlnc_start[31:0];
    } AWADDR_SRVLNC_STARTN_26 @ 0x1d0;
    reg {
        name = "AWADDR_SRVLNC_STARTN";
        desc = "AWADDR_SRVLNC_STARTN is the register for the start address of the n-th monitored address region. AWADDR_SRVLNC_STARTN (offset 0x100+0x8xaddr_zones (addr_zones = 0~31), total reset 0x0000_0000; PROVEN: Hi3535 data sheet, PDF page 662, section 4.1.7.2).";
        field {
            name = "awaddr_srvlnc_start";
            desc = "Start address of address region n. Note: The low 4 address bits are ignored.";
            sw = rw; hw = r;
            reset = 0x0;
        } awaddr_srvlnc_start[31:0];
    } AWADDR_SRVLNC_STARTN_27 @ 0x1d8;
    reg {
        name = "AWADDR_SRVLNC_STARTN";
        desc = "AWADDR_SRVLNC_STARTN is the register for the start address of the n-th monitored address region. AWADDR_SRVLNC_STARTN (offset 0x100+0x8xaddr_zones (addr_zones = 0~31), total reset 0x0000_0000; PROVEN: Hi3535 data sheet, PDF page 662, section 4.1.7.2).";
        field {
            name = "awaddr_srvlnc_start";
            desc = "Start address of address region n. Note: The low 4 address bits are ignored.";
            sw = rw; hw = r;
            reset = 0x0;
        } awaddr_srvlnc_start[31:0];
    } AWADDR_SRVLNC_STARTN_28 @ 0x1e0;
    reg {
        name = "AWADDR_SRVLNC_STARTN";
        desc = "AWADDR_SRVLNC_STARTN is the register for the start address of the n-th monitored address region. AWADDR_SRVLNC_STARTN (offset 0x100+0x8xaddr_zones (addr_zones = 0~31), total reset 0x0000_0000; PROVEN: Hi3535 data sheet, PDF page 662, section 4.1.7.2).";
        field {
            name = "awaddr_srvlnc_start";
            desc = "Start address of address region n. Note: The low 4 address bits are ignored.";
            sw = rw; hw = r;
            reset = 0x0;
        } awaddr_srvlnc_start[31:0];
    } AWADDR_SRVLNC_STARTN_29 @ 0x1e8;
    reg {
        name = "AWADDR_SRVLNC_STARTN";
        desc = "AWADDR_SRVLNC_STARTN is the register for the start address of the n-th monitored address region. AWADDR_SRVLNC_STARTN (offset 0x100+0x8xaddr_zones (addr_zones = 0~31), total reset 0x0000_0000; PROVEN: Hi3535 data sheet, PDF page 662, section 4.1.7.2).";
        field {
            name = "awaddr_srvlnc_start";
            desc = "Start address of address region n. Note: The low 4 address bits are ignored.";
            sw = rw; hw = r;
            reset = 0x0;
        } awaddr_srvlnc_start[31:0];
    } AWADDR_SRVLNC_STARTN_30 @ 0x1f0;
    reg {
        name = "AWADDR_SRVLNC_STARTN";
        desc = "AWADDR_SRVLNC_STARTN is the register for the start address of the n-th monitored address region. AWADDR_SRVLNC_STARTN (offset 0x100+0x8xaddr_zones (addr_zones = 0~31), total reset 0x0000_0000; PROVEN: Hi3535 data sheet, PDF page 662, section 4.1.7.2).";
        field {
            name = "awaddr_srvlnc_start";
            desc = "Start address of address region n. Note: The low 4 address bits are ignored.";
            sw = rw; hw = r;
            reset = 0x0;
        } awaddr_srvlnc_start[31:0];
    } AWADDR_SRVLNC_STARTN_31 @ 0x1f8;
    reg {
        name = "AWADDR_SRVLNC_ENDN";
        desc = "AWADDR_SRVLNC_ENDN is the register for the end address of the n-th monitored address region. AWADDR_SRVLNC_ENDN (offset 0x104+0x8xaddr_zones (addr_zones = 0~31), total reset 0x0000_0000; PROVEN: Hi3535 data sheet, PDF page 662, section 4.1.7.2).";
        field {
            name = "awaddr_srvlnc_end";
            desc = "End address of address region n. Note: The lower 4 address bits are ignored; the configured value is the actual end address + 1.";
            sw = rw; hw = r;
            reset = 0x0;
        } awaddr_srvlnc_end[31:0];
    } AWADDR_SRVLNC_ENDN_0 @ 0x104;
    reg {
        name = "AWADDR_SRVLNC_ENDN";
        desc = "AWADDR_SRVLNC_ENDN is the register for the end address of the n-th monitored address region. AWADDR_SRVLNC_ENDN (offset 0x104+0x8xaddr_zones (addr_zones = 0~31), total reset 0x0000_0000; PROVEN: Hi3535 data sheet, PDF page 662, section 4.1.7.2).";
        field {
            name = "awaddr_srvlnc_end";
            desc = "End address of address region n. Note: The lower 4 address bits are ignored; the configured value is the actual end address + 1.";
            sw = rw; hw = r;
            reset = 0x0;
        } awaddr_srvlnc_end[31:0];
    } AWADDR_SRVLNC_ENDN_1 @ 0x10c;
    reg {
        name = "AWADDR_SRVLNC_ENDN";
        desc = "AWADDR_SRVLNC_ENDN is the register for the end address of the n-th monitored address region. AWADDR_SRVLNC_ENDN (offset 0x104+0x8xaddr_zones (addr_zones = 0~31), total reset 0x0000_0000; PROVEN: Hi3535 data sheet, PDF page 662, section 4.1.7.2).";
        field {
            name = "awaddr_srvlnc_end";
            desc = "End address of address region n. Note: The lower 4 address bits are ignored; the configured value is the actual end address + 1.";
            sw = rw; hw = r;
            reset = 0x0;
        } awaddr_srvlnc_end[31:0];
    } AWADDR_SRVLNC_ENDN_2 @ 0x114;
    reg {
        name = "AWADDR_SRVLNC_ENDN";
        desc = "AWADDR_SRVLNC_ENDN is the register for the end address of the n-th monitored address region. AWADDR_SRVLNC_ENDN (offset 0x104+0x8xaddr_zones (addr_zones = 0~31), total reset 0x0000_0000; PROVEN: Hi3535 data sheet, PDF page 662, section 4.1.7.2).";
        field {
            name = "awaddr_srvlnc_end";
            desc = "End address of address region n. Note: The lower 4 address bits are ignored; the configured value is the actual end address + 1.";
            sw = rw; hw = r;
            reset = 0x0;
        } awaddr_srvlnc_end[31:0];
    } AWADDR_SRVLNC_ENDN_3 @ 0x11c;
    reg {
        name = "AWADDR_SRVLNC_ENDN";
        desc = "AWADDR_SRVLNC_ENDN is the register for the end address of the n-th monitored address region. AWADDR_SRVLNC_ENDN (offset 0x104+0x8xaddr_zones (addr_zones = 0~31), total reset 0x0000_0000; PROVEN: Hi3535 data sheet, PDF page 662, section 4.1.7.2).";
        field {
            name = "awaddr_srvlnc_end";
            desc = "End address of address region n. Note: The lower 4 address bits are ignored; the configured value is the actual end address + 1.";
            sw = rw; hw = r;
            reset = 0x0;
        } awaddr_srvlnc_end[31:0];
    } AWADDR_SRVLNC_ENDN_4 @ 0x124;
    reg {
        name = "AWADDR_SRVLNC_ENDN";
        desc = "AWADDR_SRVLNC_ENDN is the register for the end address of the n-th monitored address region. AWADDR_SRVLNC_ENDN (offset 0x104+0x8xaddr_zones (addr_zones = 0~31), total reset 0x0000_0000; PROVEN: Hi3535 data sheet, PDF page 662, section 4.1.7.2).";
        field {
            name = "awaddr_srvlnc_end";
            desc = "End address of address region n. Note: The lower 4 address bits are ignored; the configured value is the actual end address + 1.";
            sw = rw; hw = r;
            reset = 0x0;
        } awaddr_srvlnc_end[31:0];
    } AWADDR_SRVLNC_ENDN_5 @ 0x12c;
    reg {
        name = "AWADDR_SRVLNC_ENDN";
        desc = "AWADDR_SRVLNC_ENDN is the register for the end address of the n-th monitored address region. AWADDR_SRVLNC_ENDN (offset 0x104+0x8xaddr_zones (addr_zones = 0~31), total reset 0x0000_0000; PROVEN: Hi3535 data sheet, PDF page 662, section 4.1.7.2).";
        field {
            name = "awaddr_srvlnc_end";
            desc = "End address of address region n. Note: The lower 4 address bits are ignored; the configured value is the actual end address + 1.";
            sw = rw; hw = r;
            reset = 0x0;
        } awaddr_srvlnc_end[31:0];
    } AWADDR_SRVLNC_ENDN_6 @ 0x134;
    reg {
        name = "AWADDR_SRVLNC_ENDN";
        desc = "AWADDR_SRVLNC_ENDN is the register for the end address of the n-th monitored address region. AWADDR_SRVLNC_ENDN (offset 0x104+0x8xaddr_zones (addr_zones = 0~31), total reset 0x0000_0000; PROVEN: Hi3535 data sheet, PDF page 662, section 4.1.7.2).";
        field {
            name = "awaddr_srvlnc_end";
            desc = "End address of address region n. Note: The lower 4 address bits are ignored; the configured value is the actual end address + 1.";
            sw = rw; hw = r;
            reset = 0x0;
        } awaddr_srvlnc_end[31:0];
    } AWADDR_SRVLNC_ENDN_7 @ 0x13c;
    reg {
        name = "AWADDR_SRVLNC_ENDN";
        desc = "AWADDR_SRVLNC_ENDN is the register for the end address of the n-th monitored address region. AWADDR_SRVLNC_ENDN (offset 0x104+0x8xaddr_zones (addr_zones = 0~31), total reset 0x0000_0000; PROVEN: Hi3535 data sheet, PDF page 662, section 4.1.7.2).";
        field {
            name = "awaddr_srvlnc_end";
            desc = "End address of address region n. Note: The lower 4 address bits are ignored; the configured value is the actual end address + 1.";
            sw = rw; hw = r;
            reset = 0x0;
        } awaddr_srvlnc_end[31:0];
    } AWADDR_SRVLNC_ENDN_8 @ 0x144;
    reg {
        name = "AWADDR_SRVLNC_ENDN";
        desc = "AWADDR_SRVLNC_ENDN is the register for the end address of the n-th monitored address region. AWADDR_SRVLNC_ENDN (offset 0x104+0x8xaddr_zones (addr_zones = 0~31), total reset 0x0000_0000; PROVEN: Hi3535 data sheet, PDF page 662, section 4.1.7.2).";
        field {
            name = "awaddr_srvlnc_end";
            desc = "End address of address region n. Note: The lower 4 address bits are ignored; the configured value is the actual end address + 1.";
            sw = rw; hw = r;
            reset = 0x0;
        } awaddr_srvlnc_end[31:0];
    } AWADDR_SRVLNC_ENDN_9 @ 0x14c;
    reg {
        name = "AWADDR_SRVLNC_ENDN";
        desc = "AWADDR_SRVLNC_ENDN is the register for the end address of the n-th monitored address region. AWADDR_SRVLNC_ENDN (offset 0x104+0x8xaddr_zones (addr_zones = 0~31), total reset 0x0000_0000; PROVEN: Hi3535 data sheet, PDF page 662, section 4.1.7.2).";
        field {
            name = "awaddr_srvlnc_end";
            desc = "End address of address region n. Note: The lower 4 address bits are ignored; the configured value is the actual end address + 1.";
            sw = rw; hw = r;
            reset = 0x0;
        } awaddr_srvlnc_end[31:0];
    } AWADDR_SRVLNC_ENDN_10 @ 0x154;
    reg {
        name = "AWADDR_SRVLNC_ENDN";
        desc = "AWADDR_SRVLNC_ENDN is the register for the end address of the n-th monitored address region. AWADDR_SRVLNC_ENDN (offset 0x104+0x8xaddr_zones (addr_zones = 0~31), total reset 0x0000_0000; PROVEN: Hi3535 data sheet, PDF page 662, section 4.1.7.2).";
        field {
            name = "awaddr_srvlnc_end";
            desc = "End address of address region n. Note: The lower 4 address bits are ignored; the configured value is the actual end address + 1.";
            sw = rw; hw = r;
            reset = 0x0;
        } awaddr_srvlnc_end[31:0];
    } AWADDR_SRVLNC_ENDN_11 @ 0x15c;
    reg {
        name = "AWADDR_SRVLNC_ENDN";
        desc = "AWADDR_SRVLNC_ENDN is the register for the end address of the n-th monitored address region. AWADDR_SRVLNC_ENDN (offset 0x104+0x8xaddr_zones (addr_zones = 0~31), total reset 0x0000_0000; PROVEN: Hi3535 data sheet, PDF page 662, section 4.1.7.2).";
        field {
            name = "awaddr_srvlnc_end";
            desc = "End address of address region n. Note: The lower 4 address bits are ignored; the configured value is the actual end address + 1.";
            sw = rw; hw = r;
            reset = 0x0;
        } awaddr_srvlnc_end[31:0];
    } AWADDR_SRVLNC_ENDN_12 @ 0x164;
    reg {
        name = "AWADDR_SRVLNC_ENDN";
        desc = "AWADDR_SRVLNC_ENDN is the register for the end address of the n-th monitored address region. AWADDR_SRVLNC_ENDN (offset 0x104+0x8xaddr_zones (addr_zones = 0~31), total reset 0x0000_0000; PROVEN: Hi3535 data sheet, PDF page 662, section 4.1.7.2).";
        field {
            name = "awaddr_srvlnc_end";
            desc = "End address of address region n. Note: The lower 4 address bits are ignored; the configured value is the actual end address + 1.";
            sw = rw; hw = r;
            reset = 0x0;
        } awaddr_srvlnc_end[31:0];
    } AWADDR_SRVLNC_ENDN_13 @ 0x16c;
    reg {
        name = "AWADDR_SRVLNC_ENDN";
        desc = "AWADDR_SRVLNC_ENDN is the register for the end address of the n-th monitored address region. AWADDR_SRVLNC_ENDN (offset 0x104+0x8xaddr_zones (addr_zones = 0~31), total reset 0x0000_0000; PROVEN: Hi3535 data sheet, PDF page 662, section 4.1.7.2).";
        field {
            name = "awaddr_srvlnc_end";
            desc = "End address of address region n. Note: The lower 4 address bits are ignored; the configured value is the actual end address + 1.";
            sw = rw; hw = r;
            reset = 0x0;
        } awaddr_srvlnc_end[31:0];
    } AWADDR_SRVLNC_ENDN_14 @ 0x174;
    reg {
        name = "AWADDR_SRVLNC_ENDN";
        desc = "AWADDR_SRVLNC_ENDN is the register for the end address of the n-th monitored address region. AWADDR_SRVLNC_ENDN (offset 0x104+0x8xaddr_zones (addr_zones = 0~31), total reset 0x0000_0000; PROVEN: Hi3535 data sheet, PDF page 662, section 4.1.7.2).";
        field {
            name = "awaddr_srvlnc_end";
            desc = "End address of address region n. Note: The lower 4 address bits are ignored; the configured value is the actual end address + 1.";
            sw = rw; hw = r;
            reset = 0x0;
        } awaddr_srvlnc_end[31:0];
    } AWADDR_SRVLNC_ENDN_15 @ 0x17c;
    reg {
        name = "AWADDR_SRVLNC_ENDN";
        desc = "AWADDR_SRVLNC_ENDN is the register for the end address of the n-th monitored address region. AWADDR_SRVLNC_ENDN (offset 0x104+0x8xaddr_zones (addr_zones = 0~31), total reset 0x0000_0000; PROVEN: Hi3535 data sheet, PDF page 662, section 4.1.7.2).";
        field {
            name = "awaddr_srvlnc_end";
            desc = "End address of address region n. Note: The lower 4 address bits are ignored; the configured value is the actual end address + 1.";
            sw = rw; hw = r;
            reset = 0x0;
        } awaddr_srvlnc_end[31:0];
    } AWADDR_SRVLNC_ENDN_16 @ 0x184;
    reg {
        name = "AWADDR_SRVLNC_ENDN";
        desc = "AWADDR_SRVLNC_ENDN is the register for the end address of the n-th monitored address region. AWADDR_SRVLNC_ENDN (offset 0x104+0x8xaddr_zones (addr_zones = 0~31), total reset 0x0000_0000; PROVEN: Hi3535 data sheet, PDF page 662, section 4.1.7.2).";
        field {
            name = "awaddr_srvlnc_end";
            desc = "End address of address region n. Note: The lower 4 address bits are ignored; the configured value is the actual end address + 1.";
            sw = rw; hw = r;
            reset = 0x0;
        } awaddr_srvlnc_end[31:0];
    } AWADDR_SRVLNC_ENDN_17 @ 0x18c;
    reg {
        name = "AWADDR_SRVLNC_ENDN";
        desc = "AWADDR_SRVLNC_ENDN is the register for the end address of the n-th monitored address region. AWADDR_SRVLNC_ENDN (offset 0x104+0x8xaddr_zones (addr_zones = 0~31), total reset 0x0000_0000; PROVEN: Hi3535 data sheet, PDF page 662, section 4.1.7.2).";
        field {
            name = "awaddr_srvlnc_end";
            desc = "End address of address region n. Note: The lower 4 address bits are ignored; the configured value is the actual end address + 1.";
            sw = rw; hw = r;
            reset = 0x0;
        } awaddr_srvlnc_end[31:0];
    } AWADDR_SRVLNC_ENDN_18 @ 0x194;
    reg {
        name = "AWADDR_SRVLNC_ENDN";
        desc = "AWADDR_SRVLNC_ENDN is the register for the end address of the n-th monitored address region. AWADDR_SRVLNC_ENDN (offset 0x104+0x8xaddr_zones (addr_zones = 0~31), total reset 0x0000_0000; PROVEN: Hi3535 data sheet, PDF page 662, section 4.1.7.2).";
        field {
            name = "awaddr_srvlnc_end";
            desc = "End address of address region n. Note: The lower 4 address bits are ignored; the configured value is the actual end address + 1.";
            sw = rw; hw = r;
            reset = 0x0;
        } awaddr_srvlnc_end[31:0];
    } AWADDR_SRVLNC_ENDN_19 @ 0x19c;
    reg {
        name = "AWADDR_SRVLNC_ENDN";
        desc = "AWADDR_SRVLNC_ENDN is the register for the end address of the n-th monitored address region. AWADDR_SRVLNC_ENDN (offset 0x104+0x8xaddr_zones (addr_zones = 0~31), total reset 0x0000_0000; PROVEN: Hi3535 data sheet, PDF page 662, section 4.1.7.2).";
        field {
            name = "awaddr_srvlnc_end";
            desc = "End address of address region n. Note: The lower 4 address bits are ignored; the configured value is the actual end address + 1.";
            sw = rw; hw = r;
            reset = 0x0;
        } awaddr_srvlnc_end[31:0];
    } AWADDR_SRVLNC_ENDN_20 @ 0x1a4;
    reg {
        name = "AWADDR_SRVLNC_ENDN";
        desc = "AWADDR_SRVLNC_ENDN is the register for the end address of the n-th monitored address region. AWADDR_SRVLNC_ENDN (offset 0x104+0x8xaddr_zones (addr_zones = 0~31), total reset 0x0000_0000; PROVEN: Hi3535 data sheet, PDF page 662, section 4.1.7.2).";
        field {
            name = "awaddr_srvlnc_end";
            desc = "End address of address region n. Note: The lower 4 address bits are ignored; the configured value is the actual end address + 1.";
            sw = rw; hw = r;
            reset = 0x0;
        } awaddr_srvlnc_end[31:0];
    } AWADDR_SRVLNC_ENDN_21 @ 0x1ac;
    reg {
        name = "AWADDR_SRVLNC_ENDN";
        desc = "AWADDR_SRVLNC_ENDN is the register for the end address of the n-th monitored address region. AWADDR_SRVLNC_ENDN (offset 0x104+0x8xaddr_zones (addr_zones = 0~31), total reset 0x0000_0000; PROVEN: Hi3535 data sheet, PDF page 662, section 4.1.7.2).";
        field {
            name = "awaddr_srvlnc_end";
            desc = "End address of address region n. Note: The lower 4 address bits are ignored; the configured value is the actual end address + 1.";
            sw = rw; hw = r;
            reset = 0x0;
        } awaddr_srvlnc_end[31:0];
    } AWADDR_SRVLNC_ENDN_22 @ 0x1b4;
    reg {
        name = "AWADDR_SRVLNC_ENDN";
        desc = "AWADDR_SRVLNC_ENDN is the register for the end address of the n-th monitored address region. AWADDR_SRVLNC_ENDN (offset 0x104+0x8xaddr_zones (addr_zones = 0~31), total reset 0x0000_0000; PROVEN: Hi3535 data sheet, PDF page 662, section 4.1.7.2).";
        field {
            name = "awaddr_srvlnc_end";
            desc = "End address of address region n. Note: The lower 4 address bits are ignored; the configured value is the actual end address + 1.";
            sw = rw; hw = r;
            reset = 0x0;
        } awaddr_srvlnc_end[31:0];
    } AWADDR_SRVLNC_ENDN_23 @ 0x1bc;
    reg {
        name = "AWADDR_SRVLNC_ENDN";
        desc = "AWADDR_SRVLNC_ENDN is the register for the end address of the n-th monitored address region. AWADDR_SRVLNC_ENDN (offset 0x104+0x8xaddr_zones (addr_zones = 0~31), total reset 0x0000_0000; PROVEN: Hi3535 data sheet, PDF page 662, section 4.1.7.2).";
        field {
            name = "awaddr_srvlnc_end";
            desc = "End address of address region n. Note: The lower 4 address bits are ignored; the configured value is the actual end address + 1.";
            sw = rw; hw = r;
            reset = 0x0;
        } awaddr_srvlnc_end[31:0];
    } AWADDR_SRVLNC_ENDN_24 @ 0x1c4;
    reg {
        name = "AWADDR_SRVLNC_ENDN";
        desc = "AWADDR_SRVLNC_ENDN is the register for the end address of the n-th monitored address region. AWADDR_SRVLNC_ENDN (offset 0x104+0x8xaddr_zones (addr_zones = 0~31), total reset 0x0000_0000; PROVEN: Hi3535 data sheet, PDF page 662, section 4.1.7.2).";
        field {
            name = "awaddr_srvlnc_end";
            desc = "End address of address region n. Note: The lower 4 address bits are ignored; the configured value is the actual end address + 1.";
            sw = rw; hw = r;
            reset = 0x0;
        } awaddr_srvlnc_end[31:0];
    } AWADDR_SRVLNC_ENDN_25 @ 0x1cc;
    reg {
        name = "AWADDR_SRVLNC_ENDN";
        desc = "AWADDR_SRVLNC_ENDN is the register for the end address of the n-th monitored address region. AWADDR_SRVLNC_ENDN (offset 0x104+0x8xaddr_zones (addr_zones = 0~31), total reset 0x0000_0000; PROVEN: Hi3535 data sheet, PDF page 662, section 4.1.7.2).";
        field {
            name = "awaddr_srvlnc_end";
            desc = "End address of address region n. Note: The lower 4 address bits are ignored; the configured value is the actual end address + 1.";
            sw = rw; hw = r;
            reset = 0x0;
        } awaddr_srvlnc_end[31:0];
    } AWADDR_SRVLNC_ENDN_26 @ 0x1d4;
    reg {
        name = "AWADDR_SRVLNC_ENDN";
        desc = "AWADDR_SRVLNC_ENDN is the register for the end address of the n-th monitored address region. AWADDR_SRVLNC_ENDN (offset 0x104+0x8xaddr_zones (addr_zones = 0~31), total reset 0x0000_0000; PROVEN: Hi3535 data sheet, PDF page 662, section 4.1.7.2).";
        field {
            name = "awaddr_srvlnc_end";
            desc = "End address of address region n. Note: The lower 4 address bits are ignored; the configured value is the actual end address + 1.";
            sw = rw; hw = r;
            reset = 0x0;
        } awaddr_srvlnc_end[31:0];
    } AWADDR_SRVLNC_ENDN_27 @ 0x1dc;
    reg {
        name = "AWADDR_SRVLNC_ENDN";
        desc = "AWADDR_SRVLNC_ENDN is the register for the end address of the n-th monitored address region. AWADDR_SRVLNC_ENDN (offset 0x104+0x8xaddr_zones (addr_zones = 0~31), total reset 0x0000_0000; PROVEN: Hi3535 data sheet, PDF page 662, section 4.1.7.2).";
        field {
            name = "awaddr_srvlnc_end";
            desc = "End address of address region n. Note: The lower 4 address bits are ignored; the configured value is the actual end address + 1.";
            sw = rw; hw = r;
            reset = 0x0;
        } awaddr_srvlnc_end[31:0];
    } AWADDR_SRVLNC_ENDN_28 @ 0x1e4;
    reg {
        name = "AWADDR_SRVLNC_ENDN";
        desc = "AWADDR_SRVLNC_ENDN is the register for the end address of the n-th monitored address region. AWADDR_SRVLNC_ENDN (offset 0x104+0x8xaddr_zones (addr_zones = 0~31), total reset 0x0000_0000; PROVEN: Hi3535 data sheet, PDF page 662, section 4.1.7.2).";
        field {
            name = "awaddr_srvlnc_end";
            desc = "End address of address region n. Note: The lower 4 address bits are ignored; the configured value is the actual end address + 1.";
            sw = rw; hw = r;
            reset = 0x0;
        } awaddr_srvlnc_end[31:0];
    } AWADDR_SRVLNC_ENDN_29 @ 0x1ec;
    reg {
        name = "AWADDR_SRVLNC_ENDN";
        desc = "AWADDR_SRVLNC_ENDN is the register for the end address of the n-th monitored address region. AWADDR_SRVLNC_ENDN (offset 0x104+0x8xaddr_zones (addr_zones = 0~31), total reset 0x0000_0000; PROVEN: Hi3535 data sheet, PDF page 662, section 4.1.7.2).";
        field {
            name = "awaddr_srvlnc_end";
            desc = "End address of address region n. Note: The lower 4 address bits are ignored; the configured value is the actual end address + 1.";
            sw = rw; hw = r;
            reset = 0x0;
        } awaddr_srvlnc_end[31:0];
    } AWADDR_SRVLNC_ENDN_30 @ 0x1f4;
    reg {
        name = "AWADDR_SRVLNC_ENDN";
        desc = "AWADDR_SRVLNC_ENDN is the register for the end address of the n-th monitored address region. AWADDR_SRVLNC_ENDN (offset 0x104+0x8xaddr_zones (addr_zones = 0~31), total reset 0x0000_0000; PROVEN: Hi3535 data sheet, PDF page 662, section 4.1.7.2).";
        field {
            name = "awaddr_srvlnc_end";
            desc = "End address of address region n. Note: The lower 4 address bits are ignored; the configured value is the actual end address + 1.";
            sw = rw; hw = r;
            reset = 0x0;
        } awaddr_srvlnc_end[31:0];
    } AWADDR_SRVLNC_ENDN_31 @ 0x1fc;
    reg {
        name = "AWADDR_SRVLNC_STATUS";
        desc = "AWADDR_SRVLNC_STATUS is the address status register of the 32 monitored address regions. AWADDR_SRVLNC_STATUS (offset 0x200, total reset 0x0000_0000; PROVEN: Hi3535 data sheet, PDF page 663, section 4.1.7.2).";
        field {
            name = "addr_infect_st31";
            desc = "Monitoring status of address region segment 31.
- 0: No write command access.
- 1: Write command access occurred. (data sheet access type RC)";
            sw = r; hw = w; onread = rclr;
            reset = 0x0;
        } addr_infect_st31[31:31];
        field {
            name = "addr_infect_st30";
            desc = "Monitoring status of address region 30.
- 0: No write command access;
- 1: Write command access occurred. (data sheet access type RC)";
            sw = r; hw = w; onread = rclr;
            reset = 0x0;
        } addr_infect_st30[30:30];
        field {
            name = "addr_infect_st29";
            desc = "Monitoring status of address region 29.
- 0: No write command access;
- 1: Write command access occurred. (data sheet access type RC)";
            sw = r; hw = w; onread = rclr;
            reset = 0x0;
        } addr_infect_st29[29:29];
        field {
            name = "addr_infect_st28";
            desc = "Monitoring status of address region 28.
- 0: No write command access;
- 1: Write command access occurred. (data sheet access type RC)";
            sw = r; hw = w; onread = rclr;
            reset = 0x0;
        } addr_infect_st28[28:28];
        field {
            name = "addr_infect_st27";
            desc = "Monitoring status of address region 27.
- 0: No write command access.
- 1: Write command access occurred. (data sheet access type RC)";
            sw = r; hw = w; onread = rclr;
            reset = 0x0;
        } addr_infect_st27[27:27];
        field {
            name = "addr_infect_st26";
            desc = "Monitoring status of address region segment 26.
- 0: No write command access.
- 1: Write command access occurred. (data sheet access type RC)";
            sw = r; hw = w; onread = rclr;
            reset = 0x0;
        } addr_infect_st26[26:26];
        field {
            name = "addr_infect_st25";
            desc = "Monitoring status of address region 25.
- 0: No write command access;
- 1: Write command access occurred. (data sheet access type RC)";
            sw = r; hw = w; onread = rclr;
            reset = 0x0;
        } addr_infect_st25[25:25];
        field {
            name = "addr_infect_st24";
            desc = "Monitoring status of address region 24.
- 0: No write command access;
- 1: Write command access occurred. (data sheet access type RC)";
            sw = r; hw = w; onread = rclr;
            reset = 0x0;
        } addr_infect_st24[24:24];
        field {
            name = "addr_infect_st23";
            desc = "Monitoring status of address region 23.
- 0: No write command access;
- 1: Write command access occurred. (data sheet access type RC)";
            sw = r; hw = w; onread = rclr;
            reset = 0x0;
        } addr_infect_st23[23:23];
        field {
            name = "addr_infect_st22";
            desc = "Monitoring status of address region 22.
- 0: No write command access;
- 1: Write command access occurred. (data sheet access type RC)";
            sw = r; hw = w; onread = rclr;
            reset = 0x0;
        } addr_infect_st22[22:22];
        field {
            name = "addr_infect_st21";
            desc = "Monitoring status of address region 21.
- 0: No write command access.
- 1: Write command access occurred. (data sheet access type RC)";
            sw = r; hw = w; onread = rclr;
            reset = 0x0;
        } addr_infect_st21[21:21];
        field {
            name = "addr_infect_st20";
            desc = "Monitoring status of address region segment 20.
- 0: No write command access.
- 1: Write command access occurred. (data sheet access type RC)";
            sw = r; hw = w; onread = rclr;
            reset = 0x0;
        } addr_infect_st20[20:20];
        field {
            name = "addr_infect_st19";
            desc = "Monitoring status of address region 19.
- 0: No write command access;
- 1: Write command access occurred. (data sheet access type RC)";
            sw = r; hw = w; onread = rclr;
            reset = 0x0;
        } addr_infect_st19[19:19];
        field {
            name = "addr_infect_st18";
            desc = "Monitoring status of address region 18.
- 0: No write command access;
- 1: Write command access occurred. (data sheet access type RC)";
            sw = r; hw = w; onread = rclr;
            reset = 0x0;
        } addr_infect_st18[18:18];
        field {
            name = "addr_infect_st17";
            desc = "Monitoring status of address region 17.
- 0: No write command access;
- 1: Write command access occurred. (data sheet access type RC)";
            sw = r; hw = w; onread = rclr;
            reset = 0x0;
        } addr_infect_st17[17:17];
        field {
            name = "addr_infect_st16";
            desc = "Monitoring status of address region 16.
- 0: No write command access.
- 1: Write command access occurred. (data sheet access type RC)";
            sw = r; hw = w; onread = rclr;
            reset = 0x0;
        } addr_infect_st16[16:16];
        field {
            name = "addr_infect_st15";
            desc = "Monitoring status of address region 15.
- 0: No write command access;
- 1: Write command access occurred. (data sheet access type RC)";
            sw = r; hw = w; onread = rclr;
            reset = 0x0;
        } addr_infect_st15[15:15];
        field {
            name = "addr_infect_st14";
            desc = "Monitoring status of address region 14.
- 0: No write command access;
- 1: Write command access occurred. (data sheet access type RC)";
            sw = r; hw = w; onread = rclr;
            reset = 0x0;
        } addr_infect_st14[14:14];
        field {
            name = "addr_infect_st13";
            desc = "Monitoring status of address region 12.
- 0: No write command access;
- 1: Write command access occurred. (data sheet access type RC)";
            sw = r; hw = w; onread = rclr;
            reset = 0x0;
        } addr_infect_st13[13:13];
        field {
            name = "addr_infect_st12";
            desc = "Monitoring status of address region 12.
- 0: No write command access;
- 1: Write command access occurred. (data sheet access type RC)";
            sw = r; hw = w; onread = rclr;
            reset = 0x0;
        } addr_infect_st12[12:12];
        field {
            name = "addr_infect_st11";
            desc = "Monitoring status of address region 11.
- 0: No write command access;
- 1: Write command access occurred. (data sheet access type RC)";
            sw = r; hw = w; onread = rclr;
            reset = 0x0;
        } addr_infect_st11[11:11];
        field {
            name = "addr_infect_st10";
            desc = "Monitoring status of address region 10.
- 0: No write command access;
- 1: Write command access occurred. (data sheet access type RC)";
            sw = r; hw = w; onread = rclr;
            reset = 0x0;
        } addr_infect_st10[10:10];
        field {
            name = "addr_infect_st9";
            desc = "Monitoring status of address region segment 9.
- 0: No write command access.
- 1: Write command access occurred. (data sheet access type RC)";
            sw = r; hw = w; onread = rclr;
            reset = 0x0;
        } addr_infect_st9[9:9];
        field {
            name = "addr_infect_st8";
            desc = "Monitoring status of address region 8.
- 0: No write command access;
- 1: Write command access occurred. (data sheet access type RC)";
            sw = r; hw = w; onread = rclr;
            reset = 0x0;
        } addr_infect_st8[8:8];
        field {
            name = "addr_infect_st7";
            desc = "Monitoring status of address region 7.
- 0: No write command access;
- 1: Write command access occurred. (data sheet access type RC)";
            sw = r; hw = w; onread = rclr;
            reset = 0x0;
        } addr_infect_st7[7:7];
        field {
            name = "addr_infect_st6";
            desc = "Monitoring status of address region 6.
- 0: No write command access;
- 1: Write command access occurred. (data sheet access type RC)";
            sw = r; hw = w; onread = rclr;
            reset = 0x0;
        } addr_infect_st6[6:6];
        field {
            name = "addr_infect_st5";
            desc = "Monitoring status of address region 5.
- 0: No write command access;
- 1: Write command access occurred. (data sheet access type RC)";
            sw = r; hw = w; onread = rclr;
            reset = 0x0;
        } addr_infect_st5[5:5];
        field {
            name = "addr_infect_st4";
            desc = "Monitoring status of address region 4.
- 0: No write command access.
- 1: Write command access occurred. (data sheet access type RC)";
            sw = r; hw = w; onread = rclr;
            reset = 0x0;
        } addr_infect_st4[4:4];
        field {
            name = "addr_infect_st3";
            desc = "Monitoring status of address region 3.
- 0: No write command access;
- 1: Write command access occurred. (data sheet access type RC)";
            sw = r; hw = w; onread = rclr;
            reset = 0x0;
        } addr_infect_st3[3:3];
        field {
            name = "addr_infect_st2";
            desc = "Monitoring status of address region 2.
- 0: No write command access;
- 1: Write command access occurred. (data sheet access type RC)";
            sw = r; hw = w; onread = rclr;
            reset = 0x0;
        } addr_infect_st2[2:2];
        field {
            name = "addr_infect_st1";
            desc = "Monitoring status of address region 1.
- 0: No write command access;
- 1: Write command access occurred. (data sheet access type RC)";
            sw = r; hw = w; onread = rclr;
            reset = 0x0;
        } addr_infect_st1[1:1];
        field {
            name = "addr_infect_st0";
            desc = "Monitoring status of address region 0.
- 0: No write command access;
- 1: Write command access occurred. (data sheet access type RC)";
            sw = r; hw = w; onread = rclr;
            reset = 0x0;
        } addr_infect_st0[0:0];
    } AWADDR_SRVLNC_STATUS @ 0x200;
};

`endif
