`ifndef EHI3535_DDRC_DMC_RDL
`define EHI3535_DDRC_DMC_RDL
regfile eHI3535_DDRC_DMC {
    name = "DDRC DMC module";
    desc = "DDRC DMC module. 56 registers extracted programmatically from the Hi3535 H.264 codec processor (Hi3535 user guide) data sheet (Issue 00B08, 2014-02-25); chapter 4.1.6, table 4-3. Field names, bit ranges, access types and reset values are taken from the register tables; reset values are the data sheet total reset values split onto the fields (per-field values where the table has them). Label: PROVEN. Hardware not verified here (no board).";
    reg {
        name = "DDRC_CTRL_SREF";
        desc = "DDRC_CTRL_SREF is the DDRC self-refresh control register. DDRC_CTRL_SREF (offset 0x000, total reset 0x0000_0001; PROVEN: Hi3535 data sheet, PDF page 618, section 4.1.6.2).";
        field {
            name = "reserved";
            desc = "Reserved.";
            sw = r; hw = w;
            reset = 0x0;
        } reserved_31_2[31:2];
        field {
            name = "sref_done";
            desc = "DDRPHY self-refresh operation complete.
- 1: A transition of this configuration from 0 to 1 indicates that the DDRPHY has completed all operations required after exiting self-refresh, and the DMC can accept new requests.";
            sw = rw; hw = r;
            reset = 0x0;
        } sref_done[1:1];
        field {
            name = "sref_req";
            desc = "SDRAM self-refresh request.
- 0: Exit the self-refresh state.
- 1: Enter the self-refresh state.";
            sw = rw; hw = r;
            reset = 0x1;
        } sref_req[0:0];
    } DDRC_CTRL_SREF @ 0x0;
    reg {
        name = "DDRC_CTRL_INIT";
        desc = "DDRC_CTRL_INIT is the DDRC initialization control register. DDRC_CTRL_INIT (offset 0x004, total reset 0x0000_0000; PROVEN: Hi3535 data sheet, PDF page 618, section 4.1.6.2).";
        field {
            name = "reserved";
            desc = "Reserved.";
            sw = r; hw = w;
            reset = 0x0;
        } reserved_31_1[31:1];
        field {
            name = "init_req";
            desc = "Initialization start.
- 0: Initialization completed or in normal operation;
- 1: Start the SDRAM initialization operation.";
            sw = rw; hw = r;
            reset = 0x0;
        } init_req[0:0];
    } DDRC_CTRL_INIT @ 0x4;
    reg {
        name = "DDRC_CTRL_DDRRST";
        desc = "DDRC_CTRL_DDRRST is the DDR3 reset control register. DDRC_CTRL_DDRRST (offset 0x008, total reset 0x0000_0001; PROVEN: Hi3535 data sheet, PDF page 619, section 4.1.6.2).";
        field {
            name = "reserved";
            desc = "Reserved.";
            sw = r; hw = w;
            reset = 0x0;
        } reserved_31_1[31:1];
        field {
            name = "ddr3_rst_n";
            desc = "DDR3 SDRAM reset.
- 0: Reset asserted.
- 1: Reset deasserted. Note: Valid only for DDR3 SDRAM. The default configuration is 1.";
            sw = rw; hw = r;
            reset = 0x1;
        } ddr3_rst_n[0:0];
    } DDRC_CTRL_DDRRST @ 0x8;
    reg {
        name = "DDRC_CTRL_SFC";
        desc = "DDRC_CTRL_SFC is the register with which software starts a DDR command in the DDRC. DDRC_CTRL_SFC (offset 0x00C, total reset 0x0000_0000; PROVEN: Hi3535 data sheet, PDF page 619, section 4.1.6.2).";
        field {
            name = "reserved";
            desc = "Reserved.";
            sw = r; hw = w;
            reset = 0x0;
        } reserved_31_1[31:1];
        field {
            name = "cmd_req";
            desc = "Controller configuration command execution request.
- 0: Do not execute a command, or this parameter is cleared automatically after command execution completes; a subsequent write of 1 then takes effect.
- 1: Request command execution.";
            sw = rw; hw = r;
            reset = 0x0;
        } cmd_req[0:0];
    } DDRC_CTRL_SFC @ 0xc;
    reg {
        name = "DDRC_CTRL_PERF";
        desc = "DDRC_CTRL_PERF is the DDRC performance statistics enable register. DDRC_CTRL_PERF (offset 0x010, total reset 0x0000_0000; PROVEN: Hi3535 data sheet, PDF page 620, section 4.1.6.2).";
        field {
            name = "reserved";
            desc = "Reserved.";
            sw = r; hw = w;
            reset = 0x0;
        } reserved_31_1[31:1];
        field {
            name = "perf_en";
            desc = "Performance statistics enable.
- 0: Disable;
- 1: Enable. Note: When perf_mode=0, enabling this bit means the performance statistics registers start counting cyclically. When perf_mode=1, this bit is cleared automatically after one statistics run completes.";
            sw = rw; hw = r;
            reset = 0x0;
        } perf_en[0:0];
    } DDRC_CTRL_PERF @ 0x10;
    reg {
        name = "DDRC_CFG_SREF";
        desc = "DDRC_CFG_SREF is the DDR self-refresh configuration register. DDRC_CFG_SREF (offset 0x020, total reset 0x0000_0000; PROVEN: Hi3535 data sheet, PDF page 621, section 4.1.6.2).";
        field {
            name = "reserved";
            desc = "Reserved.";
            sw = r; hw = w;
            reset = 0x0;
        } reserved_31_16[31:16];
        field {
            name = "sref_arefnum";
            desc = "Number of auto-refresh operations issued by the DDRn SDRAM after exiting self-refresh in the DFS flow.
- 0x0: No auto-refresh operation is sent. 0x1 to 0xF: n times.";
            sw = rw; hw = r;
            reset = 0x0;
        } sref_arefnum[15:12];
        field {
            name = "reserved";
            desc = "Reserved.";
            sw = r; hw = w;
            reset = 0x0;
        } reserved_11_9[11:9];
        field {
            name = "clk_switch";
            desc = "DDRC low-power clock switching control. Whether AXI interface commands are back-pressured when the DDRC enters the low-power state (DDR Self Refresh).
- 0: Back-pressure interface commands and complete the commands already in progress;
- 1: Back-pressure interface commands, and continue executing the original commands after the clock switch completes.";
            sw = rw; hw = r;
            reset = 0x0;
        } clk_switch[8:8];
        field {
            name = "reserved";
            desc = "Reserved.";
            sw = r; hw = w;
            reset = 0x0;
        } reserved_7_5[7:5];
        field {
            name = "sref_odis";
            desc = "Self-refresh mode, output shutdown configuration for DDR command and data IOs.
- 0: Do not shut down the pin outputs;
- 1: Shut down the pin outputs. Note: This is a static configuration. It is recommended to set it to 1 after the DDR is put into self_refresh, to shut down the outputs of the DDR command and data IOs. Set it to 0 before the DDR exits self_refresh, to turn on the outputs of the DDR command and data IOs.";
            sw = rw; hw = r;
            reset = 0x0;
        } sref_odis[4:4];
        field {
            name = "reserved";
            desc = "Reserved.";
            sw = r; hw = w;
            reset = 0x0;
        } reserved_3_1[3:1];
        field {
            name = "sref_cc";
            desc = "Self-refresh mode, SDRAM clock control.
- 0: Do not turn off the SDRAM clock.
- 1: Turn off the SDRAM clock.";
            sw = rw; hw = r;
            reset = 0x0;
        } sref_cc[0:0];
    } DDRC_CFG_SREF @ 0x20;
    reg {
        name = "DDRC_CFG_PD";
        desc = "DDRC_CFG_PD is the DDR device low-power PowerDown state configuration register. DDRC_CFG_PD (offset 0x028, total reset 0x0000_0000; PROVEN: Hi3535 data sheet, PDF page 622, section 4.1.6.2).";
        field {
            name = "reserved";
            desc = "Reserved.";
            sw = r; hw = w;
            reset = 0x0;
        } reserved_31_24[31:24];
        field {
            name = "t_clk_cke";
            desc = "CLK to CKE relationship setting. 0x0 to 0x7: Delay of the PHY clock turn-off relative to CKE; depends on the specific DDRPHY.";
            sw = rw; hw = r;
            reset = 0x0;
        } t_clk_cke[23:20];
        field {
            name = "reserved";
            desc = "Reserved.";
            sw = rw; hw = r;
            reset = 0x0;
        } reserved_19_17[19:17];
        field {
            name = "pd_ac";
            desc = "Low-power mode (PowerDown): dynamic shut-off control of SDRAM address/command signals.
- 0: Do not shut off the pin outputs;
- 1: Shut off the pin outputs.
Note: valid when pd_en is enabled; the controlled pins do not include CKE, ODT, CSN, and RESET_N.";
            sw = rw; hw = r;
            reset = 0x0;
        } pd_ac[16:16];
        field {
            name = "reserved";
            desc = "Reserved.";
            sw = r; hw = w;
            reset = 0x0;
        } reserved_15_13[15:13];
        field {
            name = "pd_cc";
            desc = "Low-power mode (PowerDown), SDRAM clock control.
- 0: Do not stop the SDRAM clock;
- 1: Stop the SDRAM clock.
Note: This parameter is valid only when the external DDR is LPDDR/LPDDR2 SDRAM.";
            sw = rw; hw = r;
            reset = 0x0;
        } pd_cc[12:12];
        field {
            name = "pd_prd";
            desc = "SDRAM low-power (Power Down) period configuration. If the DDRC receives no command for pd_prd consecutive cycles, it puts the SDRAM into the low-power state; when a new command arrives, it takes the SDRAM out of the low-power state.
- 0x00: Do not enter the power down state; 0x01 to 0xFF: n clock cycles. Note: This parameter is valid only when pd_en is 1.";
            sw = rw; hw = r;
            reset = 0x0;
        } pd_prd[11:4];
        field {
            name = "reserved";
            desc = "Reserved.";
            sw = r; hw = w;
            reset = 0x0;
        } reserved_3_1[3:1];
        field {
            name = "pd_en";
            desc = "SDRAM automatic low-power enable.
- 0: Disable;
- 1: Enable.";
            sw = rw; hw = r;
            reset = 0x0;
        } pd_en[0:0];
    } DDRC_CFG_PD @ 0x28;
    reg {
        name = "DDRC_CFG_AREF";
        desc = "DDRC_CFG_AREF is the DDRC auto-refresh mode configuration register. DDRC_CFG_AREF (offset 0x02C, total reset 0x0000_0000; PROVEN: Hi3535 data sheet, PDF page 623, section 4.1.6.2).";
        field {
            name = "reserved";
            desc = "Reserved.";
            sw = r; hw = w;
            reset = 0x0;
        } reserved_31_16[31:16];
        field {
            name = "aref_alarm_num";
            desc = "Configures forcing a self refresh command after several auto refresh commands could not be issued. 0x0 to 0xFF: n+1 auto refreshes. Note: when n=255, the counter is 8 bits wide, so the carry is lost in the high bit, which is equivalent to 1.";
            sw = rw; hw = r;
            reset = 0x0;
        } aref_alarm_num[15:8];
        field {
            name = "reserved";
            desc = "Reserved.";
            sw = r; hw = w;
            reset = 0x0;
        } reserved_7_5[7:5];
        field {
            name = "aref_alarm_en";
            desc = "Alarm enable for a missed auto refresh when the AREF function is started.
- 0: Disable;
- 1: Enable.";
            sw = rw; hw = r;
            reset = 0x0;
        } aref_alarm_en[4:4];
        field {
            name = "reseverd";
            desc = "Reserved.";
            sw = r; hw = w;
            reset = 0x0;
        } reseverd[3:2];
        field {
            name = "aref_mode";
            desc = "Auto-refresh mode select.
- 00: Perform 1 auto-refresh operation every 1 tREFI period.
- 01: Perform 3 auto-refresh operations every 3 tRFI periods.
- 10: Perform 4 auto-refresh operations every 5 tREFI periods.
- 11: Perform 8 auto-refresh operations every 9 tREFI periods.";
            sw = rw; hw = r;
            reset = 0x0;
        } aref_mode[1:0];
    } DDRC_CFG_AREF @ 0x2c;
    reg {
        name = "DDRC_CFG_WORKMODE";
        desc = "DDRC_CFG_WORKMODE is the DDRC work mode configuration register. DDRC_CFG_WORKMODE (offset 0x040, total reset 0x0000_0000; PROVEN: Hi3535 data sheet, PDF page 624, section 4.1.6.2).";
        field {
            name = "reserved";
            desc = "Reserved.";
            sw = r; hw = w;
            reset = 0x0;
        } reserved_31_29[31:29];
        field {
            name = "wr_rcv_mode";
            desc = "DDRC AXI port write command acceptance mode select.
- 0: Write commands are accepted directly;
- 1: A write command is accepted only after its corresponding write data has arrived.";
            sw = rw; hw = r;
            reset = 0x0;
        } wr_rcv_mode[28:28];
        field {
            name = "reserved";
            desc = "Reserved.";
            sw = r; hw = w;
            reset = 0x0;
        } reserved_27_25[27:25];
        field {
            name = "exclu_en";
            desc = "Exclusive command enable.
- 0: Disable.
- 1: Enable.";
            sw = rw; hw = r;
            reset = 0x0;
        } exclu_en[24:24];
        field {
            name = "reserved";
            desc = "Reserved.";
            sw = r; hw = w;
            reset = 0x0;
        } reserved_23_21[23:21];
        field {
            name = "reserved";
            desc = "Reserved.";
            sw = r; hw = w;
            reset = 0x0;
        } reserved_20_20[20:20];
        field {
            name = "reserved";
            desc = "Reserved.";
            sw = r; hw = w;
            reset = 0x0;
        } reserved_19_17[19:17];
        field {
            name = "reserved";
            desc = "Reserved.";
            sw = r; hw = w;
            reset = 0x0;
        } reserved_16_16[16:16];
        field {
            name = "reserved";
            desc = "Reserved.";
            sw = r; hw = w;
            reset = 0x0;
        } reserved_15_14[15:14];
        field {
            name = "reserved";
            desc = "Reserved.";
            sw = r; hw = w;
            reset = 0x0;
        } reserved_13_13[13:13];
        field {
            name = "read_mode";
            desc = "Controller read mode select.
- 0: Follow-through read mode.
- 1: Delayed read mode. In follow-through read mode, the controller samples data according to the data valid signal sent by the PHY. In delayed read mode, the controller waits internally with a delay to complete sampling of the data sent by the PHY. Note: This value must be configured as 0 when DDRC_DTRCTRL[train_mode] is configured as 0.";
            sw = rw; hw = r;
            reset = 0x0;
        } read_mode[12:12];
        field {
            name = "reserved";
            desc = "Reserved.";
            sw = r; hw = w;
            reset = 0x0;
        } reserved_11_9[11:9];
        field {
            name = "wrap_en";
            desc = "WRAP command optimization enable.
- 0: Disable;
- 1: Enable.";
            sw = rw; hw = r;
            reset = 0x0;
        } wrap_en[8:8];
        field {
            name = "reserved";
            desc = "Reserved.";
            sw = r; hw = w;
            reset = 0x0;
        } reserved_7_5[7:5];
        field {
            name = "apre_en";
            desc = "Auto Precharge function enable.
- 0: Disable;
- 1: Enable.";
            sw = rw; hw = r;
            reset = 0x0;
        } apre_en[4:4];
        field {
            name = "func_clkon";
            desc = "Functional module clock switch.
- 0: The clock is controlled automatically internally;
- 1: Force the clock on.";
            sw = rw; hw = r;
            reset = 0x0;
        } func_clkon[3:3];
        field {
            name = "data_clkon";
            desc = "Data path clock switch.
- 0: The clock is controlled automatically inside.
- 1: Force the clock on.";
            sw = rw; hw = r;
            reset = 0x0;
        } data_clkon[2:2];
        field {
            name = "cmd_clkon";
            desc = "Command channel clock switch.
- 0: The clock is controlled automatically internally.
- 1: The clock is forced on.";
            sw = rw; hw = r;
            reset = 0x0;
        } cmd_clkon[1:1];
        field {
            name = "clk_ratio";
            desc = "Controller operating mode.
- 0: Reserved.
- 1: The DDRC-to-PHY frequency ratio is 1:2.";
            sw = rw; hw = r;
            reset = 0x0;
        } clk_ratio[0:0];
    } DDRC_CFG_WORKMODE @ 0x40;
    reg {
        name = "DDRC_CFG_DDRMODE";
        desc = "DDRC_CFG_DDRMODE is the DDR operating mode configuration register. DDRC_CFG_DDRMODE (offset 0x050, total reset 0x0000_0000; PROVEN: Hi3535 data sheet, PDF page 625, section 4.1.6.2).";
        field {
            name = "reserved";
            desc = "Reserved.";
            sw = r; hw = w;
            reset = 0x0;
        } reserved_31_22[31:22];
        field {
            name = "rank";
            desc = "Controller rank configuration.
- 00: 1 rank;
Others: Reserved.";
            sw = rw; hw = r;
            reset = 0x0;
        } rank[21:20];
        field {
            name = "reserved";
            desc = "Reserved.";
            sw = r; hw = w;
            reset = 0x0;
        } reserved_19_18[19:18];
        field {
            name = "odt_on";
            desc = "The ODT signal output to the SDRAM is a fixed value.
- 0: Controlled automatically by the DDRC;
- 1: Fixed output of the wodt configuration of rank0.";
            sw = rw; hw = r;
            reset = 0x0;
        } odt_on[17:17];
        field {
            name = "zqc_en";
            desc = "DDR3 SDRAM ZQ enable.
- 0: Disable;
- 1: Enable. Note: Only valid for DDR3/LPDDR2 SDRAM; the default is 0.";
            sw = rw; hw = r;
            reset = 0x0;
        } zqc_en[16:16];
        field {
            name = "reserved";
            desc = "Reserved.";
            sw = r; hw = w;
            reset = 0x0;
        } reserved_15_13[15:13];
        field {
            name = "bc_en";
            desc = "DDR3 Burst Chop mode enable.
- 0: Disable;
- 1: Enable.
Note: valid for DDR3 only.";
            sw = rw; hw = r;
            reset = 0x0;
        } bc_en[12:12];
        field {
            name = "reserved";
            desc = "Reserved.";
            sw = r; hw = w;
            reset = 0x0;
        } reserved_11_9[11:9];
        field {
            name = "brstlen";
            desc = "Controller burst length configuration.
- 0: BL4.
- 1: BL8.

DDR2 can be configured as Burst4 or Burst8. DDR3 can be configured only as Burst8 mode.";
            sw = rw; hw = r;
            reset = 0x0;
        } brstlen[8:8];
        field {
            name = "reserved";
            desc = "Reserved.";
            sw = r; hw = w;
            reset = 0x0;
        } reserved_7_6[7:6];
        field {
            name = "mem_width";
            desc = "Memory data bus width.
- 00: 8 bits.
- 01: 16 bits.
- 10: 32 bits.
- 11: 64 bits. Note: When the DDR3 SDRAM data bus width is configured as 32-bit mode and the capacity ratio of the high 16-bit and low 16-bit DDR3 SDRAM is 1:2, it must be configured as 0b10.";
            sw = rw; hw = r;
            reset = 0x0;
        } mem_width[5:4];
        field {
            name = "reserved";
            desc = "Reserved.";
            sw = r; hw = w;
            reset = 0x0;
        } reserved_3_3[3:3];
        field {
            name = "dram_type";
            desc = "External memory type.
- 110: DDR3;
Other values: reserved.";
            sw = rw; hw = r;
            reset = 0x0;
        } dram_type[2:0];
    } DDRC_CFG_DDRMODE @ 0x50;
    reg {
        name = "DDRC_CFG_RNKVOL";
        desc = "DDRC_CFG_RNKVOL is the register that configures the DDR capacity controlled by the DDRC. DDRC_CFG_RNKVOL (offset 0x060, total reset 0x0000_0022; PROVEN: Hi3535 data sheet, PDF page 627, section 4.1.6.2).";
        field {
            name = "reserved";
            desc = "Reserved.";
            sw = r; hw = w;
            reset = 0x0;
        } reserved_31_14[31:14];
        field {
            name = "mem_map";
            desc = "SDRAM address decoding mode.
- 00: {Rank,Row,Ba,Col,DW}= AXI_Address;
Other values: reserved.";
            sw = rw; hw = r;
            reset = 0x0;
        } mem_map[13:12];
        field {
            name = "reserved";
            desc = "Reserved.";
            sw = r; hw = w;
            reset = 0x0;
        } reserved_11_9[11:9];
        field {
            name = "mem_bank";
            desc = "Number of banks of a single SDRAM device.
- 0: 4 banks.
- 1: 8 banks.";
            sw = rw; hw = r;
            reset = 0x0;
        } mem_bank[8:8];
        field {
            name = "reserved";
            desc = "Reserved.";
            sw = r; hw = w;
            reset = 0x0;
        } reserved_7_7[7:7];
        field {
            name = "mem_row";
            desc = "Row address width configuration of a single SDRAM device.
- 000: 11 bit.
- 001: 12 bit.
- 010: 13 bit.
- 011: 14 bit.
- 100: 15 bit.
- 101: 16 bit. Others: Reserved.";
            sw = rw; hw = r;
            reset = 0x2;
        } mem_row[6:4];
        field {
            name = "reserved";
            desc = "Reserved.";
            sw = r; hw = w;
            reset = 0x0;
        } reserved_3_3[3:3];
        field {
            name = "mem_col";
            desc = "Column address width configuration of a single SDRAM chip.
- 000: 8 bit;
- 001: 9 bit;
- 010: 10 bit;
- 011: 11 bit;
- 100: 12 bit. Others: Reserved. Note: The DDRC does not support devices with a col address smaller than 8 (that is, LPDDR2 devices with a 32-bit width and a total capacity of 64Mbit).";
            sw = rw; hw = r;
            reset = 0x2;
        } mem_col[2:0];
    } DDRC_CFG_RNKVOL @ 0x60;
    reg {
        name = "DDRC_CFG_TIMING0";
        desc = "DDRC_CFG_TIMING0 is DDRC timing parameter register 0. All timing parameters in this register come from the DDR device data sheet. If [clk_ration] of DDRC_CFG_WORKMODE is 1, convert the value specified in the data sheet to a number of DDR clock cycles (no conversion is needed if the data sheet already gives cycles), then divide by 2 (add 1 if there is a remainder). If [clk_ration] is 0, convert the specified value to a number of DDR clock cycles and configure that number directly. DDRC_CFG_TIMING0 (offset 0x080, total reset 0xFFFF_FF3F; PROVEN: Hi3535 data sheet, PDF page 628, section 4.1.6.2).";
        field {
            name = "tmrd";
            desc = "Wait cycles of the mode register load (LMR) command (configure the maximum of tMOD and tMRD for DDR2 and LPDDR2, and tMRD for DDR3). 0x0 to 0x1: 1 clock cycle; 0x2 to 0xF: n clock cycles.";
            sw = rw; hw = r;
            reset = 0xf;
        } tmrd[31:28];
        field {
            name = "trrd";
            desc = "Wait cycles from activating BANK A to activating BANK B (ACT bank a to ACT bank b). 0x0 to 0x1: 1 clock cycle. 0x2 to 0xF: n clock cycles.";
            sw = rw; hw = r;
            reset = 0xf;
        } trrd[27:24];
        field {
            name = "trp";
            desc = "Wait cycles of the close (PRE period) command.
0x0 to 0x1: 1 clock cycle;
0x2 to 0xF: n clock cycles.";
            sw = rw; hw = r;
            reset = 0x1f;
        } trp[23:19];
        field {
            name = "trcd";
            desc = "Wait cycles from ACT to READ or WRITE command on the same BANK (ACT to READ or WRITE). 0x0 to 0x3: 3 clock cycles; 0x4 to 0xF: n clock cycles.";
            sw = rw; hw = r;
            reset = 0x1f;
        } trcd[18:14];
        field {
            name = "trc";
            desc = "Wait cycles from an activate command to the next activate command of the same BANK (active a bank to active a bank). 0x00 to 0x01: 1 clock cycle. 0x02 to 0x3F: n clock cycles.";
            sw = rw; hw = r;
            reset = 0x3f;
        } trc[13:8];
        field {
            name = "reserved";
            desc = "Reserved.";
            sw = r; hw = w;
            reset = 0x0;
        } reserved_7_6[7:6];
        field {
            name = "tras";
            desc = "Wait cycles from an activate command to a precharge command (ACT to PRE) of the same BANK. 0x00 to 0x01: 1 clock cycle. 0x02 to 0x0F: n clock cycles.";
            sw = rw; hw = r;
            reset = 0x3f;
        } tras[5:0];
    } DDRC_CFG_TIMING0 @ 0x80;
    reg {
        name = "DDRC_CFG_TIMING1";
        desc = "DDRC_CFG_TIMING1 is DDRC timing parameter register 1. DDRC_CFG_TIMING1 (offset 0x084, total reset 0xFF24_51FF; PROVEN: Hi3535 data sheet, PDF page 630, section 4.1.6.2).";
        field {
            name = "tsre";
            desc = "Wait cycles from exiting Self-Refresh to a read command.
- 0x0: Reserved;
0x01 to 0xFF: n x 4 clock cycles.

For DDR3 SDRAM, this value configures the maximum of tXSDLL and tXS. This timing parameter comes from the DDR device data sheet. If [clk_ration]=1 in DDRC_CFG_WORKMODE, convert the value specified in the data sheet to a number of DDR clock cycles (no conversion is needed if the data sheet already gives cycles), then divide by 2 (add 1 if there is a remainder); if [clk_ration]=0, convert the data sheet value to a number of DDR clock cycles and configure that value directly.";
            sw = rw; hw = r;
            reset = 0xff;
        } tsre[31:24];
        field {
            name = "trtw";
            desc = "Delay from the last read data to the first write data. 0x0 to 0x1: 1 clock cycle; 0x2 to 0xF: n+1 clock cycles. Note: in DDR2/DDR3 mode, the trtw parameter mainly accounts for the board, package, and IO delays; in LPDDR/LPDDR2/LPDDR3 mode, tdqsckmax must be added to the board, package, and IO delays.";
            sw = rw; hw = r;
            reset = 0x2;
        } trtw[23:20];
        field {
            name = "twl";
            desc = "Wait cycles from write command to write data. 0x0 to 0x1: 1 clock cycle. 0x2 to 0xF: n clock cycles. For example, 0x3 corresponds to 3 clock cycles. This timing parameter is obtained from the DDR device data sheet; configure the number of cycles specified in the data sheet directly.";
            sw = rw; hw = r;
            reset = 0x4;
        } twl[19:16];
        field {
            name = "tcl";
            desc = "Delay from the DDR read command to the read data (CAS Latency).
0x0 to 0x1: 1 clock cycle;
0x2 to 0xF: n clock cycles.
This timing parameter comes from the DDR device data sheet; configure the number of cycles specified there directly.";
            sw = rw; hw = r;
            reset = 0x5;
        } tcl[15:12];
        field {
            name = "reserved";
            desc = "Reserved.";
            sw = r; hw = w;
            reset = 0x0;
        } reserved_11_9[11:9];
        field {
            name = "trfc";
            desc = "Wait cycles of the auto refresh command period and of auto refresh to activate (AREF period or AREF to ACT). This register is configured with the larger of trfc and tzqcs.
- 0x00: Reserved;
0x01 to 0x1FF: n clock cycles.
This timing parameter comes from the DDR device data sheet. If [clk_ration]=1 in DDRC_CFG_WORKMODE, convert the data sheet value to DDR clock cycles (if the data sheet already gives cycles, no conversion is needed), then divide by 2 (add 1 if there is a remainder). If [clk_ration]=0, convert the data sheet value to DDR clock cycles and configure that value directly.";
            sw = rw; hw = r;
            reset = 0x1ff;
        } trfc[8:0];
    } DDRC_CFG_TIMING1 @ 0x84;
    reg {
        name = "DDRC_CFG_TIMING2";
        desc = "DDRC_CFG_TIMING2 is DDRC timing parameter register 2. DDRC_CFG_TIMING2 (offset 0x88, total reset 0xF303_F000; PROVEN: Hi3535 data sheet, PDF page 631, section 4.1.6.2).";
        field {
            name = "tcke";
            desc = "Minimum time to remain in the low-power state.
- 0x0: Reserved. 0x1 to 0xF: n clock cycles. This value must be set to the largest of tCKESR, tCKSRE, tCKSRX, and tCKE. This timing parameter is obtained from the DDR device data sheet. If [clk_ration]=1 in DDRC_CFG_WORKMODE, convert the data sheet time value to a number of DDR clock cycles (no conversion is needed if the data sheet already gives cycles), then divide by 2 (add 1 if there is a remainder). If [clk_ration]=0, convert the data sheet value to DDR clock cycles and configure that value directly.";
            sw = rw; hw = r;
            reset = 0xf;
        } tcke[31:28];
        field {
            name = "twtr";
            desc = "Wait cycles from the last write data of a write operation to a read command (write to read).
0x0 to 0x1: 1 clock cycle;
0x2 to 0xF: n clock cycles.
For example, 0x3 corresponds to 3 clock cycles. This timing parameter comes from the DDR device data sheet. If [clk_ration]=1 in DDRC_CFG_WORKMODE, convert the value specified in the data sheet to a number of DDR clock cycles (no conversion is needed if the data sheet already gives cycles), then divide by 2 (add 1 if there is a remainder); if [clk_ration]=0, convert the data sheet value to a number of DDR clock cycles and configure that value directly.";
            sw = rw; hw = r;
            reset = 0x3;
        } twtr[27:24];
        field {
            name = "reserved";
            desc = "Reserved.";
            sw = r; hw = w;
            reset = 0x0;
        } reserved_23_18[23:18];
        field {
            name = "tfaw";
            desc = "Four consecutive activate commands period. 0x00 to 0x3F: n clock cycles; for example, 0x14 corresponds to 20 clock cycles. This timing parameter is taken from the DDR device data sheet. If [clk_ration]=1 in DDRC_CFG_WORKMODE, convert the time value specified in the data sheet to a number of DDR clock cycles (no conversion is needed if the data sheet already gives a cycle count), then divide by 2 (add 1 if there is a remainder); if [clk_ration]=0, convert the value specified in the data sheet to DDR clock cycles and configure it directly.";
            sw = rw; hw = r;
            reset = 0x3f;
        } tfaw[17:12];
        field {
            name = "reserved";
            desc = "Reserved.";
            sw = r; hw = w;
            reset = 0x0;
        } reserved_11_11[11:11];
        field {
            name = "taref";
            desc = "Auto refresh period.
- 0x000: Auto refresh disabled; 0x001 to 0x7FF: The SDRAM refresh period is 16 x n clock cycles. For example, 0x008 corresponds to 128 clock cycles (16 x 8). Obtain tREFI from the DDR device data sheet. If DDRC_CFG_WORKMODE[clk_ration]=1, taref is configured as tREFI /16/(tclk*2) (add 1 if there is a remainder); if [clk_ration]=0, it is configured as tREFI /16/tclk. Tclk is the DDRn SDRAM operating period, in ns. When DDRC_CONFIG1[aref_mode]=1, this register must be configured for an interval of 8 x tREFI.";
            sw = rw; hw = r;
            reset = 0x0;
        } taref[10:0];
    } DDRC_CFG_TIMING2 @ 0x88;
    reg {
        name = "DDRC_CFG_TIMING3";
        desc = "DDRC_CFG_TIMING3 is DDRC timing parameter register 3. DDRC_CFG_TIMING3 (offset 0x8C, total reset 0xFFDF_F0F2; PROVEN: Hi3535 data sheet, PDF page 633, section 4.1.6.2).";
        field {
            name = "tzq_prd";
            desc = "ZQCS command period.
- 0x000: ZQCS command disabled;
0x001 to 0x3FF: n x 128 AREF periods.
The ZQCS command period is n x 128 taref clock cycles.";
            sw = rw; hw = r;
            reset = 0x3ff;
        } tzq_prd[31:22];
        field {
            name = "tzqinit";
            desc = "ZQ initialization delay cycles. 0x0 to 0x1FF: n+1 clock cycles. This value configures the maximum of tZQINIT and tDLLK. This timing parameter is taken from the DDR device data sheet. If [clk_ration]=1 in DDRC_CFG_WORKMODE, convert the time value specified in the data sheet to a number of DDR clock cycles (no conversion is needed if the data sheet already gives a cycle count), then divide by 2 (add 1 if there is a remainder); if [clk_ration]=0, convert the value specified in the data sheet to DDR clock cycles and configure it directly.";
            sw = rw; hw = r;
            reset = 0x1ff;
        } tzqinit[21:12];
        field {
            name = "taond";
            desc = "ODT (on-die termination) turn-on and turn-off period. In DDR2 mode (taond/taofd):
- 0x0: 2/2.5.
- 0x1: 3/3.5.
- 0x2: 4/4.5.
- 0x3: 5/5.5. Others: Reserved. In DDR3 mode, this value is configured as tWL-1 (tWL is

DDRC_CFG_TIMING1[twl]).";
            sw = rw; hw = r;
            reset = 0x0;
        } taond[11:8];
        field {
            name = "txard";
            desc = "Wait cycles for exiting the DDR low-power state. 0x0 to 0xF: n clock cycles, where n is a decimal number; for example, 0x7 corresponds to 7 clock cycles. Take the maximum of {tXP,tXARD,tXARDS,tXS}. In DDR3 mode, take the maximum of (tXP, tCKE). This timing parameter is taken from the DDR device data sheet. If [clk_ration] of DDRC_CFG_WORKMODE is 1, convert the time value specified in the data sheet to a number of DDR clock cycles (if the data sheet already gives cycles, no conversion is needed), then divide by 2 (add 1 if there is a remainder). If [clk_ration]=0, convert the value specified in the data sheet to DDR clock cycles and configure that value directly.";
            sw = rw; hw = r;
            reset = 0xf;
        } txard[7:4];
        field {
            name = "trtp";
            desc = "Wait delay from a read command to a precharge command. 000 to 010: 2 clock cycles. 011 to 111: n clock cycles. Trtp is calculated as AL+BL/2+Max(trtp,2)-2. Note: DDR3 requires Trtp >= 4. This timing parameter comes from the DDR device data sheet. If [clk_ration] of DDRC_CFG_WORKMODE is 1, convert the value specified in the data sheet to a number of DDR clock cycles (no conversion is needed if the data sheet already gives cycles), then divide by 2 (add 1 if there is a remainder). If [clk_ration] is 0, convert the specified value to a number of DDR clock cycles and configure that number directly.";
            sw = rw; hw = r;
            reset = 0x2;
        } trtp[3:0];
    } DDRC_CFG_TIMING3 @ 0x8c;
    reg {
        name = "DDRC_CFG_TIMING4";
        desc = "DDRC_CFG_TIMING4 is DDRC timing parameter register 4. DDRC_CFG_TIMING4 (offset 0x090, total reset 0x01FF_2000; PROVEN: Hi3535 data sheet, PDF page 634, section 4.1.6.2).";
        field {
            name = "reserved";
            desc = "Reserved.";
            sw = r; hw = w;
            reset = 0x0;
        } reserved_31_25[31:25];
        field {
            name = "tmod";
            desc = "Delay parameter from the MRS command to ODT and ZQCL becoming valid. 0x0 to 0x1: 1 clock cycle; 0x2 to 0x1F: n clock cycles. This timing parameter is taken from the DDR device data sheet. If [clk_ration] of DDRC_CFG_WORKMODE is 1, convert the time value specified in the data sheet to a number of DDR clock cycles (if the data sheet already gives cycles, no conversion is needed), then divide by 2 (add 1 if there is a remainder). If [clk_ration]=0, convert the value specified in the data sheet to DDR clock cycles and configure that value directly.";
            sw = rw; hw = r;
            reset = 0x1f;
        } tmod[24:20];
        field {
            name = "reserved";
            desc = "Reserved.";
            sw = r; hw = w;
            reset = 0xf2000;
        } reserved_19_0[19:0];
    } DDRC_CFG_TIMING4 @ 0x90;
    reg {
        name = "DDRC_CFG_TIMING5";
        desc = "DDRC_CFG_TIMING5 is DDRC timing parameter register 5. DDRC_CFG_TIMING5 (offset 0x094, total reset 0x0000_FF1F; PROVEN: Hi3535 data sheet, PDF page 635, section 4.1.6.2).";
        field {
            name = "reserved";
            desc = "Reserved.";
            sw = r; hw = w;
            reset = 0x0;
        } reserved_31_16[31:16];
        field {
            name = "tzqcs";
            desc = "ZQCS calibration delay cycles. 0x0 to 0xFF: n+1 clock cycles. Due to the DMC design, this value must be constrained to 10 or greater. This timing parameter comes from the DDR device data sheet. If [clk_ration] of DDRC_CFG_WORKMODE is 1, convert the value specified in the data sheet to a number of DDR clock cycles (no conversion is needed if the data sheet already gives cycles), then divide by 2 (add 1 if there is a remainder). If [clk_ration] is 0, convert the specified value to a number of DDR clock cycles and configure that number directly.";
            sw = rw; hw = r;
            reset = 0xff;
        } tzqcs[15:8];
        field {
            name = "reserved";
            desc = "Reserved.";
            sw = r; hw = w;
            reset = 0x0;
        } reserved_7_5[7:5];
        field {
            name = "twr";
            desc = "Write recovery wait cycles. 0x0 to 0x1: 1 clock cycle. 0x2 to 0x1f: n clock cycles. Note: When DFS is required, the tWR parameter must be configured for the highest frequency the chip may use in DFS, and the tWR configuration must not be changed as the DDR frequency changes. This timing parameter is obtained from the DDR device data sheet. If [clk_ration]=1 in DDRC_CFG_WORKMODE, convert the data sheet time value to a number of DDR clock cycles (no conversion is needed if the data sheet already gives cycles), then divide by 2 (add 1 if there is a remainder). If [clk_ration]=0, convert the data sheet value to DDR clock cycles and configure that value directly.";
            sw = rw; hw = r;
            reset = 0x1f;
        } twr[4:0];
    } DDRC_CFG_TIMING5 @ 0x94;
    reg {
        name = "DDRC_CFG_TIMING6";
        desc = "DDRC_CFG_TIMING6 is DDRC timing parameter register 6. DDRC_CFG_TIMING6 (offset 0x098, total reset 0x0000_00FF; PROVEN: Hi3535 data sheet, PDF page 636, section 4.1.6.2).";
        field {
            name = "reseverd";
            desc = "Reserved.";
            sw = r; hw = w;
            reset = 0x0;
        } reseverd[31:8];
        field {
            name = "tcksrx";
            desc = "tCKSRX parameter of DDR3 or DDR4. The number of valid clock cycles the clock must be present before exiting self-refresh. 0x0 to 0x1: 1 clock cycle. 0x2 to 0xF: n clock cycles. This timing parameter comes from the DDR device data sheet. If [clk_ration] of DDRC_CFG_WORKMODE is 1, convert the value specified in the data sheet to a number of DDR clock cycles (no conversion is needed if the data sheet already gives cycles), then divide by 2 (add 1 if there is a remainder). If [clk_ration] is 0, convert the specified value to a number of DDR clock cycles and configure that number directly.";
            sw = rw; hw = r;
            reset = 0xf;
        } tcksrx[7:4];
        field {
            name = "tcksre";
            desc = "tCKSRE parameter of DDR3 or DDR4: the number of cycles the clock must be held after entering self-refresh. 0x0 to 0x1: 1 clock cycle; 0x2 to 0xF: n clock cycles. This timing parameter comes from the DDR device data sheet. If [clk_ration]=1 in DDRC_CFG_WORKMODE, convert the data sheet value to DDR clock cycles (if the data sheet already gives cycles, no conversion is needed), then divide by 2 (add 1 if there is a remainder). If [clk_ration]=0, convert the data sheet value to DDR clock cycles and configure that value directly.";
            sw = rw; hw = r;
            reset = 0xf;
        } tcksre[3:0];
    } DDRC_CFG_TIMING6 @ 0x98;
    reg {
        name = "DDRC_CFG_BLDATA";
        desc = "DDRC_CFG_BLDATA is the DDRC write data pre-receive configuration register. DDRC_CFG_BLDATA (offset 0x0BC, total reset 0x0000_0002; PROVEN: Hi3535 data sheet, PDF page 637, section 4.1.6.2).";
        field {
            name = "reserved";
            desc = "Reserved.";
            sw = r; hw = w;
            reset = 0x0;
        } reserved_31_4[31:4];
        field {
            name = "bl_data";
            desc = "Number of DMC data items per DDR command in the current mode. 0x0 to 0xF: n items. Note: The DMC data width is 128 bits; if the DDR device width is 32 bits and the operation is burst8, configure 2 DMC data items.";
            sw = rw; hw = r;
            reset = 0x2;
        } bl_data[3:0];
    } DDRC_CFG_BLDATA @ 0xbc;
    reg {
        name = "DDRC_CFG_ODT";
        desc = "DDRC_CFG_ODT is the DDR ODT feature configuration register. DDRC_CFG_ODT (offset 0x0C0, total reset 0x0000_0000; PROVEN: Hi3535 data sheet, PDF page 638, section 4.1.6.2).";
        field {
            name = "reserved";
            desc = "Reserved.";
            sw = r; hw = w;
            reset = 0x0;
        } reserved_31_28[31:28];
        field {
            name = "reserved";
            desc = "Reserved.";
            sw = r; hw = w;
            reset = 0x0;
        } reserved_27_24[27:24];
        field {
            name = "reserved";
            desc = "Reserved.";
            sw = r; hw = w;
            reset = 0x0;
        } reserved_23_20[23:20];
        field {
            name = "rodt0";
            desc = "RANK0 read ODT configuration.
- 0: Disable read ODT;
- 1: Enable read ODT.";
            sw = rw; hw = r;
            reset = 0x0;
        } rodt0[19:16];
        field {
            name = "reserved";
            desc = "Reserved.";
            sw = r; hw = w;
            reset = 0x0;
        } reserved_15_12[15:12];
        field {
            name = "reserved";
            desc = "Reserved.";
            sw = r; hw = w;
            reset = 0x0;
        } reserved_11_8[11:8];
        field {
            name = "reserved";
            desc = "Reserved.";
            sw = r; hw = w;
            reset = 0x0;
        } reserved_7_4[7:4];
        field {
            name = "wodt0";
            desc = "RANK0 write ODT configuration.
- 0: Disable write ODT;
- 1: Enable write ODT.";
            sw = rw; hw = r;
            reset = 0x0;
        } wodt0[3:0];
    } DDRC_CFG_ODT @ 0xc0;
    reg {
        name = "DDRC_CFG_DMCLVL";
        desc = "DDRC_CFG_DMCLVL is the DDR controller command queue depth watermark configuration register. DDRC_CFG_DMCLVL (offset 0x0C4, total reset 0x0000_0008; PROVEN: Hi3535 data sheet, PDF page 638, section 4.1.6.2).";
        field {
            name = "reserved";
            desc = "Reserved.";
            sw = r; hw = w;
            reset = 0x0;
        } reserved_31_13[31:13];
        field {
            name = "reserved";
            desc = "Reserved.";
            sw = r; hw = w;
            reset = 0x0;
        } reserved_12_8[12:8];
        field {
            name = "reserved";
            desc = "Reserved.";
            sw = r; hw = w;
            reset = 0x0;
        } reserved_7_5[7:5];
        field {
            name = "que_level";
            desc = "Depth of the command register FIFO in the DMC. 0x1 to 0x10: n commands deep; Others: Reserved.";
            sw = rw; hw = r;
            reset = 0x8;
        } que_level[4:0];
    } DDRC_CFG_DMCLVL @ 0xc4;
    reg {
        name = "DDRC_CFG_SFC";
        desc = "DDRC_CFG_SFC is the command by which software configures DDR command attributes in the DDRC. DDRC_CFG_SFC (offset 0x210, total reset 0x0000_0000; PROVEN: Hi3535 data sheet, PDF page 639, section 4.1.6.2).";
        field {
            name = "cmd_mrs";
            desc = "DDR mode register value used when issuing the LMR command. For LPDDR2, the low 8 bits are valid.";
            sw = rw; hw = r;
            reset = 0x0;
        } cmd_mrs[31:16];
        field {
            name = "cmd_ma";
            desc = "When the LMR command is configured for LPDDR.";
            sw = rw; hw = r;
            reset = 0x0;
        } cmd_ma[15:8];
        field {
            name = "cmd_rank";
            desc = "DDR RANK that executes the command.
- 0: Do not execute the configuration command;
- 1: Execute the configuration command.
Note: each bit controls one RANK. For example, cmd_rank[0] controls DDR RANK0.";
            sw = rw; hw = r;
            reset = 0x0;
        } cmd_rank[7:4];
        field {
            name = "reserved";
            desc = "Reserved.";
            sw = r; hw = w;
            reset = 0x0;
        } reserved_3_3[3:3];
        field {
            name = "cmd_type";
            desc = "DDR command configuration.
- 000: Enter Deep Power Down;
- 001: Exit Deep Power Down;
- 010: Load Mode Register (LMR) command;
- 011: ZQCL;
- 100: WRITE command;
- 101: READ command;
- 110: PRECHARGE ALL command;
- 111: READ MRS command.";
            sw = rw; hw = r;
            reset = 0x0;
        } cmd_type[2:0];
    } DDRC_CFG_SFC @ 0x210;
    reg {
        name = "DDRC_CFG_SFC_ADDR0";
        desc = "DDRC_CFG_SFC_ADDR0 is SFC (Software config) read/write memory address configuration register 0. DDRC_CFG_SFC_ADDR0 (offset 0x214, total reset 0x0000_0000; PROVEN: Hi3535 data sheet, PDF page 640, section 4.1.6.2).";
        field {
            name = "sfc_row";
            desc = "Row address of the memory accessed by SFC reads and writes.";
            sw = rw; hw = r;
            reset = 0x0;
        } sfc_row[31:16];
        field {
            name = "sfc_col";
            desc = "Column address of the SFC read/write access to memory. Note: the data address for accessing a DDR device must be aligned to the current DMC width. For example, the DMC width of the Hi3535 DDRC is currently 128 bits, so with an external 32-bit DDR device the DMC accesses the column address as {sfc_col[15:2],2'b0}.";
            sw = rw; hw = r;
            reset = 0x0;
        } sfc_col[15:0];
    } DDRC_CFG_SFC_ADDR0 @ 0x214;
    reg {
        name = "DDRC_CFG_SFC_ADDR1";
        desc = "DDRC_CFG_SFC_ADDR1 is the SFC (Software config) read/write memory address configuration register. DDRC_CFG_SFC_ADDR1 (offset 0x218, total reset 0x0000_0000; PROVEN: Hi3535 data sheet, PDF page 640, section 4.1.6.2).";
        field {
            name = "reserved";
            desc = "Reserved.";
            sw = r; hw = w;
            reset = 0x0;
        } reserved_31_3[31:3];
        field {
            name = "sfc_bank";
            desc = "Bank address of the memory accessed by SFC reads and writes.";
            sw = rw; hw = r;
            reset = 0x0;
        } sfc_bank[2:0];
    } DDRC_CFG_SFC_ADDR1 @ 0x218;
    reg {
        name = "DDRC_CFG_SFC_WDATA0";
        desc = "DDRC_CFG_SFC_WDATA0 is the SFC (Software config) write data configuration register. DDRC_CFG_SFC_WDATA0 (offset 0x21C, total reset 0x0000_0000; PROVEN: Hi3535 data sheet, PDF page 641, section 4.1.6.2).";
        field {
            name = "wdata0";
            desc = "SFC write data [127:96].";
            sw = rw; hw = r;
            reset = 0x0;
        } wdata0[31:0];
    } DDRC_CFG_SFC_WDATA0 @ 0x21c;
    reg {
        name = "DDRC_CFG_SFC_WDATA1";
        desc = "DDRC_CFG_SFC_WDATA1 is the SFC (software config) write data configuration register. DDRC_CFG_SFC_WDATA1 (offset 0x220, total reset 0x0000_0000; PROVEN: Hi3535 data sheet, PDF page 641, section 4.1.6.2).";
        field {
            name = "wdata1";
            desc = "SFC write data [95:64].";
            sw = rw; hw = r;
            reset = 0x0;
        } wdata1[31:0];
    } DDRC_CFG_SFC_WDATA1 @ 0x220;
    reg {
        name = "DDRC_CFG_SFC_WDATA2";
        desc = "DDRC_CFG_SFC_WDATA2 is the SFC (Software config) write data configuration register. DDRC_CFG_SFC_WDATA2 (offset 0x224, total reset 0x0000_0000; PROVEN: Hi3535 data sheet, PDF page 641, section 4.1.6.2).";
        field {
            name = "wdata2";
            desc = "SFC write data [63:32].";
            sw = rw; hw = r;
            reset = 0x0;
        } wdata2[31:0];
    } DDRC_CFG_SFC_WDATA2 @ 0x224;
    reg {
        name = "DDRC_CFG_SFC_WDATA3";
        desc = "DDRC_CFG_SFC_WDATA3 is the SFC (Software Config) write data configuration register 3. DDRC_CFG_SFC_WDATA3 (offset 0x228, total reset 0x0000_0000; PROVEN: Hi3535 data sheet, PDF page 642, section 4.1.6.2).";
        field {
            name = "wdata3";
            desc = "SFC write data [31:0].";
            sw = rw; hw = r;
            reset = 0x0;
        } wdata3[31:0];
    } DDRC_CFG_SFC_WDATA3 @ 0x228;
    reg {
        name = "DDRC_CFG_PERF";
        desc = "DDRC_CFG_PERF is the DDRC performance statistics mode configuration register. DDRC_CFG_PERF (offset 0x270, total reset 0x0000_0000; PROVEN: Hi3535 data sheet, PDF page 642, section 4.1.6.2).";
        field {
            name = "reserved";
            desc = "Reserved.";
            sw = r; hw = w;
            reset = 0x0;
        } reserved_31_30[31:30];
        field {
            name = "flux_en";
            desc = "DMC traffic monitoring enable.
- 0: Traffic monitoring off;
- 1: Traffic monitoring enabled.
When traffic monitoring is enabled, the statistics module feeds back the number of cycles occupied on the DDR interface to each requesting port by ID. Together with the per-port traffic settings, this allows traffic control.";
            sw = rw; hw = r;
            reset = 0x0;
        } flux_en[29:29];
        field {
            name = "perf_mode";
            desc = "Performance statistics mode.
- 0: Continuous trigger mode. The performance statistics counters count continuously. It is guaranteed that the statistics do not overflow within 1 s in continuous statistics mode.
- 1: Single trigger mode. After the performance statistics time reaches perf_prd, the result is held and statistics stop. Note: The value is held after the statistics overflow.";
            sw = rw; hw = r;
            reset = 0x0;
        } perf_mode[28:28];
        field {
            name = "perf_prd";
            desc = "Performance statistics period.
0x0 to 0x1: Invalid configuration;
0x2 to 0xFFFFFFF: Statistics period.
The actual statistics period is perf_prd x 16 x tclk (tclk is the DDRC bus clock period). Note: This setting is valid only when perf_mode=1. In the continuous statistics mode with perf_mode=0, the performance statistics counters keep counting.";
            sw = rw; hw = r;
            reset = 0x0;
        } perf_prd[27:0];
    } DDRC_CFG_PERF @ 0x270;
    reg {
        name = "DDRC_CFG_STAID";
        desc = "DDRC_CFG_STAID is the command ID configuration register for DDRC performance statistics. DDRC_CFG_STAID (offset 0x274, total reset 0x0000_0000; PROVEN: Hi3535 data sheet, PDF page 643, section 4.1.6.2).";
        field {
            name = "reserved";
            desc = "Reserved. Note: Must be set to 0.";
            sw = r; hw = w;
            reset = 0x0;
        } reserved_31_15[31:15];
        field {
            name = "sta_id";
            desc = "Configures performance statistics for the specified ID. Used together with sta_idmask. Note: sta_id = {id[11:0],axi_port_num[3:0]}.";
            sw = rw; hw = r;
            reset = 0x0;
        } sta_id[14:0];
    } DDRC_CFG_STAID @ 0x274;
    reg {
        name = "DDRC_CFG_STAIDMSK";
        desc = "DDRC_CFG_STAIDMSK is the command ID MASK configuration register for DDR performance statistics. DDRC_CFG_STAIDMSK (offset 0x278, total reset 0x0000_FFFF; PROVEN: Hi3535 data sheet, PDF page 643, section 4.1.6.2).";
        field {
            name = "reserved";
            desc = "Reserved. Note: Must be set to 0.";
            sw = r; hw = w;
            reset = 0x0;
        } reserved_31_16[31:16];
        field {
            name = "sta_idmask";
            desc = "Configures the mask signal for the specified ID. The performance statistics registers in the DDRC count only commands of a specific ID. Cmd_id&sta_idmask=sta_id.";
            sw = rw; hw = r;
            reset = 0xffff;
        } sta_idmask[15:0];
    } DDRC_CFG_STAIDMSK @ 0x278;
    reg {
        name = "DDRC_INTMSK";
        desc = "DDRC_INTMSK is the DDRC interrupt mask register. DDRC_INTMSK (offset 0x280, total reset 0x0000_0000; PROVEN: Hi3535 data sheet, PDF page 644, section 4.1.6.2).";
        field {
            name = "rpram_merr_int_mask";
            desc = "RPRAM multi-bit error interrupt mask enable.
- 0: Interrupt enabled;
- 1: Interrupt masked.";
            sw = r; hw = w;
            reset = 0x0;
        } rpram_merr_int_mask[31:31];
        field {
            name = "reserved";
            desc = "Reserved.";
            sw = r; hw = w;
            reset = 0x0;
        } reserved_30_29[30:29];
        field {
            name = "rpram_serr_int_mask";
            desc = "RPRAM single-bit error interrupt mask enable.
- 0: Interrupt enabled.
- 1: Interrupt masked.";
            sw = rw; hw = r;
            reset = 0x0;
        } rpram_serr_int_mask[28:28];
        field {
            name = "reserved";
            desc = "Reserved.";
            sw = r; hw = w;
            reset = 0x0;
        } reserved_27_25[27:25];
        field {
            name = "sbram_merr_int_mask";
            desc = "SBRAM multi-bit error interrupt mask enable.
- 0: Enable the interrupt;
- 1: Mask the interrupt.";
            sw = rw; hw = r;
            reset = 0x0;
        } sbram_merr_int_mask[24:24];
        field {
            name = "reserved";
            desc = "Reserved.";
            sw = r; hw = w;
            reset = 0x0;
        } reserved_23_21[23:21];
        field {
            name = "sbram_serr_int_mask";
            desc = "SBRAM single-bit error interrupt mask enable.
- 0: Enable the interrupt;
- 1: Mask the interrupt.";
            sw = rw; hw = r;
            reset = 0x0;
        } sbram_serr_int_mask[20:20];
        field {
            name = "reserved";
            desc = "Reserved.";
            sw = r; hw = w;
            reset = 0x0;
        } reserved_19_17[19:17];
        field {
            name = "aref_alarm_int_mask";
            desc = "DDR AREF command error interrupt mask enable.
- 0: Enable the interrupt;
- 1: Mask the interrupt.";
            sw = rw; hw = r;
            reset = 0x0;
        } aref_alarm_int_mask[16:16];
        field {
            name = "reserved";
            desc = "Reserved.";
            sw = r; hw = w;
            reset = 0x0;
        } reserved_15_13[15:13];
        field {
            name = "rdtimeout_int_mask";
            desc = "DDRPHY read data timeout interrupt mask enable.
- 0: Interrupt enabled.
- 1: Interrupt masked.";
            sw = rw; hw = r;
            reset = 0x0;
        } rdtimeout_int_mask[12:12];
        field {
            name = "reserved";
            desc = "Reserved.";
            sw = r; hw = w;
            reset = 0x0;
        } reserved_11_9[11:9];
        field {
            name = "dimm_parity_int_mask";
            desc = "DDR DIMM parity error interrupt mask enable.
- 0: Enable the interrupt;
- 1: Mask the interrupt.";
            sw = rw; hw = r;
            reset = 0x0;
        } dimm_parity_int_mask[8:8];
        field {
            name = "reserved";
            desc = "Reserved.";
            sw = r; hw = w;
            reset = 0x0;
        } reserved_7_6[7:6];
        field {
            name = "sref_err_int_mask";
            desc = "Command access error on the interface during DDR self-refresh.
- 0: Enable the interrupt;
- 1: Mask the interrupt.";
            sw = rw; hw = r;
            reset = 0x0;
        } sref_err_int_mask[5:5];
        field {
            name = "merr_int_mask";
            desc = "DDR ECC multi-bit error interrupt mask enable.
- 0: Interrupt enabled.
- 1: Interrupt masked.";
            sw = rw; hw = r;
            reset = 0x0;
        } merr_int_mask[4:4];
        field {
            name = "reserved";
            desc = "Reserved.";
            sw = r; hw = w;
            reset = 0x0;
        } reserved_3_2[3:2];
        field {
            name = "flux_int_mask";
            desc = "DDR FLUX statistics period reached interrupt mask enable.
- 0: Enable the interrupt;
- 1: Mask the interrupt.";
            sw = rw; hw = r;
            reset = 0x0;
        } flux_int_mask[1:1];
        field {
            name = "serr_int_mask";
            desc = "DDR ECC single-bit error interrupt mask enable.
- 0: Interrupt enabled;
- 1: Interrupt masked.";
            sw = rw; hw = r;
            reset = 0x0;
        } serr_int_mask[0:0];
    } DDRC_INTMSK @ 0x280;
    reg {
        name = "DDRC_RINT";
        desc = "DDRC_RINT is the DDRC raw interrupt register. DDRC_RINT (offset 0x284, total reset 0x0000_0000; PROVEN: Hi3535 data sheet, PDF page 646, section 4.1.6.2).";
        field {
            name = "reserved";
            desc = "Reserved.";
            sw = r; hw = w;
            reset = 0x0;
        } reserved_31_31[31:31];
        field {
            name = "reserved";
            desc = "Reserved.";
            sw = r; hw = w;
            reset = 0x0;
        } reserved_30_29[30:29];
        field {
            name = "reserved";
            desc = "Reserved.";
            sw = r; hw = w;
            reset = 0x0;
        } reserved_28_28[28:28];
        field {
            name = "reserved";
            desc = "Reserved.";
            sw = r; hw = w;
            reset = 0x0;
        } reserved_27_25[27:25];
        field {
            name = "reserved";
            desc = "Reserved.";
            sw = r; hw = w;
            reset = 0x0;
        } reserved_24_24[24:24];
        field {
            name = "reserved";
            desc = "Reserved.";
            sw = r; hw = w;
            reset = 0x0;
        } reserved_23_21[23:21];
        field {
            name = "reserved";
            desc = "Reserved.";
            sw = r; hw = w;
            reset = 0x0;
        } reserved_20_20[20:20];
        field {
            name = "reserved";
            desc = "Reserved.";
            sw = r; hw = w;
            reset = 0x0;
        } reserved_19_17[19:17];
        field {
            name = "aref_alarm_rint";
            desc = "DDR AREF command error raw interrupt. Write 1 to clear the interrupt. (data sheet access type INT_WC)";
            sw = rw; hw = rw; onwrite = woclr;
            reset = 0x0;
        } aref_alarm_rint[16:16];
        field {
            name = "reserved";
            desc = "Reserved.";
            sw = r; hw = w;
            reset = 0x0;
        } reserved_15_13[15:13];
        field {
            name = "rdtimeout_rint";
            desc = "DDRPHY read data timeout raw interrupt. Write 1 to clear the interrupt. (data sheet access type INT_WC)";
            sw = rw; hw = rw; onwrite = woclr;
            reset = 0x0;
        } rdtimeout_rint[12:12];
        field {
            name = "reserved";
            desc = "Reserved.";
            sw = r; hw = w;
            reset = 0x0;
        } reserved_11_9[11:9];
        field {
            name = "reserved";
            desc = "Reserved.";
            sw = r; hw = w;
            reset = 0x0;
        } reserved_8_8[8:8];
        field {
            name = "reserved";
            desc = "Reserved.";
            sw = r; hw = w;
            reset = 0x0;
        } reserved_7_6[7:6];
        field {
            name = "sref_err_rint";
            desc = "Command access on the self-refresh interface interrupt. Write 1 to clear the interrupt. (data sheet access type INT_WC)";
            sw = rw; hw = rw; onwrite = woclr;
            reset = 0x0;
        } sref_err_rint[5:5];
        field {
            name = "reserved";
            desc = "Reserved.";
            sw = r; hw = w;
            reset = 0x0;
        } reserved_4_4[4:4];
        field {
            name = "reserved";
            desc = "Reserved.";
            sw = r; hw = w;
            reset = 0x0;
        } reserved_3_2[3:2];
        field {
            name = "flux_rint";
            desc = "DDR FLUX statistics period reached interrupt. Write 1 to clear the interrupt.";
            sw = rw; hw = r;
            reset = 0x0;
        } flux_rint[1:1];
        field {
            name = "reserved";
            desc = "Reserved.";
            sw = r; hw = w;
            reset = 0x0;
        } reserved_0_0[0:0];
    } DDRC_RINT @ 0x284;
    reg {
        name = "DDRC_INTSTS";
        desc = "DDRC_INTSTS is the DDRC interrupt status register. DDRC_INTSTS (offset 0x288, total reset 0x0000_0000; PROVEN: Hi3535 data sheet, PDF page 647, section 4.1.6.2).";
        field {
            name = "rpram_merr_intsts";
            desc = "RPRAM multi-bit error interrupt. (data sheet access type INT)";
            sw = rw; hw = rw; onwrite = woclr;
            reset = 0x0;
        } rpram_merr_intsts[31:31];
        field {
            name = "reserved";
            desc = "Reserved.";
            sw = r; hw = w;
            reset = 0x0;
        } reserved_30_29[30:29];
        field {
            name = "rpram_serr_intsts";
            desc = "RPRAM single-bit error interrupt. (data sheet access type INT)";
            sw = rw; hw = rw; onwrite = woclr;
            reset = 0x0;
        } rpram_serr_intsts[28:28];
        field {
            name = "reserved";
            desc = "Reserved.";
            sw = r; hw = w;
            reset = 0x0;
        } reserved_27_25[27:25];
        field {
            name = "sbram_merr_intsts";
            desc = "SBRAM multi-bit error interrupt. (data sheet access type INT)";
            sw = rw; hw = rw; onwrite = woclr;
            reset = 0x0;
        } sbram_merr_intsts[24:24];
        field {
            name = "reserved";
            desc = "Reserved.";
            sw = r; hw = w;
            reset = 0x0;
        } reserved_23_21[23:21];
        field {
            name = "sbram_serr_intsts";
            desc = "SBRAM single-bit error interrupt. (data sheet access type INT)";
            sw = rw; hw = rw; onwrite = woclr;
            reset = 0x0;
        } sbram_serr_intsts[20:20];
        field {
            name = "reserved";
            desc = "Reserved.";
            sw = r; hw = w;
            reset = 0x0;
        } reserved_19_17[19:17];
        field {
            name = "aref_alarm_intsts";
            desc = "DDR AREF command error interrupt. (data sheet access type INT)";
            sw = rw; hw = rw; onwrite = woclr;
            reset = 0x0;
        } aref_alarm_intsts[16:16];
        field {
            name = "reserved";
            desc = "Reserved.";
            sw = r; hw = w;
            reset = 0x0;
        } reserved_15_13[15:13];
        field {
            name = "rdtimeout_intsts";
            desc = "DDRPHY read data timeout interrupt. (data sheet access type INT)";
            sw = rw; hw = rw; onwrite = woclr;
            reset = 0x0;
        } rdtimeout_intsts[12:12];
        field {
            name = "reserved";
            desc = "Reserved.";
            sw = r; hw = w;
            reset = 0x0;
        } reserved_11_9[11:9];
        field {
            name = "dimm_parity_intsts";
            desc = "DDR DIMM parity error interrupt. (data sheet access type INT)";
            sw = rw; hw = rw; onwrite = woclr;
            reset = 0x0;
        } dimm_parity_intsts[8:8];
        field {
            name = "reserved";
            desc = "Reserved.";
            sw = r; hw = w;
            reset = 0x0;
        } reserved_7_6[7:6];
        field {
            name = "sref_err_intsts";
            desc = "Self-refresh interface command access interrupt. (data sheet access type INT)";
            sw = rw; hw = rw; onwrite = woclr;
            reset = 0x0;
        } sref_err_intsts[5:5];
        field {
            name = "merr_intsts";
            desc = "DDR ECC multi-bit error interrupt. (data sheet access type INT)";
            sw = rw; hw = rw; onwrite = woclr;
            reset = 0x0;
        } merr_intsts[4:4];
        field {
            name = "reservd";
            desc = "Reserved.";
            sw = r; hw = w;
            reset = 0x0;
        } reservd[3:2];
        field {
            name = "flux_intsts";
            desc = "DDR FLUX statistics period reached interrupt.";
            sw = rw; hw = r;
            reset = 0x0;
        } flux_intsts[1:1];
        field {
            name = "serr_intsts";
            desc = "DDR ECC single-bit error interrupt. (data sheet access type INT)";
            sw = rw; hw = rw; onwrite = woclr;
            reset = 0x0;
        } serr_intsts[0:0];
    } DDRC_INTSTS @ 0x288;
    reg {
        name = "DDRC_CURR_STATUS";
        desc = "DDRC_CURR_STATUS is the DDRC status register. DDRC_CURR_STATUS (offset 0x290, total reset 0x0000_0101; PROVEN: Hi3535 data sheet, PDF page 648, section 4.1.6.2).";
        field {
            name = "reserved";
            desc = "Reserved.";
            sw = r; hw = w;
            reset = 0x0;
        } reserved_31_9[31:9];
        field {
            name = "busy_func";
            desc = "Busy status register of the DDRC FUNC module (reset is in the sref state).
- 0: Idle.
- 1: Processing a command.";
            sw = r; hw = w;
            reset = 0x1;
        } busy_func[8:8];
        field {
            name = "reserved";
            desc = "Reserved.";
            sw = r; hw = w;
            reset = 0x0;
        } reserved_7_5[7:5];
        field {
            name = "busy_dmc";
            desc = "Busy status register of the DDRC DMC module.
- 0: Idle;
- 1: Processing commands.";
            sw = r; hw = w;
            reset = 0x0;
        } busy_dmc[4:4];
        field {
            name = "reserved";
            desc = "Reserved.";
            sw = r; hw = w;
            reset = 0x0;
        } reserved_3_1[3:1];
        field {
            name = "busy";
            desc = "DDRC overall busy status register.
- 0: Idle;
- 1: Command being processed.";
            sw = r; hw = w;
            reset = 0x1;
        } busy[0:0];
    } DDRC_CURR_STATUS @ 0x290;
    reg {
        name = "DDRC_CURR_FUNC";
        desc = "DDRC_CURR_FUNC is the DDRC FUNC module status register. DDRC_CURR_FUNC (offset 0x294, total reset 0x0000_0001; PROVEN: Hi3535 data sheet, PDF page 649, section 4.1.6.2).";
        field {
            name = "reserved";
            desc = "Reserved.";
            sw = r; hw = w;
            reset = 0x0;
        } reserved_31_29[31:29];
        field {
            name = "reserved";
            desc = "Reserved.";
            sw = r; hw = w;
            reset = 0x0;
        } reserved_28_28[28:28];
        field {
            name = "reserved";
            desc = "Reserved.";
            sw = r; hw = w;
            reset = 0x0;
        } reserved_27_25[27:25];
        field {
            name = "reserved";
            desc = "Reserved.";
            sw = r; hw = w;
            reset = 0x0;
        } reserved_24_24[24:24];
        field {
            name = "reserved";
            desc = "Reserved.";
            sw = r; hw = w;
            reset = 0x0;
        } reserved_23_21[23:21];
        field {
            name = "reserved";
            desc = "Reserved.";
            sw = r; hw = w;
            reset = 0x0;
        } reserved_20_20[20:20];
        field {
            name = "reserved";
            desc = "Reserved.";
            sw = r; hw = w;
            reset = 0x0;
        } reserved_19_17[19:17];
        field {
            name = "reserved";
            desc = "Reserved.";
            sw = r; hw = w;
            reset = 0x0;
        } reserved_16_16[16:16];
        field {
            name = "reserved";
            desc = "Reserved.";
            sw = r; hw = w;
            reset = 0x0;
        } reserved_15_13[15:13];
        field {
            name = "in_sfc";
            desc = "DDRC SFC status register.
- 0: Idle;
- 1: SFC command being processed.";
            sw = r; hw = w;
            reset = 0x0;
        } in_sfc[12:12];
        field {
            name = "in_pd";
            desc = "DDRC PowerDown status.
- 0: Normal state;
- 1: PowerDown state. Each bit represents one rank.";
            sw = r; hw = w;
            reset = 0x0;
        } in_pd[11:8];
        field {
            name = "reserved";
            desc = "Reserved.";
            sw = r; hw = w;
            reset = 0x0;
        } reserved_7_6[7:6];
        field {
            name = "dfi_init_complete";
            desc = "DFI initialization status.
- 0: DFI initialization in progress;
- 1: Normal operation.";
            sw = r; hw = w;
            reset = 0x0;
        } dfi_init_complete[5:5];
        field {
            name = "in_init";
            desc = "DDRC initialization status.
- 0: Normal state.
- 1: Initialization state.";
            sw = r; hw = w;
            reset = 0x0;
        } in_init[4:4];
        field {
            name = "reserved";
            desc = "Reserved.";
            sw = r; hw = w;
            reset = 0x0;
        } reserved_3_1[3:1];
        field {
            name = "in_sref";
            desc = "DDRC self-refresh status.
- 0: Normal state;
- 1: Self-refresh state.";
            sw = r; hw = w;
            reset = 0x1;
        } in_sref[0:0];
    } DDRC_CURR_FUNC @ 0x294;
    reg {
        name = "DDRC_CURR_EXECST";
        desc = "DDRC_CURR_EXECST is the DDRC command state machine status. DDRC_CURR_EXECST (offset 0x2A0, total reset 0x0000_0000; PROVEN: Hi3535 data sheet, PDF page 650, section 4.1.6.2).";
        field {
            name = "dmc_ct";
            desc = "Controller command type.
- 0: Read command;
- 1: Write command.";
            sw = r; hw = w;
            reset = 0x0;
        } dmc_ct[31:16];
        field {
            name = "dmc_cv";
            desc = "Controller command type.
- 0: Read command;
- 1: Write command.";
            sw = r; hw = w;
            reset = 0x0;
        } dmc_cv[15:0];
    } DDRC_CURR_EXECST @ 0x2a0;
    reg {
        name = "DDRC_CURR_WGFIFOST";
        desc = "DDRC_CURR_WGFIFOST is the write data FIFO empty/full status register in the DDRC. DDRC_CURR_WGFIFOST (offset 0x2A4, total reset 0x0000_0001; PROVEN: Hi3535 data sheet, PDF page 650, section 4.1.6.2).";
        field {
            name = "reserved";
            desc = "Reserved.";
            sw = r; hw = w;
            reset = 0x0;
        } reserved_31_1[31:1];
        field {
            name = "wgntfifo_e";
            desc = "WGNT_FIFO empty/full status. Empty means all write data has been received; non-empty means the write data has not been completely received.
- 0: FIFO not empty.
- 1: FIFO empty.";
            sw = r; hw = w;
            reset = 0x1;
        } wgntfifo_e[0:0];
    } DDRC_CURR_WGFIFOST @ 0x2a4;
    reg {
        name = "DDRC_HIS_FLUX_WR";
        desc = "DDRC_HIS_FLUX_WR is the traffic statistics register for all DDRC write commands. DDRC_HIS_FLUX_WR (offset 0x380, total reset 0x0000_0000; PROVEN: Hi3535 data sheet, PDF page 651, section 4.1.6.2).";
        field {
            name = "flux_wr";
            desc = "Write traffic statistics of the MASTER for all IDs of the DDRC. Counted within the valid statistics period. The unit is the 128-bit data width of the DMC. When perf_mode=0 the counter wraps around on overflow; when perf_mode=1 it holds the value on overflow. Cleared when the next statistics period starts.";
            sw = r; hw = w;
            reset = 0x0;
        } flux_wr[31:0];
    } DDRC_HIS_FLUX_WR @ 0x380;
    reg {
        name = "DDRC_HIS_FLUX_RD";
        desc = "DDRC_HIS_FLUX_RD is the DDRC read command traffic statistics register for all reads. DDRC_HIS_FLUX_RD (offset 0x384, total reset 0x0000_0000; PROVEN: Hi3535 data sheet, PDF page 652, section 4.1.6.2).";
        field {
            name = "flux_rd";
            desc = "DDRC read traffic statistics of MASTER for all IDs. Counted within the valid statistics period. The unit is the DMC data width of 128 bits. When perf_mode=0, wraps around on overflow; when perf_mode=1, holds on overflow. Cleared when the next statistics run starts.";
            sw = r; hw = w;
            reset = 0x0;
        } flux_rd[31:0];
    } DDRC_HIS_FLUX_RD @ 0x384;
    reg {
        name = "DDRC_HIS_FLUX_WCMD";
        desc = "DDRC_HIS_FLUX_WCMD is the DDRC statistics register for the number of all write commands. DDRC_HIS_FLUX_WCMD (offset 0x388, total reset 0x0000_0000; PROVEN: Hi3535 data sheet, PDF page 652, section 4.1.6.2).";
        field {
            name = "flux_wr_cmd";
            desc = "Count of MASTER write commands of all IDs in the DDRC. Counts within the valid statistics period. When perf_mode=0, wraps around on overflow; when perf_mode=1, holds the value on overflow. Cleared when the next statistics period starts.";
            sw = r; hw = w;
            reset = 0x0;
        } flux_wr_cmd[31:0];
    } DDRC_HIS_FLUX_WCMD @ 0x388;
    reg {
        name = "DDRC_HIS_FLUX_RCMD";
        desc = "DDRC_HIS_FLUX_RCMD is the register counting all read commands in the DDRC. DDRC_HIS_FLUX_RCMD (offset 0x38C, total reset 0x0000_0000; PROVEN: Hi3535 data sheet, PDF page 653, section 4.1.6.2).";
        field {
            name = "flux_rd_cmd";
            desc = "Count of MASTER read commands of all IDs in the DDRC. Counts within the valid statistics period. Wraps around on overflow when perf_mode=0; holds on overflow when perf_mode=1. Cleared when the next statistics period starts.";
            sw = r; hw = w;
            reset = 0x0;
        } flux_rd_cmd[31:0];
    } DDRC_HIS_FLUX_RCMD @ 0x38c;
    reg {
        name = "DDRC_HIS_FLUXID_WR";
        desc = "DDRC_HIS_FLUXID_WR is the DDRC write traffic statistics register for the specified ID. DDRC_HIS_FLUXID_WR (offset 0x390, total reset 0x0000_0000; PROVEN: Hi3535 data sheet, PDF page 653, section 4.1.6.2).";
        field {
            name = "fluxid_wr";
            desc = "Write traffic count of the MASTER with the specified ID in the DDRC. It counts within the valid statistics period, in units of the 128-bit DMC data width. When perf_mode=0 it wraps around on overflow; when perf_mode=1 it holds on overflow. It is cleared when the next statistics period starts.";
            sw = r; hw = w;
            reset = 0x0;
        } fluxid_wr[31:0];
    } DDRC_HIS_FLUXID_WR @ 0x390;
    reg {
        name = "DDRC_HIS_FLUXID_RD";
        desc = "DDRC_HIS_FLUXID_RD is the DDRC read traffic statistics register for the specified ID. DDRC_HIS_FLUXID_RD (offset 0x394, total reset 0x0000_0000; PROVEN: Hi3535 data sheet, PDF page 654, section 4.1.6.2).";
        field {
            name = "fluxid_rd";
            desc = "Read traffic statistics of the DDRC for the MASTER with the specified ID. Counts within the valid statistics period. The unit is the DMC data width of 128 bits. When perf_mode is 0, it wraps around on overflow. When perf_mode is 1, it holds its value on overflow. It is cleared when the next statistics period starts.";
            sw = r; hw = w;
            reset = 0x0;
        } fluxid_rd[31:0];
    } DDRC_HIS_FLUXID_RD @ 0x394;
    reg {
        name = "DDRC_HIS_FLUXID_WCMD";
        desc = "DDRC_HIS_FLUXID_WCMD is the register for the number of write commands of all specified IDs in the DDRC. DDRC_HIS_FLUXID_WCMD (offset 0x0398, total reset 0x0000_0000; PROVEN: Hi3535 data sheet, PDF page 654, section 4.1.6.2).";
        field {
            name = "fluxid_wr_cmd";
            desc = "Read traffic statistics of the DDRC for the MASTER with the specified ID. Counts within the valid statistics period. The unit is the DMC data width of 128 bits. When perf_mode is 0, it wraps around on overflow. When perf_mode is 1, it holds its value on overflow. It is cleared when the next statistics period starts.";
            sw = r; hw = w;
            reset = 0x0;
        } fluxid_wr_cmd[31:0];
    } DDRC_HIS_FLUXID_WCMD @ 0x398;
    reg {
        name = "DDRC_HIS_FLUXID_RCMD";
        desc = "DDRC_HIS_FLUXID_RCMD is the register for the count of read commands of all specified IDs of the DDRC. DDRC_HIS_FLUXID_RCMD (offset 0x039C, total reset 0x0000_0000; PROVEN: Hi3535 data sheet, PDF page 655, section 4.1.6.2).";
        field {
            name = "fluxid_rd_cmd";
            desc = "Count of MASTER read commands of the specified ID in the DDRC. Counts within the valid statistics period. When perf_mode=0, wraps around on overflow; when perf_mode=1, holds the value on overflow. Cleared when the next statistics period starts.";
            sw = r; hw = w;
            reset = 0x0;
        } fluxid_rd_cmd[31:0];
    } DDRC_HIS_FLUXID_RCMD @ 0x39c;
    reg {
        name = "DDRC_HIS_WLATCNT0";
        desc = "DDRC_HIS_WLATCNT0 is write command latency statistics register 0 for the specified ID of the DDRC. DDRC_HIS_WLATCNT0 (offset 0x3A0, total reset 0x0000_FFFF; PROVEN: Hi3535 data sheet, PDF page 655, section 4.1.6.2).";
        field {
            name = "wlatcnt_max";
            desc = "Maximum write command latency statistics for the specified ID of the DDRC. Cleared when the next statistics period starts.";
            sw = r; hw = w;
            reset = 0x0;
        } wlatcnt_max[31:16];
        field {
            name = "wlatcnt_min";
            desc = "Minimum write command latency statistic of the specified ID in the DDRC. Holds the maximum value on overflow. Cleared when the next statistics period starts.";
            sw = r; hw = w;
            reset = 0xffff;
        } wlatcnt_min[15:0];
    } DDRC_HIS_WLATCNT0 @ 0x3a0;
    reg {
        name = "DDRC_HIS_WLATCNT1";
        desc = "DDRC_HIS_WLATCNT1 is write command latency statistics register 1 of the specified ID in the DDRC. DDRC_HIS_WLATCNT1 (offset 0x3A4, total reset 0x0000_0000; PROVEN: Hi3535 data sheet, PDF page 656, section 4.1.6.2).";
        field {
            name = "wlatcnt_all";
            desc = "Accumulated latency of write commands of the specified ID within the statistics period (the low 4 bits of the result are ignored). Wraps around on overflow when perf_mode=0; holds on overflow when perf_mode=1. Cleared when the next statistics period starts. Note: software can obtain the average latency of write commands of the specified ID as (wlatcnt_all)/fluxid_wr_cmd.";
            sw = r; hw = w;
            reset = 0x0;
        } wlatcnt_all[31:0];
    } DDRC_HIS_WLATCNT1 @ 0x3a4;
    reg {
        name = "DDRC_HIS_RLATCNT0";
        desc = "DDRC_HIS_RLATCNT0 is read command latency statistics register 0 for the specified ID of the DDRC. DDRC_HIS_RLATCNT0 (offset 0x3A8, total reset 0x0000_FFFF; PROVEN: Hi3535 data sheet, PDF page 656, section 4.1.6.2).";
        field {
            name = "rlatcnt_max";
            desc = "Maximum read command latency statistics for the specified ID of the DDRC. The actual maximum read latency is rlatcnt_max + inhere_rlatcnt. Holds the maximum value on overflow. Cleared when the next statistics period starts.";
            sw = r; hw = w;
            reset = 0x0;
        } rlatcnt_max[31:16];
        field {
            name = "rlatcnt_min";
            desc = "DDRC minimum read command latency statistics for the specified ID. Note: The actual minimum read latency is rlatcnt_min + inhere_rlatcnt. Holds the maximum value on overflow. Cleared when the next statistics run starts.";
            sw = r; hw = w;
            reset = 0xffff;
        } rlatcnt_min[15:0];
    } DDRC_HIS_RLATCNT0 @ 0x3a8;
    reg {
        name = "DDRC_HIS_RLATCNT1";
        desc = "DDRC_HIS_RLATCNT1 is read command latency statistics register 1 of the specified ID in the DDRC. DDRC_HIS_RLATCNT1 (offset 0x3AC, total reset 0x0000_0000; PROVEN: Hi3535 data sheet, PDF page 657, section 4.1.6.2).";
        field {
            name = "rlatcnt_all";
            desc = "Accumulated read command latency for the specified ID within the statistics period (the low 4 bits of the result are ignored). When perf_mode=0 it wraps around on overflow; when perf_mode=1 it holds the value on overflow. Cleared when the next statistics period starts. Note: Software can obtain the average read command latency of the specified ID from (rlatcnt_all/fluxid_rd_cmd + inhere_rlatcnt.";
            sw = r; hw = w;
            reset = 0x0;
        } rlatcnt_all[31:0];
    } DDRC_HIS_RLATCNT1 @ 0x3ac;
    reg {
        name = "DDRC_HIS_INHERE_RLAT_CNT";
        desc = "DDRC_HIS_INHERE_RLAT_CNT is the read channel inherent latency register. DDRC_HIS_INHERE_RLAT_CNT (offset 0x3B0, total reset 0x0000_0000; PROVEN: Hi3535 data sheet, PDF page 657, section 4.1.6.2).";
        field {
            name = "reserved";
            desc = "Reserved.";
            sw = r; hw = w;
            reset = 0x0;
        } reserved_31_16[31:16];
        field {
            name = "inhere_rlatcnt";
            desc = "Indicates the inherent delay of the DDRC and PHY on the read data path. This register must be used together with rlatcnt_min, rlatcnt_max, rlatcnt_all and fluxid_rd_cmd to obtain the true latency.";
            sw = r; hw = w;
            reset = 0x0;
        } inhere_rlatcnt[15:0];
    } DDRC_HIS_INHERE_RLAT_CNT @ 0x3b0;
    reg {
        name = "DDRC_HIS_CMD_SUM";
        desc = "DDRC_HIS_CMD_SUM is the accumulation register for the DMC command count. DDRC_HIS_CMD_SUM (offset 0x3BC, total reset 0x0000_0000; PROVEN: Hi3535 data sheet, PDF page 658, section 4.1.6.2).";
        field {
            name = "dmc_cmd_sum";
            desc = "Accumulates, per cycle, the value of the commands currently buffered in the DMC; wraps around on overflow.";
            sw = r; hw = w;
            reset = 0x0;
        } dmc_cmd_sum[31:0];
    } DDRC_HIS_CMD_SUM @ 0x3bc;
    reg {
        name = "DDRC_HIS_SFC_RDATA0";
        desc = "DDRC_HIS_SFC_RDATA0 is the SFC (Software config) read data register. DDRC_HIS_SFC_RDATA0 (offset 0x4A8, total reset 0x0000_0000; PROVEN: Hi3535 data sheet, PDF page 658, section 4.1.6.2).";
        field {
            name = "rdata0";
            desc = "SFC read data [127:96].";
            sw = rw; hw = r;
            reset = 0x0;
        } rdata0[31:0];
    } DDRC_HIS_SFC_RDATA0 @ 0x4a8;
    reg {
        name = "DDRC_HIS_SFC_RDATA1";
        desc = "DDRC_HIS_SFC_RDATA1 is the SFC (Software config) read data register. DDRC_HIS_SFC_RDATA1 (offset 0x4AC, total reset 0x0000_0000; PROVEN: Hi3535 data sheet, PDF page 658, section 4.1.6.2).";
        field {
            name = "rdata1";
            desc = "SFC read data [95:64].";
            sw = rw; hw = r;
            reset = 0x0;
        } rdata1[31:0];
    } DDRC_HIS_SFC_RDATA1 @ 0x4ac;
    reg {
        name = "DDRC_HIS_SFC_RDATA2";
        desc = "DDRC_HIS_SFC_RDATA2 is the SFC (software config) read data register. DDRC_HIS_SFC_RDATA2 (offset 0x4B0, total reset 0x0000_0000; PROVEN: Hi3535 data sheet, PDF page 659, section 4.1.6.2).";
        field {
            name = "rdata2";
            desc = "SFC read data [63:32].";
            sw = rw; hw = r;
            reset = 0x0;
        } rdata2[31:0];
    } DDRC_HIS_SFC_RDATA2 @ 0x4b0;
    reg {
        name = "DDRC_HIS_SFC_RDATA3";
        desc = "DDRC_HIS_SFC_RDATA3 is the SFC (Software config) read data register. DDRC_HIS_SFC_RDATA3 (offset 0x4B4, total reset 0x0000_0000; PROVEN: Hi3535 data sheet, PDF page 659, section 4.1.6.2).";
        field {
            name = "rdata3";
            desc = "SFC read data [31:0]; in RD_MRS mode, [7:0] is the register value read back from the LP DDR2 MRS.";
            sw = rw; hw = r;
            reset = 0x0;
        } rdata3[31:0];
    } DDRC_HIS_SFC_RDATA3 @ 0x4b4;
};

`endif
